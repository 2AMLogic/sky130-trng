* extracted by klt extract --deck sky130
* parasitic model (--parasitics):
* - capacitance: net-to-ground for every net's own (non-coupled) area/perimeter, plus net-to-net for the vertical-overlap coupling `coupling` describes below -- a coupled net pair gets a direct capacitor between their two hub nodes, not just capacitors to the deck's ground/substrate net
* - coupling: vertical overlap (crossover) unconditionally -- where one net's conductor on an adjacent metal level sits directly over another *distinct* net's conductor, that overlap area is charged between the two nets instead of to ground (issue #760) -- plus lateral (same-layer, sidewall) coupling, but only for a net pair naming one of the caller's declared `--critical-net` nets (issue #976): facing-edge length within that layer's own minimum-spacing lookback is charged between the two nets, *additively* (not deducted from either net's substrate fringe term, unlike the vertical case -- a known simplification). Any same-layer pair with neither side named `--critical-net`, and fringe shielding in general, are still not modelled
* - resistance: single lumped series resistance per net, distributed as a star across that net's device terminals (issue #592) -- not a per-segment, distributed RC ladder, *unless* `--distributed-rc` names this net via `--critical-net` (issue #977, Epic #709 Phase 2b): then the net's terminals are ordered along their approximate physical spread and its total R/C is broken into a chain of per-segment resistors (segment length proportional to inter-terminal distance) with a ground capacitor at each terminal node (proportional to its adjacent segment length/2), instead of one star hub -- still an approximation (terminal position is a device-placement proxy, not true per-segment routing geometry), but a strictly finer-grained one than the single-hub star
* - frequency: quasi-static -- one frequency-independent R and C per net; no skin effect, no distributed transmission-line behavior
.GLOBAL vsubs

* cell sampler_dff
* pin a,b,inv_q_a,inv_q_a_via,s,tg_fbs_b,tg_fbs_b_via,tg_s_b,tg_s_b_via
* pin a,b,m_east,m_west,nand_m_a,nand_m_a_ext_via,nand_m_a_ext_via2,nand_m_a_stub,tg_d_b,tg_d_b_via,tg_d_b_via2,tg_fbm_b,tg_fbm_b_alt_via,tg_fbm_b_alt_via2
* pin a,clk,ctrl,ctrlb,inv_clk_a,inv_clk_clk_via,tg_d_ctrl,tg_d_ctrl_via,tg_fbm_ctrlb,tg_fbm_ctrlb_via,tg_fbs_ctrl,tg_fbs_ctrl_via,tg_s_ctrlb,tg_s_ctrlb_via
* pin a,d,tg_d_a
* pin a,inv_mc_a,mb,mnab_y,mpa_y,mpb_y,nand_m_y,tg_s_a,y
* pin a,inv_mc_y,inv_mc_y_via,mc,tg_fbm_a,tg_fbm_a_via,y
* pin a,inv_q_y,inv_q_y_via,inv_q_y_via2,nand_s2_a,nand_s2_a_stub,nand_s2_a_via,nand_s2_a_via2,q,y
* pin a,mnab_y,mpa_y,mpb_y,nand_s2_y,qb,tg_fbs_a,y
* pin clkb,clkb_bridge1,clkb_bridge2,clkb_mid,clkb_w,ctrl,ctrlb,inv_clk_y,tg_d_ctrlb,tg_fbm_ctrl,tg_fbs_ctrlb,tg_s_ctrl,y
* pin en,nand_m_en,nand_m_en_via,nand_s2_en,nand_s2_en_via,rst_n
* pin inv_clk_vdd,inv_mc_vdd,inv_q_vdd,mpa_py,mpb_py,nand_m_vdd,nand_s2_vdd,nwell_vdd,tg_d_vdd,tg_fbm_vdd,tg_fbs_vdd,tg_s_vdd,vdd
* pin inv_clk_vss,inv_mc_vss,inv_q_vss,nand_m_vss,nand_s2_vss,tg_d_vss,tg_fbm_vss,tg_fbs_vss,tg_s_vss,vss
.SUBCKT sampler_dff
+ a|b|inv_q_a|inv_q_a_via|s|tg_fbs_b|tg_fbs_b_via|tg_s_b|tg_s_b_via
+ a|b|m_east|m_west|nand_m_a|nand_m_a_ext_via|nand_m_a_ext_via2|nand_m_a_stub|tg_d_b|tg_d_b_via|tg_d_b_via2|tg_fbm_b|tg_fbm_b_alt_via|tg_fbm_b_alt_via2
+ a|clk|ctrl|ctrlb|inv_clk_a|inv_clk_clk_via|tg_d_ctrl|tg_d_ctrl_via|tg_fbm_ctrlb|tg_fbm_ctrlb_via|tg_fbs_ctrl|tg_fbs_ctrl_via|tg_s_ctrlb|tg_s_ctrlb_via
+ a|d|tg_d_a a|inv_mc_a|mb|mnab_y|mpa_y|mpb_y|nand_m_y|tg_s_a|y
+ a|inv_mc_y|inv_mc_y_via|mc|tg_fbm_a|tg_fbm_a_via|y
+ a|inv_q_y|inv_q_y_via|inv_q_y_via2|nand_s2_a|nand_s2_a_stub|nand_s2_a_via|nand_s2_a_via2|q|y
+ a|mnab_y|mpa_y|mpb_y|nand_s2_y|qb|tg_fbs_a|y
+ clkb|clkb_bridge1|clkb_bridge2|clkb_mid|clkb_w|ctrl|ctrlb|inv_clk_y|tg_d_ctrlb|tg_fbm_ctrl|tg_fbs_ctrlb|tg_s_ctrl|y
+ en|nand_m_en|nand_m_en_via|nand_s2_en|nand_s2_en_via|rst_n
+ inv_clk_vdd|inv_mc_vdd|inv_q_vdd|mpa_py|mpb_py|nand_m_vdd|nand_s2_vdd|nwell_vdd|tg_d_vdd|tg_fbm_vdd|tg_fbs_vdd|tg_s_vdd|vdd
+ inv_clk_vss|inv_mc_vss|inv_q_vss|nand_m_vss|nand_s2_vss|tg_d_vss|tg_fbm_vss|tg_fbs_vss|tg_s_vss|vss
* device instance $1 r0 *1 0.545,0.21 nfet
X$1
+ clkb\x7cclkb_bridge1\x7cclkb_bridge2\x7cclkb_mid\x7cclkb_w\x7cctrl\x7cctrlb\x7cinv_clk_y\x7ctg_d_ctrlb\x7ctg_fbm_ctrl\x7ctg_fbs_ctrlb\x7ctg_s_ctrl\x7cy__t3
+ a\x7cclk\x7cctrl\x7cctrlb\x7cinv_clk_a\x7cinv_clk_clk_via\x7ctg_d_ctrl\x7ctg_d_ctrl_via\x7ctg_fbm_ctrlb\x7ctg_fbm_ctrlb_via\x7ctg_fbs_ctrl\x7ctg_fbs_ctrl_via\x7ctg_s_ctrlb\x7ctg_s_ctrlb_via__t3
+ inv_clk_vss\x7cinv_mc_vss\x7cinv_q_vss\x7cnand_m_vss\x7cnand_s2_vss\x7ctg_d_vss\x7ctg_fbm_vss\x7ctg_fbs_vss\x7ctg_s_vss\x7cvss__t0
+ inv_clk_vss\x7cinv_mc_vss\x7cinv_q_vss\x7cnand_m_vss\x7cnand_s2_vss\x7ctg_d_vss\x7ctg_fbm_vss\x7ctg_fbs_vss\x7ctg_s_vss\x7cvss__t5
+ sky130_fd_pr__nfet_01v8 L=0.15 W=0.42 AS=0.1974 AD=0.1974 PS=1.78 PD=1.78
* device instance $2 r0 *1 5.31,0.21 nfet
X$2 a\x7cd\x7ctg_d_a__t1
+ clkb\x7cclkb_bridge1\x7cclkb_bridge2\x7cclkb_mid\x7cclkb_w\x7cctrl\x7cctrlb\x7cinv_clk_y\x7ctg_d_ctrlb\x7ctg_fbm_ctrl\x7ctg_fbs_ctrlb\x7ctg_s_ctrl\x7cy__t5
+ a\x7cb\x7cm_east\x7cm_west\x7cnand_m_a\x7cnand_m_a_ext_via\x7cnand_m_a_ext_via2\x7cnand_m_a_stub\x7ctg_d_b\x7ctg_d_b_via\x7ctg_d_b_via2\x7ctg_fbm_b\x7ctg_fbm_b_alt_via\x7ctg_fbm_b_alt_via2__t5
+ inv_clk_vss\x7cinv_mc_vss\x7cinv_q_vss\x7cnand_m_vss\x7cnand_s2_vss\x7ctg_d_vss\x7ctg_fbm_vss\x7ctg_fbs_vss\x7ctg_s_vss\x7cvss__t6
+ sky130_fd_pr__nfet_01v8 L=0.15 W=0.42 AS=0.1974 AD=0.1974 PS=1.78 PD=1.78
* device instance $3 r0 *1 19.835,0.21 nfet
X$3 a\x7cinv_mc_y\x7cinv_mc_y_via\x7cmc\x7ctg_fbm_a\x7ctg_fbm_a_via\x7cy__t3
+ a\x7cinv_mc_a\x7cmb\x7cmnab_y\x7cmpa_y\x7cmpb_y\x7cnand_m_y\x7ctg_s_a\x7cy__t0
+ inv_clk_vss\x7cinv_mc_vss\x7cinv_q_vss\x7cnand_m_vss\x7cnand_s2_vss\x7ctg_d_vss\x7ctg_fbm_vss\x7ctg_fbs_vss\x7ctg_s_vss\x7cvss__t4
+ inv_clk_vss\x7cinv_mc_vss\x7cinv_q_vss\x7cnand_m_vss\x7cnand_s2_vss\x7ctg_d_vss\x7ctg_fbm_vss\x7ctg_fbs_vss\x7ctg_s_vss\x7cvss__t7
+ sky130_fd_pr__nfet_01v8 L=0.15 W=0.42 AS=0.1974 AD=0.1974 PS=1.78 PD=1.78
* device instance $4 r0 *1 24.6,0.21 nfet
X$4 a\x7cinv_mc_y\x7cinv_mc_y_via\x7cmc\x7ctg_fbm_a\x7ctg_fbm_a_via\x7cy__t2
+ a\x7cclk\x7cctrl\x7cctrlb\x7cinv_clk_a\x7cinv_clk_clk_via\x7ctg_d_ctrl\x7ctg_d_ctrl_via\x7ctg_fbm_ctrlb\x7ctg_fbm_ctrlb_via\x7ctg_fbs_ctrl\x7ctg_fbs_ctrl_via\x7ctg_s_ctrlb\x7ctg_s_ctrlb_via__t5
+ a\x7cb\x7cm_east\x7cm_west\x7cnand_m_a\x7cnand_m_a_ext_via\x7cnand_m_a_ext_via2\x7cnand_m_a_stub\x7ctg_d_b\x7ctg_d_b_via\x7ctg_d_b_via2\x7ctg_fbm_b\x7ctg_fbm_b_alt_via\x7ctg_fbm_b_alt_via2__t4
+ inv_clk_vss\x7cinv_mc_vss\x7cinv_q_vss\x7cnand_m_vss\x7cnand_s2_vss\x7ctg_d_vss\x7ctg_fbm_vss\x7ctg_fbs_vss\x7ctg_s_vss\x7cvss__t8
+ sky130_fd_pr__nfet_01v8 L=0.15 W=0.42 AS=0.1974 AD=0.1974 PS=1.78 PD=1.78
* device instance $5 r0 *1 29.74,0.21 nfet
X$5
+ a\x7cinv_mc_a\x7cmb\x7cmnab_y\x7cmpa_y\x7cmpb_y\x7cnand_m_y\x7ctg_s_a\x7cy__t1
+ a\x7cclk\x7cctrl\x7cctrlb\x7cinv_clk_a\x7cinv_clk_clk_via\x7ctg_d_ctrl\x7ctg_d_ctrl_via\x7ctg_fbm_ctrlb\x7ctg_fbm_ctrlb_via\x7ctg_fbs_ctrl\x7ctg_fbs_ctrl_via\x7ctg_s_ctrlb\x7ctg_s_ctrlb_via__t4
+ a\x7cb\x7cinv_q_a\x7cinv_q_a_via\x7cs\x7ctg_fbs_b\x7ctg_fbs_b_via\x7ctg_s_b\x7ctg_s_b_via__t5
+ inv_clk_vss\x7cinv_mc_vss\x7cinv_q_vss\x7cnand_m_vss\x7cnand_s2_vss\x7ctg_d_vss\x7ctg_fbm_vss\x7ctg_fbs_vss\x7ctg_s_vss\x7cvss__t9
+ sky130_fd_pr__nfet_01v8 L=0.15 W=0.42 AS=0.1974 AD=0.1974 PS=1.78 PD=1.78
* device instance $6 r0 *1 36.545,0.21 nfet
X$6
+ a\x7cinv_q_y\x7cinv_q_y_via\x7cinv_q_y_via2\x7cnand_s2_a\x7cnand_s2_a_stub\x7cnand_s2_a_via\x7cnand_s2_a_via2\x7cq\x7cy__t3
+ a\x7cb\x7cinv_q_a\x7cinv_q_a_via\x7cs\x7ctg_fbs_b\x7ctg_fbs_b_via\x7ctg_s_b\x7ctg_s_b_via__t3
+ inv_clk_vss\x7cinv_mc_vss\x7cinv_q_vss\x7cnand_m_vss\x7cnand_s2_vss\x7ctg_d_vss\x7ctg_fbm_vss\x7ctg_fbs_vss\x7ctg_s_vss\x7cvss__t3
+ inv_clk_vss\x7cinv_mc_vss\x7cinv_q_vss\x7cnand_m_vss\x7cnand_s2_vss\x7ctg_d_vss\x7ctg_fbm_vss\x7ctg_fbs_vss\x7ctg_s_vss\x7cvss__t10
+ sky130_fd_pr__nfet_01v8 L=0.15 W=0.42 AS=0.1974 AD=0.1974 PS=1.78 PD=1.78
* device instance $7 r0 *1 49.03,0.21 nfet
X$7 a\x7cmnab_y\x7cmpa_y\x7cmpb_y\x7cnand_s2_y\x7cqb\x7ctg_fbs_a\x7cy__t4
+ clkb\x7cclkb_bridge1\x7cclkb_bridge2\x7cclkb_mid\x7cclkb_w\x7cctrl\x7cctrlb\x7cinv_clk_y\x7ctg_d_ctrlb\x7ctg_fbm_ctrl\x7ctg_fbs_ctrlb\x7ctg_s_ctrl\x7cy__t4
+ a\x7cb\x7cinv_q_a\x7cinv_q_a_via\x7cs\x7ctg_fbs_b\x7ctg_fbs_b_via\x7ctg_s_b\x7ctg_s_b_via__t4
+ inv_clk_vss\x7cinv_mc_vss\x7cinv_q_vss\x7cnand_m_vss\x7cnand_s2_vss\x7ctg_d_vss\x7ctg_fbm_vss\x7ctg_fbs_vss\x7ctg_s_vss\x7cvss__t11
+ sky130_fd_pr__nfet_01v8 L=0.15 W=0.42 AS=0.1974 AD=0.1974 PS=1.78 PD=1.78
* device instance $8 r0 *1 12.315,0.21 nfet
X$8 \$6__t0
+ en\x7cnand_m_en\x7cnand_m_en_via\x7cnand_s2_en\x7cnand_s2_en_via\x7crst_n__t0
+ inv_clk_vss\x7cinv_mc_vss\x7cinv_q_vss\x7cnand_m_vss\x7cnand_s2_vss\x7ctg_d_vss\x7ctg_fbm_vss\x7ctg_fbs_vss\x7ctg_s_vss\x7cvss__t1
+ inv_clk_vss\x7cinv_mc_vss\x7cinv_q_vss\x7cnand_m_vss\x7cnand_s2_vss\x7ctg_d_vss\x7ctg_fbm_vss\x7ctg_fbs_vss\x7ctg_s_vss\x7cvss__t12
+ sky130_fd_pr__nfet_01v8 L=0.15 W=0.84 AS=0.3948 AD=0.2184 PS=2.62 PD=1.36
* device instance $9 r0 *1 12.985,0.21 nfet
X$9
+ a\x7cinv_mc_a\x7cmb\x7cmnab_y\x7cmpa_y\x7cmpb_y\x7cnand_m_y\x7ctg_s_a\x7cy__t2
+ a\x7cb\x7cm_east\x7cm_west\x7cnand_m_a\x7cnand_m_a_ext_via\x7cnand_m_a_ext_via2\x7cnand_m_a_stub\x7ctg_d_b\x7ctg_d_b_via\x7ctg_d_b_via2\x7ctg_fbm_b\x7ctg_fbm_b_alt_via\x7ctg_fbm_b_alt_via2__t0
+ \$6__t1
+ inv_clk_vss\x7cinv_mc_vss\x7cinv_q_vss\x7cnand_m_vss\x7cnand_s2_vss\x7ctg_d_vss\x7ctg_fbm_vss\x7ctg_fbs_vss\x7ctg_s_vss\x7cvss__t14
+ sky130_fd_pr__nfet_01v8 L=0.15 W=0.84 AS=0.2184 AD=0.3948 PS=1.36 PD=2.62
* device instance $10 r0 *1 43.175,0.21 nfet
X$10 \$7__t1
+ en\x7cnand_m_en\x7cnand_m_en_via\x7cnand_s2_en\x7cnand_s2_en_via\x7crst_n__t1
+ inv_clk_vss\x7cinv_mc_vss\x7cinv_q_vss\x7cnand_m_vss\x7cnand_s2_vss\x7ctg_d_vss\x7ctg_fbm_vss\x7ctg_fbs_vss\x7ctg_s_vss\x7cvss__t2
+ inv_clk_vss\x7cinv_mc_vss\x7cinv_q_vss\x7cnand_m_vss\x7cnand_s2_vss\x7ctg_d_vss\x7ctg_fbm_vss\x7ctg_fbs_vss\x7ctg_s_vss\x7cvss__t13
+ sky130_fd_pr__nfet_01v8 L=0.15 W=0.84 AS=0.3948 AD=0.2184 PS=2.62 PD=1.36
* device instance $11 r0 *1 43.845,0.21 nfet
X$11 a\x7cmnab_y\x7cmpa_y\x7cmpb_y\x7cnand_s2_y\x7cqb\x7ctg_fbs_a\x7cy__t3
+ a\x7cinv_q_y\x7cinv_q_y_via\x7cinv_q_y_via2\x7cnand_s2_a\x7cnand_s2_a_stub\x7cnand_s2_a_via\x7cnand_s2_a_via2\x7cq\x7cy__t0
+ \$7__t0
+ inv_clk_vss\x7cinv_mc_vss\x7cinv_q_vss\x7cnand_m_vss\x7cnand_s2_vss\x7ctg_d_vss\x7ctg_fbm_vss\x7ctg_fbs_vss\x7ctg_s_vss\x7cvss__t15
+ sky130_fd_pr__nfet_01v8 L=0.15 W=0.84 AS=0.2184 AD=0.3948 PS=1.36 PD=2.62
* device instance $12 r0 *1 0.545,3.53 pfet
X$12
+ clkb\x7cclkb_bridge1\x7cclkb_bridge2\x7cclkb_mid\x7cclkb_w\x7cctrl\x7cctrlb\x7cinv_clk_y\x7ctg_d_ctrlb\x7ctg_fbm_ctrl\x7ctg_fbs_ctrlb\x7ctg_s_ctrl\x7cy__t0
+ a\x7cclk\x7cctrl\x7cctrlb\x7cinv_clk_a\x7cinv_clk_clk_via\x7ctg_d_ctrl\x7ctg_d_ctrl_via\x7ctg_fbm_ctrlb\x7ctg_fbm_ctrlb_via\x7ctg_fbs_ctrl\x7ctg_fbs_ctrl_via\x7ctg_s_ctrlb\x7ctg_s_ctrlb_via__t0
+ inv_clk_vdd\x7cinv_mc_vdd\x7cinv_q_vdd\x7cmpa_py\x7cmpb_py\x7cnand_m_vdd\x7cnand_s2_vdd\x7cnwell_vdd\x7ctg_d_vdd\x7ctg_fbm_vdd\x7ctg_fbs_vdd\x7ctg_s_vdd\x7cvdd__t11
+ inv_clk_vdd\x7cinv_mc_vdd\x7cinv_q_vdd\x7cmpa_py\x7cmpb_py\x7cnand_m_vdd\x7cnand_s2_vdd\x7cnwell_vdd\x7ctg_d_vdd\x7ctg_fbm_vdd\x7ctg_fbs_vdd\x7ctg_s_vdd\x7cvdd__t0
+ sky130_fd_pr__pfet_01v8 L=0.15 W=0.84 AS=0.3948 AD=0.3948 PS=2.62 PD=2.62
* device instance $13 r0 *1 5.31,3.53 pfet
X$13 a\x7cd\x7ctg_d_a__t0
+ a\x7cclk\x7cctrl\x7cctrlb\x7cinv_clk_a\x7cinv_clk_clk_via\x7ctg_d_ctrl\x7ctg_d_ctrl_via\x7ctg_fbm_ctrlb\x7ctg_fbm_ctrlb_via\x7ctg_fbs_ctrl\x7ctg_fbs_ctrl_via\x7ctg_s_ctrlb\x7ctg_s_ctrlb_via__t1
+ a\x7cb\x7cm_east\x7cm_west\x7cnand_m_a\x7cnand_m_a_ext_via\x7cnand_m_a_ext_via2\x7cnand_m_a_stub\x7ctg_d_b\x7ctg_d_b_via\x7ctg_d_b_via2\x7ctg_fbm_b\x7ctg_fbm_b_alt_via\x7ctg_fbm_b_alt_via2__t1
+ inv_clk_vdd\x7cinv_mc_vdd\x7cinv_q_vdd\x7cmpa_py\x7cmpb_py\x7cnand_m_vdd\x7cnand_s2_vdd\x7cnwell_vdd\x7ctg_d_vdd\x7ctg_fbm_vdd\x7ctg_fbs_vdd\x7ctg_s_vdd\x7cvdd__t1
+ sky130_fd_pr__pfet_01v8 L=0.15 W=0.84 AS=0.3948 AD=0.3948 PS=2.62 PD=2.62
* device instance $14 r0 *1 19.835,3.53 pfet
X$14 a\x7cinv_mc_y\x7cinv_mc_y_via\x7cmc\x7ctg_fbm_a\x7ctg_fbm_a_via\x7cy__t0
+ a\x7cinv_mc_a\x7cmb\x7cmnab_y\x7cmpa_y\x7cmpb_y\x7cnand_m_y\x7ctg_s_a\x7cy__t3
+ inv_clk_vdd\x7cinv_mc_vdd\x7cinv_q_vdd\x7cmpa_py\x7cmpb_py\x7cnand_m_vdd\x7cnand_s2_vdd\x7cnwell_vdd\x7ctg_d_vdd\x7ctg_fbm_vdd\x7ctg_fbs_vdd\x7ctg_s_vdd\x7cvdd__t12
+ inv_clk_vdd\x7cinv_mc_vdd\x7cinv_q_vdd\x7cmpa_py\x7cmpb_py\x7cnand_m_vdd\x7cnand_s2_vdd\x7cnwell_vdd\x7ctg_d_vdd\x7ctg_fbm_vdd\x7ctg_fbs_vdd\x7ctg_s_vdd\x7cvdd__t2
+ sky130_fd_pr__pfet_01v8 L=0.15 W=0.84 AS=0.3948 AD=0.3948 PS=2.62 PD=2.62
* device instance $15 r0 *1 24.6,3.53 pfet
X$15 a\x7cinv_mc_y\x7cinv_mc_y_via\x7cmc\x7ctg_fbm_a\x7ctg_fbm_a_via\x7cy__t1
+ clkb\x7cclkb_bridge1\x7cclkb_bridge2\x7cclkb_mid\x7cclkb_w\x7cctrl\x7cctrlb\x7cinv_clk_y\x7ctg_d_ctrlb\x7ctg_fbm_ctrl\x7ctg_fbs_ctrlb\x7ctg_s_ctrl\x7cy__t1
+ a\x7cb\x7cm_east\x7cm_west\x7cnand_m_a\x7cnand_m_a_ext_via\x7cnand_m_a_ext_via2\x7cnand_m_a_stub\x7ctg_d_b\x7ctg_d_b_via\x7ctg_d_b_via2\x7ctg_fbm_b\x7ctg_fbm_b_alt_via\x7ctg_fbm_b_alt_via2__t2
+ inv_clk_vdd\x7cinv_mc_vdd\x7cinv_q_vdd\x7cmpa_py\x7cmpb_py\x7cnand_m_vdd\x7cnand_s2_vdd\x7cnwell_vdd\x7ctg_d_vdd\x7ctg_fbm_vdd\x7ctg_fbs_vdd\x7ctg_s_vdd\x7cvdd__t3
+ sky130_fd_pr__pfet_01v8 L=0.15 W=0.84 AS=0.3948 AD=0.3948 PS=2.62 PD=2.62
* device instance $16 r0 *1 29.74,3.53 pfet
X$16
+ a\x7cinv_mc_a\x7cmb\x7cmnab_y\x7cmpa_y\x7cmpb_y\x7cnand_m_y\x7ctg_s_a\x7cy__t4
+ clkb\x7cclkb_bridge1\x7cclkb_bridge2\x7cclkb_mid\x7cclkb_w\x7cctrl\x7cctrlb\x7cinv_clk_y\x7ctg_d_ctrlb\x7ctg_fbm_ctrl\x7ctg_fbs_ctrlb\x7ctg_s_ctrl\x7cy__t2
+ a\x7cb\x7cinv_q_a\x7cinv_q_a_via\x7cs\x7ctg_fbs_b\x7ctg_fbs_b_via\x7ctg_s_b\x7ctg_s_b_via__t0
+ inv_clk_vdd\x7cinv_mc_vdd\x7cinv_q_vdd\x7cmpa_py\x7cmpb_py\x7cnand_m_vdd\x7cnand_s2_vdd\x7cnwell_vdd\x7ctg_d_vdd\x7ctg_fbm_vdd\x7ctg_fbs_vdd\x7ctg_s_vdd\x7cvdd__t4
+ sky130_fd_pr__pfet_01v8 L=0.15 W=0.84 AS=0.3948 AD=0.3948 PS=2.62 PD=2.62
* device instance $17 r0 *1 36.545,3.53 pfet
X$17
+ a\x7cinv_q_y\x7cinv_q_y_via\x7cinv_q_y_via2\x7cnand_s2_a\x7cnand_s2_a_stub\x7cnand_s2_a_via\x7cnand_s2_a_via2\x7cq\x7cy__t1
+ a\x7cb\x7cinv_q_a\x7cinv_q_a_via\x7cs\x7ctg_fbs_b\x7ctg_fbs_b_via\x7ctg_s_b\x7ctg_s_b_via__t2
+ inv_clk_vdd\x7cinv_mc_vdd\x7cinv_q_vdd\x7cmpa_py\x7cmpb_py\x7cnand_m_vdd\x7cnand_s2_vdd\x7cnwell_vdd\x7ctg_d_vdd\x7ctg_fbm_vdd\x7ctg_fbs_vdd\x7ctg_s_vdd\x7cvdd__t13
+ inv_clk_vdd\x7cinv_mc_vdd\x7cinv_q_vdd\x7cmpa_py\x7cmpb_py\x7cnand_m_vdd\x7cnand_s2_vdd\x7cnwell_vdd\x7ctg_d_vdd\x7ctg_fbm_vdd\x7ctg_fbs_vdd\x7ctg_s_vdd\x7cvdd__t5
+ sky130_fd_pr__pfet_01v8 L=0.15 W=0.84 AS=0.3948 AD=0.3948 PS=2.62 PD=2.62
* device instance $18 r0 *1 49.03,3.53 pfet
X$18 a\x7cmnab_y\x7cmpa_y\x7cmpb_y\x7cnand_s2_y\x7cqb\x7ctg_fbs_a\x7cy__t1
+ a\x7cclk\x7cctrl\x7cctrlb\x7cinv_clk_a\x7cinv_clk_clk_via\x7ctg_d_ctrl\x7ctg_d_ctrl_via\x7ctg_fbm_ctrlb\x7ctg_fbm_ctrlb_via\x7ctg_fbs_ctrl\x7ctg_fbs_ctrl_via\x7ctg_s_ctrlb\x7ctg_s_ctrlb_via__t2
+ a\x7cb\x7cinv_q_a\x7cinv_q_a_via\x7cs\x7ctg_fbs_b\x7ctg_fbs_b_via\x7ctg_s_b\x7ctg_s_b_via__t1
+ inv_clk_vdd\x7cinv_mc_vdd\x7cinv_q_vdd\x7cmpa_py\x7cmpb_py\x7cnand_m_vdd\x7cnand_s2_vdd\x7cnwell_vdd\x7ctg_d_vdd\x7ctg_fbm_vdd\x7ctg_fbs_vdd\x7ctg_s_vdd\x7cvdd__t6
+ sky130_fd_pr__pfet_01v8 L=0.15 W=0.84 AS=0.3948 AD=0.3948 PS=2.62 PD=2.62
* device instance $19 r0 *1 12.115,3.74 pfet
X$19
+ a\x7cinv_mc_a\x7cmb\x7cmnab_y\x7cmpa_y\x7cmpb_y\x7cnand_m_y\x7ctg_s_a\x7cy__t6
+ en\x7cnand_m_en\x7cnand_m_en_via\x7cnand_s2_en\x7cnand_s2_en_via\x7crst_n__t2
+ inv_clk_vdd\x7cinv_mc_vdd\x7cinv_q_vdd\x7cmpa_py\x7cmpb_py\x7cnand_m_vdd\x7cnand_s2_vdd\x7cnwell_vdd\x7ctg_d_vdd\x7ctg_fbm_vdd\x7ctg_fbs_vdd\x7ctg_s_vdd\x7cvdd__t14
+ inv_clk_vdd\x7cinv_mc_vdd\x7cinv_q_vdd\x7cmpa_py\x7cmpb_py\x7cnand_m_vdd\x7cnand_s2_vdd\x7cnwell_vdd\x7ctg_d_vdd\x7ctg_fbm_vdd\x7ctg_fbs_vdd\x7ctg_s_vdd\x7cvdd__t7
+ sky130_fd_pr__pfet_01v8 L=0.15 W=0.84 AS=0.3948 AD=0.3948 PS=2.62 PD=2.62
* device instance $20 r0 *1 13.405,3.74 pfet
X$20
+ inv_clk_vdd\x7cinv_mc_vdd\x7cinv_q_vdd\x7cmpa_py\x7cmpb_py\x7cnand_m_vdd\x7cnand_s2_vdd\x7cnwell_vdd\x7ctg_d_vdd\x7ctg_fbm_vdd\x7ctg_fbs_vdd\x7ctg_s_vdd\x7cvdd__t16
+ a\x7cb\x7cm_east\x7cm_west\x7cnand_m_a\x7cnand_m_a_ext_via\x7cnand_m_a_ext_via2\x7cnand_m_a_stub\x7ctg_d_b\x7ctg_d_b_via\x7ctg_d_b_via2\x7ctg_fbm_b\x7ctg_fbm_b_alt_via\x7ctg_fbm_b_alt_via2__t3
+ a\x7cinv_mc_a\x7cmb\x7cmnab_y\x7cmpa_y\x7cmpb_y\x7cnand_m_y\x7ctg_s_a\x7cy__t5
+ inv_clk_vdd\x7cinv_mc_vdd\x7cinv_q_vdd\x7cmpa_py\x7cmpb_py\x7cnand_m_vdd\x7cnand_s2_vdd\x7cnwell_vdd\x7ctg_d_vdd\x7ctg_fbm_vdd\x7ctg_fbs_vdd\x7ctg_s_vdd\x7cvdd__t8
+ sky130_fd_pr__pfet_01v8 L=0.15 W=0.84 AS=0.3948 AD=0.3948 PS=2.62 PD=2.62
* device instance $21 r0 *1 42.975,3.74 pfet
X$21 a\x7cmnab_y\x7cmpa_y\x7cmpb_y\x7cnand_s2_y\x7cqb\x7ctg_fbs_a\x7cy__t2
+ en\x7cnand_m_en\x7cnand_m_en_via\x7cnand_s2_en\x7cnand_s2_en_via\x7crst_n__t3
+ inv_clk_vdd\x7cinv_mc_vdd\x7cinv_q_vdd\x7cmpa_py\x7cmpb_py\x7cnand_m_vdd\x7cnand_s2_vdd\x7cnwell_vdd\x7ctg_d_vdd\x7ctg_fbm_vdd\x7ctg_fbs_vdd\x7ctg_s_vdd\x7cvdd__t15
+ inv_clk_vdd\x7cinv_mc_vdd\x7cinv_q_vdd\x7cmpa_py\x7cmpb_py\x7cnand_m_vdd\x7cnand_s2_vdd\x7cnwell_vdd\x7ctg_d_vdd\x7ctg_fbm_vdd\x7ctg_fbs_vdd\x7ctg_s_vdd\x7cvdd__t9
+ sky130_fd_pr__pfet_01v8 L=0.15 W=0.84 AS=0.3948 AD=0.3948 PS=2.62 PD=2.62
* device instance $22 r0 *1 44.265,3.74 pfet
X$22
+ inv_clk_vdd\x7cinv_mc_vdd\x7cinv_q_vdd\x7cmpa_py\x7cmpb_py\x7cnand_m_vdd\x7cnand_s2_vdd\x7cnwell_vdd\x7ctg_d_vdd\x7ctg_fbm_vdd\x7ctg_fbs_vdd\x7ctg_s_vdd\x7cvdd__t17
+ a\x7cinv_q_y\x7cinv_q_y_via\x7cinv_q_y_via2\x7cnand_s2_a\x7cnand_s2_a_stub\x7cnand_s2_a_via\x7cnand_s2_a_via2\x7cq\x7cy__t2
+ a\x7cmnab_y\x7cmpa_y\x7cmpb_y\x7cnand_s2_y\x7cqb\x7ctg_fbs_a\x7cy__t0
+ inv_clk_vdd\x7cinv_mc_vdd\x7cinv_q_vdd\x7cmpa_py\x7cmpb_py\x7cnand_m_vdd\x7cnand_s2_vdd\x7cnwell_vdd\x7ctg_d_vdd\x7ctg_fbm_vdd\x7ctg_fbs_vdd\x7ctg_s_vdd\x7cvdd__t10
+ sky130_fd_pr__pfet_01v8 L=0.15 W=0.84 AS=0.3948 AD=0.3948 PS=2.62 PD=2.62
* device instance _6_t0 r0 *1 0,0
R_6_t0 \$6__t0 \$6 12.8
* device instance _6_t1 r0 *1 0,0
R_6_t1 \$6__t1 \$6 12.8
* device instance _6 r0 *1 0,0
C_6 \$6 vsubs 1.15618e-16
* device instance _7_t0 r0 *1 0,0
R_7_t0 \$7__t0 \$7 12.8
* device instance _7_t1 r0 *1 0,0
R_7_t1 \$7__t1 \$7 12.8
* device instance _7 r0 *1 0,0
C_7 \$7 vsubs 1.15618e-16
* device instance a_b_inv_q_a_inv_q_a_via_s_tg_fbs_b_tg_fbs_b_via_tg_s_b_tg_s_b_via_t0 r0 *1 0,0
Ra_b_inv_q_a_inv_q_a_via_s_tg_fbs_b_tg_fbs_b_via_tg_s_b_tg_s_b_via_t0
+ a\x7cb\x7cinv_q_a\x7cinv_q_a_via\x7cs\x7ctg_fbs_b\x7ctg_fbs_b_via\x7ctg_s_b\x7ctg_s_b_via__t0
+ a|b|inv_q_a|inv_q_a_via|s|tg_fbs_b|tg_fbs_b_via|tg_s_b|tg_s_b_via
+ 242.567979706
* device instance a_b_inv_q_a_inv_q_a_via_s_tg_fbs_b_tg_fbs_b_via_tg_s_b_tg_s_b_via_t1 r0 *1 0,0
Ra_b_inv_q_a_inv_q_a_via_s_tg_fbs_b_tg_fbs_b_via_tg_s_b_tg_s_b_via_t1
+ a\x7cb\x7cinv_q_a\x7cinv_q_a_via\x7cs\x7ctg_fbs_b\x7ctg_fbs_b_via\x7ctg_s_b\x7ctg_s_b_via__t1
+ a|b|inv_q_a|inv_q_a_via|s|tg_fbs_b|tg_fbs_b_via|tg_s_b|tg_s_b_via
+ 293.672426551
* device instance a_b_inv_q_a_inv_q_a_via_s_tg_fbs_b_tg_fbs_b_via_tg_s_b_tg_s_b_via_t2 r0 *1 0,0
Ra_b_inv_q_a_inv_q_a_via_s_tg_fbs_b_tg_fbs_b_via_tg_s_b_tg_s_b_via_t2
+ a\x7cb\x7cinv_q_a\x7cinv_q_a_via\x7cs\x7ctg_fbs_b\x7ctg_fbs_b_via\x7ctg_s_b\x7ctg_s_b_via__t2
+ a|b|inv_q_a|inv_q_a_via|s|tg_fbs_b|tg_fbs_b_via|tg_s_b|tg_s_b_via
+ 68.9738937426
* device instance a_b_inv_q_a_inv_q_a_via_s_tg_fbs_b_tg_fbs_b_via_tg_s_b_tg_s_b_via_t3 r0 *1 0,0
Ra_b_inv_q_a_inv_q_a_via_s_tg_fbs_b_tg_fbs_b_via_tg_s_b_tg_s_b_via_t3
+ a\x7cb\x7cinv_q_a\x7cinv_q_a_via\x7cs\x7ctg_fbs_b\x7ctg_fbs_b_via\x7ctg_s_b\x7ctg_s_b_via__t3
+ a|b|inv_q_a|inv_q_a_via|s|tg_fbs_b|tg_fbs_b_via|tg_s_b|tg_s_b_via
+ 68.9738937426
* device instance a_b_inv_q_a_inv_q_a_via_s_tg_fbs_b_tg_fbs_b_via_tg_s_b_tg_s_b_via_t4 r0 *1 0,0
Ra_b_inv_q_a_inv_q_a_via_s_tg_fbs_b_tg_fbs_b_via_tg_s_b_tg_s_b_via_t4
+ a\x7cb\x7cinv_q_a\x7cinv_q_a_via\x7cs\x7ctg_fbs_b\x7ctg_fbs_b_via\x7ctg_s_b\x7ctg_s_b_via__t4
+ a|b|inv_q_a|inv_q_a_via|s|tg_fbs_b|tg_fbs_b_via|tg_s_b|tg_s_b_via
+ 293.672426551
* device instance a_b_inv_q_a_inv_q_a_via_s_tg_fbs_b_tg_fbs_b_via_tg_s_b_tg_s_b_via_t5 r0 *1 0,0
Ra_b_inv_q_a_inv_q_a_via_s_tg_fbs_b_tg_fbs_b_via_tg_s_b_tg_s_b_via_t5
+ a\x7cb\x7cinv_q_a\x7cinv_q_a_via\x7cs\x7ctg_fbs_b\x7ctg_fbs_b_via\x7ctg_s_b\x7ctg_s_b_via__t5
+ a|b|inv_q_a|inv_q_a_via|s|tg_fbs_b|tg_fbs_b_via|tg_s_b|tg_s_b_via
+ 242.567979706
* device instance a_b_inv_q_a_inv_q_a_via_s_tg_fbs_b_tg_fbs_b_via_tg_s_b_tg_s_b_via r0 *1 0,0
Ca_b_inv_q_a_inv_q_a_via_s_tg_fbs_b_tg_fbs_b_via_tg_s_b_tg_s_b_via
+ a|b|inv_q_a|inv_q_a_via|s|tg_fbs_b|tg_fbs_b_via|tg_s_b|tg_s_b_via vsubs
+ 3.84792e-15
* device instance a_b_m_east_m_west_nand_m_a_nand_m_a_ext_via_nand_m_a_ext_via2_nand_m_a_stub_tg_d_b_tg_d_b_via_tg_d_b_via2_tg_fbm_b_tg_fbm_b_alt_via_tg_fbm_b_alt_via2_t0 r0 *1 0,0
Ra_b_m_east_m_west_nand_m_a_nand_m_a_ext_via_nand_m_a_ext_via2_nand_m_a_stub_tg_d_b_tg_d_b_via_tg_d_b_via2_tg_fbm_b_tg_fbm_b_alt_via_tg_fbm_b_alt_via2_t0
+ a\x7cb\x7cm_east\x7cm_west\x7cnand_m_a\x7cnand_m_a_ext_via\x7cnand_m_a_ext_via2\x7cnand_m_a_stub\x7ctg_d_b\x7ctg_d_b_via\x7ctg_d_b_via2\x7ctg_fbm_b\x7ctg_fbm_b_alt_via\x7ctg_fbm_b_alt_via2__t0
+ a|b|m_east|m_west|nand_m_a|nand_m_a_ext_via|nand_m_a_ext_via2|nand_m_a_stub|tg_d_b|tg_d_b_via|tg_d_b_via2|tg_fbm_b|tg_fbm_b_alt_via|tg_fbm_b_alt_via2
+ 64.6372259156
* device instance a_b_m_east_m_west_nand_m_a_nand_m_a_ext_via_nand_m_a_ext_via2_nand_m_a_stub_tg_d_b_tg_d_b_via_tg_d_b_via2_tg_fbm_b_tg_fbm_b_alt_via_tg_fbm_b_alt_via2_t1 r0 *1 0,0
Ra_b_m_east_m_west_nand_m_a_nand_m_a_ext_via_nand_m_a_ext_via2_nand_m_a_stub_tg_d_b_tg_d_b_via_tg_d_b_via2_tg_fbm_b_tg_fbm_b_alt_via_tg_fbm_b_alt_via2_t1
+ a\x7cb\x7cm_east\x7cm_west\x7cnand_m_a\x7cnand_m_a_ext_via\x7cnand_m_a_ext_via2\x7cnand_m_a_stub\x7ctg_d_b\x7ctg_d_b_via\x7ctg_d_b_via2\x7ctg_fbm_b\x7ctg_fbm_b_alt_via\x7ctg_fbm_b_alt_via2__t1
+ a|b|m_east|m_west|nand_m_a|nand_m_a_ext_via|nand_m_a_ext_via2|nand_m_a_stub|tg_d_b|tg_d_b_via|tg_d_b_via2|tg_fbm_b|tg_fbm_b_alt_via|tg_fbm_b_alt_via2
+ 271.890414185
* device instance a_b_m_east_m_west_nand_m_a_nand_m_a_ext_via_nand_m_a_ext_via2_nand_m_a_stub_tg_d_b_tg_d_b_via_tg_d_b_via2_tg_fbm_b_tg_fbm_b_alt_via_tg_fbm_b_alt_via2_t2 r0 *1 0,0
Ra_b_m_east_m_west_nand_m_a_nand_m_a_ext_via_nand_m_a_ext_via2_nand_m_a_stub_tg_d_b_tg_d_b_via_tg_d_b_via2_tg_fbm_b_tg_fbm_b_alt_via_tg_fbm_b_alt_via2_t2
+ a\x7cb\x7cm_east\x7cm_west\x7cnand_m_a\x7cnand_m_a_ext_via\x7cnand_m_a_ext_via2\x7cnand_m_a_stub\x7ctg_d_b\x7ctg_d_b_via\x7ctg_d_b_via2\x7ctg_fbm_b\x7ctg_fbm_b_alt_via\x7ctg_fbm_b_alt_via2__t2
+ a|b|m_east|m_west|nand_m_a|nand_m_a_ext_via|nand_m_a_ext_via2|nand_m_a_stub|tg_d_b|tg_d_b_via|tg_d_b_via2|tg_fbm_b|tg_fbm_b_alt_via|tg_fbm_b_alt_via2
+ 306.071765034
* device instance a_b_m_east_m_west_nand_m_a_nand_m_a_ext_via_nand_m_a_ext_via2_nand_m_a_stub_tg_d_b_tg_d_b_via_tg_d_b_via2_tg_fbm_b_tg_fbm_b_alt_via_tg_fbm_b_alt_via2_t3 r0 *1 0,0
Ra_b_m_east_m_west_nand_m_a_nand_m_a_ext_via_nand_m_a_ext_via2_nand_m_a_stub_tg_d_b_tg_d_b_via_tg_d_b_via2_tg_fbm_b_tg_fbm_b_alt_via_tg_fbm_b_alt_via2_t3
+ a\x7cb\x7cm_east\x7cm_west\x7cnand_m_a\x7cnand_m_a_ext_via\x7cnand_m_a_ext_via2\x7cnand_m_a_stub\x7ctg_d_b\x7ctg_d_b_via\x7ctg_d_b_via2\x7ctg_fbm_b\x7ctg_fbm_b_alt_via\x7ctg_fbm_b_alt_via2__t3
+ a|b|m_east|m_west|nand_m_a|nand_m_a_ext_via|nand_m_a_ext_via2|nand_m_a_stub|tg_d_b|tg_d_b_via|tg_d_b_via2|tg_fbm_b|tg_fbm_b_alt_via|tg_fbm_b_alt_via2
+ 61.22954383
* device instance a_b_m_east_m_west_nand_m_a_nand_m_a_ext_via_nand_m_a_ext_via2_nand_m_a_stub_tg_d_b_tg_d_b_via_tg_d_b_via2_tg_fbm_b_tg_fbm_b_alt_via_tg_fbm_b_alt_via2_t4 r0 *1 0,0
Ra_b_m_east_m_west_nand_m_a_nand_m_a_ext_via_nand_m_a_ext_via2_nand_m_a_stub_tg_d_b_tg_d_b_via_tg_d_b_via2_tg_fbm_b_tg_fbm_b_alt_via_tg_fbm_b_alt_via2_t4
+ a\x7cb\x7cm_east\x7cm_west\x7cnand_m_a\x7cnand_m_a_ext_via\x7cnand_m_a_ext_via2\x7cnand_m_a_stub\x7ctg_d_b\x7ctg_d_b_via\x7ctg_d_b_via2\x7ctg_fbm_b\x7ctg_fbm_b_alt_via\x7ctg_fbm_b_alt_via2__t4
+ a|b|m_east|m_west|nand_m_a|nand_m_a_ext_via|nand_m_a_ext_via2|nand_m_a_stub|tg_d_b|tg_d_b_via|tg_d_b_via2|tg_fbm_b|tg_fbm_b_alt_via|tg_fbm_b_alt_via2
+ 306.402959413
* device instance a_b_m_east_m_west_nand_m_a_nand_m_a_ext_via_nand_m_a_ext_via2_nand_m_a_stub_tg_d_b_tg_d_b_via_tg_d_b_via2_tg_fbm_b_tg_fbm_b_alt_via_tg_fbm_b_alt_via2_t5 r0 *1 0,0
Ra_b_m_east_m_west_nand_m_a_nand_m_a_ext_via_nand_m_a_ext_via2_nand_m_a_stub_tg_d_b_tg_d_b_via_tg_d_b_via2_tg_fbm_b_tg_fbm_b_alt_via_tg_fbm_b_alt_via2_t5
+ a\x7cb\x7cm_east\x7cm_west\x7cnand_m_a\x7cnand_m_a_ext_via\x7cnand_m_a_ext_via2\x7cnand_m_a_stub\x7ctg_d_b\x7ctg_d_b_via\x7ctg_d_b_via2\x7ctg_fbm_b\x7ctg_fbm_b_alt_via\x7ctg_fbm_b_alt_via2__t5
+ a|b|m_east|m_west|nand_m_a|nand_m_a_ext_via|nand_m_a_ext_via2|nand_m_a_stub|tg_d_b|tg_d_b_via|tg_d_b_via2|tg_fbm_b|tg_fbm_b_alt_via|tg_fbm_b_alt_via2
+ 272.263191622
* device instance a_b_m_east_m_west_nand_m_a_nand_m_a_ext_via_nand_m_a_ext_via2_nand_m_a_stub_tg_d_b_tg_d_b_via_tg_d_b_via2_tg_fbm_b_tg_fbm_b_alt_via_tg_fbm_b_alt_via2 r0 *1 0,0
Ca_b_m_east_m_west_nand_m_a_nand_m_a_ext_via_nand_m_a_ext_via2_nand_m_a_stub_tg_d_b_tg_d_b_via_tg_d_b_via2_tg_fbm_b_tg_fbm_b_alt_via_tg_fbm_b_alt_via2
+ a|b|m_east|m_west|nand_m_a|nand_m_a_ext_via|nand_m_a_ext_via2|nand_m_a_stub|tg_d_b|tg_d_b_via|tg_d_b_via2|tg_fbm_b|tg_fbm_b_alt_via|tg_fbm_b_alt_via2
+ vsubs 3.815817e-15
* device instance a_clk_ctrl_ctrlb_inv_clk_a_inv_clk_clk_via_tg_d_ctrl_tg_d_ctrl_via_tg_fbm_ctrlb_tg_fbm_ctrlb_via_tg_fbs_ctrl_tg_fbs_ctrl_via_tg_s_ctrlb_tg_s_ctrlb_via_t0 r0 *1 0,0
Ra_clk_ctrl_ctrlb_inv_clk_a_inv_clk_clk_via_tg_d_ctrl_tg_d_ctrl_via_tg_fbm_ctrlb_tg_fbm_ctrlb_via_tg_fbs_ctrl_tg_fbs_ctrl_via_tg_s_ctrlb_tg_s_ctrlb_via_t0
+ a\x7cclk\x7cctrl\x7cctrlb\x7cinv_clk_a\x7cinv_clk_clk_via\x7ctg_d_ctrl\x7ctg_d_ctrl_via\x7ctg_fbm_ctrlb\x7ctg_fbm_ctrlb_via\x7ctg_fbs_ctrl\x7ctg_fbs_ctrl_via\x7ctg_s_ctrlb\x7ctg_s_ctrlb_via__t0
+ a|clk|ctrl|ctrlb|inv_clk_a|inv_clk_clk_via|tg_d_ctrl|tg_d_ctrl_via|tg_fbm_ctrlb|tg_fbm_ctrlb_via|tg_fbs_ctrl|tg_fbs_ctrl_via|tg_s_ctrlb|tg_s_ctrlb_via
+ 288.510437213
* device instance a_clk_ctrl_ctrlb_inv_clk_a_inv_clk_clk_via_tg_d_ctrl_tg_d_ctrl_via_tg_fbm_ctrlb_tg_fbm_ctrlb_via_tg_fbs_ctrl_tg_fbs_ctrl_via_tg_s_ctrlb_tg_s_ctrlb_via_t1 r0 *1 0,0
Ra_clk_ctrl_ctrlb_inv_clk_a_inv_clk_clk_via_tg_d_ctrl_tg_d_ctrl_via_tg_fbm_ctrlb_tg_fbm_ctrlb_via_tg_fbs_ctrl_tg_fbs_ctrl_via_tg_s_ctrlb_tg_s_ctrlb_via_t1
+ a\x7cclk\x7cctrl\x7cctrlb\x7cinv_clk_a\x7cinv_clk_clk_via\x7ctg_d_ctrl\x7ctg_d_ctrl_via\x7ctg_fbm_ctrlb\x7ctg_fbm_ctrlb_via\x7ctg_fbs_ctrl\x7ctg_fbs_ctrl_via\x7ctg_s_ctrlb\x7ctg_s_ctrlb_via__t1
+ a|clk|ctrl|ctrlb|inv_clk_a|inv_clk_clk_via|tg_d_ctrl|tg_d_ctrl_via|tg_fbm_ctrlb|tg_fbm_ctrlb_via|tg_fbs_ctrl|tg_fbs_ctrl_via|tg_s_ctrlb|tg_s_ctrlb_via
+ 211.852856161
* device instance a_clk_ctrl_ctrlb_inv_clk_a_inv_clk_clk_via_tg_d_ctrl_tg_d_ctrl_via_tg_fbm_ctrlb_tg_fbm_ctrlb_via_tg_fbs_ctrl_tg_fbs_ctrl_via_tg_s_ctrlb_tg_s_ctrlb_via_t2 r0 *1 0,0
Ra_clk_ctrl_ctrlb_inv_clk_a_inv_clk_clk_via_tg_d_ctrl_tg_d_ctrl_via_tg_fbm_ctrlb_tg_fbm_ctrlb_via_tg_fbs_ctrl_tg_fbs_ctrl_via_tg_s_ctrlb_tg_s_ctrlb_via_t2
+ a\x7cclk\x7cctrl\x7cctrlb\x7cinv_clk_a\x7cinv_clk_clk_via\x7ctg_d_ctrl\x7ctg_d_ctrl_via\x7ctg_fbm_ctrlb\x7ctg_fbm_ctrlb_via\x7ctg_fbs_ctrl\x7ctg_fbs_ctrl_via\x7ctg_s_ctrlb\x7ctg_s_ctrlb_via__t2
+ a|clk|ctrl|ctrlb|inv_clk_a|inv_clk_clk_via|tg_d_ctrl|tg_d_ctrl_via|tg_fbm_ctrlb|tg_fbm_ctrlb_via|tg_fbs_ctrl|tg_fbs_ctrl_via|tg_s_ctrlb|tg_s_ctrlb_via
+ 498.124552601
* device instance a_clk_ctrl_ctrlb_inv_clk_a_inv_clk_clk_via_tg_d_ctrl_tg_d_ctrl_via_tg_fbm_ctrlb_tg_fbm_ctrlb_via_tg_fbs_ctrl_tg_fbs_ctrl_via_tg_s_ctrlb_tg_s_ctrlb_via_t3 r0 *1 0,0
Ra_clk_ctrl_ctrlb_inv_clk_a_inv_clk_clk_via_tg_d_ctrl_tg_d_ctrl_via_tg_fbm_ctrlb_tg_fbm_ctrlb_via_tg_fbs_ctrl_tg_fbs_ctrl_via_tg_s_ctrlb_tg_s_ctrlb_via_t3
+ a\x7cclk\x7cctrl\x7cctrlb\x7cinv_clk_a\x7cinv_clk_clk_via\x7ctg_d_ctrl\x7ctg_d_ctrl_via\x7ctg_fbm_ctrlb\x7ctg_fbm_ctrlb_via\x7ctg_fbs_ctrl\x7ctg_fbs_ctrl_via\x7ctg_s_ctrlb\x7ctg_s_ctrlb_via__t3
+ a|clk|ctrl|ctrlb|inv_clk_a|inv_clk_clk_via|tg_d_ctrl|tg_d_ctrl_via|tg_fbm_ctrlb|tg_fbm_ctrlb_via|tg_fbs_ctrl|tg_fbs_ctrl_via|tg_s_ctrlb|tg_s_ctrlb_via
+ 288.510437213
* device instance a_clk_ctrl_ctrlb_inv_clk_a_inv_clk_clk_via_tg_d_ctrl_tg_d_ctrl_via_tg_fbm_ctrlb_tg_fbm_ctrlb_via_tg_fbs_ctrl_tg_fbs_ctrl_via_tg_s_ctrlb_tg_s_ctrlb_via_t4 r0 *1 0,0
Ra_clk_ctrl_ctrlb_inv_clk_a_inv_clk_clk_via_tg_d_ctrl_tg_d_ctrl_via_tg_fbm_ctrlb_tg_fbm_ctrlb_via_tg_fbs_ctrl_tg_fbs_ctrl_via_tg_s_ctrlb_tg_s_ctrlb_via_t4
+ a\x7cclk\x7cctrl\x7cctrlb\x7cinv_clk_a\x7cinv_clk_clk_via\x7ctg_d_ctrl\x7ctg_d_ctrl_via\x7ctg_fbm_ctrlb\x7ctg_fbm_ctrlb_via\x7ctg_fbs_ctrl\x7ctg_fbs_ctrl_via\x7ctg_s_ctrlb\x7ctg_s_ctrlb_via__t4
+ a|clk|ctrl|ctrlb|inv_clk_a|inv_clk_clk_via|tg_d_ctrl|tg_d_ctrl_via|tg_fbm_ctrlb|tg_fbm_ctrlb_via|tg_fbs_ctrl|tg_fbs_ctrl_via|tg_s_ctrlb|tg_s_ctrlb_via
+ 187.158157247
* device instance a_clk_ctrl_ctrlb_inv_clk_a_inv_clk_clk_via_tg_d_ctrl_tg_d_ctrl_via_tg_fbm_ctrlb_tg_fbm_ctrlb_via_tg_fbs_ctrl_tg_fbs_ctrl_via_tg_s_ctrlb_tg_s_ctrlb_via_t5 r0 *1 0,0
Ra_clk_ctrl_ctrlb_inv_clk_a_inv_clk_clk_via_tg_d_ctrl_tg_d_ctrl_via_tg_fbm_ctrlb_tg_fbm_ctrlb_via_tg_fbs_ctrl_tg_fbs_ctrl_via_tg_s_ctrlb_tg_s_ctrlb_via_t5
+ a\x7cclk\x7cctrl\x7cctrlb\x7cinv_clk_a\x7cinv_clk_clk_via\x7ctg_d_ctrl\x7ctg_d_ctrl_via\x7ctg_fbm_ctrlb\x7ctg_fbm_ctrlb_via\x7ctg_fbs_ctrl\x7ctg_fbs_ctrl_via\x7ctg_s_ctrlb\x7ctg_s_ctrlb_via__t5
+ a|clk|ctrl|ctrlb|inv_clk_a|inv_clk_clk_via|tg_d_ctrl|tg_d_ctrl_via|tg_fbm_ctrlb|tg_fbm_ctrlb_via|tg_fbs_ctrl|tg_fbs_ctrl_via|tg_s_ctrlb|tg_s_ctrlb_via
+ 105.514159565
* device instance a_clk_ctrl_ctrlb_inv_clk_a_inv_clk_clk_via_tg_d_ctrl_tg_d_ctrl_via_tg_fbm_ctrlb_tg_fbm_ctrlb_via_tg_fbs_ctrl_tg_fbs_ctrl_via_tg_s_ctrlb_tg_s_ctrlb_via r0 *1 0,0
Ca_clk_ctrl_ctrlb_inv_clk_a_inv_clk_clk_via_tg_d_ctrl_tg_d_ctrl_via_tg_fbm_ctrlb_tg_fbm_ctrlb_via_tg_fbs_ctrl_tg_fbs_ctrl_via_tg_s_ctrlb_tg_s_ctrlb_via
+ a|clk|ctrl|ctrlb|inv_clk_a|inv_clk_clk_via|tg_d_ctrl|tg_d_ctrl_via|tg_fbm_ctrlb|tg_fbm_ctrlb_via|tg_fbs_ctrl|tg_fbs_ctrl_via|tg_s_ctrlb|tg_s_ctrlb_via
+ vsubs 7.213055e-15
* device instance a_d_tg_d_a_t0 r0 *1 0,0
Ra_d_tg_d_a_t0 a\x7cd\x7ctg_d_a__t0 a|d|tg_d_a 207.64565
* device instance a_d_tg_d_a_t1 r0 *1 0,0
Ra_d_tg_d_a_t1 a\x7cd\x7ctg_d_a__t1 a|d|tg_d_a 207.64565
* device instance a_d_tg_d_a r0 *1 0,0
Ca_d_tg_d_a a|d|tg_d_a vsubs 6.0717e-16
* device instance a_inv_mc_a_mb_mnab_y_mpa_y_mpb_y_nand_m_y_tg_s_a_y_t0 r0 *1 0,0
Ra_inv_mc_a_mb_mnab_y_mpa_y_mpb_y_nand_m_y_tg_s_a_y_t0
+ a\x7cinv_mc_a\x7cmb\x7cmnab_y\x7cmpa_y\x7cmpb_y\x7cnand_m_y\x7ctg_s_a\x7cy__t0
+ a|inv_mc_a|mb|mnab_y|mpa_y|mpb_y|nand_m_y|tg_s_a|y 47.2529843038
* device instance a_inv_mc_a_mb_mnab_y_mpa_y_mpb_y_nand_m_y_tg_s_a_y_t1 r0 *1 0,0
Ra_inv_mc_a_mb_mnab_y_mpa_y_mpb_y_nand_m_y_tg_s_a_y_t1
+ a\x7cinv_mc_a\x7cmb\x7cmnab_y\x7cmpa_y\x7cmpb_y\x7cnand_m_y\x7ctg_s_a\x7cy__t1
+ a|inv_mc_a|mb|mnab_y|mpa_y|mpb_y|nand_m_y|tg_s_a|y 246.866973374
* device instance a_inv_mc_a_mb_mnab_y_mpa_y_mpb_y_nand_m_y_tg_s_a_y_t2 r0 *1 0,0
Ra_inv_mc_a_mb_mnab_y_mpa_y_mpb_y_nand_m_y_tg_s_a_y_t2
+ a\x7cinv_mc_a\x7cmb\x7cmnab_y\x7cmpa_y\x7cmpb_y\x7cnand_m_y\x7ctg_s_a\x7cy__t2
+ a|inv_mc_a|mb|mnab_y|mpa_y|mpb_y|nand_m_y|tg_s_a|y 167.430274441
* device instance a_inv_mc_a_mb_mnab_y_mpa_y_mpb_y_nand_m_y_tg_s_a_y_t3 r0 *1 0,0
Ra_inv_mc_a_mb_mnab_y_mpa_y_mpb_y_nand_m_y_tg_s_a_y_t3
+ a\x7cinv_mc_a\x7cmb\x7cmnab_y\x7cmpa_y\x7cmpb_y\x7cnand_m_y\x7ctg_s_a\x7cy__t3
+ a|inv_mc_a|mb|mnab_y|mpa_y|mpb_y|nand_m_y|tg_s_a|y 33.0352460576
* device instance a_inv_mc_a_mb_mnab_y_mpa_y_mpb_y_nand_m_y_tg_s_a_y_t4 r0 *1 0,0
Ra_inv_mc_a_mb_mnab_y_mpa_y_mpb_y_nand_m_y_tg_s_a_y_t4
+ a\x7cinv_mc_a\x7cmb\x7cmnab_y\x7cmpa_y\x7cmpb_y\x7cnand_m_y\x7ctg_s_a\x7cy__t4
+ a|inv_mc_a|mb|mnab_y|mpa_y|mpb_y|nand_m_y|tg_s_a|y 244.54403591
* device instance a_inv_mc_a_mb_mnab_y_mpa_y_mpb_y_nand_m_y_tg_s_a_y_t5 r0 *1 0,0
Ra_inv_mc_a_mb_mnab_y_mpa_y_mpb_y_nand_m_y_tg_s_a_y_t5
+ a\x7cinv_mc_a\x7cmb\x7cmnab_y\x7cmpa_y\x7cmpb_y\x7cnand_m_y\x7ctg_s_a\x7cy__t5
+ a|inv_mc_a|mb|mnab_y|mpa_y|mpb_y|nand_m_y|tg_s_a|y 155.253663787
* device instance a_inv_mc_a_mb_mnab_y_mpa_y_mpb_y_nand_m_y_tg_s_a_y_t6 r0 *1 0,0
Ra_inv_mc_a_mb_mnab_y_mpa_y_mpb_y_nand_m_y_tg_s_a_y_t6
+ a\x7cinv_mc_a\x7cmb\x7cmnab_y\x7cmpa_y\x7cmpb_y\x7cnand_m_y\x7ctg_s_a\x7cy__t6
+ a|inv_mc_a|mb|mnab_y|mpa_y|mpb_y|nand_m_y|tg_s_a|y 185.501222126
* device instance a_inv_mc_a_mb_mnab_y_mpa_y_mpb_y_nand_m_y_tg_s_a_y r0 *1 0,0
Ca_inv_mc_a_mb_mnab_y_mpa_y_mpb_y_nand_m_y_tg_s_a_y
+ a|inv_mc_a|mb|mnab_y|mpa_y|mpb_y|nand_m_y|tg_s_a|y vsubs 4.013475e-15
* device instance a_inv_mc_y_inv_mc_y_via_mc_tg_fbm_a_tg_fbm_a_via_y_t0 r0 *1 0,0
Ra_inv_mc_y_inv_mc_y_via_mc_tg_fbm_a_tg_fbm_a_via_y_t0
+ a\x7cinv_mc_y\x7cinv_mc_y_via\x7cmc\x7ctg_fbm_a\x7ctg_fbm_a_via\x7cy__t0
+ a|inv_mc_y|inv_mc_y_via|mc|tg_fbm_a|tg_fbm_a_via|y 214.9829
* device instance a_inv_mc_y_inv_mc_y_via_mc_tg_fbm_a_tg_fbm_a_via_y_t1 r0 *1 0,0
Ra_inv_mc_y_inv_mc_y_via_mc_tg_fbm_a_tg_fbm_a_via_y_t1
+ a\x7cinv_mc_y\x7cinv_mc_y_via\x7cmc\x7ctg_fbm_a\x7ctg_fbm_a_via\x7cy__t1
+ a|inv_mc_y|inv_mc_y_via|mc|tg_fbm_a|tg_fbm_a_via|y 214.9829
* device instance a_inv_mc_y_inv_mc_y_via_mc_tg_fbm_a_tg_fbm_a_via_y_t2 r0 *1 0,0
Ra_inv_mc_y_inv_mc_y_via_mc_tg_fbm_a_tg_fbm_a_via_y_t2
+ a\x7cinv_mc_y\x7cinv_mc_y_via\x7cmc\x7ctg_fbm_a\x7ctg_fbm_a_via\x7cy__t2
+ a|inv_mc_y|inv_mc_y_via|mc|tg_fbm_a|tg_fbm_a_via|y 214.9829
* device instance a_inv_mc_y_inv_mc_y_via_mc_tg_fbm_a_tg_fbm_a_via_y_t3 r0 *1 0,0
Ra_inv_mc_y_inv_mc_y_via_mc_tg_fbm_a_tg_fbm_a_via_y_t3
+ a\x7cinv_mc_y\x7cinv_mc_y_via\x7cmc\x7ctg_fbm_a\x7ctg_fbm_a_via\x7cy__t3
+ a|inv_mc_y|inv_mc_y_via|mc|tg_fbm_a|tg_fbm_a_via|y 214.9829
* device instance a_inv_mc_y_inv_mc_y_via_mc_tg_fbm_a_tg_fbm_a_via_y r0 *1 0,0
Ca_inv_mc_y_inv_mc_y_via_mc_tg_fbm_a_tg_fbm_a_via_y
+ a|inv_mc_y|inv_mc_y_via|mc|tg_fbm_a|tg_fbm_a_via|y vsubs 1.955756e-15
* device instance a_inv_q_y_inv_q_y_via_inv_q_y_via2_nand_s2_a_nand_s2_a_stub_nand_s2_a_via_nand_s2_a_via2_q_y_t0 r0 *1 0,0
Ra_inv_q_y_inv_q_y_via_inv_q_y_via2_nand_s2_a_nand_s2_a_stub_nand_s2_a_via_nand_s2_a_via2_q_y_t0
+ a\x7cinv_q_y\x7cinv_q_y_via\x7cinv_q_y_via2\x7cnand_s2_a\x7cnand_s2_a_stub\x7cnand_s2_a_via\x7cnand_s2_a_via2\x7cq\x7cy__t0
+ a|inv_q_y|inv_q_y_via|inv_q_y_via2|nand_s2_a|nand_s2_a_stub|nand_s2_a_via|nand_s2_a_via2|q|y
+ 234.34304473
* device instance a_inv_q_y_inv_q_y_via_inv_q_y_via2_nand_s2_a_nand_s2_a_stub_nand_s2_a_via_nand_s2_a_via2_q_y_t1 r0 *1 0,0
Ra_inv_q_y_inv_q_y_via_inv_q_y_via2_nand_s2_a_nand_s2_a_stub_nand_s2_a_via_nand_s2_a_via2_q_y_t1
+ a\x7cinv_q_y\x7cinv_q_y_via\x7cinv_q_y_via2\x7cnand_s2_a\x7cnand_s2_a_stub\x7cnand_s2_a_via\x7cnand_s2_a_via2\x7cq\x7cy__t1
+ a|inv_q_y|inv_q_y_via|inv_q_y_via2|nand_s2_a|nand_s2_a_stub|nand_s2_a_via|nand_s2_a_via2|q|y
+ 243.131837768
* device instance a_inv_q_y_inv_q_y_via_inv_q_y_via2_nand_s2_a_nand_s2_a_stub_nand_s2_a_via_nand_s2_a_via2_q_y_t2 r0 *1 0,0
Ra_inv_q_y_inv_q_y_via_inv_q_y_via2_nand_s2_a_nand_s2_a_stub_nand_s2_a_via_nand_s2_a_via2_q_y_t2
+ a\x7cinv_q_y\x7cinv_q_y_via\x7cinv_q_y_via2\x7cnand_s2_a\x7cnand_s2_a_stub\x7cnand_s2_a_via\x7cnand_s2_a_via2\x7cq\x7cy__t2
+ a|inv_q_y|inv_q_y_via|inv_q_y_via2|nand_s2_a|nand_s2_a_stub|nand_s2_a_via|nand_s2_a_via2|q|y
+ 259.625692045
* device instance a_inv_q_y_inv_q_y_via_inv_q_y_via2_nand_s2_a_nand_s2_a_stub_nand_s2_a_via_nand_s2_a_via2_q_y_t3 r0 *1 0,0
Ra_inv_q_y_inv_q_y_via_inv_q_y_via2_nand_s2_a_nand_s2_a_stub_nand_s2_a_via_nand_s2_a_via2_q_y_t3
+ a\x7cinv_q_y\x7cinv_q_y_via\x7cinv_q_y_via2\x7cnand_s2_a\x7cnand_s2_a_stub\x7cnand_s2_a_via\x7cnand_s2_a_via2\x7cq\x7cy__t3
+ a|inv_q_y|inv_q_y_via|inv_q_y_via2|nand_s2_a|nand_s2_a_stub|nand_s2_a_via|nand_s2_a_via2|q|y
+ 245.658725457
* device instance a_inv_q_y_inv_q_y_via_inv_q_y_via2_nand_s2_a_nand_s2_a_stub_nand_s2_a_via_nand_s2_a_via2_q_y r0 *1 0,0
Ca_inv_q_y_inv_q_y_via_inv_q_y_via2_nand_s2_a_nand_s2_a_stub_nand_s2_a_via_nand_s2_a_via2_q_y
+ a|inv_q_y|inv_q_y_via|inv_q_y_via2|nand_s2_a|nand_s2_a_stub|nand_s2_a_via|nand_s2_a_via2|q|y
+ vsubs 2.217373e-15
* device instance a_mnab_y_mpa_y_mpb_y_nand_s2_y_qb_tg_fbs_a_y_t0 r0 *1 0,0
Ra_mnab_y_mpa_y_mpb_y_nand_s2_y_qb_tg_fbs_a_y_t0
+ a\x7cmnab_y\x7cmpa_y\x7cmpb_y\x7cnand_s2_y\x7cqb\x7ctg_fbs_a\x7cy__t0
+ a|mnab_y|mpa_y|mpb_y|nand_s2_y|qb|tg_fbs_a|y 79.2876741218
* device instance a_mnab_y_mpa_y_mpb_y_nand_s2_y_qb_tg_fbs_a_y_t1 r0 *1 0,0
Ra_mnab_y_mpa_y_mpb_y_nand_s2_y_qb_tg_fbs_a_y_t1
+ a\x7cmnab_y\x7cmpa_y\x7cmpb_y\x7cnand_s2_y\x7cqb\x7ctg_fbs_a\x7cy__t1
+ a|mnab_y|mpa_y|mpb_y|nand_s2_y|qb|tg_fbs_a|y 127.509506058
* device instance a_mnab_y_mpa_y_mpb_y_nand_s2_y_qb_tg_fbs_a_y_t2 r0 *1 0,0
Ra_mnab_y_mpa_y_mpb_y_nand_s2_y_qb_tg_fbs_a_y_t2
+ a\x7cmnab_y\x7cmpa_y\x7cmpb_y\x7cnand_s2_y\x7cqb\x7ctg_fbs_a\x7cy__t2
+ a|mnab_y|mpa_y|mpb_y|nand_s2_y|qb|tg_fbs_a|y 118.925454613
* device instance a_mnab_y_mpa_y_mpb_y_nand_s2_y_qb_tg_fbs_a_y_t3 r0 *1 0,0
Ra_mnab_y_mpa_y_mpb_y_nand_s2_y_qb_tg_fbs_a_y_t3
+ a\x7cmnab_y\x7cmpa_y\x7cmpb_y\x7cnand_s2_y\x7cqb\x7ctg_fbs_a\x7cy__t3
+ a|mnab_y|mpa_y|mpb_y|nand_s2_y|qb|tg_fbs_a|y 106.619261369
* device instance a_mnab_y_mpa_y_mpb_y_nand_s2_y_qb_tg_fbs_a_y_t4 r0 *1 0,0
Ra_mnab_y_mpa_y_mpb_y_nand_s2_y_qb_tg_fbs_a_y_t4
+ a\x7cmnab_y\x7cmpa_y\x7cmpb_y\x7cnand_s2_y\x7cqb\x7ctg_fbs_a\x7cy__t4
+ a|mnab_y|mpa_y|mpb_y|nand_s2_y|qb|tg_fbs_a|y 141.656603839
* device instance a_mnab_y_mpa_y_mpb_y_nand_s2_y_qb_tg_fbs_a_y r0 *1 0,0
Ca_mnab_y_mpa_y_mpb_y_nand_s2_y_qb_tg_fbs_a_y
+ a|mnab_y|mpa_y|mpb_y|nand_s2_y|qb|tg_fbs_a|y vsubs 2.242968e-15
* device instance clkb_clkb_bridge1_clkb_bridge2_clkb_mid_clkb_w_ctrl_ctrlb_inv_clk_y_tg_d_ctrlb_tg_fbm_ctrl_tg_fbs_ctrlb_tg_s_ctrl_y_t0 r0 *1 0,0
Rclkb_clkb_bridge1_clkb_bridge2_clkb_mid_clkb_w_ctrl_ctrlb_inv_clk_y_tg_d_ctrlb_tg_fbm_ctrl_tg_fbs_ctrlb_tg_s_ctrl_y_t0
+ clkb\x7cclkb_bridge1\x7cclkb_bridge2\x7cclkb_mid\x7cclkb_w\x7cctrl\x7cctrlb\x7cinv_clk_y\x7ctg_d_ctrlb\x7ctg_fbm_ctrl\x7ctg_fbs_ctrlb\x7ctg_s_ctrl\x7cy__t0
+ clkb|clkb_bridge1|clkb_bridge2|clkb_mid|clkb_w|ctrl|ctrlb|inv_clk_y|tg_d_ctrlb|tg_fbm_ctrl|tg_fbs_ctrlb|tg_s_ctrl|y
+ 259.586366866
* device instance clkb_clkb_bridge1_clkb_bridge2_clkb_mid_clkb_w_ctrl_ctrlb_inv_clk_y_tg_d_ctrlb_tg_fbm_ctrl_tg_fbs_ctrlb_tg_s_ctrl_y_t1 r0 *1 0,0
Rclkb_clkb_bridge1_clkb_bridge2_clkb_mid_clkb_w_ctrl_ctrlb_inv_clk_y_tg_d_ctrlb_tg_fbm_ctrl_tg_fbs_ctrlb_tg_s_ctrl_y_t1
+ clkb\x7cclkb_bridge1\x7cclkb_bridge2\x7cclkb_mid\x7cclkb_w\x7cctrl\x7cctrlb\x7cinv_clk_y\x7ctg_d_ctrlb\x7ctg_fbm_ctrl\x7ctg_fbs_ctrlb\x7ctg_s_ctrl\x7cy__t1
+ clkb|clkb_bridge1|clkb_bridge2|clkb_mid|clkb_w|ctrl|ctrlb|inv_clk_y|tg_d_ctrlb|tg_fbm_ctrl|tg_fbs_ctrlb|tg_s_ctrl|y
+ 94.93603628
* device instance clkb_clkb_bridge1_clkb_bridge2_clkb_mid_clkb_w_ctrl_ctrlb_inv_clk_y_tg_d_ctrlb_tg_fbm_ctrl_tg_fbs_ctrlb_tg_s_ctrl_y_t2 r0 *1 0,0
Rclkb_clkb_bridge1_clkb_bridge2_clkb_mid_clkb_w_ctrl_ctrlb_inv_clk_y_tg_d_ctrlb_tg_fbm_ctrl_tg_fbs_ctrlb_tg_s_ctrl_y_t2
+ clkb\x7cclkb_bridge1\x7cclkb_bridge2\x7cclkb_mid\x7cclkb_w\x7cctrl\x7cctrlb\x7cinv_clk_y\x7ctg_d_ctrlb\x7ctg_fbm_ctrl\x7ctg_fbs_ctrlb\x7ctg_s_ctrl\x7cy__t2
+ clkb|clkb_bridge1|clkb_bridge2|clkb_mid|clkb_w|ctrl|ctrlb|inv_clk_y|tg_d_ctrlb|tg_fbm_ctrl|tg_fbs_ctrlb|tg_s_ctrl|y
+ 168.394968787
* device instance clkb_clkb_bridge1_clkb_bridge2_clkb_mid_clkb_w_ctrl_ctrlb_inv_clk_y_tg_d_ctrlb_tg_fbm_ctrl_tg_fbs_ctrlb_tg_s_ctrl_y_t3 r0 *1 0,0
Rclkb_clkb_bridge1_clkb_bridge2_clkb_mid_clkb_w_ctrl_ctrlb_inv_clk_y_tg_d_ctrlb_tg_fbm_ctrl_tg_fbs_ctrlb_tg_s_ctrl_y_t3
+ clkb\x7cclkb_bridge1\x7cclkb_bridge2\x7cclkb_mid\x7cclkb_w\x7cctrl\x7cctrlb\x7cinv_clk_y\x7ctg_d_ctrlb\x7ctg_fbm_ctrl\x7ctg_fbs_ctrlb\x7ctg_s_ctrl\x7cy__t3
+ clkb|clkb_bridge1|clkb_bridge2|clkb_mid|clkb_w|ctrl|ctrlb|inv_clk_y|tg_d_ctrlb|tg_fbm_ctrl|tg_fbs_ctrlb|tg_s_ctrl|y
+ 259.586366866
* device instance clkb_clkb_bridge1_clkb_bridge2_clkb_mid_clkb_w_ctrl_ctrlb_inv_clk_y_tg_d_ctrlb_tg_fbm_ctrl_tg_fbs_ctrlb_tg_s_ctrl_y_t4 r0 *1 0,0
Rclkb_clkb_bridge1_clkb_bridge2_clkb_mid_clkb_w_ctrl_ctrlb_inv_clk_y_tg_d_ctrlb_tg_fbm_ctrl_tg_fbs_ctrlb_tg_s_ctrl_y_t4
+ clkb\x7cclkb_bridge1\x7cclkb_bridge2\x7cclkb_mid\x7cclkb_w\x7cctrl\x7cctrlb\x7cinv_clk_y\x7ctg_d_ctrlb\x7ctg_fbm_ctrl\x7ctg_fbs_ctrlb\x7ctg_s_ctrl\x7cy__t4
+ clkb|clkb_bridge1|clkb_bridge2|clkb_mid|clkb_w|ctrl|ctrlb|inv_clk_y|tg_d_ctrlb|tg_fbm_ctrl|tg_fbs_ctrlb|tg_s_ctrl|y
+ 448.186014016
* device instance clkb_clkb_bridge1_clkb_bridge2_clkb_mid_clkb_w_ctrl_ctrlb_inv_clk_y_tg_d_ctrlb_tg_fbm_ctrl_tg_fbs_ctrlb_tg_s_ctrl_y_t5 r0 *1 0,0
Rclkb_clkb_bridge1_clkb_bridge2_clkb_mid_clkb_w_ctrl_ctrlb_inv_clk_y_tg_d_ctrlb_tg_fbm_ctrl_tg_fbs_ctrlb_tg_s_ctrl_y_t5
+ clkb\x7cclkb_bridge1\x7cclkb_bridge2\x7cclkb_mid\x7cclkb_w\x7cctrl\x7cctrlb\x7cinv_clk_y\x7ctg_d_ctrlb\x7ctg_fbm_ctrl\x7ctg_fbs_ctrlb\x7ctg_s_ctrl\x7cy__t5
+ clkb|clkb_bridge1|clkb_bridge2|clkb_mid|clkb_w|ctrl|ctrlb|inv_clk_y|tg_d_ctrlb|tg_fbm_ctrl|tg_fbs_ctrlb|tg_s_ctrl|y
+ 190.613947185
* device instance clkb_clkb_bridge1_clkb_bridge2_clkb_mid_clkb_w_ctrl_ctrlb_inv_clk_y_tg_d_ctrlb_tg_fbm_ctrl_tg_fbs_ctrlb_tg_s_ctrl_y r0 *1 0,0
Cclkb_clkb_bridge1_clkb_bridge2_clkb_mid_clkb_w_ctrl_ctrlb_inv_clk_y_tg_d_ctrlb_tg_fbm_ctrl_tg_fbs_ctrlb_tg_s_ctrl_y
+ clkb|clkb_bridge1|clkb_bridge2|clkb_mid|clkb_w|ctrl|ctrlb|inv_clk_y|tg_d_ctrlb|tg_fbm_ctrl|tg_fbs_ctrlb|tg_s_ctrl|y
+ vsubs 6.708136e-15
* device instance en_nand_m_en_nand_m_en_via_nand_s2_en_nand_s2_en_via_rst_n_t0 r0 *1 0,0
Ren_nand_m_en_nand_m_en_via_nand_s2_en_nand_s2_en_via_rst_n_t0
+ en\x7cnand_m_en\x7cnand_m_en_via\x7cnand_s2_en\x7cnand_s2_en_via\x7crst_n__t0
+ en|nand_m_en|nand_m_en_via|nand_s2_en|nand_s2_en_via|rst_n 267.389052661
* device instance en_nand_m_en_nand_m_en_via_nand_s2_en_nand_s2_en_via_rst_n_t1 r0 *1 0,0
Ren_nand_m_en_nand_m_en_via_nand_s2_en_nand_s2_en_via_rst_n_t1
+ en\x7cnand_m_en\x7cnand_m_en_via\x7cnand_s2_en\x7cnand_s2_en_via\x7crst_n__t1
+ en|nand_m_en|nand_m_en_via|nand_s2_en|nand_s2_en_via|rst_n 270.832147339
* device instance en_nand_m_en_nand_m_en_via_nand_s2_en_nand_s2_en_via_rst_n_t2 r0 *1 0,0
Ren_nand_m_en_nand_m_en_via_nand_s2_en_nand_s2_en_via_rst_n_t2
+ en\x7cnand_m_en\x7cnand_m_en_via\x7cnand_s2_en\x7cnand_s2_en_via\x7crst_n__t2
+ en|nand_m_en|nand_m_en_via|nand_s2_en|nand_s2_en_via|rst_n 270.832147339
* device instance en_nand_m_en_nand_m_en_via_nand_s2_en_nand_s2_en_via_rst_n_t3 r0 *1 0,0
Ren_nand_m_en_nand_m_en_via_nand_s2_en_nand_s2_en_via_rst_n_t3
+ en\x7cnand_m_en\x7cnand_m_en_via\x7cnand_s2_en\x7cnand_s2_en_via\x7crst_n__t3
+ en|nand_m_en|nand_m_en_via|nand_s2_en|nand_s2_en_via|rst_n 267.389052661
* device instance en_nand_m_en_nand_m_en_via_nand_s2_en_nand_s2_en_via_rst_n r0 *1 0,0
Cen_nand_m_en_nand_m_en_via_nand_s2_en_nand_s2_en_via_rst_n
+ en|nand_m_en|nand_m_en_via|nand_s2_en|nand_s2_en_via|rst_n vsubs 3.866751e-15
* device instance inv_clk_vdd_inv_mc_vdd_inv_q_vdd_mpa_py_mpb_py_nand_m_vdd_nand_s2_vdd_nwell_vdd_tg_d_vdd_tg_fbm_vdd_tg_fbs_vdd_tg_s_vdd_vdd_t0 r0 *1 0,0
Rinv_clk_vdd_inv_mc_vdd_inv_q_vdd_mpa_py_mpb_py_nand_m_vdd_nand_s2_vdd_nwell_vdd_tg_d_vdd_tg_fbm_vdd_tg_fbs_vdd_tg_s_vdd_vdd_t0
+ inv_clk_vdd\x7cinv_mc_vdd\x7cinv_q_vdd\x7cmpa_py\x7cmpb_py\x7cnand_m_vdd\x7cnand_s2_vdd\x7cnwell_vdd\x7ctg_d_vdd\x7ctg_fbm_vdd\x7ctg_fbs_vdd\x7ctg_s_vdd\x7cvdd__t0
+ inv_clk_vdd|inv_mc_vdd|inv_q_vdd|mpa_py|mpb_py|nand_m_vdd|nand_s2_vdd|nwell_vdd|tg_d_vdd|tg_fbm_vdd|tg_fbs_vdd|tg_s_vdd|vdd
+ 186.638720992
* device instance inv_clk_vdd_inv_mc_vdd_inv_q_vdd_mpa_py_mpb_py_nand_m_vdd_nand_s2_vdd_nwell_vdd_tg_d_vdd_tg_fbm_vdd_tg_fbs_vdd_tg_s_vdd_vdd_t1 r0 *1 0,0
Rinv_clk_vdd_inv_mc_vdd_inv_q_vdd_mpa_py_mpb_py_nand_m_vdd_nand_s2_vdd_nwell_vdd_tg_d_vdd_tg_fbm_vdd_tg_fbs_vdd_tg_s_vdd_vdd_t1
+ inv_clk_vdd\x7cinv_mc_vdd\x7cinv_q_vdd\x7cmpa_py\x7cmpb_py\x7cnand_m_vdd\x7cnand_s2_vdd\x7cnwell_vdd\x7ctg_d_vdd\x7ctg_fbm_vdd\x7ctg_fbs_vdd\x7ctg_s_vdd\x7cvdd__t1
+ inv_clk_vdd|inv_mc_vdd|inv_q_vdd|mpa_py|mpb_py|nand_m_vdd|nand_s2_vdd|nwell_vdd|tg_d_vdd|tg_fbm_vdd|tg_fbs_vdd|tg_s_vdd|vdd
+ 150.11138613
* device instance inv_clk_vdd_inv_mc_vdd_inv_q_vdd_mpa_py_mpb_py_nand_m_vdd_nand_s2_vdd_nwell_vdd_tg_d_vdd_tg_fbm_vdd_tg_fbs_vdd_tg_s_vdd_vdd_t2 r0 *1 0,0
Rinv_clk_vdd_inv_mc_vdd_inv_q_vdd_mpa_py_mpb_py_nand_m_vdd_nand_s2_vdd_nwell_vdd_tg_d_vdd_tg_fbm_vdd_tg_fbs_vdd_tg_s_vdd_vdd_t2
+ inv_clk_vdd\x7cinv_mc_vdd\x7cinv_q_vdd\x7cmpa_py\x7cmpb_py\x7cnand_m_vdd\x7cnand_s2_vdd\x7cnwell_vdd\x7ctg_d_vdd\x7ctg_fbm_vdd\x7ctg_fbs_vdd\x7ctg_s_vdd\x7cvdd__t2
+ inv_clk_vdd|inv_mc_vdd|inv_q_vdd|mpa_py|mpb_py|nand_m_vdd|nand_s2_vdd|nwell_vdd|tg_d_vdd|tg_fbm_vdd|tg_fbs_vdd|tg_s_vdd|vdd
+ 38.7701373513
* device instance inv_clk_vdd_inv_mc_vdd_inv_q_vdd_mpa_py_mpb_py_nand_m_vdd_nand_s2_vdd_nwell_vdd_tg_d_vdd_tg_fbm_vdd_tg_fbs_vdd_tg_s_vdd_vdd_t3 r0 *1 0,0
Rinv_clk_vdd_inv_mc_vdd_inv_q_vdd_mpa_py_mpb_py_nand_m_vdd_nand_s2_vdd_nwell_vdd_tg_d_vdd_tg_fbm_vdd_tg_fbs_vdd_tg_s_vdd_vdd_t3
+ inv_clk_vdd\x7cinv_mc_vdd\x7cinv_q_vdd\x7cmpa_py\x7cmpb_py\x7cnand_m_vdd\x7cnand_s2_vdd\x7cnwell_vdd\x7ctg_d_vdd\x7ctg_fbm_vdd\x7ctg_fbs_vdd\x7ctg_s_vdd\x7cvdd__t3
+ inv_clk_vdd|inv_mc_vdd|inv_q_vdd|mpa_py|mpb_py|nand_m_vdd|nand_s2_vdd|nwell_vdd|tg_d_vdd|tg_fbm_vdd|tg_fbs_vdd|tg_s_vdd|vdd
+ 2.34755323402
* device instance inv_clk_vdd_inv_mc_vdd_inv_q_vdd_mpa_py_mpb_py_nand_m_vdd_nand_s2_vdd_nwell_vdd_tg_d_vdd_tg_fbm_vdd_tg_fbs_vdd_tg_s_vdd_vdd_t4 r0 *1 0,0
Rinv_clk_vdd_inv_mc_vdd_inv_q_vdd_mpa_py_mpb_py_nand_m_vdd_nand_s2_vdd_nwell_vdd_tg_d_vdd_tg_fbm_vdd_tg_fbs_vdd_tg_s_vdd_vdd_t4
+ inv_clk_vdd\x7cinv_mc_vdd\x7cinv_q_vdd\x7cmpa_py\x7cmpb_py\x7cnand_m_vdd\x7cnand_s2_vdd\x7cnwell_vdd\x7ctg_d_vdd\x7ctg_fbm_vdd\x7ctg_fbs_vdd\x7ctg_s_vdd\x7cvdd__t4
+ inv_clk_vdd|inv_mc_vdd|inv_q_vdd|mpa_py|mpb_py|nand_m_vdd|nand_s2_vdd|nwell_vdd|tg_d_vdd|tg_fbm_vdd|tg_fbs_vdd|tg_s_vdd|vdd
+ 37.173373586
* device instance inv_clk_vdd_inv_mc_vdd_inv_q_vdd_mpa_py_mpb_py_nand_m_vdd_nand_s2_vdd_nwell_vdd_tg_d_vdd_tg_fbm_vdd_tg_fbs_vdd_tg_s_vdd_vdd_t5 r0 *1 0,0
Rinv_clk_vdd_inv_mc_vdd_inv_q_vdd_mpa_py_mpb_py_nand_m_vdd_nand_s2_vdd_nwell_vdd_tg_d_vdd_tg_fbm_vdd_tg_fbs_vdd_tg_s_vdd_vdd_t5
+ inv_clk_vdd\x7cinv_mc_vdd\x7cinv_q_vdd\x7cmpa_py\x7cmpb_py\x7cnand_m_vdd\x7cnand_s2_vdd\x7cnwell_vdd\x7ctg_d_vdd\x7ctg_fbm_vdd\x7ctg_fbs_vdd\x7ctg_s_vdd\x7cvdd__t5
+ inv_clk_vdd|inv_mc_vdd|inv_q_vdd|mpa_py|mpb_py|nand_m_vdd|nand_s2_vdd|nwell_vdd|tg_d_vdd|tg_fbm_vdd|tg_fbs_vdd|tg_s_vdd|vdd
+ 89.3353095793
* device instance inv_clk_vdd_inv_mc_vdd_inv_q_vdd_mpa_py_mpb_py_nand_m_vdd_nand_s2_vdd_nwell_vdd_tg_d_vdd_tg_fbm_vdd_tg_fbs_vdd_tg_s_vdd_vdd_t6 r0 *1 0,0
Rinv_clk_vdd_inv_mc_vdd_inv_q_vdd_mpa_py_mpb_py_nand_m_vdd_nand_s2_vdd_nwell_vdd_tg_d_vdd_tg_fbm_vdd_tg_fbs_vdd_tg_s_vdd_vdd_t6
+ inv_clk_vdd\x7cinv_mc_vdd\x7cinv_q_vdd\x7cmpa_py\x7cmpb_py\x7cnand_m_vdd\x7cnand_s2_vdd\x7cnwell_vdd\x7ctg_d_vdd\x7ctg_fbm_vdd\x7ctg_fbs_vdd\x7ctg_s_vdd\x7cvdd__t6
+ inv_clk_vdd|inv_mc_vdd|inv_q_vdd|mpa_py|mpb_py|nand_m_vdd|nand_s2_vdd|nwell_vdd|tg_d_vdd|tg_fbm_vdd|tg_fbs_vdd|tg_s_vdd|vdd
+ 185.041685409
* device instance inv_clk_vdd_inv_mc_vdd_inv_q_vdd_mpa_py_mpb_py_nand_m_vdd_nand_s2_vdd_nwell_vdd_tg_d_vdd_tg_fbm_vdd_tg_fbs_vdd_tg_s_vdd_vdd_t7 r0 *1 0,0
Rinv_clk_vdd_inv_mc_vdd_inv_q_vdd_mpa_py_mpb_py_nand_m_vdd_nand_s2_vdd_nwell_vdd_tg_d_vdd_tg_fbm_vdd_tg_fbs_vdd_tg_s_vdd_vdd_t7
+ inv_clk_vdd\x7cinv_mc_vdd\x7cinv_q_vdd\x7cmpa_py\x7cmpb_py\x7cnand_m_vdd\x7cnand_s2_vdd\x7cnwell_vdd\x7ctg_d_vdd\x7ctg_fbm_vdd\x7ctg_fbs_vdd\x7ctg_s_vdd\x7cvdd__t7
+ inv_clk_vdd|inv_mc_vdd|inv_q_vdd|mpa_py|mpb_py|nand_m_vdd|nand_s2_vdd|nwell_vdd|tg_d_vdd|tg_fbm_vdd|tg_fbs_vdd|tg_s_vdd|vdd
+ 97.9478072826
* device instance inv_clk_vdd_inv_mc_vdd_inv_q_vdd_mpa_py_mpb_py_nand_m_vdd_nand_s2_vdd_nwell_vdd_tg_d_vdd_tg_fbm_vdd_tg_fbs_vdd_tg_s_vdd_vdd_t8 r0 *1 0,0
Rinv_clk_vdd_inv_mc_vdd_inv_q_vdd_mpa_py_mpb_py_nand_m_vdd_nand_s2_vdd_nwell_vdd_tg_d_vdd_tg_fbm_vdd_tg_fbs_vdd_tg_s_vdd_vdd_t8
+ inv_clk_vdd\x7cinv_mc_vdd\x7cinv_q_vdd\x7cmpa_py\x7cmpb_py\x7cnand_m_vdd\x7cnand_s2_vdd\x7cnwell_vdd\x7ctg_d_vdd\x7ctg_fbm_vdd\x7ctg_fbs_vdd\x7ctg_s_vdd\x7cvdd__t8
+ inv_clk_vdd|inv_mc_vdd|inv_q_vdd|mpa_py|mpb_py|nand_m_vdd|nand_s2_vdd|nwell_vdd|tg_d_vdd|tg_fbm_vdd|tg_fbs_vdd|tg_s_vdd|vdd
+ 88.0593481956
* device instance inv_clk_vdd_inv_mc_vdd_inv_q_vdd_mpa_py_mpb_py_nand_m_vdd_nand_s2_vdd_nwell_vdd_tg_d_vdd_tg_fbm_vdd_tg_fbs_vdd_tg_s_vdd_vdd_t9 r0 *1 0,0
Rinv_clk_vdd_inv_mc_vdd_inv_q_vdd_mpa_py_mpb_py_nand_m_vdd_nand_s2_vdd_nwell_vdd_tg_d_vdd_tg_fbm_vdd_tg_fbs_vdd_tg_s_vdd_vdd_t9
+ inv_clk_vdd\x7cinv_mc_vdd\x7cinv_q_vdd\x7cmpa_py\x7cmpb_py\x7cnand_m_vdd\x7cnand_s2_vdd\x7cnwell_vdd\x7ctg_d_vdd\x7ctg_fbm_vdd\x7ctg_fbs_vdd\x7ctg_s_vdd\x7cvdd__t9
+ inv_clk_vdd|inv_mc_vdd|inv_q_vdd|mpa_py|mpb_py|nand_m_vdd|nand_s2_vdd|nwell_vdd|tg_d_vdd|tg_fbm_vdd|tg_fbs_vdd|tg_s_vdd|vdd
+ 138.626600948
* device instance inv_clk_vdd_inv_mc_vdd_inv_q_vdd_mpa_py_mpb_py_nand_m_vdd_nand_s2_vdd_nwell_vdd_tg_d_vdd_tg_fbm_vdd_tg_fbs_vdd_tg_s_vdd_vdd_t10 r0 *1 0,0
Rinv_clk_vdd_inv_mc_vdd_inv_q_vdd_mpa_py_mpb_py_nand_m_vdd_nand_s2_vdd_nwell_vdd_tg_d_vdd_tg_fbm_vdd_tg_fbs_vdd_tg_s_vdd_vdd_t10
+ inv_clk_vdd\x7cinv_mc_vdd\x7cinv_q_vdd\x7cmpa_py\x7cmpb_py\x7cnand_m_vdd\x7cnand_s2_vdd\x7cnwell_vdd\x7ctg_d_vdd\x7ctg_fbm_vdd\x7ctg_fbs_vdd\x7ctg_s_vdd\x7cvdd__t10
+ inv_clk_vdd|inv_mc_vdd|inv_q_vdd|mpa_py|mpb_py|nand_m_vdd|nand_s2_vdd|nwell_vdd|tg_d_vdd|tg_fbm_vdd|tg_fbs_vdd|tg_s_vdd|vdd
+ 148.515326472
* device instance inv_clk_vdd_inv_mc_vdd_inv_q_vdd_mpa_py_mpb_py_nand_m_vdd_nand_s2_vdd_nwell_vdd_tg_d_vdd_tg_fbm_vdd_tg_fbs_vdd_tg_s_vdd_vdd_t11 r0 *1 0,0
Rinv_clk_vdd_inv_mc_vdd_inv_q_vdd_mpa_py_mpb_py_nand_m_vdd_nand_s2_vdd_nwell_vdd_tg_d_vdd_tg_fbm_vdd_tg_fbs_vdd_tg_s_vdd_vdd_t11
+ inv_clk_vdd\x7cinv_mc_vdd\x7cinv_q_vdd\x7cmpa_py\x7cmpb_py\x7cnand_m_vdd\x7cnand_s2_vdd\x7cnwell_vdd\x7ctg_d_vdd\x7ctg_fbm_vdd\x7ctg_fbs_vdd\x7ctg_s_vdd\x7cvdd__t11
+ inv_clk_vdd|inv_mc_vdd|inv_q_vdd|mpa_py|mpb_py|nand_m_vdd|nand_s2_vdd|nwell_vdd|tg_d_vdd|tg_fbm_vdd|tg_fbs_vdd|tg_s_vdd|vdd
+ 186.638720992
* device instance inv_clk_vdd_inv_mc_vdd_inv_q_vdd_mpa_py_mpb_py_nand_m_vdd_nand_s2_vdd_nwell_vdd_tg_d_vdd_tg_fbm_vdd_tg_fbs_vdd_tg_s_vdd_vdd_t12 r0 *1 0,0
Rinv_clk_vdd_inv_mc_vdd_inv_q_vdd_mpa_py_mpb_py_nand_m_vdd_nand_s2_vdd_nwell_vdd_tg_d_vdd_tg_fbm_vdd_tg_fbs_vdd_tg_s_vdd_vdd_t12
+ inv_clk_vdd\x7cinv_mc_vdd\x7cinv_q_vdd\x7cmpa_py\x7cmpb_py\x7cnand_m_vdd\x7cnand_s2_vdd\x7cnwell_vdd\x7ctg_d_vdd\x7ctg_fbm_vdd\x7ctg_fbs_vdd\x7ctg_s_vdd\x7cvdd__t12
+ inv_clk_vdd|inv_mc_vdd|inv_q_vdd|mpa_py|mpb_py|nand_m_vdd|nand_s2_vdd|nwell_vdd|tg_d_vdd|tg_fbm_vdd|tg_fbs_vdd|tg_s_vdd|vdd
+ 38.7701373513
* device instance inv_clk_vdd_inv_mc_vdd_inv_q_vdd_mpa_py_mpb_py_nand_m_vdd_nand_s2_vdd_nwell_vdd_tg_d_vdd_tg_fbm_vdd_tg_fbs_vdd_tg_s_vdd_vdd_t13 r0 *1 0,0
Rinv_clk_vdd_inv_mc_vdd_inv_q_vdd_mpa_py_mpb_py_nand_m_vdd_nand_s2_vdd_nwell_vdd_tg_d_vdd_tg_fbm_vdd_tg_fbs_vdd_tg_s_vdd_vdd_t13
+ inv_clk_vdd\x7cinv_mc_vdd\x7cinv_q_vdd\x7cmpa_py\x7cmpb_py\x7cnand_m_vdd\x7cnand_s2_vdd\x7cnwell_vdd\x7ctg_d_vdd\x7ctg_fbm_vdd\x7ctg_fbs_vdd\x7ctg_s_vdd\x7cvdd__t13
+ inv_clk_vdd|inv_mc_vdd|inv_q_vdd|mpa_py|mpb_py|nand_m_vdd|nand_s2_vdd|nwell_vdd|tg_d_vdd|tg_fbm_vdd|tg_fbs_vdd|tg_s_vdd|vdd
+ 89.3353095793
* device instance inv_clk_vdd_inv_mc_vdd_inv_q_vdd_mpa_py_mpb_py_nand_m_vdd_nand_s2_vdd_nwell_vdd_tg_d_vdd_tg_fbm_vdd_tg_fbs_vdd_tg_s_vdd_vdd_t14 r0 *1 0,0
Rinv_clk_vdd_inv_mc_vdd_inv_q_vdd_mpa_py_mpb_py_nand_m_vdd_nand_s2_vdd_nwell_vdd_tg_d_vdd_tg_fbm_vdd_tg_fbs_vdd_tg_s_vdd_vdd_t14
+ inv_clk_vdd\x7cinv_mc_vdd\x7cinv_q_vdd\x7cmpa_py\x7cmpb_py\x7cnand_m_vdd\x7cnand_s2_vdd\x7cnwell_vdd\x7ctg_d_vdd\x7ctg_fbm_vdd\x7ctg_fbs_vdd\x7ctg_s_vdd\x7cvdd__t14
+ inv_clk_vdd|inv_mc_vdd|inv_q_vdd|mpa_py|mpb_py|nand_m_vdd|nand_s2_vdd|nwell_vdd|tg_d_vdd|tg_fbm_vdd|tg_fbs_vdd|tg_s_vdd|vdd
+ 97.9478072826
* device instance inv_clk_vdd_inv_mc_vdd_inv_q_vdd_mpa_py_mpb_py_nand_m_vdd_nand_s2_vdd_nwell_vdd_tg_d_vdd_tg_fbm_vdd_tg_fbs_vdd_tg_s_vdd_vdd_t15 r0 *1 0,0
Rinv_clk_vdd_inv_mc_vdd_inv_q_vdd_mpa_py_mpb_py_nand_m_vdd_nand_s2_vdd_nwell_vdd_tg_d_vdd_tg_fbm_vdd_tg_fbs_vdd_tg_s_vdd_vdd_t15
+ inv_clk_vdd\x7cinv_mc_vdd\x7cinv_q_vdd\x7cmpa_py\x7cmpb_py\x7cnand_m_vdd\x7cnand_s2_vdd\x7cnwell_vdd\x7ctg_d_vdd\x7ctg_fbm_vdd\x7ctg_fbs_vdd\x7ctg_s_vdd\x7cvdd__t15
+ inv_clk_vdd|inv_mc_vdd|inv_q_vdd|mpa_py|mpb_py|nand_m_vdd|nand_s2_vdd|nwell_vdd|tg_d_vdd|tg_fbm_vdd|tg_fbs_vdd|tg_s_vdd|vdd
+ 138.626600948
* device instance inv_clk_vdd_inv_mc_vdd_inv_q_vdd_mpa_py_mpb_py_nand_m_vdd_nand_s2_vdd_nwell_vdd_tg_d_vdd_tg_fbm_vdd_tg_fbs_vdd_tg_s_vdd_vdd_t16 r0 *1 0,0
Rinv_clk_vdd_inv_mc_vdd_inv_q_vdd_mpa_py_mpb_py_nand_m_vdd_nand_s2_vdd_nwell_vdd_tg_d_vdd_tg_fbm_vdd_tg_fbs_vdd_tg_s_vdd_vdd_t16
+ inv_clk_vdd\x7cinv_mc_vdd\x7cinv_q_vdd\x7cmpa_py\x7cmpb_py\x7cnand_m_vdd\x7cnand_s2_vdd\x7cnwell_vdd\x7ctg_d_vdd\x7ctg_fbm_vdd\x7ctg_fbs_vdd\x7ctg_s_vdd\x7cvdd__t16
+ inv_clk_vdd|inv_mc_vdd|inv_q_vdd|mpa_py|mpb_py|nand_m_vdd|nand_s2_vdd|nwell_vdd|tg_d_vdd|tg_fbm_vdd|tg_fbs_vdd|tg_s_vdd|vdd
+ 88.0593481956
* device instance inv_clk_vdd_inv_mc_vdd_inv_q_vdd_mpa_py_mpb_py_nand_m_vdd_nand_s2_vdd_nwell_vdd_tg_d_vdd_tg_fbm_vdd_tg_fbs_vdd_tg_s_vdd_vdd_t17 r0 *1 0,0
Rinv_clk_vdd_inv_mc_vdd_inv_q_vdd_mpa_py_mpb_py_nand_m_vdd_nand_s2_vdd_nwell_vdd_tg_d_vdd_tg_fbm_vdd_tg_fbs_vdd_tg_s_vdd_vdd_t17
+ inv_clk_vdd\x7cinv_mc_vdd\x7cinv_q_vdd\x7cmpa_py\x7cmpb_py\x7cnand_m_vdd\x7cnand_s2_vdd\x7cnwell_vdd\x7ctg_d_vdd\x7ctg_fbm_vdd\x7ctg_fbs_vdd\x7ctg_s_vdd\x7cvdd__t17
+ inv_clk_vdd|inv_mc_vdd|inv_q_vdd|mpa_py|mpb_py|nand_m_vdd|nand_s2_vdd|nwell_vdd|tg_d_vdd|tg_fbm_vdd|tg_fbs_vdd|tg_s_vdd|vdd
+ 148.515326472
* device instance inv_clk_vdd_inv_mc_vdd_inv_q_vdd_mpa_py_mpb_py_nand_m_vdd_nand_s2_vdd_nwell_vdd_tg_d_vdd_tg_fbm_vdd_tg_fbs_vdd_tg_s_vdd_vdd r0 *1 0,0
Cinv_clk_vdd_inv_mc_vdd_inv_q_vdd_mpa_py_mpb_py_nand_m_vdd_nand_s2_vdd_nwell_vdd_tg_d_vdd_tg_fbm_vdd_tg_fbs_vdd_tg_s_vdd_vdd
+ inv_clk_vdd|inv_mc_vdd|inv_q_vdd|mpa_py|mpb_py|nand_m_vdd|nand_s2_vdd|nwell_vdd|tg_d_vdd|tg_fbm_vdd|tg_fbs_vdd|tg_s_vdd|vdd
+ vsubs 1.2933798e-14
* device instance inv_clk_vss_inv_mc_vss_inv_q_vss_nand_m_vss_nand_s2_vss_tg_d_vss_tg_fbm_vss_tg_fbs_vss_tg_s_vss_vss_t0 r0 *1 0,0
Rinv_clk_vss_inv_mc_vss_inv_q_vss_nand_m_vss_nand_s2_vss_tg_d_vss_tg_fbm_vss_tg_fbs_vss_tg_s_vss_vss_t0
+ inv_clk_vss\x7cinv_mc_vss\x7cinv_q_vss\x7cnand_m_vss\x7cnand_s2_vss\x7ctg_d_vss\x7ctg_fbm_vss\x7ctg_fbs_vss\x7ctg_s_vss\x7cvss__t0
+ inv_clk_vss|inv_mc_vss|inv_q_vss|nand_m_vss|nand_s2_vss|tg_d_vss|tg_fbm_vss|tg_fbs_vss|tg_s_vss|vss
+ 196.116600933
* device instance inv_clk_vss_inv_mc_vss_inv_q_vss_nand_m_vss_nand_s2_vss_tg_d_vss_tg_fbm_vss_tg_fbs_vss_tg_s_vss_vss_t1 r0 *1 0,0
Rinv_clk_vss_inv_mc_vss_inv_q_vss_nand_m_vss_nand_s2_vss_tg_d_vss_tg_fbm_vss_tg_fbs_vss_tg_s_vss_vss_t1
+ inv_clk_vss\x7cinv_mc_vss\x7cinv_q_vss\x7cnand_m_vss\x7cnand_s2_vss\x7ctg_d_vss\x7ctg_fbm_vss\x7ctg_fbs_vss\x7ctg_s_vss\x7cvss__t1
+ inv_clk_vss|inv_mc_vss|inv_q_vss|nand_m_vss|nand_s2_vss|tg_d_vss|tg_fbm_vss|tg_fbs_vss|tg_s_vss|vss
+ 99.3379250572
* device instance inv_clk_vss_inv_mc_vss_inv_q_vss_nand_m_vss_nand_s2_vss_tg_d_vss_tg_fbm_vss_tg_fbs_vss_tg_s_vss_vss_t2 r0 *1 0,0
Rinv_clk_vss_inv_mc_vss_inv_q_vss_nand_m_vss_nand_s2_vss_tg_d_vss_tg_fbm_vss_tg_fbs_vss_tg_s_vss_vss_t2
+ inv_clk_vss\x7cinv_mc_vss\x7cinv_q_vss\x7cnand_m_vss\x7cnand_s2_vss\x7ctg_d_vss\x7ctg_fbm_vss\x7ctg_fbs_vss\x7ctg_s_vss\x7cvss__t2
+ inv_clk_vss|inv_mc_vss|inv_q_vss|nand_m_vss|nand_s2_vss|tg_d_vss|tg_fbm_vss|tg_fbs_vss|tg_s_vss|vss
+ 154.408033951
* device instance inv_clk_vss_inv_mc_vss_inv_q_vss_nand_m_vss_nand_s2_vss_tg_d_vss_tg_fbm_vss_tg_fbs_vss_tg_s_vss_vss_t3 r0 *1 0,0
Rinv_clk_vss_inv_mc_vss_inv_q_vss_nand_m_vss_nand_s2_vss_tg_d_vss_tg_fbm_vss_tg_fbs_vss_tg_s_vss_vss_t3
+ inv_clk_vss\x7cinv_mc_vss\x7cinv_q_vss\x7cnand_m_vss\x7cnand_s2_vss\x7ctg_d_vss\x7ctg_fbm_vss\x7ctg_fbs_vss\x7ctg_s_vss\x7cvss__t3
+ inv_clk_vss|inv_mc_vss|inv_q_vss|nand_m_vss|nand_s2_vss|tg_d_vss|tg_fbm_vss|tg_fbs_vss|tg_s_vss|vss
+ 99.892942952
* device instance inv_clk_vss_inv_mc_vss_inv_q_vss_nand_m_vss_nand_s2_vss_tg_d_vss_tg_fbm_vss_tg_fbs_vss_tg_s_vss_vss_t4 r0 *1 0,0
Rinv_clk_vss_inv_mc_vss_inv_q_vss_nand_m_vss_nand_s2_vss_tg_d_vss_tg_fbm_vss_tg_fbs_vss_tg_s_vss_vss_t4
+ inv_clk_vss\x7cinv_mc_vss\x7cinv_q_vss\x7cnand_m_vss\x7cnand_s2_vss\x7ctg_d_vss\x7ctg_fbm_vss\x7ctg_fbs_vss\x7ctg_s_vss\x7cvss__t4
+ inv_clk_vss|inv_mc_vss|inv_q_vss|nand_m_vss|nand_s2_vss|tg_d_vss|tg_fbm_vss|tg_fbs_vss|tg_s_vss|vss
+ 37.5048203346
* device instance inv_clk_vss_inv_mc_vss_inv_q_vss_nand_m_vss_nand_s2_vss_tg_d_vss_tg_fbm_vss_tg_fbs_vss_tg_s_vss_vss_t5 r0 *1 0,0
Rinv_clk_vss_inv_mc_vss_inv_q_vss_nand_m_vss_nand_s2_vss_tg_d_vss_tg_fbm_vss_tg_fbs_vss_tg_s_vss_vss_t5
+ inv_clk_vss\x7cinv_mc_vss\x7cinv_q_vss\x7cnand_m_vss\x7cnand_s2_vss\x7ctg_d_vss\x7ctg_fbm_vss\x7ctg_fbs_vss\x7ctg_s_vss\x7cvss__t5
+ inv_clk_vss|inv_mc_vss|inv_q_vss|nand_m_vss|nand_s2_vss|tg_d_vss|tg_fbm_vss|tg_fbs_vss|tg_s_vss|vss
+ 196.116600933
* device instance inv_clk_vss_inv_mc_vss_inv_q_vss_nand_m_vss_nand_s2_vss_tg_d_vss_tg_fbm_vss_tg_fbs_vss_tg_s_vss_vss_t6 r0 *1 0,0
Rinv_clk_vss_inv_mc_vss_inv_q_vss_nand_m_vss_nand_s2_vss_tg_d_vss_tg_fbm_vss_tg_fbs_vss_tg_s_vss_vss_t6
+ inv_clk_vss\x7cinv_mc_vss\x7cinv_q_vss\x7cnand_m_vss\x7cnand_s2_vss\x7ctg_d_vss\x7ctg_fbm_vss\x7ctg_fbs_vss\x7ctg_s_vss\x7cvss__t6
+ inv_clk_vss|inv_mc_vss|inv_q_vss|nand_m_vss|nand_s2_vss|tg_d_vss|tg_fbm_vss|tg_fbs_vss|tg_s_vss|vss
+ 156.936448805
* device instance inv_clk_vss_inv_mc_vss_inv_q_vss_nand_m_vss_nand_s2_vss_tg_d_vss_tg_fbm_vss_tg_fbs_vss_tg_s_vss_vss_t7 r0 *1 0,0
Rinv_clk_vss_inv_mc_vss_inv_q_vss_nand_m_vss_nand_s2_vss_tg_d_vss_tg_fbm_vss_tg_fbs_vss_tg_s_vss_vss_t7
+ inv_clk_vss\x7cinv_mc_vss\x7cinv_q_vss\x7cnand_m_vss\x7cnand_s2_vss\x7ctg_d_vss\x7ctg_fbm_vss\x7ctg_fbs_vss\x7ctg_s_vss\x7cvss__t7
+ inv_clk_vss|inv_mc_vss|inv_q_vss|nand_m_vss|nand_s2_vss|tg_d_vss|tg_fbm_vss|tg_fbs_vss|tg_s_vss|vss
+ 37.5048203346
* device instance inv_clk_vss_inv_mc_vss_inv_q_vss_nand_m_vss_nand_s2_vss_tg_d_vss_tg_fbm_vss_tg_fbs_vss_tg_s_vss_vss_t8 r0 *1 0,0
Rinv_clk_vss_inv_mc_vss_inv_q_vss_nand_m_vss_nand_s2_vss_tg_d_vss_tg_fbm_vss_tg_fbs_vss_tg_s_vss_vss_t8
+ inv_clk_vss\x7cinv_mc_vss\x7cinv_q_vss\x7cnand_m_vss\x7cnand_s2_vss\x7ctg_d_vss\x7ctg_fbm_vss\x7ctg_fbs_vss\x7ctg_s_vss\x7cvss__t8
+ inv_clk_vss|inv_mc_vss|inv_q_vss|nand_m_vss|nand_s2_vss|tg_d_vss|tg_fbm_vss|tg_fbs_vss|tg_s_vss|vss
+ 1.67533179351
* device instance inv_clk_vss_inv_mc_vss_inv_q_vss_nand_m_vss_nand_s2_vss_tg_d_vss_tg_fbm_vss_tg_fbs_vss_tg_s_vss_vss_t9 r0 *1 0,0
Rinv_clk_vss_inv_mc_vss_inv_q_vss_nand_m_vss_nand_s2_vss_tg_d_vss_tg_fbm_vss_tg_fbs_vss_tg_s_vss_vss_t9
+ inv_clk_vss\x7cinv_mc_vss\x7cinv_q_vss\x7cnand_m_vss\x7cnand_s2_vss\x7ctg_d_vss\x7ctg_fbm_vss\x7ctg_fbs_vss\x7ctg_s_vss\x7cvss__t9
+ inv_clk_vss|inv_mc_vss|inv_q_vss|nand_m_vss|nand_s2_vss|tg_d_vss|tg_fbm_vss|tg_fbs_vss|tg_s_vss|vss
+ 43.9389166704
* device instance inv_clk_vss_inv_mc_vss_inv_q_vss_nand_m_vss_nand_s2_vss_tg_d_vss_tg_fbm_vss_tg_fbs_vss_tg_s_vss_vss_t10 r0 *1 0,0
Rinv_clk_vss_inv_mc_vss_inv_q_vss_nand_m_vss_nand_s2_vss_tg_d_vss_tg_fbm_vss_tg_fbs_vss_tg_s_vss_vss_t10
+ inv_clk_vss\x7cinv_mc_vss\x7cinv_q_vss\x7cnand_m_vss\x7cnand_s2_vss\x7ctg_d_vss\x7ctg_fbm_vss\x7ctg_fbs_vss\x7ctg_s_vss\x7cvss__t10
+ inv_clk_vss|inv_mc_vss|inv_q_vss|nand_m_vss|nand_s2_vss|tg_d_vss|tg_fbm_vss|tg_fbs_vss|tg_s_vss|vss
+ 99.892942952
* device instance inv_clk_vss_inv_mc_vss_inv_q_vss_nand_m_vss_nand_s2_vss_tg_d_vss_tg_fbm_vss_tg_fbs_vss_tg_s_vss_vss_t11 r0 *1 0,0
Rinv_clk_vss_inv_mc_vss_inv_q_vss_nand_m_vss_nand_s2_vss_tg_d_vss_tg_fbm_vss_tg_fbs_vss_tg_s_vss_vss_t11
+ inv_clk_vss\x7cinv_mc_vss\x7cinv_q_vss\x7cnand_m_vss\x7cnand_s2_vss\x7ctg_d_vss\x7ctg_fbm_vss\x7ctg_fbs_vss\x7ctg_s_vss\x7cvss__t11
+ inv_clk_vss|inv_mc_vss|inv_q_vss|nand_m_vss|nand_s2_vss|tg_d_vss|tg_fbm_vss|tg_fbs_vss|tg_s_vss|vss
+ 202.550697269
* device instance inv_clk_vss_inv_mc_vss_inv_q_vss_nand_m_vss_nand_s2_vss_tg_d_vss_tg_fbm_vss_tg_fbs_vss_tg_s_vss_vss_t12 r0 *1 0,0
Rinv_clk_vss_inv_mc_vss_inv_q_vss_nand_m_vss_nand_s2_vss_tg_d_vss_tg_fbm_vss_tg_fbs_vss_tg_s_vss_vss_t12
+ inv_clk_vss\x7cinv_mc_vss\x7cinv_q_vss\x7cnand_m_vss\x7cnand_s2_vss\x7ctg_d_vss\x7ctg_fbm_vss\x7ctg_fbs_vss\x7ctg_s_vss\x7cvss__t12
+ inv_clk_vss|inv_mc_vss|inv_q_vss|nand_m_vss|nand_s2_vss|tg_d_vss|tg_fbm_vss|tg_fbs_vss|tg_s_vss|vss
+ 99.3379250572
* device instance inv_clk_vss_inv_mc_vss_inv_q_vss_nand_m_vss_nand_s2_vss_tg_d_vss_tg_fbm_vss_tg_fbs_vss_tg_s_vss_vss_t13 r0 *1 0,0
Rinv_clk_vss_inv_mc_vss_inv_q_vss_nand_m_vss_nand_s2_vss_tg_d_vss_tg_fbm_vss_tg_fbs_vss_tg_s_vss_vss_t13
+ inv_clk_vss\x7cinv_mc_vss\x7cinv_q_vss\x7cnand_m_vss\x7cnand_s2_vss\x7ctg_d_vss\x7ctg_fbm_vss\x7ctg_fbs_vss\x7ctg_s_vss\x7cvss__t13
+ inv_clk_vss|inv_mc_vss|inv_q_vss|nand_m_vss|nand_s2_vss|tg_d_vss|tg_fbm_vss|tg_fbs_vss|tg_s_vss|vss
+ 154.408033951
* device instance inv_clk_vss_inv_mc_vss_inv_q_vss_nand_m_vss_nand_s2_vss_tg_d_vss_tg_fbm_vss_tg_fbs_vss_tg_s_vss_vss_t14 r0 *1 0,0
Rinv_clk_vss_inv_mc_vss_inv_q_vss_nand_m_vss_nand_s2_vss_tg_d_vss_tg_fbm_vss_tg_fbs_vss_tg_s_vss_vss_t14
+ inv_clk_vss\x7cinv_mc_vss\x7cinv_q_vss\x7cnand_m_vss\x7cnand_s2_vss\x7ctg_d_vss\x7ctg_fbm_vss\x7ctg_fbs_vss\x7ctg_s_vss\x7cvss__t14
+ inv_clk_vss|inv_mc_vss|inv_q_vss|nand_m_vss|nand_s2_vss|tg_d_vss|tg_fbm_vss|tg_fbs_vss|tg_s_vss|vss
+ 93.828858546
* device instance inv_clk_vss_inv_mc_vss_inv_q_vss_nand_m_vss_nand_s2_vss_tg_d_vss_tg_fbm_vss_tg_fbs_vss_tg_s_vss_vss_t15 r0 *1 0,0
Rinv_clk_vss_inv_mc_vss_inv_q_vss_nand_m_vss_nand_s2_vss_tg_d_vss_tg_fbm_vss_tg_fbs_vss_tg_s_vss_vss_t15
+ inv_clk_vss\x7cinv_mc_vss\x7cinv_q_vss\x7cnand_m_vss\x7cnand_s2_vss\x7ctg_d_vss\x7ctg_fbm_vss\x7ctg_fbs_vss\x7ctg_s_vss\x7cvss__t15
+ inv_clk_vss|inv_mc_vss|inv_q_vss|nand_m_vss|nand_s2_vss|tg_d_vss|tg_fbm_vss|tg_fbs_vss|tg_s_vss|vss
+ 159.917100462
* device instance inv_clk_vss_inv_mc_vss_inv_q_vss_nand_m_vss_nand_s2_vss_tg_d_vss_tg_fbm_vss_tg_fbs_vss_tg_s_vss_vss r0 *1 0,0
Cinv_clk_vss_inv_mc_vss_inv_q_vss_nand_m_vss_nand_s2_vss_tg_d_vss_tg_fbm_vss_tg_fbs_vss_tg_s_vss_vss
+ inv_clk_vss|inv_mc_vss|inv_q_vss|nand_m_vss|nand_s2_vss|tg_d_vss|tg_fbm_vss|tg_fbs_vss|tg_s_vss|vss
+ vsubs 1.1780945e-14
* device instance cc_a_b_inv_q_a_inv_q_a_via_s_tg_fbs_b_tg_fbs_b_via_tg_s_b_tg_s_b_via_a_inv_mc_a_mb_mnab_y_mpa_y_mpb_y_nand_m_y_tg_s_a_y r0 *1 0,0
Ccc_a_b_inv_q_a_inv_q_a_via_s_tg_fbs_b_tg_fbs_b_via_tg_s_b_tg_s_b_via_a_inv_mc_a_mb_mnab_y_mpa_y_mpb_y_nand_m_y_tg_s_a_y
+ a|b|inv_q_a|inv_q_a_via|s|tg_fbs_b|tg_fbs_b_via|tg_s_b|tg_s_b_via
+ a|inv_mc_a|mb|mnab_y|mpa_y|mpb_y|nand_m_y|tg_s_a|y 1.5323e-17
* device instance cc_a_b_inv_q_a_inv_q_a_via_s_tg_fbs_b_tg_fbs_b_via_tg_s_b_tg_s_b_via_a_mnab_y_mpa_y_mpb_y_nand_s2_y_qb_tg_fbs_a_y r0 *1 0,0
Ccc_a_b_inv_q_a_inv_q_a_via_s_tg_fbs_b_tg_fbs_b_via_tg_s_b_tg_s_b_via_a_mnab_y_mpa_y_mpb_y_nand_s2_y_qb_tg_fbs_a_y
+ a|b|inv_q_a|inv_q_a_via|s|tg_fbs_b|tg_fbs_b_via|tg_s_b|tg_s_b_via
+ a|mnab_y|mpa_y|mpb_y|nand_s2_y|qb|tg_fbs_a|y 3.3459e-17
* device instance cc_a_b_inv_q_a_inv_q_a_via_s_tg_fbs_b_tg_fbs_b_via_tg_s_b_tg_s_b_via_clkb_clkb_bridge1_clkb_bridge2_clkb_mid_clkb_w_ctrl_ctrlb_inv_clk_y_tg_d_ctrlb_tg_fbm_ctrl_tg_fbs_ctrlb_tg_s_ctrl_y r0 *1 0,0
Ccc_a_b_inv_q_a_inv_q_a_via_s_tg_fbs_b_tg_fbs_b_via_tg_s_b_tg_s_b_via_clkb_clkb_bridge1_clkb_bridge2_clkb_mid_clkb_w_ctrl_ctrlb_inv_clk_y_tg_d_ctrlb_tg_fbm_ctrl_tg_fbs_ctrlb_tg_s_ctrl_y
+ a|b|inv_q_a|inv_q_a_via|s|tg_fbs_b|tg_fbs_b_via|tg_s_b|tg_s_b_via
+ clkb|clkb_bridge1|clkb_bridge2|clkb_mid|clkb_w|ctrl|ctrlb|inv_clk_y|tg_d_ctrlb|tg_fbm_ctrl|tg_fbs_ctrlb|tg_s_ctrl|y
+ 1.5506e-17
* device instance cc_a_b_m_east_m_west_nand_m_a_nand_m_a_ext_via_nand_m_a_ext_via2_nand_m_a_stub_tg_d_b_tg_d_b_via_tg_d_b_via2_tg_fbm_b_tg_fbm_b_alt_via_tg_fbm_b_alt_via2_a_inv_mc_a_mb_mnab_y_mpa_y_mpb_y_nand_m_y_tg_s_a_y r0 *1 0,0
Ccc_a_b_m_east_m_west_nand_m_a_nand_m_a_ext_via_nand_m_a_ext_via2_nand_m_a_stub_tg_d_b_tg_d_b_via_tg_d_b_via2_tg_fbm_b_tg_fbm_b_alt_via_tg_fbm_b_alt_via2_a_inv_mc_a_mb_mnab_y_mpa_y_mpb_y_nand_m_y_tg_s_a_y
+ a|b|m_east|m_west|nand_m_a|nand_m_a_ext_via|nand_m_a_ext_via2|nand_m_a_stub|tg_d_b|tg_d_b_via|tg_d_b_via2|tg_fbm_b|tg_fbm_b_alt_via|tg_fbm_b_alt_via2
+ a|inv_mc_a|mb|mnab_y|mpa_y|mpb_y|nand_m_y|tg_s_a|y 3.5168e-17
* device instance cc_a_b_m_east_m_west_nand_m_a_nand_m_a_ext_via_nand_m_a_ext_via2_nand_m_a_stub_tg_d_b_tg_d_b_via_tg_d_b_via2_tg_fbm_b_tg_fbm_b_alt_via_tg_fbm_b_alt_via2_clkb_clkb_bridge1_clkb_bridge2_clkb_mid_clkb_w_ctrl_ctrlb_inv_clk_y_tg_d_ctrlb_tg_fbm_ctrl_tg_fbs_ctrlb_tg_s_ctrl_y r0 *1 0,0
Ccc_a_b_m_east_m_west_nand_m_a_nand_m_a_ext_via_nand_m_a_ext_via2_nand_m_a_stub_tg_d_b_tg_d_b_via_tg_d_b_via2_tg_fbm_b_tg_fbm_b_alt_via_tg_fbm_b_alt_via2_clkb_clkb_bridge1_clkb_bridge2_clkb_mid_clkb_w_ctrl_ctrlb_inv_clk_y_tg_d_ctrlb_tg_fbm_ctrl_tg_fbs_ctrlb_tg_s_ctrl_y
+ a|b|m_east|m_west|nand_m_a|nand_m_a_ext_via|nand_m_a_ext_via2|nand_m_a_stub|tg_d_b|tg_d_b_via|tg_d_b_via2|tg_fbm_b|tg_fbm_b_alt_via|tg_fbm_b_alt_via2
+ clkb|clkb_bridge1|clkb_bridge2|clkb_mid|clkb_w|ctrl|ctrlb|inv_clk_y|tg_d_ctrlb|tg_fbm_ctrl|tg_fbs_ctrlb|tg_s_ctrl|y
+ 1.6673e-17
* device instance cc_a_clk_ctrl_ctrlb_inv_clk_a_inv_clk_clk_via_tg_d_ctrl_tg_d_ctrl_via_tg_fbm_ctrlb_tg_fbm_ctrlb_via_tg_fbs_ctrl_tg_fbs_ctrl_via_tg_s_ctrlb_tg_s_ctrlb_via_a_mnab_y_mpa_y_mpb_y_nand_s2_y_qb_tg_fbs_a_y r0 *1 0,0
Ccc_a_clk_ctrl_ctrlb_inv_clk_a_inv_clk_clk_via_tg_d_ctrl_tg_d_ctrl_via_tg_fbm_ctrlb_tg_fbm_ctrlb_via_tg_fbs_ctrl_tg_fbs_ctrl_via_tg_s_ctrlb_tg_s_ctrlb_via_a_mnab_y_mpa_y_mpb_y_nand_s2_y_qb_tg_fbs_a_y
+ a|clk|ctrl|ctrlb|inv_clk_a|inv_clk_clk_via|tg_d_ctrl|tg_d_ctrl_via|tg_fbm_ctrlb|tg_fbm_ctrlb_via|tg_fbs_ctrl|tg_fbs_ctrl_via|tg_s_ctrlb|tg_s_ctrlb_via
+ a|mnab_y|mpa_y|mpb_y|nand_s2_y|qb|tg_fbs_a|y 3.869e-18
* device instance cc_a_clk_ctrl_ctrlb_inv_clk_a_inv_clk_clk_via_tg_d_ctrl_tg_d_ctrl_via_tg_fbm_ctrlb_tg_fbm_ctrlb_via_tg_fbs_ctrl_tg_fbs_ctrl_via_tg_s_ctrlb_tg_s_ctrlb_via_clkb_clkb_bridge1_clkb_bridge2_clkb_mid_clkb_w_ctrl_ctrlb_inv_clk_y_tg_d_ctrlb_tg_fbm_ctrl_tg_fbs_ctrlb_tg_s_ctrl_y r0 *1 0,0
Ccc_a_clk_ctrl_ctrlb_inv_clk_a_inv_clk_clk_via_tg_d_ctrl_tg_d_ctrl_via_tg_fbm_ctrlb_tg_fbm_ctrlb_via_tg_fbs_ctrl_tg_fbs_ctrl_via_tg_s_ctrlb_tg_s_ctrlb_via_clkb_clkb_bridge1_clkb_bridge2_clkb_mid_clkb_w_ctrl_ctrlb_inv_clk_y_tg_d_ctrlb_tg_fbm_ctrl_tg_fbs_ctrlb_tg_s_ctrl_y
+ a|clk|ctrl|ctrlb|inv_clk_a|inv_clk_clk_via|tg_d_ctrl|tg_d_ctrl_via|tg_fbm_ctrlb|tg_fbm_ctrlb_via|tg_fbs_ctrl|tg_fbs_ctrl_via|tg_s_ctrlb|tg_s_ctrlb_via
+ clkb|clkb_bridge1|clkb_bridge2|clkb_mid|clkb_w|ctrl|ctrlb|inv_clk_y|tg_d_ctrlb|tg_fbm_ctrl|tg_fbs_ctrlb|tg_s_ctrl|y
+ 4.5968e-17
* device instance cc_a_clk_ctrl_ctrlb_inv_clk_a_inv_clk_clk_via_tg_d_ctrl_tg_d_ctrl_via_tg_fbm_ctrlb_tg_fbm_ctrlb_via_tg_fbs_ctrl_tg_fbs_ctrl_via_tg_s_ctrlb_tg_s_ctrlb_via_inv_clk_vss_inv_mc_vss_inv_q_vss_nand_m_vss_nand_s2_vss_tg_d_vss_tg_fbm_vss_tg_fbs_vss_tg_s_vss_vss r0 *1 0,0
Ccc_a_clk_ctrl_ctrlb_inv_clk_a_inv_clk_clk_via_tg_d_ctrl_tg_d_ctrl_via_tg_fbm_ctrlb_tg_fbm_ctrlb_via_tg_fbs_ctrl_tg_fbs_ctrl_via_tg_s_ctrlb_tg_s_ctrlb_via_inv_clk_vss_inv_mc_vss_inv_q_vss_nand_m_vss_nand_s2_vss_tg_d_vss_tg_fbm_vss_tg_fbs_vss_tg_s_vss_vss
+ a|clk|ctrl|ctrlb|inv_clk_a|inv_clk_clk_via|tg_d_ctrl|tg_d_ctrl_via|tg_fbm_ctrlb|tg_fbm_ctrlb_via|tg_fbs_ctrl|tg_fbs_ctrl_via|tg_s_ctrlb|tg_s_ctrlb_via
+ inv_clk_vss|inv_mc_vss|inv_q_vss|nand_m_vss|nand_s2_vss|tg_d_vss|tg_fbm_vss|tg_fbs_vss|tg_s_vss|vss
+ 1.5474e-17
* device instance cc_a_d_tg_d_a_clkb_clkb_bridge1_clkb_bridge2_clkb_mid_clkb_w_ctrl_ctrlb_inv_clk_y_tg_d_ctrlb_tg_fbm_ctrl_tg_fbs_ctrlb_tg_s_ctrl_y r0 *1 0,0
Ccc_a_d_tg_d_a_clkb_clkb_bridge1_clkb_bridge2_clkb_mid_clkb_w_ctrl_ctrlb_inv_clk_y_tg_d_ctrlb_tg_fbm_ctrl_tg_fbs_ctrlb_tg_s_ctrl_y
+ a|d|tg_d_a
+ clkb|clkb_bridge1|clkb_bridge2|clkb_mid|clkb_w|ctrl|ctrlb|inv_clk_y|tg_d_ctrlb|tg_fbm_ctrl|tg_fbs_ctrlb|tg_s_ctrl|y
+ 8.337e-18
* device instance cc_a_inv_mc_a_mb_mnab_y_mpa_y_mpb_y_nand_m_y_tg_s_a_y_a_inv_mc_y_inv_mc_y_via_mc_tg_fbm_a_tg_fbm_a_via_y r0 *1 0,0
Ccc_a_inv_mc_a_mb_mnab_y_mpa_y_mpb_y_nand_m_y_tg_s_a_y_a_inv_mc_y_inv_mc_y_via_mc_tg_fbm_a_tg_fbm_a_via_y
+ a|inv_mc_a|mb|mnab_y|mpa_y|mpb_y|nand_m_y|tg_s_a|y
+ a|inv_mc_y|inv_mc_y_via|mc|tg_fbm_a|tg_fbm_a_via|y 2.2909e-17
* device instance cc_a_inv_mc_a_mb_mnab_y_mpa_y_mpb_y_nand_m_y_tg_s_a_y_clkb_clkb_bridge1_clkb_bridge2_clkb_mid_clkb_w_ctrl_ctrlb_inv_clk_y_tg_d_ctrlb_tg_fbm_ctrl_tg_fbs_ctrlb_tg_s_ctrl_y r0 *1 0,0
Ccc_a_inv_mc_a_mb_mnab_y_mpa_y_mpb_y_nand_m_y_tg_s_a_y_clkb_clkb_bridge1_clkb_bridge2_clkb_mid_clkb_w_ctrl_ctrlb_inv_clk_y_tg_d_ctrlb_tg_fbm_ctrl_tg_fbs_ctrlb_tg_s_ctrl_y
+ a|inv_mc_a|mb|mnab_y|mpa_y|mpb_y|nand_m_y|tg_s_a|y
+ clkb|clkb_bridge1|clkb_bridge2|clkb_mid|clkb_w|ctrl|ctrlb|inv_clk_y|tg_d_ctrlb|tg_fbm_ctrl|tg_fbs_ctrlb|tg_s_ctrl|y
+ 1.2699e-17
* device instance cc_a_inv_mc_a_mb_mnab_y_mpa_y_mpb_y_nand_m_y_tg_s_a_y_en_nand_m_en_nand_m_en_via_nand_s2_en_nand_s2_en_via_rst_n r0 *1 0,0
Ccc_a_inv_mc_a_mb_mnab_y_mpa_y_mpb_y_nand_m_y_tg_s_a_y_en_nand_m_en_nand_m_en_via_nand_s2_en_nand_s2_en_via_rst_n
+ a|inv_mc_a|mb|mnab_y|mpa_y|mpb_y|nand_m_y|tg_s_a|y
+ en|nand_m_en|nand_m_en_via|nand_s2_en|nand_s2_en_via|rst_n 1.1606e-17
* device instance cc_a_inv_mc_y_inv_mc_y_via_mc_tg_fbm_a_tg_fbm_a_via_y_clkb_clkb_bridge1_clkb_bridge2_clkb_mid_clkb_w_ctrl_ctrlb_inv_clk_y_tg_d_ctrlb_tg_fbm_ctrl_tg_fbs_ctrlb_tg_s_ctrl_y r0 *1 0,0
Ccc_a_inv_mc_y_inv_mc_y_via_mc_tg_fbm_a_tg_fbm_a_via_y_clkb_clkb_bridge1_clkb_bridge2_clkb_mid_clkb_w_ctrl_ctrlb_inv_clk_y_tg_d_ctrlb_tg_fbm_ctrl_tg_fbs_ctrlb_tg_s_ctrl_y
+ a|inv_mc_y|inv_mc_y_via|mc|tg_fbm_a|tg_fbm_a_via|y
+ clkb|clkb_bridge1|clkb_bridge2|clkb_mid|clkb_w|ctrl|ctrlb|inv_clk_y|tg_d_ctrlb|tg_fbm_ctrl|tg_fbs_ctrlb|tg_s_ctrl|y
+ 2.0542e-17
* device instance cc_a_inv_q_y_inv_q_y_via_inv_q_y_via2_nand_s2_a_nand_s2_a_stub_nand_s2_a_via_nand_s2_a_via2_q_y_a_mnab_y_mpa_y_mpb_y_nand_s2_y_qb_tg_fbs_a_y r0 *1 0,0
Ccc_a_inv_q_y_inv_q_y_via_inv_q_y_via2_nand_s2_a_nand_s2_a_stub_nand_s2_a_via_nand_s2_a_via2_q_y_a_mnab_y_mpa_y_mpb_y_nand_s2_y_qb_tg_fbs_a_y
+ a|inv_q_y|inv_q_y_via|inv_q_y_via2|nand_s2_a|nand_s2_a_stub|nand_s2_a_via|nand_s2_a_via2|q|y
+ a|mnab_y|mpa_y|mpb_y|nand_s2_y|qb|tg_fbs_a|y 2.9475e-17
* device instance cc_a_inv_q_y_inv_q_y_via_inv_q_y_via2_nand_s2_a_nand_s2_a_stub_nand_s2_a_via_nand_s2_a_via2_q_y_clkb_clkb_bridge1_clkb_bridge2_clkb_mid_clkb_w_ctrl_ctrlb_inv_clk_y_tg_d_ctrlb_tg_fbm_ctrl_tg_fbs_ctrlb_tg_s_ctrl_y r0 *1 0,0
Ccc_a_inv_q_y_inv_q_y_via_inv_q_y_via2_nand_s2_a_nand_s2_a_stub_nand_s2_a_via_nand_s2_a_via2_q_y_clkb_clkb_bridge1_clkb_bridge2_clkb_mid_clkb_w_ctrl_ctrlb_inv_clk_y_tg_d_ctrlb_tg_fbm_ctrl_tg_fbs_ctrlb_tg_s_ctrl_y
+ a|inv_q_y|inv_q_y_via|inv_q_y_via2|nand_s2_a|nand_s2_a_stub|nand_s2_a_via|nand_s2_a_via2|q|y
+ clkb|clkb_bridge1|clkb_bridge2|clkb_mid|clkb_w|ctrl|ctrlb|inv_clk_y|tg_d_ctrlb|tg_fbm_ctrl|tg_fbs_ctrlb|tg_s_ctrl|y
+ 8.337e-18
* device instance cc_a_mnab_y_mpa_y_mpb_y_nand_s2_y_qb_tg_fbs_a_y_clkb_clkb_bridge1_clkb_bridge2_clkb_mid_clkb_w_ctrl_ctrlb_inv_clk_y_tg_d_ctrlb_tg_fbm_ctrl_tg_fbs_ctrlb_tg_s_ctrl_y r0 *1 0,0
Ccc_a_mnab_y_mpa_y_mpb_y_nand_s2_y_qb_tg_fbs_a_y_clkb_clkb_bridge1_clkb_bridge2_clkb_mid_clkb_w_ctrl_ctrlb_inv_clk_y_tg_d_ctrlb_tg_fbm_ctrl_tg_fbs_ctrlb_tg_s_ctrl_y
+ a|mnab_y|mpa_y|mpb_y|nand_s2_y|qb|tg_fbs_a|y
+ clkb|clkb_bridge1|clkb_bridge2|clkb_mid|clkb_w|ctrl|ctrlb|inv_clk_y|tg_d_ctrlb|tg_fbm_ctrl|tg_fbs_ctrlb|tg_s_ctrl|y
+ 8.015e-18
* device instance cc_clkb_clkb_bridge1_clkb_bridge2_clkb_mid_clkb_w_ctrl_ctrlb_inv_clk_y_tg_d_ctrlb_tg_fbm_ctrl_tg_fbs_ctrlb_tg_s_ctrl_y_en_nand_m_en_nand_m_en_via_nand_s2_en_nand_s2_en_via_rst_n r0 *1 0,0
Ccc_clkb_clkb_bridge1_clkb_bridge2_clkb_mid_clkb_w_ctrl_ctrlb_inv_clk_y_tg_d_ctrlb_tg_fbm_ctrl_tg_fbs_ctrlb_tg_s_ctrl_y_en_nand_m_en_nand_m_en_via_nand_s2_en_nand_s2_en_via_rst_n
+ clkb|clkb_bridge1|clkb_bridge2|clkb_mid|clkb_w|ctrl|ctrlb|inv_clk_y|tg_d_ctrlb|tg_fbm_ctrl|tg_fbs_ctrlb|tg_s_ctrl|y
+ en|nand_m_en|nand_m_en_via|nand_s2_en|nand_s2_en_via|rst_n 2.38e-17
* device instance cc_clkb_clkb_bridge1_clkb_bridge2_clkb_mid_clkb_w_ctrl_ctrlb_inv_clk_y_tg_d_ctrlb_tg_fbm_ctrl_tg_fbs_ctrlb_tg_s_ctrl_y_inv_clk_vss_inv_mc_vss_inv_q_vss_nand_m_vss_nand_s2_vss_tg_d_vss_tg_fbm_vss_tg_fbs_vss_tg_s_vss_vss r0 *1 0,0
Ccc_clkb_clkb_bridge1_clkb_bridge2_clkb_mid_clkb_w_ctrl_ctrlb_inv_clk_y_tg_d_ctrlb_tg_fbm_ctrl_tg_fbs_ctrlb_tg_s_ctrl_y_inv_clk_vss_inv_mc_vss_inv_q_vss_nand_m_vss_nand_s2_vss_tg_d_vss_tg_fbm_vss_tg_fbs_vss_tg_s_vss_vss
+ clkb|clkb_bridge1|clkb_bridge2|clkb_mid|clkb_w|ctrl|ctrlb|inv_clk_y|tg_d_ctrlb|tg_fbm_ctrl|tg_fbs_ctrlb|tg_s_ctrl|y
+ inv_clk_vss|inv_mc_vss|inv_q_vss|nand_m_vss|nand_s2_vss|tg_d_vss|tg_fbm_vss|tg_fbs_vss|tg_s_vss|vss
+ 1.02283e-16
* device instance vsubs_dctie r0 *1 0,0
Rvsubs_dctie vsubs 0 1e+12
.ENDS sampler_dff
