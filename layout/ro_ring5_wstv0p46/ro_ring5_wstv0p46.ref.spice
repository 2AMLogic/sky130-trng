* Reference netlist for ro_ring5_wstv0p46 LVS -- GENERATED by layout/bin/compose-cell.py
* Source: design/ro_array_core.spice .subckt ro_ring5 plus dependency subckt(s) ro_nand2, ro_stage
* Only unit spellings (and any substituted subckt parameter)
* differ from the source -- see compose-cell.py's docstring.
.subckt ro_nand2 a en y vddr vss
*.ipin a
*.ipin en
*.opin y
*.iopin vddr
*.iopin vss
XMph py vss vddr vddr sky130_fd_pr__pfet_01v8 L=2u W=0.46u nf=1 ad='int((1 + 1)/2) * wstv / 1 * 0.29'
+ as='int((1 + 2)/2) * wstv / 1 * 0.29' pd='2*int((1 + 1)/2) * (wstv / 1 + 0.29)'
+ ps='2*int((1 + 2)/2) * (wstv / 1 + 0.29)' nrd='0.29 / wstv ' nrs='0.29 / wstv ' sa=0 sb=0 sd=0 mult=1 m=1
XMpa y a py vddr sky130_fd_pr__pfet_01v8 L=0.15u W=0.84u nf=1 ad=0.2436 as=0.2436 pd=2.26 ps=2.26 nrd=0.345238095238095
+ nrs=0.345238095238095 sa=0 sb=0 sd=0 mult=1 m=1
XMpb y en py vddr sky130_fd_pr__pfet_01v8 L=0.15u W=0.84u nf=1 ad=0.2436 as=0.2436 pd=2.26 ps=2.26 nrd=0.345238095238095
+ nrs=0.345238095238095 sa=0 sb=0 sd=0 mult=1 m=1
XMna y a nm vss sky130_fd_pr__nfet_01v8 L=0.15u W=0.84u nf=1 ad=0.2436 as=0.2436 pd=2.26 ps=2.26 nrd=0.345238095238095
+ nrs=0.345238095238095 sa=0 sb=0 sd=0 mult=1 m=1
XMnb nm en ny vss sky130_fd_pr__nfet_01v8 L=0.15u W=0.84u nf=1 ad=0.2436 as=0.2436 pd=2.26 ps=2.26 nrd=0.345238095238095
+ nrs=0.345238095238095 sa=0 sb=0 sd=0 mult=1 m=1
XMnt ny vddr vss vss sky130_fd_pr__nfet_01v8 L=2u W=0.46u nf=1 ad='int((1 + 1)/2) * wstv / 1 * 0.29'
+ as='int((1 + 2)/2) * wstv / 1 * 0.29' pd='2*int((1 + 1)/2) * (wstv / 1 + 0.29)'
+ ps='2*int((1 + 2)/2) * (wstv / 1 + 0.29)' nrd='0.29 / wstv ' nrs='0.29 / wstv ' sa=0 sb=0 sd=0 mult=1 m=1
.ends

.subckt ro_stage a y vddr vss
*.ipin a
*.opin y
*.iopin vddr
*.iopin vss
XMph py vss vddr vddr sky130_fd_pr__pfet_01v8 L=2u W=0.46u nf=1 ad='int((1 + 1)/2) * wstv / 1 * 0.29'
+ as='int((1 + 2)/2) * wstv / 1 * 0.29' pd='2*int((1 + 1)/2) * (wstv / 1 + 0.29)'
+ ps='2*int((1 + 2)/2) * (wstv / 1 + 0.29)' nrd='0.29 / wstv ' nrs='0.29 / wstv ' sa=0 sb=0 sd=0 mult=1 m=1
XMp y a py vddr sky130_fd_pr__pfet_01v8 L=0.15u W=0.84u nf=1 ad=0.2436 as=0.2436 pd=2.26 ps=2.26 nrd=0.345238095238095
+ nrs=0.345238095238095 sa=0 sb=0 sd=0 mult=1 m=1
XMn y a ny vss sky130_fd_pr__nfet_01v8 L=0.15u W=0.42u nf=1 ad=0.1218 as=0.1218 pd=1.42 ps=1.42 nrd=0.69047619047619
+ nrs=0.69047619047619 sa=0 sb=0 sd=0 mult=1 m=1
XMnt ny vddr vss vss sky130_fd_pr__nfet_01v8 L=2u W=0.46u nf=1 ad='int((1 + 1)/2) * wstv / 1 * 0.29'
+ as='int((1 + 2)/2) * wstv / 1 * 0.29' pd='2*int((1 + 1)/2) * (wstv / 1 + 0.29)'
+ ps='2*int((1 + 2)/2) * (wstv / 1 + 0.29)' nrd='0.29 / wstv ' nrs='0.29 / wstv ' sa=0 sb=0 sd=0 mult=1 m=1
.ends

.subckt ro_ring5 en ro vddr vss
*.ipin en
*.opin ro
*.iopin vddr
*.iopin vss
xg ro en n1 vddr vss ro_nand2
x1 n1 n2 vddr vss ro_stage
x2 n2 n3 vddr vss ro_stage
x3 n3 n4 vddr vss ro_stage
x4 n4 ro vddr vss ro_stage
.ends
