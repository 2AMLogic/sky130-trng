* extracted by klt extract --deck sky130

* cell ro_ring5_wstv0p46
* pin a,g_a,ro,s4_y,y
* pin a,g_y,mnab_y,mpa_y,mpb_y,n1,s1_a,y
* pin a,n2,s1_y,s2_a,y
* pin a,n3,s2_y,s3_a,y
* pin a,n4,s3_y,s4_a,y
* pin en,g_en
* pin g_vddr_m1,mnt_g,s1_vddr_m1,s2_vddr_m1,s3_vddr_m1,s4_vddr_m1,vddr
* pin g_vss_m1,mph_g,s1_vss_m1,s2_vss_m1,s3_vss_m1,s4_vss_m1,vss
* pin mpa_py,mpb_py,mph_py,py
* pin ny
* pin ny
* pin ny
* pin ny
* pin ny
* pin py
* pin py
* pin py
* pin py
.SUBCKT ro_ring5_wstv0p46 a|g_a|ro|s4_y|y a|g_y|mnab_y|mpa_y|mpb_y|n1|s1_a|y
+ a|n2|s1_y|s2_a|y a|n3|s2_y|s3_a|y a|n4|s3_y|s4_a|y en|g_en
+ g_vddr_m1|mnt_g|s1_vddr_m1|s2_vddr_m1|s3_vddr_m1|s4_vddr_m1|vddr
+ g_vss_m1|mph_g|s1_vss_m1|s2_vss_m1|s3_vss_m1|s4_vss_m1|vss
+ mpa_py|mpb_py|mph_py|py ny ny$1 ny$2 ny$3 ny$4 py py$1 py$2 py$3
* device instance $1 r0 *1 13.085,0.21 nfet
M$1 a|n2|s1_y|s2_a|y a|g_y|mnab_y|mpa_y|mpb_y|n1|s1_a|y ny$1
+ g_vss_m1|mph_g|s1_vss_m1|s2_vss_m1|s3_vss_m1|s4_vss_m1|vss nfet L=0.15U
+ W=0.42U AS=0.1974P AD=0.1974P PS=1.78U PD=1.78U
* device instance $2 r0 *1 21.26,0.21 nfet
M$2 a|n3|s2_y|s3_a|y a|n2|s1_y|s2_a|y ny$2
+ g_vss_m1|mph_g|s1_vss_m1|s2_vss_m1|s3_vss_m1|s4_vss_m1|vss nfet L=0.15U
+ W=0.42U AS=0.1974P AD=0.1974P PS=1.78U PD=1.78U
* device instance $3 r0 *1 29.435,0.21 nfet
M$3 a|n4|s3_y|s4_a|y a|n3|s2_y|s3_a|y ny$3
+ g_vss_m1|mph_g|s1_vss_m1|s2_vss_m1|s3_vss_m1|s4_vss_m1|vss nfet L=0.15U
+ W=0.42U AS=0.1974P AD=0.1974P PS=1.78U PD=1.78U
* device instance $4 r0 *1 37.61,0.21 nfet
M$4 a|g_a|ro|s4_y|y a|n4|s3_y|s4_a|y ny$4
+ g_vss_m1|mph_g|s1_vss_m1|s2_vss_m1|s3_vss_m1|s4_vss_m1|vss nfet L=0.15U
+ W=0.42U AS=0.1974P AD=0.1974P PS=1.78U PD=1.78U
* device instance $5 r0 *1 1.42,0.21 nfet
M$5 ny g_vddr_m1|mnt_g|s1_vddr_m1|s2_vddr_m1|s3_vddr_m1|s4_vddr_m1|vddr
+ g_vss_m1|mph_g|s1_vss_m1|s2_vss_m1|s3_vss_m1|s4_vss_m1|vss
+ g_vss_m1|mph_g|s1_vss_m1|s2_vss_m1|s3_vss_m1|s4_vss_m1|vss nfet L=2U W=0.46U
+ AS=0.1932P AD=0.1932P PS=1.76U PD=1.76U
* device instance $6 r0 *1 10.72,0.21 nfet
M$6 ny$1 g_vddr_m1|mnt_g|s1_vddr_m1|s2_vddr_m1|s3_vddr_m1|s4_vddr_m1|vddr
+ g_vss_m1|mph_g|s1_vss_m1|s2_vss_m1|s3_vss_m1|s4_vss_m1|vss
+ g_vss_m1|mph_g|s1_vss_m1|s2_vss_m1|s3_vss_m1|s4_vss_m1|vss nfet L=2U W=0.46U
+ AS=0.1932P AD=0.1932P PS=1.76U PD=1.76U
* device instance $7 r0 *1 18.895,0.21 nfet
M$7 ny$2 g_vddr_m1|mnt_g|s1_vddr_m1|s2_vddr_m1|s3_vddr_m1|s4_vddr_m1|vddr
+ g_vss_m1|mph_g|s1_vss_m1|s2_vss_m1|s3_vss_m1|s4_vss_m1|vss
+ g_vss_m1|mph_g|s1_vss_m1|s2_vss_m1|s3_vss_m1|s4_vss_m1|vss nfet L=2U W=0.46U
+ AS=0.1932P AD=0.1932P PS=1.76U PD=1.76U
* device instance $8 r0 *1 27.07,0.21 nfet
M$8 ny$3 g_vddr_m1|mnt_g|s1_vddr_m1|s2_vddr_m1|s3_vddr_m1|s4_vddr_m1|vddr
+ g_vss_m1|mph_g|s1_vss_m1|s2_vss_m1|s3_vss_m1|s4_vss_m1|vss
+ g_vss_m1|mph_g|s1_vss_m1|s2_vss_m1|s3_vss_m1|s4_vss_m1|vss nfet L=2U W=0.46U
+ AS=0.1932P AD=0.1932P PS=1.76U PD=1.76U
* device instance $9 r0 *1 35.245,0.21 nfet
M$9 ny$4 g_vddr_m1|mnt_g|s1_vddr_m1|s2_vddr_m1|s3_vddr_m1|s4_vddr_m1|vddr
+ g_vss_m1|mph_g|s1_vss_m1|s2_vss_m1|s3_vss_m1|s4_vss_m1|vss
+ g_vss_m1|mph_g|s1_vss_m1|s2_vss_m1|s3_vss_m1|s4_vss_m1|vss nfet L=2U W=0.46U
+ AS=0.1932P AD=0.1932P PS=1.76U PD=1.76U
* device instance $10 r0 *1 3.785,0.21 nfet
M$10 \$3 en|g_en ny g_vss_m1|mph_g|s1_vss_m1|s2_vss_m1|s3_vss_m1|s4_vss_m1|vss
+ nfet L=0.15U W=0.84U AS=0.3948P AD=0.2184P PS=2.62U PD=1.36U
* device instance $11 r0 *1 4.455,0.21 nfet
M$11 a|g_y|mnab_y|mpa_y|mpb_y|n1|s1_a|y a|g_a|ro|s4_y|y \$3
+ g_vss_m1|mph_g|s1_vss_m1|s2_vss_m1|s3_vss_m1|s4_vss_m1|vss nfet L=0.15U
+ W=0.84U AS=0.2184P AD=0.3948P PS=1.36U PD=2.62U
* device instance $12 r0 *1 1.42,3.74 pfet
M$12 mpa_py|mpb_py|mph_py|py
+ g_vss_m1|mph_g|s1_vss_m1|s2_vss_m1|s3_vss_m1|s4_vss_m1|vss
+ g_vddr_m1|mnt_g|s1_vddr_m1|s2_vddr_m1|s3_vddr_m1|s4_vddr_m1|vddr
+ g_vddr_m1|mnt_g|s1_vddr_m1|s2_vddr_m1|s3_vddr_m1|s4_vddr_m1|vddr pfet L=2U
+ W=0.46U AS=0.1932P AD=0.1932P PS=1.76U PD=1.76U
* device instance $13 r0 *1 10.72,3.74 pfet
M$13 py g_vss_m1|mph_g|s1_vss_m1|s2_vss_m1|s3_vss_m1|s4_vss_m1|vss
+ g_vddr_m1|mnt_g|s1_vddr_m1|s2_vddr_m1|s3_vddr_m1|s4_vddr_m1|vddr
+ g_vddr_m1|mnt_g|s1_vddr_m1|s2_vddr_m1|s3_vddr_m1|s4_vddr_m1|vddr pfet L=2U
+ W=0.46U AS=0.1932P AD=0.1932P PS=1.76U PD=1.76U
* device instance $14 r0 *1 18.895,3.74 pfet
M$14 py$1 g_vss_m1|mph_g|s1_vss_m1|s2_vss_m1|s3_vss_m1|s4_vss_m1|vss
+ g_vddr_m1|mnt_g|s1_vddr_m1|s2_vddr_m1|s3_vddr_m1|s4_vddr_m1|vddr
+ g_vddr_m1|mnt_g|s1_vddr_m1|s2_vddr_m1|s3_vddr_m1|s4_vddr_m1|vddr pfet L=2U
+ W=0.46U AS=0.1932P AD=0.1932P PS=1.76U PD=1.76U
* device instance $15 r0 *1 27.07,3.74 pfet
M$15 py$2 g_vss_m1|mph_g|s1_vss_m1|s2_vss_m1|s3_vss_m1|s4_vss_m1|vss
+ g_vddr_m1|mnt_g|s1_vddr_m1|s2_vddr_m1|s3_vddr_m1|s4_vddr_m1|vddr
+ g_vddr_m1|mnt_g|s1_vddr_m1|s2_vddr_m1|s3_vddr_m1|s4_vddr_m1|vddr pfet L=2U
+ W=0.46U AS=0.1932P AD=0.1932P PS=1.76U PD=1.76U
* device instance $16 r0 *1 35.245,3.74 pfet
M$16 py$3 g_vss_m1|mph_g|s1_vss_m1|s2_vss_m1|s3_vss_m1|s4_vss_m1|vss
+ g_vddr_m1|mnt_g|s1_vddr_m1|s2_vddr_m1|s3_vddr_m1|s4_vddr_m1|vddr
+ g_vddr_m1|mnt_g|s1_vddr_m1|s2_vddr_m1|s3_vddr_m1|s4_vddr_m1|vddr pfet L=2U
+ W=0.46U AS=0.1932P AD=0.1932P PS=1.76U PD=1.76U
* device instance $17 r0 *1 3.585,3.74 pfet
M$17 a|g_y|mnab_y|mpa_y|mpb_y|n1|s1_a|y en|g_en mpa_py|mpb_py|mph_py|py
+ g_vddr_m1|mnt_g|s1_vddr_m1|s2_vddr_m1|s3_vddr_m1|s4_vddr_m1|vddr pfet L=0.15U
+ W=0.84U AS=0.3948P AD=0.3948P PS=2.62U PD=2.62U
* device instance $18 r0 *1 4.875,3.74 pfet
M$18 mpa_py|mpb_py|mph_py|py a|g_a|ro|s4_y|y a|g_y|mnab_y|mpa_y|mpb_y|n1|s1_a|y
+ g_vddr_m1|mnt_g|s1_vddr_m1|s2_vddr_m1|s3_vddr_m1|s4_vddr_m1|vddr pfet L=0.15U
+ W=0.84U AS=0.3948P AD=0.3948P PS=2.62U PD=2.62U
* device instance $19 r0 *1 12.885,3.74 pfet
M$19 a|n2|s1_y|s2_a|y a|g_y|mnab_y|mpa_y|mpb_y|n1|s1_a|y py
+ g_vddr_m1|mnt_g|s1_vddr_m1|s2_vddr_m1|s3_vddr_m1|s4_vddr_m1|vddr pfet L=0.15U
+ W=0.84U AS=0.3948P AD=0.3948P PS=2.62U PD=2.62U
* device instance $20 r0 *1 21.06,3.74 pfet
M$20 a|n3|s2_y|s3_a|y a|n2|s1_y|s2_a|y py$1
+ g_vddr_m1|mnt_g|s1_vddr_m1|s2_vddr_m1|s3_vddr_m1|s4_vddr_m1|vddr pfet L=0.15U
+ W=0.84U AS=0.3948P AD=0.3948P PS=2.62U PD=2.62U
* device instance $21 r0 *1 29.235,3.74 pfet
M$21 a|n4|s3_y|s4_a|y a|n3|s2_y|s3_a|y py$2
+ g_vddr_m1|mnt_g|s1_vddr_m1|s2_vddr_m1|s3_vddr_m1|s4_vddr_m1|vddr pfet L=0.15U
+ W=0.84U AS=0.3948P AD=0.3948P PS=2.62U PD=2.62U
* device instance $22 r0 *1 37.41,3.74 pfet
M$22 a|g_a|ro|s4_y|y a|n4|s3_y|s4_a|y py$3
+ g_vddr_m1|mnt_g|s1_vddr_m1|s2_vddr_m1|s3_vddr_m1|s4_vddr_m1|vddr pfet L=0.15U
+ W=0.84U AS=0.3948P AD=0.3948P PS=2.62U PD=2.62U
.ENDS ro_ring5_wstv0p46
