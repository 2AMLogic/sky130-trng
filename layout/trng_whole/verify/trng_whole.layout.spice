* extracted by klt extract --deck sky130

* cell trng_whole
* pin VGND,g_vss_m1,inv_clk_vss,inv_mc_vss,inv_q_vss,mph_g,nand_m_vss,nand_s2_vss,s1_vss_m1,s2_vss_m1,s3_vss_m1,s4_vss_m1,sb_vss,sr1_vss,sr2_vss,sr3_vss,sr4_vss,sv_vss,tg_d_vss,tg_fbm_vss,tg_fbs_vss,tg_s_vss,vss,vss_link,vss_link_bridge,vss_link_dip,vss_link_m1,vss_x1,vss_x2,vss_x3
* pin VPWR,a,d,inv_clk_vdd,inv_mc_vdd,inv_q_vdd,mpa_py,mpb_py,nand_m_vdd,nand_s2_vdd,nwell_vdd,sb_vdd,sr1_vdd,sr2_vdd,sr3_vdd,sr4_vdd,sv_d_vdd_tie,sv_vdd,tg_d_a,tg_d_vdd,tg_fbm_vdd,tg_fbs_vdd,tg_s_vdd,vdd,vdd_b1,vdd_b2,vdd_b3,vdd_b4,vdd_link,vdd_link_dip,vdd_x1,vdd_x2,vdd_x3
* pin a,clk,ctrl,ctrlb,inv_clk_a,inv_clk_clk_via,tg_d_ctrl,tg_d_ctrl_via,tg_fbm_ctrlb,tg_fbm_ctrlb_via,tg_fbs_ctrl,tg_fbs_ctrl_via,tg_s_ctrlb,tg_s_ctrlb_via
* pin a,inv_q_y,inv_q_y_via,inv_q_y_via2,nand_s2_a,nand_s2_a_stub,nand_s2_a_via,nand_s2_a_via2,q,ring_bit1,y
* pin a,inv_q_y,inv_q_y_via,inv_q_y_via2,nand_s2_a,nand_s2_a_stub,nand_s2_a_via,nand_s2_a_via2,q,ring_bit2,y
* pin a,inv_q_y,inv_q_y_via,inv_q_y_via2,nand_s2_a,nand_s2_a_stub,nand_s2_a_via,nand_s2_a_via2,q,ring_bit3,y
* pin a,inv_q_y,inv_q_y_via,inv_q_y_via2,nand_s2_a,nand_s2_a_stub,nand_s2_a_via,nand_s2_a_via2,q,ring_bit4,y
* pin alarm
* pin bus_addr[0]
* pin bus_addr[1]
* pin bus_addr[2]
* pin bus_addr[3]
* pin bus_rdata[0]
* pin bus_rdata[10]
* pin bus_rdata[11]
* pin bus_rdata[12]
* pin bus_rdata[13]
* pin bus_rdata[14]
* pin bus_rdata[15]
* pin bus_rdata[16]
* pin bus_rdata[17]
* pin bus_rdata[18]
* pin bus_rdata[19]
* pin bus_rdata[1]
* pin bus_rdata[20]
* pin bus_rdata[21]
* pin bus_rdata[22]
* pin bus_rdata[23]
* pin bus_rdata[24]
* pin bus_rdata[25]
* pin bus_rdata[26]
* pin bus_rdata[27]
* pin bus_rdata[28]
* pin bus_rdata[29]
* pin bus_rdata[2]
* pin bus_rdata[30]
* pin bus_rdata[31]
* pin bus_rdata[3]
* pin bus_rdata[4]
* pin bus_rdata[5]
* pin bus_rdata[6]
* pin bus_rdata[7]
* pin bus_rdata[8]
* pin bus_rdata[9]
* pin bus_re
* pin bus_wdata[0]
* pin bus_wdata[1]
* pin bus_wdata[2]
* pin bus_we
* pin en,en1,g_en
* pin en,en2,g_en
* pin en,en3,g_en
* pin en,en4,g_en
* pin en,nand_m_en,nand_m_en_via,nand_s2_en,nand_s2_en_via,rst_n
* pin g_vddr_m1,mnt_g,s1_vddr_m1,s2_vddr_m1,s3_vddr_m1,s4_vddr_m1,vddr,vddr1
* pin g_vddr_m1,mnt_g,s1_vddr_m1,s2_vddr_m1,s3_vddr_m1,s4_vddr_m1,vddr,vddr2
* pin g_vddr_m1,mnt_g,s1_vddr_m1,s2_vddr_m1,s3_vddr_m1,s4_vddr_m1,vddr,vddr3
* pin g_vddr_m1,mnt_g,s1_vddr_m1,s2_vddr_m1,s3_vddr_m1,s4_vddr_m1,vddr,vddr4
* pin gated
* pin out_data[0]
* pin out_data[10]
* pin out_data[11]
* pin out_data[12]
* pin out_data[13]
* pin out_data[14]
* pin out_data[15]
* pin out_data[16]
* pin out_data[17]
* pin out_data[18]
* pin out_data[19]
* pin out_data[1]
* pin out_data[20]
* pin out_data[21]
* pin out_data[22]
* pin out_data[23]
* pin out_data[24]
* pin out_data[25]
* pin out_data[26]
* pin out_data[27]
* pin out_data[28]
* pin out_data[29]
* pin out_data[2]
* pin out_data[30]
* pin out_data[31]
* pin out_data[3]
* pin out_data[4]
* pin out_data[5]
* pin out_data[6]
* pin out_data[7]
* pin out_data[8]
* pin out_data[9]
* pin out_ready
* pin out_valid
* pin startup_done
* pin bus_wdata[9]
* pin bus_wdata[8]
* pin bus_wdata[7]
* pin bus_wdata[6]
* pin bus_wdata[5]
* pin bus_wdata[4]
* pin bus_wdata[3]
* pin bus_wdata[31]
* pin bus_wdata[30]
* pin bus_wdata[29]
* pin bus_wdata[28]
* pin bus_wdata[27]
* pin bus_wdata[26]
* pin bus_wdata[25]
* pin bus_wdata[24]
* pin bus_wdata[23]
* pin bus_wdata[22]
* pin bus_wdata[21]
* pin bus_wdata[20]
* pin bus_wdata[19]
* pin bus_wdata[18]
* pin bus_wdata[17]
* pin bus_wdata[16]
* pin bus_wdata[15]
* pin bus_wdata[14]
* pin bus_wdata[13]
* pin bus_wdata[12]
* pin bus_wdata[11]
* pin bus_wdata[10]
.SUBCKT trng_whole
+ vss
+ vdd
+ clk
+ ring_bit1
+ ring_bit2
+ ring_bit3
+ ring_bit4
+ alarm bus_addr[0] bus_addr[1] bus_addr[2] bus_addr[3] bus_rdata[0]
+ bus_rdata[10] bus_rdata[11] bus_rdata[12] bus_rdata[13] bus_rdata[14]
+ bus_rdata[15] bus_rdata[16] bus_rdata[17] bus_rdata[18] bus_rdata[19]
+ bus_rdata[1] bus_rdata[20] bus_rdata[21] bus_rdata[22] bus_rdata[23]
+ bus_rdata[24] bus_rdata[25] bus_rdata[26] bus_rdata[27] bus_rdata[28]
+ bus_rdata[29] bus_rdata[2] bus_rdata[30] bus_rdata[31] bus_rdata[3]
+ bus_rdata[4] bus_rdata[5] bus_rdata[6] bus_rdata[7] bus_rdata[8] bus_rdata[9]
+ bus_re bus_wdata[0] bus_wdata[1] bus_wdata[2] bus_we en1 en2
+ en3 en4
+ rst_n
+ vddr1
+ vddr2
+ vddr3
+ vddr4 gated
+ out_data[0] out_data[10] out_data[11] out_data[12] out_data[13] out_data[14]
+ out_data[15] out_data[16] out_data[17] out_data[18] out_data[19] out_data[1]
+ out_data[20] out_data[21] out_data[22] out_data[23] out_data[24] out_data[25]
+ out_data[26] out_data[27] out_data[28] out_data[29] out_data[2] out_data[30]
+ out_data[31] out_data[3] out_data[4] out_data[5] out_data[6] out_data[7]
+ out_data[8] out_data[9] out_ready out_valid startup_done bus_wdata[9]
+ bus_wdata[8] bus_wdata[7] bus_wdata[6] bus_wdata[5] bus_wdata[4] bus_wdata[3]
+ bus_wdata[31] bus_wdata[30] bus_wdata[29] bus_wdata[28] bus_wdata[27]
+ bus_wdata[26] bus_wdata[25] bus_wdata[24] bus_wdata[23] bus_wdata[22]
+ bus_wdata[21] bus_wdata[20] bus_wdata[19] bus_wdata[18] bus_wdata[17]
+ bus_wdata[16] bus_wdata[15] bus_wdata[14] bus_wdata[13] bus_wdata[12]
+ bus_wdata[11] bus_wdata[10]
* cell instance sky130_fd_sc_hd__a211oi_1_0 r0 *1 0,0
Xsky130_fd_sc_hd__a211oi_1_0 \$1377 \$1384 \$1721 \$1548
+ vss
+ vdd
+ vdd
+ \$1722 sky130_fd_sc_hd__a211oi_1
* cell instance sky130_fd_sc_hd__a21o_1_0 r0 *1 0,0
Xsky130_fd_sc_hd__a21o_1_0 \$5974 \$5975 \$5978
+ vss
+ vdd
+ vdd
+ \$5865 sky130_fd_sc_hd__a21o_1
* cell instance sky130_fd_sc_hd__a21o_1_1 r0 *1 0,0
Xsky130_fd_sc_hd__a21o_1_1 \$4604 \$4365 \$4367
+ vss
+ vdd
+ vdd
+ \$4368 sky130_fd_sc_hd__a21o_1
* cell instance sky130_fd_sc_hd__a21o_1_2 r0 *1 0,0
Xsky130_fd_sc_hd__a21o_1_2 \$3891 \$3842 \$4202
+ vss
+ vdd
+ vdd
+ \$3845 sky130_fd_sc_hd__a21o_1
* cell instance sky130_fd_sc_hd__a21oi_1_0 r0 *1 0,0
Xsky130_fd_sc_hd__a21oi_1_0 \$4479 \$4244 \$4016
+ vss
+ vdd
+ vdd
+ \$4340 sky130_fd_sc_hd__a21oi_1
* cell instance sky130_fd_sc_hd__a21oi_1_1 r0 *1 0,0
Xsky130_fd_sc_hd__a21oi_1_1 \$3667 \$3666 \$3904
+ vss
+ vdd
+ vdd
+ \$3903 sky130_fd_sc_hd__a21oi_1
* cell instance sky130_fd_sc_hd__a21oi_1_2 r0 *1 0,0
Xsky130_fd_sc_hd__a21oi_1_2 \$1998 \$1919 \$2097
+ vss
+ vdd
+ vdd
+ \$2297 sky130_fd_sc_hd__a21oi_1
* cell instance sky130_fd_sc_hd__a21oi_1_3 r0 *1 0,0
Xsky130_fd_sc_hd__a21oi_1_3 \$1997 \$2205 \$2202
+ vss
+ vdd
+ vdd
+ \$1825 sky130_fd_sc_hd__a21oi_1
* cell instance sky130_fd_sc_hd__a21oi_1_4 r0 *1 0,0
Xsky130_fd_sc_hd__a21oi_1_4 \$5400 \$5522 \$5638
+ vss
+ vdd
+ vdd
+ \$5741 sky130_fd_sc_hd__a21oi_1
* cell instance sky130_fd_sc_hd__a21oi_1_5 r0 *1 0,0
Xsky130_fd_sc_hd__a21oi_1_5 \$2851 \$1995 \$2725
+ vss
+ vdd
+ vdd
+ \$2508 sky130_fd_sc_hd__a21oi_1
* cell instance sky130_fd_sc_hd__a21oi_1_6 r0 *1 0,0
Xsky130_fd_sc_hd__a21oi_1_6 \$1998 \$1919 \$2209
+ vss
+ vdd
+ vdd
+ \$2207 sky130_fd_sc_hd__a21oi_1
* cell instance sky130_fd_sc_hd__a21oi_1_7 r0 *1 0,0
Xsky130_fd_sc_hd__a21oi_1_7 \$5852 \$5740 \$6091
+ vss
+ vdd
+ vdd
+ \$5968 sky130_fd_sc_hd__a21oi_1
* cell instance sky130_fd_sc_hd__a21oi_1_8 r0 *1 0,0
Xsky130_fd_sc_hd__a21oi_1_8 \$4353 \$1146 \$4483
+ vss
+ vdd
+ vdd
+ \$4591 sky130_fd_sc_hd__a21oi_1
* cell instance sky130_fd_sc_hd__a21oi_1_9 r0 *1 0,0
Xsky130_fd_sc_hd__a21oi_1_9 \$2214 \$2109 \$1999
+ vss
+ vdd
+ vdd
+ \$2211 sky130_fd_sc_hd__a21oi_1
* cell instance sky130_fd_sc_hd__a21oi_1_10 r0 *1 0,0
Xsky130_fd_sc_hd__a21oi_1_10 \$3885 \$3909 \$3908
+ vss
+ vdd
+ vdd
+ \$3910 sky130_fd_sc_hd__a21oi_1
* cell instance sky130_fd_sc_hd__a21oi_1_11 r0 *1 0,0
Xsky130_fd_sc_hd__a21oi_1_11 \$3885 \$290 \$4250
+ vss
+ vdd
+ vdd
+ \$4252 sky130_fd_sc_hd__a21oi_1
* cell instance sky130_fd_sc_hd__a21oi_1_12 r0 *1 0,0
Xsky130_fd_sc_hd__a21oi_1_12 \$5301 \$5189 \$4821
+ vss
+ vdd
+ vdd
+ \$5057 sky130_fd_sc_hd__a21oi_1
* cell instance sky130_fd_sc_hd__a21oi_1_13 r0 *1 0,0
Xsky130_fd_sc_hd__a21oi_1_13 \$4484 \$290 \$5056
+ vss
+ vdd
+ vdd
+ \$4913 sky130_fd_sc_hd__a21oi_1
* cell instance sky130_fd_sc_hd__a21oi_1_14 r0 *1 0,0
Xsky130_fd_sc_hd__a21oi_1_14 \$1146 \$4821 \$4938
+ vss
+ vdd
+ vdd
+ \$4826 sky130_fd_sc_hd__a21oi_1
* cell instance sky130_fd_sc_hd__a21oi_1_15 r0 *1 0,0
Xsky130_fd_sc_hd__a21oi_1_15 \$1381 \$1382 \$1283
+ vss
+ vdd
+ vdd
+ \$1636 sky130_fd_sc_hd__a21oi_1
* cell instance sky130_fd_sc_hd__a21oi_1_16 r0 *1 0,0
Xsky130_fd_sc_hd__a21oi_1_16 \$4494 \$290 \$4593
+ vss
+ vdd
+ vdd
+ \$4495 sky130_fd_sc_hd__a21oi_1
* cell instance sky130_fd_sc_hd__a21oi_1_17 r0 *1 0,0
Xsky130_fd_sc_hd__a21oi_1_17 \$2631 \$2632 \$2202
+ vss
+ vdd
+ vdd
+ \$2419 sky130_fd_sc_hd__a21oi_1
* cell instance sky130_fd_sc_hd__a21oi_1_18 r0 *1 0,0
Xsky130_fd_sc_hd__a21oi_1_18 \$5974 \$5975 \$5972
+ vss
+ vdd
+ vdd
+ \$6177 sky130_fd_sc_hd__a21oi_1
* cell instance sky130_fd_sc_hd__a21oi_1_19 r0 *1 0,0
Xsky130_fd_sc_hd__a21oi_1_19 \$5974 \$290 \$6177
+ vss
+ vdd
+ vdd
+ \$6284 sky130_fd_sc_hd__a21oi_1
* cell instance sky130_fd_sc_hd__a21oi_1_20 r0 *1 0,0
Xsky130_fd_sc_hd__a21oi_1_20 \$4151 \$290 \$4256
+ vss
+ vdd
+ vdd
+ \$3922 sky130_fd_sc_hd__a21oi_1
* cell instance sky130_fd_sc_hd__a21oi_1_21 r0 *1 0,0
Xsky130_fd_sc_hd__a21oi_1_21 \$5415 \$5062 \$5308
+ vss
+ vdd
+ vdd
+ \$5529 sky130_fd_sc_hd__a21oi_1
* cell instance sky130_fd_sc_hd__a21oi_1_22 r0 *1 0,0
Xsky130_fd_sc_hd__a21oi_1_22 \$3463 startup_done \$3583
+ vss
+ vdd
+ vdd
+ \$3582 sky130_fd_sc_hd__a21oi_1
* cell instance sky130_fd_sc_hd__a21oi_1_23 r0 *1 0,0
Xsky130_fd_sc_hd__a21oi_1_23 \$3680 \$290 \$3582
+ vss
+ vdd
+ vdd
+ \$3683 sky130_fd_sc_hd__a21oi_1
* cell instance sky130_fd_sc_hd__a21oi_1_24 r0 *1 0,0
Xsky130_fd_sc_hd__a21oi_1_24 \$4257 \$4031 \$2202
+ vss
+ vdd
+ vdd
+ \$4259 sky130_fd_sc_hd__a21oi_1
* cell instance sky130_fd_sc_hd__a21oi_1_25 r0 *1 0,0
Xsky130_fd_sc_hd__a21oi_1_25 startup_done \$2744 \$3027
+ vss
+ vdd
+ vdd
+ \$3171 sky130_fd_sc_hd__a21oi_1
* cell instance sky130_fd_sc_hd__a21oi_1_26 r0 *1 0,0
Xsky130_fd_sc_hd__a21oi_1_26 \$4500 \$290 \$4828
+ vss
+ vdd
+ vdd
+ \$4830 sky130_fd_sc_hd__a21oi_1
* cell instance sky130_fd_sc_hd__a21oi_1_27 r0 *1 0,0
Xsky130_fd_sc_hd__a21oi_1_27 \$5163 \$290 \$5193
+ vss
+ vdd
+ vdd
+ \$5195 sky130_fd_sc_hd__a21oi_1
* cell instance sky130_fd_sc_hd__a21oi_1_28 r0 *1 0,0
Xsky130_fd_sc_hd__a21oi_1_28 \$5415 \$290 \$5530
+ vss
+ vdd
+ vdd
+ \$5650 sky130_fd_sc_hd__a21oi_1
* cell instance sky130_fd_sc_hd__a21oi_1_29 r0 *1 0,0
Xsky130_fd_sc_hd__a21oi_1_29 \$1377 \$1384 \$1479
+ vss
+ vdd
+ vdd
+ \$1639 sky130_fd_sc_hd__a21oi_1
* cell instance sky130_fd_sc_hd__a21oi_1_30 r0 *1 0,0
Xsky130_fd_sc_hd__a21oi_1_30 \$2869 \$290 \$3171
+ vss
+ vdd
+ vdd
+ \$3041 sky130_fd_sc_hd__a21oi_1
* cell instance sky130_fd_sc_hd__a21oi_1_31 r0 *1 0,0
Xsky130_fd_sc_hd__a21oi_1_31 \$1385 \$1388 \$1726
+ vss
+ vdd
+ vdd
+ \$1931 sky130_fd_sc_hd__a21oi_1
* cell instance sky130_fd_sc_hd__a21oi_1_32 r0 *1 0,0
Xsky130_fd_sc_hd__a21oi_1_32 \$6396 \$6398 \$6187
+ vss
+ vdd
+ vdd
+ \$6498 sky130_fd_sc_hd__a21oi_1
* cell instance sky130_fd_sc_hd__a21oi_1_33 r0 *1 0,0
Xsky130_fd_sc_hd__a21oi_1_33 \$6396 \$6398 \$6286
+ vss
+ vdd
+ vdd
+ \$6500 sky130_fd_sc_hd__a21oi_1
* cell instance sky130_fd_sc_hd__a21oi_1_34 r0 *1 0,0
Xsky130_fd_sc_hd__a21oi_1_34 \$3645 \$180 \$3588
+ vss
+ vdd
+ vdd
+ \$3587 sky130_fd_sc_hd__a21oi_1
* cell instance sky130_fd_sc_hd__a21oi_1_35 r0 *1 0,0
Xsky130_fd_sc_hd__a21oi_1_35 \$1390 \$180 \$1643
+ vss
+ vdd
+ vdd
+ \$1642 sky130_fd_sc_hd__a21oi_1
* cell instance sky130_fd_sc_hd__a21oi_1_36 r0 *1 0,0
Xsky130_fd_sc_hd__a21oi_1_36 \$2608 \$180 \$2429
+ vss
+ vdd
+ vdd
+ \$2531 sky130_fd_sc_hd__a21oi_1
* cell instance sky130_fd_sc_hd__a21oi_1_37 r0 *1 0,0
Xsky130_fd_sc_hd__a21oi_1_37 \$4367 \$290 \$4369
+ vss
+ vdd
+ vdd
+ \$4271 sky130_fd_sc_hd__a21oi_1
* cell instance sky130_fd_sc_hd__a21oi_1_38 r0 *1 0,0
Xsky130_fd_sc_hd__a21oi_1_38 \$3686 \$399 \$3812
+ vss
+ vdd
+ vdd
+ \$3694 sky130_fd_sc_hd__a21oi_1
* cell instance sky130_fd_sc_hd__a21oi_1_39 r0 *1 0,0
Xsky130_fd_sc_hd__a21oi_1_39 \$1837 \$399 \$1644
+ vss
+ vdd
+ vdd
+ \$2016 sky130_fd_sc_hd__a21oi_1
* cell instance sky130_fd_sc_hd__a21oi_1_40 r0 *1 0,0
Xsky130_fd_sc_hd__a21oi_1_40 \$4372 \$5318 \$5166
+ vss
+ vdd
+ vdd
+ \$5320 sky130_fd_sc_hd__a21oi_1
* cell instance sky130_fd_sc_hd__a21oi_1_41 r0 *1 0,0
Xsky130_fd_sc_hd__a21oi_1_41 \$4372 \$4735 \$4370
+ vss
+ vdd
+ vdd
+ \$4369 sky130_fd_sc_hd__a21oi_1
* cell instance sky130_fd_sc_hd__a21oi_1_42 r0 *1 0,0
Xsky130_fd_sc_hd__a21oi_1_42 \$6190 \$6504 \$6497
+ vss
+ vdd
+ vdd
+ \$6503 sky130_fd_sc_hd__a21oi_1
* cell instance sky130_fd_sc_hd__a21oi_1_43 r0 *1 0,0
Xsky130_fd_sc_hd__a21oi_1_43 \$3029 \$180 \$2875
+ vss
+ vdd
+ vdd
+ \$2969 sky130_fd_sc_hd__a21oi_1
* cell instance sky130_fd_sc_hd__a21oi_1_44 r0 *1 0,0
Xsky130_fd_sc_hd__a21oi_1_44 \$4372 \$5073 \$5165
+ vss
+ vdd
+ vdd
+ \$5166 sky130_fd_sc_hd__a21oi_1
* cell instance sky130_fd_sc_hd__a21oi_1_45 r0 *1 0,0
Xsky130_fd_sc_hd__a21oi_1_45 \$5318 \$5475 \$5200
+ vss
+ vdd
+ vdd
+ \$5767 sky130_fd_sc_hd__a21oi_1
* cell instance sky130_fd_sc_hd__a21oi_1_46 r0 *1 0,0
Xsky130_fd_sc_hd__a21oi_1_46 \$1056 \$290 \$1058
+ vss
+ vdd
+ vdd
+ \$1057 sky130_fd_sc_hd__a21oi_1
* cell instance sky130_fd_sc_hd__a21oi_1_47 r0 *1 0,0
Xsky130_fd_sc_hd__a21oi_1_47 \$6190 \$6504 \$6753
+ vss
+ vdd
+ vdd
+ \$6678 sky130_fd_sc_hd__a21oi_1
* cell instance sky130_fd_sc_hd__a21oi_1_48 r0 *1 0,0
Xsky130_fd_sc_hd__a21oi_1_48 \$702 \$290 \$928
+ vss
+ vdd
+ vdd
+ \$927 sky130_fd_sc_hd__a21oi_1
* cell instance sky130_fd_sc_hd__a21oi_1_49 r0 *1 0,0
Xsky130_fd_sc_hd__a21oi_1_49 \$1130 \$290 \$1403
+ vss
+ vdd
+ vdd
+ \$1402 sky130_fd_sc_hd__a21oi_1
* cell instance sky130_fd_sc_hd__a21oi_1_50 r0 *1 0,0
Xsky130_fd_sc_hd__a21oi_1_50 \$3050 \$399 \$3256
+ vss
+ vdd
+ vdd
+ \$3186 sky130_fd_sc_hd__a21oi_1
* cell instance sky130_fd_sc_hd__a21oi_1_51 r0 *1 0,0
Xsky130_fd_sc_hd__a21oi_1_51 \$2019 \$180 \$2130
+ vss
+ vdd
+ vdd
+ \$2021 sky130_fd_sc_hd__a21oi_1
* cell instance sky130_fd_sc_hd__a21oi_1_52 r0 *1 0,0
Xsky130_fd_sc_hd__a21oi_1_52 \$4372 \$4606 \$4374
+ vss
+ vdd
+ vdd
+ \$4373 sky130_fd_sc_hd__a21oi_1
* cell instance sky130_fd_sc_hd__a21oi_1_53 r0 *1 0,0
Xsky130_fd_sc_hd__a21oi_1_53 \$6403 \$5475 \$6402
+ vss
+ vdd
+ vdd
+ \$6405 sky130_fd_sc_hd__a21oi_1
* cell instance sky130_fd_sc_hd__a21oi_1_54 r0 *1 0,0
Xsky130_fd_sc_hd__a21oi_1_54 \$6403 \$5475 \$6755
+ vss
+ vdd
+ vdd
+ \$6920 sky130_fd_sc_hd__a21oi_1
* cell instance sky130_fd_sc_hd__a21oi_1_55 r0 *1 0,0
Xsky130_fd_sc_hd__a21oi_1_55 \$423 \$290 \$861
+ vss
+ vdd
+ vdd
+ \$780 sky130_fd_sc_hd__a21oi_1
* cell instance sky130_fd_sc_hd__a21oi_1_56 r0 *1 0,0
Xsky130_fd_sc_hd__a21oi_1_56 \$3468 \$180 \$3290
+ vss
+ vdd
+ vdd
+ \$3590 sky130_fd_sc_hd__a21oi_1
* cell instance sky130_fd_sc_hd__a21oi_1_57 r0 *1 0,0
Xsky130_fd_sc_hd__a21oi_1_57 \$2430 \$399 \$2611
+ vss
+ vdd
+ vdd
+ \$2533 sky130_fd_sc_hd__a21oi_1
* cell instance sky130_fd_sc_hd__a21oi_1_58 r0 *1 0,0
Xsky130_fd_sc_hd__a21oi_1_58 \$3927 \$399 \$3928
+ vss
+ vdd
+ vdd
+ \$3816 sky130_fd_sc_hd__a21oi_1
* cell instance sky130_fd_sc_hd__a21oi_1_59 r0 *1 0,0
Xsky130_fd_sc_hd__a21oi_1_59 \$493 \$290 \$560
+ vss
+ vdd
+ vdd
+ \$559 sky130_fd_sc_hd__a21oi_1
* cell instance sky130_fd_sc_hd__a21oi_1_60 r0 *1 0,0
Xsky130_fd_sc_hd__a21oi_1_60 \$1498 \$290 \$1502
+ vss
+ vdd
+ vdd
+ \$1503 sky130_fd_sc_hd__a21oi_1
* cell instance sky130_fd_sc_hd__a21oi_1_61 r0 *1 0,0
Xsky130_fd_sc_hd__a21oi_1_61 \$2022 \$399 \$2134
+ vss
+ vdd
+ vdd
+ \$2133 sky130_fd_sc_hd__a21oi_1
* cell instance sky130_fd_sc_hd__a21oi_1_62 r0 *1 0,0
Xsky130_fd_sc_hd__a21oi_1_62 \$1056 \$1059 \$1140
+ vss
+ vdd
+ vdd
+ \$1211 sky130_fd_sc_hd__a21oi_1
* cell instance sky130_fd_sc_hd__a21oi_1_63 r0 *1 0,0
Xsky130_fd_sc_hd__a21oi_1_63 \$1498 \$1466 \$1505
+ vss
+ vdd
+ vdd
+ \$1500 sky130_fd_sc_hd__a21oi_1
* cell instance sky130_fd_sc_hd__a21oi_1_64 r0 *1 0,0
Xsky130_fd_sc_hd__a21oi_1_64 \$493 \$626 \$562
+ vss
+ vdd
+ vdd
+ \$625 sky130_fd_sc_hd__a21oi_1
* cell instance sky130_fd_sc_hd__a21oi_1_65 r0 *1 0,0
Xsky130_fd_sc_hd__a21oi_1_65 \$1130 \$1213 \$1215
+ vss
+ vdd
+ vdd
+ \$1210 sky130_fd_sc_hd__a21oi_1
* cell instance sky130_fd_sc_hd__a21oi_1_66 r0 *1 0,0
Xsky130_fd_sc_hd__a21oi_1_66 \$2764 \$742 \$2534
+ vss
+ vdd
+ vdd
+ \$2656 sky130_fd_sc_hd__a21oi_1
* cell instance sky130_fd_sc_hd__a21oi_1_67 r0 *1 0,0
Xsky130_fd_sc_hd__a21oi_1_67 \$4178 \$742 \$4051
+ vss
+ vdd
+ vdd
+ \$4180 sky130_fd_sc_hd__a21oi_1
* cell instance sky130_fd_sc_hd__a21oi_1_68 r0 *1 0,0
Xsky130_fd_sc_hd__a21oi_1_68 \$4050 \$742 \$3929
+ vss
+ vdd
+ vdd
+ \$4053 sky130_fd_sc_hd__a21oi_1
* cell instance sky130_fd_sc_hd__a21oi_1_69 r0 *1 0,0
Xsky130_fd_sc_hd__a21oi_1_69 \$1300 \$290 \$1467
+ vss
+ vdd
+ vdd
+ \$1565 sky130_fd_sc_hd__a21oi_1
* cell instance sky130_fd_sc_hd__a21oi_1_70 r0 *1 0,0
Xsky130_fd_sc_hd__a21oi_1_70 \$1736 \$742 \$1846
+ vss
+ vdd
+ vdd
+ \$1940 sky130_fd_sc_hd__a21oi_1
* cell instance sky130_fd_sc_hd__a21oi_1_71 r0 *1 0,0
Xsky130_fd_sc_hd__a21oi_1_71 \$1300 \$1142 \$1144
+ vss
+ vdd
+ vdd
+ \$1141 sky130_fd_sc_hd__a21oi_1
* cell instance sky130_fd_sc_hd__a21oi_1_72 r0 *1 0,0
Xsky130_fd_sc_hd__a21oi_1_72 \$2971 \$742 \$3058
+ vss
+ vdd
+ vdd
+ \$3060 sky130_fd_sc_hd__a21oi_1
* cell instance sky130_fd_sc_hd__a21oi_1_73 r0 *1 0,0
Xsky130_fd_sc_hd__a21oi_1_73 \$3477 \$180 \$3480
+ vss
+ vdd
+ vdd
+ \$3479 sky130_fd_sc_hd__a21oi_1
* cell instance sky130_fd_sc_hd__a21oi_1_74 r0 *1 0,0
Xsky130_fd_sc_hd__a21oi_1_74 \$6591 \$5325 \$6593
+ vss
+ vdd
+ vdd
+ \$6507 sky130_fd_sc_hd__a21oi_1
* cell instance sky130_fd_sc_hd__a21oi_1_75 r0 *1 0,0
Xsky130_fd_sc_hd__a21oi_1_75 \$7282 \$5325 \$7285
+ vss
+ vdd
+ vdd
+ \$7284 sky130_fd_sc_hd__a21oi_1
* cell instance sky130_fd_sc_hd__a21oi_1_76 r0 *1 0,0
Xsky130_fd_sc_hd__a21oi_1_76 \$210 \$290 \$504
+ vss
+ vdd
+ vdd
+ \$503 sky130_fd_sc_hd__a21oi_1
* cell instance sky130_fd_sc_hd__a21oi_1_77 r0 *1 0,0
Xsky130_fd_sc_hd__a21oi_1_77 \$862 \$290 \$997
+ vss
+ vdd
+ vdd
+ \$932 sky130_fd_sc_hd__a21oi_1
* cell instance sky130_fd_sc_hd__a21oi_1_78 r0 *1 0,0
Xsky130_fd_sc_hd__a21oi_1_78 \$210 \$566 \$630
+ vss
+ vdd
+ vdd
+ \$505 sky130_fd_sc_hd__a21oi_1
* cell instance sky130_fd_sc_hd__a21oi_1_79 r0 *1 0,0
Xsky130_fd_sc_hd__a21oi_1_79 \$5213 \$5325 \$5429
+ vss
+ vdd
+ vdd
+ \$4744 sky130_fd_sc_hd__a21oi_1
* cell instance sky130_fd_sc_hd__a21oi_1_80 r0 *1 0,0
Xsky130_fd_sc_hd__a21oi_1_80 \$3649 \$399 \$3710
+ vss
+ vdd
+ vdd
+ \$3709 sky130_fd_sc_hd__a21oi_1
* cell instance sky130_fd_sc_hd__a21oi_1_81 r0 *1 0,0
Xsky130_fd_sc_hd__a21oi_1_81 \$2140 \$742 \$2139
+ vss
+ vdd
+ vdd
+ \$2035 sky130_fd_sc_hd__a21oi_1
* cell instance sky130_fd_sc_hd__a21oi_1_82 r0 *1 0,0
Xsky130_fd_sc_hd__a21oi_1_82 \$2535 \$180 \$2882
+ vss
+ vdd
+ vdd
+ \$2658 sky130_fd_sc_hd__a21oi_1
* cell instance sky130_fd_sc_hd__a21oi_1_83 r0 *1 0,0
Xsky130_fd_sc_hd__a21oi_1_83 \$5328 \$5325 \$5551
+ vss
+ vdd
+ vdd
+ \$5329 sky130_fd_sc_hd__a21oi_1
* cell instance sky130_fd_sc_hd__a21oi_1_84 r0 *1 0,0
Xsky130_fd_sc_hd__a21oi_1_84 \$1653 \$1408 \$1407
+ vss
+ vdd
+ vdd
+ \$1508 sky130_fd_sc_hd__a21oi_1
* cell instance sky130_fd_sc_hd__a21oi_1_85 r0 *1 0,0
Xsky130_fd_sc_hd__a21oi_1_85 \$6000 \$4302 \$6208
+ vss
+ vdd
+ vdd
+ \$3613 sky130_fd_sc_hd__a21oi_1
* cell instance sky130_fd_sc_hd__a21oi_1_86 r0 *1 0,0
Xsky130_fd_sc_hd__a21oi_1_86 \$358 \$290 \$283
+ vss
+ vdd
+ vdd
+ \$282 sky130_fd_sc_hd__a21oi_1
* cell instance sky130_fd_sc_hd__a21oi_1_87 r0 *1 0,0
Xsky130_fd_sc_hd__a21oi_1_87 \$2774 \$399 \$2883
+ vss
+ vdd
+ vdd
+ \$2982 sky130_fd_sc_hd__a21oi_1
* cell instance sky130_fd_sc_hd__a21oi_1_88 r0 *1 0,0
Xsky130_fd_sc_hd__a21oi_1_88 \$4453 \$4302 \$4522
+ vss
+ vdd
+ vdd
+ \$4242 sky130_fd_sc_hd__a21oi_1
* cell instance sky130_fd_sc_hd__a21oi_1_89 r0 *1 0,0
Xsky130_fd_sc_hd__a21oi_1_89 \$3827 \$742 \$3825
+ vss
+ vdd
+ vdd
+ \$3828 sky130_fd_sc_hd__a21oi_1
* cell instance sky130_fd_sc_hd__a21oi_1_90 r0 *1 0,0
Xsky130_fd_sc_hd__a21oi_1_90 \$6929 \$4302 \$7115
+ vss
+ vdd
+ vdd
+ \$4577 sky130_fd_sc_hd__a21oi_1
* cell instance sky130_fd_sc_hd__a21oi_1_91 r0 *1 0,0
Xsky130_fd_sc_hd__a21oi_1_91 \$718 \$1146 \$1751
+ vss
+ vdd
+ vdd
+ \$1750 sky130_fd_sc_hd__a21oi_1
* cell instance sky130_fd_sc_hd__a21oi_1_92 r0 *1 0,0
Xsky130_fd_sc_hd__a21oi_1_92 \$3031 \$742 \$2884
+ vss
+ vdd
+ vdd
+ \$2989 sky130_fd_sc_hd__a21oi_1
* cell instance sky130_fd_sc_hd__a21oi_1_93 r0 *1 0,0
Xsky130_fd_sc_hd__a21oi_1_93 \$149 \$290 \$285
+ vss
+ vdd
+ vdd
+ \$368 sky130_fd_sc_hd__a21oi_1
* cell instance sky130_fd_sc_hd__a21oi_1_94 r0 *1 0,0
Xsky130_fd_sc_hd__a21oi_1_94 \$3484 \$180 \$3485
+ vss
+ vdd
+ vdd
+ \$3488 sky130_fd_sc_hd__a21oi_1
* cell instance sky130_fd_sc_hd__a21oi_1_95 r0 *1 0,0
Xsky130_fd_sc_hd__a21oi_1_95 \$1755 \$290 \$1856
+ vss
+ vdd
+ vdd
+ \$1855 sky130_fd_sc_hd__a21oi_1
* cell instance sky130_fd_sc_hd__a21oi_1_96 r0 *1 0,0
Xsky130_fd_sc_hd__a21oi_1_96 \$3888 \$399 \$3831
+ vss
+ vdd
+ vdd
+ \$3601 sky130_fd_sc_hd__a21oi_1
* cell instance sky130_fd_sc_hd__a21oi_1_97 r0 *1 0,0
Xsky130_fd_sc_hd__a21oi_1_97 \$718 \$1146 \$716
+ vss
+ vdd
+ vdd
+ \$1148 sky130_fd_sc_hd__a21oi_1
* cell instance sky130_fd_sc_hd__a21oi_1_98 r0 *1 0,0
Xsky130_fd_sc_hd__a21oi_1_98 \$2291 \$180 \$2546
+ vss
+ vdd
+ vdd
+ \$2444 sky130_fd_sc_hd__a21oi_1
* cell instance sky130_fd_sc_hd__a21oi_1_99 r0 *1 0,0
Xsky130_fd_sc_hd__a21oi_1_99 \$4372 \$5474 \$4457
+ vss
+ vdd
+ vdd
+ \$4625 sky130_fd_sc_hd__a21oi_1
* cell instance sky130_fd_sc_hd__a21oi_1_100 r0 *1 0,0
Xsky130_fd_sc_hd__a21oi_1_100 \$433 \$578 \$634
+ vss
+ vdd
+ vdd
+ \$370 sky130_fd_sc_hd__a21oi_1
* cell instance sky130_fd_sc_hd__a21oi_1_101 r0 *1 0,0
Xsky130_fd_sc_hd__a21oi_1_101 \$2150 \$399 \$2445
+ vss
+ vdd
+ vdd
+ \$2548 sky130_fd_sc_hd__a21oi_1
* cell instance sky130_fd_sc_hd__a21oi_1_102 r0 *1 0,0
Xsky130_fd_sc_hd__a21oi_1_102 \$92 \$793 \$581
+ vss
+ vdd
+ vdd
+ \$221 sky130_fd_sc_hd__a21oi_1
* cell instance sky130_fd_sc_hd__a21oi_1_103 r0 *1 0,0
Xsky130_fd_sc_hd__a21oi_1_103 \$1413 \$1369 \$1219
+ vss
+ vdd
+ vdd
+ \$1509 sky130_fd_sc_hd__a21oi_1
* cell instance sky130_fd_sc_hd__a21oi_1_104 r0 *1 0,0
Xsky130_fd_sc_hd__a21oi_1_104 \$1413 \$290 \$1510
+ vss
+ vdd
+ vdd
+ \$1575 sky130_fd_sc_hd__a21oi_1
* cell instance sky130_fd_sc_hd__a21oi_1_105 r0 *1 0,0
Xsky130_fd_sc_hd__a21oi_1_105 \$433 \$290 \$288
+ vss
+ vdd
+ vdd
+ \$287 sky130_fd_sc_hd__a21oi_1
* cell instance sky130_fd_sc_hd__a21oi_1_106 r0 *1 0,0
Xsky130_fd_sc_hd__a21oi_1_106 \$1758 \$290 \$1759
+ vss
+ vdd
+ vdd
+ \$1946 sky130_fd_sc_hd__a21oi_1
* cell instance sky130_fd_sc_hd__a21oi_1_107 r0 *1 0,0
Xsky130_fd_sc_hd__a21oi_1_107 \$92 \$290 \$160
+ vss
+ vdd
+ vdd
+ \$159 sky130_fd_sc_hd__a21oi_1
* cell instance sky130_fd_sc_hd__a21oi_1_108 r0 *1 0,0
Xsky130_fd_sc_hd__a21oi_1_108 \$726 \$724 \$723
+ vss
+ vdd
+ vdd
+ \$727 sky130_fd_sc_hd__a21oi_1
* cell instance sky130_fd_sc_hd__a21oi_1_109 r0 *1 0,0
Xsky130_fd_sc_hd__a21oi_1_109 \$4063 \$742 \$3944
+ vss
+ vdd
+ vdd
+ \$3992 sky130_fd_sc_hd__a21oi_1
* cell instance sky130_fd_sc_hd__a21oi_1_110 r0 *1 0,0
Xsky130_fd_sc_hd__a21oi_1_110 \$2784 \$180 \$2894
+ vss
+ vdd
+ vdd
+ \$3072 sky130_fd_sc_hd__a21oi_1
* cell instance sky130_fd_sc_hd__a21oi_1_111 r0 *1 0,0
Xsky130_fd_sc_hd__a21oi_1_111 \$3198 \$399 \$3301
+ vss
+ vdd
+ vdd
+ \$3078 sky130_fd_sc_hd__a21oi_1
* cell instance sky130_fd_sc_hd__a21oi_1_112 r0 *1 0,0
Xsky130_fd_sc_hd__a21oi_1_112 \$726 \$290 \$638
+ vss
+ vdd
+ vdd
+ \$637 sky130_fd_sc_hd__a21oi_1
* cell instance sky130_fd_sc_hd__a21oi_1_113 r0 *1 0,0
Xsky130_fd_sc_hd__a21oi_1_113 \$3603 \$742 \$3393
+ vss
+ vdd
+ vdd
+ \$3494 sky130_fd_sc_hd__a21oi_1
* cell instance sky130_fd_sc_hd__a21oi_1_114 r0 *1 0,0
Xsky130_fd_sc_hd__a21oi_1_114 \$2668 \$742 \$2549
+ vss
+ vdd
+ vdd
+ \$2613 sky130_fd_sc_hd__a21oi_1
* cell instance sky130_fd_sc_hd__a21oi_1_115 r0 *1 0,0
Xsky130_fd_sc_hd__a21oi_1_115 \$222 \$290 \$293
+ vss
+ vdd
+ vdd
+ \$292 sky130_fd_sc_hd__a21oi_1
* cell instance sky130_fd_sc_hd__a21oi_1_116 r0 *1 0,0
Xsky130_fd_sc_hd__a21oi_1_116 \$1576 \$290 \$1760
+ vss
+ vdd
+ vdd
+ \$1762 sky130_fd_sc_hd__a21oi_1
* cell instance sky130_fd_sc_hd__a21oi_1_117 r0 *1 0,0
Xsky130_fd_sc_hd__a21oi_1_117 \$2160 \$180 \$2254
+ vss
+ vdd
+ vdd
+ \$2257 sky130_fd_sc_hd__a21oi_1
* cell instance sky130_fd_sc_hd__a21oi_1_118 r0 *1 0,0
Xsky130_fd_sc_hd__a21oi_1_118 \$234 \$290 \$103
+ vss
+ vdd
+ vdd
+ \$236 sky130_fd_sc_hd__a21oi_1
* cell instance sky130_fd_sc_hd__a21oi_1_119 r0 *1 0,0
Xsky130_fd_sc_hd__a21oi_1_119 \$294 \$290 \$298
+ vss
+ vdd
+ vdd
+ \$296 sky130_fd_sc_hd__a21oi_1
* cell instance sky130_fd_sc_hd__a21oi_1_120 r0 *1 0,0
Xsky130_fd_sc_hd__a21oi_1_120 \$6489 \$5325 \$6320
+ vss
+ vdd
+ vdd
+ \$5897 sky130_fd_sc_hd__a21oi_1
* cell instance sky130_fd_sc_hd__a21oi_1_121 r0 *1 0,0
Xsky130_fd_sc_hd__a21oi_1_121 \$3207 \$180 \$3305
+ vss
+ vdd
+ vdd
+ \$3304 sky130_fd_sc_hd__a21oi_1
* cell instance sky130_fd_sc_hd__a21oi_1_122 r0 *1 0,0
Xsky130_fd_sc_hd__a21oi_1_122 \$2895 \$399 \$2344
+ vss
+ vdd
+ vdd
+ \$2452 sky130_fd_sc_hd__a21oi_1
* cell instance sky130_fd_sc_hd__a21oi_1_123 r0 *1 0,0
Xsky130_fd_sc_hd__a21oi_1_123 \$1866 \$290 \$1715
+ vss
+ vdd
+ vdd
+ \$1769 sky130_fd_sc_hd__a21oi_1
* cell instance sky130_fd_sc_hd__a21oi_1_124 r0 *1 0,0
Xsky130_fd_sc_hd__a21oi_1_124 \$586 \$290 \$880
+ vss
+ vdd
+ vdd
+ \$881 sky130_fd_sc_hd__a21oi_1
* cell instance sky130_fd_sc_hd__a21oi_1_125 r0 *1 0,0
Xsky130_fd_sc_hd__a21oi_1_125 \$1766 \$290 \$1868
+ vss
+ vdd
+ vdd
+ \$1768 sky130_fd_sc_hd__a21oi_1
* cell instance sky130_fd_sc_hd__a21oi_1_126 r0 *1 0,0
Xsky130_fd_sc_hd__a21oi_1_126 \$5238 \$4302 \$5279
+ vss
+ vdd
+ vdd
+ \$2685 sky130_fd_sc_hd__a21oi_1
* cell instance sky130_fd_sc_hd__a21oi_1_127 r0 *1 0,0
Xsky130_fd_sc_hd__a21oi_1_127 \$3302 \$399 \$3307
+ vss
+ vdd
+ vdd
+ \$3308 sky130_fd_sc_hd__a21oi_1
* cell instance sky130_fd_sc_hd__a21oi_1_128 r0 *1 0,0
Xsky130_fd_sc_hd__a21oi_1_128 \$4202 \$4299 \$4286
+ vss
+ vdd
+ vdd
+ \$4298 sky130_fd_sc_hd__a21oi_1
* cell instance sky130_fd_sc_hd__a21oi_1_129 r0 *1 0,0
Xsky130_fd_sc_hd__a21oi_1_129 \$2715 \$742 \$2453
+ vss
+ vdd
+ vdd
+ \$2502 sky130_fd_sc_hd__a21oi_1
* cell instance sky130_fd_sc_hd__a21oi_1_130 r0 *1 0,0
Xsky130_fd_sc_hd__a21oi_1_130 \$1078 \$1313 \$219
+ vss
+ vdd
+ vdd
+ \$1317 sky130_fd_sc_hd__a21oi_1
* cell instance sky130_fd_sc_hd__a21oi_1_131 r0 *1 0,0
Xsky130_fd_sc_hd__a21oi_1_131 \$170 \$290 \$302
+ vss
+ vdd
+ vdd
+ \$301 sky130_fd_sc_hd__a21oi_1
* cell instance sky130_fd_sc_hd__a21oi_1_132 r0 *1 0,0
Xsky130_fd_sc_hd__a21oi_1_132 \$4751 \$4302 \$5900
+ vss
+ vdd
+ vdd
+ \$3730 sky130_fd_sc_hd__a21oi_1
* cell instance sky130_fd_sc_hd__a21oi_1_133 r0 *1 0,0
Xsky130_fd_sc_hd__a21oi_1_133 \$7137 \$5325 \$6956
+ vss
+ vdd
+ vdd
+ \$6955 sky130_fd_sc_hd__a21oi_1
* cell instance sky130_fd_sc_hd__a21oi_1_134 r0 *1 0,0
Xsky130_fd_sc_hd__a21oi_1_134 \$3502 \$742 \$3614
+ vss
+ vdd
+ vdd
+ \$3617 sky130_fd_sc_hd__a21oi_1
* cell instance sky130_fd_sc_hd__a21oi_1_135 r0 *1 0,0
Xsky130_fd_sc_hd__a21oi_1_135 \$444 \$290 \$521
+ vss
+ vdd
+ vdd
+ \$520 sky130_fd_sc_hd__a21oi_1
* cell instance sky130_fd_sc_hd__a21oi_1_136 r0 *1 0,0
Xsky130_fd_sc_hd__a21oi_1_136 \$941 \$1013 \$940
+ vss
+ vdd
+ vdd
+ \$1016 sky130_fd_sc_hd__a21oi_1
* cell instance sky130_fd_sc_hd__a21oi_1_137 r0 *1 0,0
Xsky130_fd_sc_hd__a21oi_1_137 \$4979 \$4302 \$6523
+ vss
+ vdd
+ vdd
+ \$2807 sky130_fd_sc_hd__a21oi_1
* cell instance sky130_fd_sc_hd__a21oi_1_138 r0 *1 0,0
Xsky130_fd_sc_hd__a21oi_1_138 \$732 \$290 \$596
+ vss
+ vdd
+ vdd
+ \$644 sky130_fd_sc_hd__a21oi_1
* cell instance sky130_fd_sc_hd__a21oi_1_139 r0 *1 0,0
Xsky130_fd_sc_hd__a21oi_1_139 \$5172 \$5325 \$5240
+ vss
+ vdd
+ vdd
+ \$4917 sky130_fd_sc_hd__a21oi_1
* cell instance sky130_fd_sc_hd__a21oi_1_140 r0 *1 0,0
Xsky130_fd_sc_hd__a21oi_1_140 \$941 \$290 \$1017
+ vss
+ vdd
+ vdd
+ \$884 sky130_fd_sc_hd__a21oi_1
* cell instance sky130_fd_sc_hd__a21oi_1_141 r0 *1 0,0
Xsky130_fd_sc_hd__a21oi_1_141 \$238 \$180 \$179
+ vss
+ vdd
+ vdd
+ \$241 sky130_fd_sc_hd__a21oi_1
* cell instance sky130_fd_sc_hd__a21oi_1_142 r0 *1 0,0
Xsky130_fd_sc_hd__a21oi_1_142 \$3994 \$4302 \$4303
+ vss
+ vdd
+ vdd
+ \$4647 sky130_fd_sc_hd__a21oi_1
* cell instance sky130_fd_sc_hd__a21oi_1_143 r0 *1 0,0
Xsky130_fd_sc_hd__a21oi_1_143 \$1956 \$742 \$1872
+ vss
+ vdd
+ vdd
+ \$1871 sky130_fd_sc_hd__a21oi_1
* cell instance sky130_fd_sc_hd__a21oi_1_144 r0 *1 0,0
Xsky130_fd_sc_hd__a21oi_1_144 \$1226 \$290 \$1324
+ vss
+ vdd
+ vdd
+ \$1323 sky130_fd_sc_hd__a21oi_1
* cell instance sky130_fd_sc_hd__a21oi_1_145 r0 *1 0,0
Xsky130_fd_sc_hd__a21oi_1_145 \$1086 \$290 \$1092
+ vss
+ vdd
+ vdd
+ \$1020 sky130_fd_sc_hd__a21oi_1
* cell instance sky130_fd_sc_hd__a21oi_1_146 r0 *1 0,0
Xsky130_fd_sc_hd__a21oi_1_146 \$809 \$742 \$741
+ vss
+ vdd
+ vdd
+ \$951 sky130_fd_sc_hd__a21oi_1
* cell instance sky130_fd_sc_hd__a21oi_1_147 r0 *1 0,0
Xsky130_fd_sc_hd__a21oi_1_147 \$456 \$453 \$182
+ vss
+ vdd
+ vdd
+ \$457 sky130_fd_sc_hd__a21oi_1
* cell instance sky130_fd_sc_hd__a21oi_1_148 r0 *1 0,0
Xsky130_fd_sc_hd__a21oi_1_148 \$182 \$241 \$457
+ vss
+ vdd
+ vdd
+ \$250 sky130_fd_sc_hd__a21oi_1
* cell instance sky130_fd_sc_hd__a21oi_1_149 r0 *1 0,0
Xsky130_fd_sc_hd__a21oi_1_149 \$645 \$742 \$743
+ vss
+ vdd
+ vdd
+ \$886 sky130_fd_sc_hd__a21oi_1
* cell instance sky130_fd_sc_hd__a21oi_1_150 r0 *1 0,0
Xsky130_fd_sc_hd__a21oi_1_150 \$525 \$381 \$182
+ vss
+ vdd
+ vdd
+ \$383 sky130_fd_sc_hd__a21oi_1
* cell instance sky130_fd_sc_hd__a21oi_1_151 r0 *1 0,0
Xsky130_fd_sc_hd__a21oi_1_151 \$1517 \$1597 \$182
+ vss
+ vdd
+ vdd
+ \$1519 sky130_fd_sc_hd__a21oi_1
* cell instance sky130_fd_sc_hd__a21oi_1_152 r0 *1 0,0
Xsky130_fd_sc_hd__a21oi_1_152 \$2579 \$3848 \$4085
+ vss
+ vdd
+ vdd
+ \$4091 sky130_fd_sc_hd__a21oi_1
* cell instance sky130_fd_sc_hd__a21oi_1_153 r0 *1 0,0
Xsky130_fd_sc_hd__a21oi_1_153 \$41 \$180 \$252
+ vss
+ vdd
+ vdd
+ \$187 sky130_fd_sc_hd__a21oi_1
* cell instance sky130_fd_sc_hd__a21oi_1_154 r0 *1 0,0
Xsky130_fd_sc_hd__a21oi_1_154 \$182 \$187 \$383
+ vss
+ vdd
+ vdd
+ \$385 sky130_fd_sc_hd__a21oi_1
* cell instance sky130_fd_sc_hd__a21oi_1_155 r0 *1 0,0
Xsky130_fd_sc_hd__a21oi_1_155 \$2569 \$2354 \$2356
+ vss
+ vdd
+ vdd
+ \$2179 sky130_fd_sc_hd__a21oi_1
* cell instance sky130_fd_sc_hd__a21oi_1_156 r0 *1 0,0
Xsky130_fd_sc_hd__a21oi_1_156 \$952 \$399 \$888
+ vss
+ vdd
+ vdd
+ \$887 sky130_fd_sc_hd__a21oi_1
* cell instance sky130_fd_sc_hd__a21oi_1_157 r0 *1 0,0
Xsky130_fd_sc_hd__a21oi_1_157 \$1174 \$180 \$1327
+ vss
+ vdd
+ vdd
+ \$1520 sky130_fd_sc_hd__a21oi_1
* cell instance sky130_fd_sc_hd__a21oi_1_158 r0 *1 0,0
Xsky130_fd_sc_hd__a21oi_1_158 \$182 \$1520 \$1519
+ vss
+ vdd
+ vdd
+ \$1599 sky130_fd_sc_hd__a21oi_1
* cell instance sky130_fd_sc_hd__a21oi_1_159 r0 *1 0,0
Xsky130_fd_sc_hd__a21oi_1_159 \$3260 \$3513 \$3512
+ vss
+ vdd
+ vdd
+ \$3515 sky130_fd_sc_hd__a21oi_1
* cell instance sky130_fd_sc_hd__a21oi_1_160 r0 *1 0,0
Xsky130_fd_sc_hd__a21oi_1_160 \$1672 \$180 \$1774
+ vss
+ vdd
+ vdd
+ \$1776 sky130_fd_sc_hd__a21oi_1
* cell instance sky130_fd_sc_hd__a21oi_1_161 r0 *1 0,0
Xsky130_fd_sc_hd__a21oi_1_161 \$2847 \$1022 \$3850
+ vss
+ vdd
+ vdd
+ \$4093 sky130_fd_sc_hd__a21oi_1
* cell instance sky130_fd_sc_hd__a21oi_1_162 r0 *1 0,0
Xsky130_fd_sc_hd__a21oi_1_162 \$6624 \$5325 \$6720
+ vss
+ vdd
+ vdd
+ \$6719 sky130_fd_sc_hd__a21oi_1
* cell instance sky130_fd_sc_hd__a21oi_1_163 r0 *1 0,0
Xsky130_fd_sc_hd__a21oi_1_163 \$7860 \$5325 \$7775
+ vss
+ vdd
+ vdd
+ \$7861 sky130_fd_sc_hd__a21oi_1
* cell instance sky130_fd_sc_hd__a21oi_1_164 r0 *1 0,0
Xsky130_fd_sc_hd__a21oi_1_164 \$182 \$887 \$961
+ vss
+ vdd
+ vdd
+ \$1025 sky130_fd_sc_hd__a21oi_1
* cell instance sky130_fd_sc_hd__a21oi_1_165 r0 *1 0,0
Xsky130_fd_sc_hd__a21oi_1_165 \$2458 \$3232 \$3234
+ vss
+ vdd
+ vdd
+ \$3225 sky130_fd_sc_hd__a21oi_1
* cell instance sky130_fd_sc_hd__a21oi_1_166 r0 *1 0,0
Xsky130_fd_sc_hd__a21oi_1_166 \$7465 \$4302 \$7397
+ vss
+ vdd
+ vdd
+ \$2469 sky130_fd_sc_hd__a21oi_1
* cell instance sky130_fd_sc_hd__a21oi_1_167 r0 *1 0,0
Xsky130_fd_sc_hd__a21oi_1_167 \$663 \$399 \$755
+ vss
+ vdd
+ vdd
+ \$821 sky130_fd_sc_hd__a21oi_1
* cell instance sky130_fd_sc_hd__a21oi_1_168 r0 *1 0,0
Xsky130_fd_sc_hd__a21oi_1_168 \$1245 \$180 \$1681
+ vss
+ vdd
+ vdd
+ \$1601 sky130_fd_sc_hd__a21oi_1
* cell instance sky130_fd_sc_hd__a21oi_1_169 r0 *1 0,0
Xsky130_fd_sc_hd__a21oi_1_169 \$1777 \$683 \$2069
+ vss
+ vdd
+ vdd
+ \$2182 sky130_fd_sc_hd__a21oi_1
* cell instance sky130_fd_sc_hd__a21oi_1_170 r0 *1 0,0
Xsky130_fd_sc_hd__a21oi_1_170 \$1967 \$399 \$1887
+ vss
+ vdd
+ vdd
+ \$1891 sky130_fd_sc_hd__a21oi_1
* cell instance sky130_fd_sc_hd__a21oi_1_171 r0 *1 0,0
Xsky130_fd_sc_hd__a21oi_1_171 \$182 \$821 \$1027
+ vss
+ vdd
+ vdd
+ \$895 sky130_fd_sc_hd__a21oi_1
* cell instance sky130_fd_sc_hd__a21oi_1_172 r0 *1 0,0
Xsky130_fd_sc_hd__a21oi_1_172 \$2815 \$892 \$3235
+ vss
+ vdd
+ vdd
+ \$3007 sky130_fd_sc_hd__a21oi_1
* cell instance sky130_fd_sc_hd__a21oi_1_173 r0 *1 0,0
Xsky130_fd_sc_hd__a21oi_1_173 \$1441 \$399 \$1338
+ vss
+ vdd
+ vdd
+ \$1340 sky130_fd_sc_hd__a21oi_1
* cell instance sky130_fd_sc_hd__a21oi_1_174 r0 *1 0,0
Xsky130_fd_sc_hd__a21oi_1_174 \$389 \$399 \$533
+ vss
+ vdd
+ vdd
+ \$532 sky130_fd_sc_hd__a21oi_1
* cell instance sky130_fd_sc_hd__a21oi_1_175 r0 *1 0,0
Xsky130_fd_sc_hd__a21oi_1_175 \$3260 \$3327 \$2586
+ vss
+ vdd
+ vdd
+ \$3239 sky130_fd_sc_hd__a21oi_1
* cell instance sky130_fd_sc_hd__a21oi_1_176 r0 *1 0,0
Xsky130_fd_sc_hd__a21oi_1_176 \$2074 \$4302 \$5596
+ vss
+ vdd
+ vdd
+ \$3860 sky130_fd_sc_hd__a21oi_1
* cell instance sky130_fd_sc_hd__a21oi_1_177 r0 *1 0,0
Xsky130_fd_sc_hd__a21oi_1_177 \$2815 \$1527 \$3107
+ vss
+ vdd
+ vdd
+ \$3109 sky130_fd_sc_hd__a21oi_1
* cell instance sky130_fd_sc_hd__a21oi_1_178 r0 *1 0,0
Xsky130_fd_sc_hd__a21oi_1_178 \$535 \$399 \$470
+ vss
+ vdd
+ vdd
+ \$609 sky130_fd_sc_hd__a21oi_1
* cell instance sky130_fd_sc_hd__a21oi_1_179 r0 *1 0,0
Xsky130_fd_sc_hd__a21oi_1_179 \$6063 \$5325 \$6061
+ vss
+ vdd
+ vdd
+ \$5816 sky130_fd_sc_hd__a21oi_1
* cell instance sky130_fd_sc_hd__a21oi_1_180 r0 *1 0,0
Xsky130_fd_sc_hd__a21oi_1_180 \$7475 \$5325 \$7166
+ vss
+ vdd
+ vdd
+ \$7167 sky130_fd_sc_hd__a21oi_1
* cell instance sky130_fd_sc_hd__a21oi_1_181 r0 *1 0,0
Xsky130_fd_sc_hd__a21oi_1_181 \$182 \$532 \$759
+ vss
+ vdd
+ vdd
+ \$611 sky130_fd_sc_hd__a21oi_1
* cell instance sky130_fd_sc_hd__a21oi_1_182 r0 *1 0,0
Xsky130_fd_sc_hd__a21oi_1_182 \$5924 \$4302 \$6457
+ vss
+ vdd
+ vdd
+ \$6546 sky130_fd_sc_hd__a21oi_1
* cell instance sky130_fd_sc_hd__a21oi_1_183 r0 *1 0,0
Xsky130_fd_sc_hd__a21oi_1_183 \$2847 \$1608 \$2583
+ vss
+ vdd
+ vdd
+ \$2587 sky130_fd_sc_hd__a21oi_1
* cell instance sky130_fd_sc_hd__a21oi_1_184 r0 *1 0,0
Xsky130_fd_sc_hd__a21oi_1_184 \$182 \$609 \$836
+ vss
+ vdd
+ vdd
+ \$762 sky130_fd_sc_hd__a21oi_1
* cell instance sky130_fd_sc_hd__a21oi_1_185 r0 *1 0,0
Xsky130_fd_sc_hd__a21oi_1_185 \$6458 \$4302 \$6891
+ vss
+ vdd
+ vdd
+ \$6893 sky130_fd_sc_hd__a21oi_1
* cell instance sky130_fd_sc_hd__a21oi_1_186 r0 *1 0,0
Xsky130_fd_sc_hd__a21oi_1_186 \$2913 \$2909 \$3111
+ vss
+ vdd
+ vdd
+ \$2911 sky130_fd_sc_hd__a21oi_1
* cell instance sky130_fd_sc_hd__a21oi_1_187 r0 *1 0,0
Xsky130_fd_sc_hd__a21oi_1_187 \$2815 \$832 \$2911
+ vss
+ vdd
+ vdd
+ \$3013 sky130_fd_sc_hd__a21oi_1
* cell instance sky130_fd_sc_hd__a21oi_1_188 r0 *1 0,0
Xsky130_fd_sc_hd__a21oi_1_188 bus_rdata[13] \$2486 \$3977
+ vss
+ vdd
+ vdd
+ \$4107 sky130_fd_sc_hd__a21oi_1
* cell instance sky130_fd_sc_hd__a21oi_1_189 r0 *1 0,0
Xsky130_fd_sc_hd__a21oi_1_189 \$1896 \$180 \$1979
+ vss
+ vdd
+ vdd
+ \$2078 sky130_fd_sc_hd__a21oi_1
* cell instance sky130_fd_sc_hd__a21oi_1_190 r0 *1 0,0
Xsky130_fd_sc_hd__a21oi_1_190 \$1529 \$399 \$1451
+ vss
+ vdd
+ vdd
+ \$1452 sky130_fd_sc_hd__a21oi_1
* cell instance sky130_fd_sc_hd__a21oi_1_191 r0 *1 0,0
Xsky130_fd_sc_hd__a21oi_1_191 \$473 \$399 \$401
+ vss
+ vdd
+ vdd
+ \$545 sky130_fd_sc_hd__a21oi_1
* cell instance sky130_fd_sc_hd__a21oi_1_192 r0 *1 0,0
Xsky130_fd_sc_hd__a21oi_1_192 \$1718 \$399 \$2281
+ vss
+ vdd
+ vdd
+ \$2080 sky130_fd_sc_hd__a21oi_1
* cell instance sky130_fd_sc_hd__a21oi_1_193 r0 *1 0,0
Xsky130_fd_sc_hd__a21oi_1_193 \$2376 \$683 \$2194
+ vss
+ vdd
+ vdd
+ \$2283 sky130_fd_sc_hd__a21oi_1
* cell instance sky130_fd_sc_hd__a21oi_1_194 r0 *1 0,0
Xsky130_fd_sc_hd__a21oi_1_194 \$182 \$1452 \$1609
+ vss
+ vdd
+ vdd
+ \$1348 sky130_fd_sc_hd__a21oi_1
* cell instance sky130_fd_sc_hd__a21oi_1_195 r0 *1 0,0
Xsky130_fd_sc_hd__a21oi_1_195 \$4324 \$4302 \$4561
+ vss
+ vdd
+ vdd
+ \$3531 sky130_fd_sc_hd__a21oi_1
* cell instance sky130_fd_sc_hd__a21oi_1_196 r0 *1 0,0
Xsky130_fd_sc_hd__a21oi_1_196 \$182 \$545 \$839
+ vss
+ vdd
+ vdd
+ \$685 sky130_fd_sc_hd__a21oi_1
* cell instance sky130_fd_sc_hd__a21oi_1_197 r0 *1 0,0
Xsky130_fd_sc_hd__a21oi_1_197 \$5926 \$5325 \$6156
+ vss
+ vdd
+ vdd
+ \$5719 sky130_fd_sc_hd__a21oi_1
* cell instance sky130_fd_sc_hd__a21oi_1_198 r0 *1 0,0
Xsky130_fd_sc_hd__a21oi_1_198 \$7484 \$5325 \$7485
+ vss
+ vdd
+ vdd
+ \$7487 sky130_fd_sc_hd__a21oi_1
* cell instance sky130_fd_sc_hd__a21oi_1_199 r0 *1 0,0
Xsky130_fd_sc_hd__a21oi_1_199 \$6731 \$5325 \$6734
+ vss
+ vdd
+ vdd
+ \$6561 sky130_fd_sc_hd__a21oi_1
* cell instance sky130_fd_sc_hd__a21oi_1_200 r0 *1 0,0
Xsky130_fd_sc_hd__a21oi_1_200 \$7081 \$4302 \$7079
+ vss
+ vdd
+ vdd
+ \$4229 sky130_fd_sc_hd__a21oi_1
* cell instance sky130_fd_sc_hd__a21oi_1_201 r0 *1 0,0
Xsky130_fd_sc_hd__a21oi_1_201 \$1611 \$399 \$1798
+ vss
+ vdd
+ vdd
+ \$1700 sky130_fd_sc_hd__a21oi_1
* cell instance sky130_fd_sc_hd__a21oi_1_202 r0 *1 0,0
Xsky130_fd_sc_hd__a21oi_1_202 \$405 \$399 \$547
+ vss
+ vdd
+ vdd
+ \$621 sky130_fd_sc_hd__a21oi_1
* cell instance sky130_fd_sc_hd__a21oi_1_203 r0 *1 0,0
Xsky130_fd_sc_hd__a21oi_1_203 \$981 \$180 \$1043
+ vss
+ vdd
+ vdd
+ \$1117 sky130_fd_sc_hd__a21oi_1
* cell instance sky130_fd_sc_hd__a21oi_1_204 r0 *1 0,0
Xsky130_fd_sc_hd__a21oi_1_204 \$6089 \$4302 \$6470
+ vss
+ vdd
+ vdd
+ \$3537 sky130_fd_sc_hd__a21oi_1
* cell instance sky130_fd_sc_hd__a21oi_1_205 r0 *1 0,0
Xsky130_fd_sc_hd__a21oi_1_205 \$182 \$621 \$688
+ vss
+ vdd
+ vdd
+ \$690 sky130_fd_sc_hd__a21oi_1
* cell instance sky130_fd_sc_hd__a21oi_1_206 r0 *1 0,0
Xsky130_fd_sc_hd__a21oi_1_206 \$2818 \$180 \$2704
+ vss
+ vdd
+ vdd
+ \$2707 sky130_fd_sc_hd__a21oi_1
* cell instance sky130_fd_sc_hd__a21oi_1_207 r0 *1 0,0
Xsky130_fd_sc_hd__a21oi_1_207 \$842 \$399 \$1118
+ vss
+ vdd
+ vdd
+ \$1197 sky130_fd_sc_hd__a21oi_1
* cell instance sky130_fd_sc_hd__a21oi_1_208 r0 *1 0,0
Xsky130_fd_sc_hd__a21oi_1_208 bus_rdata[8] \$2486 \$3248
+ vss
+ vdd
+ vdd
+ \$3342 sky130_fd_sc_hd__a21oi_1
* cell instance sky130_fd_sc_hd__a21oi_1_209 r0 *1 0,0
Xsky130_fd_sc_hd__a21oi_1_209 \$2598 \$399 \$2921
+ vss
+ vdd
+ vdd
+ \$3018 sky130_fd_sc_hd__a21oi_1
* cell instance sky130_fd_sc_hd__a21oi_1_210 r0 *1 0,0
Xsky130_fd_sc_hd__a21oi_1_210 \$1983 \$683 \$1908
+ vss
+ vdd
+ vdd
+ \$2095 sky130_fd_sc_hd__a21oi_1
* cell instance sky130_fd_sc_hd__a21oi_1_211 r0 *1 0,0
Xsky130_fd_sc_hd__a21oi_1_211 \$1357 \$180 \$1538
+ vss
+ vdd
+ vdd
+ \$1622 sky130_fd_sc_hd__a21oi_1
* cell instance sky130_fd_sc_hd__a21oi_1_212 r0 *1 0,0
Xsky130_fd_sc_hd__a21oi_1_212 \$1272 \$683 \$1198
+ vss
+ vdd
+ vdd
+ \$1273 sky130_fd_sc_hd__a21oi_1
* cell instance sky130_fd_sc_hd__a21oi_1_213 r0 *1 0,0
Xsky130_fd_sc_hd__a21oi_1_213 \$549 \$683 \$486
+ vss
+ vdd
+ vdd
+ \$623 sky130_fd_sc_hd__a21oi_1
* cell instance sky130_fd_sc_hd__a21oi_1_214 r0 *1 0,0
Xsky130_fd_sc_hd__a21oi_1_214 \$3266 \$683 \$3019
+ vss
+ vdd
+ vdd
+ \$3022 sky130_fd_sc_hd__a21oi_1
* cell instance sky130_fd_sc_hd__a21oi_1_215 r0 *1 0,0
Xsky130_fd_sc_hd__a21oi_1_215 \$1457 \$399 \$1623
+ vss
+ vdd
+ vdd
+ \$1625 sky130_fd_sc_hd__a21oi_1
* cell instance sky130_fd_sc_hd__a21oi_1_216 r0 *1 0,0
Xsky130_fd_sc_hd__a21oi_1_216 \$1046 \$180 \$773
+ vss
+ vdd
+ vdd
+ \$775 sky130_fd_sc_hd__a21oi_1
* cell instance sky130_fd_sc_hd__a21oi_1_217 r0 *1 0,0
Xsky130_fd_sc_hd__a21oi_1_217 \$852 \$399 \$918
+ vss
+ vdd
+ vdd
+ \$920 sky130_fd_sc_hd__a21oi_1
* cell instance sky130_fd_sc_hd__a21oi_1_218 r0 *1 0,0
Xsky130_fd_sc_hd__a21oi_1_218 \$1703 \$683 \$1702
+ vss
+ vdd
+ vdd
+ \$1816 sky130_fd_sc_hd__a21oi_1
* cell instance sky130_fd_sc_hd__a21oi_1_219 r0 *1 0,0
Xsky130_fd_sc_hd__a21oi_1_219 \$352 \$399 \$353
+ vss
+ vdd
+ vdd
+ \$355 sky130_fd_sc_hd__a21oi_1
* cell instance sky130_fd_sc_hd__a21oi_1_220 r0 *1 0,0
Xsky130_fd_sc_hd__a21oi_1_220 \$992 \$683 \$991
+ vss
+ vdd
+ vdd
+ \$994 sky130_fd_sc_hd__a21oi_1
* cell instance sky130_fd_sc_hd__a221o_1_0 r0 *1 0,0
Xsky130_fd_sc_hd__a221o_1_0 bus_rdata[16] \$2575 \$2471 \$2579 \$2573
+ vss
+ vdd
+ vdd
+ \$2619 sky130_fd_sc_hd__a221o_1
* cell instance sky130_fd_sc_hd__a221oi_1_0 r0 *1 0,0
Xsky130_fd_sc_hd__a221oi_1_0 \$1516 \$1669 \$2263 \$2350 \$2679
+ vss
+ vdd
+ vdd
+ \$2352 sky130_fd_sc_hd__a221oi_1
* cell instance sky130_fd_sc_hd__a221oi_1_1 r0 *1 0,0
Xsky130_fd_sc_hd__a221oi_1_1 \$2847 \$686 \$2486 bus_rdata[12] \$4095
+ vss
+ vdd
+ vdd
+ \$3979 sky130_fd_sc_hd__a221oi_1
* cell instance sky130_fd_sc_hd__a222oi_1_0 r0 *1 0,0
Xsky130_fd_sc_hd__a222oi_1_0 \$5859 \$5857 \$5860 \$5862 \$5865 \$5864
+ vss
+ vdd
+ vdd
+ \$5863 sky130_fd_sc_hd__a222oi_1
* cell instance sky130_fd_sc_hd__a22o_1_0 r0 *1 0,0
Xsky130_fd_sc_hd__a22o_1_0 bus_rdata[9] \$2486 \$3628 \$2579
+ vss
+ vdd
+ vdd
+ \$3850 sky130_fd_sc_hd__a22o_1
* cell instance sky130_fd_sc_hd__a22o_1_1 r0 *1 0,0
Xsky130_fd_sc_hd__a22o_1_1 \$3260 \$3106 \$3232
+ a|inv_q_y|inv_q_y_via|inv_q_y_via2|nand_s2_a|nand_s2_a_stub|nand_s2_a_via|nand_s2_a_via2|q|raw_valid|y
+ vss
+ vdd
+ vdd
+ \$3235 sky130_fd_sc_hd__a22o_1
* cell instance sky130_fd_sc_hd__a22o_1_2 r0 *1 0,0
Xsky130_fd_sc_hd__a22o_1_2 bus_rdata[6] \$2575 \$2586 \$2579
+ vss
+ vdd
+ vdd
+ \$2583 sky130_fd_sc_hd__a22o_1
* cell instance sky130_fd_sc_hd__a22o_1_3 r0 *1 0,0
Xsky130_fd_sc_hd__a22o_1_3 bus_rdata[20] \$2486 \$2802 \$2579
+ vss
+ vdd
+ vdd
+ \$2597 sky130_fd_sc_hd__a22o_1
* cell instance sky130_fd_sc_hd__a22o_1_4 r0 *1 0,0
Xsky130_fd_sc_hd__a22o_1_4 bus_rdata[28] \$2486 \$3846 \$2579
+ vss
+ vdd
+ vdd
+ \$3876 sky130_fd_sc_hd__a22o_1
* cell instance sky130_fd_sc_hd__a22o_1_5 r0 *1 0,0
Xsky130_fd_sc_hd__a22o_1_5 bus_rdata[30] \$2486 \$2489 \$2579
+ vss
+ vdd
+ vdd
+ \$2093 sky130_fd_sc_hd__a22o_1
* cell instance sky130_fd_sc_hd__a22o_1_6 r0 *1 0,0
Xsky130_fd_sc_hd__a22o_1_6 bus_rdata[22] \$2486 \$3612 \$2579
+ vss
+ vdd
+ vdd
+ \$3541 sky130_fd_sc_hd__a22o_1
* cell instance sky130_fd_sc_hd__a22o_1_7 r0 *1 0,0
Xsky130_fd_sc_hd__a22o_1_7 bus_rdata[0] \$2486 \$3863 \$2579
+ vss
+ vdd
+ vdd
+ \$3981 sky130_fd_sc_hd__a22o_1
* cell instance sky130_fd_sc_hd__a22o_1_8 r0 *1 0,0
Xsky130_fd_sc_hd__a22o_1_8 bus_rdata[10] \$2486 \$3731 \$2579
+ vss
+ vdd
+ vdd
+ \$3758 sky130_fd_sc_hd__a22o_1
* cell instance sky130_fd_sc_hd__a22o_1_9 r0 *1 0,0
Xsky130_fd_sc_hd__a22o_1_9 bus_rdata[11] \$2486 \$2806 \$2579
+ vss
+ vdd
+ vdd
+ \$2836 sky130_fd_sc_hd__a22o_1
* cell instance sky130_fd_sc_hd__a22o_1_10 r0 *1 0,0
Xsky130_fd_sc_hd__a22o_1_10 bus_rdata[26] \$2486 \$3428 \$2579
+ vss
+ vdd
+ vdd
+ \$3429 sky130_fd_sc_hd__a22o_1
* cell instance sky130_fd_sc_hd__a22oi_1_0 r0 *1 0,0
Xsky130_fd_sc_hd__a22oi_1_0 \$2097 \$290 \$2108 \$2498
+ vss
+ vdd
+ vdd
+ \$2204 sky130_fd_sc_hd__a22oi_1
* cell instance sky130_fd_sc_hd__a22oi_1_1 r0 *1 0,0
Xsky130_fd_sc_hd__a22oi_1_1 \$5638 \$290 \$5833 \$5303
+ vss
+ vdd
+ vdd
+ \$5964 sky130_fd_sc_hd__a22oi_1
* cell instance sky130_fd_sc_hd__a22oi_1_2 r0 *1 0,0
Xsky130_fd_sc_hd__a22oi_1_2 \$2851 \$290 \$2108 \$2626
+ vss
+ vdd
+ vdd
+ \$2722 sky130_fd_sc_hd__a22oi_1
* cell instance sky130_fd_sc_hd__a22oi_1_3 r0 *1 0,0
Xsky130_fd_sc_hd__a22oi_1_3 \$5624 \$290 \$5965 \$5303
+ vss
+ vdd
+ vdd
+ \$5739 sky130_fd_sc_hd__a22oi_1
* cell instance sky130_fd_sc_hd__a22oi_1_4 r0 *1 0,0
Xsky130_fd_sc_hd__a22oi_1_4 \$5400 \$290 \$5303 \$5520
+ vss
+ vdd
+ vdd
+ \$5187 sky130_fd_sc_hd__a22oi_1
* cell instance sky130_fd_sc_hd__a22oi_1_5 r0 *1 0,0
Xsky130_fd_sc_hd__a22oi_1_5 \$2725 \$290 \$2507 \$2108
+ vss
+ vdd
+ vdd
+ \$2726 sky130_fd_sc_hd__a22oi_1
* cell instance sky130_fd_sc_hd__a22oi_1_6 r0 *1 0,0
Xsky130_fd_sc_hd__a22oi_1_6 \$6091 \$290 \$6172 \$5303
+ vss
+ vdd
+ vdd
+ \$6170 sky130_fd_sc_hd__a22oi_1
* cell instance sky130_fd_sc_hd__a22oi_1_7 r0 *1 0,0
Xsky130_fd_sc_hd__a22oi_1_7 \$1999 \$290 \$2108 \$2210
+ vss
+ vdd
+ vdd
+ \$2106 sky130_fd_sc_hd__a22oi_1
* cell instance sky130_fd_sc_hd__a22oi_1_8 r0 *1 0,0
Xsky130_fd_sc_hd__a22oi_1_8 \$6174 \$290 \$6388 \$5303
+ vss
+ vdd
+ vdd
+ \$6493 sky130_fd_sc_hd__a22oi_1
* cell instance sky130_fd_sc_hd__a22oi_1_9 r0 *1 0,0
Xsky130_fd_sc_hd__a22oi_1_9 \$2109 \$290 \$2108 \$2411
+ vss
+ vdd
+ vdd
+ \$2302 sky130_fd_sc_hd__a22oi_1
* cell instance sky130_fd_sc_hd__a22oi_1_10 r0 *1 0,0
Xsky130_fd_sc_hd__a22oi_1_10 \$4936 \$290 \$5303 \$5304
+ vss
+ vdd
+ vdd
+ \$5302 sky130_fd_sc_hd__a22oi_1
* cell instance sky130_fd_sc_hd__a22oi_1_11 r0 *1 0,0
Xsky130_fd_sc_hd__a22oi_1_11 \$3279 \$290 \$2108 \$3461
+ vss
+ vdd
+ vdd
+ \$3579 sky130_fd_sc_hd__a22oi_1
* cell instance sky130_fd_sc_hd__a22oi_1_12 r0 *1 0,0
Xsky130_fd_sc_hd__a22oi_1_12 \$2634 \$290 \$2108 \$2743
+ vss
+ vdd
+ vdd
+ \$2741 sky130_fd_sc_hd__a22oi_1
* cell instance sky130_fd_sc_hd__a22oi_1_13 r0 *1 0,0
Xsky130_fd_sc_hd__a22oi_1_13 \$2121 \$290 \$2108 \$2011
+ vss
+ vdd
+ vdd
+ \$2010 sky130_fd_sc_hd__a22oi_1
* cell instance sky130_fd_sc_hd__a22oi_1_14 r0 *1 0,0
Xsky130_fd_sc_hd__a22oi_1_14 \$5308 \$290 \$5510 \$5303
+ vss
+ vdd
+ vdd
+ \$5647 sky130_fd_sc_hd__a22oi_1
* cell instance sky130_fd_sc_hd__a22oi_1_15 r0 *1 0,0
Xsky130_fd_sc_hd__a22oi_1_15 \$2746 \$290 \$2108 \$3255
+ vss
+ vdd
+ vdd
+ \$3173 sky130_fd_sc_hd__a22oi_1
* cell instance sky130_fd_sc_hd__a22oi_1_16 r0 *1 0,0
Xsky130_fd_sc_hd__a22oi_1_16 \$4604 \$290 \$2108 \$4951
+ vss
+ vdd
+ vdd
+ \$4949 sky130_fd_sc_hd__a22oi_1
* cell instance sky130_fd_sc_hd__a22oi_1_17 r0 *1 0,0
Xsky130_fd_sc_hd__a22oi_1_17 \$4261 \$290 \$2108 \$4363
+ vss
+ vdd
+ vdd
+ \$4362 sky130_fd_sc_hd__a22oi_1
* cell instance sky130_fd_sc_hd__a22oi_1_18 r0 *1 0,0
Xsky130_fd_sc_hd__a22oi_1_18 \$4609 \$290 \$2108 \$4373
+ vss
+ vdd
+ vdd
+ \$4610 sky130_fd_sc_hd__a22oi_1
* cell instance sky130_fd_sc_hd__a22oi_1_19 r0 *1 0,0
Xsky130_fd_sc_hd__a22oi_1_19 \$5076 \$290 \$2108 \$4959
+ vss
+ vdd
+ vdd
+ \$4957 sky130_fd_sc_hd__a22oi_1
* cell instance sky130_fd_sc_hd__a22oi_1_20 r0 *1 0,0
Xsky130_fd_sc_hd__a22oi_1_20 \$702 \$929 \$787 \$788
+ vss
+ vdd
+ vdd
+ \$1559 sky130_fd_sc_hd__a22oi_1
* cell instance sky130_fd_sc_hd__a22oi_1_21 r0 *1 0,0
Xsky130_fd_sc_hd__a22oi_1_21 \$787 \$585 \$791 \$862
+ vss
+ vdd
+ vdd
+ \$789 sky130_fd_sc_hd__a22oi_1
* cell instance sky130_fd_sc_hd__a22oi_1_22 r0 *1 0,0
Xsky130_fd_sc_hd__a22oi_1_22 \$1755 \$1661 \$1074 \$788
+ vss
+ vdd
+ vdd
+ \$1753 sky130_fd_sc_hd__a22oi_1
* cell instance sky130_fd_sc_hd__a22oi_1_23 r0 *1 0,0
Xsky130_fd_sc_hd__a22oi_1_23 \$1074 \$585 \$1662 \$1758
+ vss
+ vdd
+ vdd
+ \$1756 sky130_fd_sc_hd__a22oi_1
* cell instance sky130_fd_sc_hd__a22oi_1_24 r0 *1 0,0
Xsky130_fd_sc_hd__a22oi_1_24 \$585 \$1411 \$1370 \$1576
+ vss
+ vdd
+ vdd
+ \$1663 sky130_fd_sc_hd__a22oi_1
* cell instance sky130_fd_sc_hd__a22oi_1_25 r0 *1 0,0
Xsky130_fd_sc_hd__a22oi_1_25 \$582 \$585 \$584 \$234
+ vss
+ vdd
+ vdd
+ \$102 sky130_fd_sc_hd__a22oi_1
* cell instance sky130_fd_sc_hd__a22oi_1_26 r0 *1 0,0
Xsky130_fd_sc_hd__a22oi_1_26 \$586 \$730 \$582 \$788
+ vss
+ vdd
+ vdd
+ \$805 sky130_fd_sc_hd__a22oi_1
* cell instance sky130_fd_sc_hd__a22oi_1_27 r0 *1 0,0
Xsky130_fd_sc_hd__a22oi_1_27 \$1866 \$1763 \$1414 \$788
+ vss
+ vdd
+ vdd
+ \$1666 sky130_fd_sc_hd__a22oi_1
* cell instance sky130_fd_sc_hd__a22oi_1_28 r0 *1 0,0
Xsky130_fd_sc_hd__a22oi_1_28 \$1414 \$585 \$1665 \$1766
+ vss
+ vdd
+ vdd
+ \$1764 sky130_fd_sc_hd__a22oi_1
* cell instance sky130_fd_sc_hd__a22oi_1_29 r0 *1 0,0
Xsky130_fd_sc_hd__a22oi_1_29 \$633 \$585 \$807 \$444
+ vss
+ vdd
+ vdd
+ \$641 sky130_fd_sc_hd__a22oi_1
* cell instance sky130_fd_sc_hd__a22oi_1_30 r0 *1 0,0
Xsky130_fd_sc_hd__a22oi_1_30 \$732 \$731 \$633 \$788
+ vss
+ vdd
+ vdd
+ \$594 sky130_fd_sc_hd__a22oi_1
* cell instance sky130_fd_sc_hd__a22oi_1_31 r0 *1 0,0
Xsky130_fd_sc_hd__a22oi_1_31 bus_rdata[14] \$2575 \$3841 \$2579
+ vss
+ vdd
+ vdd
+ \$4083 sky130_fd_sc_hd__a22oi_1
* cell instance sky130_fd_sc_hd__a22oi_1_32 r0 *1 0,0
Xsky130_fd_sc_hd__a22oi_1_32 \$1586 \$1316 \$788 \$1411
+ vss
+ vdd
+ vdd
+ \$1667 sky130_fd_sc_hd__a22oi_1
* cell instance sky130_fd_sc_hd__a22oi_1_33 r0 *1 0,0
Xsky130_fd_sc_hd__a22oi_1_33 \$2682 \$2684 \$2683 \$2458
+ vss
+ vdd
+ vdd
+ \$2354 sky130_fd_sc_hd__a22oi_1
* cell instance sky130_fd_sc_hd__a22oi_1_34 r0 *1 0,0
Xsky130_fd_sc_hd__a22oi_1_34 bus_rdata[3] \$2575 \$3003 \$2579
+ vss
+ vdd
+ vdd
+ \$2905 sky130_fd_sc_hd__a22oi_1
* cell instance sky130_fd_sc_hd__a22oi_1_35 r0 *1 0,0
Xsky130_fd_sc_hd__a22oi_1_35 bus_rdata[1] \$2486 \$3629 \$2579
+ vss
+ vdd
+ vdd
+ \$4422 sky130_fd_sc_hd__a22oi_1
* cell instance sky130_fd_sc_hd__a22oi_1_36 r0 *1 0,0
Xsky130_fd_sc_hd__a22oi_1_36 bus_rdata[2] \$2575 \$2580 \$2579
+ vss
+ vdd
+ vdd
+ \$2581 sky130_fd_sc_hd__a22oi_1
* cell instance sky130_fd_sc_hd__a22oi_1_37 r0 *1 0,0
Xsky130_fd_sc_hd__a22oi_1_37 bus_rdata[5] \$2486 \$3632 \$2579
+ vss
+ vdd
+ vdd
+ \$4558 sky130_fd_sc_hd__a22oi_1
* cell instance sky130_fd_sc_hd__a22oi_1_38 r0 *1 0,0
Xsky130_fd_sc_hd__a22oi_1_38 bus_rdata[4] \$2486 \$3633 \$2579
+ vss
+ vdd
+ vdd
+ \$3978 sky130_fd_sc_hd__a22oi_1
* cell instance sky130_fd_sc_hd__a311o_1_0 r0 *1 0,0
Xsky130_fd_sc_hd__a311o_1_0 \$4457 \$4372 \$5474 \$4627 \$4625
+ vss
+ vdd
+ vdd
+ \$4456 sky130_fd_sc_hd__a311o_1
* cell instance sky130_fd_sc_hd__a311oi_1_0 r0 *1 0,0
Xsky130_fd_sc_hd__a311oi_1_0 \$4797 \$4360 \$4361 \$4358 \$290
+ vss
+ vdd
+ vdd
+ \$3972 sky130_fd_sc_hd__a311oi_1
* cell instance sky130_fd_sc_hd__a31o_2_0 r0 *1 0,0
Xsky130_fd_sc_hd__a31o_2_0 \$5974 \$5978 \$5975 \$5976
+ vss
+ vdd
+ vdd
+ \$5857 sky130_fd_sc_hd__a31o_2
* cell instance sky130_fd_sc_hd__a31oi_1_0 r0 *1 0,0
Xsky130_fd_sc_hd__a31oi_1_0 \$4574 \$4353 \$1146 \$4481
+ vss
+ vdd
+ vdd
+ \$4706 sky130_fd_sc_hd__a31oi_1
* cell instance sky130_fd_sc_hd__a31oi_1_1 r0 *1 0,0
Xsky130_fd_sc_hd__a31oi_1_1 \$5852 \$6091 \$5740 \$6174
+ vss
+ vdd
+ vdd
+ \$6387 sky130_fd_sc_hd__a31oi_1
* cell instance sky130_fd_sc_hd__a31oi_1_2 r0 *1 0,0
Xsky130_fd_sc_hd__a31oi_1_2 \$4936 \$4484 \$4937 \$4933
+ vss
+ vdd
+ vdd
+ \$4934 sky130_fd_sc_hd__a31oi_1
* cell instance sky130_fd_sc_hd__a31oi_1_3 r0 *1 0,0
Xsky130_fd_sc_hd__a31oi_1_3 \$4797 \$4360 \$4361 \$4358
+ vss
+ vdd
+ vdd
+ \$4033 sky130_fd_sc_hd__a31oi_1
* cell instance sky130_fd_sc_hd__a31oi_1_4 r0 *1 0,0
Xsky130_fd_sc_hd__a31oi_1_4 \$5200 \$5273 \$5318 \$5076
+ vss
+ vdd
+ vdd
+ \$5201 sky130_fd_sc_hd__a31oi_1
* cell instance sky130_fd_sc_hd__a31oi_1_5 r0 *1 0,0
Xsky130_fd_sc_hd__a31oi_1_5 \$4747 \$5475 \$4627 \$4851
+ vss
+ vdd
+ vdd
+ \$3210 sky130_fd_sc_hd__a31oi_1
* cell instance sky130_fd_sc_hd__a31oi_1_6 r0 *1 0,0
Xsky130_fd_sc_hd__a31oi_1_6 \$2350 \$1669 \$2263 \$2264
+ vss
+ vdd
+ vdd
+ \$2265 sky130_fd_sc_hd__a31oi_1
* cell instance sky130_fd_sc_hd__a32o_1_0 r0 *1 0,0
Xsky130_fd_sc_hd__a32o_1_0 \$2579 \$3891 \$3232 \$897 \$2847
+ vss
+ vdd
+ vdd
+ \$3977 sky130_fd_sc_hd__a32o_1
* cell instance sky130_fd_sc_hd__a32oi_1_0 r0 *1 0,0
Xsky130_fd_sc_hd__a32oi_1_0 \$2213 \$3154 \$2944 \$2507 \$2627
+ vss
+ vdd
+ vdd
+ \$4150 sky130_fd_sc_hd__a32oi_1
* cell instance sky130_fd_sc_hd__a32oi_1_1 r0 *1 0,0
Xsky130_fd_sc_hd__a32oi_1_1 \$2213 \$2108 \$2299 \$290 \$2214
+ vss
+ vdd
+ vdd
+ \$2215 sky130_fd_sc_hd__a32oi_1
* cell instance sky130_fd_sc_hd__a32oi_1_2 r0 *1 0,0
Xsky130_fd_sc_hd__a32oi_1_2 \$5859 \$5857 \$5303 \$290 \$5976
+ vss
+ vdd
+ vdd
+ \$5753 sky130_fd_sc_hd__a32oi_1
* cell instance sky130_fd_sc_hd__a32oi_1_3 r0 *1 0,0
Xsky130_fd_sc_hd__a32oi_1_3 \$5864 \$5865 \$5303 \$290 \$5978
+ vss
+ vdd
+ vdd
+ \$6103 sky130_fd_sc_hd__a32oi_1
* cell instance sky130_fd_sc_hd__a32oi_1_4 r0 *1 0,0
Xsky130_fd_sc_hd__a32oi_1_4 \$2108 \$2518 \$2870 \$290 \$2747
+ vss
+ vdd
+ vdd
+ \$2639 sky130_fd_sc_hd__a32oi_1
* cell instance sky130_fd_sc_hd__a32oi_1_5 r0 *1 0,0
Xsky130_fd_sc_hd__a32oi_1_5 \$5203 \$2108 \$5320 \$290 \$5165
+ vss
+ vdd
+ vdd
+ \$5321 sky130_fd_sc_hd__a32oi_1
* cell instance sky130_fd_sc_hd__and2_1_0 r0 *1 0,0
Xsky130_fd_sc_hd__and2_1_0 \$3767 \$4139
+ vss
+ vdd
+ vdd
+ \$3666 sky130_fd_sc_hd__and2_1
* cell instance sky130_fd_sc_hd__and2_1_1 r0 *1 0,0
Xsky130_fd_sc_hd__and2_1_1 \$5624 \$5508
+ vss
+ vdd
+ vdd
+ \$5522 sky130_fd_sc_hd__and2_1
* cell instance sky130_fd_sc_hd__and2_1_2 r0 *1 0,0
Xsky130_fd_sc_hd__and2_1_2 \$1146 \$4020
+ vss
+ vdd
+ vdd
+ \$3909 sky130_fd_sc_hd__and2_1
* cell instance sky130_fd_sc_hd__and2_1_3 r0 *1 0,0
Xsky130_fd_sc_hd__and2_1_3 \$2729 \$2628
+ vss
+ vdd
+ vdd
+ \$2213 sky130_fd_sc_hd__and2_1
* cell instance sky130_fd_sc_hd__and2_1_4 r0 *1 0,0
Xsky130_fd_sc_hd__and2_1_4 \$1380 \$1384
+ vss
+ vdd
+ vdd
+ \$1382 sky130_fd_sc_hd__and2_1
* cell instance sky130_fd_sc_hd__and2_1_5 r0 *1 0,0
Xsky130_fd_sc_hd__and2_1_5 \$2423 \$2422
+ vss
+ vdd
+ vdd
+ \$2306 sky130_fd_sc_hd__and2_1
* cell instance sky130_fd_sc_hd__and2_1_6 r0 *1 0,0
Xsky130_fd_sc_hd__and2_1_6 \$1653 \$290
+ vss
+ vdd
+ vdd
+ \$1746 sky130_fd_sc_hd__and2_1
* cell instance sky130_fd_sc_hd__and2_1_7 r0 *1 0,0
Xsky130_fd_sc_hd__and2_1_7 \$4955 \$4953
+ vss
+ vdd
+ vdd
+ \$4747 sky130_fd_sc_hd__and2_1
* cell instance sky130_fd_sc_hd__and2_1_8 r0 *1 0,0
Xsky130_fd_sc_hd__and2_1_8 startup_done \$3721
+ vss
+ vdd
+ vdd
+ \$4372 sky130_fd_sc_hd__and2_1
* cell instance sky130_fd_sc_hd__and2_1_9 r0 *1 0,0
Xsky130_fd_sc_hd__and2_1_9 \$1080 \$1317
+ vss
+ vdd
+ vdd
+ \$1512 sky130_fd_sc_hd__and2_1
* cell instance sky130_fd_sc_hd__and2_1_10 r0 *1 0,0
Xsky130_fd_sc_hd__and2_1_10 \$1752 \$4198
+ vss
+ vdd
+ vdd
+ \$3891 sky130_fd_sc_hd__and2_1
* cell instance sky130_fd_sc_hd__and2_1_11 r0 *1 0,0
Xsky130_fd_sc_hd__and2_1_11 \$3093
+ a|inv_q_y|inv_q_y_via|inv_q_y_via2|nand_s2_a|nand_s2_a_stub|nand_s2_a_via|nand_s2_a_via2|q|raw_valid|y
+ vss
+ vdd
+ vdd
+ \$1146 sky130_fd_sc_hd__and2_1
* cell instance sky130_fd_sc_hd__and2_1_12 r0 *1 0,0
Xsky130_fd_sc_hd__and2_1_12 \$3098 \$3318
+ vss
+ vdd
+ vdd
+ \$3106 sky130_fd_sc_hd__and2_1
* cell instance sky130_fd_sc_hd__and2_1_13 r0 *1 0,0
Xsky130_fd_sc_hd__and2_1_13 \$2814 \$2687
+ vss
+ vdd
+ vdd
+ \$2815 sky130_fd_sc_hd__and2_1
* cell instance sky130_fd_sc_hd__and3_1_0 r0 *1 0,0
Xsky130_fd_sc_hd__and3_1_0 \$4016 \$4479 \$4244
+ vss
+ vdd
+ vdd
+ \$4139 sky130_fd_sc_hd__and3_1
* cell instance sky130_fd_sc_hd__and3_1_1 r0 *1 0,0
Xsky130_fd_sc_hd__and3_1_1 \$3036 \$290 \$3268
+ vss
+ vdd
+ vdd
+ \$3128 sky130_fd_sc_hd__and3_1
* cell instance sky130_fd_sc_hd__and3_1_2 r0 *1 0,0
Xsky130_fd_sc_hd__and3_1_2 \$3138 \$290 \$3268
+ vss
+ vdd
+ vdd
+ \$3147 sky130_fd_sc_hd__and3_1
* cell instance sky130_fd_sc_hd__and3_1_3 r0 *1 0,0
Xsky130_fd_sc_hd__and3_1_3 \$3269 \$290 \$3268
+ vss
+ vdd
+ vdd
+ \$3362 sky130_fd_sc_hd__and3_1
* cell instance sky130_fd_sc_hd__and3_1_4 r0 *1 0,0
Xsky130_fd_sc_hd__and3_1_4 \$3904 \$3667 \$3666
+ vss
+ vdd
+ vdd
+ \$3906 sky130_fd_sc_hd__and3_1
* cell instance sky130_fd_sc_hd__and3_1_5 r0 *1 0,0
Xsky130_fd_sc_hd__and3_1_5 \$3363 \$290 \$3268
+ vss
+ vdd
+ vdd
+ \$3432 sky130_fd_sc_hd__and3_1
* cell instance sky130_fd_sc_hd__and3_1_6 r0 *1 0,0
Xsky130_fd_sc_hd__and3_1_6 \$1998 \$2097 \$1919
+ vss
+ vdd
+ vdd
+ \$1995 sky130_fd_sc_hd__and3_1
* cell instance sky130_fd_sc_hd__and3_1_7 r0 *1 0,0
Xsky130_fd_sc_hd__and3_1_7 \$2725 \$2851 \$1995
+ vss
+ vdd
+ vdd
+ \$2942 sky130_fd_sc_hd__and3_1
* cell instance sky130_fd_sc_hd__and3_1_8 r0 *1 0,0
Xsky130_fd_sc_hd__and3_1_8 \$3344 \$290 \$3268
+ vss
+ vdd
+ vdd
+ \$3568 sky130_fd_sc_hd__and3_1
* cell instance sky130_fd_sc_hd__and3_1_9 r0 *1 0,0
Xsky130_fd_sc_hd__and3_1_9 \$5852 \$6091 \$5740
+ vss
+ vdd
+ vdd
+ \$5966 sky130_fd_sc_hd__and3_1
* cell instance sky130_fd_sc_hd__and3_1_10 r0 *1 0,0
Xsky130_fd_sc_hd__and3_1_10 \$2214 \$2109 \$1999
+ vss
+ vdd
+ vdd
+ \$1919 sky130_fd_sc_hd__and3_1
* cell instance sky130_fd_sc_hd__and3_1_11 r0 *1 0,0
Xsky130_fd_sc_hd__and3_1_11 \$3155 \$290 \$3268
+ vss
+ vdd
+ vdd
+ \$3345 sky130_fd_sc_hd__and3_1
* cell instance sky130_fd_sc_hd__and3_1_12 r0 *1 0,0
Xsky130_fd_sc_hd__and3_1_12 \$3156 \$290 \$3268
+ vss
+ vdd
+ vdd
+ \$3253 sky130_fd_sc_hd__and3_1
* cell instance sky130_fd_sc_hd__and3_1_13 r0 *1 0,0
Xsky130_fd_sc_hd__and3_1_13 \$3274 \$290 \$3268
+ vss
+ vdd
+ vdd
+ \$3373 sky130_fd_sc_hd__and3_1
* cell instance sky130_fd_sc_hd__and3_1_14 r0 *1 0,0
Xsky130_fd_sc_hd__and3_1_14 \$2946 \$290 \$3268
+ vss
+ vdd
+ vdd
+ \$2954 sky130_fd_sc_hd__and3_1
* cell instance sky130_fd_sc_hd__and3_1_15 r0 *1 0,0
Xsky130_fd_sc_hd__and3_1_15 \$1283 \$1381 \$1382
+ vss
+ vdd
+ vdd
+ \$1633 sky130_fd_sc_hd__and3_1
* cell instance sky130_fd_sc_hd__and3_1_16 r0 *1 0,0
Xsky130_fd_sc_hd__and3_1_16 \$5415 \$5308 \$5062
+ vss
+ vdd
+ vdd
+ \$5307 sky130_fd_sc_hd__and3_1
* cell instance sky130_fd_sc_hd__and3_1_17 r0 *1 0,0
Xsky130_fd_sc_hd__and3_1_17 \$1479 \$1377 \$1384
+ vss
+ vdd
+ vdd
+ \$1388 sky130_fd_sc_hd__and3_1
* cell instance sky130_fd_sc_hd__and3_1_18 r0 *1 0,0
Xsky130_fd_sc_hd__and3_1_18 \$1726 \$1385 \$1388
+ vss
+ vdd
+ vdd
+ \$1929 sky130_fd_sc_hd__and3_1
* cell instance sky130_fd_sc_hd__and3_1_19 r0 *1 0,0
Xsky130_fd_sc_hd__and3_1_19 \$6190 \$6497 \$6504
+ vss
+ vdd
+ vdd
+ \$6398 sky130_fd_sc_hd__and3_1
* cell instance sky130_fd_sc_hd__and3_1_20 r0 *1 0,0
Xsky130_fd_sc_hd__and3_1_20 \$5200 \$5318 \$5475
+ vss
+ vdd
+ vdd
+ \$5836 sky130_fd_sc_hd__and3_1
* cell instance sky130_fd_sc_hd__and3_1_21 r0 *1 0,0
Xsky130_fd_sc_hd__and3_1_21 \$6402 \$6403 \$5475
+ vss
+ vdd
+ vdd
+ \$6504 sky130_fd_sc_hd__and3_1
* cell instance sky130_fd_sc_hd__and3b_1_0 r0 *1 0,0
Xsky130_fd_sc_hd__and3b_1_0 \$6500 \$6188 \$6397
+ vss
+ vdd
+ vdd
+ \$6295 sky130_fd_sc_hd__and3b_1
* cell instance sky130_fd_sc_hd__and3b_1_1 r0 *1 0,0
Xsky130_fd_sc_hd__and3b_1_1 \$718 \$717 \$716
+ vss
+ vdd
+ vdd
+ \$930 sky130_fd_sc_hd__and3b_1
* cell instance sky130_fd_sc_hd__and3b_1_2 r0 *1 0,0
Xsky130_fd_sc_hd__and3b_1_2 \$716 \$718 \$717
+ vss
+ vdd
+ vdd
+ \$635 sky130_fd_sc_hd__and3b_1
* cell instance sky130_fd_sc_hd__and4_1_0 r0 *1 0,0
Xsky130_fd_sc_hd__and4_1_0 \$5638 \$5400 \$5624 \$5508
+ vss
+ vdd
+ vdd
+ \$5740 sky130_fd_sc_hd__and4_1
* cell instance sky130_fd_sc_hd__and4_1_1 r0 *1 0,0
Xsky130_fd_sc_hd__and4_1_1 \$5852 \$6091 \$6174 \$5740
+ vss
+ vdd
+ vdd
+ \$5975 sky130_fd_sc_hd__and4_1
* cell instance sky130_fd_sc_hd__and4_1_2 r0 *1 0,0
Xsky130_fd_sc_hd__and4_1_2 \$4933 \$4936 \$4484 \$4937
+ vss
+ vdd
+ vdd
+ \$5508 sky130_fd_sc_hd__and4_1
* cell instance sky130_fd_sc_hd__and4_1_3 r0 *1 0,0
Xsky130_fd_sc_hd__and4_1_3 \$1283 \$1381 \$1379 \$1380
+ vss
+ vdd
+ vdd
+ \$1377 sky130_fd_sc_hd__and4_1
* cell instance sky130_fd_sc_hd__and4_1_4 r0 *1 0,0
Xsky130_fd_sc_hd__and4_1_4 \$5974 \$5978 \$5976 \$5975
+ vss
+ vdd
+ vdd
+ \$5062 sky130_fd_sc_hd__and4_1
* cell instance sky130_fd_sc_hd__and4_1_5 r0 *1 0,0
Xsky130_fd_sc_hd__and4_1_5 \$5076 \$5200 \$5273 \$5318
+ vss
+ vdd
+ vdd
+ \$4365 sky130_fd_sc_hd__and4_1
* cell instance sky130_fd_sc_hd__and4_1_6 r0 *1 0,0
Xsky130_fd_sc_hd__and4_1_6 \$4162 \$4606 \$4735 \$5198
+ vss
+ vdd
+ vdd
+ \$4953 sky130_fd_sc_hd__and4_1
* cell instance sky130_fd_sc_hd__and4_1_7 r0 *1 0,0
Xsky130_fd_sc_hd__and4_1_7 \$2579 \$4085 \$3735 \$3848
+ vss
+ vdd
+ vdd
+ \$3960 sky130_fd_sc_hd__and4_1
* cell instance sky130_fd_sc_hd__and4b_1_0 r0 *1 0,0
Xsky130_fd_sc_hd__and4b_1_0 \$4833 \$4735 \$4606 \$4162
+ vss
+ vdd
+ vdd
+ \$4737 sky130_fd_sc_hd__and4b_1
* cell instance sky130_fd_sc_hd__buf_4_0 r0 *1 0,0
Xsky130_fd_sc_hd__buf_4_0 \$2426
+ vss
+ vdd
+ vdd
+ \$2409 sky130_fd_sc_hd__buf_4
* cell instance sky130_fd_sc_hd__buf_4_1 r0 *1 0,0
Xsky130_fd_sc_hd__buf_4_1 \$4152
+ vss
+ vdd
+ vdd
+ \$4478 sky130_fd_sc_hd__buf_4
* cell instance sky130_fd_sc_hd__buf_4_2 r0 *1 0,0
Xsky130_fd_sc_hd__buf_4_2 \$4820
+ vss
+ vdd
+ vdd
+ \$4821 sky130_fd_sc_hd__buf_4
* cell instance sky130_fd_sc_hd__buf_4_3 r0 *1 0,0
Xsky130_fd_sc_hd__buf_4_3 \$4152
+ vss
+ vdd
+ vdd
+ \$3785 sky130_fd_sc_hd__buf_4
* cell instance sky130_fd_sc_hd__buf_4_4 r0 *1 0,0
Xsky130_fd_sc_hd__buf_4_4 \$5856
+ vss
+ vdd
+ vdd
+ \$5634 sky130_fd_sc_hd__buf_4
* cell instance sky130_fd_sc_hd__buf_4_5 r0 *1 0,0
Xsky130_fd_sc_hd__buf_4_5 \$2426
+ vss
+ vdd
+ vdd
+ \$2739 sky130_fd_sc_hd__buf_4
* cell instance sky130_fd_sc_hd__buf_4_6 r0 *1 0,0
Xsky130_fd_sc_hd__buf_4_6 \$1208
+ vss
+ vdd
+ vdd
+ \$1827 sky130_fd_sc_hd__buf_4
* cell instance sky130_fd_sc_hd__buf_4_7 r0 *1 0,0
Xsky130_fd_sc_hd__buf_4_7 \$2426
+ vss
+ vdd
+ vdd
+ \$2420 sky130_fd_sc_hd__buf_4
* cell instance sky130_fd_sc_hd__buf_4_8 r0 *1 0,0
Xsky130_fd_sc_hd__buf_4_8 \$5856
+ vss
+ vdd
+ vdd
+ \$6273 sky130_fd_sc_hd__buf_4
* cell instance sky130_fd_sc_hd__buf_4_9 r0 *1 0,0
Xsky130_fd_sc_hd__buf_4_9 \$4152
+ vss
+ vdd
+ vdd
+ \$3920 sky130_fd_sc_hd__buf_4
* cell instance sky130_fd_sc_hd__buf_4_10 r0 *1 0,0
Xsky130_fd_sc_hd__buf_4_10 \$1208
+ vss
+ vdd
+ vdd
+ \$701 sky130_fd_sc_hd__buf_4
* cell instance sky130_fd_sc_hd__buf_4_11 r0 *1 0,0
Xsky130_fd_sc_hd__buf_4_11 \$4152
+ vss
+ vdd
+ vdd
+ \$4734 sky130_fd_sc_hd__buf_4
* cell instance sky130_fd_sc_hd__buf_4_12 r0 *1 0,0
Xsky130_fd_sc_hd__buf_4_12 \$2426
+ vss
+ vdd
+ vdd
+ \$1735 sky130_fd_sc_hd__buf_4
* cell instance sky130_fd_sc_hd__buf_4_13 r0 *1 0,0
Xsky130_fd_sc_hd__buf_4_13 \$3945
+ vss
+ vdd
+ vdd
+ \$4152 sky130_fd_sc_hd__buf_4
* cell instance sky130_fd_sc_hd__buf_4_14 r0 *1 0,0
Xsky130_fd_sc_hd__buf_4_14 \$3945
+ vss
+ vdd
+ vdd
+ \$2426 sky130_fd_sc_hd__buf_4
* cell instance sky130_fd_sc_hd__buf_4_15 r0 *1 0,0
Xsky130_fd_sc_hd__buf_4_15 \$4737
+ vss
+ vdd
+ vdd
+ \$5474 sky130_fd_sc_hd__buf_4
* cell instance sky130_fd_sc_hd__buf_4_16 r0 *1 0,0
Xsky130_fd_sc_hd__buf_4_16 \$2426
+ vss
+ vdd
+ vdd
+ \$2773 sky130_fd_sc_hd__buf_4
* cell instance sky130_fd_sc_hd__buf_4_17 r0 *1 0,0
Xsky130_fd_sc_hd__buf_4_17 \$3945
+ vss
+ vdd
+ vdd
+ \$1208 sky130_fd_sc_hd__buf_4
* cell instance sky130_fd_sc_hd__buf_4_18 r0 *1 0,0
Xsky130_fd_sc_hd__buf_4_18 \$1208
+ vss
+ vdd
+ vdd
+ \$1400 sky130_fd_sc_hd__buf_4
* cell instance sky130_fd_sc_hd__buf_4_19 r0 *1 0,0
Xsky130_fd_sc_hd__buf_4_19 \$5856
+ vss
+ vdd
+ vdd
+ \$5212 sky130_fd_sc_hd__buf_4
* cell instance sky130_fd_sc_hd__buf_4_20 r0 *1 0,0
Xsky130_fd_sc_hd__buf_4_20 \$4152
+ vss
+ vdd
+ vdd
+ \$3811 sky130_fd_sc_hd__buf_4
* cell instance sky130_fd_sc_hd__buf_4_21 r0 *1 0,0
Xsky130_fd_sc_hd__buf_4_21 \$4613
+ vss
+ vdd
+ vdd
+ \$5475 sky130_fd_sc_hd__buf_4
* cell instance sky130_fd_sc_hd__buf_4_22 r0 *1 0,0
Xsky130_fd_sc_hd__buf_4_22 \$3945
+ vss
+ vdd
+ vdd
+ \$5856 sky130_fd_sc_hd__buf_4
* cell instance sky130_fd_sc_hd__buf_4_23 r0 *1 0,0
Xsky130_fd_sc_hd__buf_4_23 \$6188
+ vss
+ vdd
+ vdd
+ \$5592 sky130_fd_sc_hd__buf_4
* cell instance sky130_fd_sc_hd__buf_4_24 r0 *1 0,0
Xsky130_fd_sc_hd__buf_4_24 \$1208
+ vss
+ vdd
+ vdd
+ \$1005 sky130_fd_sc_hd__buf_4
* cell instance sky130_fd_sc_hd__buf_4_25 r0 *1 0,0
Xsky130_fd_sc_hd__buf_4_25 \$1208
+ vss
+ vdd
+ vdd
+ \$148 sky130_fd_sc_hd__buf_4
* cell instance sky130_fd_sc_hd__buf_4_26 r0 *1 0,0
Xsky130_fd_sc_hd__buf_4_26 \$5856
+ vss
+ vdd
+ vdd
+ \$6922 sky130_fd_sc_hd__buf_4
* cell instance sky130_fd_sc_hd__buf_4_27 r0 *1 0,0
Xsky130_fd_sc_hd__buf_4_27 \$2426
+ vss
+ vdd
+ vdd
+ \$2981 sky130_fd_sc_hd__buf_4
* cell instance sky130_fd_sc_hd__buf_4_28 r0 *1 0,0
Xsky130_fd_sc_hd__buf_4_28 \$5856
+ vss
+ vdd
+ vdd
+ \$5428 sky130_fd_sc_hd__buf_4
* cell instance sky130_fd_sc_hd__buf_4_29 r0 *1 0,0
Xsky130_fd_sc_hd__buf_4_29 \$5856
+ vss
+ vdd
+ vdd
+ \$6207 sky130_fd_sc_hd__buf_4
* cell instance sky130_fd_sc_hd__buf_4_30 r0 *1 0,0
Xsky130_fd_sc_hd__buf_4_30 \$1208
+ vss
+ vdd
+ vdd
+ \$1713 sky130_fd_sc_hd__buf_4
* cell instance sky130_fd_sc_hd__buf_4_31 r0 *1 0,0
Xsky130_fd_sc_hd__buf_4_31 \$4848
+ vss
+ vdd
+ vdd
+ \$5325 sky130_fd_sc_hd__buf_4
* cell instance sky130_fd_sc_hd__buf_4_32 r0 *1 0,0
Xsky130_fd_sc_hd__buf_4_32 \$4746
+ vss
+ vdd
+ vdd
+ \$4802 sky130_fd_sc_hd__buf_4
* cell instance sky130_fd_sc_hd__buf_4_33 r0 *1 0,0
Xsky130_fd_sc_hd__buf_4_33 \$5856
+ vss
+ vdd
+ vdd
+ \$6850 sky130_fd_sc_hd__buf_4
* cell instance sky130_fd_sc_hd__buf_4_34 r0 *1 0,0
Xsky130_fd_sc_hd__buf_4_34 \$4527
+ vss
+ vdd
+ vdd
+ \$5547 sky130_fd_sc_hd__buf_4
* cell instance sky130_fd_sc_hd__buf_4_35 r0 *1 0,0
Xsky130_fd_sc_hd__buf_4_35 \$2426
+ vss
+ vdd
+ vdd
+ \$2545 sky130_fd_sc_hd__buf_4
* cell instance sky130_fd_sc_hd__buf_4_36 r0 *1 0,0
Xsky130_fd_sc_hd__buf_4_36 \$4152
+ vss
+ vdd
+ vdd
+ \$4073 sky130_fd_sc_hd__buf_4
* cell instance sky130_fd_sc_hd__buf_4_37 r0 *1 0,0
Xsky130_fd_sc_hd__buf_4_37 \$4748
+ vss
+ vdd
+ vdd
+ \$4302 sky130_fd_sc_hd__buf_4
* cell instance sky130_fd_sc_hd__buf_4_38 r0 *1 0,0
Xsky130_fd_sc_hd__buf_4_38
+ clk
+ vss
+ vdd
+ vdd
+ \$3945 sky130_fd_sc_hd__buf_4
* cell instance sky130_fd_sc_hd__buf_4_39 r0 *1 0,0
Xsky130_fd_sc_hd__buf_4_39 \$5856
+ vss
+ vdd
+ vdd
+ \$5099 sky130_fd_sc_hd__buf_4
* cell instance sky130_fd_sc_hd__buf_4_40 r0 *1 0,0
Xsky130_fd_sc_hd__buf_4_40 \$4152
+ vss
+ vdd
+ vdd
+ \$3404 sky130_fd_sc_hd__buf_4
* cell instance sky130_fd_sc_hd__buf_4_41 r0 *1 0,0
Xsky130_fd_sc_hd__buf_4_41 \$7029
+ vss
+ vdd
+ vdd
+ \$6863 sky130_fd_sc_hd__buf_4
* cell instance sky130_fd_sc_hd__buf_4_42 r0 *1 0,0
Xsky130_fd_sc_hd__buf_4_42 \$443
+ vss
+ vdd
+ vdd
+ \$233 sky130_fd_sc_hd__buf_4
* cell instance sky130_fd_sc_hd__buf_4_43 r0 *1 0,0
Xsky130_fd_sc_hd__buf_4_43 \$2426
+ vss
+ vdd
+ vdd
+ \$1864 sky130_fd_sc_hd__buf_4
* cell instance sky130_fd_sc_hd__buf_4_44 r0 *1 0,0
Xsky130_fd_sc_hd__buf_4_44 \$7029
+ vss
+ vdd
+ vdd
+ \$7441 sky130_fd_sc_hd__buf_4
* cell instance sky130_fd_sc_hd__buf_4_45 r0 *1 0,0
Xsky130_fd_sc_hd__buf_4_45 \$443
+ vss
+ vdd
+ vdd
+ \$804 sky130_fd_sc_hd__buf_4
* cell instance sky130_fd_sc_hd__buf_4_46 r0 *1 0,0
Xsky130_fd_sc_hd__buf_4_46 \$7029
+ vss
+ vdd
+ vdd
+ \$6431 sky130_fd_sc_hd__buf_4
* cell instance sky130_fd_sc_hd__buf_4_47 r0 *1 0,0
Xsky130_fd_sc_hd__buf_4_47 \$1424
+ vss
+ vdd
+ vdd
+ \$180 sky130_fd_sc_hd__buf_4
* cell instance sky130_fd_sc_hd__buf_4_48 r0 *1 0,0
Xsky130_fd_sc_hd__buf_4_48 \$2170
+ vss
+ vdd
+ vdd
+ \$191 sky130_fd_sc_hd__buf_4
* cell instance sky130_fd_sc_hd__buf_4_49 r0 *1 0,0
Xsky130_fd_sc_hd__buf_4_49 \$3619
+ vss
+ vdd
+ vdd
+ \$2057 sky130_fd_sc_hd__buf_4
* cell instance sky130_fd_sc_hd__buf_4_50 r0 *1 0,0
Xsky130_fd_sc_hd__buf_4_50 \$3134
+ vss
+ vdd
+ vdd
+ \$290 sky130_fd_sc_hd__buf_4
* cell instance sky130_fd_sc_hd__buf_4_51 r0 *1 0,0
Xsky130_fd_sc_hd__buf_4_51 \$1561
+ vss
+ vdd
+ vdd
+ \$182 sky130_fd_sc_hd__buf_4
* cell instance sky130_fd_sc_hd__buf_4_52 r0 *1 0,0
Xsky130_fd_sc_hd__buf_4_52 \$4104
+ vss
+ vdd
+ vdd
+ \$5115 sky130_fd_sc_hd__buf_4
* cell instance sky130_fd_sc_hd__buf_4_53 r0 *1 0,0
Xsky130_fd_sc_hd__buf_4_53 \$1431
+ vss
+ vdd
+ vdd
+ \$2567 sky130_fd_sc_hd__buf_4
* cell instance sky130_fd_sc_hd__buf_4_54 r0 *1 0,0
Xsky130_fd_sc_hd__buf_4_54 \$2679
+ vss
+ vdd
+ vdd
+ \$219 sky130_fd_sc_hd__buf_4
* cell instance sky130_fd_sc_hd__buf_4_55 r0 *1 0,0
Xsky130_fd_sc_hd__buf_4_55 \$4089
+ vss
+ vdd
+ vdd
+ \$4299 sky130_fd_sc_hd__buf_4
* cell instance sky130_fd_sc_hd__buf_4_56 r0 *1 0,0
Xsky130_fd_sc_hd__buf_4_56 \$1431
+ vss
+ vdd
+ vdd
+ \$1173 sky130_fd_sc_hd__buf_4
* cell instance sky130_fd_sc_hd__buf_4_57 r0 *1 0,0
Xsky130_fd_sc_hd__buf_4_57 \$4299
+ vss
+ vdd
+ vdd
+ \$4428 sky130_fd_sc_hd__buf_4
* cell instance sky130_fd_sc_hd__buf_4_58 r0 *1 0,0
Xsky130_fd_sc_hd__buf_4_58 \$683
+ vss
+ vdd
+ vdd
+ \$742 sky130_fd_sc_hd__buf_4
* cell instance sky130_fd_sc_hd__buf_4_59 r0 *1 0,0
Xsky130_fd_sc_hd__buf_4_59 \$443
+ vss
+ vdd
+ vdd
+ \$40 sky130_fd_sc_hd__buf_4
* cell instance sky130_fd_sc_hd__buf_4_60 r0 *1 0,0
Xsky130_fd_sc_hd__buf_4_60 \$3228
+ vss
+ vdd
+ vdd
+ \$1561 sky130_fd_sc_hd__buf_4
* cell instance sky130_fd_sc_hd__buf_4_61 r0 *1 0,0
Xsky130_fd_sc_hd__buf_4_61 \$4104
+ vss
+ vdd
+ vdd
+ \$4407 sky130_fd_sc_hd__buf_4
* cell instance sky130_fd_sc_hd__buf_4_62 r0 *1 0,0
Xsky130_fd_sc_hd__buf_4_62 \$7029
+ vss
+ vdd
+ vdd
+ \$7626 sky130_fd_sc_hd__buf_4
* cell instance sky130_fd_sc_hd__buf_4_63 r0 *1 0,0
Xsky130_fd_sc_hd__buf_4_63 \$7029
+ vss
+ vdd
+ vdd
+ \$6714 sky130_fd_sc_hd__buf_4
* cell instance sky130_fd_sc_hd__buf_4_64 r0 *1 0,0
Xsky130_fd_sc_hd__buf_4_64 \$443
+ vss
+ vdd
+ vdd
+ \$655 sky130_fd_sc_hd__buf_4
* cell instance sky130_fd_sc_hd__buf_4_65 r0 *1 0,0
Xsky130_fd_sc_hd__buf_4_65 \$4104
+ vss
+ vdd
+ vdd
+ \$5248 sky130_fd_sc_hd__buf_4
* cell instance sky130_fd_sc_hd__buf_4_66 r0 *1 0,0
Xsky130_fd_sc_hd__buf_4_66 \$7029
+ vss
+ vdd
+ vdd
+ \$7057 sky130_fd_sc_hd__buf_4
* cell instance sky130_fd_sc_hd__buf_4_67 r0 *1 0,0
Xsky130_fd_sc_hd__buf_4_67 \$3945
+ vss
+ vdd
+ vdd
+ \$7029 sky130_fd_sc_hd__buf_4
* cell instance sky130_fd_sc_hd__buf_4_68 r0 *1 0,0
Xsky130_fd_sc_hd__buf_4_68 \$1431
+ vss
+ vdd
+ vdd
+ \$2180 sky130_fd_sc_hd__buf_4
* cell instance sky130_fd_sc_hd__buf_4_69 r0 *1 0,0
Xsky130_fd_sc_hd__buf_4_69 \$3415
+ vss
+ vdd
+ vdd
+ \$2202 sky130_fd_sc_hd__buf_4
* cell instance sky130_fd_sc_hd__buf_4_70 r0 *1 0,0
Xsky130_fd_sc_hd__buf_4_70 \$5809
+ vss
+ vdd
+ vdd
+ \$5999 sky130_fd_sc_hd__buf_4
* cell instance sky130_fd_sc_hd__buf_4_71 r0 *1 0,0
Xsky130_fd_sc_hd__buf_4_71 \$3945
+ vss
+ vdd
+ vdd
+ \$443 sky130_fd_sc_hd__buf_4
* cell instance sky130_fd_sc_hd__buf_4_72 r0 *1 0,0
Xsky130_fd_sc_hd__buf_4_72 \$4104
+ vss
+ vdd
+ vdd
+ \$4421 sky130_fd_sc_hd__buf_4
* cell instance sky130_fd_sc_hd__buf_4_73 r0 *1 0,0
Xsky130_fd_sc_hd__buf_4_73 \$7029
+ vss
+ vdd
+ vdd
+ \$6633 sky130_fd_sc_hd__buf_4
* cell instance sky130_fd_sc_hd__buf_4_74 r0 *1 0,0
Xsky130_fd_sc_hd__buf_4_74 \$443
+ vss
+ vdd
+ vdd
+ \$59 sky130_fd_sc_hd__buf_4
* cell instance sky130_fd_sc_hd__buf_4_75 r0 *1 0,0
Xsky130_fd_sc_hd__buf_4_75 \$2575
+ vss
+ vdd
+ vdd
+ \$2486 sky130_fd_sc_hd__buf_4
* cell instance sky130_fd_sc_hd__buf_4_76 r0 *1 0,0
Xsky130_fd_sc_hd__buf_4_76 \$1431
+ vss
+ vdd
+ vdd
+ \$673 sky130_fd_sc_hd__buf_4
* cell instance sky130_fd_sc_hd__buf_4_77 r0 *1 0,0
Xsky130_fd_sc_hd__buf_4_77 \$3945
+ vss
+ vdd
+ vdd
+ \$1431 sky130_fd_sc_hd__buf_4
* cell instance sky130_fd_sc_hd__buf_4_78 r0 *1 0,0
Xsky130_fd_sc_hd__buf_4_78 \$3945
+ vss
+ vdd
+ vdd
+ \$4104 sky130_fd_sc_hd__buf_4
* cell instance sky130_fd_sc_hd__buf_4_79 r0 *1 0,0
Xsky130_fd_sc_hd__buf_4_79 \$1431
+ vss
+ vdd
+ vdd
+ \$1787 sky130_fd_sc_hd__buf_4
* cell instance sky130_fd_sc_hd__buf_4_80 r0 *1 0,0
Xsky130_fd_sc_hd__buf_4_80 \$7029
+ vss
+ vdd
+ vdd
+ \$7474 sky130_fd_sc_hd__buf_4
* cell instance sky130_fd_sc_hd__buf_4_81 r0 *1 0,0
Xsky130_fd_sc_hd__buf_4_81 \$4104
+ vss
+ vdd
+ vdd
+ \$3862 sky130_fd_sc_hd__buf_4
* cell instance sky130_fd_sc_hd__buf_4_82 r0 *1 0,0
Xsky130_fd_sc_hd__buf_4_82 \$4104
+ vss
+ vdd
+ vdd
+ \$6060 sky130_fd_sc_hd__buf_4
* cell instance sky130_fd_sc_hd__buf_4_83 r0 *1 0,0
Xsky130_fd_sc_hd__buf_4_83 \$443
+ vss
+ vdd
+ vdd
+ \$907 sky130_fd_sc_hd__buf_4
* cell instance sky130_fd_sc_hd__buf_4_84 r0 *1 0,0
Xsky130_fd_sc_hd__buf_4_84 \$443
+ vss
+ vdd
+ vdd
+ \$79 sky130_fd_sc_hd__buf_4
* cell instance sky130_fd_sc_hd__buf_4_85 r0 *1 0,0
Xsky130_fd_sc_hd__buf_4_85 \$4104
+ vss
+ vdd
+ vdd
+ \$5497 sky130_fd_sc_hd__buf_4
* cell instance sky130_fd_sc_hd__buf_4_86 r0 *1 0,0
Xsky130_fd_sc_hd__buf_4_86 \$1431
+ vss
+ vdd
+ vdd
+ \$1698 sky130_fd_sc_hd__buf_4
* cell instance sky130_fd_sc_hd__buf_4_87 r0 *1 0,0
Xsky130_fd_sc_hd__buf_4_87 \$1431
+ vss
+ vdd
+ vdd
+ \$3417 sky130_fd_sc_hd__buf_4
* cell instance sky130_fd_sc_hd__buf_4_88 r0 *1 0,0
Xsky130_fd_sc_hd__buf_4_88 \$7029
+ vss
+ vdd
+ vdd
+ \$6996 sky130_fd_sc_hd__buf_4
* cell instance sky130_fd_sc_hd__buf_4_89 r0 *1 0,0
Xsky130_fd_sc_hd__buf_4_89 \$4104
+ vss
+ vdd
+ vdd
+ \$4685 sky130_fd_sc_hd__buf_4
* cell instance sky130_fd_sc_hd__buf_4_90 r0 *1 0,0
Xsky130_fd_sc_hd__buf_4_90 \$4104
+ vss
+ vdd
+ vdd
+ \$6260 sky130_fd_sc_hd__buf_4
* cell instance sky130_fd_sc_hd__buf_4_91 r0 *1 0,0
Xsky130_fd_sc_hd__buf_4_91 \$443
+ vss
+ vdd
+ vdd
+ \$851 sky130_fd_sc_hd__buf_4
* cell instance sky130_fd_sc_hd__buf_4_92 r0 *1 0,0
Xsky130_fd_sc_hd__buf_4_92 \$4104
+ vss
+ vdd
+ vdd
+ \$3877 sky130_fd_sc_hd__buf_4
* cell instance sky130_fd_sc_hd__buf_4_93 r0 *1 0,0
Xsky130_fd_sc_hd__buf_4_93 \$7029
+ vss
+ vdd
+ vdd
+ \$7655 sky130_fd_sc_hd__buf_4
* cell instance sky130_fd_sc_hd__buf_4_94 r0 *1 0,0
Xsky130_fd_sc_hd__buf_4_94 \$1541
+ vss
+ vdd
+ vdd
+ \$1083 sky130_fd_sc_hd__buf_4
* cell instance sky130_fd_sc_hd__buf_4_95 r0 *1 0,0
Xsky130_fd_sc_hd__buf_4_95 \$443
+ vss
+ vdd
+ vdd
+ \$89 sky130_fd_sc_hd__buf_4
* cell instance sky130_fd_sc_hd__buf_4_96 r0 *1 0,0
Xsky130_fd_sc_hd__buf_4_96 \$1431
+ vss
+ vdd
+ vdd
+ \$2491 sky130_fd_sc_hd__buf_4
* cell instance sky130_fd_sc_hd__buf_4_97 r0 *1 0,0
Xsky130_fd_sc_hd__buf_4_97 \$5018
+ vss
+ vdd
+ vdd
+ \$2579 sky130_fd_sc_hd__buf_4
* cell instance sky130_fd_sc_hd__buf_4_98 r0 *1 0,0
Xsky130_fd_sc_hd__buf_4_98 \$443
+ vss
+ vdd
+ vdd
+ \$1282 sky130_fd_sc_hd__buf_4
* cell instance sky130_fd_sc_hd__bufinv_16_0 r0 *1 0,0
Xsky130_fd_sc_hd__bufinv_16_0 \$4152
+ vss
+ vdd
+ vdd
+ \$4509 sky130_fd_sc_hd__bufinv_16
* cell instance sky130_fd_sc_hd__clkbuf_1_0 r0 *1 0,0
Xsky130_fd_sc_hd__clkbuf_1_0
+ a|inv_q_y|inv_q_y_via|inv_q_y_via2|nand_s2_a|nand_s2_a_stub|nand_s2_a_via|nand_s2_a_via2|q|raw_bit|y
+ vss
+ vdd
+ vdd
+ \$1541 sky130_fd_sc_hd__clkbuf_1
* cell instance sky130_fd_sc_hd__clkbuf_1_1 r0 *1 0,0
Xsky130_fd_sc_hd__clkbuf_1_1 bus_re
+ vss
+ vdd
+ vdd
+ \$5018 sky130_fd_sc_hd__clkbuf_1
* cell instance sky130_fd_sc_hd__clkinv_1_0 r0 *1 0,0
Xsky130_fd_sc_hd__clkinv_1_0 \$1827
+ vss
+ vdd
+ vdd
+ \$2304 sky130_fd_sc_hd__clkinv_1
* cell instance sky130_fd_sc_hd__clkinv_1_1 r0 *1 0,0
Xsky130_fd_sc_hd__clkinv_1_1 \$3920
+ vss
+ vdd
+ vdd
+ \$4260 sky130_fd_sc_hd__clkinv_1
* cell instance sky130_fd_sc_hd__clkinv_1_2 r0 *1 0,0
Xsky130_fd_sc_hd__clkinv_1_2 \$4372
+ vss
+ vdd
+ vdd
+ gated sky130_fd_sc_hd__clkinv_1
* cell instance sky130_fd_sc_hd__clkinv_1_3 r0 *1 0,0
Xsky130_fd_sc_hd__clkinv_1_3 \$4073
+ vss
+ vdd
+ vdd
+ \$4629 sky130_fd_sc_hd__clkinv_1
* cell instance sky130_fd_sc_hd__clkinv_1_4 r0 *1 0,0
Xsky130_fd_sc_hd__clkinv_1_4 \$804
+ vss
+ vdd
+ vdd
+ \$1084 sky130_fd_sc_hd__clkinv_1
* cell instance sky130_fd_sc_hd__clkinv_1_5 r0 *1 0,0
Xsky130_fd_sc_hd__clkinv_1_5 \$4407
+ vss
+ vdd
+ vdd
+ \$4542 sky130_fd_sc_hd__clkinv_1
* cell instance sky130_fd_sc_hd__clkinv_1_6 r0 *1 0,0
Xsky130_fd_sc_hd__clkinv_1_6 \$1787
+ vss
+ vdd
+ vdd
+ \$2076 sky130_fd_sc_hd__clkinv_1
* cell instance sky130_fd_sc_hd__clkinv_1_7 r0 *1 0,0
Xsky130_fd_sc_hd__clkinv_1_7 \$5497
+ vss
+ vdd
+ vdd
+ \$5605 sky130_fd_sc_hd__clkinv_1
* cell instance sky130_fd_sc_hd__clkinv_1_8 r0 *1 0,0
Xsky130_fd_sc_hd__clkinv_1_8 \$3417
+ vss
+ vdd
+ vdd
+ \$3749 sky130_fd_sc_hd__clkinv_1
* cell instance sky130_fd_sc_hd__clkinv_1_9 r0 *1 0,0
Xsky130_fd_sc_hd__clkinv_1_9 \$89
+ vss
+ vdd
+ vdd
+ \$492 sky130_fd_sc_hd__clkinv_1
* cell instance sky130_fd_sc_hd__clkinv_2_0 r0 *1 0,0
Xsky130_fd_sc_hd__clkinv_2_0 \$2420
+ vss
+ vdd
+ vdd
+ \$2517 sky130_fd_sc_hd__clkinv_2
* cell instance sky130_fd_sc_hd__clkinv_2_1 r0 *1 0,0
Xsky130_fd_sc_hd__clkinv_2_1 \$701
+ vss
+ vdd
+ vdd
+ \$1292 sky130_fd_sc_hd__clkinv_2
* cell instance sky130_fd_sc_hd__clkinv_2_2 r0 *1 0,0
Xsky130_fd_sc_hd__clkinv_2_2 \$148
+ vss
+ vdd
+ vdd
+ \$279 sky130_fd_sc_hd__clkinv_2
* cell instance sky130_fd_sc_hd__clkinv_4_0 r0 *1 0,0
Xsky130_fd_sc_hd__clkinv_4_0 \$1282
+ vss
+ vdd
+ vdd
+ \$1544 sky130_fd_sc_hd__clkinv_4
* cell instance sky130_fd_sc_hd__clkinvlp_2_0 r0 *1 0,0
Xsky130_fd_sc_hd__clkinvlp_2_0 \$2426
+ vss
+ vdd
+ vdd
+ \$3467 sky130_fd_sc_hd__clkinvlp_2
* cell instance sky130_fd_sc_hd__clkinvlp_2_1 r0 *1 0,0
Xsky130_fd_sc_hd__clkinvlp_2_1 \$5856
+ vss
+ vdd
+ vdd
+ \$6406 sky130_fd_sc_hd__clkinvlp_2
* cell instance sky130_fd_sc_hd__clkinvlp_2_2 r0 *1 0,0
Xsky130_fd_sc_hd__clkinvlp_2_2 \$1431
+ vss
+ vdd
+ vdd
+ \$2187 sky130_fd_sc_hd__clkinvlp_2
* cell instance sky130_fd_sc_hd__dfrtp_1_0 r0 *1 0,0
Xsky130_fd_sc_hd__dfrtp_1_0 \$3785 \$3776 \$3767
+ rst_n
+ vss
+ vdd
+ vdd
+ sky130_fd_sc_hd__dfrtp_1
* cell instance sky130_fd_sc_hd__dfrtp_1_1 r0 *1 0,0
Xsky130_fd_sc_hd__dfrtp_1_1 \$4478 \$4350 \$4016
+ rst_n
+ vss
+ vdd
+ vdd
+ sky130_fd_sc_hd__dfrtp_1
* cell instance sky130_fd_sc_hd__dfrtp_1_2 r0 *1 0,0
Xsky130_fd_sc_hd__dfrtp_1_2 \$4478 \$4589 \$4479
+ rst_n
+ vss
+ vdd
+ vdd
+ sky130_fd_sc_hd__dfrtp_1
* cell instance sky130_fd_sc_hd__dfrtp_1_3 r0 *1 0,0
Xsky130_fd_sc_hd__dfrtp_1_3 \$3785 \$3902 \$3667
+ rst_n
+ vss
+ vdd
+ vdd
+ sky130_fd_sc_hd__dfrtp_1
* cell instance sky130_fd_sc_hd__dfrtp_1_4 r0 *1 0,0
Xsky130_fd_sc_hd__dfrtp_1_4 \$2409 \$3128 \$3036
+ rst_n
+ vss
+ vdd
+ vdd
+ sky130_fd_sc_hd__dfrtp_1
* cell instance sky130_fd_sc_hd__dfrtp_1_5 r0 *1 0,0
Xsky130_fd_sc_hd__dfrtp_1_5 \$4478 \$4912 \$4818
+ rst_n
+ vss
+ vdd
+ vdd
+ sky130_fd_sc_hd__dfrtp_1
* cell instance sky130_fd_sc_hd__dfrtp_1_6 r0 *1 0,0
Xsky130_fd_sc_hd__dfrtp_1_6 \$2409 \$3147 \$3138
+ rst_n
+ vss
+ vdd
+ vdd
+ sky130_fd_sc_hd__dfrtp_1
* cell instance sky130_fd_sc_hd__dfrtp_1_7 r0 *1 0,0
Xsky130_fd_sc_hd__dfrtp_1_7 \$2409 \$3362 \$3269
+ rst_n
+ vss
+ vdd
+ vdd
+ sky130_fd_sc_hd__dfrtp_1
* cell instance sky130_fd_sc_hd__dfrtp_1_8 r0 *1 0,0
Xsky130_fd_sc_hd__dfrtp_1_8 \$4478 \$4703 \$4574
+ rst_n
+ vss
+ vdd
+ vdd
+ sky130_fd_sc_hd__dfrtp_1
* cell instance sky130_fd_sc_hd__dfrtp_1_9 r0 *1 0,0
Xsky130_fd_sc_hd__dfrtp_1_9 \$5634 \$5633 \$5624
+ rst_n
+ vss
+ vdd
+ vdd
+ sky130_fd_sc_hd__dfrtp_1
* cell instance sky130_fd_sc_hd__dfrtp_1_10 r0 *1 0,0
Xsky130_fd_sc_hd__dfrtp_1_10 \$5634 \$5849 \$5638
+ rst_n
+ vss
+ vdd
+ vdd
+ sky130_fd_sc_hd__dfrtp_1
* cell instance sky130_fd_sc_hd__dfrtp_1_11 r0 *1 0,0
Xsky130_fd_sc_hd__dfrtp_1_11 \$2409 \$2723 \$2851
+ rst_n
+ vss
+ vdd
+ vdd
+ sky130_fd_sc_hd__dfrtp_1
* cell instance sky130_fd_sc_hd__dfrtp_1_12 r0 *1 0,0
Xsky130_fd_sc_hd__dfrtp_1_12 \$2409 \$3432 \$3363
+ rst_n
+ vss
+ vdd
+ vdd
+ sky130_fd_sc_hd__dfrtp_1
* cell instance sky130_fd_sc_hd__dfrtp_1_13 r0 *1 0,0
Xsky130_fd_sc_hd__dfrtp_1_13 \$2409 \$2203 \$2097
+ rst_n
+ vss
+ vdd
+ vdd
+ sky130_fd_sc_hd__dfrtp_1
* cell instance sky130_fd_sc_hd__dfrtp_1_14 r0 *1 0,0
Xsky130_fd_sc_hd__dfrtp_1_14 \$3785 \$3905 \$3904
+ rst_n
+ vss
+ vdd
+ vdd
+ sky130_fd_sc_hd__dfrtp_1
* cell instance sky130_fd_sc_hd__dfrtp_1_15 r0 *1 0,0
Xsky130_fd_sc_hd__dfrtp_1_15 \$1827 \$1825 \$1998
+ rst_n
+ vss
+ vdd
+ vdd
+ sky130_fd_sc_hd__dfrtp_1
* cell instance sky130_fd_sc_hd__dfrtp_1_16 r0 *1 0,0
Xsky130_fd_sc_hd__dfrtp_1_16 \$4478 \$5188 \$5400
+ rst_n
+ vss
+ vdd
+ vdd
+ sky130_fd_sc_hd__dfrtp_1
* cell instance sky130_fd_sc_hd__dfrtp_1_17 r0 *1 0,0
Xsky130_fd_sc_hd__dfrtp_1_17 \$4478 \$4819 \$4481
+ rst_n
+ vss
+ vdd
+ vdd
+ sky130_fd_sc_hd__dfrtp_1
* cell instance sky130_fd_sc_hd__dfrtp_1_18 r0 *1 0,0
Xsky130_fd_sc_hd__dfrtp_1_18 \$6273 \$6272 \$6091
+ rst_n
+ vss
+ vdd
+ vdd
+ sky130_fd_sc_hd__dfrtp_1
* cell instance sky130_fd_sc_hd__dfrtp_1_19 r0 *1 0,0
Xsky130_fd_sc_hd__dfrtp_1_19 \$2739 \$3676 \$3668
+ rst_n
+ vss
+ vdd
+ vdd
+ sky130_fd_sc_hd__dfrtp_1
* cell instance sky130_fd_sc_hd__dfrtp_1_20 r0 *1 0,0
Xsky130_fd_sc_hd__dfrtp_1_20 \$3785 \$3568 \$3344
+ rst_n
+ vss
+ vdd
+ vdd
+ sky130_fd_sc_hd__dfrtp_1
* cell instance sky130_fd_sc_hd__dfrtp_1_21 r0 *1 0,0
Xsky130_fd_sc_hd__dfrtp_1_21 \$2409 \$2728 \$2725
+ rst_n
+ vss
+ vdd
+ vdd
+ sky130_fd_sc_hd__dfrtp_1
* cell instance sky130_fd_sc_hd__dfrtp_1_22 r0 *1 0,0
Xsky130_fd_sc_hd__dfrtp_1_22 \$4478 \$4591 \$4353
+ rst_n
+ vss
+ vdd
+ vdd
+ sky130_fd_sc_hd__dfrtp_1
* cell instance sky130_fd_sc_hd__dfrtp_1_23 r0 *1 0,0
Xsky130_fd_sc_hd__dfrtp_1_23 \$1827 \$2007 \$1999
+ rst_n
+ vss
+ vdd
+ vdd
+ sky130_fd_sc_hd__dfrtp_1
* cell instance sky130_fd_sc_hd__dfrtp_1_24 r0 *1 0,0
Xsky130_fd_sc_hd__dfrtp_1_24 \$2739 \$3345 \$3155
+ rst_n
+ vss
+ vdd
+ vdd
+ sky130_fd_sc_hd__dfrtp_1
* cell instance sky130_fd_sc_hd__dfrtp_1_25 r0 *1 0,0
Xsky130_fd_sc_hd__dfrtp_1_25 \$2739 \$3253 \$3156
+ rst_n
+ vss
+ vdd
+ vdd
+ sky130_fd_sc_hd__dfrtp_1
* cell instance sky130_fd_sc_hd__dfrtp_1_26 r0 *1 0,0
Xsky130_fd_sc_hd__dfrtp_1_26 \$5634 \$5970 \$5852
+ rst_n
+ vss
+ vdd
+ vdd
+ sky130_fd_sc_hd__dfrtp_1
* cell instance sky130_fd_sc_hd__dfrtp_1_27 r0 *1 0,0
Xsky130_fd_sc_hd__dfrtp_1_27 \$6273 \$6281 \$6174
+ rst_n
+ vss
+ vdd
+ vdd
+ sky130_fd_sc_hd__dfrtp_1
* cell instance sky130_fd_sc_hd__dfrtp_1_28 r0 *1 0,0
Xsky130_fd_sc_hd__dfrtp_1_28 \$2739 \$3643 \$3570
+ rst_n
+ vss
+ vdd
+ vdd
+ sky130_fd_sc_hd__dfrtp_1
* cell instance sky130_fd_sc_hd__dfrtp_1_29 r0 *1 0,0
Xsky130_fd_sc_hd__dfrtp_1_29 \$3785 \$3793 \$3885
+ rst_n
+ vss
+ vdd
+ vdd
+ sky130_fd_sc_hd__dfrtp_1
* cell instance sky130_fd_sc_hd__dfrtp_1_30 r0 *1 0,0
Xsky130_fd_sc_hd__dfrtp_1_30 \$1827 \$2216 \$2214
+ rst_n
+ vss
+ vdd
+ vdd
+ sky130_fd_sc_hd__dfrtp_1
* cell instance sky130_fd_sc_hd__dfrtp_1_31 r0 *1 0,0
Xsky130_fd_sc_hd__dfrtp_1_31 \$2739 \$2737 \$2729
+ rst_n
+ vss
+ vdd
+ vdd
+ sky130_fd_sc_hd__dfrtp_1
* cell instance sky130_fd_sc_hd__dfrtp_1_32 r0 *1 0,0
Xsky130_fd_sc_hd__dfrtp_1_32 \$2739 \$3373 \$3274
+ rst_n
+ vss
+ vdd
+ vdd
+ sky130_fd_sc_hd__dfrtp_1
* cell instance sky130_fd_sc_hd__dfrtp_1_33 r0 *1 0,0
Xsky130_fd_sc_hd__dfrtp_1_33 \$3785 \$3912 \$3908
+ rst_n
+ vss
+ vdd
+ vdd
+ sky130_fd_sc_hd__dfrtp_1
* cell instance sky130_fd_sc_hd__dfrtp_1_34 r0 *1 0,0
Xsky130_fd_sc_hd__dfrtp_1_34 \$3785 \$4492 \$4484
+ rst_n
+ vss
+ vdd
+ vdd
+ sky130_fd_sc_hd__dfrtp_1
* cell instance sky130_fd_sc_hd__dfrtp_1_35 r0 *1 0,0
Xsky130_fd_sc_hd__dfrtp_1_35 \$5634 \$5526 \$4933
+ rst_n
+ vss
+ vdd
+ vdd
+ sky130_fd_sc_hd__dfrtp_1
* cell instance sky130_fd_sc_hd__dfrtp_1_36 r0 *1 0,0
Xsky130_fd_sc_hd__dfrtp_1_36 \$2739 \$2954 \$2946
+ rst_n
+ vss
+ vdd
+ vdd
+ sky130_fd_sc_hd__dfrtp_1
* cell instance sky130_fd_sc_hd__dfrtp_1_37 r0 *1 0,0
Xsky130_fd_sc_hd__dfrtp_1_37 \$1827 \$2118 \$2109
+ rst_n
+ vss
+ vdd
+ vdd
+ sky130_fd_sc_hd__dfrtp_1
* cell instance sky130_fd_sc_hd__dfrtp_1_38 r0 *1 0,0
Xsky130_fd_sc_hd__dfrtp_1_38 \$3785 \$4576 \$4494
+ rst_n
+ vss
+ vdd
+ vdd
+ sky130_fd_sc_hd__dfrtp_1
* cell instance sky130_fd_sc_hd__dfrtp_1_39 r0 *1 0,0
Xsky130_fd_sc_hd__dfrtp_1_39 \$5634 \$5527 \$4936
+ rst_n
+ vss
+ vdd
+ vdd
+ sky130_fd_sc_hd__dfrtp_1
* cell instance sky130_fd_sc_hd__dfrtp_1_40 r0 *1 0,0
Xsky130_fd_sc_hd__dfrtp_1_40 \$1827 \$1722 \$1379
+ rst_n
+ vss
+ vdd
+ vdd
+ sky130_fd_sc_hd__dfrtp_1
* cell instance sky130_fd_sc_hd__dfrtp_1_41 r0 *1 0,0
Xsky130_fd_sc_hd__dfrtp_1_41 \$701 \$1635 \$1283
+ rst_n
+ vss
+ vdd
+ vdd
+ sky130_fd_sc_hd__dfrtp_1
* cell instance sky130_fd_sc_hd__dfrtp_1_42 r0 *1 0,0
Xsky130_fd_sc_hd__dfrtp_1_42 \$4734 \$4827 \$4938
+ rst_n
+ vss
+ vdd
+ vdd
+ sky130_fd_sc_hd__dfrtp_1
* cell instance sky130_fd_sc_hd__dfrtp_1_43 r0 *1 0,0
Xsky130_fd_sc_hd__dfrtp_1_43 \$2420 \$2419 \$2499
+ rst_n
+ vss
+ vdd
+ vdd
+ sky130_fd_sc_hd__dfrtp_1
* cell instance sky130_fd_sc_hd__dfrtp_1_44 r0 *1 0,0
Xsky130_fd_sc_hd__dfrtp_1_44 \$701 \$1549 \$1381
+ rst_n
+ vss
+ vdd
+ vdd
+ sky130_fd_sc_hd__dfrtp_1
* cell instance sky130_fd_sc_hd__dfrtp_1_45 r0 *1 0,0
Xsky130_fd_sc_hd__dfrtp_1_45 \$1827 \$1724 \$1380
+ rst_n
+ vss
+ vdd
+ vdd
+ sky130_fd_sc_hd__dfrtp_1
* cell instance sky130_fd_sc_hd__dfrtp_1_46 r0 *1 0,0
Xsky130_fd_sc_hd__dfrtp_1_46 \$2420 \$2224 \$2121
+ rst_n
+ vss
+ vdd
+ vdd
+ sky130_fd_sc_hd__dfrtp_1
* cell instance sky130_fd_sc_hd__dfrtp_1_47 r0 *1 0,0
Xsky130_fd_sc_hd__dfrtp_1_47 \$3920 \$3580 \$3279
+ rst_n
+ vss
+ vdd
+ vdd
+ sky130_fd_sc_hd__dfrtp_1
* cell instance sky130_fd_sc_hd__dfrtp_1_48 r0 *1 0,0
Xsky130_fd_sc_hd__dfrtp_1_48 \$6273 \$6285 \$5974
+ rst_n
+ vss
+ vdd
+ vdd
+ sky130_fd_sc_hd__dfrtp_1
* cell instance sky130_fd_sc_hd__dfrtp_1_49 r0 *1 0,0
Xsky130_fd_sc_hd__dfrtp_1_49 \$2420 \$2867 \$2634
+ rst_n
+ vss
+ vdd
+ vdd
+ sky130_fd_sc_hd__dfrtp_1
* cell instance sky130_fd_sc_hd__dfrtp_1_50 r0 *1 0,0
Xsky130_fd_sc_hd__dfrtp_1_50 \$3920 \$3921 \$4151
+ rst_n
+ vss
+ vdd
+ vdd
+ sky130_fd_sc_hd__dfrtp_1
* cell instance sky130_fd_sc_hd__dfrtp_1_51 r0 *1 0,0
Xsky130_fd_sc_hd__dfrtp_1_51 \$3920 \$4259 \$4254
+ rst_n
+ vss
+ vdd
+ vdd
+ sky130_fd_sc_hd__dfrtp_1
* cell instance sky130_fd_sc_hd__dfrtp_1_52 r0 *1 0,0
Xsky130_fd_sc_hd__dfrtp_1_52 \$3920 \$3682 \$3680
+ rst_n
+ vss
+ vdd
+ vdd
+ sky130_fd_sc_hd__dfrtp_1
* cell instance sky130_fd_sc_hd__dfrtp_1_53 r0 *1 0,0
Xsky130_fd_sc_hd__dfrtp_1_53 \$3920 \$4831 \$4500
+ rst_n
+ vss
+ vdd
+ vdd
+ sky130_fd_sc_hd__dfrtp_1
* cell instance sky130_fd_sc_hd__dfrtp_1_54 r0 *1 0,0
Xsky130_fd_sc_hd__dfrtp_1_54 \$5634 \$6104 \$5976
+ rst_n
+ vss
+ vdd
+ vdd
+ sky130_fd_sc_hd__dfrtp_1
* cell instance sky130_fd_sc_hd__dfrtp_1_55 r0 *1 0,0
Xsky130_fd_sc_hd__dfrtp_1_55 \$701 \$1291 \$1385
+ rst_n
+ vss
+ vdd
+ vdd
+ sky130_fd_sc_hd__dfrtp_1
* cell instance sky130_fd_sc_hd__dfrtp_1_56 r0 *1 0,0
Xsky130_fd_sc_hd__dfrtp_1_56 \$4734 \$5196 \$5163
+ rst_n
+ vss
+ vdd
+ vdd
+ sky130_fd_sc_hd__dfrtp_1
* cell instance sky130_fd_sc_hd__dfrtp_1_57 r0 *1 0,0
Xsky130_fd_sc_hd__dfrtp_1_57 \$701 \$1640 \$1479
+ rst_n
+ vss
+ vdd
+ vdd
+ sky130_fd_sc_hd__dfrtp_1
* cell instance sky130_fd_sc_hd__dfrtp_1_58 r0 *1 0,0
Xsky130_fd_sc_hd__dfrtp_1_58 \$4734 \$5531 \$5308
+ rst_n
+ vss
+ vdd
+ vdd
+ sky130_fd_sc_hd__dfrtp_1
* cell instance sky130_fd_sc_hd__dfrtp_1_59 r0 *1 0,0
Xsky130_fd_sc_hd__dfrtp_1_59 \$6273 \$6105 \$5978
+ rst_n
+ vss
+ vdd
+ vdd
+ sky130_fd_sc_hd__dfrtp_1
* cell instance sky130_fd_sc_hd__dfrtp_1_60 r0 *1 0,0
Xsky130_fd_sc_hd__dfrtp_1_60 \$1735 \$2311 \$2288
+ rst_n
+ vss
+ vdd
+ vdd
+ sky130_fd_sc_hd__dfrtp_1
* cell instance sky130_fd_sc_hd__dfrtp_1_61 r0 *1 0,0
Xsky130_fd_sc_hd__dfrtp_1_61 \$2420 \$2638 \$2747
+ rst_n
+ vss
+ vdd
+ vdd
+ sky130_fd_sc_hd__dfrtp_1
* cell instance sky130_fd_sc_hd__dfrtp_1_62 r0 *1 0,0
Xsky130_fd_sc_hd__dfrtp_1_62 \$4734 \$5651 \$5415
+ rst_n
+ vss
+ vdd
+ vdd
+ sky130_fd_sc_hd__dfrtp_1
* cell instance sky130_fd_sc_hd__dfrtp_1_63 r0 *1 0,0
Xsky130_fd_sc_hd__dfrtp_1_63 \$2420 \$2965 \$2869
+ rst_n
+ vss
+ vdd
+ vdd
+ sky130_fd_sc_hd__dfrtp_1
* cell instance sky130_fd_sc_hd__dfrtp_1_64 r0 *1 0,0
Xsky130_fd_sc_hd__dfrtp_1_64 \$3920 \$3685 startup_done
+ rst_n
+ vss
+ vdd
+ vdd
+ sky130_fd_sc_hd__dfrtp_1
* cell instance sky130_fd_sc_hd__dfrtp_1_65 r0 *1 0,0
Xsky130_fd_sc_hd__dfrtp_1_65 \$1735 \$1932 \$1726
+ rst_n
+ vss
+ vdd
+ vdd
+ sky130_fd_sc_hd__dfrtp_1
* cell instance sky130_fd_sc_hd__dfrtp_1_66 r0 *1 0,0
Xsky130_fd_sc_hd__dfrtp_1_66 \$1735 \$2126 \$2012
+ rst_n
+ vss
+ vdd
+ vdd
+ sky130_fd_sc_hd__dfrtp_1
* cell instance sky130_fd_sc_hd__dfrtp_1_67 r0 *1 0,0
Xsky130_fd_sc_hd__dfrtp_1_67 \$6273 \$6295 \$6286
+ rst_n
+ vss
+ vdd
+ vdd
+ sky130_fd_sc_hd__dfrtp_1
* cell instance sky130_fd_sc_hd__dfrtp_1_68 r0 *1 0,0
Xsky130_fd_sc_hd__dfrtp_1_68 \$2773 \$3042 \$2746
+ rst_n
+ vss
+ vdd
+ vdd
+ sky130_fd_sc_hd__dfrtp_1
* cell instance sky130_fd_sc_hd__dfrtp_1_69 r0 *1 0,0
Xsky130_fd_sc_hd__dfrtp_1_69 \$6273 \$6498 \$6396
+ rst_n
+ vss
+ vdd
+ vdd
+ sky130_fd_sc_hd__dfrtp_1
* cell instance sky130_fd_sc_hd__dfrtp_1_70 r0 *1 0,0
Xsky130_fd_sc_hd__dfrtp_1_70 \$4734 \$4733 \$4604
+ rst_n
+ vss
+ vdd
+ vdd
+ sky130_fd_sc_hd__dfrtp_1
* cell instance sky130_fd_sc_hd__dfrtp_1_71 r0 *1 0,0
Xsky130_fd_sc_hd__dfrtp_1_71 \$3811 \$4161 \$4261
+ rst_n
+ vss
+ vdd
+ vdd
+ sky130_fd_sc_hd__dfrtp_1
* cell instance sky130_fd_sc_hd__dfrtp_1_72 r0 *1 0,0
Xsky130_fd_sc_hd__dfrtp_1_72 \$2773 \$3184 \$3175
+ rst_n
+ vss
+ vdd
+ vdd
+ sky130_fd_sc_hd__dfrtp_1
* cell instance sky130_fd_sc_hd__dfrtp_1_73 r0 *1 0,0
Xsky130_fd_sc_hd__dfrtp_1_73 \$3811 \$3646 \$3645
+ rst_n
+ vss
+ vdd
+ vdd
+ sky130_fd_sc_hd__dfrtp_1
* cell instance sky130_fd_sc_hd__dfrtp_1_74 r0 *1 0,0
Xsky130_fd_sc_hd__dfrtp_1_74 \$5212 \$5987 \$5986
+ rst_n
+ vss
+ vdd
+ vdd
+ sky130_fd_sc_hd__dfrtp_1
* cell instance sky130_fd_sc_hd__dfrtp_1_75 r0 *1 0,0
Xsky130_fd_sc_hd__dfrtp_1_75 \$1400 \$1497 \$1488
+ rst_n
+ vss
+ vdd
+ vdd
+ sky130_fd_sc_hd__dfrtp_1
* cell instance sky130_fd_sc_hd__dfrtp_1_76 r0 *1 0,0
Xsky130_fd_sc_hd__dfrtp_1_76 \$1735 \$2427 \$2527
+ rst_n
+ vss
+ vdd
+ vdd
+ sky130_fd_sc_hd__dfrtp_1
* cell instance sky130_fd_sc_hd__dfrtp_1_77 r0 *1 0,0
Xsky130_fd_sc_hd__dfrtp_1_77 \$1735 \$2931 \$2872
+ rst_n
+ vss
+ vdd
+ vdd
+ sky130_fd_sc_hd__dfrtp_1
* cell instance sky130_fd_sc_hd__dfrtp_1_78 r0 *1 0,0
Xsky130_fd_sc_hd__dfrtp_1_78 \$6273 \$6582 \$6497
+ rst_n
+ vss
+ vdd
+ vdd
+ sky130_fd_sc_hd__dfrtp_1
* cell instance sky130_fd_sc_hd__dfrtp_1_79 r0 *1 0,0
Xsky130_fd_sc_hd__dfrtp_1_79 \$1400 \$1398 \$1390
+ rst_n
+ vss
+ vdd
+ vdd
+ sky130_fd_sc_hd__dfrtp_1
* cell instance sky130_fd_sc_hd__dfrtp_1_80 r0 *1 0,0
Xsky130_fd_sc_hd__dfrtp_1_80 \$1735 \$2609 \$2608
+ rst_n
+ vss
+ vdd
+ vdd
+ sky130_fd_sc_hd__dfrtp_1
* cell instance sky130_fd_sc_hd__dfrtp_1_81 r0 *1 0,0
Xsky130_fd_sc_hd__dfrtp_1_81 \$4734 \$5765 \$5273
+ rst_n
+ vss
+ vdd
+ vdd
+ sky130_fd_sc_hd__dfrtp_1
* cell instance sky130_fd_sc_hd__dfrtp_1_82 r0 *1 0,0
Xsky130_fd_sc_hd__dfrtp_1_82 \$3811 \$4131 \$4367
+ rst_n
+ vss
+ vdd
+ vdd
+ sky130_fd_sc_hd__dfrtp_1
* cell instance sky130_fd_sc_hd__dfrtp_1_83 r0 *1 0,0
Xsky130_fd_sc_hd__dfrtp_1_83 \$2773 \$3695 \$3686
+ rst_n
+ vss
+ vdd
+ vdd
+ sky130_fd_sc_hd__dfrtp_1
* cell instance sky130_fd_sc_hd__dfrtp_1_84 r0 *1 0,0
Xsky130_fd_sc_hd__dfrtp_1_84 \$1400 \$1937 \$1837
+ rst_n
+ vss
+ vdd
+ vdd
+ sky130_fd_sc_hd__dfrtp_1
* cell instance sky130_fd_sc_hd__dfrtp_1_85 r0 *1 0,0
Xsky130_fd_sc_hd__dfrtp_1_85 \$1735 \$2017 \$2127
+ rst_n
+ vss
+ vdd
+ vdd
+ sky130_fd_sc_hd__dfrtp_1
* cell instance sky130_fd_sc_hd__dfrtp_1_86 r0 *1 0,0
Xsky130_fd_sc_hd__dfrtp_1_86 \$5212 \$5660 \$5200
+ rst_n
+ vss
+ vdd
+ vdd
+ sky130_fd_sc_hd__dfrtp_1
* cell instance sky130_fd_sc_hd__dfrtp_1_87 r0 *1 0,0
Xsky130_fd_sc_hd__dfrtp_1_87 \$1005 \$1139 \$1130
+ rst_n
+ vss
+ vdd
+ vdd
+ sky130_fd_sc_hd__dfrtp_1
* cell instance sky130_fd_sc_hd__dfrtp_1_88 r0 *1 0,0
Xsky130_fd_sc_hd__dfrtp_1_88 \$1005 \$1209 \$1056
+ rst_n
+ vss
+ vdd
+ vdd
+ sky130_fd_sc_hd__dfrtp_1
* cell instance sky130_fd_sc_hd__dfrtp_1_89 r0 *1 0,0
Xsky130_fd_sc_hd__dfrtp_1_89 \$2773 \$2970 \$3029
+ rst_n
+ vss
+ vdd
+ vdd
+ sky130_fd_sc_hd__dfrtp_1
* cell instance sky130_fd_sc_hd__dfrtp_1_90 r0 *1 0,0
Xsky130_fd_sc_hd__dfrtp_1_90 \$701 \$995 \$702
+ rst_n
+ vss
+ vdd
+ vdd
+ sky130_fd_sc_hd__dfrtp_1
* cell instance sky130_fd_sc_hd__dfrtp_1_91 r0 *1 0,0
Xsky130_fd_sc_hd__dfrtp_1_91 \$5212 \$6678 \$6190
+ rst_n
+ vss
+ vdd
+ vdd
+ sky130_fd_sc_hd__dfrtp_1
* cell instance sky130_fd_sc_hd__dfrtp_1_92 r0 *1 0,0
Xsky130_fd_sc_hd__dfrtp_1_92 \$6922 \$6920 \$6403
+ rst_n
+ vss
+ vdd
+ vdd
+ sky130_fd_sc_hd__dfrtp_1
* cell instance sky130_fd_sc_hd__dfrtp_1_93 r0 *1 0,0
Xsky130_fd_sc_hd__dfrtp_1_93 \$1400 \$2131 \$2019
+ rst_n
+ vss
+ vdd
+ vdd
+ sky130_fd_sc_hd__dfrtp_1
* cell instance sky130_fd_sc_hd__dfrtp_1_94 r0 *1 0,0
Xsky130_fd_sc_hd__dfrtp_1_94 \$148 \$781 \$423
+ rst_n
+ vss
+ vdd
+ vdd
+ sky130_fd_sc_hd__dfrtp_1
* cell instance sky130_fd_sc_hd__dfrtp_1_95 r0 *1 0,0
Xsky130_fd_sc_hd__dfrtp_1_95 \$2773 \$2880 \$3050
+ rst_n
+ vss
+ vdd
+ vdd
+ sky130_fd_sc_hd__dfrtp_1
* cell instance sky130_fd_sc_hd__dfrtp_1_96 r0 *1 0,0
Xsky130_fd_sc_hd__dfrtp_1_96 \$5212 \$6506 \$6402
+ rst_n
+ vss
+ vdd
+ vdd
+ sky130_fd_sc_hd__dfrtp_1
* cell instance sky130_fd_sc_hd__dfrtp_1_97 r0 *1 0,0
Xsky130_fd_sc_hd__dfrtp_1_97 \$5212 \$6298 \$5989
+ rst_n
+ vss
+ vdd
+ vdd
+ sky130_fd_sc_hd__dfrtp_1
* cell instance sky130_fd_sc_hd__dfrtp_1_98 r0 *1 0,0
Xsky130_fd_sc_hd__dfrtp_1_98 \$2773 \$3476 \$3468
+ rst_n
+ vss
+ vdd
+ vdd
+ sky130_fd_sc_hd__dfrtp_1
* cell instance sky130_fd_sc_hd__dfrtp_1_99 r0 *1 0,0
Xsky130_fd_sc_hd__dfrtp_1_99 \$5212 \$5322 \$5165
+ rst_n
+ vss
+ vdd
+ vdd
+ sky130_fd_sc_hd__dfrtp_1
* cell instance sky130_fd_sc_hd__dfrtp_1_100 r0 *1 0,0
Xsky130_fd_sc_hd__dfrtp_1_100 \$2773 \$3388 \$3386
+ rst_n
+ vss
+ vdd
+ vdd
+ sky130_fd_sc_hd__dfrtp_1
* cell instance sky130_fd_sc_hd__dfrtp_1_101 r0 *1 0,0
Xsky130_fd_sc_hd__dfrtp_1_101 \$4734 \$4612 \$4609
+ rst_n
+ vss
+ vdd
+ vdd
+ sky130_fd_sc_hd__dfrtp_1
* cell instance sky130_fd_sc_hd__dfrtp_1_102 r0 *1 0,0
Xsky130_fd_sc_hd__dfrtp_1_102 \$1400 \$2437 \$2430
+ rst_n
+ vss
+ vdd
+ vdd
+ sky130_fd_sc_hd__dfrtp_1
* cell instance sky130_fd_sc_hd__dfrtp_1_103 r0 *1 0,0
Xsky130_fd_sc_hd__dfrtp_1_103 \$148 \$561 \$493
+ rst_n
+ vss
+ vdd
+ vdd
+ sky130_fd_sc_hd__dfrtp_1
* cell instance sky130_fd_sc_hd__dfrtp_1_104 r0 *1 0,0
Xsky130_fd_sc_hd__dfrtp_1_104 \$1400 \$1563 \$1498
+ rst_n
+ vss
+ vdd
+ vdd
+ sky130_fd_sc_hd__dfrtp_1
* cell instance sky130_fd_sc_hd__dfrtp_1_105 r0 *1 0,0
Xsky130_fd_sc_hd__dfrtp_1_105 \$3811 \$3815 \$3927
+ rst_n
+ vss
+ vdd
+ vdd
+ sky130_fd_sc_hd__dfrtp_1
* cell instance sky130_fd_sc_hd__dfrtp_1_106 r0 *1 0,0
Xsky130_fd_sc_hd__dfrtp_1_106 \$5212 \$5078 \$5076
+ rst_n
+ vss
+ vdd
+ vdd
+ sky130_fd_sc_hd__dfrtp_1
* cell instance sky130_fd_sc_hd__dfrtp_1_107 r0 *1 0,0
Xsky130_fd_sc_hd__dfrtp_1_107 \$1400 \$2323 \$2022
+ rst_n
+ vss
+ vdd
+ vdd
+ sky130_fd_sc_hd__dfrtp_1
* cell instance sky130_fd_sc_hd__dfrtp_1_108 r0 *1 0,0
Xsky130_fd_sc_hd__dfrtp_1_108 \$2773 \$2655 \$2764
+ rst_n
+ vss
+ vdd
+ vdd
+ sky130_fd_sc_hd__dfrtp_1
* cell instance sky130_fd_sc_hd__dfrtp_1_109 r0 *1 0,0
Xsky130_fd_sc_hd__dfrtp_1_109 \$1005 \$871 \$862
+ rst_n
+ vss
+ vdd
+ vdd
+ sky130_fd_sc_hd__dfrtp_1
* cell instance sky130_fd_sc_hd__dfrtp_1_110 r0 *1 0,0
Xsky130_fd_sc_hd__dfrtp_1_110 \$1005 \$1652 \$1300
+ rst_n
+ vss
+ vdd
+ vdd
+ sky130_fd_sc_hd__dfrtp_1
* cell instance sky130_fd_sc_hd__dfrtp_1_111 r0 *1 0,0
Xsky130_fd_sc_hd__dfrtp_1_111 \$6922 \$7424 \$7422
+ rst_n
+ vss
+ vdd
+ vdd
+ sky130_fd_sc_hd__dfrtp_1
* cell instance sky130_fd_sc_hd__dfrtp_1_112 r0 *1 0,0
Xsky130_fd_sc_hd__dfrtp_1_112 \$1713 \$1745 \$1736
+ rst_n
+ vss
+ vdd
+ vdd
+ sky130_fd_sc_hd__dfrtp_1
* cell instance sky130_fd_sc_hd__dfrtp_1_113 r0 *1 0,0
Xsky130_fd_sc_hd__dfrtp_1_113 \$3811 \$4281 \$4178
+ rst_n
+ vss
+ vdd
+ vdd
+ sky130_fd_sc_hd__dfrtp_1
* cell instance sky130_fd_sc_hd__dfrtp_1_114 r0 *1 0,0
Xsky130_fd_sc_hd__dfrtp_1_114 \$5428 \$5427 \$5418
+ rst_n
+ vss
+ vdd
+ vdd
+ sky130_fd_sc_hd__dfrtp_1
* cell instance sky130_fd_sc_hd__dfrtp_1_115 r0 *1 0,0
Xsky130_fd_sc_hd__dfrtp_1_115 \$3811 \$3707 \$4050
+ rst_n
+ vss
+ vdd
+ vdd
+ sky130_fd_sc_hd__dfrtp_1
* cell instance sky130_fd_sc_hd__dfrtp_1_116 r0 *1 0,0
Xsky130_fd_sc_hd__dfrtp_1_116 \$6207 \$6926 \$6832
+ rst_n
+ vss
+ vdd
+ vdd
+ sky130_fd_sc_hd__dfrtp_1
* cell instance sky130_fd_sc_hd__dfrtp_1_117 r0 *1 0,0
Xsky130_fd_sc_hd__dfrtp_1_117 \$148 \$629 \$210
+ rst_n
+ vss
+ vdd
+ vdd
+ sky130_fd_sc_hd__dfrtp_1
* cell instance sky130_fd_sc_hd__dfrtp_1_118 r0 *1 0,0
Xsky130_fd_sc_hd__dfrtp_1_118 \$2981 \$3257 \$3187
+ rst_n
+ vss
+ vdd
+ vdd
+ sky130_fd_sc_hd__dfrtp_1
* cell instance sky130_fd_sc_hd__dfrtp_1_119 r0 *1 0,0
Xsky130_fd_sc_hd__dfrtp_1_119 \$2981 \$2979 \$2971
+ rst_n
+ vss
+ vdd
+ vdd
+ sky130_fd_sc_hd__dfrtp_1
* cell instance sky130_fd_sc_hd__dfrtp_1_120 r0 *1 0,0
Xsky130_fd_sc_hd__dfrtp_1_120 \$2981 \$3481 \$3477
+ rst_n
+ vss
+ vdd
+ vdd
+ sky130_fd_sc_hd__dfrtp_1
* cell instance sky130_fd_sc_hd__dfrtp_1_121 r0 *1 0,0
Xsky130_fd_sc_hd__dfrtp_1_121 \$6207 \$6687 \$6591
+ rst_n
+ vss
+ vdd
+ vdd
+ sky130_fd_sc_hd__dfrtp_1
* cell instance sky130_fd_sc_hd__dfrtp_1_122 r0 *1 0,0
Xsky130_fd_sc_hd__dfrtp_1_122 \$6922 \$7514 \$7282
+ rst_n
+ vss
+ vdd
+ vdd
+ sky130_fd_sc_hd__dfrtp_1
* cell instance sky130_fd_sc_hd__dfrtp_1_123 r0 *1 0,0
Xsky130_fd_sc_hd__dfrtp_1_123 \$1713 \$2440 \$2324
+ rst_n
+ vss
+ vdd
+ vdd
+ sky130_fd_sc_hd__dfrtp_1
* cell instance sky130_fd_sc_hd__dfrtp_1_124 r0 *1 0,0
Xsky130_fd_sc_hd__dfrtp_1_124 \$4073 \$5083 \$5022
+ rst_n
+ vss
+ vdd
+ vdd
+ sky130_fd_sc_hd__dfrtp_1
* cell instance sky130_fd_sc_hd__dfrtp_1_125 r0 *1 0,0
Xsky130_fd_sc_hd__dfrtp_1_125 \$2981 \$3650 \$3649
+ rst_n
+ vss
+ vdd
+ vdd
+ sky130_fd_sc_hd__dfrtp_1
* cell instance sky130_fd_sc_hd__dfrtp_1_126 r0 *1 0,0
Xsky130_fd_sc_hd__dfrtp_1_126 \$5428 \$4846 \$5213
+ rst_n
+ vss
+ vdd
+ vdd
+ sky130_fd_sc_hd__dfrtp_1
* cell instance sky130_fd_sc_hd__dfrtp_1_127 r0 *1 0,0
Xsky130_fd_sc_hd__dfrtp_1_127 \$2545 \$2544 \$2535
+ rst_n
+ vss
+ vdd
+ vdd
+ sky130_fd_sc_hd__dfrtp_1
* cell instance sky130_fd_sc_hd__dfrtp_1_128 r0 *1 0,0
Xsky130_fd_sc_hd__dfrtp_1_128 \$1713 \$2034 \$2140
+ rst_n
+ vss
+ vdd
+ vdd
+ sky130_fd_sc_hd__dfrtp_1
* cell instance sky130_fd_sc_hd__dfrtp_1_129 r0 *1 0,0
Xsky130_fd_sc_hd__dfrtp_1_129 \$148 \$220 \$358
+ rst_n
+ vss
+ vdd
+ vdd
+ sky130_fd_sc_hd__dfrtp_1
* cell instance sky130_fd_sc_hd__dfrtp_1_130 r0 *1 0,0
Xsky130_fd_sc_hd__dfrtp_1_130 \$5428 \$5433 \$5328
+ rst_n
+ vss
+ vdd
+ vdd
+ sky130_fd_sc_hd__dfrtp_1
* cell instance sky130_fd_sc_hd__dfrtp_1_131 r0 *1 0,0
Xsky130_fd_sc_hd__dfrtp_1_131 \$4073 \$4619 \$4614
+ rst_n
+ vss
+ vdd
+ vdd
+ sky130_fd_sc_hd__dfrtp_1
* cell instance sky130_fd_sc_hd__dfrtp_1_132 r0 *1 0,0
Xsky130_fd_sc_hd__dfrtp_1_132 \$5428 \$6008 \$6000
+ rst_n
+ vss
+ vdd
+ vdd
+ sky130_fd_sc_hd__dfrtp_1
* cell instance sky130_fd_sc_hd__dfrtp_1_133 r0 *1 0,0
Xsky130_fd_sc_hd__dfrtp_1_133 \$6850 \$7202 \$7194
+ rst_n
+ vss
+ vdd
+ vdd
+ sky130_fd_sc_hd__dfrtp_1
* cell instance sky130_fd_sc_hd__dfrtp_1_134 r0 *1 0,0
Xsky130_fd_sc_hd__dfrtp_1_134 \$1713 \$1943 \$1653
+ rst_n
+ vss
+ vdd
+ vdd
+ sky130_fd_sc_hd__dfrtp_1
* cell instance sky130_fd_sc_hd__dfrtp_1_135 r0 *1 0,0
Xsky130_fd_sc_hd__dfrtp_1_135 \$6207 \$6511 \$6304
+ rst_n
+ vss
+ vdd
+ vdd
+ sky130_fd_sc_hd__dfrtp_1
* cell instance sky130_fd_sc_hd__dfrtp_1_136 r0 *1 0,0
Xsky130_fd_sc_hd__dfrtp_1_136 \$1713 \$1750 \$718
+ rst_n
+ vss
+ vdd
+ vdd
+ sky130_fd_sc_hd__dfrtp_1
* cell instance sky130_fd_sc_hd__dfrtp_1_137 r0 *1 0,0
Xsky130_fd_sc_hd__dfrtp_1_137 \$3811 \$4285 \$4453
+ rst_n
+ vss
+ vdd
+ vdd
+ sky130_fd_sc_hd__dfrtp_1
* cell instance sky130_fd_sc_hd__dfrtp_1_138 r0 *1 0,0
Xsky130_fd_sc_hd__dfrtp_1_138 \$2981 \$3936 \$3827
+ rst_n
+ vss
+ vdd
+ vdd
+ sky130_fd_sc_hd__dfrtp_1
* cell instance sky130_fd_sc_hd__dfrtp_1_139 r0 *1 0,0
Xsky130_fd_sc_hd__dfrtp_1_139 \$2545 \$2986 \$2774
+ rst_n
+ vss
+ vdd
+ vdd
+ sky130_fd_sc_hd__dfrtp_1
* cell instance sky130_fd_sc_hd__dfrtp_1_140 r0 *1 0,0
Xsky130_fd_sc_hd__dfrtp_1_140 \$1005 \$1410 \$565
+ rst_n
+ vss
+ vdd
+ vdd
+ sky130_fd_sc_hd__dfrtp_1
* cell instance sky130_fd_sc_hd__dfrtp_1_141 r0 *1 0,0
Xsky130_fd_sc_hd__dfrtp_1_141 \$6850 \$7120 \$6929
+ rst_n
+ vss
+ vdd
+ vdd
+ sky130_fd_sc_hd__dfrtp_1
* cell instance sky130_fd_sc_hd__dfrtp_1_142 r0 *1 0,0
Xsky130_fd_sc_hd__dfrtp_1_142 \$1005 \$1072 \$717
+ rst_n
+ vss
+ vdd
+ vdd
+ sky130_fd_sc_hd__dfrtp_1
* cell instance sky130_fd_sc_hd__dfrtp_1_143 r0 *1 0,0
Xsky130_fd_sc_hd__dfrtp_1_143 \$5428 \$5224 \$5087
+ rst_n
+ vss
+ vdd
+ vdd
+ sky130_fd_sc_hd__dfrtp_1
* cell instance sky130_fd_sc_hd__dfrtp_1_144 r0 *1 0,0
Xsky130_fd_sc_hd__dfrtp_1_144 \$2545 \$2889 \$3031
+ rst_n
+ vss
+ vdd
+ vdd
+ sky130_fd_sc_hd__dfrtp_1
* cell instance sky130_fd_sc_hd__dfrtp_1_145 r0 *1 0,0
Xsky130_fd_sc_hd__dfrtp_1_145 \$1713 \$1944 \$1755
+ rst_n
+ vss
+ vdd
+ vdd
+ sky130_fd_sc_hd__dfrtp_1
* cell instance sky130_fd_sc_hd__dfrtp_1_146 r0 *1 0,0
Xsky130_fd_sc_hd__dfrtp_1_146 \$1005 \$1007 \$716
+ rst_n
+ vss
+ vdd
+ vdd
+ sky130_fd_sc_hd__dfrtp_1
* cell instance sky130_fd_sc_hd__dfrtp_1_147 r0 *1 0,0
Xsky130_fd_sc_hd__dfrtp_1_147 \$2545 \$2334 \$2659
+ rst_n
+ vss
+ vdd
+ vdd
+ sky130_fd_sc_hd__dfrtp_1
* cell instance sky130_fd_sc_hd__dfrtp_1_148 r0 *1 0,0
Xsky130_fd_sc_hd__dfrtp_1_148 \$5428 \$5560 \$5621
+ rst_n
+ vss
+ vdd
+ vdd
+ sky130_fd_sc_hd__dfrtp_1
* cell instance sky130_fd_sc_hd__dfrtp_1_149 r0 *1 0,0
Xsky130_fd_sc_hd__dfrtp_1_149 \$2981 \$3197 \$3712
+ rst_n
+ vss
+ vdd
+ vdd
+ sky130_fd_sc_hd__dfrtp_1
* cell instance sky130_fd_sc_hd__dfrtp_1_150 r0 *1 0,0
Xsky130_fd_sc_hd__dfrtp_1_150 \$148 \$369 \$149
+ rst_n
+ vss
+ vdd
+ vdd
+ sky130_fd_sc_hd__dfrtp_1
* cell instance sky130_fd_sc_hd__dfrtp_1_151 r0 *1 0,0
Xsky130_fd_sc_hd__dfrtp_1_151 \$6207 \$6217 \$6209
+ rst_n
+ vss
+ vdd
+ vdd
+ sky130_fd_sc_hd__dfrtp_1
* cell instance sky130_fd_sc_hd__dfrtp_1_152 r0 *1 0,0
Xsky130_fd_sc_hd__dfrtp_1_152 \$6207 \$6421 \$6594
+ rst_n
+ vss
+ vdd
+ vdd
+ sky130_fd_sc_hd__dfrtp_1
* cell instance sky130_fd_sc_hd__dfrtp_1_153 r0 *1 0,0
Xsky130_fd_sc_hd__dfrtp_1_153 \$2981 \$3486 \$3484
+ rst_n
+ vss
+ vdd
+ vdd
+ sky130_fd_sc_hd__dfrtp_1
* cell instance sky130_fd_sc_hd__dfrtp_1_154 r0 *1 0,0
Xsky130_fd_sc_hd__dfrtp_1_154 \$6922 \$7607 \$7904
+ rst_n
+ vss
+ vdd
+ vdd
+ sky130_fd_sc_hd__dfrtp_1
* cell instance sky130_fd_sc_hd__dfrtp_1_155 r0 *1 0,0
Xsky130_fd_sc_hd__dfrtp_1_155 \$4073 \$3602 \$3888
+ rst_n
+ vss
+ vdd
+ vdd
+ sky130_fd_sc_hd__dfrtp_1
* cell instance sky130_fd_sc_hd__dfrtp_1_156 r0 *1 0,0
Xsky130_fd_sc_hd__dfrtp_1_156 \$6850 \$7296 \$7746
+ rst_n
+ vss
+ vdd
+ vdd
+ sky130_fd_sc_hd__dfrtp_1
* cell instance sky130_fd_sc_hd__dfrtp_1_157 r0 *1 0,0
Xsky130_fd_sc_hd__dfrtp_1_157 \$1713 \$2249 \$2291
+ rst_n
+ vss
+ vdd
+ vdd
+ sky130_fd_sc_hd__dfrtp_1
* cell instance sky130_fd_sc_hd__dfrtp_1_158 r0 *1 0,0
Xsky130_fd_sc_hd__dfrtp_1_158 \$2545 \$2892 \$2890
+ rst_n
+ vss
+ vdd
+ vdd
+ sky130_fd_sc_hd__dfrtp_1
* cell instance sky130_fd_sc_hd__dfrtp_1_159 r0 *1 0,0
Xsky130_fd_sc_hd__dfrtp_1_159 \$6850 \$7208 \$4193
+ rst_n
+ vss
+ vdd
+ vdd
+ sky130_fd_sc_hd__dfrtp_1
* cell instance sky130_fd_sc_hd__dfrtp_1_160 r0 *1 0,0
Xsky130_fd_sc_hd__dfrtp_1_160 \$6207 \$6128 \$6013
+ rst_n
+ vss
+ vdd
+ vdd
+ sky130_fd_sc_hd__dfrtp_1
* cell instance sky130_fd_sc_hd__dfrtp_1_161 r0 *1 0,0
Xsky130_fd_sc_hd__dfrtp_1_161 \$6850 \$7521 \$7601
+ rst_n
+ vss
+ vdd
+ vdd
+ sky130_fd_sc_hd__dfrtp_1
* cell instance sky130_fd_sc_hd__dfrtp_1_162 r0 *1 0,0
Xsky130_fd_sc_hd__dfrtp_1_162 \$1713 \$2159 \$2150
+ rst_n
+ vss
+ vdd
+ vdd
+ sky130_fd_sc_hd__dfrtp_1
* cell instance sky130_fd_sc_hd__dfrtp_1_163 r0 *1 0,0
Xsky130_fd_sc_hd__dfrtp_1_163 \$233 \$289 \$433
+ rst_n
+ vss
+ vdd
+ vdd
+ sky130_fd_sc_hd__dfrtp_1
* cell instance sky130_fd_sc_hd__dfrtp_1_164 r0 *1 0,0
Xsky130_fd_sc_hd__dfrtp_1_164 \$4073 \$4072 \$4063
+ rst_n
+ vss
+ vdd
+ vdd
+ sky130_fd_sc_hd__dfrtp_1
* cell instance sky130_fd_sc_hd__dfrtp_1_165 r0 *1 0,0
Xsky130_fd_sc_hd__dfrtp_1_165 \$5099 \$5098 \$5168
+ rst_n
+ vss
+ vdd
+ vdd
+ sky130_fd_sc_hd__dfrtp_1
* cell instance sky130_fd_sc_hd__dfrtp_1_166 r0 *1 0,0
Xsky130_fd_sc_hd__dfrtp_1_166 \$1864 \$1511 \$1413
+ rst_n
+ vss
+ vdd
+ vdd
+ sky130_fd_sc_hd__dfrtp_1
* cell instance sky130_fd_sc_hd__dfrtp_1_167 r0 *1 0,0
Xsky130_fd_sc_hd__dfrtp_1_167 \$1864 \$1947 \$1758
+ rst_n
+ vss
+ vdd
+ vdd
+ sky130_fd_sc_hd__dfrtp_1
* cell instance sky130_fd_sc_hd__dfrtp_1_168 r0 *1 0,0
Xsky130_fd_sc_hd__dfrtp_1_168 \$233 \$161 \$92
+ rst_n
+ vss
+ vdd
+ vdd
+ sky130_fd_sc_hd__dfrtp_1
* cell instance sky130_fd_sc_hd__dfrtp_1_169 r0 *1 0,0
Xsky130_fd_sc_hd__dfrtp_1_169 \$5099 \$5567 \$5562
+ rst_n
+ vss
+ vdd
+ vdd
+ sky130_fd_sc_hd__dfrtp_1
* cell instance sky130_fd_sc_hd__dfrtp_1_170 r0 *1 0,0
Xsky130_fd_sc_hd__dfrtp_1_170 \$2545 \$2839 \$2784
+ rst_n
+ vss
+ vdd
+ vdd
+ sky130_fd_sc_hd__dfrtp_1
* cell instance sky130_fd_sc_hd__dfrtp_1_171 r0 *1 0,0
Xsky130_fd_sc_hd__dfrtp_1_171 \$6431 \$6430 \$6422
+ rst_n
+ vss
+ vdd
+ vdd
+ sky130_fd_sc_hd__dfrtp_1
* cell instance sky130_fd_sc_hd__dfrtp_1_172 r0 *1 0,0
Xsky130_fd_sc_hd__dfrtp_1_172 \$6863 \$6945 \$6939
+ rst_n
+ vss
+ vdd
+ vdd
+ sky130_fd_sc_hd__dfrtp_1
* cell instance sky130_fd_sc_hd__dfrtp_1_173 r0 *1 0,0
Xsky130_fd_sc_hd__dfrtp_1_173 \$6863 \$6776 \$7018
+ rst_n
+ vss
+ vdd
+ vdd
+ sky130_fd_sc_hd__dfrtp_1
* cell instance sky130_fd_sc_hd__dfrtp_1_174 r0 *1 0,0
Xsky130_fd_sc_hd__dfrtp_1_174 \$5099 \$5276 \$5226
+ rst_n
+ vss
+ vdd
+ vdd
+ sky130_fd_sc_hd__dfrtp_1
* cell instance sky130_fd_sc_hd__dfrtp_1_175 r0 *1 0,0
Xsky130_fd_sc_hd__dfrtp_1_175 \$2545 \$3077 \$3198
+ rst_n
+ vss
+ vdd
+ vdd
+ sky130_fd_sc_hd__dfrtp_1
* cell instance sky130_fd_sc_hd__dfrtp_1_176 r0 *1 0,0
Xsky130_fd_sc_hd__dfrtp_1_176 \$804 \$583 \$726
+ rst_n
+ vss
+ vdd
+ vdd
+ sky130_fd_sc_hd__dfrtp_1
* cell instance sky130_fd_sc_hd__dfrtp_1_177 r0 *1 0,0
Xsky130_fd_sc_hd__dfrtp_1_177 \$233 \$231 \$222
+ rst_n
+ vss
+ vdd
+ vdd
+ sky130_fd_sc_hd__dfrtp_1
* cell instance sky130_fd_sc_hd__dfrtp_1_178 r0 *1 0,0
Xsky130_fd_sc_hd__dfrtp_1_178 \$804 \$1584 \$1576
+ rst_n
+ vss
+ vdd
+ vdd
+ sky130_fd_sc_hd__dfrtp_1
* cell instance sky130_fd_sc_hd__dfrtp_1_179 r0 *1 0,0
Xsky130_fd_sc_hd__dfrtp_1_179 \$3404 \$3493 \$3603
+ rst_n
+ vss
+ vdd
+ vdd
+ sky130_fd_sc_hd__dfrtp_1
* cell instance sky130_fd_sc_hd__dfrtp_1_180 r0 *1 0,0
Xsky130_fd_sc_hd__dfrtp_1_180 \$4073 \$4803 \$4851
+ rst_n
+ vss
+ vdd
+ vdd
+ sky130_fd_sc_hd__dfrtp_1
* cell instance sky130_fd_sc_hd__dfrtp_1_181 r0 *1 0,0
Xsky130_fd_sc_hd__dfrtp_1_181 \$6863 \$6699 \$6693
+ rst_n
+ vss
+ vdd
+ vdd
+ sky130_fd_sc_hd__dfrtp_1
* cell instance sky130_fd_sc_hd__dfrtp_1_182 r0 *1 0,0
Xsky130_fd_sc_hd__dfrtp_1_182 \$6863 \$7828 \$7209
+ rst_n
+ vss
+ vdd
+ vdd
+ sky130_fd_sc_hd__dfrtp_1
* cell instance sky130_fd_sc_hd__dfrtp_1_183 r0 *1 0,0
Xsky130_fd_sc_hd__dfrtp_1_183 \$1864 \$2252 \$2250
+ rst_n
+ vss
+ vdd
+ vdd
+ sky130_fd_sc_hd__dfrtp_1
* cell instance sky130_fd_sc_hd__dfrtp_1_184 r0 *1 0,0
Xsky130_fd_sc_hd__dfrtp_1_184 \$3404 \$3840 \$4062
+ rst_n
+ vss
+ vdd
+ vdd
+ sky130_fd_sc_hd__dfrtp_1
* cell instance sky130_fd_sc_hd__dfrtp_1_185 r0 *1 0,0
Xsky130_fd_sc_hd__dfrtp_1_185 \$3404 \$4082 \$4457
+ rst_n
+ vss
+ vdd
+ vdd
+ sky130_fd_sc_hd__dfrtp_1
* cell instance sky130_fd_sc_hd__dfrtp_1_186 r0 *1 0,0
Xsky130_fd_sc_hd__dfrtp_1_186 \$7441 \$7922 \$7680
+ rst_n
+ vss
+ vdd
+ vdd
+ sky130_fd_sc_hd__dfrtp_1
* cell instance sky130_fd_sc_hd__dfrtp_1_187 r0 *1 0,0
Xsky130_fd_sc_hd__dfrtp_1_187 \$3404 \$3402 bus_rdata[15]
+ rst_n
+ vss
+ vdd
+ vdd
+ sky130_fd_sc_hd__dfrtp_1
* cell instance sky130_fd_sc_hd__dfrtp_1_188 r0 *1 0,0
Xsky130_fd_sc_hd__dfrtp_1_188 \$3404 \$4298 \$4391
+ rst_n
+ vss
+ vdd
+ vdd
+ sky130_fd_sc_hd__dfrtp_1
* cell instance sky130_fd_sc_hd__dfrtp_1_189 r0 *1 0,0
Xsky130_fd_sc_hd__dfrtp_1_189 \$1864 \$2552 \$2668
+ rst_n
+ vss
+ vdd
+ vdd
+ sky130_fd_sc_hd__dfrtp_1
* cell instance sky130_fd_sc_hd__dfrtp_1_190 r0 *1 0,0
Xsky130_fd_sc_hd__dfrtp_1_190 \$4073 \$4631 bus_rdata[23]
+ rst_n
+ vss
+ vdd
+ vdd
+ sky130_fd_sc_hd__dfrtp_1
* cell instance sky130_fd_sc_hd__dfrtp_1_191 r0 *1 0,0
Xsky130_fd_sc_hd__dfrtp_1_191 \$5099 \$5107 \$5170
+ rst_n
+ vss
+ vdd
+ vdd
+ sky130_fd_sc_hd__dfrtp_1
* cell instance sky130_fd_sc_hd__dfrtp_1_192 r0 *1 0,0
Xsky130_fd_sc_hd__dfrtp_1_192 \$3404 \$2995 \$2992
+ rst_n
+ vss
+ vdd
+ vdd
+ sky130_fd_sc_hd__dfrtp_1
* cell instance sky130_fd_sc_hd__dfrtp_1_193 r0 *1 0,0
Xsky130_fd_sc_hd__dfrtp_1_193 \$233 \$104 \$234
+ rst_n
+ vss
+ vdd
+ vdd
+ sky130_fd_sc_hd__dfrtp_1
* cell instance sky130_fd_sc_hd__dfrtp_1_194 r0 *1 0,0
Xsky130_fd_sc_hd__dfrtp_1_194 \$1173 \$2168 \$2160
+ rst_n
+ vss
+ vdd
+ vdd
+ sky130_fd_sc_hd__dfrtp_1
* cell instance sky130_fd_sc_hd__dfrtp_1_195 r0 *1 0,0
Xsky130_fd_sc_hd__dfrtp_1_195 \$233 \$237 \$294
+ rst_n
+ vss
+ vdd
+ vdd
+ sky130_fd_sc_hd__dfrtp_1
* cell instance sky130_fd_sc_hd__dfrtp_1_196 r0 *1 0,0
Xsky130_fd_sc_hd__dfrtp_1_196 \$3404 \$4529 bus_rdata[21]
+ rst_n
+ vss
+ vdd
+ vdd
+ sky130_fd_sc_hd__dfrtp_1
* cell instance sky130_fd_sc_hd__dfrtp_1_197 r0 *1 0,0
Xsky130_fd_sc_hd__dfrtp_1_197 \$6863 \$7447 \$5444
+ rst_n
+ vss
+ vdd
+ vdd
+ sky130_fd_sc_hd__dfrtp_1
* cell instance sky130_fd_sc_hd__dfrtp_1_198 r0 *1 0,0
Xsky130_fd_sc_hd__dfrtp_1_198 \$2567 \$3081 \$3207
+ rst_n
+ vss
+ vdd
+ vdd
+ sky130_fd_sc_hd__dfrtp_1
* cell instance sky130_fd_sc_hd__dfrtp_1_199 r0 *1 0,0
Xsky130_fd_sc_hd__dfrtp_1_199 \$7441 \$7833 \$7962
+ rst_n
+ vss
+ vdd
+ vdd
+ sky130_fd_sc_hd__dfrtp_1
* cell instance sky130_fd_sc_hd__dfrtp_1_200 r0 *1 0,0
Xsky130_fd_sc_hd__dfrtp_1_200 \$6431 \$6229 \$6220
+ rst_n
+ vss
+ vdd
+ vdd
+ sky130_fd_sc_hd__dfrtp_1
* cell instance sky130_fd_sc_hd__dfrtp_1_201 r0 *1 0,0
Xsky130_fd_sc_hd__dfrtp_1_201 \$6431 \$5899 \$6489
+ rst_n
+ vss
+ vdd
+ vdd
+ sky130_fd_sc_hd__dfrtp_1
* cell instance sky130_fd_sc_hd__dfrtp_1_202 r0 *1 0,0
Xsky130_fd_sc_hd__dfrtp_1_202 \$5099 \$6032 \$6022
+ rst_n
+ vss
+ vdd
+ vdd
+ sky130_fd_sc_hd__dfrtp_1
* cell instance sky130_fd_sc_hd__dfrtp_1_203 r0 *1 0,0
Xsky130_fd_sc_hd__dfrtp_1_203 \$804 \$1512 \$1080
+ rst_n
+ vss
+ vdd
+ vdd
+ sky130_fd_sc_hd__dfrtp_1
* cell instance sky130_fd_sc_hd__dfrtp_1_204 r0 *1 0,0
Xsky130_fd_sc_hd__dfrtp_1_204 \$1864 \$1770 \$1866
+ rst_n
+ vss
+ vdd
+ vdd
+ sky130_fd_sc_hd__dfrtp_1
* cell instance sky130_fd_sc_hd__dfrtp_1_205 r0 *1 0,0
Xsky130_fd_sc_hd__dfrtp_1_205 \$5115 \$5354 \$5238
+ rst_n
+ vss
+ vdd
+ vdd
+ sky130_fd_sc_hd__dfrtp_1
* cell instance sky130_fd_sc_hd__dfrtp_1_206 r0 *1 0,0
Xsky130_fd_sc_hd__dfrtp_1_206 \$804 \$882 \$586
+ rst_n
+ vss
+ vdd
+ vdd
+ sky130_fd_sc_hd__dfrtp_1
* cell instance sky130_fd_sc_hd__dfrtp_1_207 r0 *1 0,0
Xsky130_fd_sc_hd__dfrtp_1_207 \$6431 \$7034 \$6777
+ rst_n
+ vss
+ vdd
+ vdd
+ sky130_fd_sc_hd__dfrtp_1
* cell instance sky130_fd_sc_hd__dfrtp_1_208 r0 *1 0,0
Xsky130_fd_sc_hd__dfrtp_1_208 \$1864 \$2348 \$2895
+ rst_n
+ vss
+ vdd
+ vdd
+ sky130_fd_sc_hd__dfrtp_1
* cell instance sky130_fd_sc_hd__dfrtp_1_209 r0 *1 0,0
Xsky130_fd_sc_hd__dfrtp_1_209 \$1864 \$1869 \$1766
+ rst_n
+ vss
+ vdd
+ vdd
+ sky130_fd_sc_hd__dfrtp_1
* cell instance sky130_fd_sc_hd__dfrtp_1_210 r0 *1 0,0
Xsky130_fd_sc_hd__dfrtp_1_210 \$3404 \$3407 \$3302
+ rst_n
+ vss
+ vdd
+ vdd
+ sky130_fd_sc_hd__dfrtp_1
* cell instance sky130_fd_sc_hd__dfrtp_1_211 r0 *1 0,0
Xsky130_fd_sc_hd__dfrtp_1_211 \$4407 \$4200 bus_rdata[14]
+ rst_n
+ vss
+ vdd
+ vdd
+ sky130_fd_sc_hd__dfrtp_1
* cell instance sky130_fd_sc_hd__dfrtp_1_212 r0 *1 0,0
Xsky130_fd_sc_hd__dfrtp_1_212 \$1864 \$2556 \$2715
+ rst_n
+ vss
+ vdd
+ vdd
+ sky130_fd_sc_hd__dfrtp_1
* cell instance sky130_fd_sc_hd__dfrtp_1_213 r0 *1 0,0
Xsky130_fd_sc_hd__dfrtp_1_213 \$804 \$1321 \$1078
+ rst_n
+ vss
+ vdd
+ vdd
+ sky130_fd_sc_hd__dfrtp_1
* cell instance sky130_fd_sc_hd__dfrtp_1_214 r0 *1 0,0
Xsky130_fd_sc_hd__dfrtp_1_214 \$5115 \$5576 \$4751
+ rst_n
+ vss
+ vdd
+ vdd
+ sky130_fd_sc_hd__dfrtp_1
* cell instance sky130_fd_sc_hd__dfrtp_1_215 r0 *1 0,0
Xsky130_fd_sc_hd__dfrtp_1_215 \$233 \$303 \$170
+ rst_n
+ vss
+ vdd
+ vdd
+ sky130_fd_sc_hd__dfrtp_1
* cell instance sky130_fd_sc_hd__dfrtp_1_216 r0 *1 0,0
Xsky130_fd_sc_hd__dfrtp_1_216 \$233 \$522 \$444
+ rst_n
+ vss
+ vdd
+ vdd
+ sky130_fd_sc_hd__dfrtp_1
* cell instance sky130_fd_sc_hd__dfrtp_1_217 r0 *1 0,0
Xsky130_fd_sc_hd__dfrtp_1_217 \$6863 \$7039 \$7137
+ rst_n
+ vss
+ vdd
+ vdd
+ sky130_fd_sc_hd__dfrtp_1
* cell instance sky130_fd_sc_hd__dfrtp_1_218 r0 *1 0,0
Xsky130_fd_sc_hd__dfrtp_1_218 \$2567 \$3510 \$3502
+ rst_n
+ vss
+ vdd
+ vdd
+ sky130_fd_sc_hd__dfrtp_1
* cell instance sky130_fd_sc_hd__dfrtp_1_219 r0 *1 0,0
Xsky130_fd_sc_hd__dfrtp_1_219 \$2567 \$3085 bus_rdata[17]
+ rst_n
+ vss
+ vdd
+ vdd
+ sky130_fd_sc_hd__dfrtp_1
* cell instance sky130_fd_sc_hd__dfrtp_1_220 r0 *1 0,0
Xsky130_fd_sc_hd__dfrtp_1_220 \$40 \$597 \$732
+ rst_n
+ vss
+ vdd
+ vdd
+ sky130_fd_sc_hd__dfrtp_1
* cell instance sky130_fd_sc_hd__dfrtp_1_221 r0 *1 0,0
Xsky130_fd_sc_hd__dfrtp_1_221 \$4407 \$4462 \$4460
+ rst_n
+ vss
+ vdd
+ vdd
+ sky130_fd_sc_hd__dfrtp_1
* cell instance sky130_fd_sc_hd__dfrtp_1_222 r0 *1 0,0
Xsky130_fd_sc_hd__dfrtp_1_222 \$6431 \$6446 \$4979
+ rst_n
+ vss
+ vdd
+ vdd
+ sky130_fd_sc_hd__dfrtp_1
* cell instance sky130_fd_sc_hd__dfrtp_1_223 r0 *1 0,0
Xsky130_fd_sc_hd__dfrtp_1_223 \$7441 \$7383 \$5683
+ rst_n
+ vss
+ vdd
+ vdd
+ sky130_fd_sc_hd__dfrtp_1
* cell instance sky130_fd_sc_hd__dfrtp_1_224 r0 *1 0,0
Xsky130_fd_sc_hd__dfrtp_1_224 \$7626 \$7843 \$7923
+ rst_n
+ vss
+ vdd
+ vdd
+ sky130_fd_sc_hd__dfrtp_1
* cell instance sky130_fd_sc_hd__dfrtp_1_225 r0 *1 0,0
Xsky130_fd_sc_hd__dfrtp_1_225 \$40 \$35 \$30
+ rst_n
+ vss
+ vdd
+ vdd
+ sky130_fd_sc_hd__dfrtp_1
* cell instance sky130_fd_sc_hd__dfrtp_1_226 r0 *1 0,0
Xsky130_fd_sc_hd__dfrtp_1_226 \$5115 \$4984 \$5172
+ rst_n
+ vss
+ vdd
+ vdd
+ sky130_fd_sc_hd__dfrtp_1
* cell instance sky130_fd_sc_hd__dfrtp_1_227 r0 *1 0,0
Xsky130_fd_sc_hd__dfrtp_1_227 \$804 \$1018 \$941
+ rst_n
+ vss
+ vdd
+ vdd
+ sky130_fd_sc_hd__dfrtp_1
* cell instance sky130_fd_sc_hd__dfrtp_1_228 r0 *1 0,0
Xsky130_fd_sc_hd__dfrtp_1_228 \$4407 \$4646 \$3994
+ rst_n
+ vss
+ vdd
+ vdd
+ sky130_fd_sc_hd__dfrtp_1
* cell instance sky130_fd_sc_hd__dfrtp_1_229 r0 *1 0,0
Xsky130_fd_sc_hd__dfrtp_1_229 \$5115 \$5358 \$5455
+ rst_n
+ vss
+ vdd
+ vdd
+ sky130_fd_sc_hd__dfrtp_1
* cell instance sky130_fd_sc_hd__dfrtp_1_230 r0 *1 0,0
Xsky130_fd_sc_hd__dfrtp_1_230 \$40 \$183 \$238
+ rst_n
+ vss
+ vdd
+ vdd
+ sky130_fd_sc_hd__dfrtp_1
* cell instance sky130_fd_sc_hd__dfrtp_1_231 r0 *1 0,0
Xsky130_fd_sc_hd__dfrtp_1_231 \$1173 \$1594 \$1586
+ rst_n
+ vss
+ vdd
+ vdd
+ sky130_fd_sc_hd__dfrtp_1
* cell instance sky130_fd_sc_hd__dfrtp_1_232 r0 *1 0,0
Xsky130_fd_sc_hd__dfrtp_1_232 \$1173 \$1093 \$1086
+ rst_n
+ vss
+ vdd
+ vdd
+ sky130_fd_sc_hd__dfrtp_1
* cell instance sky130_fd_sc_hd__dfrtp_1_233 r0 *1 0,0
Xsky130_fd_sc_hd__dfrtp_1_233 \$2567 \$3090 bus_rdata[7]
+ rst_n
+ vss
+ vdd
+ vdd
+ sky130_fd_sc_hd__dfrtp_1
* cell instance sky130_fd_sc_hd__dfrtp_1_234 r0 *1 0,0
Xsky130_fd_sc_hd__dfrtp_1_234 \$5115 \$5693 \$2062
+ rst_n
+ vss
+ vdd
+ vdd
+ sky130_fd_sc_hd__dfrtp_1
* cell instance sky130_fd_sc_hd__dfrtp_1_235 r0 *1 0,0
Xsky130_fd_sc_hd__dfrtp_1_235 \$7626 \$7695 \$7764
+ rst_n
+ vss
+ vdd
+ vdd
+ sky130_fd_sc_hd__dfrtp_1
* cell instance sky130_fd_sc_hd__dfrtp_1_236 r0 *1 0,0
Xsky130_fd_sc_hd__dfrtp_1_236 \$6431 \$6871 \$6869
+ rst_n
+ vss
+ vdd
+ vdd
+ sky130_fd_sc_hd__dfrtp_1
* cell instance sky130_fd_sc_hd__dfrtp_1_237 r0 *1 0,0
Xsky130_fd_sc_hd__dfrtp_1_237 \$655 \$654 \$645
+ rst_n
+ vss
+ vdd
+ vdd
+ sky130_fd_sc_hd__dfrtp_1
* cell instance sky130_fd_sc_hd__dfrtp_1_238 r0 *1 0,0
Xsky130_fd_sc_hd__dfrtp_1_238 \$1173 \$1325 \$1226
+ rst_n
+ vss
+ vdd
+ vdd
+ sky130_fd_sc_hd__dfrtp_1
* cell instance sky130_fd_sc_hd__dfrtp_1_239 r0 *1 0,0
Xsky130_fd_sc_hd__dfrtp_1_239 \$1173 \$1873 \$1956
+ rst_n
+ vss
+ vdd
+ vdd
+ sky130_fd_sc_hd__dfrtp_1
* cell instance sky130_fd_sc_hd__dfrtp_1_240 r0 *1 0,0
Xsky130_fd_sc_hd__dfrtp_1_240 \$5115 \$5909 \$5901
+ rst_n
+ vss
+ vdd
+ vdd
+ sky130_fd_sc_hd__dfrtp_1
* cell instance sky130_fd_sc_hd__dfrtp_1_241 r0 *1 0,0
Xsky130_fd_sc_hd__dfrtp_1_241 \$5115 \$6147 \$6139
+ rst_n
+ vss
+ vdd
+ vdd
+ sky130_fd_sc_hd__dfrtp_1
* cell instance sky130_fd_sc_hd__dfrtp_1_242 r0 *1 0,0
Xsky130_fd_sc_hd__dfrtp_1_242 \$40 \$250 \$242
+ rst_n
+ vss
+ vdd
+ vdd
+ sky130_fd_sc_hd__dfrtp_1
* cell instance sky130_fd_sc_hd__dfrtp_1_243 r0 *1 0,0
Xsky130_fd_sc_hd__dfrtp_1_243 \$5115 \$6331 \$6322
+ rst_n
+ vss
+ vdd
+ vdd
+ sky130_fd_sc_hd__dfrtp_1
* cell instance sky130_fd_sc_hd__dfrtp_1_244 r0 *1 0,0
Xsky130_fd_sc_hd__dfrtp_1_244 \$2567 \$2566 \$2350
+ rst_n
+ vss
+ vdd
+ vdd
+ sky130_fd_sc_hd__dfrtp_1
* cell instance sky130_fd_sc_hd__dfrtp_1_245 r0 *1 0,0
Xsky130_fd_sc_hd__dfrtp_1_245 \$655 \$744 \$809
+ rst_n
+ vss
+ vdd
+ vdd
+ sky130_fd_sc_hd__dfrtp_1
* cell instance sky130_fd_sc_hd__dfrtp_1_246 r0 *1 0,0
Xsky130_fd_sc_hd__dfrtp_1_246 \$2567 \$3513 \$3619
+ rst_n
+ vss
+ vdd
+ vdd
+ sky130_fd_sc_hd__dfrtp_1
* cell instance sky130_fd_sc_hd__dfrtp_1_247 r0 *1 0,0
Xsky130_fd_sc_hd__dfrtp_1_247 \$4407 \$4652 \$2258
+ rst_n
+ vss
+ vdd
+ vdd
+ sky130_fd_sc_hd__dfrtp_1
* cell instance sky130_fd_sc_hd__dfrtp_1_248 r0 *1 0,0
Xsky130_fd_sc_hd__dfrtp_1_248 \$5248 \$4877 \$5464
+ rst_n
+ vss
+ vdd
+ vdd
+ sky130_fd_sc_hd__dfrtp_1
* cell instance sky130_fd_sc_hd__dfrtp_1_249 r0 *1 0,0
Xsky130_fd_sc_hd__dfrtp_1_249 \$2180 \$2179 \$1515
+ rst_n
+ vss
+ vdd
+ vdd
+ sky130_fd_sc_hd__dfrtp_1
* cell instance sky130_fd_sc_hd__dfrtp_1_250 r0 *1 0,0
Xsky130_fd_sc_hd__dfrtp_1_250 \$40 \$114 \$106
+ rst_n
+ vss
+ vdd
+ vdd
+ sky130_fd_sc_hd__dfrtp_1
* cell instance sky130_fd_sc_hd__dfrtp_1_251 r0 *1 0,0
Xsky130_fd_sc_hd__dfrtp_1_251 \$7626 \$7932 \$7848
+ rst_n
+ vss
+ vdd
+ vdd
+ sky130_fd_sc_hd__dfrtp_1
* cell instance sky130_fd_sc_hd__dfrtp_1_252 r0 *1 0,0
Xsky130_fd_sc_hd__dfrtp_1_252 \$40 \$385 \$312
+ rst_n
+ vss
+ vdd
+ vdd
+ sky130_fd_sc_hd__dfrtp_1
* cell instance sky130_fd_sc_hd__dfrtp_1_253 r0 *1 0,0
Xsky130_fd_sc_hd__dfrtp_1_253 \$5248 \$4991 \$4987
+ rst_n
+ vss
+ vdd
+ vdd
+ sky130_fd_sc_hd__dfrtp_1
* cell instance sky130_fd_sc_hd__dfrtp_1_254 r0 *1 0,0
Xsky130_fd_sc_hd__dfrtp_1_254 \$5248 \$5247 \$5245
+ rst_n
+ vss
+ vdd
+ vdd
+ sky130_fd_sc_hd__dfrtp_1
* cell instance sky130_fd_sc_hd__dfrtp_1_255 r0 *1 0,0
Xsky130_fd_sc_hd__dfrtp_1_255 \$1173 \$1599 \$1432
+ rst_n
+ vss
+ vdd
+ vdd
+ sky130_fd_sc_hd__dfrtp_1
* cell instance sky130_fd_sc_hd__dfrtp_1_256 r0 *1 0,0
Xsky130_fd_sc_hd__dfrtp_1_256 \$40 \$188 \$41
+ rst_n
+ vss
+ vdd
+ vdd
+ sky130_fd_sc_hd__dfrtp_1
* cell instance sky130_fd_sc_hd__dfrtp_1_257 r0 *1 0,0
Xsky130_fd_sc_hd__dfrtp_1_257 \$2180 \$2273 \$1516
+ rst_n
+ vss
+ vdd
+ vdd
+ sky130_fd_sc_hd__dfrtp_1
* cell instance sky130_fd_sc_hd__dfrtp_1_258 r0 *1 0,0
Xsky130_fd_sc_hd__dfrtp_1_258 \$4407 \$4412 bus_rdata[18]
+ rst_n
+ vss
+ vdd
+ vdd
+ sky130_fd_sc_hd__dfrtp_1
* cell instance sky130_fd_sc_hd__dfrtp_1_259 r0 *1 0,0
Xsky130_fd_sc_hd__dfrtp_1_259 \$6714 \$7152 \$5588
+ rst_n
+ vss
+ vdd
+ vdd
+ sky130_fd_sc_hd__dfrtp_1
* cell instance sky130_fd_sc_hd__dfrtp_1_260 r0 *1 0,0
Xsky130_fd_sc_hd__dfrtp_1_260 \$655 \$890 \$952
+ rst_n
+ vss
+ vdd
+ vdd
+ sky130_fd_sc_hd__dfrtp_1
* cell instance sky130_fd_sc_hd__dfrtp_1_261 r0 *1 0,0
Xsky130_fd_sc_hd__dfrtp_1_261 \$655 \$1025 \$1095
+ rst_n
+ vss
+ vdd
+ vdd
+ sky130_fd_sc_hd__dfrtp_1
* cell instance sky130_fd_sc_hd__dfrtp_1_262 r0 *1 0,0
Xsky130_fd_sc_hd__dfrtp_1_262 \$655 \$1243 \$1235
+ rst_n
+ vss
+ vdd
+ vdd
+ sky130_fd_sc_hd__dfrtp_1
* cell instance sky130_fd_sc_hd__dfrtp_1_263 r0 *1 0,0
Xsky130_fd_sc_hd__dfrtp_1_263 \$6714 \$6800 \$6796
+ rst_n
+ vss
+ vdd
+ vdd
+ sky130_fd_sc_hd__dfrtp_1
* cell instance sky130_fd_sc_hd__dfrtp_1_264 r0 *1 0,0
Xsky130_fd_sc_hd__dfrtp_1_264 \$7626 \$7464 \$7458
+ rst_n
+ vss
+ vdd
+ vdd
+ sky130_fd_sc_hd__dfrtp_1
* cell instance sky130_fd_sc_hd__dfrtp_1_265 r0 *1 0,0
Xsky130_fd_sc_hd__dfrtp_1_265 \$6714 \$7240 \$7318
+ rst_n
+ vss
+ vdd
+ vdd
+ sky130_fd_sc_hd__dfrtp_1
* cell instance sky130_fd_sc_hd__dfrtp_1_266 r0 *1 0,0
Xsky130_fd_sc_hd__dfrtp_1_266 \$1173 \$1679 \$1672
+ rst_n
+ vss
+ vdd
+ vdd
+ sky130_fd_sc_hd__dfrtp_1
* cell instance sky130_fd_sc_hd__dfrtp_1_267 r0 *1 0,0
Xsky130_fd_sc_hd__dfrtp_1_267 \$2180 \$2295 \$2264
+ rst_n
+ vss
+ vdd
+ vdd
+ sky130_fd_sc_hd__dfrtp_1
* cell instance sky130_fd_sc_hd__dfrtp_1_268 r0 *1 0,0
Xsky130_fd_sc_hd__dfrtp_1_268 \$655 \$1182 \$1174
+ rst_n
+ vss
+ vdd
+ vdd
+ sky130_fd_sc_hd__dfrtp_1
* cell instance sky130_fd_sc_hd__dfrtp_1_269 r0 *1 0,0
Xsky130_fd_sc_hd__dfrtp_1_269 \$2567 \$3327 \$3093
+ rst_n
+ vss
+ vdd
+ vdd
+ sky130_fd_sc_hd__dfrtp_1
* cell instance sky130_fd_sc_hd__dfrtp_1_270 r0 *1 0,0
Xsky130_fd_sc_hd__dfrtp_1_270 \$655 \$528 \$526
+ rst_n
+ vss
+ vdd
+ vdd
+ sky130_fd_sc_hd__dfrtp_1
* cell instance sky130_fd_sc_hd__dfrtp_1_271 r0 *1 0,0
Xsky130_fd_sc_hd__dfrtp_1_271 \$655 \$662 \$746
+ rst_n
+ vss
+ vdd
+ vdd
+ sky130_fd_sc_hd__dfrtp_1
* cell instance sky130_fd_sc_hd__dfrtp_1_272 r0 *1 0,0
Xsky130_fd_sc_hd__dfrtp_1_272 \$2180 \$1814 \$1879
+ rst_n
+ vss
+ vdd
+ vdd
+ sky130_fd_sc_hd__dfrtp_1
* cell instance sky130_fd_sc_hd__dfrtp_1_273 r0 *1 0,0
Xsky130_fd_sc_hd__dfrtp_1_273 \$4407 \$3970 bus_rdata[9]
+ rst_n
+ vss
+ vdd
+ vdd
+ sky130_fd_sc_hd__dfrtp_1
* cell instance sky130_fd_sc_hd__dfrtp_1_274 r0 *1 0,0
Xsky130_fd_sc_hd__dfrtp_1_274 \$6633 \$6974 \$6624
+ rst_n
+ vss
+ vdd
+ vdd
+ sky130_fd_sc_hd__dfrtp_1
* cell instance sky130_fd_sc_hd__dfrtp_1_275 r0 *1 0,0
Xsky130_fd_sc_hd__dfrtp_1_275 \$7626 \$7937 \$7630
+ rst_n
+ vss
+ vdd
+ vdd
+ sky130_fd_sc_hd__dfrtp_1
* cell instance sky130_fd_sc_hd__dfrtp_1_276 r0 *1 0,0
Xsky130_fd_sc_hd__dfrtp_1_276 \$59 \$254 \$321
+ rst_n
+ vss
+ vdd
+ vdd
+ sky130_fd_sc_hd__dfrtp_1
* cell instance sky130_fd_sc_hd__dfrtp_1_277 r0 *1 0,0
Xsky130_fd_sc_hd__dfrtp_1_277 \$6633 \$7156 \$7153
+ rst_n
+ vss
+ vdd
+ vdd
+ sky130_fd_sc_hd__dfrtp_1
* cell instance sky130_fd_sc_hd__dfrtp_1_278 r0 *1 0,0
Xsky130_fd_sc_hd__dfrtp_1_278 \$2180 \$3106 \$3098
+ rst_n
+ vss
+ vdd
+ vdd
+ sky130_fd_sc_hd__dfrtp_1
* cell instance sky130_fd_sc_hd__dfrtp_1_279 r0 *1 0,0
Xsky130_fd_sc_hd__dfrtp_1_279 \$4421 \$4464 \$2813
+ rst_n
+ vss
+ vdd
+ vdd
+ sky130_fd_sc_hd__dfrtp_1
* cell instance sky130_fd_sc_hd__dfrtp_1_280 r0 *1 0,0
Xsky130_fd_sc_hd__dfrtp_1_280 \$4421 \$4885 \$4918
+ rst_n
+ vss
+ vdd
+ vdd
+ sky130_fd_sc_hd__dfrtp_1
* cell instance sky130_fd_sc_hd__dfrtp_1_281 r0 *1 0,0
Xsky130_fd_sc_hd__dfrtp_1_281 \$4421 \$4998 \$4994
+ rst_n
+ vss
+ vdd
+ vdd
+ sky130_fd_sc_hd__dfrtp_1
* cell instance sky130_fd_sc_hd__dfrtp_1_282 r0 *1 0,0
Xsky130_fd_sc_hd__dfrtp_1_282 \$59 \$259 \$460
+ rst_n
+ vss
+ vdd
+ vdd
+ sky130_fd_sc_hd__dfrtp_1
* cell instance sky130_fd_sc_hd__dfrtp_1_283 r0 *1 0,0
Xsky130_fd_sc_hd__dfrtp_1_283 \$673 \$1523 \$1330
+ rst_n
+ vss
+ vdd
+ vdd
+ sky130_fd_sc_hd__dfrtp_1
* cell instance sky130_fd_sc_hd__dfrtp_1_284 r0 *1 0,0
Xsky130_fd_sc_hd__dfrtp_1_284 \$7474 \$7866 \$7860
+ rst_n
+ vss
+ vdd
+ vdd
+ sky130_fd_sc_hd__dfrtp_1
* cell instance sky130_fd_sc_hd__dfrtp_1_285 r0 *1 0,0
Xsky130_fd_sc_hd__dfrtp_1_285 \$59 \$192 \$116
+ rst_n
+ vss
+ vdd
+ vdd
+ sky130_fd_sc_hd__dfrtp_1
* cell instance sky130_fd_sc_hd__dfrtp_1_286 r0 *1 0,0
Xsky130_fd_sc_hd__dfrtp_1_286 \$2180 \$2366 bus_rdata[3]
+ rst_n
+ vss
+ vdd
+ vdd
+ sky130_fd_sc_hd__dfrtp_1
* cell instance sky130_fd_sc_hd__dfrtp_1_287 r0 *1 0,0
Xsky130_fd_sc_hd__dfrtp_1_287 \$7474 \$7707 \$7704
+ rst_n
+ vss
+ vdd
+ vdd
+ sky130_fd_sc_hd__dfrtp_1
* cell instance sky130_fd_sc_hd__dfrtp_1_288 r0 *1 0,0
Xsky130_fd_sc_hd__dfrtp_1_288 \$4421 \$4660 \$4657
+ rst_n
+ vss
+ vdd
+ vdd
+ sky130_fd_sc_hd__dfrtp_1
* cell instance sky130_fd_sc_hd__dfrtp_1_289 r0 *1 0,0
Xsky130_fd_sc_hd__dfrtp_1_289 \$7474 \$7556 \$7465
+ rst_n
+ vss
+ vdd
+ vdd
+ sky130_fd_sc_hd__dfrtp_1
* cell instance sky130_fd_sc_hd__dfrtp_1_290 r0 *1 0,0
Xsky130_fd_sc_hd__dfrtp_1_290 \$673 \$895 \$962
+ rst_n
+ vss
+ vdd
+ vdd
+ sky130_fd_sc_hd__dfrtp_1
* cell instance sky130_fd_sc_hd__dfrtp_1_291 r0 *1 0,0
Xsky130_fd_sc_hd__dfrtp_1_291 \$673 \$1254 \$1245
+ rst_n
+ vss
+ vdd
+ vdd
+ sky130_fd_sc_hd__dfrtp_1
* cell instance sky130_fd_sc_hd__dfrtp_1_292 r0 *1 0,0
Xsky130_fd_sc_hd__dfrtp_1_292 \$59 \$263 \$50
+ rst_n
+ vss
+ vdd
+ vdd
+ sky130_fd_sc_hd__dfrtp_1
* cell instance sky130_fd_sc_hd__dfrtp_1_293 r0 *1 0,0
Xsky130_fd_sc_hd__dfrtp_1_293 \$2180 \$2619 bus_rdata[16]
+ rst_n
+ vss
+ vdd
+ vdd
+ sky130_fd_sc_hd__dfrtp_1
* cell instance sky130_fd_sc_hd__dfrtp_1_294 r0 *1 0,0
Xsky130_fd_sc_hd__dfrtp_1_294 \$673 \$672 \$663
+ rst_n
+ vss
+ vdd
+ vdd
+ sky130_fd_sc_hd__dfrtp_1
* cell instance sky130_fd_sc_hd__dfrtp_1_295 r0 *1 0,0
Xsky130_fd_sc_hd__dfrtp_1_295 \$1787 \$1786 \$1777
+ rst_n
+ vss
+ vdd
+ vdd
+ sky130_fd_sc_hd__dfrtp_1
* cell instance sky130_fd_sc_hd__dfrtp_1_296 r0 *1 0,0
Xsky130_fd_sc_hd__dfrtp_1_296 \$1787 \$1372 \$1441
+ rst_n
+ vss
+ vdd
+ vdd
+ sky130_fd_sc_hd__dfrtp_1
* cell instance sky130_fd_sc_hd__dfrtp_1_297 r0 *1 0,0
Xsky130_fd_sc_hd__dfrtp_1_297 \$3862 \$3736 \$3328
+ rst_n
+ vss
+ vdd
+ vdd
+ sky130_fd_sc_hd__dfrtp_1
* cell instance sky130_fd_sc_hd__dfrtp_1_298 r0 *1 0,0
Xsky130_fd_sc_hd__dfrtp_1_298 \$3862 \$4215 bus_rdata[1]
+ rst_n
+ vss
+ vdd
+ vdd
+ sky130_fd_sc_hd__dfrtp_1
* cell instance sky130_fd_sc_hd__dfrtp_1_299 r0 *1 0,0
Xsky130_fd_sc_hd__dfrtp_1_299 \$673 \$830 \$822
+ rst_n
+ vss
+ vdd
+ vdd
+ sky130_fd_sc_hd__dfrtp_1
* cell instance sky130_fd_sc_hd__dfrtp_1_300 r0 *1 0,0
Xsky130_fd_sc_hd__dfrtp_1_300 \$3862 \$3737 \$3413
+ rst_n
+ vss
+ vdd
+ vdd
+ sky130_fd_sc_hd__dfrtp_1
* cell instance sky130_fd_sc_hd__dfrtp_1_301 r0 *1 0,0
Xsky130_fd_sc_hd__dfrtp_1_301 \$59 \$398 \$389
+ rst_n
+ vss
+ vdd
+ vdd
+ sky130_fd_sc_hd__dfrtp_1
* cell instance sky130_fd_sc_hd__dfrtp_1_302 r0 *1 0,0
Xsky130_fd_sc_hd__dfrtp_1_302 \$1787 \$1893 \$1967
+ rst_n
+ vss
+ vdd
+ vdd
+ sky130_fd_sc_hd__dfrtp_1
* cell instance sky130_fd_sc_hd__dfrtp_1_303 r0 *1 0,0
Xsky130_fd_sc_hd__dfrtp_1_303 \$673 \$1114 \$1105
+ rst_n
+ vss
+ vdd
+ vdd
+ sky130_fd_sc_hd__dfrtp_1
* cell instance sky130_fd_sc_hd__dfrtp_1_304 r0 *1 0,0
Xsky130_fd_sc_hd__dfrtp_1_304 \$7474 \$7723 \$7714
+ rst_n
+ vss
+ vdd
+ vdd
+ sky130_fd_sc_hd__dfrtp_1
* cell instance sky130_fd_sc_hd__dfrtp_1_305 r0 *1 0,0
Xsky130_fd_sc_hd__dfrtp_1_305 \$2180 \$2374 bus_rdata[2]
+ rst_n
+ vss
+ vdd
+ vdd
+ sky130_fd_sc_hd__dfrtp_1
* cell instance sky130_fd_sc_hd__dfrtp_1_306 r0 *1 0,0
Xsky130_fd_sc_hd__dfrtp_1_306 \$4421 \$5006 \$5035
+ rst_n
+ vss
+ vdd
+ vdd
+ sky130_fd_sc_hd__dfrtp_1
* cell instance sky130_fd_sc_hd__dfrtp_1_307 r0 *1 0,0
Xsky130_fd_sc_hd__dfrtp_1_307 \$6633 \$7403 \$7249
+ rst_n
+ vss
+ vdd
+ vdd
+ sky130_fd_sc_hd__dfrtp_1
* cell instance sky130_fd_sc_hd__dfrtp_1_308 r0 *1 0,0
Xsky130_fd_sc_hd__dfrtp_1_308 \$5497 \$5487 \$2074
+ rst_n
+ vss
+ vdd
+ vdd
+ sky130_fd_sc_hd__dfrtp_1
* cell instance sky130_fd_sc_hd__dfrtp_1_309 r0 *1 0,0
Xsky130_fd_sc_hd__dfrtp_1_309 \$59 \$68 \$60
+ rst_n
+ vss
+ vdd
+ vdd
+ sky130_fd_sc_hd__dfrtp_1
* cell instance sky130_fd_sc_hd__dfrtp_1_310 r0 *1 0,0
Xsky130_fd_sc_hd__dfrtp_1_310 \$1787 \$1606 \$1603
+ rst_n
+ vss
+ vdd
+ vdd
+ sky130_fd_sc_hd__dfrtp_1
* cell instance sky130_fd_sc_hd__dfrtp_1_311 r0 *1 0,0
Xsky130_fd_sc_hd__dfrtp_1_311 \$3862 \$4673 \$4666
+ rst_n
+ vss
+ vdd
+ vdd
+ sky130_fd_sc_hd__dfrtp_1
* cell instance sky130_fd_sc_hd__dfrtp_1_312 r0 *1 0,0
Xsky130_fd_sc_hd__dfrtp_1_312 \$4421 \$5385 \$5408
+ rst_n
+ vss
+ vdd
+ vdd
+ sky130_fd_sc_hd__dfrtp_1
* cell instance sky130_fd_sc_hd__dfrtp_1_313 r0 *1 0,0
Xsky130_fd_sc_hd__dfrtp_1_313 \$7474 \$7873 \$7871
+ rst_n
+ vss
+ vdd
+ vdd
+ sky130_fd_sc_hd__dfrtp_1
* cell instance sky130_fd_sc_hd__dfrtp_1_314 r0 *1 0,0
Xsky130_fd_sc_hd__dfrtp_1_314 \$59 \$128 \$332
+ rst_n
+ vss
+ vdd
+ vdd
+ sky130_fd_sc_hd__dfrtp_1
* cell instance sky130_fd_sc_hd__dfrtp_1_315 r0 *1 0,0
Xsky130_fd_sc_hd__dfrtp_1_315 \$3417 \$3657 \$3519
+ rst_n
+ vss
+ vdd
+ vdd
+ sky130_fd_sc_hd__dfrtp_1
* cell instance sky130_fd_sc_hd__dfrtp_1_316 r0 *1 0,0
Xsky130_fd_sc_hd__dfrtp_1_316 \$6060 \$6730 \$6809
+ rst_n
+ vss
+ vdd
+ vdd
+ sky130_fd_sc_hd__dfrtp_1
* cell instance sky130_fd_sc_hd__dfrtp_1_317 r0 *1 0,0
Xsky130_fd_sc_hd__dfrtp_1_317 \$7474 \$7338 \$7475
+ rst_n
+ vss
+ vdd
+ vdd
+ sky130_fd_sc_hd__dfrtp_1
* cell instance sky130_fd_sc_hd__dfrtp_1_318 r0 *1 0,0
Xsky130_fd_sc_hd__dfrtp_1_318 \$79 \$471 \$535
+ rst_n
+ vss
+ vdd
+ vdd
+ sky130_fd_sc_hd__dfrtp_1
* cell instance sky130_fd_sc_hd__dfrtp_1_319 r0 *1 0,0
Xsky130_fd_sc_hd__dfrtp_1_319 \$1787 \$1977 \$1788
+ rst_n
+ vss
+ vdd
+ vdd
+ sky130_fd_sc_hd__dfrtp_1
* cell instance sky130_fd_sc_hd__dfrtp_1_320 r0 *1 0,0
Xsky130_fd_sc_hd__dfrtp_1_320 \$3862 \$4323 \$2191
+ rst_n
+ vss
+ vdd
+ vdd
+ sky130_fd_sc_hd__dfrtp_1
* cell instance sky130_fd_sc_hd__dfrtp_1_321 r0 *1 0,0
Xsky130_fd_sc_hd__dfrtp_1_321 \$4421 \$5140 \$5255
+ rst_n
+ vss
+ vdd
+ vdd
+ sky130_fd_sc_hd__dfrtp_1
* cell instance sky130_fd_sc_hd__dfrtp_1_322 r0 *1 0,0
Xsky130_fd_sc_hd__dfrtp_1_322 \$673 \$611 \$757
+ rst_n
+ vss
+ vdd
+ vdd
+ sky130_fd_sc_hd__dfrtp_1
* cell instance sky130_fd_sc_hd__dfrtp_1_323 r0 *1 0,0
Xsky130_fd_sc_hd__dfrtp_1_323 \$6060 \$6069 \$6063
+ rst_n
+ vss
+ vdd
+ vdd
+ sky130_fd_sc_hd__dfrtp_1
* cell instance sky130_fd_sc_hd__dfrtp_1_324 r0 *1 0,0
Xsky130_fd_sc_hd__dfrtp_1_324 \$7474 \$7570 \$4466
+ rst_n
+ vss
+ vdd
+ vdd
+ sky130_fd_sc_hd__dfrtp_1
* cell instance sky130_fd_sc_hd__dfrtp_1_325 r0 *1 0,0
Xsky130_fd_sc_hd__dfrtp_1_325 \$1787 \$2480 bus_rdata[6]
+ rst_n
+ vss
+ vdd
+ vdd
+ sky130_fd_sc_hd__dfrtp_1
* cell instance sky130_fd_sc_hd__dfrtp_1_326 r0 *1 0,0
Xsky130_fd_sc_hd__dfrtp_1_326 \$907 \$762 \$834
+ rst_n
+ vss
+ vdd
+ vdd
+ sky130_fd_sc_hd__dfrtp_1
* cell instance sky130_fd_sc_hd__dfrtp_1_327 r0 *1 0,0
Xsky130_fd_sc_hd__dfrtp_1_327 \$5497 \$6155 \$5707
+ rst_n
+ vss
+ vdd
+ vdd
+ sky130_fd_sc_hd__dfrtp_1
* cell instance sky130_fd_sc_hd__dfrtp_1_328 r0 *1 0,0
Xsky130_fd_sc_hd__dfrtp_1_328 \$6633 \$7076 \$7068
+ rst_n
+ vss
+ vdd
+ vdd
+ sky130_fd_sc_hd__dfrtp_1
* cell instance sky130_fd_sc_hd__dfrtp_1_329 r0 *1 0,0
Xsky130_fd_sc_hd__dfrtp_1_329 \$7474 \$7790 \$7785
+ rst_n
+ vss
+ vdd
+ vdd
+ sky130_fd_sc_hd__dfrtp_1
* cell instance sky130_fd_sc_hd__dfrtp_1_330 r0 *1 0,0
Xsky130_fd_sc_hd__dfrtp_1_330 \$907 \$1190 \$972
+ rst_n
+ vss
+ vdd
+ vdd
+ sky130_fd_sc_hd__dfrtp_1
* cell instance sky130_fd_sc_hd__dfrtp_1_331 r0 *1 0,0
Xsky130_fd_sc_hd__dfrtp_1_331 \$3862 \$4776 bus_rdata[5]
+ rst_n
+ vss
+ vdd
+ vdd
+ sky130_fd_sc_hd__dfrtp_1
* cell instance sky130_fd_sc_hd__dfrtp_1_332 r0 *1 0,0
Xsky130_fd_sc_hd__dfrtp_1_332 \$6060 \$6550 \$5924
+ rst_n
+ vss
+ vdd
+ vdd
+ sky130_fd_sc_hd__dfrtp_1
* cell instance sky130_fd_sc_hd__dfrtp_1_333 r0 *1 0,0
Xsky130_fd_sc_hd__dfrtp_1_333 \$6060 \$6466 \$6458
+ rst_n
+ vss
+ vdd
+ vdd
+ sky130_fd_sc_hd__dfrtp_1
* cell instance sky130_fd_sc_hd__dfrtp_1_334 r0 *1 0,0
Xsky130_fd_sc_hd__dfrtp_1_334 \$3862 \$4108 bus_rdata[13]
+ rst_n
+ vss
+ vdd
+ vdd
+ sky130_fd_sc_hd__dfrtp_1
* cell instance sky130_fd_sc_hd__dfrtp_1_335 r0 *1 0,0
Xsky130_fd_sc_hd__dfrtp_1_335 \$907 \$909 \$899
+ rst_n
+ vss
+ vdd
+ vdd
+ sky130_fd_sc_hd__dfrtp_1
* cell instance sky130_fd_sc_hd__dfrtp_1_336 r0 *1 0,0
Xsky130_fd_sc_hd__dfrtp_1_336 \$907 \$1348 \$1373
+ rst_n
+ vss
+ vdd
+ vdd
+ sky130_fd_sc_hd__dfrtp_1
* cell instance sky130_fd_sc_hd__dfrtp_1_337 r0 *1 0,0
Xsky130_fd_sc_hd__dfrtp_1_337 \$1698 \$1981 \$1896
+ rst_n
+ vss
+ vdd
+ vdd
+ sky130_fd_sc_hd__dfrtp_1
* cell instance sky130_fd_sc_hd__dfrtp_1_338 r0 *1 0,0
Xsky130_fd_sc_hd__dfrtp_1_338 \$79 \$403 \$473
+ rst_n
+ vss
+ vdd
+ vdd
+ sky130_fd_sc_hd__dfrtp_1
* cell instance sky130_fd_sc_hd__dfrtp_1_339 r0 *1 0,0
Xsky130_fd_sc_hd__dfrtp_1_339 \$907 \$1453 \$1529
+ rst_n
+ vss
+ vdd
+ vdd
+ sky130_fd_sc_hd__dfrtp_1
* cell instance sky130_fd_sc_hd__dfrtp_1_340 r0 *1 0,0
Xsky130_fd_sc_hd__dfrtp_1_340 \$79 \$198 \$196
+ rst_n
+ vss
+ vdd
+ vdd
+ sky130_fd_sc_hd__dfrtp_1
* cell instance sky130_fd_sc_hd__dfrtp_1_341 r0 *1 0,0
Xsky130_fd_sc_hd__dfrtp_1_341 \$89 \$685 \$760
+ rst_n
+ vss
+ vdd
+ vdd
+ sky130_fd_sc_hd__dfrtp_1
* cell instance sky130_fd_sc_hd__dfrtp_1_342 r0 *1 0,0
Xsky130_fd_sc_hd__dfrtp_1_342 \$79 \$202 \$268
+ rst_n
+ vss
+ vdd
+ vdd
+ sky130_fd_sc_hd__dfrtp_1
* cell instance sky130_fd_sc_hd__dfrtp_1_343 r0 *1 0,0
Xsky130_fd_sc_hd__dfrtp_1_343 \$1698 \$1697 \$1718
+ rst_n
+ vss
+ vdd
+ vdd
+ sky130_fd_sc_hd__dfrtp_1
* cell instance sky130_fd_sc_hd__dfrtp_1_344 r0 *1 0,0
Xsky130_fd_sc_hd__dfrtp_1_344 \$7655 \$7887 \$7882
+ rst_n
+ vss
+ vdd
+ vdd
+ sky130_fd_sc_hd__dfrtp_1
* cell instance sky130_fd_sc_hd__dfrtp_1_345 r0 *1 0,0
Xsky130_fd_sc_hd__dfrtp_1_345 \$5497 \$5391 \$5817
+ rst_n
+ vss
+ vdd
+ vdd
+ sky130_fd_sc_hd__dfrtp_1
* cell instance sky130_fd_sc_hd__dfrtp_1_346 r0 *1 0,0
Xsky130_fd_sc_hd__dfrtp_1_346 \$4685 \$5148 \$4920
+ rst_n
+ vss
+ vdd
+ vdd
+ sky130_fd_sc_hd__dfrtp_1
* cell instance sky130_fd_sc_hd__dfrtp_1_347 r0 *1 0,0
Xsky130_fd_sc_hd__dfrtp_1_347 \$3417 \$3634 bus_rdata[4]
+ rst_n
+ vss
+ vdd
+ vdd
+ sky130_fd_sc_hd__dfrtp_1
* cell instance sky130_fd_sc_hd__dfrtp_1_348 r0 *1 0,0
Xsky130_fd_sc_hd__dfrtp_1_348 \$907 \$1040 \$1038
+ rst_n
+ vss
+ vdd
+ vdd
+ sky130_fd_sc_hd__dfrtp_1
* cell instance sky130_fd_sc_hd__dfrtp_1_349 r0 *1 0,0
Xsky130_fd_sc_hd__dfrtp_1_349 \$1698 \$2485 \$2376
+ rst_n
+ vss
+ vdd
+ vdd
+ sky130_fd_sc_hd__dfrtp_1
* cell instance sky130_fd_sc_hd__dfrtp_1_350 r0 *1 0,0
Xsky130_fd_sc_hd__dfrtp_1_350 \$2491 \$2597 bus_rdata[20]
+ rst_n
+ vss
+ vdd
+ vdd
+ sky130_fd_sc_hd__dfrtp_1
* cell instance sky130_fd_sc_hd__dfrtp_1_351 r0 *1 0,0
Xsky130_fd_sc_hd__dfrtp_1_351 \$3877 \$4347 \$4324
+ rst_n
+ vss
+ vdd
+ vdd
+ sky130_fd_sc_hd__dfrtp_1
* cell instance sky130_fd_sc_hd__dfrtp_1_352 r0 *1 0,0
Xsky130_fd_sc_hd__dfrtp_1_352 \$5497 \$5494 \$5518
+ rst_n
+ vss
+ vdd
+ vdd
+ sky130_fd_sc_hd__dfrtp_1
* cell instance sky130_fd_sc_hd__dfrtp_1_353 r0 *1 0,0
Xsky130_fd_sc_hd__dfrtp_1_353 \$5497 \$5935 \$5926
+ rst_n
+ vss
+ vdd
+ vdd
+ sky130_fd_sc_hd__dfrtp_1
* cell instance sky130_fd_sc_hd__dfrtp_1_354 r0 *1 0,0
Xsky130_fd_sc_hd__dfrtp_1_354 \$6996 \$7575 \$7258
+ rst_n
+ vss
+ vdd
+ vdd
+ sky130_fd_sc_hd__dfrtp_1
* cell instance sky130_fd_sc_hd__dfrtp_1_355 r0 *1 0,0
Xsky130_fd_sc_hd__dfrtp_1_355 \$6260 \$6158 \$6251
+ rst_n
+ vss
+ vdd
+ vdd
+ sky130_fd_sc_hd__dfrtp_1
* cell instance sky130_fd_sc_hd__dfrtp_1_356 r0 *1 0,0
Xsky130_fd_sc_hd__dfrtp_1_356 \$6260 \$6735 \$6894
+ rst_n
+ vss
+ vdd
+ vdd
+ sky130_fd_sc_hd__dfrtp_1
* cell instance sky130_fd_sc_hd__dfrtp_1_357 r0 *1 0,0
Xsky130_fd_sc_hd__dfrtp_1_357 \$6260 \$6562 \$6553
+ rst_n
+ vss
+ vdd
+ vdd
+ sky130_fd_sc_hd__dfrtp_1
* cell instance sky130_fd_sc_hd__dfrtp_1_358 r0 *1 0,0
Xsky130_fd_sc_hd__dfrtp_1_358 \$7655 \$7729 \$7992
+ rst_n
+ vss
+ vdd
+ vdd
+ sky130_fd_sc_hd__dfrtp_1
* cell instance sky130_fd_sc_hd__dfrtp_1_359 r0 *1 0,0
Xsky130_fd_sc_hd__dfrtp_1_359 \$6996 \$6823 \$6731
+ rst_n
+ vss
+ vdd
+ vdd
+ sky130_fd_sc_hd__dfrtp_1
* cell instance sky130_fd_sc_hd__dfrtp_1_360 r0 *1 0,0
Xsky130_fd_sc_hd__dfrtp_1_360 \$7655 \$7492 \$7484
+ rst_n
+ vss
+ vdd
+ vdd
+ sky130_fd_sc_hd__dfrtp_1
* cell instance sky130_fd_sc_hd__dfrtp_1_361 r0 *1 0,0
Xsky130_fd_sc_hd__dfrtp_1_361 \$6996 \$7344 \$7404
+ rst_n
+ vss
+ vdd
+ vdd
+ sky130_fd_sc_hd__dfrtp_1
* cell instance sky130_fd_sc_hd__dfrtp_1_362 r0 *1 0,0
Xsky130_fd_sc_hd__dfrtp_1_362 \$4685 \$4684 \$4676
+ rst_n
+ vss
+ vdd
+ vdd
+ sky130_fd_sc_hd__dfrtp_1
* cell instance sky130_fd_sc_hd__dfrtp_1_363 r0 *1 0,0
Xsky130_fd_sc_hd__dfrtp_1_363 \$851 \$690 \$840
+ rst_n
+ vss
+ vdd
+ vdd
+ sky130_fd_sc_hd__dfrtp_1
* cell instance sky130_fd_sc_hd__dfrtp_1_364 r0 *1 0,0
Xsky130_fd_sc_hd__dfrtp_1_364 \$4685 \$4783 \$2917
+ rst_n
+ vss
+ vdd
+ vdd
+ sky130_fd_sc_hd__dfrtp_1
* cell instance sky130_fd_sc_hd__dfrtp_1_365 r0 *1 0,0
Xsky130_fd_sc_hd__dfrtp_1_365 \$3877 \$4119 bus_rdata[12]
+ rst_n
+ vss
+ vdd
+ vdd
+ sky130_fd_sc_hd__dfrtp_1
* cell instance sky130_fd_sc_hd__dfrtp_1_366 r0 *1 0,0
Xsky130_fd_sc_hd__dfrtp_1_366 \$907 \$1619 \$1611
+ rst_n
+ vss
+ vdd
+ vdd
+ sky130_fd_sc_hd__dfrtp_1
* cell instance sky130_fd_sc_hd__dfrtp_1_367 r0 *1 0,0
Xsky130_fd_sc_hd__dfrtp_1_367 \$79 \$273 \$70
+ rst_n
+ vss
+ vdd
+ vdd
+ sky130_fd_sc_hd__dfrtp_1
* cell instance sky130_fd_sc_hd__dfrtp_1_368 r0 *1 0,0
Xsky130_fd_sc_hd__dfrtp_1_368 \$907 \$1455 \$1349
+ rst_n
+ vss
+ vdd
+ vdd
+ sky130_fd_sc_hd__dfrtp_1
* cell instance sky130_fd_sc_hd__dfrtp_1_369 r0 *1 0,0
Xsky130_fd_sc_hd__dfrtp_1_369 \$1698 \$2093 bus_rdata[30]
+ rst_n
+ vss
+ vdd
+ vdd
+ sky130_fd_sc_hd__dfrtp_1
* cell instance sky130_fd_sc_hd__dfrtp_1_370 r0 *1 0,0
Xsky130_fd_sc_hd__dfrtp_1_370 \$3417 \$3541 bus_rdata[22]
+ rst_n
+ vss
+ vdd
+ vdd
+ sky130_fd_sc_hd__dfrtp_1
* cell instance sky130_fd_sc_hd__dfrtp_1_371 r0 *1 0,0
Xsky130_fd_sc_hd__dfrtp_1_371 \$3877 \$3876 bus_rdata[28]
+ rst_n
+ vss
+ vdd
+ vdd
+ sky130_fd_sc_hd__dfrtp_1
* cell instance sky130_fd_sc_hd__dfrtp_1_372 r0 *1 0,0
Xsky130_fd_sc_hd__dfrtp_1_372 \$3877 \$4562 bus_rdata[27]
+ rst_n
+ vss
+ vdd
+ vdd
+ sky130_fd_sc_hd__dfrtp_1
* cell instance sky130_fd_sc_hd__dfrtp_1_373 r0 *1 0,0
Xsky130_fd_sc_hd__dfrtp_1_373 \$79 \$138 \$129
+ rst_n
+ vss
+ vdd
+ vdd
+ sky130_fd_sc_hd__dfrtp_1
* cell instance sky130_fd_sc_hd__dfrtp_1_374 r0 *1 0,0
Xsky130_fd_sc_hd__dfrtp_1_374 \$6260 \$6355 \$6089
+ rst_n
+ vss
+ vdd
+ vdd
+ sky130_fd_sc_hd__dfrtp_1
* cell instance sky130_fd_sc_hd__dfrtp_1_375 r0 *1 0,0
Xsky130_fd_sc_hd__dfrtp_1_375 \$851 \$990 \$981
+ rst_n
+ vss
+ vdd
+ vdd
+ sky130_fd_sc_hd__dfrtp_1
* cell instance sky130_fd_sc_hd__dfrtp_1_376 r0 *1 0,0
Xsky130_fd_sc_hd__dfrtp_1_376 \$79 \$413 \$405
+ rst_n
+ vss
+ vdd
+ vdd
+ sky130_fd_sc_hd__dfrtp_1
* cell instance sky130_fd_sc_hd__dfrtp_1_377 r0 *1 0,0
Xsky130_fd_sc_hd__dfrtp_1_377 \$6996 \$7089 \$7081
+ rst_n
+ vss
+ vdd
+ vdd
+ sky130_fd_sc_hd__dfrtp_1
* cell instance sky130_fd_sc_hd__dfrtp_1_378 r0 *1 0,0
Xsky130_fd_sc_hd__dfrtp_1_378 \$7655 \$7738 \$7730
+ rst_n
+ vss
+ vdd
+ vdd
+ sky130_fd_sc_hd__dfrtp_1
* cell instance sky130_fd_sc_hd__dfrtp_1_379 r0 *1 0,0
Xsky130_fd_sc_hd__dfrtp_1_379 \$851 \$1269 \$842
+ rst_n
+ vss
+ vdd
+ vdd
+ sky130_fd_sc_hd__dfrtp_1
* cell instance sky130_fd_sc_hd__dfrtp_1_380 r0 *1 0,0
Xsky130_fd_sc_hd__dfrtp_1_380 \$2491 \$2705 \$2818
+ rst_n
+ vss
+ vdd
+ vdd
+ sky130_fd_sc_hd__dfrtp_1
* cell instance sky130_fd_sc_hd__dfrtp_1_381 r0 *1 0,0
Xsky130_fd_sc_hd__dfrtp_1_381 \$1698 \$2385 \$1799
+ rst_n
+ vss
+ vdd
+ vdd
+ sky130_fd_sc_hd__dfrtp_1
* cell instance sky130_fd_sc_hd__dfrtp_1_382 r0 *1 0,0
Xsky130_fd_sc_hd__dfrtp_1_382 \$2491 \$2622 \$2598
+ rst_n
+ vss
+ vdd
+ vdd
+ sky130_fd_sc_hd__dfrtp_1
* cell instance sky130_fd_sc_hd__dfrtp_1_383 r0 *1 0,0
Xsky130_fd_sc_hd__dfrtp_1_383 \$3417 \$3427 bus_rdata[8]
+ rst_n
+ vss
+ vdd
+ vdd
+ sky130_fd_sc_hd__dfrtp_1
* cell instance sky130_fd_sc_hd__dfrtp_1_384 r0 *1 0,0
Xsky130_fd_sc_hd__dfrtp_1_384 \$4685 \$5729 \$5610
+ rst_n
+ vss
+ vdd
+ vdd
+ sky130_fd_sc_hd__dfrtp_1
* cell instance sky130_fd_sc_hd__dfrtp_1_385 r0 *1 0,0
Xsky130_fd_sc_hd__dfrtp_1_385 \$1698 \$2198 \$1983
+ rst_n
+ vss
+ vdd
+ vdd
+ sky130_fd_sc_hd__dfrtp_1
* cell instance sky130_fd_sc_hd__dfrtp_1_386 r0 *1 0,0
Xsky130_fd_sc_hd__dfrtp_1_386 \$4685 \$5506 \$5519
+ rst_n
+ vss
+ vdd
+ vdd
+ sky130_fd_sc_hd__dfrtp_1
* cell instance sky130_fd_sc_hd__dfrtp_1_387 r0 *1 0,0
Xsky130_fd_sc_hd__dfrtp_1_387 \$89 \$700 \$691
+ rst_n
+ vss
+ vdd
+ vdd
+ sky130_fd_sc_hd__dfrtp_1
* cell instance sky130_fd_sc_hd__dfrtp_1_388 r0 *1 0,0
Xsky130_fd_sc_hd__dfrtp_1_388 \$4685 \$4793 \$4784
+ rst_n
+ vss
+ vdd
+ vdd
+ sky130_fd_sc_hd__dfrtp_1
* cell instance sky130_fd_sc_hd__dfrtp_1_389 r0 *1 0,0
Xsky130_fd_sc_hd__dfrtp_1_389 \$89 \$204 \$139
+ rst_n
+ vss
+ vdd
+ vdd
+ sky130_fd_sc_hd__dfrtp_1
* cell instance sky130_fd_sc_hd__dfrtp_1_390 r0 *1 0,0
Xsky130_fd_sc_hd__dfrtp_1_390 \$851 \$1539 \$1357
+ rst_n
+ vss
+ vdd
+ vdd
+ sky130_fd_sc_hd__dfrtp_1
* cell instance sky130_fd_sc_hd__dfrtp_1_391 r0 *1 0,0
Xsky130_fd_sc_hd__dfrtp_1_391 \$7655 \$7497 \$3639
+ rst_n
+ vss
+ vdd
+ vdd
+ sky130_fd_sc_hd__dfrtp_1
* cell instance sky130_fd_sc_hd__dfrtp_1_392 r0 *1 0,0
Xsky130_fd_sc_hd__dfrtp_1_392 \$3877 \$4232 bus_rdata[31]
+ rst_n
+ vss
+ vdd
+ vdd
+ sky130_fd_sc_hd__dfrtp_1
* cell instance sky130_fd_sc_hd__dfrtp_1_393 r0 *1 0,0
Xsky130_fd_sc_hd__dfrtp_1_393 \$3877 \$3981 bus_rdata[0]
+ rst_n
+ vss
+ vdd
+ vdd
+ sky130_fd_sc_hd__dfrtp_1
* cell instance sky130_fd_sc_hd__dfrtp_1_394 r0 *1 0,0
Xsky130_fd_sc_hd__dfrtp_1_394 \$6260 \$6667 \$6736
+ rst_n
+ vss
+ vdd
+ vdd
+ sky130_fd_sc_hd__dfrtp_1
* cell instance sky130_fd_sc_hd__dfrtp_1_395 r0 *1 0,0
Xsky130_fd_sc_hd__dfrtp_1_395 \$6996 \$7007 \$6998
+ rst_n
+ vss
+ vdd
+ vdd
+ sky130_fd_sc_hd__dfrtp_1
* cell instance sky130_fd_sc_hd__dfrtp_1_396 r0 *1 0,0
Xsky130_fd_sc_hd__dfrtp_1_396 \$6996 \$7190 \$7345
+ rst_n
+ vss
+ vdd
+ vdd
+ sky130_fd_sc_hd__dfrtp_1
* cell instance sky130_fd_sc_hd__dfrtp_1_397 r0 *1 0,0
Xsky130_fd_sc_hd__dfrtp_1_397 \$3417 \$3758 bus_rdata[10]
+ rst_n
+ vss
+ vdd
+ vdd
+ sky130_fd_sc_hd__dfrtp_1
* cell instance sky130_fd_sc_hd__dfrtp_1_398 r0 *1 0,0
Xsky130_fd_sc_hd__dfrtp_1_398 \$3877 \$4334 bus_rdata[24]
+ rst_n
+ vss
+ vdd
+ vdd
+ sky130_fd_sc_hd__dfrtp_1
* cell instance sky130_fd_sc_hd__dfrtp_1_399 r0 *1 0,0
Xsky130_fd_sc_hd__dfrtp_1_399 \$4685 \$5015 \$5268
+ rst_n
+ vss
+ vdd
+ vdd
+ sky130_fd_sc_hd__dfrtp_1
* cell instance sky130_fd_sc_hd__dfrtp_1_400 r0 *1 0,0
Xsky130_fd_sc_hd__dfrtp_1_400 \$5497 \$6270 \$6159
+ rst_n
+ vss
+ vdd
+ vdd
+ sky130_fd_sc_hd__dfrtp_1
* cell instance sky130_fd_sc_hd__dfrtp_1_401 r0 *1 0,0
Xsky130_fd_sc_hd__dfrtp_1_401 \$6260 \$6912 \$5829
+ rst_n
+ vss
+ vdd
+ vdd
+ sky130_fd_sc_hd__dfrtp_1
* cell instance sky130_fd_sc_hd__dfrtp_1_402 r0 *1 0,0
Xsky130_fd_sc_hd__dfrtp_1_402 \$7655 \$7902 \$7805
+ rst_n
+ vss
+ vdd
+ vdd
+ sky130_fd_sc_hd__dfrtp_1
* cell instance sky130_fd_sc_hd__dfrtp_1_403 r0 *1 0,0
Xsky130_fd_sc_hd__dfrtp_1_403 \$89 \$209 \$80
+ rst_n
+ vss
+ vdd
+ vdd
+ sky130_fd_sc_hd__dfrtp_1
* cell instance sky130_fd_sc_hd__dfrtp_1_404 r0 *1 0,0
Xsky130_fd_sc_hd__dfrtp_1_404 \$7655 \$7903 \$7896
+ rst_n
+ vss
+ vdd
+ vdd
+ sky130_fd_sc_hd__dfrtp_1
* cell instance sky130_fd_sc_hd__dfrtp_1_405 r0 *1 0,0
Xsky130_fd_sc_hd__dfrtp_1_405 \$6260 \$6366 \$6357
+ rst_n
+ vss
+ vdd
+ vdd
+ sky130_fd_sc_hd__dfrtp_1
* cell instance sky130_fd_sc_hd__dfrtp_1_406 r0 *1 0,0
Xsky130_fd_sc_hd__dfrtp_1_406 \$89 \$356 \$352
+ rst_n
+ vss
+ vdd
+ vdd
+ sky130_fd_sc_hd__dfrtp_1
* cell instance sky130_fd_sc_hd__dfrtp_1_407 r0 *1 0,0
Xsky130_fd_sc_hd__dfrtp_1_407 \$89 \$491 \$549
+ rst_n
+ vss
+ vdd
+ vdd
+ sky130_fd_sc_hd__dfrtp_1
* cell instance sky130_fd_sc_hd__dfrtp_1_408 r0 *1 0,0
Xsky130_fd_sc_hd__dfrtp_1_408 \$851 \$925 \$852
+ rst_n
+ vss
+ vdd
+ vdd
+ sky130_fd_sc_hd__dfrtp_1
* cell instance sky130_fd_sc_hd__dfrtp_1_409 r0 *1 0,0
Xsky130_fd_sc_hd__dfrtp_1_409 \$851 \$777 \$1046
+ rst_n
+ vss
+ vdd
+ vdd
+ sky130_fd_sc_hd__dfrtp_1
* cell instance sky130_fd_sc_hd__dfrtp_1_410 r0 *1 0,0
Xsky130_fd_sc_hd__dfrtp_1_410 \$851 \$1129 \$992
+ rst_n
+ vss
+ vdd
+ vdd
+ sky130_fd_sc_hd__dfrtp_1
* cell instance sky130_fd_sc_hd__dfrtp_1_411 r0 *1 0,0
Xsky130_fd_sc_hd__dfrtp_1_411 \$1282 \$1123 \$1272
+ rst_n
+ vss
+ vdd
+ vdd
+ sky130_fd_sc_hd__dfrtp_1
* cell instance sky130_fd_sc_hd__dfrtp_1_412 r0 *1 0,0
Xsky130_fd_sc_hd__dfrtp_1_412 \$1282 \$1629 \$1457
+ rst_n
+ vss
+ vdd
+ vdd
+ sky130_fd_sc_hd__dfrtp_1
* cell instance sky130_fd_sc_hd__dfrtp_1_413 r0 *1 0,0
Xsky130_fd_sc_hd__dfrtp_1_413 \$2491 \$2393 bus_rdata[19]
+ rst_n
+ vss
+ vdd
+ vdd
+ sky130_fd_sc_hd__dfrtp_1
* cell instance sky130_fd_sc_hd__dfrtp_1_414 r0 *1 0,0
Xsky130_fd_sc_hd__dfrtp_1_414 \$2491 \$2607 bus_rdata[25]
+ rst_n
+ vss
+ vdd
+ vdd
+ sky130_fd_sc_hd__dfrtp_1
* cell instance sky130_fd_sc_hd__dfrtp_1_415 r0 *1 0,0
Xsky130_fd_sc_hd__dfrtp_1_415 \$2491 \$2836 bus_rdata[11]
+ rst_n
+ vss
+ vdd
+ vdd
+ sky130_fd_sc_hd__dfrtp_1
* cell instance sky130_fd_sc_hd__dfrtp_1_416 r0 *1 0,0
Xsky130_fd_sc_hd__dfrtp_1_416 \$2491 \$3024 \$3266
+ rst_n
+ vss
+ vdd
+ vdd
+ sky130_fd_sc_hd__dfrtp_1
* cell instance sky130_fd_sc_hd__dfrtp_1_417 r0 *1 0,0
Xsky130_fd_sc_hd__dfrtp_1_417 \$3417 \$3429 bus_rdata[26]
+ rst_n
+ vss
+ vdd
+ vdd
+ sky130_fd_sc_hd__dfrtp_1
* cell instance sky130_fd_sc_hd__dfrtp_1_418 r0 *1 0,0
Xsky130_fd_sc_hd__dfrtp_1_418 \$3877 \$5269 bus_rdata[29]
+ rst_n
+ vss
+ vdd
+ vdd
+ sky130_fd_sc_hd__dfrtp_1
* cell instance sky130_fd_sc_hd__dfrtp_1_419 r0 *1 0,0
Xsky130_fd_sc_hd__dfrtp_1_419 \$6996 \$7586 \$3880
+ rst_n
+ vss
+ vdd
+ vdd
+ sky130_fd_sc_hd__dfrtp_1
* cell instance sky130_fd_sc_hd__dfrtp_1_420 r0 *1 0,0
Xsky130_fd_sc_hd__dfrtp_1_420 \$1698 \$1711 \$1703
+ rst_n
+ vss
+ vdd
+ vdd
+ sky130_fd_sc_hd__dfrtp_1
* cell instance sky130_fd_sc_hd__dfrtp_1_421 r0 *1 0,0
Xsky130_fd_sc_hd__dfrtp_1_421 \$6260 \$6668 \$6569
+ rst_n
+ vss
+ vdd
+ vdd
+ sky130_fd_sc_hd__dfrtp_1
* cell instance sky130_fd_sc_hd__dfrtp_1_422 r0 *1 0,0
Xsky130_fd_sc_hd__dfrtp_1_422 \$6996 \$7421 \$7272
+ rst_n
+ vss
+ vdd
+ vdd
+ sky130_fd_sc_hd__dfrtp_1
* cell instance sky130_fd_sc_hd__dfrtp_1_423 r0 *1 0,0
Xsky130_fd_sc_hd__dfrtp_1_423 \$7655 \$7745 \$7580
+ rst_n
+ vss
+ vdd
+ vdd
+ sky130_fd_sc_hd__dfrtp_1
* cell instance sky130_fd_sc_hd__dfstp_1_0 r0 *1 0,0
Xsky130_fd_sc_hd__dfstp_1_0 \$6922 \$7009 \$7100
+ rst_n
+ vss
+ vdd
+ vdd
+ sky130_fd_sc_hd__dfstp_1
* cell instance sky130_fd_sc_hd__dfstp_1_1 r0 *1 0,0
Xsky130_fd_sc_hd__dfstp_1_1 \$5428 \$5876 \$5661
+ rst_n
+ vss
+ vdd
+ vdd
+ sky130_fd_sc_hd__dfstp_1
* cell instance sky130_fd_sc_hd__dfstp_1_2 r0 *1 0,0
Xsky130_fd_sc_hd__dfstp_1_2 \$6207 \$6300 \$6116
+ rst_n
+ vss
+ vdd
+ vdd
+ sky130_fd_sc_hd__dfstp_1
* cell instance sky130_fd_sc_hd__dfstp_1_3 r0 *1 0,0
Xsky130_fd_sc_hd__dfstp_1_3 \$6922 \$7596 \$7510
+ rst_n
+ vss
+ vdd
+ vdd
+ sky130_fd_sc_hd__dfstp_1
* cell instance sky130_fd_sc_hd__dfstp_1_4 r0 *1 0,0
Xsky130_fd_sc_hd__dfstp_1_4 \$6850 \$6766 \$6841
+ rst_n
+ vss
+ vdd
+ vdd
+ sky130_fd_sc_hd__dfstp_1
* cell instance sky130_fd_sc_hd__dfstp_1_5 r0 *1 0,0
Xsky130_fd_sc_hd__dfstp_1_5 \$6850 \$6769 \$5882
+ rst_n
+ vss
+ vdd
+ vdd
+ sky130_fd_sc_hd__dfstp_1
* cell instance sky130_fd_sc_hd__dfstp_1_6 r0 *1 0,0
Xsky130_fd_sc_hd__dfstp_1_6 \$7441 \$7523 \$7367
+ rst_n
+ vss
+ vdd
+ vdd
+ sky130_fd_sc_hd__dfstp_1
* cell instance sky130_fd_sc_hd__dfstp_1_7 r0 *1 0,0
Xsky130_fd_sc_hd__dfstp_1_7 \$5099 \$5570 \$5406
+ rst_n
+ vss
+ vdd
+ vdd
+ sky130_fd_sc_hd__dfstp_1
* cell instance sky130_fd_sc_hd__dfstp_1_8 r0 *1 0,0
Xsky130_fd_sc_hd__dfstp_1_8 \$7441 \$7439 \$7369
+ rst_n
+ vss
+ vdd
+ vdd
+ sky130_fd_sc_hd__dfstp_1
* cell instance sky130_fd_sc_hd__dfstp_1_9 r0 *1 0,0
Xsky130_fd_sc_hd__dfstp_1_9 \$5099 \$5891 \$5953
+ rst_n
+ vss
+ vdd
+ vdd
+ sky130_fd_sc_hd__dfstp_1
* cell instance sky130_fd_sc_hd__dfstp_1_10 r0 *1 0,0
Xsky130_fd_sc_hd__dfstp_1_10 \$6863 \$7218 \$6604
+ rst_n
+ vss
+ vdd
+ vdd
+ sky130_fd_sc_hd__dfstp_1
* cell instance sky130_fd_sc_hd__dfstp_1_11 r0 *1 0,0
Xsky130_fd_sc_hd__dfstp_1_11 \$7441 \$7615 \$7525
+ rst_n
+ vss
+ vdd
+ vdd
+ sky130_fd_sc_hd__dfstp_1
* cell instance sky130_fd_sc_hd__dfstp_1_12 r0 *1 0,0
Xsky130_fd_sc_hd__dfstp_1_12 \$6863 \$6703 \$6608
+ rst_n
+ vss
+ vdd
+ vdd
+ sky130_fd_sc_hd__dfstp_1
* cell instance sky130_fd_sc_hd__dfstp_1_13 r0 *1 0,0
Xsky130_fd_sc_hd__dfstp_1_13 \$7441 \$7384 \$7308
+ rst_n
+ vss
+ vdd
+ vdd
+ sky130_fd_sc_hd__dfstp_1
* cell instance sky130_fd_sc_hd__dfstp_1_14 r0 *1 0,0
Xsky130_fd_sc_hd__dfstp_1_14 \$7626 \$7624 \$7532
+ rst_n
+ vss
+ vdd
+ vdd
+ sky130_fd_sc_hd__dfstp_1
* cell instance sky130_fd_sc_hd__dfstp_1_15 r0 *1 0,0
Xsky130_fd_sc_hd__dfstp_1_15 \$6431 \$6618 \$6613
+ rst_n
+ vss
+ vdd
+ vdd
+ sky130_fd_sc_hd__dfstp_1
* cell instance sky130_fd_sc_hd__dfstp_1_16 r0 *1 0,0
Xsky130_fd_sc_hd__dfstp_1_16 \$6714 \$6964 \$7040
+ rst_n
+ vss
+ vdd
+ vdd
+ sky130_fd_sc_hd__dfstp_1
* cell instance sky130_fd_sc_hd__dfstp_1_17 r0 *1 0,0
Xsky130_fd_sc_hd__dfstp_1_17 \$6714 \$7456 \$7222
+ rst_n
+ vss
+ vdd
+ vdd
+ sky130_fd_sc_hd__dfstp_1
* cell instance sky130_fd_sc_hd__dfstp_1_18 r0 *1 0,0
Xsky130_fd_sc_hd__dfstp_1_18 \$6714 \$6797 \$4213
+ rst_n
+ vss
+ vdd
+ vdd
+ sky130_fd_sc_hd__dfstp_1
* cell instance sky130_fd_sc_hd__dfstp_1_19 r0 *1 0,0
Xsky130_fd_sc_hd__dfstp_1_19 \$5248 \$5515 \$4541
+ rst_n
+ vss
+ vdd
+ vdd
+ sky130_fd_sc_hd__dfstp_1
* cell instance sky130_fd_sc_hd__dfstp_1_20 r0 *1 0,0
Xsky130_fd_sc_hd__dfstp_1_20 \$7626 \$7696 \$7538
+ rst_n
+ vss
+ vdd
+ vdd
+ sky130_fd_sc_hd__dfstp_1
* cell instance sky130_fd_sc_hd__dfstp_1_21 r0 *1 0,0
Xsky130_fd_sc_hd__dfstp_1_21 \$5248 \$5623 \$5149
+ rst_n
+ vss
+ vdd
+ vdd
+ sky130_fd_sc_hd__dfstp_1
* cell instance sky130_fd_sc_hd__dfstp_1_22 r0 *1 0,0
Xsky130_fd_sc_hd__dfstp_1_22 \$5248 \$5805 \$5582
+ rst_n
+ vss
+ vdd
+ vdd
+ sky130_fd_sc_hd__dfstp_1
* cell instance sky130_fd_sc_hd__dfstp_1_23 r0 *1 0,0
Xsky130_fd_sc_hd__dfstp_1_23 \$6714 \$6334 \$6332
+ rst_n
+ vss
+ vdd
+ vdd
+ sky130_fd_sc_hd__dfstp_1
* cell instance sky130_fd_sc_hd__dfstp_1_24 r0 *1 0,0
Xsky130_fd_sc_hd__dfstp_1_24 \$5248 \$6050 \$6087
+ rst_n
+ vss
+ vdd
+ vdd
+ sky130_fd_sc_hd__dfstp_1
* cell instance sky130_fd_sc_hd__dfstp_1_25 r0 *1 0,0
Xsky130_fd_sc_hd__dfstp_1_25 \$6633 \$7329 \$6721
+ rst_n
+ vss
+ vdd
+ vdd
+ sky130_fd_sc_hd__dfstp_1
* cell instance sky130_fd_sc_hd__dfstp_1_26 r0 *1 0,0
Xsky130_fd_sc_hd__dfstp_1_26 \$4421 \$5594 \$4777
+ rst_n
+ vss
+ vdd
+ vdd
+ sky130_fd_sc_hd__dfstp_1
* cell instance sky130_fd_sc_hd__dfstp_1_27 r0 *1 0,0
Xsky130_fd_sc_hd__dfstp_1_27 \$6060 \$6152 \$5703
+ rst_n
+ vss
+ vdd
+ vdd
+ sky130_fd_sc_hd__dfstp_1
* cell instance sky130_fd_sc_hd__dfstp_1_28 r0 *1 0,0
Xsky130_fd_sc_hd__dfstp_1_28 \$6633 \$7164 \$6975
+ rst_n
+ vss
+ vdd
+ vdd
+ sky130_fd_sc_hd__dfstp_1
* cell instance sky130_fd_sc_hd__dfstp_1_29 r0 *1 0,0
Xsky130_fd_sc_hd__dfstp_1_29 \$6633 \$6888 \$4221
+ rst_n
+ vss
+ vdd
+ vdd
+ sky130_fd_sc_hd__dfstp_1
* cell instance sky130_fd_sc_hd__dfstp_1_30 r0 *1 0,0
Xsky130_fd_sc_hd__dfstp_1_30 \$6060 \$6635 \$6536
+ rst_n
+ vss
+ vdd
+ vdd
+ sky130_fd_sc_hd__dfstp_1
* cell instance sky130_fd_sc_hd__dfstp_1_31 r0 *1 0,0
Xsky130_fd_sc_hd__dfstp_1_31 \$6060 \$6240 \$6335
+ rst_n
+ vss
+ vdd
+ vdd
+ sky130_fd_sc_hd__dfstp_1
* cell instance sky130_fd_sc_hd__diode_2_0 r0 *1 0,0
Xsky130_fd_sc_hd__diode_2_0
+ clk
+ vss
+ vdd
+ vdd
+ sky130_fd_sc_hd__diode_2
* cell instance sky130_fd_sc_hd__fill_1_0 r0 *1 0,0
Xsky130_fd_sc_hd__fill_1_0
+ vss
+ vdd
+ vdd
+ sky130_fd_sc_hd__fill_1
* cell instance sky130_fd_sc_hd__fill_1_1 r0 *1 0,0
Xsky130_fd_sc_hd__fill_1_1
+ vss
+ vdd
+ vdd
+ sky130_fd_sc_hd__fill_1
* cell instance sky130_fd_sc_hd__fill_1_2 r0 *1 0,0
Xsky130_fd_sc_hd__fill_1_2
+ vss
+ vdd
+ vdd
+ sky130_fd_sc_hd__fill_1
* cell instance sky130_fd_sc_hd__fill_1_3 r0 *1 0,0
Xsky130_fd_sc_hd__fill_1_3
+ vss
+ vdd
+ vdd
+ sky130_fd_sc_hd__fill_1
* cell instance sky130_fd_sc_hd__fill_1_4 r0 *1 0,0
Xsky130_fd_sc_hd__fill_1_4
+ vss
+ vdd
+ vdd
+ sky130_fd_sc_hd__fill_1
* cell instance sky130_fd_sc_hd__fill_1_5 r0 *1 0,0
Xsky130_fd_sc_hd__fill_1_5
+ vss
+ vdd
+ vdd
+ sky130_fd_sc_hd__fill_1
* cell instance sky130_fd_sc_hd__fill_1_6 r0 *1 0,0
Xsky130_fd_sc_hd__fill_1_6
+ vss
+ vdd
+ vdd
+ sky130_fd_sc_hd__fill_1
* cell instance sky130_fd_sc_hd__fill_1_7 r0 *1 0,0
Xsky130_fd_sc_hd__fill_1_7
+ vss
+ vdd
+ vdd
+ sky130_fd_sc_hd__fill_1
* cell instance sky130_fd_sc_hd__fill_1_8 r0 *1 0,0
Xsky130_fd_sc_hd__fill_1_8
+ vss
+ vdd
+ vdd
+ sky130_fd_sc_hd__fill_1
* cell instance sky130_fd_sc_hd__fill_1_9 r0 *1 0,0
Xsky130_fd_sc_hd__fill_1_9
+ vss
+ vdd
+ vdd
+ sky130_fd_sc_hd__fill_1
* cell instance sky130_fd_sc_hd__fill_1_10 r0 *1 0,0
Xsky130_fd_sc_hd__fill_1_10
+ vss
+ vdd
+ vdd
+ sky130_fd_sc_hd__fill_1
* cell instance sky130_fd_sc_hd__fill_1_11 r0 *1 0,0
Xsky130_fd_sc_hd__fill_1_11
+ vss
+ vdd
+ vdd
+ sky130_fd_sc_hd__fill_1
* cell instance sky130_fd_sc_hd__fill_1_12 r0 *1 0,0
Xsky130_fd_sc_hd__fill_1_12
+ vss
+ vdd
+ vdd
+ sky130_fd_sc_hd__fill_1
* cell instance sky130_fd_sc_hd__fill_1_13 r0 *1 0,0
Xsky130_fd_sc_hd__fill_1_13
+ vss
+ vdd
+ vdd
+ sky130_fd_sc_hd__fill_1
* cell instance sky130_fd_sc_hd__fill_1_14 r0 *1 0,0
Xsky130_fd_sc_hd__fill_1_14
+ vss
+ vdd
+ vdd
+ sky130_fd_sc_hd__fill_1
* cell instance sky130_fd_sc_hd__fill_1_15 r0 *1 0,0
Xsky130_fd_sc_hd__fill_1_15
+ vss
+ vdd
+ vdd
+ sky130_fd_sc_hd__fill_1
* cell instance sky130_fd_sc_hd__fill_1_16 r0 *1 0,0
Xsky130_fd_sc_hd__fill_1_16
+ vss
+ vdd
+ vdd
+ sky130_fd_sc_hd__fill_1
* cell instance sky130_fd_sc_hd__fill_1_17 r0 *1 0,0
Xsky130_fd_sc_hd__fill_1_17
+ vss
+ vdd
+ vdd
+ sky130_fd_sc_hd__fill_1
* cell instance sky130_fd_sc_hd__fill_1_18 r0 *1 0,0
Xsky130_fd_sc_hd__fill_1_18
+ vss
+ vdd
+ vdd
+ sky130_fd_sc_hd__fill_1
* cell instance sky130_fd_sc_hd__fill_1_19 r0 *1 0,0
Xsky130_fd_sc_hd__fill_1_19
+ vss
+ vdd
+ vdd
+ sky130_fd_sc_hd__fill_1
* cell instance sky130_fd_sc_hd__fill_1_20 r0 *1 0,0
Xsky130_fd_sc_hd__fill_1_20
+ vss
+ vdd
+ vdd
+ sky130_fd_sc_hd__fill_1
* cell instance sky130_fd_sc_hd__fill_1_21 r0 *1 0,0
Xsky130_fd_sc_hd__fill_1_21
+ vss
+ vdd
+ vdd
+ sky130_fd_sc_hd__fill_1
* cell instance sky130_fd_sc_hd__fill_1_22 r0 *1 0,0
Xsky130_fd_sc_hd__fill_1_22
+ vss
+ vdd
+ vdd
+ sky130_fd_sc_hd__fill_1
* cell instance sky130_fd_sc_hd__fill_1_23 r0 *1 0,0
Xsky130_fd_sc_hd__fill_1_23
+ vss
+ vdd
+ vdd
+ sky130_fd_sc_hd__fill_1
* cell instance sky130_fd_sc_hd__fill_1_24 r0 *1 0,0
Xsky130_fd_sc_hd__fill_1_24
+ vss
+ vdd
+ vdd
+ sky130_fd_sc_hd__fill_1
* cell instance sky130_fd_sc_hd__fill_1_25 r0 *1 0,0
Xsky130_fd_sc_hd__fill_1_25
+ vss
+ vdd
+ vdd
+ sky130_fd_sc_hd__fill_1
* cell instance sky130_fd_sc_hd__fill_1_26 r0 *1 0,0
Xsky130_fd_sc_hd__fill_1_26
+ vss
+ vdd
+ vdd
+ sky130_fd_sc_hd__fill_1
* cell instance sky130_fd_sc_hd__fill_1_27 r0 *1 0,0
Xsky130_fd_sc_hd__fill_1_27
+ vss
+ vdd
+ vdd
+ sky130_fd_sc_hd__fill_1
* cell instance sky130_fd_sc_hd__fill_1_28 r0 *1 0,0
Xsky130_fd_sc_hd__fill_1_28
+ vss
+ vdd
+ vdd
+ sky130_fd_sc_hd__fill_1
* cell instance sky130_fd_sc_hd__fill_1_29 r0 *1 0,0
Xsky130_fd_sc_hd__fill_1_29
+ vss
+ vdd
+ vdd
+ sky130_fd_sc_hd__fill_1
* cell instance sky130_fd_sc_hd__fill_1_30 r0 *1 0,0
Xsky130_fd_sc_hd__fill_1_30
+ vss
+ vdd
+ vdd
+ sky130_fd_sc_hd__fill_1
* cell instance sky130_fd_sc_hd__fill_1_31 r0 *1 0,0
Xsky130_fd_sc_hd__fill_1_31
+ vss
+ vdd
+ vdd
+ sky130_fd_sc_hd__fill_1
* cell instance sky130_fd_sc_hd__fill_1_32 r0 *1 0,0
Xsky130_fd_sc_hd__fill_1_32
+ vss
+ vdd
+ vdd
+ sky130_fd_sc_hd__fill_1
* cell instance sky130_fd_sc_hd__fill_1_33 r0 *1 0,0
Xsky130_fd_sc_hd__fill_1_33
+ vss
+ vdd
+ vdd
+ sky130_fd_sc_hd__fill_1
* cell instance sky130_fd_sc_hd__fill_1_34 r0 *1 0,0
Xsky130_fd_sc_hd__fill_1_34
+ vss
+ vdd
+ vdd
+ sky130_fd_sc_hd__fill_1
* cell instance sky130_fd_sc_hd__fill_1_35 r0 *1 0,0
Xsky130_fd_sc_hd__fill_1_35
+ vss
+ vdd
+ vdd
+ sky130_fd_sc_hd__fill_1
* cell instance sky130_fd_sc_hd__fill_1_36 r0 *1 0,0
Xsky130_fd_sc_hd__fill_1_36
+ vss
+ vdd
+ vdd
+ sky130_fd_sc_hd__fill_1
* cell instance sky130_fd_sc_hd__fill_1_37 r0 *1 0,0
Xsky130_fd_sc_hd__fill_1_37
+ vss
+ vdd
+ vdd
+ sky130_fd_sc_hd__fill_1
* cell instance sky130_fd_sc_hd__fill_1_38 r0 *1 0,0
Xsky130_fd_sc_hd__fill_1_38
+ vss
+ vdd
+ vdd
+ sky130_fd_sc_hd__fill_1
* cell instance sky130_fd_sc_hd__fill_1_39 r0 *1 0,0
Xsky130_fd_sc_hd__fill_1_39
+ vss
+ vdd
+ vdd
+ sky130_fd_sc_hd__fill_1
* cell instance sky130_fd_sc_hd__fill_1_40 r0 *1 0,0
Xsky130_fd_sc_hd__fill_1_40
+ vss
+ vdd
+ vdd
+ sky130_fd_sc_hd__fill_1
* cell instance sky130_fd_sc_hd__fill_1_41 r0 *1 0,0
Xsky130_fd_sc_hd__fill_1_41
+ vss
+ vdd
+ vdd
+ sky130_fd_sc_hd__fill_1
* cell instance sky130_fd_sc_hd__fill_1_42 r0 *1 0,0
Xsky130_fd_sc_hd__fill_1_42
+ vss
+ vdd
+ vdd
+ sky130_fd_sc_hd__fill_1
* cell instance sky130_fd_sc_hd__fill_1_43 r0 *1 0,0
Xsky130_fd_sc_hd__fill_1_43
+ vss
+ vdd
+ vdd
+ sky130_fd_sc_hd__fill_1
* cell instance sky130_fd_sc_hd__fill_1_44 r0 *1 0,0
Xsky130_fd_sc_hd__fill_1_44
+ vss
+ vdd
+ vdd
+ sky130_fd_sc_hd__fill_1
* cell instance sky130_fd_sc_hd__fill_1_45 r0 *1 0,0
Xsky130_fd_sc_hd__fill_1_45
+ vss
+ vdd
+ vdd
+ sky130_fd_sc_hd__fill_1
* cell instance sky130_fd_sc_hd__fill_1_46 r0 *1 0,0
Xsky130_fd_sc_hd__fill_1_46
+ vss
+ vdd
+ vdd
+ sky130_fd_sc_hd__fill_1
* cell instance sky130_fd_sc_hd__fill_1_47 r0 *1 0,0
Xsky130_fd_sc_hd__fill_1_47
+ vss
+ vdd
+ vdd
+ sky130_fd_sc_hd__fill_1
* cell instance sky130_fd_sc_hd__fill_1_48 r0 *1 0,0
Xsky130_fd_sc_hd__fill_1_48
+ vss
+ vdd
+ vdd
+ sky130_fd_sc_hd__fill_1
* cell instance sky130_fd_sc_hd__fill_1_49 r0 *1 0,0
Xsky130_fd_sc_hd__fill_1_49
+ vss
+ vdd
+ vdd
+ sky130_fd_sc_hd__fill_1
* cell instance sky130_fd_sc_hd__fill_1_50 r0 *1 0,0
Xsky130_fd_sc_hd__fill_1_50
+ vss
+ vdd
+ vdd
+ sky130_fd_sc_hd__fill_1
* cell instance sky130_fd_sc_hd__fill_1_51 r0 *1 0,0
Xsky130_fd_sc_hd__fill_1_51
+ vss
+ vdd
+ vdd
+ sky130_fd_sc_hd__fill_1
* cell instance sky130_fd_sc_hd__fill_1_52 r0 *1 0,0
Xsky130_fd_sc_hd__fill_1_52
+ vss
+ vdd
+ vdd
+ sky130_fd_sc_hd__fill_1
* cell instance sky130_fd_sc_hd__fill_1_53 r0 *1 0,0
Xsky130_fd_sc_hd__fill_1_53
+ vss
+ vdd
+ vdd
+ sky130_fd_sc_hd__fill_1
* cell instance sky130_fd_sc_hd__fill_1_54 r0 *1 0,0
Xsky130_fd_sc_hd__fill_1_54
+ vss
+ vdd
+ vdd
+ sky130_fd_sc_hd__fill_1
* cell instance sky130_fd_sc_hd__fill_1_55 r0 *1 0,0
Xsky130_fd_sc_hd__fill_1_55
+ vss
+ vdd
+ vdd
+ sky130_fd_sc_hd__fill_1
* cell instance sky130_fd_sc_hd__fill_1_56 r0 *1 0,0
Xsky130_fd_sc_hd__fill_1_56
+ vss
+ vdd
+ vdd
+ sky130_fd_sc_hd__fill_1
* cell instance sky130_fd_sc_hd__fill_1_57 r0 *1 0,0
Xsky130_fd_sc_hd__fill_1_57
+ vss
+ vdd
+ vdd
+ sky130_fd_sc_hd__fill_1
* cell instance sky130_fd_sc_hd__fill_1_58 r0 *1 0,0
Xsky130_fd_sc_hd__fill_1_58
+ vss
+ vdd
+ vdd
+ sky130_fd_sc_hd__fill_1
* cell instance sky130_fd_sc_hd__fill_1_59 r0 *1 0,0
Xsky130_fd_sc_hd__fill_1_59
+ vss
+ vdd
+ vdd
+ sky130_fd_sc_hd__fill_1
* cell instance sky130_fd_sc_hd__fill_1_60 r0 *1 0,0
Xsky130_fd_sc_hd__fill_1_60
+ vss
+ vdd
+ vdd
+ sky130_fd_sc_hd__fill_1
* cell instance sky130_fd_sc_hd__fill_1_61 r0 *1 0,0
Xsky130_fd_sc_hd__fill_1_61
+ vss
+ vdd
+ vdd
+ sky130_fd_sc_hd__fill_1
* cell instance sky130_fd_sc_hd__fill_1_62 r0 *1 0,0
Xsky130_fd_sc_hd__fill_1_62
+ vss
+ vdd
+ vdd
+ sky130_fd_sc_hd__fill_1
* cell instance sky130_fd_sc_hd__fill_1_63 r0 *1 0,0
Xsky130_fd_sc_hd__fill_1_63
+ vss
+ vdd
+ vdd
+ sky130_fd_sc_hd__fill_1
* cell instance sky130_fd_sc_hd__fill_1_64 r0 *1 0,0
Xsky130_fd_sc_hd__fill_1_64
+ vss
+ vdd
+ vdd
+ sky130_fd_sc_hd__fill_1
* cell instance sky130_fd_sc_hd__fill_1_65 r0 *1 0,0
Xsky130_fd_sc_hd__fill_1_65
+ vss
+ vdd
+ vdd
+ sky130_fd_sc_hd__fill_1
* cell instance sky130_fd_sc_hd__fill_1_66 r0 *1 0,0
Xsky130_fd_sc_hd__fill_1_66
+ vss
+ vdd
+ vdd
+ sky130_fd_sc_hd__fill_1
* cell instance sky130_fd_sc_hd__fill_1_67 r0 *1 0,0
Xsky130_fd_sc_hd__fill_1_67
+ vss
+ vdd
+ vdd
+ sky130_fd_sc_hd__fill_1
* cell instance sky130_fd_sc_hd__fill_1_68 r0 *1 0,0
Xsky130_fd_sc_hd__fill_1_68
+ vss
+ vdd
+ vdd
+ sky130_fd_sc_hd__fill_1
* cell instance sky130_fd_sc_hd__fill_1_69 r0 *1 0,0
Xsky130_fd_sc_hd__fill_1_69
+ vss
+ vdd
+ vdd
+ sky130_fd_sc_hd__fill_1
* cell instance sky130_fd_sc_hd__fill_1_70 r0 *1 0,0
Xsky130_fd_sc_hd__fill_1_70
+ vss
+ vdd
+ vdd
+ sky130_fd_sc_hd__fill_1
* cell instance sky130_fd_sc_hd__fill_1_71 r0 *1 0,0
Xsky130_fd_sc_hd__fill_1_71
+ vss
+ vdd
+ vdd
+ sky130_fd_sc_hd__fill_1
* cell instance sky130_fd_sc_hd__fill_1_72 r0 *1 0,0
Xsky130_fd_sc_hd__fill_1_72
+ vss
+ vdd
+ vdd
+ sky130_fd_sc_hd__fill_1
* cell instance sky130_fd_sc_hd__fill_1_73 r0 *1 0,0
Xsky130_fd_sc_hd__fill_1_73
+ vss
+ vdd
+ vdd
+ sky130_fd_sc_hd__fill_1
* cell instance sky130_fd_sc_hd__fill_1_74 r0 *1 0,0
Xsky130_fd_sc_hd__fill_1_74
+ vss
+ vdd
+ vdd
+ sky130_fd_sc_hd__fill_1
* cell instance sky130_fd_sc_hd__fill_1_75 r0 *1 0,0
Xsky130_fd_sc_hd__fill_1_75
+ vss
+ vdd
+ vdd
+ sky130_fd_sc_hd__fill_1
* cell instance sky130_fd_sc_hd__fill_1_76 r0 *1 0,0
Xsky130_fd_sc_hd__fill_1_76
+ vss
+ vdd
+ vdd
+ sky130_fd_sc_hd__fill_1
* cell instance sky130_fd_sc_hd__fill_1_77 r0 *1 0,0
Xsky130_fd_sc_hd__fill_1_77
+ vss
+ vdd
+ vdd
+ sky130_fd_sc_hd__fill_1
* cell instance sky130_fd_sc_hd__fill_1_78 r0 *1 0,0
Xsky130_fd_sc_hd__fill_1_78
+ vss
+ vdd
+ vdd
+ sky130_fd_sc_hd__fill_1
* cell instance sky130_fd_sc_hd__fill_1_79 r0 *1 0,0
Xsky130_fd_sc_hd__fill_1_79
+ vss
+ vdd
+ vdd
+ sky130_fd_sc_hd__fill_1
* cell instance sky130_fd_sc_hd__fill_1_80 r0 *1 0,0
Xsky130_fd_sc_hd__fill_1_80
+ vss
+ vdd
+ vdd
+ sky130_fd_sc_hd__fill_1
* cell instance sky130_fd_sc_hd__fill_1_81 r0 *1 0,0
Xsky130_fd_sc_hd__fill_1_81
+ vss
+ vdd
+ vdd
+ sky130_fd_sc_hd__fill_1
* cell instance sky130_fd_sc_hd__fill_1_82 r0 *1 0,0
Xsky130_fd_sc_hd__fill_1_82
+ vss
+ vdd
+ vdd
+ sky130_fd_sc_hd__fill_1
* cell instance sky130_fd_sc_hd__fill_1_83 r0 *1 0,0
Xsky130_fd_sc_hd__fill_1_83
+ vss
+ vdd
+ vdd
+ sky130_fd_sc_hd__fill_1
* cell instance sky130_fd_sc_hd__fill_1_84 r0 *1 0,0
Xsky130_fd_sc_hd__fill_1_84
+ vss
+ vdd
+ vdd
+ sky130_fd_sc_hd__fill_1
* cell instance sky130_fd_sc_hd__fill_1_85 r0 *1 0,0
Xsky130_fd_sc_hd__fill_1_85
+ vss
+ vdd
+ vdd
+ sky130_fd_sc_hd__fill_1
* cell instance sky130_fd_sc_hd__fill_1_86 r0 *1 0,0
Xsky130_fd_sc_hd__fill_1_86
+ vss
+ vdd
+ vdd
+ sky130_fd_sc_hd__fill_1
* cell instance sky130_fd_sc_hd__fill_1_87 r0 *1 0,0
Xsky130_fd_sc_hd__fill_1_87
+ vss
+ vdd
+ vdd
+ sky130_fd_sc_hd__fill_1
* cell instance sky130_fd_sc_hd__fill_1_88 r0 *1 0,0
Xsky130_fd_sc_hd__fill_1_88
+ vss
+ vdd
+ vdd
+ sky130_fd_sc_hd__fill_1
* cell instance sky130_fd_sc_hd__fill_1_89 r0 *1 0,0
Xsky130_fd_sc_hd__fill_1_89
+ vss
+ vdd
+ vdd
+ sky130_fd_sc_hd__fill_1
* cell instance sky130_fd_sc_hd__fill_1_90 r0 *1 0,0
Xsky130_fd_sc_hd__fill_1_90
+ vss
+ vdd
+ vdd
+ sky130_fd_sc_hd__fill_1
* cell instance sky130_fd_sc_hd__fill_1_91 r0 *1 0,0
Xsky130_fd_sc_hd__fill_1_91
+ vss
+ vdd
+ vdd
+ sky130_fd_sc_hd__fill_1
* cell instance sky130_fd_sc_hd__fill_1_92 r0 *1 0,0
Xsky130_fd_sc_hd__fill_1_92
+ vss
+ vdd
+ vdd
+ sky130_fd_sc_hd__fill_1
* cell instance sky130_fd_sc_hd__fill_1_93 r0 *1 0,0
Xsky130_fd_sc_hd__fill_1_93
+ vss
+ vdd
+ vdd
+ sky130_fd_sc_hd__fill_1
* cell instance sky130_fd_sc_hd__fill_1_94 r0 *1 0,0
Xsky130_fd_sc_hd__fill_1_94
+ vss
+ vdd
+ vdd
+ sky130_fd_sc_hd__fill_1
* cell instance sky130_fd_sc_hd__fill_1_95 r0 *1 0,0
Xsky130_fd_sc_hd__fill_1_95
+ vss
+ vdd
+ vdd
+ sky130_fd_sc_hd__fill_1
* cell instance sky130_fd_sc_hd__fill_1_96 r0 *1 0,0
Xsky130_fd_sc_hd__fill_1_96
+ vss
+ vdd
+ vdd
+ sky130_fd_sc_hd__fill_1
* cell instance sky130_fd_sc_hd__fill_1_97 r0 *1 0,0
Xsky130_fd_sc_hd__fill_1_97
+ vss
+ vdd
+ vdd
+ sky130_fd_sc_hd__fill_1
* cell instance sky130_fd_sc_hd__fill_1_98 r0 *1 0,0
Xsky130_fd_sc_hd__fill_1_98
+ vss
+ vdd
+ vdd
+ sky130_fd_sc_hd__fill_1
* cell instance sky130_fd_sc_hd__fill_1_99 r0 *1 0,0
Xsky130_fd_sc_hd__fill_1_99
+ vss
+ vdd
+ vdd
+ sky130_fd_sc_hd__fill_1
* cell instance sky130_fd_sc_hd__fill_1_100 r0 *1 0,0
Xsky130_fd_sc_hd__fill_1_100
+ vss
+ vdd
+ vdd
+ sky130_fd_sc_hd__fill_1
* cell instance sky130_fd_sc_hd__fill_1_101 r0 *1 0,0
Xsky130_fd_sc_hd__fill_1_101
+ vss
+ vdd
+ vdd
+ sky130_fd_sc_hd__fill_1
* cell instance sky130_fd_sc_hd__fill_1_102 r0 *1 0,0
Xsky130_fd_sc_hd__fill_1_102
+ vss
+ vdd
+ vdd
+ sky130_fd_sc_hd__fill_1
* cell instance sky130_fd_sc_hd__fill_1_103 r0 *1 0,0
Xsky130_fd_sc_hd__fill_1_103
+ vss
+ vdd
+ vdd
+ sky130_fd_sc_hd__fill_1
* cell instance sky130_fd_sc_hd__fill_1_104 r0 *1 0,0
Xsky130_fd_sc_hd__fill_1_104
+ vss
+ vdd
+ vdd
+ sky130_fd_sc_hd__fill_1
* cell instance sky130_fd_sc_hd__fill_1_105 r0 *1 0,0
Xsky130_fd_sc_hd__fill_1_105
+ vss
+ vdd
+ vdd
+ sky130_fd_sc_hd__fill_1
* cell instance sky130_fd_sc_hd__fill_1_106 r0 *1 0,0
Xsky130_fd_sc_hd__fill_1_106
+ vss
+ vdd
+ vdd
+ sky130_fd_sc_hd__fill_1
* cell instance sky130_fd_sc_hd__fill_1_107 r0 *1 0,0
Xsky130_fd_sc_hd__fill_1_107
+ vss
+ vdd
+ vdd
+ sky130_fd_sc_hd__fill_1
* cell instance sky130_fd_sc_hd__fill_1_108 r0 *1 0,0
Xsky130_fd_sc_hd__fill_1_108
+ vss
+ vdd
+ vdd
+ sky130_fd_sc_hd__fill_1
* cell instance sky130_fd_sc_hd__fill_1_109 r0 *1 0,0
Xsky130_fd_sc_hd__fill_1_109
+ vss
+ vdd
+ vdd
+ sky130_fd_sc_hd__fill_1
* cell instance sky130_fd_sc_hd__fill_1_110 r0 *1 0,0
Xsky130_fd_sc_hd__fill_1_110
+ vss
+ vdd
+ vdd
+ sky130_fd_sc_hd__fill_1
* cell instance sky130_fd_sc_hd__fill_1_111 r0 *1 0,0
Xsky130_fd_sc_hd__fill_1_111
+ vss
+ vdd
+ vdd
+ sky130_fd_sc_hd__fill_1
* cell instance sky130_fd_sc_hd__fill_1_112 r0 *1 0,0
Xsky130_fd_sc_hd__fill_1_112
+ vss
+ vdd
+ vdd
+ sky130_fd_sc_hd__fill_1
* cell instance sky130_fd_sc_hd__fill_1_113 r0 *1 0,0
Xsky130_fd_sc_hd__fill_1_113
+ vss
+ vdd
+ vdd
+ sky130_fd_sc_hd__fill_1
* cell instance sky130_fd_sc_hd__fill_1_114 r0 *1 0,0
Xsky130_fd_sc_hd__fill_1_114
+ vss
+ vdd
+ vdd
+ sky130_fd_sc_hd__fill_1
* cell instance sky130_fd_sc_hd__fill_1_115 r0 *1 0,0
Xsky130_fd_sc_hd__fill_1_115
+ vss
+ vdd
+ vdd
+ sky130_fd_sc_hd__fill_1
* cell instance sky130_fd_sc_hd__fill_1_116 r0 *1 0,0
Xsky130_fd_sc_hd__fill_1_116
+ vss
+ vdd
+ vdd
+ sky130_fd_sc_hd__fill_1
* cell instance sky130_fd_sc_hd__fill_1_117 r0 *1 0,0
Xsky130_fd_sc_hd__fill_1_117
+ vss
+ vdd
+ vdd
+ sky130_fd_sc_hd__fill_1
* cell instance sky130_fd_sc_hd__fill_1_118 r0 *1 0,0
Xsky130_fd_sc_hd__fill_1_118
+ vss
+ vdd
+ vdd
+ sky130_fd_sc_hd__fill_1
* cell instance sky130_fd_sc_hd__fill_1_119 r0 *1 0,0
Xsky130_fd_sc_hd__fill_1_119
+ vss
+ vdd
+ vdd
+ sky130_fd_sc_hd__fill_1
* cell instance sky130_fd_sc_hd__fill_1_120 r0 *1 0,0
Xsky130_fd_sc_hd__fill_1_120
+ vss
+ vdd
+ vdd
+ sky130_fd_sc_hd__fill_1
* cell instance sky130_fd_sc_hd__fill_1_121 r0 *1 0,0
Xsky130_fd_sc_hd__fill_1_121
+ vss
+ vdd
+ vdd
+ sky130_fd_sc_hd__fill_1
* cell instance sky130_fd_sc_hd__fill_1_122 r0 *1 0,0
Xsky130_fd_sc_hd__fill_1_122
+ vss
+ vdd
+ vdd
+ sky130_fd_sc_hd__fill_1
* cell instance sky130_fd_sc_hd__fill_1_123 r0 *1 0,0
Xsky130_fd_sc_hd__fill_1_123
+ vss
+ vdd
+ vdd
+ sky130_fd_sc_hd__fill_1
* cell instance sky130_fd_sc_hd__fill_1_124 r0 *1 0,0
Xsky130_fd_sc_hd__fill_1_124
+ vss
+ vdd
+ vdd
+ sky130_fd_sc_hd__fill_1
* cell instance sky130_fd_sc_hd__fill_1_125 r0 *1 0,0
Xsky130_fd_sc_hd__fill_1_125
+ vss
+ vdd
+ vdd
+ sky130_fd_sc_hd__fill_1
* cell instance sky130_fd_sc_hd__fill_1_126 r0 *1 0,0
Xsky130_fd_sc_hd__fill_1_126
+ vss
+ vdd
+ vdd
+ sky130_fd_sc_hd__fill_1
* cell instance sky130_fd_sc_hd__fill_1_127 r0 *1 0,0
Xsky130_fd_sc_hd__fill_1_127
+ vss
+ vdd
+ vdd
+ sky130_fd_sc_hd__fill_1
* cell instance sky130_fd_sc_hd__fill_1_128 r0 *1 0,0
Xsky130_fd_sc_hd__fill_1_128
+ vss
+ vdd
+ vdd
+ sky130_fd_sc_hd__fill_1
* cell instance sky130_fd_sc_hd__fill_1_129 r0 *1 0,0
Xsky130_fd_sc_hd__fill_1_129
+ vss
+ vdd
+ vdd
+ sky130_fd_sc_hd__fill_1
* cell instance sky130_fd_sc_hd__fill_1_130 r0 *1 0,0
Xsky130_fd_sc_hd__fill_1_130
+ vss
+ vdd
+ vdd
+ sky130_fd_sc_hd__fill_1
* cell instance sky130_fd_sc_hd__fill_1_131 r0 *1 0,0
Xsky130_fd_sc_hd__fill_1_131
+ vss
+ vdd
+ vdd
+ sky130_fd_sc_hd__fill_1
* cell instance sky130_fd_sc_hd__fill_1_132 r0 *1 0,0
Xsky130_fd_sc_hd__fill_1_132
+ vss
+ vdd
+ vdd
+ sky130_fd_sc_hd__fill_1
* cell instance sky130_fd_sc_hd__fill_1_133 r0 *1 0,0
Xsky130_fd_sc_hd__fill_1_133
+ vss
+ vdd
+ vdd
+ sky130_fd_sc_hd__fill_1
* cell instance sky130_fd_sc_hd__fill_1_134 r0 *1 0,0
Xsky130_fd_sc_hd__fill_1_134
+ vss
+ vdd
+ vdd
+ sky130_fd_sc_hd__fill_1
* cell instance sky130_fd_sc_hd__fill_1_135 r0 *1 0,0
Xsky130_fd_sc_hd__fill_1_135
+ vss
+ vdd
+ vdd
+ sky130_fd_sc_hd__fill_1
* cell instance sky130_fd_sc_hd__fill_1_136 r0 *1 0,0
Xsky130_fd_sc_hd__fill_1_136
+ vss
+ vdd
+ vdd
+ sky130_fd_sc_hd__fill_1
* cell instance sky130_fd_sc_hd__fill_1_137 r0 *1 0,0
Xsky130_fd_sc_hd__fill_1_137
+ vss
+ vdd
+ vdd
+ sky130_fd_sc_hd__fill_1
* cell instance sky130_fd_sc_hd__fill_1_138 r0 *1 0,0
Xsky130_fd_sc_hd__fill_1_138
+ vss
+ vdd
+ vdd
+ sky130_fd_sc_hd__fill_1
* cell instance sky130_fd_sc_hd__fill_1_139 r0 *1 0,0
Xsky130_fd_sc_hd__fill_1_139
+ vss
+ vdd
+ vdd
+ sky130_fd_sc_hd__fill_1
* cell instance sky130_fd_sc_hd__fill_1_140 r0 *1 0,0
Xsky130_fd_sc_hd__fill_1_140
+ vss
+ vdd
+ vdd
+ sky130_fd_sc_hd__fill_1
* cell instance sky130_fd_sc_hd__fill_1_141 r0 *1 0,0
Xsky130_fd_sc_hd__fill_1_141
+ vss
+ vdd
+ vdd
+ sky130_fd_sc_hd__fill_1
* cell instance sky130_fd_sc_hd__fill_1_142 r0 *1 0,0
Xsky130_fd_sc_hd__fill_1_142
+ vss
+ vdd
+ vdd
+ sky130_fd_sc_hd__fill_1
* cell instance sky130_fd_sc_hd__fill_1_143 r0 *1 0,0
Xsky130_fd_sc_hd__fill_1_143
+ vss
+ vdd
+ vdd
+ sky130_fd_sc_hd__fill_1
* cell instance sky130_fd_sc_hd__fill_1_144 r0 *1 0,0
Xsky130_fd_sc_hd__fill_1_144
+ vss
+ vdd
+ vdd
+ sky130_fd_sc_hd__fill_1
* cell instance sky130_fd_sc_hd__fill_1_145 r0 *1 0,0
Xsky130_fd_sc_hd__fill_1_145
+ vss
+ vdd
+ vdd
+ sky130_fd_sc_hd__fill_1
* cell instance sky130_fd_sc_hd__fill_1_146 r0 *1 0,0
Xsky130_fd_sc_hd__fill_1_146
+ vss
+ vdd
+ vdd
+ sky130_fd_sc_hd__fill_1
* cell instance sky130_fd_sc_hd__fill_1_147 r0 *1 0,0
Xsky130_fd_sc_hd__fill_1_147
+ vss
+ vdd
+ vdd
+ sky130_fd_sc_hd__fill_1
* cell instance sky130_fd_sc_hd__fill_1_148 r0 *1 0,0
Xsky130_fd_sc_hd__fill_1_148
+ vss
+ vdd
+ vdd
+ sky130_fd_sc_hd__fill_1
* cell instance sky130_fd_sc_hd__fill_1_149 r0 *1 0,0
Xsky130_fd_sc_hd__fill_1_149
+ vss
+ vdd
+ vdd
+ sky130_fd_sc_hd__fill_1
* cell instance sky130_fd_sc_hd__fill_1_150 r0 *1 0,0
Xsky130_fd_sc_hd__fill_1_150
+ vss
+ vdd
+ vdd
+ sky130_fd_sc_hd__fill_1
* cell instance sky130_fd_sc_hd__fill_1_151 r0 *1 0,0
Xsky130_fd_sc_hd__fill_1_151
+ vss
+ vdd
+ vdd
+ sky130_fd_sc_hd__fill_1
* cell instance sky130_fd_sc_hd__fill_1_152 r0 *1 0,0
Xsky130_fd_sc_hd__fill_1_152
+ vss
+ vdd
+ vdd
+ sky130_fd_sc_hd__fill_1
* cell instance sky130_fd_sc_hd__fill_1_153 r0 *1 0,0
Xsky130_fd_sc_hd__fill_1_153
+ vss
+ vdd
+ vdd
+ sky130_fd_sc_hd__fill_1
* cell instance sky130_fd_sc_hd__fill_1_154 r0 *1 0,0
Xsky130_fd_sc_hd__fill_1_154
+ vss
+ vdd
+ vdd
+ sky130_fd_sc_hd__fill_1
* cell instance sky130_fd_sc_hd__fill_1_155 r0 *1 0,0
Xsky130_fd_sc_hd__fill_1_155
+ vss
+ vdd
+ vdd
+ sky130_fd_sc_hd__fill_1
* cell instance sky130_fd_sc_hd__fill_1_156 r0 *1 0,0
Xsky130_fd_sc_hd__fill_1_156
+ vss
+ vdd
+ vdd
+ sky130_fd_sc_hd__fill_1
* cell instance sky130_fd_sc_hd__fill_1_157 r0 *1 0,0
Xsky130_fd_sc_hd__fill_1_157
+ vss
+ vdd
+ vdd
+ sky130_fd_sc_hd__fill_1
* cell instance sky130_fd_sc_hd__fill_1_158 r0 *1 0,0
Xsky130_fd_sc_hd__fill_1_158
+ vss
+ vdd
+ vdd
+ sky130_fd_sc_hd__fill_1
* cell instance sky130_fd_sc_hd__fill_1_159 r0 *1 0,0
Xsky130_fd_sc_hd__fill_1_159
+ vss
+ vdd
+ vdd
+ sky130_fd_sc_hd__fill_1
* cell instance sky130_fd_sc_hd__fill_1_160 r0 *1 0,0
Xsky130_fd_sc_hd__fill_1_160
+ vss
+ vdd
+ vdd
+ sky130_fd_sc_hd__fill_1
* cell instance sky130_fd_sc_hd__fill_1_161 r0 *1 0,0
Xsky130_fd_sc_hd__fill_1_161
+ vss
+ vdd
+ vdd
+ sky130_fd_sc_hd__fill_1
* cell instance sky130_fd_sc_hd__fill_1_162 r0 *1 0,0
Xsky130_fd_sc_hd__fill_1_162
+ vss
+ vdd
+ vdd
+ sky130_fd_sc_hd__fill_1
* cell instance sky130_fd_sc_hd__fill_1_163 r0 *1 0,0
Xsky130_fd_sc_hd__fill_1_163
+ vss
+ vdd
+ vdd
+ sky130_fd_sc_hd__fill_1
* cell instance sky130_fd_sc_hd__fill_1_164 r0 *1 0,0
Xsky130_fd_sc_hd__fill_1_164
+ vss
+ vdd
+ vdd
+ sky130_fd_sc_hd__fill_1
* cell instance sky130_fd_sc_hd__fill_1_165 r0 *1 0,0
Xsky130_fd_sc_hd__fill_1_165
+ vss
+ vdd
+ vdd
+ sky130_fd_sc_hd__fill_1
* cell instance sky130_fd_sc_hd__fill_1_166 r0 *1 0,0
Xsky130_fd_sc_hd__fill_1_166
+ vss
+ vdd
+ vdd
+ sky130_fd_sc_hd__fill_1
* cell instance sky130_fd_sc_hd__fill_1_167 r0 *1 0,0
Xsky130_fd_sc_hd__fill_1_167
+ vss
+ vdd
+ vdd
+ sky130_fd_sc_hd__fill_1
* cell instance sky130_fd_sc_hd__fill_1_168 r0 *1 0,0
Xsky130_fd_sc_hd__fill_1_168
+ vss
+ vdd
+ vdd
+ sky130_fd_sc_hd__fill_1
* cell instance sky130_fd_sc_hd__fill_1_169 r0 *1 0,0
Xsky130_fd_sc_hd__fill_1_169
+ vss
+ vdd
+ vdd
+ sky130_fd_sc_hd__fill_1
* cell instance sky130_fd_sc_hd__fill_1_170 r0 *1 0,0
Xsky130_fd_sc_hd__fill_1_170
+ vss
+ vdd
+ vdd
+ sky130_fd_sc_hd__fill_1
* cell instance sky130_fd_sc_hd__fill_1_171 r0 *1 0,0
Xsky130_fd_sc_hd__fill_1_171
+ vss
+ vdd
+ vdd
+ sky130_fd_sc_hd__fill_1
* cell instance sky130_fd_sc_hd__fill_1_172 r0 *1 0,0
Xsky130_fd_sc_hd__fill_1_172
+ vss
+ vdd
+ vdd
+ sky130_fd_sc_hd__fill_1
* cell instance sky130_fd_sc_hd__fill_1_173 r0 *1 0,0
Xsky130_fd_sc_hd__fill_1_173
+ vss
+ vdd
+ vdd
+ sky130_fd_sc_hd__fill_1
* cell instance sky130_fd_sc_hd__fill_1_174 r0 *1 0,0
Xsky130_fd_sc_hd__fill_1_174
+ vss
+ vdd
+ vdd
+ sky130_fd_sc_hd__fill_1
* cell instance sky130_fd_sc_hd__fill_1_175 r0 *1 0,0
Xsky130_fd_sc_hd__fill_1_175
+ vss
+ vdd
+ vdd
+ sky130_fd_sc_hd__fill_1
* cell instance sky130_fd_sc_hd__fill_1_176 r0 *1 0,0
Xsky130_fd_sc_hd__fill_1_176
+ vss
+ vdd
+ vdd
+ sky130_fd_sc_hd__fill_1
* cell instance sky130_fd_sc_hd__fill_1_177 r0 *1 0,0
Xsky130_fd_sc_hd__fill_1_177
+ vss
+ vdd
+ vdd
+ sky130_fd_sc_hd__fill_1
* cell instance sky130_fd_sc_hd__fill_1_178 r0 *1 0,0
Xsky130_fd_sc_hd__fill_1_178
+ vss
+ vdd
+ vdd
+ sky130_fd_sc_hd__fill_1
* cell instance sky130_fd_sc_hd__fill_1_179 r0 *1 0,0
Xsky130_fd_sc_hd__fill_1_179
+ vss
+ vdd
+ vdd
+ sky130_fd_sc_hd__fill_1
* cell instance sky130_fd_sc_hd__fill_1_180 r0 *1 0,0
Xsky130_fd_sc_hd__fill_1_180
+ vss
+ vdd
+ vdd
+ sky130_fd_sc_hd__fill_1
* cell instance sky130_fd_sc_hd__fill_1_181 r0 *1 0,0
Xsky130_fd_sc_hd__fill_1_181
+ vss
+ vdd
+ vdd
+ sky130_fd_sc_hd__fill_1
* cell instance sky130_fd_sc_hd__fill_1_182 r0 *1 0,0
Xsky130_fd_sc_hd__fill_1_182
+ vss
+ vdd
+ vdd
+ sky130_fd_sc_hd__fill_1
* cell instance sky130_fd_sc_hd__fill_1_183 r0 *1 0,0
Xsky130_fd_sc_hd__fill_1_183
+ vss
+ vdd
+ vdd
+ sky130_fd_sc_hd__fill_1
* cell instance sky130_fd_sc_hd__fill_1_184 r0 *1 0,0
Xsky130_fd_sc_hd__fill_1_184
+ vss
+ vdd
+ vdd
+ sky130_fd_sc_hd__fill_1
* cell instance sky130_fd_sc_hd__fill_1_185 r0 *1 0,0
Xsky130_fd_sc_hd__fill_1_185
+ vss
+ vdd
+ vdd
+ sky130_fd_sc_hd__fill_1
* cell instance sky130_fd_sc_hd__fill_1_186 r0 *1 0,0
Xsky130_fd_sc_hd__fill_1_186
+ vss
+ vdd
+ vdd
+ sky130_fd_sc_hd__fill_1
* cell instance sky130_fd_sc_hd__fill_1_187 r0 *1 0,0
Xsky130_fd_sc_hd__fill_1_187
+ vss
+ vdd
+ vdd
+ sky130_fd_sc_hd__fill_1
* cell instance sky130_fd_sc_hd__fill_1_188 r0 *1 0,0
Xsky130_fd_sc_hd__fill_1_188
+ vss
+ vdd
+ vdd
+ sky130_fd_sc_hd__fill_1
* cell instance sky130_fd_sc_hd__fill_1_189 r0 *1 0,0
Xsky130_fd_sc_hd__fill_1_189
+ vss
+ vdd
+ vdd
+ sky130_fd_sc_hd__fill_1
* cell instance sky130_fd_sc_hd__fill_1_190 r0 *1 0,0
Xsky130_fd_sc_hd__fill_1_190
+ vss
+ vdd
+ vdd
+ sky130_fd_sc_hd__fill_1
* cell instance sky130_fd_sc_hd__fill_1_191 r0 *1 0,0
Xsky130_fd_sc_hd__fill_1_191
+ vss
+ vdd
+ vdd
+ sky130_fd_sc_hd__fill_1
* cell instance sky130_fd_sc_hd__fill_1_192 r0 *1 0,0
Xsky130_fd_sc_hd__fill_1_192
+ vss
+ vdd
+ vdd
+ sky130_fd_sc_hd__fill_1
* cell instance sky130_fd_sc_hd__fill_1_193 r0 *1 0,0
Xsky130_fd_sc_hd__fill_1_193
+ vss
+ vdd
+ vdd
+ sky130_fd_sc_hd__fill_1
* cell instance sky130_fd_sc_hd__fill_1_194 r0 *1 0,0
Xsky130_fd_sc_hd__fill_1_194
+ vss
+ vdd
+ vdd
+ sky130_fd_sc_hd__fill_1
* cell instance sky130_fd_sc_hd__fill_1_195 r0 *1 0,0
Xsky130_fd_sc_hd__fill_1_195
+ vss
+ vdd
+ vdd
+ sky130_fd_sc_hd__fill_1
* cell instance sky130_fd_sc_hd__fill_1_196 r0 *1 0,0
Xsky130_fd_sc_hd__fill_1_196
+ vss
+ vdd
+ vdd
+ sky130_fd_sc_hd__fill_1
* cell instance sky130_fd_sc_hd__fill_1_197 r0 *1 0,0
Xsky130_fd_sc_hd__fill_1_197
+ vss
+ vdd
+ vdd
+ sky130_fd_sc_hd__fill_1
* cell instance sky130_fd_sc_hd__fill_1_198 r0 *1 0,0
Xsky130_fd_sc_hd__fill_1_198
+ vss
+ vdd
+ vdd
+ sky130_fd_sc_hd__fill_1
* cell instance sky130_fd_sc_hd__fill_1_199 r0 *1 0,0
Xsky130_fd_sc_hd__fill_1_199
+ vss
+ vdd
+ vdd
+ sky130_fd_sc_hd__fill_1
* cell instance sky130_fd_sc_hd__fill_1_200 r0 *1 0,0
Xsky130_fd_sc_hd__fill_1_200
+ vss
+ vdd
+ vdd
+ sky130_fd_sc_hd__fill_1
* cell instance sky130_fd_sc_hd__fill_1_201 r0 *1 0,0
Xsky130_fd_sc_hd__fill_1_201
+ vss
+ vdd
+ vdd
+ sky130_fd_sc_hd__fill_1
* cell instance sky130_fd_sc_hd__fill_1_202 r0 *1 0,0
Xsky130_fd_sc_hd__fill_1_202
+ vss
+ vdd
+ vdd
+ sky130_fd_sc_hd__fill_1
* cell instance sky130_fd_sc_hd__fill_1_203 r0 *1 0,0
Xsky130_fd_sc_hd__fill_1_203
+ vss
+ vdd
+ vdd
+ sky130_fd_sc_hd__fill_1
* cell instance sky130_fd_sc_hd__fill_1_204 r0 *1 0,0
Xsky130_fd_sc_hd__fill_1_204
+ vss
+ vdd
+ vdd
+ sky130_fd_sc_hd__fill_1
* cell instance sky130_fd_sc_hd__fill_1_205 r0 *1 0,0
Xsky130_fd_sc_hd__fill_1_205
+ vss
+ vdd
+ vdd
+ sky130_fd_sc_hd__fill_1
* cell instance sky130_fd_sc_hd__fill_1_206 r0 *1 0,0
Xsky130_fd_sc_hd__fill_1_206
+ vss
+ vdd
+ vdd
+ sky130_fd_sc_hd__fill_1
* cell instance sky130_fd_sc_hd__fill_1_207 r0 *1 0,0
Xsky130_fd_sc_hd__fill_1_207
+ vss
+ vdd
+ vdd
+ sky130_fd_sc_hd__fill_1
* cell instance sky130_fd_sc_hd__fill_1_208 r0 *1 0,0
Xsky130_fd_sc_hd__fill_1_208
+ vss
+ vdd
+ vdd
+ sky130_fd_sc_hd__fill_1
* cell instance sky130_fd_sc_hd__fill_1_209 r0 *1 0,0
Xsky130_fd_sc_hd__fill_1_209
+ vss
+ vdd
+ vdd
+ sky130_fd_sc_hd__fill_1
* cell instance sky130_fd_sc_hd__fill_1_210 r0 *1 0,0
Xsky130_fd_sc_hd__fill_1_210
+ vss
+ vdd
+ vdd
+ sky130_fd_sc_hd__fill_1
* cell instance sky130_fd_sc_hd__fill_1_211 r0 *1 0,0
Xsky130_fd_sc_hd__fill_1_211
+ vss
+ vdd
+ vdd
+ sky130_fd_sc_hd__fill_1
* cell instance sky130_fd_sc_hd__fill_1_212 r0 *1 0,0
Xsky130_fd_sc_hd__fill_1_212
+ vss
+ vdd
+ vdd
+ sky130_fd_sc_hd__fill_1
* cell instance sky130_fd_sc_hd__fill_1_213 r0 *1 0,0
Xsky130_fd_sc_hd__fill_1_213
+ vss
+ vdd
+ vdd
+ sky130_fd_sc_hd__fill_1
* cell instance sky130_fd_sc_hd__fill_1_214 r0 *1 0,0
Xsky130_fd_sc_hd__fill_1_214
+ vss
+ vdd
+ vdd
+ sky130_fd_sc_hd__fill_1
* cell instance sky130_fd_sc_hd__fill_1_215 r0 *1 0,0
Xsky130_fd_sc_hd__fill_1_215
+ vss
+ vdd
+ vdd
+ sky130_fd_sc_hd__fill_1
* cell instance sky130_fd_sc_hd__fill_1_216 r0 *1 0,0
Xsky130_fd_sc_hd__fill_1_216
+ vss
+ vdd
+ vdd
+ sky130_fd_sc_hd__fill_1
* cell instance sky130_fd_sc_hd__fill_1_217 r0 *1 0,0
Xsky130_fd_sc_hd__fill_1_217
+ vss
+ vdd
+ vdd
+ sky130_fd_sc_hd__fill_1
* cell instance sky130_fd_sc_hd__fill_1_218 r0 *1 0,0
Xsky130_fd_sc_hd__fill_1_218
+ vss
+ vdd
+ vdd
+ sky130_fd_sc_hd__fill_1
* cell instance sky130_fd_sc_hd__fill_1_219 r0 *1 0,0
Xsky130_fd_sc_hd__fill_1_219
+ vss
+ vdd
+ vdd
+ sky130_fd_sc_hd__fill_1
* cell instance sky130_fd_sc_hd__fill_1_220 r0 *1 0,0
Xsky130_fd_sc_hd__fill_1_220
+ vss
+ vdd
+ vdd
+ sky130_fd_sc_hd__fill_1
* cell instance sky130_fd_sc_hd__fill_1_221 r0 *1 0,0
Xsky130_fd_sc_hd__fill_1_221
+ vss
+ vdd
+ vdd
+ sky130_fd_sc_hd__fill_1
* cell instance sky130_fd_sc_hd__fill_1_222 r0 *1 0,0
Xsky130_fd_sc_hd__fill_1_222
+ vss
+ vdd
+ vdd
+ sky130_fd_sc_hd__fill_1
* cell instance sky130_fd_sc_hd__fill_1_223 r0 *1 0,0
Xsky130_fd_sc_hd__fill_1_223
+ vss
+ vdd
+ vdd
+ sky130_fd_sc_hd__fill_1
* cell instance sky130_fd_sc_hd__fill_1_224 r0 *1 0,0
Xsky130_fd_sc_hd__fill_1_224
+ vss
+ vdd
+ vdd
+ sky130_fd_sc_hd__fill_1
* cell instance sky130_fd_sc_hd__fill_1_225 r0 *1 0,0
Xsky130_fd_sc_hd__fill_1_225
+ vss
+ vdd
+ vdd
+ sky130_fd_sc_hd__fill_1
* cell instance sky130_fd_sc_hd__fill_1_226 r0 *1 0,0
Xsky130_fd_sc_hd__fill_1_226
+ vss
+ vdd
+ vdd
+ sky130_fd_sc_hd__fill_1
* cell instance sky130_fd_sc_hd__fill_1_227 r0 *1 0,0
Xsky130_fd_sc_hd__fill_1_227
+ vss
+ vdd
+ vdd
+ sky130_fd_sc_hd__fill_1
* cell instance sky130_fd_sc_hd__fill_1_228 r0 *1 0,0
Xsky130_fd_sc_hd__fill_1_228
+ vss
+ vdd
+ vdd
+ sky130_fd_sc_hd__fill_1
* cell instance sky130_fd_sc_hd__fill_1_229 r0 *1 0,0
Xsky130_fd_sc_hd__fill_1_229
+ vss
+ vdd
+ vdd
+ sky130_fd_sc_hd__fill_1
* cell instance sky130_fd_sc_hd__fill_1_230 r0 *1 0,0
Xsky130_fd_sc_hd__fill_1_230
+ vss
+ vdd
+ vdd
+ sky130_fd_sc_hd__fill_1
* cell instance sky130_fd_sc_hd__fill_1_231 r0 *1 0,0
Xsky130_fd_sc_hd__fill_1_231
+ vss
+ vdd
+ vdd
+ sky130_fd_sc_hd__fill_1
* cell instance sky130_fd_sc_hd__fill_1_232 r0 *1 0,0
Xsky130_fd_sc_hd__fill_1_232
+ vss
+ vdd
+ vdd
+ sky130_fd_sc_hd__fill_1
* cell instance sky130_fd_sc_hd__fill_1_233 r0 *1 0,0
Xsky130_fd_sc_hd__fill_1_233
+ vss
+ vdd
+ vdd
+ sky130_fd_sc_hd__fill_1
* cell instance sky130_fd_sc_hd__fill_1_234 r0 *1 0,0
Xsky130_fd_sc_hd__fill_1_234
+ vss
+ vdd
+ vdd
+ sky130_fd_sc_hd__fill_1
* cell instance sky130_fd_sc_hd__fill_1_235 r0 *1 0,0
Xsky130_fd_sc_hd__fill_1_235
+ vss
+ vdd
+ vdd
+ sky130_fd_sc_hd__fill_1
* cell instance sky130_fd_sc_hd__fill_1_236 r0 *1 0,0
Xsky130_fd_sc_hd__fill_1_236
+ vss
+ vdd
+ vdd
+ sky130_fd_sc_hd__fill_1
* cell instance sky130_fd_sc_hd__fill_1_237 r0 *1 0,0
Xsky130_fd_sc_hd__fill_1_237
+ vss
+ vdd
+ vdd
+ sky130_fd_sc_hd__fill_1
* cell instance sky130_fd_sc_hd__fill_1_238 r0 *1 0,0
Xsky130_fd_sc_hd__fill_1_238
+ vss
+ vdd
+ vdd
+ sky130_fd_sc_hd__fill_1
* cell instance sky130_fd_sc_hd__fill_1_239 r0 *1 0,0
Xsky130_fd_sc_hd__fill_1_239
+ vss
+ vdd
+ vdd
+ sky130_fd_sc_hd__fill_1
* cell instance sky130_fd_sc_hd__fill_1_240 r0 *1 0,0
Xsky130_fd_sc_hd__fill_1_240
+ vss
+ vdd
+ vdd
+ sky130_fd_sc_hd__fill_1
* cell instance sky130_fd_sc_hd__fill_1_241 r0 *1 0,0
Xsky130_fd_sc_hd__fill_1_241
+ vss
+ vdd
+ vdd
+ sky130_fd_sc_hd__fill_1
* cell instance sky130_fd_sc_hd__fill_1_242 r0 *1 0,0
Xsky130_fd_sc_hd__fill_1_242
+ vss
+ vdd
+ vdd
+ sky130_fd_sc_hd__fill_1
* cell instance sky130_fd_sc_hd__fill_1_243 r0 *1 0,0
Xsky130_fd_sc_hd__fill_1_243
+ vss
+ vdd
+ vdd
+ sky130_fd_sc_hd__fill_1
* cell instance sky130_fd_sc_hd__fill_1_244 r0 *1 0,0
Xsky130_fd_sc_hd__fill_1_244
+ vss
+ vdd
+ vdd
+ sky130_fd_sc_hd__fill_1
* cell instance sky130_fd_sc_hd__fill_1_245 r0 *1 0,0
Xsky130_fd_sc_hd__fill_1_245
+ vss
+ vdd
+ vdd
+ sky130_fd_sc_hd__fill_1
* cell instance sky130_fd_sc_hd__fill_1_246 r0 *1 0,0
Xsky130_fd_sc_hd__fill_1_246
+ vss
+ vdd
+ vdd
+ sky130_fd_sc_hd__fill_1
* cell instance sky130_fd_sc_hd__fill_1_247 r0 *1 0,0
Xsky130_fd_sc_hd__fill_1_247
+ vss
+ vdd
+ vdd
+ sky130_fd_sc_hd__fill_1
* cell instance sky130_fd_sc_hd__fill_1_248 r0 *1 0,0
Xsky130_fd_sc_hd__fill_1_248
+ vss
+ vdd
+ vdd
+ sky130_fd_sc_hd__fill_1
* cell instance sky130_fd_sc_hd__fill_1_249 r0 *1 0,0
Xsky130_fd_sc_hd__fill_1_249
+ vss
+ vdd
+ vdd
+ sky130_fd_sc_hd__fill_1
* cell instance sky130_fd_sc_hd__fill_1_250 r0 *1 0,0
Xsky130_fd_sc_hd__fill_1_250
+ vss
+ vdd
+ vdd
+ sky130_fd_sc_hd__fill_1
* cell instance sky130_fd_sc_hd__fill_1_251 r0 *1 0,0
Xsky130_fd_sc_hd__fill_1_251
+ vss
+ vdd
+ vdd
+ sky130_fd_sc_hd__fill_1
* cell instance sky130_fd_sc_hd__fill_1_252 r0 *1 0,0
Xsky130_fd_sc_hd__fill_1_252
+ vss
+ vdd
+ vdd
+ sky130_fd_sc_hd__fill_1
* cell instance sky130_fd_sc_hd__fill_1_253 r0 *1 0,0
Xsky130_fd_sc_hd__fill_1_253
+ vss
+ vdd
+ vdd
+ sky130_fd_sc_hd__fill_1
* cell instance sky130_fd_sc_hd__fill_1_254 r0 *1 0,0
Xsky130_fd_sc_hd__fill_1_254
+ vss
+ vdd
+ vdd
+ sky130_fd_sc_hd__fill_1
* cell instance sky130_fd_sc_hd__fill_1_255 r0 *1 0,0
Xsky130_fd_sc_hd__fill_1_255
+ vss
+ vdd
+ vdd
+ sky130_fd_sc_hd__fill_1
* cell instance sky130_fd_sc_hd__fill_1_256 r0 *1 0,0
Xsky130_fd_sc_hd__fill_1_256
+ vss
+ vdd
+ vdd
+ sky130_fd_sc_hd__fill_1
* cell instance sky130_fd_sc_hd__fill_1_257 r0 *1 0,0
Xsky130_fd_sc_hd__fill_1_257
+ vss
+ vdd
+ vdd
+ sky130_fd_sc_hd__fill_1
* cell instance sky130_fd_sc_hd__fill_1_258 r0 *1 0,0
Xsky130_fd_sc_hd__fill_1_258
+ vss
+ vdd
+ vdd
+ sky130_fd_sc_hd__fill_1
* cell instance sky130_fd_sc_hd__fill_1_259 r0 *1 0,0
Xsky130_fd_sc_hd__fill_1_259
+ vss
+ vdd
+ vdd
+ sky130_fd_sc_hd__fill_1
* cell instance sky130_fd_sc_hd__fill_1_260 r0 *1 0,0
Xsky130_fd_sc_hd__fill_1_260
+ vss
+ vdd
+ vdd
+ sky130_fd_sc_hd__fill_1
* cell instance sky130_fd_sc_hd__fill_1_261 r0 *1 0,0
Xsky130_fd_sc_hd__fill_1_261
+ vss
+ vdd
+ vdd
+ sky130_fd_sc_hd__fill_1
* cell instance sky130_fd_sc_hd__fill_1_262 r0 *1 0,0
Xsky130_fd_sc_hd__fill_1_262
+ vss
+ vdd
+ vdd
+ sky130_fd_sc_hd__fill_1
* cell instance sky130_fd_sc_hd__fill_1_263 r0 *1 0,0
Xsky130_fd_sc_hd__fill_1_263
+ vss
+ vdd
+ vdd
+ sky130_fd_sc_hd__fill_1
* cell instance sky130_fd_sc_hd__fill_1_264 r0 *1 0,0
Xsky130_fd_sc_hd__fill_1_264
+ vss
+ vdd
+ vdd
+ sky130_fd_sc_hd__fill_1
* cell instance sky130_fd_sc_hd__fill_1_265 r0 *1 0,0
Xsky130_fd_sc_hd__fill_1_265
+ vss
+ vdd
+ vdd
+ sky130_fd_sc_hd__fill_1
* cell instance sky130_fd_sc_hd__fill_1_266 r0 *1 0,0
Xsky130_fd_sc_hd__fill_1_266
+ vss
+ vdd
+ vdd
+ sky130_fd_sc_hd__fill_1
* cell instance sky130_fd_sc_hd__fill_1_267 r0 *1 0,0
Xsky130_fd_sc_hd__fill_1_267
+ vss
+ vdd
+ vdd
+ sky130_fd_sc_hd__fill_1
* cell instance sky130_fd_sc_hd__fill_1_268 r0 *1 0,0
Xsky130_fd_sc_hd__fill_1_268
+ vss
+ vdd
+ vdd
+ sky130_fd_sc_hd__fill_1
* cell instance sky130_fd_sc_hd__fill_1_269 r0 *1 0,0
Xsky130_fd_sc_hd__fill_1_269
+ vss
+ vdd
+ vdd
+ sky130_fd_sc_hd__fill_1
* cell instance sky130_fd_sc_hd__fill_1_270 r0 *1 0,0
Xsky130_fd_sc_hd__fill_1_270
+ vss
+ vdd
+ vdd
+ sky130_fd_sc_hd__fill_1
* cell instance sky130_fd_sc_hd__fill_1_271 r0 *1 0,0
Xsky130_fd_sc_hd__fill_1_271
+ vss
+ vdd
+ vdd
+ sky130_fd_sc_hd__fill_1
* cell instance sky130_fd_sc_hd__fill_1_272 r0 *1 0,0
Xsky130_fd_sc_hd__fill_1_272
+ vss
+ vdd
+ vdd
+ sky130_fd_sc_hd__fill_1
* cell instance sky130_fd_sc_hd__fill_1_273 r0 *1 0,0
Xsky130_fd_sc_hd__fill_1_273
+ vss
+ vdd
+ vdd
+ sky130_fd_sc_hd__fill_1
* cell instance sky130_fd_sc_hd__fill_1_274 r0 *1 0,0
Xsky130_fd_sc_hd__fill_1_274
+ vss
+ vdd
+ vdd
+ sky130_fd_sc_hd__fill_1
* cell instance sky130_fd_sc_hd__fill_1_275 r0 *1 0,0
Xsky130_fd_sc_hd__fill_1_275
+ vss
+ vdd
+ vdd
+ sky130_fd_sc_hd__fill_1
* cell instance sky130_fd_sc_hd__fill_1_276 r0 *1 0,0
Xsky130_fd_sc_hd__fill_1_276
+ vss
+ vdd
+ vdd
+ sky130_fd_sc_hd__fill_1
* cell instance sky130_fd_sc_hd__fill_1_277 r0 *1 0,0
Xsky130_fd_sc_hd__fill_1_277
+ vss
+ vdd
+ vdd
+ sky130_fd_sc_hd__fill_1
* cell instance sky130_fd_sc_hd__fill_1_278 r0 *1 0,0
Xsky130_fd_sc_hd__fill_1_278
+ vss
+ vdd
+ vdd
+ sky130_fd_sc_hd__fill_1
* cell instance sky130_fd_sc_hd__fill_1_279 r0 *1 0,0
Xsky130_fd_sc_hd__fill_1_279
+ vss
+ vdd
+ vdd
+ sky130_fd_sc_hd__fill_1
* cell instance sky130_fd_sc_hd__fill_1_280 r0 *1 0,0
Xsky130_fd_sc_hd__fill_1_280
+ vss
+ vdd
+ vdd
+ sky130_fd_sc_hd__fill_1
* cell instance sky130_fd_sc_hd__fill_1_281 r0 *1 0,0
Xsky130_fd_sc_hd__fill_1_281
+ vss
+ vdd
+ vdd
+ sky130_fd_sc_hd__fill_1
* cell instance sky130_fd_sc_hd__fill_1_282 r0 *1 0,0
Xsky130_fd_sc_hd__fill_1_282
+ vss
+ vdd
+ vdd
+ sky130_fd_sc_hd__fill_1
* cell instance sky130_fd_sc_hd__fill_1_283 r0 *1 0,0
Xsky130_fd_sc_hd__fill_1_283
+ vss
+ vdd
+ vdd
+ sky130_fd_sc_hd__fill_1
* cell instance sky130_fd_sc_hd__fill_1_284 r0 *1 0,0
Xsky130_fd_sc_hd__fill_1_284
+ vss
+ vdd
+ vdd
+ sky130_fd_sc_hd__fill_1
* cell instance sky130_fd_sc_hd__fill_1_285 r0 *1 0,0
Xsky130_fd_sc_hd__fill_1_285
+ vss
+ vdd
+ vdd
+ sky130_fd_sc_hd__fill_1
* cell instance sky130_fd_sc_hd__fill_1_286 r0 *1 0,0
Xsky130_fd_sc_hd__fill_1_286
+ vss
+ vdd
+ vdd
+ sky130_fd_sc_hd__fill_1
* cell instance sky130_fd_sc_hd__fill_1_287 r0 *1 0,0
Xsky130_fd_sc_hd__fill_1_287
+ vss
+ vdd
+ vdd
+ sky130_fd_sc_hd__fill_1
* cell instance sky130_fd_sc_hd__fill_1_288 r0 *1 0,0
Xsky130_fd_sc_hd__fill_1_288
+ vss
+ vdd
+ vdd
+ sky130_fd_sc_hd__fill_1
* cell instance sky130_fd_sc_hd__fill_1_289 r0 *1 0,0
Xsky130_fd_sc_hd__fill_1_289
+ vss
+ vdd
+ vdd
+ sky130_fd_sc_hd__fill_1
* cell instance sky130_fd_sc_hd__fill_1_290 r0 *1 0,0
Xsky130_fd_sc_hd__fill_1_290
+ vss
+ vdd
+ vdd
+ sky130_fd_sc_hd__fill_1
* cell instance sky130_fd_sc_hd__fill_1_291 r0 *1 0,0
Xsky130_fd_sc_hd__fill_1_291
+ vss
+ vdd
+ vdd
+ sky130_fd_sc_hd__fill_1
* cell instance sky130_fd_sc_hd__fill_1_292 r0 *1 0,0
Xsky130_fd_sc_hd__fill_1_292
+ vss
+ vdd
+ vdd
+ sky130_fd_sc_hd__fill_1
* cell instance sky130_fd_sc_hd__fill_1_293 r0 *1 0,0
Xsky130_fd_sc_hd__fill_1_293
+ vss
+ vdd
+ vdd
+ sky130_fd_sc_hd__fill_1
* cell instance sky130_fd_sc_hd__fill_1_294 r0 *1 0,0
Xsky130_fd_sc_hd__fill_1_294
+ vss
+ vdd
+ vdd
+ sky130_fd_sc_hd__fill_1
* cell instance sky130_fd_sc_hd__fill_1_295 r0 *1 0,0
Xsky130_fd_sc_hd__fill_1_295
+ vss
+ vdd
+ vdd
+ sky130_fd_sc_hd__fill_1
* cell instance sky130_fd_sc_hd__fill_1_296 r0 *1 0,0
Xsky130_fd_sc_hd__fill_1_296
+ vss
+ vdd
+ vdd
+ sky130_fd_sc_hd__fill_1
* cell instance sky130_fd_sc_hd__fill_1_297 r0 *1 0,0
Xsky130_fd_sc_hd__fill_1_297
+ vss
+ vdd
+ vdd
+ sky130_fd_sc_hd__fill_1
* cell instance sky130_fd_sc_hd__fill_1_298 r0 *1 0,0
Xsky130_fd_sc_hd__fill_1_298
+ vss
+ vdd
+ vdd
+ sky130_fd_sc_hd__fill_1
* cell instance sky130_fd_sc_hd__fill_1_299 r0 *1 0,0
Xsky130_fd_sc_hd__fill_1_299
+ vss
+ vdd
+ vdd
+ sky130_fd_sc_hd__fill_1
* cell instance sky130_fd_sc_hd__fill_1_300 r0 *1 0,0
Xsky130_fd_sc_hd__fill_1_300
+ vss
+ vdd
+ vdd
+ sky130_fd_sc_hd__fill_1
* cell instance sky130_fd_sc_hd__fill_1_301 r0 *1 0,0
Xsky130_fd_sc_hd__fill_1_301
+ vss
+ vdd
+ vdd
+ sky130_fd_sc_hd__fill_1
* cell instance sky130_fd_sc_hd__fill_1_302 r0 *1 0,0
Xsky130_fd_sc_hd__fill_1_302
+ vss
+ vdd
+ vdd
+ sky130_fd_sc_hd__fill_1
* cell instance sky130_fd_sc_hd__fill_1_303 r0 *1 0,0
Xsky130_fd_sc_hd__fill_1_303
+ vss
+ vdd
+ vdd
+ sky130_fd_sc_hd__fill_1
* cell instance sky130_fd_sc_hd__fill_1_304 r0 *1 0,0
Xsky130_fd_sc_hd__fill_1_304
+ vss
+ vdd
+ vdd
+ sky130_fd_sc_hd__fill_1
* cell instance sky130_fd_sc_hd__fill_1_305 r0 *1 0,0
Xsky130_fd_sc_hd__fill_1_305
+ vss
+ vdd
+ vdd
+ sky130_fd_sc_hd__fill_1
* cell instance sky130_fd_sc_hd__fill_1_306 r0 *1 0,0
Xsky130_fd_sc_hd__fill_1_306
+ vss
+ vdd
+ vdd
+ sky130_fd_sc_hd__fill_1
* cell instance sky130_fd_sc_hd__fill_1_307 r0 *1 0,0
Xsky130_fd_sc_hd__fill_1_307
+ vss
+ vdd
+ vdd
+ sky130_fd_sc_hd__fill_1
* cell instance sky130_fd_sc_hd__fill_1_308 r0 *1 0,0
Xsky130_fd_sc_hd__fill_1_308
+ vss
+ vdd
+ vdd
+ sky130_fd_sc_hd__fill_1
* cell instance sky130_fd_sc_hd__fill_1_309 r0 *1 0,0
Xsky130_fd_sc_hd__fill_1_309
+ vss
+ vdd
+ vdd
+ sky130_fd_sc_hd__fill_1
* cell instance sky130_fd_sc_hd__fill_1_310 r0 *1 0,0
Xsky130_fd_sc_hd__fill_1_310
+ vss
+ vdd
+ vdd
+ sky130_fd_sc_hd__fill_1
* cell instance sky130_fd_sc_hd__fill_1_311 r0 *1 0,0
Xsky130_fd_sc_hd__fill_1_311
+ vss
+ vdd
+ vdd
+ sky130_fd_sc_hd__fill_1
* cell instance sky130_fd_sc_hd__fill_1_312 r0 *1 0,0
Xsky130_fd_sc_hd__fill_1_312
+ vss
+ vdd
+ vdd
+ sky130_fd_sc_hd__fill_1
* cell instance sky130_fd_sc_hd__fill_1_313 r0 *1 0,0
Xsky130_fd_sc_hd__fill_1_313
+ vss
+ vdd
+ vdd
+ sky130_fd_sc_hd__fill_1
* cell instance sky130_fd_sc_hd__fill_1_314 r0 *1 0,0
Xsky130_fd_sc_hd__fill_1_314
+ vss
+ vdd
+ vdd
+ sky130_fd_sc_hd__fill_1
* cell instance sky130_fd_sc_hd__fill_1_315 r0 *1 0,0
Xsky130_fd_sc_hd__fill_1_315
+ vss
+ vdd
+ vdd
+ sky130_fd_sc_hd__fill_1
* cell instance sky130_fd_sc_hd__fill_1_316 r0 *1 0,0
Xsky130_fd_sc_hd__fill_1_316
+ vss
+ vdd
+ vdd
+ sky130_fd_sc_hd__fill_1
* cell instance sky130_fd_sc_hd__fill_1_317 r0 *1 0,0
Xsky130_fd_sc_hd__fill_1_317
+ vss
+ vdd
+ vdd
+ sky130_fd_sc_hd__fill_1
* cell instance sky130_fd_sc_hd__fill_1_318 r0 *1 0,0
Xsky130_fd_sc_hd__fill_1_318
+ vss
+ vdd
+ vdd
+ sky130_fd_sc_hd__fill_1
* cell instance sky130_fd_sc_hd__fill_1_319 r0 *1 0,0
Xsky130_fd_sc_hd__fill_1_319
+ vss
+ vdd
+ vdd
+ sky130_fd_sc_hd__fill_1
* cell instance sky130_fd_sc_hd__fill_1_320 r0 *1 0,0
Xsky130_fd_sc_hd__fill_1_320
+ vss
+ vdd
+ vdd
+ sky130_fd_sc_hd__fill_1
* cell instance sky130_fd_sc_hd__fill_1_321 r0 *1 0,0
Xsky130_fd_sc_hd__fill_1_321
+ vss
+ vdd
+ vdd
+ sky130_fd_sc_hd__fill_1
* cell instance sky130_fd_sc_hd__fill_1_322 r0 *1 0,0
Xsky130_fd_sc_hd__fill_1_322
+ vss
+ vdd
+ vdd
+ sky130_fd_sc_hd__fill_1
* cell instance sky130_fd_sc_hd__fill_1_323 r0 *1 0,0
Xsky130_fd_sc_hd__fill_1_323
+ vss
+ vdd
+ vdd
+ sky130_fd_sc_hd__fill_1
* cell instance sky130_fd_sc_hd__fill_1_324 r0 *1 0,0
Xsky130_fd_sc_hd__fill_1_324
+ vss
+ vdd
+ vdd
+ sky130_fd_sc_hd__fill_1
* cell instance sky130_fd_sc_hd__fill_1_325 r0 *1 0,0
Xsky130_fd_sc_hd__fill_1_325
+ vss
+ vdd
+ vdd
+ sky130_fd_sc_hd__fill_1
* cell instance sky130_fd_sc_hd__fill_1_326 r0 *1 0,0
Xsky130_fd_sc_hd__fill_1_326
+ vss
+ vdd
+ vdd
+ sky130_fd_sc_hd__fill_1
* cell instance sky130_fd_sc_hd__fill_1_327 r0 *1 0,0
Xsky130_fd_sc_hd__fill_1_327
+ vss
+ vdd
+ vdd
+ sky130_fd_sc_hd__fill_1
* cell instance sky130_fd_sc_hd__fill_1_328 r0 *1 0,0
Xsky130_fd_sc_hd__fill_1_328
+ vss
+ vdd
+ vdd
+ sky130_fd_sc_hd__fill_1
* cell instance sky130_fd_sc_hd__fill_1_329 r0 *1 0,0
Xsky130_fd_sc_hd__fill_1_329
+ vss
+ vdd
+ vdd
+ sky130_fd_sc_hd__fill_1
* cell instance sky130_fd_sc_hd__fill_1_330 r0 *1 0,0
Xsky130_fd_sc_hd__fill_1_330
+ vss
+ vdd
+ vdd
+ sky130_fd_sc_hd__fill_1
* cell instance sky130_fd_sc_hd__fill_1_331 r0 *1 0,0
Xsky130_fd_sc_hd__fill_1_331
+ vss
+ vdd
+ vdd
+ sky130_fd_sc_hd__fill_1
* cell instance sky130_fd_sc_hd__fill_1_332 r0 *1 0,0
Xsky130_fd_sc_hd__fill_1_332
+ vss
+ vdd
+ vdd
+ sky130_fd_sc_hd__fill_1
* cell instance sky130_fd_sc_hd__fill_1_333 r0 *1 0,0
Xsky130_fd_sc_hd__fill_1_333
+ vss
+ vdd
+ vdd
+ sky130_fd_sc_hd__fill_1
* cell instance sky130_fd_sc_hd__fill_1_334 r0 *1 0,0
Xsky130_fd_sc_hd__fill_1_334
+ vss
+ vdd
+ vdd
+ sky130_fd_sc_hd__fill_1
* cell instance sky130_fd_sc_hd__fill_1_335 r0 *1 0,0
Xsky130_fd_sc_hd__fill_1_335
+ vss
+ vdd
+ vdd
+ sky130_fd_sc_hd__fill_1
* cell instance sky130_fd_sc_hd__fill_1_336 r0 *1 0,0
Xsky130_fd_sc_hd__fill_1_336
+ vss
+ vdd
+ vdd
+ sky130_fd_sc_hd__fill_1
* cell instance sky130_fd_sc_hd__fill_1_337 r0 *1 0,0
Xsky130_fd_sc_hd__fill_1_337
+ vss
+ vdd
+ vdd
+ sky130_fd_sc_hd__fill_1
* cell instance sky130_fd_sc_hd__fill_1_338 r0 *1 0,0
Xsky130_fd_sc_hd__fill_1_338
+ vss
+ vdd
+ vdd
+ sky130_fd_sc_hd__fill_1
* cell instance sky130_fd_sc_hd__fill_1_339 r0 *1 0,0
Xsky130_fd_sc_hd__fill_1_339
+ vss
+ vdd
+ vdd
+ sky130_fd_sc_hd__fill_1
* cell instance sky130_fd_sc_hd__fill_1_340 r0 *1 0,0
Xsky130_fd_sc_hd__fill_1_340
+ vss
+ vdd
+ vdd
+ sky130_fd_sc_hd__fill_1
* cell instance sky130_fd_sc_hd__fill_1_341 r0 *1 0,0
Xsky130_fd_sc_hd__fill_1_341
+ vss
+ vdd
+ vdd
+ sky130_fd_sc_hd__fill_1
* cell instance sky130_fd_sc_hd__fill_1_342 r0 *1 0,0
Xsky130_fd_sc_hd__fill_1_342
+ vss
+ vdd
+ vdd
+ sky130_fd_sc_hd__fill_1
* cell instance sky130_fd_sc_hd__fill_1_343 r0 *1 0,0
Xsky130_fd_sc_hd__fill_1_343
+ vss
+ vdd
+ vdd
+ sky130_fd_sc_hd__fill_1
* cell instance sky130_fd_sc_hd__fill_1_344 r0 *1 0,0
Xsky130_fd_sc_hd__fill_1_344
+ vss
+ vdd
+ vdd
+ sky130_fd_sc_hd__fill_1
* cell instance sky130_fd_sc_hd__fill_1_345 r0 *1 0,0
Xsky130_fd_sc_hd__fill_1_345
+ vss
+ vdd
+ vdd
+ sky130_fd_sc_hd__fill_1
* cell instance sky130_fd_sc_hd__fill_1_346 r0 *1 0,0
Xsky130_fd_sc_hd__fill_1_346
+ vss
+ vdd
+ vdd
+ sky130_fd_sc_hd__fill_1
* cell instance sky130_fd_sc_hd__fill_1_347 r0 *1 0,0
Xsky130_fd_sc_hd__fill_1_347
+ vss
+ vdd
+ vdd
+ sky130_fd_sc_hd__fill_1
* cell instance sky130_fd_sc_hd__fill_1_348 r0 *1 0,0
Xsky130_fd_sc_hd__fill_1_348
+ vss
+ vdd
+ vdd
+ sky130_fd_sc_hd__fill_1
* cell instance sky130_fd_sc_hd__fill_1_349 r0 *1 0,0
Xsky130_fd_sc_hd__fill_1_349
+ vss
+ vdd
+ vdd
+ sky130_fd_sc_hd__fill_1
* cell instance sky130_fd_sc_hd__fill_1_350 r0 *1 0,0
Xsky130_fd_sc_hd__fill_1_350
+ vss
+ vdd
+ vdd
+ sky130_fd_sc_hd__fill_1
* cell instance sky130_fd_sc_hd__fill_1_351 r0 *1 0,0
Xsky130_fd_sc_hd__fill_1_351
+ vss
+ vdd
+ vdd
+ sky130_fd_sc_hd__fill_1
* cell instance sky130_fd_sc_hd__fill_1_352 r0 *1 0,0
Xsky130_fd_sc_hd__fill_1_352
+ vss
+ vdd
+ vdd
+ sky130_fd_sc_hd__fill_1
* cell instance sky130_fd_sc_hd__fill_1_353 r0 *1 0,0
Xsky130_fd_sc_hd__fill_1_353
+ vss
+ vdd
+ vdd
+ sky130_fd_sc_hd__fill_1
* cell instance sky130_fd_sc_hd__fill_1_354 r0 *1 0,0
Xsky130_fd_sc_hd__fill_1_354
+ vss
+ vdd
+ vdd
+ sky130_fd_sc_hd__fill_1
* cell instance sky130_fd_sc_hd__fill_1_355 r0 *1 0,0
Xsky130_fd_sc_hd__fill_1_355
+ vss
+ vdd
+ vdd
+ sky130_fd_sc_hd__fill_1
* cell instance sky130_fd_sc_hd__fill_1_356 r0 *1 0,0
Xsky130_fd_sc_hd__fill_1_356
+ vss
+ vdd
+ vdd
+ sky130_fd_sc_hd__fill_1
* cell instance sky130_fd_sc_hd__fill_1_357 r0 *1 0,0
Xsky130_fd_sc_hd__fill_1_357
+ vss
+ vdd
+ vdd
+ sky130_fd_sc_hd__fill_1
* cell instance sky130_fd_sc_hd__fill_1_358 r0 *1 0,0
Xsky130_fd_sc_hd__fill_1_358
+ vss
+ vdd
+ vdd
+ sky130_fd_sc_hd__fill_1
* cell instance sky130_fd_sc_hd__fill_1_359 r0 *1 0,0
Xsky130_fd_sc_hd__fill_1_359
+ vss
+ vdd
+ vdd
+ sky130_fd_sc_hd__fill_1
* cell instance sky130_fd_sc_hd__fill_1_360 r0 *1 0,0
Xsky130_fd_sc_hd__fill_1_360
+ vss
+ vdd
+ vdd
+ sky130_fd_sc_hd__fill_1
* cell instance sky130_fd_sc_hd__fill_1_361 r0 *1 0,0
Xsky130_fd_sc_hd__fill_1_361
+ vss
+ vdd
+ vdd
+ sky130_fd_sc_hd__fill_1
* cell instance sky130_fd_sc_hd__fill_1_362 r0 *1 0,0
Xsky130_fd_sc_hd__fill_1_362
+ vss
+ vdd
+ vdd
+ sky130_fd_sc_hd__fill_1
* cell instance sky130_fd_sc_hd__fill_1_363 r0 *1 0,0
Xsky130_fd_sc_hd__fill_1_363
+ vss
+ vdd
+ vdd
+ sky130_fd_sc_hd__fill_1
* cell instance sky130_fd_sc_hd__fill_1_364 r0 *1 0,0
Xsky130_fd_sc_hd__fill_1_364
+ vss
+ vdd
+ vdd
+ sky130_fd_sc_hd__fill_1
* cell instance sky130_fd_sc_hd__fill_1_365 r0 *1 0,0
Xsky130_fd_sc_hd__fill_1_365
+ vss
+ vdd
+ vdd
+ sky130_fd_sc_hd__fill_1
* cell instance sky130_fd_sc_hd__fill_1_366 r0 *1 0,0
Xsky130_fd_sc_hd__fill_1_366
+ vss
+ vdd
+ vdd
+ sky130_fd_sc_hd__fill_1
* cell instance sky130_fd_sc_hd__fill_1_367 r0 *1 0,0
Xsky130_fd_sc_hd__fill_1_367
+ vss
+ vdd
+ vdd
+ sky130_fd_sc_hd__fill_1
* cell instance sky130_fd_sc_hd__fill_1_368 r0 *1 0,0
Xsky130_fd_sc_hd__fill_1_368
+ vss
+ vdd
+ vdd
+ sky130_fd_sc_hd__fill_1
* cell instance sky130_fd_sc_hd__fill_1_369 r0 *1 0,0
Xsky130_fd_sc_hd__fill_1_369
+ vss
+ vdd
+ vdd
+ sky130_fd_sc_hd__fill_1
* cell instance sky130_fd_sc_hd__fill_1_370 r0 *1 0,0
Xsky130_fd_sc_hd__fill_1_370
+ vss
+ vdd
+ vdd
+ sky130_fd_sc_hd__fill_1
* cell instance sky130_fd_sc_hd__fill_1_371 r0 *1 0,0
Xsky130_fd_sc_hd__fill_1_371
+ vss
+ vdd
+ vdd
+ sky130_fd_sc_hd__fill_1
* cell instance sky130_fd_sc_hd__fill_1_372 r0 *1 0,0
Xsky130_fd_sc_hd__fill_1_372
+ vss
+ vdd
+ vdd
+ sky130_fd_sc_hd__fill_1
* cell instance sky130_fd_sc_hd__fill_1_373 r0 *1 0,0
Xsky130_fd_sc_hd__fill_1_373
+ vss
+ vdd
+ vdd
+ sky130_fd_sc_hd__fill_1
* cell instance sky130_fd_sc_hd__fill_1_374 r0 *1 0,0
Xsky130_fd_sc_hd__fill_1_374
+ vss
+ vdd
+ vdd
+ sky130_fd_sc_hd__fill_1
* cell instance sky130_fd_sc_hd__fill_1_375 r0 *1 0,0
Xsky130_fd_sc_hd__fill_1_375
+ vss
+ vdd
+ vdd
+ sky130_fd_sc_hd__fill_1
* cell instance sky130_fd_sc_hd__fill_1_376 r0 *1 0,0
Xsky130_fd_sc_hd__fill_1_376
+ vss
+ vdd
+ vdd
+ sky130_fd_sc_hd__fill_1
* cell instance sky130_fd_sc_hd__fill_1_377 r0 *1 0,0
Xsky130_fd_sc_hd__fill_1_377
+ vss
+ vdd
+ vdd
+ sky130_fd_sc_hd__fill_1
* cell instance sky130_fd_sc_hd__fill_1_378 r0 *1 0,0
Xsky130_fd_sc_hd__fill_1_378
+ vss
+ vdd
+ vdd
+ sky130_fd_sc_hd__fill_1
* cell instance sky130_fd_sc_hd__fill_1_379 r0 *1 0,0
Xsky130_fd_sc_hd__fill_1_379
+ vss
+ vdd
+ vdd
+ sky130_fd_sc_hd__fill_1
* cell instance sky130_fd_sc_hd__fill_1_380 r0 *1 0,0
Xsky130_fd_sc_hd__fill_1_380
+ vss
+ vdd
+ vdd
+ sky130_fd_sc_hd__fill_1
* cell instance sky130_fd_sc_hd__fill_1_381 r0 *1 0,0
Xsky130_fd_sc_hd__fill_1_381
+ vss
+ vdd
+ vdd
+ sky130_fd_sc_hd__fill_1
* cell instance sky130_fd_sc_hd__fill_1_382 r0 *1 0,0
Xsky130_fd_sc_hd__fill_1_382
+ vss
+ vdd
+ vdd
+ sky130_fd_sc_hd__fill_1
* cell instance sky130_fd_sc_hd__fill_1_383 r0 *1 0,0
Xsky130_fd_sc_hd__fill_1_383
+ vss
+ vdd
+ vdd
+ sky130_fd_sc_hd__fill_1
* cell instance sky130_fd_sc_hd__fill_1_384 r0 *1 0,0
Xsky130_fd_sc_hd__fill_1_384
+ vss
+ vdd
+ vdd
+ sky130_fd_sc_hd__fill_1
* cell instance sky130_fd_sc_hd__fill_1_385 r0 *1 0,0
Xsky130_fd_sc_hd__fill_1_385
+ vss
+ vdd
+ vdd
+ sky130_fd_sc_hd__fill_1
* cell instance sky130_fd_sc_hd__fill_1_386 r0 *1 0,0
Xsky130_fd_sc_hd__fill_1_386
+ vss
+ vdd
+ vdd
+ sky130_fd_sc_hd__fill_1
* cell instance sky130_fd_sc_hd__fill_1_387 r0 *1 0,0
Xsky130_fd_sc_hd__fill_1_387
+ vss
+ vdd
+ vdd
+ sky130_fd_sc_hd__fill_1
* cell instance sky130_fd_sc_hd__fill_1_388 r0 *1 0,0
Xsky130_fd_sc_hd__fill_1_388
+ vss
+ vdd
+ vdd
+ sky130_fd_sc_hd__fill_1
* cell instance sky130_fd_sc_hd__fill_1_389 r0 *1 0,0
Xsky130_fd_sc_hd__fill_1_389
+ vss
+ vdd
+ vdd
+ sky130_fd_sc_hd__fill_1
* cell instance sky130_fd_sc_hd__fill_1_390 r0 *1 0,0
Xsky130_fd_sc_hd__fill_1_390
+ vss
+ vdd
+ vdd
+ sky130_fd_sc_hd__fill_1
* cell instance sky130_fd_sc_hd__fill_1_391 r0 *1 0,0
Xsky130_fd_sc_hd__fill_1_391
+ vss
+ vdd
+ vdd
+ sky130_fd_sc_hd__fill_1
* cell instance sky130_fd_sc_hd__fill_1_392 r0 *1 0,0
Xsky130_fd_sc_hd__fill_1_392
+ vss
+ vdd
+ vdd
+ sky130_fd_sc_hd__fill_1
* cell instance sky130_fd_sc_hd__fill_1_393 r0 *1 0,0
Xsky130_fd_sc_hd__fill_1_393
+ vss
+ vdd
+ vdd
+ sky130_fd_sc_hd__fill_1
* cell instance sky130_fd_sc_hd__fill_1_394 r0 *1 0,0
Xsky130_fd_sc_hd__fill_1_394
+ vss
+ vdd
+ vdd
+ sky130_fd_sc_hd__fill_1
* cell instance sky130_fd_sc_hd__fill_1_395 r0 *1 0,0
Xsky130_fd_sc_hd__fill_1_395
+ vss
+ vdd
+ vdd
+ sky130_fd_sc_hd__fill_1
* cell instance sky130_fd_sc_hd__fill_1_396 r0 *1 0,0
Xsky130_fd_sc_hd__fill_1_396
+ vss
+ vdd
+ vdd
+ sky130_fd_sc_hd__fill_1
* cell instance sky130_fd_sc_hd__fill_1_397 r0 *1 0,0
Xsky130_fd_sc_hd__fill_1_397
+ vss
+ vdd
+ vdd
+ sky130_fd_sc_hd__fill_1
* cell instance sky130_fd_sc_hd__fill_1_398 r0 *1 0,0
Xsky130_fd_sc_hd__fill_1_398
+ vss
+ vdd
+ vdd
+ sky130_fd_sc_hd__fill_1
* cell instance sky130_fd_sc_hd__fill_1_399 r0 *1 0,0
Xsky130_fd_sc_hd__fill_1_399
+ vss
+ vdd
+ vdd
+ sky130_fd_sc_hd__fill_1
* cell instance sky130_fd_sc_hd__fill_1_400 r0 *1 0,0
Xsky130_fd_sc_hd__fill_1_400
+ vss
+ vdd
+ vdd
+ sky130_fd_sc_hd__fill_1
* cell instance sky130_fd_sc_hd__fill_1_401 r0 *1 0,0
Xsky130_fd_sc_hd__fill_1_401
+ vss
+ vdd
+ vdd
+ sky130_fd_sc_hd__fill_1
* cell instance sky130_fd_sc_hd__fill_1_402 r0 *1 0,0
Xsky130_fd_sc_hd__fill_1_402
+ vss
+ vdd
+ vdd
+ sky130_fd_sc_hd__fill_1
* cell instance sky130_fd_sc_hd__fill_1_403 r0 *1 0,0
Xsky130_fd_sc_hd__fill_1_403
+ vss
+ vdd
+ vdd
+ sky130_fd_sc_hd__fill_1
* cell instance sky130_fd_sc_hd__fill_1_404 r0 *1 0,0
Xsky130_fd_sc_hd__fill_1_404
+ vss
+ vdd
+ vdd
+ sky130_fd_sc_hd__fill_1
* cell instance sky130_fd_sc_hd__fill_1_405 r0 *1 0,0
Xsky130_fd_sc_hd__fill_1_405
+ vss
+ vdd
+ vdd
+ sky130_fd_sc_hd__fill_1
* cell instance sky130_fd_sc_hd__fill_1_406 r0 *1 0,0
Xsky130_fd_sc_hd__fill_1_406
+ vss
+ vdd
+ vdd
+ sky130_fd_sc_hd__fill_1
* cell instance sky130_fd_sc_hd__fill_1_407 r0 *1 0,0
Xsky130_fd_sc_hd__fill_1_407
+ vss
+ vdd
+ vdd
+ sky130_fd_sc_hd__fill_1
* cell instance sky130_fd_sc_hd__fill_1_408 r0 *1 0,0
Xsky130_fd_sc_hd__fill_1_408
+ vss
+ vdd
+ vdd
+ sky130_fd_sc_hd__fill_1
* cell instance sky130_fd_sc_hd__fill_1_409 r0 *1 0,0
Xsky130_fd_sc_hd__fill_1_409
+ vss
+ vdd
+ vdd
+ sky130_fd_sc_hd__fill_1
* cell instance sky130_fd_sc_hd__fill_1_410 r0 *1 0,0
Xsky130_fd_sc_hd__fill_1_410
+ vss
+ vdd
+ vdd
+ sky130_fd_sc_hd__fill_1
* cell instance sky130_fd_sc_hd__fill_1_411 r0 *1 0,0
Xsky130_fd_sc_hd__fill_1_411
+ vss
+ vdd
+ vdd
+ sky130_fd_sc_hd__fill_1
* cell instance sky130_fd_sc_hd__fill_1_412 r0 *1 0,0
Xsky130_fd_sc_hd__fill_1_412
+ vss
+ vdd
+ vdd
+ sky130_fd_sc_hd__fill_1
* cell instance sky130_fd_sc_hd__fill_1_413 r0 *1 0,0
Xsky130_fd_sc_hd__fill_1_413
+ vss
+ vdd
+ vdd
+ sky130_fd_sc_hd__fill_1
* cell instance sky130_fd_sc_hd__fill_1_414 r0 *1 0,0
Xsky130_fd_sc_hd__fill_1_414
+ vss
+ vdd
+ vdd
+ sky130_fd_sc_hd__fill_1
* cell instance sky130_fd_sc_hd__fill_1_415 r0 *1 0,0
Xsky130_fd_sc_hd__fill_1_415
+ vss
+ vdd
+ vdd
+ sky130_fd_sc_hd__fill_1
* cell instance sky130_fd_sc_hd__fill_1_416 r0 *1 0,0
Xsky130_fd_sc_hd__fill_1_416
+ vss
+ vdd
+ vdd
+ sky130_fd_sc_hd__fill_1
* cell instance sky130_fd_sc_hd__fill_1_417 r0 *1 0,0
Xsky130_fd_sc_hd__fill_1_417
+ vss
+ vdd
+ vdd
+ sky130_fd_sc_hd__fill_1
* cell instance sky130_fd_sc_hd__fill_1_418 r0 *1 0,0
Xsky130_fd_sc_hd__fill_1_418
+ vss
+ vdd
+ vdd
+ sky130_fd_sc_hd__fill_1
* cell instance sky130_fd_sc_hd__fill_1_419 r0 *1 0,0
Xsky130_fd_sc_hd__fill_1_419
+ vss
+ vdd
+ vdd
+ sky130_fd_sc_hd__fill_1
* cell instance sky130_fd_sc_hd__fill_1_420 r0 *1 0,0
Xsky130_fd_sc_hd__fill_1_420
+ vss
+ vdd
+ vdd
+ sky130_fd_sc_hd__fill_1
* cell instance sky130_fd_sc_hd__fill_1_421 r0 *1 0,0
Xsky130_fd_sc_hd__fill_1_421
+ vss
+ vdd
+ vdd
+ sky130_fd_sc_hd__fill_1
* cell instance sky130_fd_sc_hd__fill_1_422 r0 *1 0,0
Xsky130_fd_sc_hd__fill_1_422
+ vss
+ vdd
+ vdd
+ sky130_fd_sc_hd__fill_1
* cell instance sky130_fd_sc_hd__fill_1_423 r0 *1 0,0
Xsky130_fd_sc_hd__fill_1_423
+ vss
+ vdd
+ vdd
+ sky130_fd_sc_hd__fill_1
* cell instance sky130_fd_sc_hd__fill_1_424 r0 *1 0,0
Xsky130_fd_sc_hd__fill_1_424
+ vss
+ vdd
+ vdd
+ sky130_fd_sc_hd__fill_1
* cell instance sky130_fd_sc_hd__fill_1_425 r0 *1 0,0
Xsky130_fd_sc_hd__fill_1_425
+ vss
+ vdd
+ vdd
+ sky130_fd_sc_hd__fill_1
* cell instance sky130_fd_sc_hd__fill_1_426 r0 *1 0,0
Xsky130_fd_sc_hd__fill_1_426
+ vss
+ vdd
+ vdd
+ sky130_fd_sc_hd__fill_1
* cell instance sky130_fd_sc_hd__fill_1_427 r0 *1 0,0
Xsky130_fd_sc_hd__fill_1_427
+ vss
+ vdd
+ vdd
+ sky130_fd_sc_hd__fill_1
* cell instance sky130_fd_sc_hd__fill_1_428 r0 *1 0,0
Xsky130_fd_sc_hd__fill_1_428
+ vss
+ vdd
+ vdd
+ sky130_fd_sc_hd__fill_1
* cell instance sky130_fd_sc_hd__fill_1_429 r0 *1 0,0
Xsky130_fd_sc_hd__fill_1_429
+ vss
+ vdd
+ vdd
+ sky130_fd_sc_hd__fill_1
* cell instance sky130_fd_sc_hd__fill_1_430 r0 *1 0,0
Xsky130_fd_sc_hd__fill_1_430
+ vss
+ vdd
+ vdd
+ sky130_fd_sc_hd__fill_1
* cell instance sky130_fd_sc_hd__fill_1_431 r0 *1 0,0
Xsky130_fd_sc_hd__fill_1_431
+ vss
+ vdd
+ vdd
+ sky130_fd_sc_hd__fill_1
* cell instance sky130_fd_sc_hd__fill_1_432 r0 *1 0,0
Xsky130_fd_sc_hd__fill_1_432
+ vss
+ vdd
+ vdd
+ sky130_fd_sc_hd__fill_1
* cell instance sky130_fd_sc_hd__fill_1_433 r0 *1 0,0
Xsky130_fd_sc_hd__fill_1_433
+ vss
+ vdd
+ vdd
+ sky130_fd_sc_hd__fill_1
* cell instance sky130_fd_sc_hd__fill_1_434 r0 *1 0,0
Xsky130_fd_sc_hd__fill_1_434
+ vss
+ vdd
+ vdd
+ sky130_fd_sc_hd__fill_1
* cell instance sky130_fd_sc_hd__fill_1_435 r0 *1 0,0
Xsky130_fd_sc_hd__fill_1_435
+ vss
+ vdd
+ vdd
+ sky130_fd_sc_hd__fill_1
* cell instance sky130_fd_sc_hd__fill_1_436 r0 *1 0,0
Xsky130_fd_sc_hd__fill_1_436
+ vss
+ vdd
+ vdd
+ sky130_fd_sc_hd__fill_1
* cell instance sky130_fd_sc_hd__fill_1_437 r0 *1 0,0
Xsky130_fd_sc_hd__fill_1_437
+ vss
+ vdd
+ vdd
+ sky130_fd_sc_hd__fill_1
* cell instance sky130_fd_sc_hd__fill_1_438 r0 *1 0,0
Xsky130_fd_sc_hd__fill_1_438
+ vss
+ vdd
+ vdd
+ sky130_fd_sc_hd__fill_1
* cell instance sky130_fd_sc_hd__fill_1_439 r0 *1 0,0
Xsky130_fd_sc_hd__fill_1_439
+ vss
+ vdd
+ vdd
+ sky130_fd_sc_hd__fill_1
* cell instance sky130_fd_sc_hd__fill_1_440 r0 *1 0,0
Xsky130_fd_sc_hd__fill_1_440
+ vss
+ vdd
+ vdd
+ sky130_fd_sc_hd__fill_1
* cell instance sky130_fd_sc_hd__fill_1_441 r0 *1 0,0
Xsky130_fd_sc_hd__fill_1_441
+ vss
+ vdd
+ vdd
+ sky130_fd_sc_hd__fill_1
* cell instance sky130_fd_sc_hd__fill_1_442 r0 *1 0,0
Xsky130_fd_sc_hd__fill_1_442
+ vss
+ vdd
+ vdd
+ sky130_fd_sc_hd__fill_1
* cell instance sky130_fd_sc_hd__fill_1_443 r0 *1 0,0
Xsky130_fd_sc_hd__fill_1_443
+ vss
+ vdd
+ vdd
+ sky130_fd_sc_hd__fill_1
* cell instance sky130_fd_sc_hd__fill_1_444 r0 *1 0,0
Xsky130_fd_sc_hd__fill_1_444
+ vss
+ vdd
+ vdd
+ sky130_fd_sc_hd__fill_1
* cell instance sky130_fd_sc_hd__fill_1_445 r0 *1 0,0
Xsky130_fd_sc_hd__fill_1_445
+ vss
+ vdd
+ vdd
+ sky130_fd_sc_hd__fill_1
* cell instance sky130_fd_sc_hd__fill_1_446 r0 *1 0,0
Xsky130_fd_sc_hd__fill_1_446
+ vss
+ vdd
+ vdd
+ sky130_fd_sc_hd__fill_1
* cell instance sky130_fd_sc_hd__fill_1_447 r0 *1 0,0
Xsky130_fd_sc_hd__fill_1_447
+ vss
+ vdd
+ vdd
+ sky130_fd_sc_hd__fill_1
* cell instance sky130_fd_sc_hd__fill_1_448 r0 *1 0,0
Xsky130_fd_sc_hd__fill_1_448
+ vss
+ vdd
+ vdd
+ sky130_fd_sc_hd__fill_1
* cell instance sky130_fd_sc_hd__fill_1_449 r0 *1 0,0
Xsky130_fd_sc_hd__fill_1_449
+ vss
+ vdd
+ vdd
+ sky130_fd_sc_hd__fill_1
* cell instance sky130_fd_sc_hd__fill_1_450 r0 *1 0,0
Xsky130_fd_sc_hd__fill_1_450
+ vss
+ vdd
+ vdd
+ sky130_fd_sc_hd__fill_1
* cell instance sky130_fd_sc_hd__fill_1_451 r0 *1 0,0
Xsky130_fd_sc_hd__fill_1_451
+ vss
+ vdd
+ vdd
+ sky130_fd_sc_hd__fill_1
* cell instance sky130_fd_sc_hd__fill_1_452 r0 *1 0,0
Xsky130_fd_sc_hd__fill_1_452
+ vss
+ vdd
+ vdd
+ sky130_fd_sc_hd__fill_1
* cell instance sky130_fd_sc_hd__fill_1_453 r0 *1 0,0
Xsky130_fd_sc_hd__fill_1_453
+ vss
+ vdd
+ vdd
+ sky130_fd_sc_hd__fill_1
* cell instance sky130_fd_sc_hd__fill_1_454 r0 *1 0,0
Xsky130_fd_sc_hd__fill_1_454
+ vss
+ vdd
+ vdd
+ sky130_fd_sc_hd__fill_1
* cell instance sky130_fd_sc_hd__fill_1_455 r0 *1 0,0
Xsky130_fd_sc_hd__fill_1_455
+ vss
+ vdd
+ vdd
+ sky130_fd_sc_hd__fill_1
* cell instance sky130_fd_sc_hd__fill_1_456 r0 *1 0,0
Xsky130_fd_sc_hd__fill_1_456
+ vss
+ vdd
+ vdd
+ sky130_fd_sc_hd__fill_1
* cell instance sky130_fd_sc_hd__fill_1_457 r0 *1 0,0
Xsky130_fd_sc_hd__fill_1_457
+ vss
+ vdd
+ vdd
+ sky130_fd_sc_hd__fill_1
* cell instance sky130_fd_sc_hd__fill_1_458 r0 *1 0,0
Xsky130_fd_sc_hd__fill_1_458
+ vss
+ vdd
+ vdd
+ sky130_fd_sc_hd__fill_1
* cell instance sky130_fd_sc_hd__fill_1_459 r0 *1 0,0
Xsky130_fd_sc_hd__fill_1_459
+ vss
+ vdd
+ vdd
+ sky130_fd_sc_hd__fill_1
* cell instance sky130_fd_sc_hd__fill_1_460 r0 *1 0,0
Xsky130_fd_sc_hd__fill_1_460
+ vss
+ vdd
+ vdd
+ sky130_fd_sc_hd__fill_1
* cell instance sky130_fd_sc_hd__fill_1_461 r0 *1 0,0
Xsky130_fd_sc_hd__fill_1_461
+ vss
+ vdd
+ vdd
+ sky130_fd_sc_hd__fill_1
* cell instance sky130_fd_sc_hd__fill_1_462 r0 *1 0,0
Xsky130_fd_sc_hd__fill_1_462
+ vss
+ vdd
+ vdd
+ sky130_fd_sc_hd__fill_1
* cell instance sky130_fd_sc_hd__fill_1_463 r0 *1 0,0
Xsky130_fd_sc_hd__fill_1_463
+ vss
+ vdd
+ vdd
+ sky130_fd_sc_hd__fill_1
* cell instance sky130_fd_sc_hd__fill_1_464 r0 *1 0,0
Xsky130_fd_sc_hd__fill_1_464
+ vss
+ vdd
+ vdd
+ sky130_fd_sc_hd__fill_1
* cell instance sky130_fd_sc_hd__fill_1_465 r0 *1 0,0
Xsky130_fd_sc_hd__fill_1_465
+ vss
+ vdd
+ vdd
+ sky130_fd_sc_hd__fill_1
* cell instance sky130_fd_sc_hd__fill_1_466 r0 *1 0,0
Xsky130_fd_sc_hd__fill_1_466
+ vss
+ vdd
+ vdd
+ sky130_fd_sc_hd__fill_1
* cell instance sky130_fd_sc_hd__fill_1_467 r0 *1 0,0
Xsky130_fd_sc_hd__fill_1_467
+ vss
+ vdd
+ vdd
+ sky130_fd_sc_hd__fill_1
* cell instance sky130_fd_sc_hd__fill_1_468 r0 *1 0,0
Xsky130_fd_sc_hd__fill_1_468
+ vss
+ vdd
+ vdd
+ sky130_fd_sc_hd__fill_1
* cell instance sky130_fd_sc_hd__fill_1_469 r0 *1 0,0
Xsky130_fd_sc_hd__fill_1_469
+ vss
+ vdd
+ vdd
+ sky130_fd_sc_hd__fill_1
* cell instance sky130_fd_sc_hd__fill_1_470 r0 *1 0,0
Xsky130_fd_sc_hd__fill_1_470
+ vss
+ vdd
+ vdd
+ sky130_fd_sc_hd__fill_1
* cell instance sky130_fd_sc_hd__fill_1_471 r0 *1 0,0
Xsky130_fd_sc_hd__fill_1_471
+ vss
+ vdd
+ vdd
+ sky130_fd_sc_hd__fill_1
* cell instance sky130_fd_sc_hd__fill_1_472 r0 *1 0,0
Xsky130_fd_sc_hd__fill_1_472
+ vss
+ vdd
+ vdd
+ sky130_fd_sc_hd__fill_1
* cell instance sky130_fd_sc_hd__fill_1_473 r0 *1 0,0
Xsky130_fd_sc_hd__fill_1_473
+ vss
+ vdd
+ vdd
+ sky130_fd_sc_hd__fill_1
* cell instance sky130_fd_sc_hd__fill_1_474 r0 *1 0,0
Xsky130_fd_sc_hd__fill_1_474
+ vss
+ vdd
+ vdd
+ sky130_fd_sc_hd__fill_1
* cell instance sky130_fd_sc_hd__fill_1_475 r0 *1 0,0
Xsky130_fd_sc_hd__fill_1_475
+ vss
+ vdd
+ vdd
+ sky130_fd_sc_hd__fill_1
* cell instance sky130_fd_sc_hd__fill_1_476 r0 *1 0,0
Xsky130_fd_sc_hd__fill_1_476
+ vss
+ vdd
+ vdd
+ sky130_fd_sc_hd__fill_1
* cell instance sky130_fd_sc_hd__fill_1_477 r0 *1 0,0
Xsky130_fd_sc_hd__fill_1_477
+ vss
+ vdd
+ vdd
+ sky130_fd_sc_hd__fill_1
* cell instance sky130_fd_sc_hd__fill_1_478 r0 *1 0,0
Xsky130_fd_sc_hd__fill_1_478
+ vss
+ vdd
+ vdd
+ sky130_fd_sc_hd__fill_1
* cell instance sky130_fd_sc_hd__fill_1_479 r0 *1 0,0
Xsky130_fd_sc_hd__fill_1_479
+ vss
+ vdd
+ vdd
+ sky130_fd_sc_hd__fill_1
* cell instance sky130_fd_sc_hd__fill_1_480 r0 *1 0,0
Xsky130_fd_sc_hd__fill_1_480
+ vss
+ vdd
+ vdd
+ sky130_fd_sc_hd__fill_1
* cell instance sky130_fd_sc_hd__fill_1_481 r0 *1 0,0
Xsky130_fd_sc_hd__fill_1_481
+ vss
+ vdd
+ vdd
+ sky130_fd_sc_hd__fill_1
* cell instance sky130_fd_sc_hd__fill_1_482 r0 *1 0,0
Xsky130_fd_sc_hd__fill_1_482
+ vss
+ vdd
+ vdd
+ sky130_fd_sc_hd__fill_1
* cell instance sky130_fd_sc_hd__fill_1_483 r0 *1 0,0
Xsky130_fd_sc_hd__fill_1_483
+ vss
+ vdd
+ vdd
+ sky130_fd_sc_hd__fill_1
* cell instance sky130_fd_sc_hd__fill_1_484 r0 *1 0,0
Xsky130_fd_sc_hd__fill_1_484
+ vss
+ vdd
+ vdd
+ sky130_fd_sc_hd__fill_1
* cell instance sky130_fd_sc_hd__fill_1_485 r0 *1 0,0
Xsky130_fd_sc_hd__fill_1_485
+ vss
+ vdd
+ vdd
+ sky130_fd_sc_hd__fill_1
* cell instance sky130_fd_sc_hd__fill_1_486 r0 *1 0,0
Xsky130_fd_sc_hd__fill_1_486
+ vss
+ vdd
+ vdd
+ sky130_fd_sc_hd__fill_1
* cell instance sky130_fd_sc_hd__fill_1_487 r0 *1 0,0
Xsky130_fd_sc_hd__fill_1_487
+ vss
+ vdd
+ vdd
+ sky130_fd_sc_hd__fill_1
* cell instance sky130_fd_sc_hd__fill_1_488 r0 *1 0,0
Xsky130_fd_sc_hd__fill_1_488
+ vss
+ vdd
+ vdd
+ sky130_fd_sc_hd__fill_1
* cell instance sky130_fd_sc_hd__fill_1_489 r0 *1 0,0
Xsky130_fd_sc_hd__fill_1_489
+ vss
+ vdd
+ vdd
+ sky130_fd_sc_hd__fill_1
* cell instance sky130_fd_sc_hd__fill_1_490 r0 *1 0,0
Xsky130_fd_sc_hd__fill_1_490
+ vss
+ vdd
+ vdd
+ sky130_fd_sc_hd__fill_1
* cell instance sky130_fd_sc_hd__fill_1_491 r0 *1 0,0
Xsky130_fd_sc_hd__fill_1_491
+ vss
+ vdd
+ vdd
+ sky130_fd_sc_hd__fill_1
* cell instance sky130_fd_sc_hd__fill_1_492 r0 *1 0,0
Xsky130_fd_sc_hd__fill_1_492
+ vss
+ vdd
+ vdd
+ sky130_fd_sc_hd__fill_1
* cell instance sky130_fd_sc_hd__fill_1_493 r0 *1 0,0
Xsky130_fd_sc_hd__fill_1_493
+ vss
+ vdd
+ vdd
+ sky130_fd_sc_hd__fill_1
* cell instance sky130_fd_sc_hd__fill_1_494 r0 *1 0,0
Xsky130_fd_sc_hd__fill_1_494
+ vss
+ vdd
+ vdd
+ sky130_fd_sc_hd__fill_1
* cell instance sky130_fd_sc_hd__fill_1_495 r0 *1 0,0
Xsky130_fd_sc_hd__fill_1_495
+ vss
+ vdd
+ vdd
+ sky130_fd_sc_hd__fill_1
* cell instance sky130_fd_sc_hd__fill_1_496 r0 *1 0,0
Xsky130_fd_sc_hd__fill_1_496
+ vss
+ vdd
+ vdd
+ sky130_fd_sc_hd__fill_1
* cell instance sky130_fd_sc_hd__fill_1_497 r0 *1 0,0
Xsky130_fd_sc_hd__fill_1_497
+ vss
+ vdd
+ vdd
+ sky130_fd_sc_hd__fill_1
* cell instance sky130_fd_sc_hd__fill_1_498 r0 *1 0,0
Xsky130_fd_sc_hd__fill_1_498
+ vss
+ vdd
+ vdd
+ sky130_fd_sc_hd__fill_1
* cell instance sky130_fd_sc_hd__fill_1_499 r0 *1 0,0
Xsky130_fd_sc_hd__fill_1_499
+ vss
+ vdd
+ vdd
+ sky130_fd_sc_hd__fill_1
* cell instance sky130_fd_sc_hd__fill_1_500 r0 *1 0,0
Xsky130_fd_sc_hd__fill_1_500
+ vss
+ vdd
+ vdd
+ sky130_fd_sc_hd__fill_1
* cell instance sky130_fd_sc_hd__fill_1_501 r0 *1 0,0
Xsky130_fd_sc_hd__fill_1_501
+ vss
+ vdd
+ vdd
+ sky130_fd_sc_hd__fill_1
* cell instance sky130_fd_sc_hd__fill_1_502 r0 *1 0,0
Xsky130_fd_sc_hd__fill_1_502
+ vss
+ vdd
+ vdd
+ sky130_fd_sc_hd__fill_1
* cell instance sky130_fd_sc_hd__fill_1_503 r0 *1 0,0
Xsky130_fd_sc_hd__fill_1_503
+ vss
+ vdd
+ vdd
+ sky130_fd_sc_hd__fill_1
* cell instance sky130_fd_sc_hd__fill_1_504 r0 *1 0,0
Xsky130_fd_sc_hd__fill_1_504
+ vss
+ vdd
+ vdd
+ sky130_fd_sc_hd__fill_1
* cell instance sky130_fd_sc_hd__fill_1_505 r0 *1 0,0
Xsky130_fd_sc_hd__fill_1_505
+ vss
+ vdd
+ vdd
+ sky130_fd_sc_hd__fill_1
* cell instance sky130_fd_sc_hd__fill_1_506 r0 *1 0,0
Xsky130_fd_sc_hd__fill_1_506
+ vss
+ vdd
+ vdd
+ sky130_fd_sc_hd__fill_1
* cell instance sky130_fd_sc_hd__fill_1_507 r0 *1 0,0
Xsky130_fd_sc_hd__fill_1_507
+ vss
+ vdd
+ vdd
+ sky130_fd_sc_hd__fill_1
* cell instance sky130_fd_sc_hd__fill_1_508 r0 *1 0,0
Xsky130_fd_sc_hd__fill_1_508
+ vss
+ vdd
+ vdd
+ sky130_fd_sc_hd__fill_1
* cell instance sky130_fd_sc_hd__fill_1_509 r0 *1 0,0
Xsky130_fd_sc_hd__fill_1_509
+ vss
+ vdd
+ vdd
+ sky130_fd_sc_hd__fill_1
* cell instance sky130_fd_sc_hd__fill_1_510 r0 *1 0,0
Xsky130_fd_sc_hd__fill_1_510
+ vss
+ vdd
+ vdd
+ sky130_fd_sc_hd__fill_1
* cell instance sky130_fd_sc_hd__fill_1_511 r0 *1 0,0
Xsky130_fd_sc_hd__fill_1_511
+ vss
+ vdd
+ vdd
+ sky130_fd_sc_hd__fill_1
* cell instance sky130_fd_sc_hd__fill_1_512 r0 *1 0,0
Xsky130_fd_sc_hd__fill_1_512
+ vss
+ vdd
+ vdd
+ sky130_fd_sc_hd__fill_1
* cell instance sky130_fd_sc_hd__fill_1_513 r0 *1 0,0
Xsky130_fd_sc_hd__fill_1_513
+ vss
+ vdd
+ vdd
+ sky130_fd_sc_hd__fill_1
* cell instance sky130_fd_sc_hd__fill_1_514 r0 *1 0,0
Xsky130_fd_sc_hd__fill_1_514
+ vss
+ vdd
+ vdd
+ sky130_fd_sc_hd__fill_1
* cell instance sky130_fd_sc_hd__fill_1_515 r0 *1 0,0
Xsky130_fd_sc_hd__fill_1_515
+ vss
+ vdd
+ vdd
+ sky130_fd_sc_hd__fill_1
* cell instance sky130_fd_sc_hd__fill_1_516 r0 *1 0,0
Xsky130_fd_sc_hd__fill_1_516
+ vss
+ vdd
+ vdd
+ sky130_fd_sc_hd__fill_1
* cell instance sky130_fd_sc_hd__fill_1_517 r0 *1 0,0
Xsky130_fd_sc_hd__fill_1_517
+ vss
+ vdd
+ vdd
+ sky130_fd_sc_hd__fill_1
* cell instance sky130_fd_sc_hd__fill_1_518 r0 *1 0,0
Xsky130_fd_sc_hd__fill_1_518
+ vss
+ vdd
+ vdd
+ sky130_fd_sc_hd__fill_1
* cell instance sky130_fd_sc_hd__fill_1_519 r0 *1 0,0
Xsky130_fd_sc_hd__fill_1_519
+ vss
+ vdd
+ vdd
+ sky130_fd_sc_hd__fill_1
* cell instance sky130_fd_sc_hd__fill_1_520 r0 *1 0,0
Xsky130_fd_sc_hd__fill_1_520
+ vss
+ vdd
+ vdd
+ sky130_fd_sc_hd__fill_1
* cell instance sky130_fd_sc_hd__fill_1_521 r0 *1 0,0
Xsky130_fd_sc_hd__fill_1_521
+ vss
+ vdd
+ vdd
+ sky130_fd_sc_hd__fill_1
* cell instance sky130_fd_sc_hd__fill_1_522 r0 *1 0,0
Xsky130_fd_sc_hd__fill_1_522
+ vss
+ vdd
+ vdd
+ sky130_fd_sc_hd__fill_1
* cell instance sky130_fd_sc_hd__fill_1_523 r0 *1 0,0
Xsky130_fd_sc_hd__fill_1_523
+ vss
+ vdd
+ vdd
+ sky130_fd_sc_hd__fill_1
* cell instance sky130_fd_sc_hd__fill_1_524 r0 *1 0,0
Xsky130_fd_sc_hd__fill_1_524
+ vss
+ vdd
+ vdd
+ sky130_fd_sc_hd__fill_1
* cell instance sky130_fd_sc_hd__fill_1_525 r0 *1 0,0
Xsky130_fd_sc_hd__fill_1_525
+ vss
+ vdd
+ vdd
+ sky130_fd_sc_hd__fill_1
* cell instance sky130_fd_sc_hd__fill_1_526 r0 *1 0,0
Xsky130_fd_sc_hd__fill_1_526
+ vss
+ vdd
+ vdd
+ sky130_fd_sc_hd__fill_1
* cell instance sky130_fd_sc_hd__fill_1_527 r0 *1 0,0
Xsky130_fd_sc_hd__fill_1_527
+ vss
+ vdd
+ vdd
+ sky130_fd_sc_hd__fill_1
* cell instance sky130_fd_sc_hd__fill_1_528 r0 *1 0,0
Xsky130_fd_sc_hd__fill_1_528
+ vss
+ vdd
+ vdd
+ sky130_fd_sc_hd__fill_1
* cell instance sky130_fd_sc_hd__fill_1_529 r0 *1 0,0
Xsky130_fd_sc_hd__fill_1_529
+ vss
+ vdd
+ vdd
+ sky130_fd_sc_hd__fill_1
* cell instance sky130_fd_sc_hd__fill_1_530 r0 *1 0,0
Xsky130_fd_sc_hd__fill_1_530
+ vss
+ vdd
+ vdd
+ sky130_fd_sc_hd__fill_1
* cell instance sky130_fd_sc_hd__fill_1_531 r0 *1 0,0
Xsky130_fd_sc_hd__fill_1_531
+ vss
+ vdd
+ vdd
+ sky130_fd_sc_hd__fill_1
* cell instance sky130_fd_sc_hd__fill_1_532 r0 *1 0,0
Xsky130_fd_sc_hd__fill_1_532
+ vss
+ vdd
+ vdd
+ sky130_fd_sc_hd__fill_1
* cell instance sky130_fd_sc_hd__fill_1_533 r0 *1 0,0
Xsky130_fd_sc_hd__fill_1_533
+ vss
+ vdd
+ vdd
+ sky130_fd_sc_hd__fill_1
* cell instance sky130_fd_sc_hd__fill_1_534 r0 *1 0,0
Xsky130_fd_sc_hd__fill_1_534
+ vss
+ vdd
+ vdd
+ sky130_fd_sc_hd__fill_1
* cell instance sky130_fd_sc_hd__fill_1_535 r0 *1 0,0
Xsky130_fd_sc_hd__fill_1_535
+ vss
+ vdd
+ vdd
+ sky130_fd_sc_hd__fill_1
* cell instance sky130_fd_sc_hd__fill_1_536 r0 *1 0,0
Xsky130_fd_sc_hd__fill_1_536
+ vss
+ vdd
+ vdd
+ sky130_fd_sc_hd__fill_1
* cell instance sky130_fd_sc_hd__fill_1_537 r0 *1 0,0
Xsky130_fd_sc_hd__fill_1_537
+ vss
+ vdd
+ vdd
+ sky130_fd_sc_hd__fill_1
* cell instance sky130_fd_sc_hd__fill_1_538 r0 *1 0,0
Xsky130_fd_sc_hd__fill_1_538
+ vss
+ vdd
+ vdd
+ sky130_fd_sc_hd__fill_1
* cell instance sky130_fd_sc_hd__fill_1_539 r0 *1 0,0
Xsky130_fd_sc_hd__fill_1_539
+ vss
+ vdd
+ vdd
+ sky130_fd_sc_hd__fill_1
* cell instance sky130_fd_sc_hd__fill_1_540 r0 *1 0,0
Xsky130_fd_sc_hd__fill_1_540
+ vss
+ vdd
+ vdd
+ sky130_fd_sc_hd__fill_1
* cell instance sky130_fd_sc_hd__fill_1_541 r0 *1 0,0
Xsky130_fd_sc_hd__fill_1_541
+ vss
+ vdd
+ vdd
+ sky130_fd_sc_hd__fill_1
* cell instance sky130_fd_sc_hd__fill_1_542 r0 *1 0,0
Xsky130_fd_sc_hd__fill_1_542
+ vss
+ vdd
+ vdd
+ sky130_fd_sc_hd__fill_1
* cell instance sky130_fd_sc_hd__fill_1_543 r0 *1 0,0
Xsky130_fd_sc_hd__fill_1_543
+ vss
+ vdd
+ vdd
+ sky130_fd_sc_hd__fill_1
* cell instance sky130_fd_sc_hd__fill_1_544 r0 *1 0,0
Xsky130_fd_sc_hd__fill_1_544
+ vss
+ vdd
+ vdd
+ sky130_fd_sc_hd__fill_1
* cell instance sky130_fd_sc_hd__fill_1_545 r0 *1 0,0
Xsky130_fd_sc_hd__fill_1_545
+ vss
+ vdd
+ vdd
+ sky130_fd_sc_hd__fill_1
* cell instance sky130_fd_sc_hd__fill_1_546 r0 *1 0,0
Xsky130_fd_sc_hd__fill_1_546
+ vss
+ vdd
+ vdd
+ sky130_fd_sc_hd__fill_1
* cell instance sky130_fd_sc_hd__fill_1_547 r0 *1 0,0
Xsky130_fd_sc_hd__fill_1_547
+ vss
+ vdd
+ vdd
+ sky130_fd_sc_hd__fill_1
* cell instance sky130_fd_sc_hd__fill_1_548 r0 *1 0,0
Xsky130_fd_sc_hd__fill_1_548
+ vss
+ vdd
+ vdd
+ sky130_fd_sc_hd__fill_1
* cell instance sky130_fd_sc_hd__fill_1_549 r0 *1 0,0
Xsky130_fd_sc_hd__fill_1_549
+ vss
+ vdd
+ vdd
+ sky130_fd_sc_hd__fill_1
* cell instance sky130_fd_sc_hd__fill_1_550 r0 *1 0,0
Xsky130_fd_sc_hd__fill_1_550
+ vss
+ vdd
+ vdd
+ sky130_fd_sc_hd__fill_1
* cell instance sky130_fd_sc_hd__fill_1_551 r0 *1 0,0
Xsky130_fd_sc_hd__fill_1_551
+ vss
+ vdd
+ vdd
+ sky130_fd_sc_hd__fill_1
* cell instance sky130_fd_sc_hd__fill_1_552 r0 *1 0,0
Xsky130_fd_sc_hd__fill_1_552
+ vss
+ vdd
+ vdd
+ sky130_fd_sc_hd__fill_1
* cell instance sky130_fd_sc_hd__fill_1_553 r0 *1 0,0
Xsky130_fd_sc_hd__fill_1_553
+ vss
+ vdd
+ vdd
+ sky130_fd_sc_hd__fill_1
* cell instance sky130_fd_sc_hd__fill_1_554 r0 *1 0,0
Xsky130_fd_sc_hd__fill_1_554
+ vss
+ vdd
+ vdd
+ sky130_fd_sc_hd__fill_1
* cell instance sky130_fd_sc_hd__fill_1_555 r0 *1 0,0
Xsky130_fd_sc_hd__fill_1_555
+ vss
+ vdd
+ vdd
+ sky130_fd_sc_hd__fill_1
* cell instance sky130_fd_sc_hd__fill_1_556 r0 *1 0,0
Xsky130_fd_sc_hd__fill_1_556
+ vss
+ vdd
+ vdd
+ sky130_fd_sc_hd__fill_1
* cell instance sky130_fd_sc_hd__fill_1_557 r0 *1 0,0
Xsky130_fd_sc_hd__fill_1_557
+ vss
+ vdd
+ vdd
+ sky130_fd_sc_hd__fill_1
* cell instance sky130_fd_sc_hd__fill_1_558 r0 *1 0,0
Xsky130_fd_sc_hd__fill_1_558
+ vss
+ vdd
+ vdd
+ sky130_fd_sc_hd__fill_1
* cell instance sky130_fd_sc_hd__fill_1_559 r0 *1 0,0
Xsky130_fd_sc_hd__fill_1_559
+ vss
+ vdd
+ vdd
+ sky130_fd_sc_hd__fill_1
* cell instance sky130_fd_sc_hd__fill_1_560 r0 *1 0,0
Xsky130_fd_sc_hd__fill_1_560
+ vss
+ vdd
+ vdd
+ sky130_fd_sc_hd__fill_1
* cell instance sky130_fd_sc_hd__fill_1_561 r0 *1 0,0
Xsky130_fd_sc_hd__fill_1_561
+ vss
+ vdd
+ vdd
+ sky130_fd_sc_hd__fill_1
* cell instance sky130_fd_sc_hd__fill_1_562 r0 *1 0,0
Xsky130_fd_sc_hd__fill_1_562
+ vss
+ vdd
+ vdd
+ sky130_fd_sc_hd__fill_1
* cell instance sky130_fd_sc_hd__fill_1_563 r0 *1 0,0
Xsky130_fd_sc_hd__fill_1_563
+ vss
+ vdd
+ vdd
+ sky130_fd_sc_hd__fill_1
* cell instance sky130_fd_sc_hd__fill_1_564 r0 *1 0,0
Xsky130_fd_sc_hd__fill_1_564
+ vss
+ vdd
+ vdd
+ sky130_fd_sc_hd__fill_1
* cell instance sky130_fd_sc_hd__fill_1_565 r0 *1 0,0
Xsky130_fd_sc_hd__fill_1_565
+ vss
+ vdd
+ vdd
+ sky130_fd_sc_hd__fill_1
* cell instance sky130_fd_sc_hd__fill_1_566 r0 *1 0,0
Xsky130_fd_sc_hd__fill_1_566
+ vss
+ vdd
+ vdd
+ sky130_fd_sc_hd__fill_1
* cell instance sky130_fd_sc_hd__fill_1_567 r0 *1 0,0
Xsky130_fd_sc_hd__fill_1_567
+ vss
+ vdd
+ vdd
+ sky130_fd_sc_hd__fill_1
* cell instance sky130_fd_sc_hd__fill_1_568 r0 *1 0,0
Xsky130_fd_sc_hd__fill_1_568
+ vss
+ vdd
+ vdd
+ sky130_fd_sc_hd__fill_1
* cell instance sky130_fd_sc_hd__fill_1_569 r0 *1 0,0
Xsky130_fd_sc_hd__fill_1_569
+ vss
+ vdd
+ vdd
+ sky130_fd_sc_hd__fill_1
* cell instance sky130_fd_sc_hd__fill_1_570 r0 *1 0,0
Xsky130_fd_sc_hd__fill_1_570
+ vss
+ vdd
+ vdd
+ sky130_fd_sc_hd__fill_1
* cell instance sky130_fd_sc_hd__fill_1_571 r0 *1 0,0
Xsky130_fd_sc_hd__fill_1_571
+ vss
+ vdd
+ vdd
+ sky130_fd_sc_hd__fill_1
* cell instance sky130_fd_sc_hd__fill_1_572 r0 *1 0,0
Xsky130_fd_sc_hd__fill_1_572
+ vss
+ vdd
+ vdd
+ sky130_fd_sc_hd__fill_1
* cell instance sky130_fd_sc_hd__fill_1_573 r0 *1 0,0
Xsky130_fd_sc_hd__fill_1_573
+ vss
+ vdd
+ vdd
+ sky130_fd_sc_hd__fill_1
* cell instance sky130_fd_sc_hd__fill_1_574 r0 *1 0,0
Xsky130_fd_sc_hd__fill_1_574
+ vss
+ vdd
+ vdd
+ sky130_fd_sc_hd__fill_1
* cell instance sky130_fd_sc_hd__fill_1_575 r0 *1 0,0
Xsky130_fd_sc_hd__fill_1_575
+ vss
+ vdd
+ vdd
+ sky130_fd_sc_hd__fill_1
* cell instance sky130_fd_sc_hd__fill_1_576 r0 *1 0,0
Xsky130_fd_sc_hd__fill_1_576
+ vss
+ vdd
+ vdd
+ sky130_fd_sc_hd__fill_1
* cell instance sky130_fd_sc_hd__fill_1_577 r0 *1 0,0
Xsky130_fd_sc_hd__fill_1_577
+ vss
+ vdd
+ vdd
+ sky130_fd_sc_hd__fill_1
* cell instance sky130_fd_sc_hd__fill_1_578 r0 *1 0,0
Xsky130_fd_sc_hd__fill_1_578
+ vss
+ vdd
+ vdd
+ sky130_fd_sc_hd__fill_1
* cell instance sky130_fd_sc_hd__fill_1_579 r0 *1 0,0
Xsky130_fd_sc_hd__fill_1_579
+ vss
+ vdd
+ vdd
+ sky130_fd_sc_hd__fill_1
* cell instance sky130_fd_sc_hd__fill_1_580 r0 *1 0,0
Xsky130_fd_sc_hd__fill_1_580
+ vss
+ vdd
+ vdd
+ sky130_fd_sc_hd__fill_1
* cell instance sky130_fd_sc_hd__fill_1_581 r0 *1 0,0
Xsky130_fd_sc_hd__fill_1_581
+ vss
+ vdd
+ vdd
+ sky130_fd_sc_hd__fill_1
* cell instance sky130_fd_sc_hd__fill_1_582 r0 *1 0,0
Xsky130_fd_sc_hd__fill_1_582
+ vss
+ vdd
+ vdd
+ sky130_fd_sc_hd__fill_1
* cell instance sky130_fd_sc_hd__fill_1_583 r0 *1 0,0
Xsky130_fd_sc_hd__fill_1_583
+ vss
+ vdd
+ vdd
+ sky130_fd_sc_hd__fill_1
* cell instance sky130_fd_sc_hd__fill_1_584 r0 *1 0,0
Xsky130_fd_sc_hd__fill_1_584
+ vss
+ vdd
+ vdd
+ sky130_fd_sc_hd__fill_1
* cell instance sky130_fd_sc_hd__fill_1_585 r0 *1 0,0
Xsky130_fd_sc_hd__fill_1_585
+ vss
+ vdd
+ vdd
+ sky130_fd_sc_hd__fill_1
* cell instance sky130_fd_sc_hd__fill_1_586 r0 *1 0,0
Xsky130_fd_sc_hd__fill_1_586
+ vss
+ vdd
+ vdd
+ sky130_fd_sc_hd__fill_1
* cell instance sky130_fd_sc_hd__fill_1_587 r0 *1 0,0
Xsky130_fd_sc_hd__fill_1_587
+ vss
+ vdd
+ vdd
+ sky130_fd_sc_hd__fill_1
* cell instance sky130_fd_sc_hd__fill_1_588 r0 *1 0,0
Xsky130_fd_sc_hd__fill_1_588
+ vss
+ vdd
+ vdd
+ sky130_fd_sc_hd__fill_1
* cell instance sky130_fd_sc_hd__fill_1_589 r0 *1 0,0
Xsky130_fd_sc_hd__fill_1_589
+ vss
+ vdd
+ vdd
+ sky130_fd_sc_hd__fill_1
* cell instance sky130_fd_sc_hd__fill_1_590 r0 *1 0,0
Xsky130_fd_sc_hd__fill_1_590
+ vss
+ vdd
+ vdd
+ sky130_fd_sc_hd__fill_1
* cell instance sky130_fd_sc_hd__fill_1_591 r0 *1 0,0
Xsky130_fd_sc_hd__fill_1_591
+ vss
+ vdd
+ vdd
+ sky130_fd_sc_hd__fill_1
* cell instance sky130_fd_sc_hd__fill_1_592 r0 *1 0,0
Xsky130_fd_sc_hd__fill_1_592
+ vss
+ vdd
+ vdd
+ sky130_fd_sc_hd__fill_1
* cell instance sky130_fd_sc_hd__fill_1_593 r0 *1 0,0
Xsky130_fd_sc_hd__fill_1_593
+ vss
+ vdd
+ vdd
+ sky130_fd_sc_hd__fill_1
* cell instance sky130_fd_sc_hd__fill_1_594 r0 *1 0,0
Xsky130_fd_sc_hd__fill_1_594
+ vss
+ vdd
+ vdd
+ sky130_fd_sc_hd__fill_1
* cell instance sky130_fd_sc_hd__fill_1_595 r0 *1 0,0
Xsky130_fd_sc_hd__fill_1_595
+ vss
+ vdd
+ vdd
+ sky130_fd_sc_hd__fill_1
* cell instance sky130_fd_sc_hd__fill_1_596 r0 *1 0,0
Xsky130_fd_sc_hd__fill_1_596
+ vss
+ vdd
+ vdd
+ sky130_fd_sc_hd__fill_1
* cell instance sky130_fd_sc_hd__fill_1_597 r0 *1 0,0
Xsky130_fd_sc_hd__fill_1_597
+ vss
+ vdd
+ vdd
+ sky130_fd_sc_hd__fill_1
* cell instance sky130_fd_sc_hd__fill_1_598 r0 *1 0,0
Xsky130_fd_sc_hd__fill_1_598
+ vss
+ vdd
+ vdd
+ sky130_fd_sc_hd__fill_1
* cell instance sky130_fd_sc_hd__fill_1_599 r0 *1 0,0
Xsky130_fd_sc_hd__fill_1_599
+ vss
+ vdd
+ vdd
+ sky130_fd_sc_hd__fill_1
* cell instance sky130_fd_sc_hd__fill_1_600 r0 *1 0,0
Xsky130_fd_sc_hd__fill_1_600
+ vss
+ vdd
+ vdd
+ sky130_fd_sc_hd__fill_1
* cell instance sky130_fd_sc_hd__fill_1_601 r0 *1 0,0
Xsky130_fd_sc_hd__fill_1_601
+ vss
+ vdd
+ vdd
+ sky130_fd_sc_hd__fill_1
* cell instance sky130_fd_sc_hd__fill_1_602 r0 *1 0,0
Xsky130_fd_sc_hd__fill_1_602
+ vss
+ vdd
+ vdd
+ sky130_fd_sc_hd__fill_1
* cell instance sky130_fd_sc_hd__fill_1_603 r0 *1 0,0
Xsky130_fd_sc_hd__fill_1_603
+ vss
+ vdd
+ vdd
+ sky130_fd_sc_hd__fill_1
* cell instance sky130_fd_sc_hd__fill_1_604 r0 *1 0,0
Xsky130_fd_sc_hd__fill_1_604
+ vss
+ vdd
+ vdd
+ sky130_fd_sc_hd__fill_1
* cell instance sky130_fd_sc_hd__fill_1_605 r0 *1 0,0
Xsky130_fd_sc_hd__fill_1_605
+ vss
+ vdd
+ vdd
+ sky130_fd_sc_hd__fill_1
* cell instance sky130_fd_sc_hd__fill_1_606 r0 *1 0,0
Xsky130_fd_sc_hd__fill_1_606
+ vss
+ vdd
+ vdd
+ sky130_fd_sc_hd__fill_1
* cell instance sky130_fd_sc_hd__fill_1_607 r0 *1 0,0
Xsky130_fd_sc_hd__fill_1_607
+ vss
+ vdd
+ vdd
+ sky130_fd_sc_hd__fill_1
* cell instance sky130_fd_sc_hd__fill_1_608 r0 *1 0,0
Xsky130_fd_sc_hd__fill_1_608
+ vss
+ vdd
+ vdd
+ sky130_fd_sc_hd__fill_1
* cell instance sky130_fd_sc_hd__fill_1_609 r0 *1 0,0
Xsky130_fd_sc_hd__fill_1_609
+ vss
+ vdd
+ vdd
+ sky130_fd_sc_hd__fill_1
* cell instance sky130_fd_sc_hd__fill_1_610 r0 *1 0,0
Xsky130_fd_sc_hd__fill_1_610
+ vss
+ vdd
+ vdd
+ sky130_fd_sc_hd__fill_1
* cell instance sky130_fd_sc_hd__fill_1_611 r0 *1 0,0
Xsky130_fd_sc_hd__fill_1_611
+ vss
+ vdd
+ vdd
+ sky130_fd_sc_hd__fill_1
* cell instance sky130_fd_sc_hd__fill_1_612 r0 *1 0,0
Xsky130_fd_sc_hd__fill_1_612
+ vss
+ vdd
+ vdd
+ sky130_fd_sc_hd__fill_1
* cell instance sky130_fd_sc_hd__fill_1_613 r0 *1 0,0
Xsky130_fd_sc_hd__fill_1_613
+ vss
+ vdd
+ vdd
+ sky130_fd_sc_hd__fill_1
* cell instance sky130_fd_sc_hd__fill_1_614 r0 *1 0,0
Xsky130_fd_sc_hd__fill_1_614
+ vss
+ vdd
+ vdd
+ sky130_fd_sc_hd__fill_1
* cell instance sky130_fd_sc_hd__fill_1_615 r0 *1 0,0
Xsky130_fd_sc_hd__fill_1_615
+ vss
+ vdd
+ vdd
+ sky130_fd_sc_hd__fill_1
* cell instance sky130_fd_sc_hd__fill_1_616 r0 *1 0,0
Xsky130_fd_sc_hd__fill_1_616
+ vss
+ vdd
+ vdd
+ sky130_fd_sc_hd__fill_1
* cell instance sky130_fd_sc_hd__fill_1_617 r0 *1 0,0
Xsky130_fd_sc_hd__fill_1_617
+ vss
+ vdd
+ vdd
+ sky130_fd_sc_hd__fill_1
* cell instance sky130_fd_sc_hd__fill_1_618 r0 *1 0,0
Xsky130_fd_sc_hd__fill_1_618
+ vss
+ vdd
+ vdd
+ sky130_fd_sc_hd__fill_1
* cell instance sky130_fd_sc_hd__fill_1_619 r0 *1 0,0
Xsky130_fd_sc_hd__fill_1_619
+ vss
+ vdd
+ vdd
+ sky130_fd_sc_hd__fill_1
* cell instance sky130_fd_sc_hd__fill_1_620 r0 *1 0,0
Xsky130_fd_sc_hd__fill_1_620
+ vss
+ vdd
+ vdd
+ sky130_fd_sc_hd__fill_1
* cell instance sky130_fd_sc_hd__fill_1_621 r0 *1 0,0
Xsky130_fd_sc_hd__fill_1_621
+ vss
+ vdd
+ vdd
+ sky130_fd_sc_hd__fill_1
* cell instance sky130_fd_sc_hd__fill_1_622 r0 *1 0,0
Xsky130_fd_sc_hd__fill_1_622
+ vss
+ vdd
+ vdd
+ sky130_fd_sc_hd__fill_1
* cell instance sky130_fd_sc_hd__fill_1_623 r0 *1 0,0
Xsky130_fd_sc_hd__fill_1_623
+ vss
+ vdd
+ vdd
+ sky130_fd_sc_hd__fill_1
* cell instance sky130_fd_sc_hd__fill_1_624 r0 *1 0,0
Xsky130_fd_sc_hd__fill_1_624
+ vss
+ vdd
+ vdd
+ sky130_fd_sc_hd__fill_1
* cell instance sky130_fd_sc_hd__fill_1_625 r0 *1 0,0
Xsky130_fd_sc_hd__fill_1_625
+ vss
+ vdd
+ vdd
+ sky130_fd_sc_hd__fill_1
* cell instance sky130_fd_sc_hd__fill_1_626 r0 *1 0,0
Xsky130_fd_sc_hd__fill_1_626
+ vss
+ vdd
+ vdd
+ sky130_fd_sc_hd__fill_1
* cell instance sky130_fd_sc_hd__fill_1_627 r0 *1 0,0
Xsky130_fd_sc_hd__fill_1_627
+ vss
+ vdd
+ vdd
+ sky130_fd_sc_hd__fill_1
* cell instance sky130_fd_sc_hd__fill_1_628 r0 *1 0,0
Xsky130_fd_sc_hd__fill_1_628
+ vss
+ vdd
+ vdd
+ sky130_fd_sc_hd__fill_1
* cell instance sky130_fd_sc_hd__fill_1_629 r0 *1 0,0
Xsky130_fd_sc_hd__fill_1_629
+ vss
+ vdd
+ vdd
+ sky130_fd_sc_hd__fill_1
* cell instance sky130_fd_sc_hd__fill_1_630 r0 *1 0,0
Xsky130_fd_sc_hd__fill_1_630
+ vss
+ vdd
+ vdd
+ sky130_fd_sc_hd__fill_1
* cell instance sky130_fd_sc_hd__fill_1_631 r0 *1 0,0
Xsky130_fd_sc_hd__fill_1_631
+ vss
+ vdd
+ vdd
+ sky130_fd_sc_hd__fill_1
* cell instance sky130_fd_sc_hd__fill_1_632 r0 *1 0,0
Xsky130_fd_sc_hd__fill_1_632
+ vss
+ vdd
+ vdd
+ sky130_fd_sc_hd__fill_1
* cell instance sky130_fd_sc_hd__fill_1_633 r0 *1 0,0
Xsky130_fd_sc_hd__fill_1_633
+ vss
+ vdd
+ vdd
+ sky130_fd_sc_hd__fill_1
* cell instance sky130_fd_sc_hd__fill_1_634 r0 *1 0,0
Xsky130_fd_sc_hd__fill_1_634
+ vss
+ vdd
+ vdd
+ sky130_fd_sc_hd__fill_1
* cell instance sky130_fd_sc_hd__fill_1_635 r0 *1 0,0
Xsky130_fd_sc_hd__fill_1_635
+ vss
+ vdd
+ vdd
+ sky130_fd_sc_hd__fill_1
* cell instance sky130_fd_sc_hd__fill_1_636 r0 *1 0,0
Xsky130_fd_sc_hd__fill_1_636
+ vss
+ vdd
+ vdd
+ sky130_fd_sc_hd__fill_1
* cell instance sky130_fd_sc_hd__fill_1_637 r0 *1 0,0
Xsky130_fd_sc_hd__fill_1_637
+ vss
+ vdd
+ vdd
+ sky130_fd_sc_hd__fill_1
* cell instance sky130_fd_sc_hd__fill_1_638 r0 *1 0,0
Xsky130_fd_sc_hd__fill_1_638
+ vss
+ vdd
+ vdd
+ sky130_fd_sc_hd__fill_1
* cell instance sky130_fd_sc_hd__fill_1_639 r0 *1 0,0
Xsky130_fd_sc_hd__fill_1_639
+ vss
+ vdd
+ vdd
+ sky130_fd_sc_hd__fill_1
* cell instance sky130_fd_sc_hd__fill_1_640 r0 *1 0,0
Xsky130_fd_sc_hd__fill_1_640
+ vss
+ vdd
+ vdd
+ sky130_fd_sc_hd__fill_1
* cell instance sky130_fd_sc_hd__fill_1_641 r0 *1 0,0
Xsky130_fd_sc_hd__fill_1_641
+ vss
+ vdd
+ vdd
+ sky130_fd_sc_hd__fill_1
* cell instance sky130_fd_sc_hd__fill_1_642 r0 *1 0,0
Xsky130_fd_sc_hd__fill_1_642
+ vss
+ vdd
+ vdd
+ sky130_fd_sc_hd__fill_1
* cell instance sky130_fd_sc_hd__fill_1_643 r0 *1 0,0
Xsky130_fd_sc_hd__fill_1_643
+ vss
+ vdd
+ vdd
+ sky130_fd_sc_hd__fill_1
* cell instance sky130_fd_sc_hd__fill_1_644 r0 *1 0,0
Xsky130_fd_sc_hd__fill_1_644
+ vss
+ vdd
+ vdd
+ sky130_fd_sc_hd__fill_1
* cell instance sky130_fd_sc_hd__fill_1_645 r0 *1 0,0
Xsky130_fd_sc_hd__fill_1_645
+ vss
+ vdd
+ vdd
+ sky130_fd_sc_hd__fill_1
* cell instance sky130_fd_sc_hd__fill_1_646 r0 *1 0,0
Xsky130_fd_sc_hd__fill_1_646
+ vss
+ vdd
+ vdd
+ sky130_fd_sc_hd__fill_1
* cell instance sky130_fd_sc_hd__fill_1_647 r0 *1 0,0
Xsky130_fd_sc_hd__fill_1_647
+ vss
+ vdd
+ vdd
+ sky130_fd_sc_hd__fill_1
* cell instance sky130_fd_sc_hd__fill_1_648 r0 *1 0,0
Xsky130_fd_sc_hd__fill_1_648
+ vss
+ vdd
+ vdd
+ sky130_fd_sc_hd__fill_1
* cell instance sky130_fd_sc_hd__fill_1_649 r0 *1 0,0
Xsky130_fd_sc_hd__fill_1_649
+ vss
+ vdd
+ vdd
+ sky130_fd_sc_hd__fill_1
* cell instance sky130_fd_sc_hd__fill_1_650 r0 *1 0,0
Xsky130_fd_sc_hd__fill_1_650
+ vss
+ vdd
+ vdd
+ sky130_fd_sc_hd__fill_1
* cell instance sky130_fd_sc_hd__fill_1_651 r0 *1 0,0
Xsky130_fd_sc_hd__fill_1_651
+ vss
+ vdd
+ vdd
+ sky130_fd_sc_hd__fill_1
* cell instance sky130_fd_sc_hd__fill_1_652 r0 *1 0,0
Xsky130_fd_sc_hd__fill_1_652
+ vss
+ vdd
+ vdd
+ sky130_fd_sc_hd__fill_1
* cell instance sky130_fd_sc_hd__fill_1_653 r0 *1 0,0
Xsky130_fd_sc_hd__fill_1_653
+ vss
+ vdd
+ vdd
+ sky130_fd_sc_hd__fill_1
* cell instance sky130_fd_sc_hd__fill_1_654 r0 *1 0,0
Xsky130_fd_sc_hd__fill_1_654
+ vss
+ vdd
+ vdd
+ sky130_fd_sc_hd__fill_1
* cell instance sky130_fd_sc_hd__fill_1_655 r0 *1 0,0
Xsky130_fd_sc_hd__fill_1_655
+ vss
+ vdd
+ vdd
+ sky130_fd_sc_hd__fill_1
* cell instance sky130_fd_sc_hd__fill_1_656 r0 *1 0,0
Xsky130_fd_sc_hd__fill_1_656
+ vss
+ vdd
+ vdd
+ sky130_fd_sc_hd__fill_1
* cell instance sky130_fd_sc_hd__fill_1_657 r0 *1 0,0
Xsky130_fd_sc_hd__fill_1_657
+ vss
+ vdd
+ vdd
+ sky130_fd_sc_hd__fill_1
* cell instance sky130_fd_sc_hd__fill_1_658 r0 *1 0,0
Xsky130_fd_sc_hd__fill_1_658
+ vss
+ vdd
+ vdd
+ sky130_fd_sc_hd__fill_1
* cell instance sky130_fd_sc_hd__fill_1_659 r0 *1 0,0
Xsky130_fd_sc_hd__fill_1_659
+ vss
+ vdd
+ vdd
+ sky130_fd_sc_hd__fill_1
* cell instance sky130_fd_sc_hd__fill_1_660 r0 *1 0,0
Xsky130_fd_sc_hd__fill_1_660
+ vss
+ vdd
+ vdd
+ sky130_fd_sc_hd__fill_1
* cell instance sky130_fd_sc_hd__fill_1_661 r0 *1 0,0
Xsky130_fd_sc_hd__fill_1_661
+ vss
+ vdd
+ vdd
+ sky130_fd_sc_hd__fill_1
* cell instance sky130_fd_sc_hd__fill_1_662 r0 *1 0,0
Xsky130_fd_sc_hd__fill_1_662
+ vss
+ vdd
+ vdd
+ sky130_fd_sc_hd__fill_1
* cell instance sky130_fd_sc_hd__fill_1_663 r0 *1 0,0
Xsky130_fd_sc_hd__fill_1_663
+ vss
+ vdd
+ vdd
+ sky130_fd_sc_hd__fill_1
* cell instance sky130_fd_sc_hd__fill_1_664 r0 *1 0,0
Xsky130_fd_sc_hd__fill_1_664
+ vss
+ vdd
+ vdd
+ sky130_fd_sc_hd__fill_1
* cell instance sky130_fd_sc_hd__fill_1_665 r0 *1 0,0
Xsky130_fd_sc_hd__fill_1_665
+ vss
+ vdd
+ vdd
+ sky130_fd_sc_hd__fill_1
* cell instance sky130_fd_sc_hd__fill_1_666 r0 *1 0,0
Xsky130_fd_sc_hd__fill_1_666
+ vss
+ vdd
+ vdd
+ sky130_fd_sc_hd__fill_1
* cell instance sky130_fd_sc_hd__fill_1_667 r0 *1 0,0
Xsky130_fd_sc_hd__fill_1_667
+ vss
+ vdd
+ vdd
+ sky130_fd_sc_hd__fill_1
* cell instance sky130_fd_sc_hd__fill_1_668 r0 *1 0,0
Xsky130_fd_sc_hd__fill_1_668
+ vss
+ vdd
+ vdd
+ sky130_fd_sc_hd__fill_1
* cell instance sky130_fd_sc_hd__fill_1_669 r0 *1 0,0
Xsky130_fd_sc_hd__fill_1_669
+ vss
+ vdd
+ vdd
+ sky130_fd_sc_hd__fill_1
* cell instance sky130_fd_sc_hd__fill_1_670 r0 *1 0,0
Xsky130_fd_sc_hd__fill_1_670
+ vss
+ vdd
+ vdd
+ sky130_fd_sc_hd__fill_1
* cell instance sky130_fd_sc_hd__fill_1_671 r0 *1 0,0
Xsky130_fd_sc_hd__fill_1_671
+ vss
+ vdd
+ vdd
+ sky130_fd_sc_hd__fill_1
* cell instance sky130_fd_sc_hd__fill_1_672 r0 *1 0,0
Xsky130_fd_sc_hd__fill_1_672
+ vss
+ vdd
+ vdd
+ sky130_fd_sc_hd__fill_1
* cell instance sky130_fd_sc_hd__fill_1_673 r0 *1 0,0
Xsky130_fd_sc_hd__fill_1_673
+ vss
+ vdd
+ vdd
+ sky130_fd_sc_hd__fill_1
* cell instance sky130_fd_sc_hd__fill_1_674 r0 *1 0,0
Xsky130_fd_sc_hd__fill_1_674
+ vss
+ vdd
+ vdd
+ sky130_fd_sc_hd__fill_1
* cell instance sky130_fd_sc_hd__fill_1_675 r0 *1 0,0
Xsky130_fd_sc_hd__fill_1_675
+ vss
+ vdd
+ vdd
+ sky130_fd_sc_hd__fill_1
* cell instance sky130_fd_sc_hd__fill_1_676 r0 *1 0,0
Xsky130_fd_sc_hd__fill_1_676
+ vss
+ vdd
+ vdd
+ sky130_fd_sc_hd__fill_1
* cell instance sky130_fd_sc_hd__fill_1_677 r0 *1 0,0
Xsky130_fd_sc_hd__fill_1_677
+ vss
+ vdd
+ vdd
+ sky130_fd_sc_hd__fill_1
* cell instance sky130_fd_sc_hd__fill_1_678 r0 *1 0,0
Xsky130_fd_sc_hd__fill_1_678
+ vss
+ vdd
+ vdd
+ sky130_fd_sc_hd__fill_1
* cell instance sky130_fd_sc_hd__fill_1_679 r0 *1 0,0
Xsky130_fd_sc_hd__fill_1_679
+ vss
+ vdd
+ vdd
+ sky130_fd_sc_hd__fill_1
* cell instance sky130_fd_sc_hd__fill_1_680 r0 *1 0,0
Xsky130_fd_sc_hd__fill_1_680
+ vss
+ vdd
+ vdd
+ sky130_fd_sc_hd__fill_1
* cell instance sky130_fd_sc_hd__fill_1_681 r0 *1 0,0
Xsky130_fd_sc_hd__fill_1_681
+ vss
+ vdd
+ vdd
+ sky130_fd_sc_hd__fill_1
* cell instance sky130_fd_sc_hd__fill_1_682 r0 *1 0,0
Xsky130_fd_sc_hd__fill_1_682
+ vss
+ vdd
+ vdd
+ sky130_fd_sc_hd__fill_1
* cell instance sky130_fd_sc_hd__fill_1_683 r0 *1 0,0
Xsky130_fd_sc_hd__fill_1_683
+ vss
+ vdd
+ vdd
+ sky130_fd_sc_hd__fill_1
* cell instance sky130_fd_sc_hd__fill_1_684 r0 *1 0,0
Xsky130_fd_sc_hd__fill_1_684
+ vss
+ vdd
+ vdd
+ sky130_fd_sc_hd__fill_1
* cell instance sky130_fd_sc_hd__fill_1_685 r0 *1 0,0
Xsky130_fd_sc_hd__fill_1_685
+ vss
+ vdd
+ vdd
+ sky130_fd_sc_hd__fill_1
* cell instance sky130_fd_sc_hd__fill_1_686 r0 *1 0,0
Xsky130_fd_sc_hd__fill_1_686
+ vss
+ vdd
+ vdd
+ sky130_fd_sc_hd__fill_1
* cell instance sky130_fd_sc_hd__fill_1_687 r0 *1 0,0
Xsky130_fd_sc_hd__fill_1_687
+ vss
+ vdd
+ vdd
+ sky130_fd_sc_hd__fill_1
* cell instance sky130_fd_sc_hd__fill_1_688 r0 *1 0,0
Xsky130_fd_sc_hd__fill_1_688
+ vss
+ vdd
+ vdd
+ sky130_fd_sc_hd__fill_1
* cell instance sky130_fd_sc_hd__fill_1_689 r0 *1 0,0
Xsky130_fd_sc_hd__fill_1_689
+ vss
+ vdd
+ vdd
+ sky130_fd_sc_hd__fill_1
* cell instance sky130_fd_sc_hd__fill_1_690 r0 *1 0,0
Xsky130_fd_sc_hd__fill_1_690
+ vss
+ vdd
+ vdd
+ sky130_fd_sc_hd__fill_1
* cell instance sky130_fd_sc_hd__fill_1_691 r0 *1 0,0
Xsky130_fd_sc_hd__fill_1_691
+ vss
+ vdd
+ vdd
+ sky130_fd_sc_hd__fill_1
* cell instance sky130_fd_sc_hd__fill_1_692 r0 *1 0,0
Xsky130_fd_sc_hd__fill_1_692
+ vss
+ vdd
+ vdd
+ sky130_fd_sc_hd__fill_1
* cell instance sky130_fd_sc_hd__fill_1_693 r0 *1 0,0
Xsky130_fd_sc_hd__fill_1_693
+ vss
+ vdd
+ vdd
+ sky130_fd_sc_hd__fill_1
* cell instance sky130_fd_sc_hd__fill_1_694 r0 *1 0,0
Xsky130_fd_sc_hd__fill_1_694
+ vss
+ vdd
+ vdd
+ sky130_fd_sc_hd__fill_1
* cell instance sky130_fd_sc_hd__fill_1_695 r0 *1 0,0
Xsky130_fd_sc_hd__fill_1_695
+ vss
+ vdd
+ vdd
+ sky130_fd_sc_hd__fill_1
* cell instance sky130_fd_sc_hd__fill_1_696 r0 *1 0,0
Xsky130_fd_sc_hd__fill_1_696
+ vss
+ vdd
+ vdd
+ sky130_fd_sc_hd__fill_1
* cell instance sky130_fd_sc_hd__fill_1_697 r0 *1 0,0
Xsky130_fd_sc_hd__fill_1_697
+ vss
+ vdd
+ vdd
+ sky130_fd_sc_hd__fill_1
* cell instance sky130_fd_sc_hd__fill_1_698 r0 *1 0,0
Xsky130_fd_sc_hd__fill_1_698
+ vss
+ vdd
+ vdd
+ sky130_fd_sc_hd__fill_1
* cell instance sky130_fd_sc_hd__fill_1_699 r0 *1 0,0
Xsky130_fd_sc_hd__fill_1_699
+ vss
+ vdd
+ vdd
+ sky130_fd_sc_hd__fill_1
* cell instance sky130_fd_sc_hd__fill_1_700 r0 *1 0,0
Xsky130_fd_sc_hd__fill_1_700
+ vss
+ vdd
+ vdd
+ sky130_fd_sc_hd__fill_1
* cell instance sky130_fd_sc_hd__fill_1_701 r0 *1 0,0
Xsky130_fd_sc_hd__fill_1_701
+ vss
+ vdd
+ vdd
+ sky130_fd_sc_hd__fill_1
* cell instance sky130_fd_sc_hd__fill_1_702 r0 *1 0,0
Xsky130_fd_sc_hd__fill_1_702
+ vss
+ vdd
+ vdd
+ sky130_fd_sc_hd__fill_1
* cell instance sky130_fd_sc_hd__fill_1_703 r0 *1 0,0
Xsky130_fd_sc_hd__fill_1_703
+ vss
+ vdd
+ vdd
+ sky130_fd_sc_hd__fill_1
* cell instance sky130_fd_sc_hd__fill_1_704 r0 *1 0,0
Xsky130_fd_sc_hd__fill_1_704
+ vss
+ vdd
+ vdd
+ sky130_fd_sc_hd__fill_1
* cell instance sky130_fd_sc_hd__fill_1_705 r0 *1 0,0
Xsky130_fd_sc_hd__fill_1_705
+ vss
+ vdd
+ vdd
+ sky130_fd_sc_hd__fill_1
* cell instance sky130_fd_sc_hd__fill_1_706 r0 *1 0,0
Xsky130_fd_sc_hd__fill_1_706
+ vss
+ vdd
+ vdd
+ sky130_fd_sc_hd__fill_1
* cell instance sky130_fd_sc_hd__fill_1_707 r0 *1 0,0
Xsky130_fd_sc_hd__fill_1_707
+ vss
+ vdd
+ vdd
+ sky130_fd_sc_hd__fill_1
* cell instance sky130_fd_sc_hd__fill_1_708 r0 *1 0,0
Xsky130_fd_sc_hd__fill_1_708
+ vss
+ vdd
+ vdd
+ sky130_fd_sc_hd__fill_1
* cell instance sky130_fd_sc_hd__fill_1_709 r0 *1 0,0
Xsky130_fd_sc_hd__fill_1_709
+ vss
+ vdd
+ vdd
+ sky130_fd_sc_hd__fill_1
* cell instance sky130_fd_sc_hd__fill_1_710 r0 *1 0,0
Xsky130_fd_sc_hd__fill_1_710
+ vss
+ vdd
+ vdd
+ sky130_fd_sc_hd__fill_1
* cell instance sky130_fd_sc_hd__fill_1_711 r0 *1 0,0
Xsky130_fd_sc_hd__fill_1_711
+ vss
+ vdd
+ vdd
+ sky130_fd_sc_hd__fill_1
* cell instance sky130_fd_sc_hd__fill_1_712 r0 *1 0,0
Xsky130_fd_sc_hd__fill_1_712
+ vss
+ vdd
+ vdd
+ sky130_fd_sc_hd__fill_1
* cell instance sky130_fd_sc_hd__fill_1_713 r0 *1 0,0
Xsky130_fd_sc_hd__fill_1_713
+ vss
+ vdd
+ vdd
+ sky130_fd_sc_hd__fill_1
* cell instance sky130_fd_sc_hd__fill_1_714 r0 *1 0,0
Xsky130_fd_sc_hd__fill_1_714
+ vss
+ vdd
+ vdd
+ sky130_fd_sc_hd__fill_1
* cell instance sky130_fd_sc_hd__fill_1_715 r0 *1 0,0
Xsky130_fd_sc_hd__fill_1_715
+ vss
+ vdd
+ vdd
+ sky130_fd_sc_hd__fill_1
* cell instance sky130_fd_sc_hd__fill_1_716 r0 *1 0,0
Xsky130_fd_sc_hd__fill_1_716
+ vss
+ vdd
+ vdd
+ sky130_fd_sc_hd__fill_1
* cell instance sky130_fd_sc_hd__fill_1_717 r0 *1 0,0
Xsky130_fd_sc_hd__fill_1_717
+ vss
+ vdd
+ vdd
+ sky130_fd_sc_hd__fill_1
* cell instance sky130_fd_sc_hd__fill_1_718 r0 *1 0,0
Xsky130_fd_sc_hd__fill_1_718
+ vss
+ vdd
+ vdd
+ sky130_fd_sc_hd__fill_1
* cell instance sky130_fd_sc_hd__fill_1_719 r0 *1 0,0
Xsky130_fd_sc_hd__fill_1_719
+ vss
+ vdd
+ vdd
+ sky130_fd_sc_hd__fill_1
* cell instance sky130_fd_sc_hd__fill_1_720 r0 *1 0,0
Xsky130_fd_sc_hd__fill_1_720
+ vss
+ vdd
+ vdd
+ sky130_fd_sc_hd__fill_1
* cell instance sky130_fd_sc_hd__fill_1_721 r0 *1 0,0
Xsky130_fd_sc_hd__fill_1_721
+ vss
+ vdd
+ vdd
+ sky130_fd_sc_hd__fill_1
* cell instance sky130_fd_sc_hd__fill_1_722 r0 *1 0,0
Xsky130_fd_sc_hd__fill_1_722
+ vss
+ vdd
+ vdd
+ sky130_fd_sc_hd__fill_1
* cell instance sky130_fd_sc_hd__fill_1_723 r0 *1 0,0
Xsky130_fd_sc_hd__fill_1_723
+ vss
+ vdd
+ vdd
+ sky130_fd_sc_hd__fill_1
* cell instance sky130_fd_sc_hd__fill_1_724 r0 *1 0,0
Xsky130_fd_sc_hd__fill_1_724
+ vss
+ vdd
+ vdd
+ sky130_fd_sc_hd__fill_1
* cell instance sky130_fd_sc_hd__fill_1_725 r0 *1 0,0
Xsky130_fd_sc_hd__fill_1_725
+ vss
+ vdd
+ vdd
+ sky130_fd_sc_hd__fill_1
* cell instance sky130_fd_sc_hd__fill_1_726 r0 *1 0,0
Xsky130_fd_sc_hd__fill_1_726
+ vss
+ vdd
+ vdd
+ sky130_fd_sc_hd__fill_1
* cell instance sky130_fd_sc_hd__fill_1_727 r0 *1 0,0
Xsky130_fd_sc_hd__fill_1_727
+ vss
+ vdd
+ vdd
+ sky130_fd_sc_hd__fill_1
* cell instance sky130_fd_sc_hd__fill_1_728 r0 *1 0,0
Xsky130_fd_sc_hd__fill_1_728
+ vss
+ vdd
+ vdd
+ sky130_fd_sc_hd__fill_1
* cell instance sky130_fd_sc_hd__fill_1_729 r0 *1 0,0
Xsky130_fd_sc_hd__fill_1_729
+ vss
+ vdd
+ vdd
+ sky130_fd_sc_hd__fill_1
* cell instance sky130_fd_sc_hd__fill_1_730 r0 *1 0,0
Xsky130_fd_sc_hd__fill_1_730
+ vss
+ vdd
+ vdd
+ sky130_fd_sc_hd__fill_1
* cell instance sky130_fd_sc_hd__fill_1_731 r0 *1 0,0
Xsky130_fd_sc_hd__fill_1_731
+ vss
+ vdd
+ vdd
+ sky130_fd_sc_hd__fill_1
* cell instance sky130_fd_sc_hd__fill_1_732 r0 *1 0,0
Xsky130_fd_sc_hd__fill_1_732
+ vss
+ vdd
+ vdd
+ sky130_fd_sc_hd__fill_1
* cell instance sky130_fd_sc_hd__fill_1_733 r0 *1 0,0
Xsky130_fd_sc_hd__fill_1_733
+ vss
+ vdd
+ vdd
+ sky130_fd_sc_hd__fill_1
* cell instance sky130_fd_sc_hd__fill_1_734 r0 *1 0,0
Xsky130_fd_sc_hd__fill_1_734
+ vss
+ vdd
+ vdd
+ sky130_fd_sc_hd__fill_1
* cell instance sky130_fd_sc_hd__fill_1_735 r0 *1 0,0
Xsky130_fd_sc_hd__fill_1_735
+ vss
+ vdd
+ vdd
+ sky130_fd_sc_hd__fill_1
* cell instance sky130_fd_sc_hd__fill_1_736 r0 *1 0,0
Xsky130_fd_sc_hd__fill_1_736
+ vss
+ vdd
+ vdd
+ sky130_fd_sc_hd__fill_1
* cell instance sky130_fd_sc_hd__fill_1_737 r0 *1 0,0
Xsky130_fd_sc_hd__fill_1_737
+ vss
+ vdd
+ vdd
+ sky130_fd_sc_hd__fill_1
* cell instance sky130_fd_sc_hd__fill_1_738 r0 *1 0,0
Xsky130_fd_sc_hd__fill_1_738
+ vss
+ vdd
+ vdd
+ sky130_fd_sc_hd__fill_1
* cell instance sky130_fd_sc_hd__fill_1_739 r0 *1 0,0
Xsky130_fd_sc_hd__fill_1_739
+ vss
+ vdd
+ vdd
+ sky130_fd_sc_hd__fill_1
* cell instance sky130_fd_sc_hd__fill_1_740 r0 *1 0,0
Xsky130_fd_sc_hd__fill_1_740
+ vss
+ vdd
+ vdd
+ sky130_fd_sc_hd__fill_1
* cell instance sky130_fd_sc_hd__fill_1_741 r0 *1 0,0
Xsky130_fd_sc_hd__fill_1_741
+ vss
+ vdd
+ vdd
+ sky130_fd_sc_hd__fill_1
* cell instance sky130_fd_sc_hd__fill_1_742 r0 *1 0,0
Xsky130_fd_sc_hd__fill_1_742
+ vss
+ vdd
+ vdd
+ sky130_fd_sc_hd__fill_1
* cell instance sky130_fd_sc_hd__fill_1_743 r0 *1 0,0
Xsky130_fd_sc_hd__fill_1_743
+ vss
+ vdd
+ vdd
+ sky130_fd_sc_hd__fill_1
* cell instance sky130_fd_sc_hd__fill_1_744 r0 *1 0,0
Xsky130_fd_sc_hd__fill_1_744
+ vss
+ vdd
+ vdd
+ sky130_fd_sc_hd__fill_1
* cell instance sky130_fd_sc_hd__fill_1_745 r0 *1 0,0
Xsky130_fd_sc_hd__fill_1_745
+ vss
+ vdd
+ vdd
+ sky130_fd_sc_hd__fill_1
* cell instance sky130_fd_sc_hd__fill_1_746 r0 *1 0,0
Xsky130_fd_sc_hd__fill_1_746
+ vss
+ vdd
+ vdd
+ sky130_fd_sc_hd__fill_1
* cell instance sky130_fd_sc_hd__fill_1_747 r0 *1 0,0
Xsky130_fd_sc_hd__fill_1_747
+ vss
+ vdd
+ vdd
+ sky130_fd_sc_hd__fill_1
* cell instance sky130_fd_sc_hd__fill_1_748 r0 *1 0,0
Xsky130_fd_sc_hd__fill_1_748
+ vss
+ vdd
+ vdd
+ sky130_fd_sc_hd__fill_1
* cell instance sky130_fd_sc_hd__fill_1_749 r0 *1 0,0
Xsky130_fd_sc_hd__fill_1_749
+ vss
+ vdd
+ vdd
+ sky130_fd_sc_hd__fill_1
* cell instance sky130_fd_sc_hd__fill_1_750 r0 *1 0,0
Xsky130_fd_sc_hd__fill_1_750
+ vss
+ vdd
+ vdd
+ sky130_fd_sc_hd__fill_1
* cell instance sky130_fd_sc_hd__fill_1_751 r0 *1 0,0
Xsky130_fd_sc_hd__fill_1_751
+ vss
+ vdd
+ vdd
+ sky130_fd_sc_hd__fill_1
* cell instance sky130_fd_sc_hd__fill_1_752 r0 *1 0,0
Xsky130_fd_sc_hd__fill_1_752
+ vss
+ vdd
+ vdd
+ sky130_fd_sc_hd__fill_1
* cell instance sky130_fd_sc_hd__fill_1_753 r0 *1 0,0
Xsky130_fd_sc_hd__fill_1_753
+ vss
+ vdd
+ vdd
+ sky130_fd_sc_hd__fill_1
* cell instance sky130_fd_sc_hd__fill_1_754 r0 *1 0,0
Xsky130_fd_sc_hd__fill_1_754
+ vss
+ vdd
+ vdd
+ sky130_fd_sc_hd__fill_1
* cell instance sky130_fd_sc_hd__fill_1_755 r0 *1 0,0
Xsky130_fd_sc_hd__fill_1_755
+ vss
+ vdd
+ vdd
+ sky130_fd_sc_hd__fill_1
* cell instance sky130_fd_sc_hd__fill_1_756 r0 *1 0,0
Xsky130_fd_sc_hd__fill_1_756
+ vss
+ vdd
+ vdd
+ sky130_fd_sc_hd__fill_1
* cell instance sky130_fd_sc_hd__fill_1_757 r0 *1 0,0
Xsky130_fd_sc_hd__fill_1_757
+ vss
+ vdd
+ vdd
+ sky130_fd_sc_hd__fill_1
* cell instance sky130_fd_sc_hd__fill_1_758 r0 *1 0,0
Xsky130_fd_sc_hd__fill_1_758
+ vss
+ vdd
+ vdd
+ sky130_fd_sc_hd__fill_1
* cell instance sky130_fd_sc_hd__fill_1_759 r0 *1 0,0
Xsky130_fd_sc_hd__fill_1_759
+ vss
+ vdd
+ vdd
+ sky130_fd_sc_hd__fill_1
* cell instance sky130_fd_sc_hd__fill_1_760 r0 *1 0,0
Xsky130_fd_sc_hd__fill_1_760
+ vss
+ vdd
+ vdd
+ sky130_fd_sc_hd__fill_1
* cell instance sky130_fd_sc_hd__fill_1_761 r0 *1 0,0
Xsky130_fd_sc_hd__fill_1_761
+ vss
+ vdd
+ vdd
+ sky130_fd_sc_hd__fill_1
* cell instance sky130_fd_sc_hd__fill_1_762 r0 *1 0,0
Xsky130_fd_sc_hd__fill_1_762
+ vss
+ vdd
+ vdd
+ sky130_fd_sc_hd__fill_1
* cell instance sky130_fd_sc_hd__fill_1_763 r0 *1 0,0
Xsky130_fd_sc_hd__fill_1_763
+ vss
+ vdd
+ vdd
+ sky130_fd_sc_hd__fill_1
* cell instance sky130_fd_sc_hd__fill_1_764 r0 *1 0,0
Xsky130_fd_sc_hd__fill_1_764
+ vss
+ vdd
+ vdd
+ sky130_fd_sc_hd__fill_1
* cell instance sky130_fd_sc_hd__fill_1_765 r0 *1 0,0
Xsky130_fd_sc_hd__fill_1_765
+ vss
+ vdd
+ vdd
+ sky130_fd_sc_hd__fill_1
* cell instance sky130_fd_sc_hd__fill_1_766 r0 *1 0,0
Xsky130_fd_sc_hd__fill_1_766
+ vss
+ vdd
+ vdd
+ sky130_fd_sc_hd__fill_1
* cell instance sky130_fd_sc_hd__fill_1_767 r0 *1 0,0
Xsky130_fd_sc_hd__fill_1_767
+ vss
+ vdd
+ vdd
+ sky130_fd_sc_hd__fill_1
* cell instance sky130_fd_sc_hd__fill_1_768 r0 *1 0,0
Xsky130_fd_sc_hd__fill_1_768
+ vss
+ vdd
+ vdd
+ sky130_fd_sc_hd__fill_1
* cell instance sky130_fd_sc_hd__fill_1_769 r0 *1 0,0
Xsky130_fd_sc_hd__fill_1_769
+ vss
+ vdd
+ vdd
+ sky130_fd_sc_hd__fill_1
* cell instance sky130_fd_sc_hd__fill_1_770 r0 *1 0,0
Xsky130_fd_sc_hd__fill_1_770
+ vss
+ vdd
+ vdd
+ sky130_fd_sc_hd__fill_1
* cell instance sky130_fd_sc_hd__fill_1_771 r0 *1 0,0
Xsky130_fd_sc_hd__fill_1_771
+ vss
+ vdd
+ vdd
+ sky130_fd_sc_hd__fill_1
* cell instance sky130_fd_sc_hd__fill_1_772 r0 *1 0,0
Xsky130_fd_sc_hd__fill_1_772
+ vss
+ vdd
+ vdd
+ sky130_fd_sc_hd__fill_1
* cell instance sky130_fd_sc_hd__fill_1_773 r0 *1 0,0
Xsky130_fd_sc_hd__fill_1_773
+ vss
+ vdd
+ vdd
+ sky130_fd_sc_hd__fill_1
* cell instance sky130_fd_sc_hd__fill_1_774 r0 *1 0,0
Xsky130_fd_sc_hd__fill_1_774
+ vss
+ vdd
+ vdd
+ sky130_fd_sc_hd__fill_1
* cell instance sky130_fd_sc_hd__fill_1_775 r0 *1 0,0
Xsky130_fd_sc_hd__fill_1_775
+ vss
+ vdd
+ vdd
+ sky130_fd_sc_hd__fill_1
* cell instance sky130_fd_sc_hd__fill_1_776 r0 *1 0,0
Xsky130_fd_sc_hd__fill_1_776
+ vss
+ vdd
+ vdd
+ sky130_fd_sc_hd__fill_1
* cell instance sky130_fd_sc_hd__fill_1_777 r0 *1 0,0
Xsky130_fd_sc_hd__fill_1_777
+ vss
+ vdd
+ vdd
+ sky130_fd_sc_hd__fill_1
* cell instance sky130_fd_sc_hd__fill_1_778 r0 *1 0,0
Xsky130_fd_sc_hd__fill_1_778
+ vss
+ vdd
+ vdd
+ sky130_fd_sc_hd__fill_1
* cell instance sky130_fd_sc_hd__fill_1_779 r0 *1 0,0
Xsky130_fd_sc_hd__fill_1_779
+ vss
+ vdd
+ vdd
+ sky130_fd_sc_hd__fill_1
* cell instance sky130_fd_sc_hd__fill_1_780 r0 *1 0,0
Xsky130_fd_sc_hd__fill_1_780
+ vss
+ vdd
+ vdd
+ sky130_fd_sc_hd__fill_1
* cell instance sky130_fd_sc_hd__fill_1_781 r0 *1 0,0
Xsky130_fd_sc_hd__fill_1_781
+ vss
+ vdd
+ vdd
+ sky130_fd_sc_hd__fill_1
* cell instance sky130_fd_sc_hd__fill_1_782 r0 *1 0,0
Xsky130_fd_sc_hd__fill_1_782
+ vss
+ vdd
+ vdd
+ sky130_fd_sc_hd__fill_1
* cell instance sky130_fd_sc_hd__fill_1_783 r0 *1 0,0
Xsky130_fd_sc_hd__fill_1_783
+ vss
+ vdd
+ vdd
+ sky130_fd_sc_hd__fill_1
* cell instance sky130_fd_sc_hd__fill_1_784 r0 *1 0,0
Xsky130_fd_sc_hd__fill_1_784
+ vss
+ vdd
+ vdd
+ sky130_fd_sc_hd__fill_1
* cell instance sky130_fd_sc_hd__fill_1_785 r0 *1 0,0
Xsky130_fd_sc_hd__fill_1_785
+ vss
+ vdd
+ vdd
+ sky130_fd_sc_hd__fill_1
* cell instance sky130_fd_sc_hd__fill_1_786 r0 *1 0,0
Xsky130_fd_sc_hd__fill_1_786
+ vss
+ vdd
+ vdd
+ sky130_fd_sc_hd__fill_1
* cell instance sky130_fd_sc_hd__fill_1_787 r0 *1 0,0
Xsky130_fd_sc_hd__fill_1_787
+ vss
+ vdd
+ vdd
+ sky130_fd_sc_hd__fill_1
* cell instance sky130_fd_sc_hd__fill_1_788 r0 *1 0,0
Xsky130_fd_sc_hd__fill_1_788
+ vss
+ vdd
+ vdd
+ sky130_fd_sc_hd__fill_1
* cell instance sky130_fd_sc_hd__fill_1_789 r0 *1 0,0
Xsky130_fd_sc_hd__fill_1_789
+ vss
+ vdd
+ vdd
+ sky130_fd_sc_hd__fill_1
* cell instance sky130_fd_sc_hd__fill_1_790 r0 *1 0,0
Xsky130_fd_sc_hd__fill_1_790
+ vss
+ vdd
+ vdd
+ sky130_fd_sc_hd__fill_1
* cell instance sky130_fd_sc_hd__fill_1_791 r0 *1 0,0
Xsky130_fd_sc_hd__fill_1_791
+ vss
+ vdd
+ vdd
+ sky130_fd_sc_hd__fill_1
* cell instance sky130_fd_sc_hd__fill_1_792 r0 *1 0,0
Xsky130_fd_sc_hd__fill_1_792
+ vss
+ vdd
+ vdd
+ sky130_fd_sc_hd__fill_1
* cell instance sky130_fd_sc_hd__fill_1_793 r0 *1 0,0
Xsky130_fd_sc_hd__fill_1_793
+ vss
+ vdd
+ vdd
+ sky130_fd_sc_hd__fill_1
* cell instance sky130_fd_sc_hd__fill_1_794 r0 *1 0,0
Xsky130_fd_sc_hd__fill_1_794
+ vss
+ vdd
+ vdd
+ sky130_fd_sc_hd__fill_1
* cell instance sky130_fd_sc_hd__fill_1_795 r0 *1 0,0
Xsky130_fd_sc_hd__fill_1_795
+ vss
+ vdd
+ vdd
+ sky130_fd_sc_hd__fill_1
* cell instance sky130_fd_sc_hd__fill_1_796 r0 *1 0,0
Xsky130_fd_sc_hd__fill_1_796
+ vss
+ vdd
+ vdd
+ sky130_fd_sc_hd__fill_1
* cell instance sky130_fd_sc_hd__fill_1_797 r0 *1 0,0
Xsky130_fd_sc_hd__fill_1_797
+ vss
+ vdd
+ vdd
+ sky130_fd_sc_hd__fill_1
* cell instance sky130_fd_sc_hd__fill_1_798 r0 *1 0,0
Xsky130_fd_sc_hd__fill_1_798
+ vss
+ vdd
+ vdd
+ sky130_fd_sc_hd__fill_1
* cell instance sky130_fd_sc_hd__fill_1_799 r0 *1 0,0
Xsky130_fd_sc_hd__fill_1_799
+ vss
+ vdd
+ vdd
+ sky130_fd_sc_hd__fill_1
* cell instance sky130_fd_sc_hd__fill_1_800 r0 *1 0,0
Xsky130_fd_sc_hd__fill_1_800
+ vss
+ vdd
+ vdd
+ sky130_fd_sc_hd__fill_1
* cell instance sky130_fd_sc_hd__fill_1_801 r0 *1 0,0
Xsky130_fd_sc_hd__fill_1_801
+ vss
+ vdd
+ vdd
+ sky130_fd_sc_hd__fill_1
* cell instance sky130_fd_sc_hd__fill_1_802 r0 *1 0,0
Xsky130_fd_sc_hd__fill_1_802
+ vss
+ vdd
+ vdd
+ sky130_fd_sc_hd__fill_1
* cell instance sky130_fd_sc_hd__fill_1_803 r0 *1 0,0
Xsky130_fd_sc_hd__fill_1_803
+ vss
+ vdd
+ vdd
+ sky130_fd_sc_hd__fill_1
* cell instance sky130_fd_sc_hd__fill_1_804 r0 *1 0,0
Xsky130_fd_sc_hd__fill_1_804
+ vss
+ vdd
+ vdd
+ sky130_fd_sc_hd__fill_1
* cell instance sky130_fd_sc_hd__fill_1_805 r0 *1 0,0
Xsky130_fd_sc_hd__fill_1_805
+ vss
+ vdd
+ vdd
+ sky130_fd_sc_hd__fill_1
* cell instance sky130_fd_sc_hd__fill_1_806 r0 *1 0,0
Xsky130_fd_sc_hd__fill_1_806
+ vss
+ vdd
+ vdd
+ sky130_fd_sc_hd__fill_1
* cell instance sky130_fd_sc_hd__fill_1_807 r0 *1 0,0
Xsky130_fd_sc_hd__fill_1_807
+ vss
+ vdd
+ vdd
+ sky130_fd_sc_hd__fill_1
* cell instance sky130_fd_sc_hd__fill_1_808 r0 *1 0,0
Xsky130_fd_sc_hd__fill_1_808
+ vss
+ vdd
+ vdd
+ sky130_fd_sc_hd__fill_1
* cell instance sky130_fd_sc_hd__fill_1_809 r0 *1 0,0
Xsky130_fd_sc_hd__fill_1_809
+ vss
+ vdd
+ vdd
+ sky130_fd_sc_hd__fill_1
* cell instance sky130_fd_sc_hd__fill_1_810 r0 *1 0,0
Xsky130_fd_sc_hd__fill_1_810
+ vss
+ vdd
+ vdd
+ sky130_fd_sc_hd__fill_1
* cell instance sky130_fd_sc_hd__fill_1_811 r0 *1 0,0
Xsky130_fd_sc_hd__fill_1_811
+ vss
+ vdd
+ vdd
+ sky130_fd_sc_hd__fill_1
* cell instance sky130_fd_sc_hd__fill_1_812 r0 *1 0,0
Xsky130_fd_sc_hd__fill_1_812
+ vss
+ vdd
+ vdd
+ sky130_fd_sc_hd__fill_1
* cell instance sky130_fd_sc_hd__fill_1_813 r0 *1 0,0
Xsky130_fd_sc_hd__fill_1_813
+ vss
+ vdd
+ vdd
+ sky130_fd_sc_hd__fill_1
* cell instance sky130_fd_sc_hd__fill_1_814 r0 *1 0,0
Xsky130_fd_sc_hd__fill_1_814
+ vss
+ vdd
+ vdd
+ sky130_fd_sc_hd__fill_1
* cell instance sky130_fd_sc_hd__fill_1_815 r0 *1 0,0
Xsky130_fd_sc_hd__fill_1_815
+ vss
+ vdd
+ vdd
+ sky130_fd_sc_hd__fill_1
* cell instance sky130_fd_sc_hd__fill_1_816 r0 *1 0,0
Xsky130_fd_sc_hd__fill_1_816
+ vss
+ vdd
+ vdd
+ sky130_fd_sc_hd__fill_1
* cell instance sky130_fd_sc_hd__fill_1_817 r0 *1 0,0
Xsky130_fd_sc_hd__fill_1_817
+ vss
+ vdd
+ vdd
+ sky130_fd_sc_hd__fill_1
* cell instance sky130_fd_sc_hd__fill_1_818 r0 *1 0,0
Xsky130_fd_sc_hd__fill_1_818
+ vss
+ vdd
+ vdd
+ sky130_fd_sc_hd__fill_1
* cell instance sky130_fd_sc_hd__fill_1_819 r0 *1 0,0
Xsky130_fd_sc_hd__fill_1_819
+ vss
+ vdd
+ vdd
+ sky130_fd_sc_hd__fill_1
* cell instance sky130_fd_sc_hd__fill_1_820 r0 *1 0,0
Xsky130_fd_sc_hd__fill_1_820
+ vss
+ vdd
+ vdd
+ sky130_fd_sc_hd__fill_1
* cell instance sky130_fd_sc_hd__fill_1_821 r0 *1 0,0
Xsky130_fd_sc_hd__fill_1_821
+ vss
+ vdd
+ vdd
+ sky130_fd_sc_hd__fill_1
* cell instance sky130_fd_sc_hd__fill_1_822 r0 *1 0,0
Xsky130_fd_sc_hd__fill_1_822
+ vss
+ vdd
+ vdd
+ sky130_fd_sc_hd__fill_1
* cell instance sky130_fd_sc_hd__fill_1_823 r0 *1 0,0
Xsky130_fd_sc_hd__fill_1_823
+ vss
+ vdd
+ vdd
+ sky130_fd_sc_hd__fill_1
* cell instance sky130_fd_sc_hd__fill_1_824 r0 *1 0,0
Xsky130_fd_sc_hd__fill_1_824
+ vss
+ vdd
+ vdd
+ sky130_fd_sc_hd__fill_1
* cell instance sky130_fd_sc_hd__fill_1_825 r0 *1 0,0
Xsky130_fd_sc_hd__fill_1_825
+ vss
+ vdd
+ vdd
+ sky130_fd_sc_hd__fill_1
* cell instance sky130_fd_sc_hd__fill_1_826 r0 *1 0,0
Xsky130_fd_sc_hd__fill_1_826
+ vss
+ vdd
+ vdd
+ sky130_fd_sc_hd__fill_1
* cell instance sky130_fd_sc_hd__fill_1_827 r0 *1 0,0
Xsky130_fd_sc_hd__fill_1_827
+ vss
+ vdd
+ vdd
+ sky130_fd_sc_hd__fill_1
* cell instance sky130_fd_sc_hd__fill_1_828 r0 *1 0,0
Xsky130_fd_sc_hd__fill_1_828
+ vss
+ vdd
+ vdd
+ sky130_fd_sc_hd__fill_1
* cell instance sky130_fd_sc_hd__fill_1_829 r0 *1 0,0
Xsky130_fd_sc_hd__fill_1_829
+ vss
+ vdd
+ vdd
+ sky130_fd_sc_hd__fill_1
* cell instance sky130_fd_sc_hd__fill_1_830 r0 *1 0,0
Xsky130_fd_sc_hd__fill_1_830
+ vss
+ vdd
+ vdd
+ sky130_fd_sc_hd__fill_1
* cell instance sky130_fd_sc_hd__fill_1_831 r0 *1 0,0
Xsky130_fd_sc_hd__fill_1_831
+ vss
+ vdd
+ vdd
+ sky130_fd_sc_hd__fill_1
* cell instance sky130_fd_sc_hd__fill_1_832 r0 *1 0,0
Xsky130_fd_sc_hd__fill_1_832
+ vss
+ vdd
+ vdd
+ sky130_fd_sc_hd__fill_1
* cell instance sky130_fd_sc_hd__fill_1_833 r0 *1 0,0
Xsky130_fd_sc_hd__fill_1_833
+ vss
+ vdd
+ vdd
+ sky130_fd_sc_hd__fill_1
* cell instance sky130_fd_sc_hd__fill_1_834 r0 *1 0,0
Xsky130_fd_sc_hd__fill_1_834
+ vss
+ vdd
+ vdd
+ sky130_fd_sc_hd__fill_1
* cell instance sky130_fd_sc_hd__fill_1_835 r0 *1 0,0
Xsky130_fd_sc_hd__fill_1_835
+ vss
+ vdd
+ vdd
+ sky130_fd_sc_hd__fill_1
* cell instance sky130_fd_sc_hd__fill_1_836 r0 *1 0,0
Xsky130_fd_sc_hd__fill_1_836
+ vss
+ vdd
+ vdd
+ sky130_fd_sc_hd__fill_1
* cell instance sky130_fd_sc_hd__fill_1_837 r0 *1 0,0
Xsky130_fd_sc_hd__fill_1_837
+ vss
+ vdd
+ vdd
+ sky130_fd_sc_hd__fill_1
* cell instance sky130_fd_sc_hd__fill_1_838 r0 *1 0,0
Xsky130_fd_sc_hd__fill_1_838
+ vss
+ vdd
+ vdd
+ sky130_fd_sc_hd__fill_1
* cell instance sky130_fd_sc_hd__fill_1_839 r0 *1 0,0
Xsky130_fd_sc_hd__fill_1_839
+ vss
+ vdd
+ vdd
+ sky130_fd_sc_hd__fill_1
* cell instance sky130_fd_sc_hd__fill_1_840 r0 *1 0,0
Xsky130_fd_sc_hd__fill_1_840
+ vss
+ vdd
+ vdd
+ sky130_fd_sc_hd__fill_1
* cell instance sky130_fd_sc_hd__fill_1_841 r0 *1 0,0
Xsky130_fd_sc_hd__fill_1_841
+ vss
+ vdd
+ vdd
+ sky130_fd_sc_hd__fill_1
* cell instance sky130_fd_sc_hd__fill_1_842 r0 *1 0,0
Xsky130_fd_sc_hd__fill_1_842
+ vss
+ vdd
+ vdd
+ sky130_fd_sc_hd__fill_1
* cell instance sky130_fd_sc_hd__fill_1_843 r0 *1 0,0
Xsky130_fd_sc_hd__fill_1_843
+ vss
+ vdd
+ vdd
+ sky130_fd_sc_hd__fill_1
* cell instance sky130_fd_sc_hd__fill_1_844 r0 *1 0,0
Xsky130_fd_sc_hd__fill_1_844
+ vss
+ vdd
+ vdd
+ sky130_fd_sc_hd__fill_1
* cell instance sky130_fd_sc_hd__fill_1_845 r0 *1 0,0
Xsky130_fd_sc_hd__fill_1_845
+ vss
+ vdd
+ vdd
+ sky130_fd_sc_hd__fill_1
* cell instance sky130_fd_sc_hd__fill_1_846 r0 *1 0,0
Xsky130_fd_sc_hd__fill_1_846
+ vss
+ vdd
+ vdd
+ sky130_fd_sc_hd__fill_1
* cell instance sky130_fd_sc_hd__fill_1_847 r0 *1 0,0
Xsky130_fd_sc_hd__fill_1_847
+ vss
+ vdd
+ vdd
+ sky130_fd_sc_hd__fill_1
* cell instance sky130_fd_sc_hd__fill_1_848 r0 *1 0,0
Xsky130_fd_sc_hd__fill_1_848
+ vss
+ vdd
+ vdd
+ sky130_fd_sc_hd__fill_1
* cell instance sky130_fd_sc_hd__fill_1_849 r0 *1 0,0
Xsky130_fd_sc_hd__fill_1_849
+ vss
+ vdd
+ vdd
+ sky130_fd_sc_hd__fill_1
* cell instance sky130_fd_sc_hd__fill_1_850 r0 *1 0,0
Xsky130_fd_sc_hd__fill_1_850
+ vss
+ vdd
+ vdd
+ sky130_fd_sc_hd__fill_1
* cell instance sky130_fd_sc_hd__fill_1_851 r0 *1 0,0
Xsky130_fd_sc_hd__fill_1_851
+ vss
+ vdd
+ vdd
+ sky130_fd_sc_hd__fill_1
* cell instance sky130_fd_sc_hd__fill_1_852 r0 *1 0,0
Xsky130_fd_sc_hd__fill_1_852
+ vss
+ vdd
+ vdd
+ sky130_fd_sc_hd__fill_1
* cell instance sky130_fd_sc_hd__fill_1_853 r0 *1 0,0
Xsky130_fd_sc_hd__fill_1_853
+ vss
+ vdd
+ vdd
+ sky130_fd_sc_hd__fill_1
* cell instance sky130_fd_sc_hd__fill_1_854 r0 *1 0,0
Xsky130_fd_sc_hd__fill_1_854
+ vss
+ vdd
+ vdd
+ sky130_fd_sc_hd__fill_1
* cell instance sky130_fd_sc_hd__fill_1_855 r0 *1 0,0
Xsky130_fd_sc_hd__fill_1_855
+ vss
+ vdd
+ vdd
+ sky130_fd_sc_hd__fill_1
* cell instance sky130_fd_sc_hd__fill_1_856 r0 *1 0,0
Xsky130_fd_sc_hd__fill_1_856
+ vss
+ vdd
+ vdd
+ sky130_fd_sc_hd__fill_1
* cell instance sky130_fd_sc_hd__fill_1_857 r0 *1 0,0
Xsky130_fd_sc_hd__fill_1_857
+ vss
+ vdd
+ vdd
+ sky130_fd_sc_hd__fill_1
* cell instance sky130_fd_sc_hd__fill_1_858 r0 *1 0,0
Xsky130_fd_sc_hd__fill_1_858
+ vss
+ vdd
+ vdd
+ sky130_fd_sc_hd__fill_1
* cell instance sky130_fd_sc_hd__fill_1_859 r0 *1 0,0
Xsky130_fd_sc_hd__fill_1_859
+ vss
+ vdd
+ vdd
+ sky130_fd_sc_hd__fill_1
* cell instance sky130_fd_sc_hd__fill_1_860 r0 *1 0,0
Xsky130_fd_sc_hd__fill_1_860
+ vss
+ vdd
+ vdd
+ sky130_fd_sc_hd__fill_1
* cell instance sky130_fd_sc_hd__fill_1_861 r0 *1 0,0
Xsky130_fd_sc_hd__fill_1_861
+ vss
+ vdd
+ vdd
+ sky130_fd_sc_hd__fill_1
* cell instance sky130_fd_sc_hd__fill_1_862 r0 *1 0,0
Xsky130_fd_sc_hd__fill_1_862
+ vss
+ vdd
+ vdd
+ sky130_fd_sc_hd__fill_1
* cell instance sky130_fd_sc_hd__fill_1_863 r0 *1 0,0
Xsky130_fd_sc_hd__fill_1_863
+ vss
+ vdd
+ vdd
+ sky130_fd_sc_hd__fill_1
* cell instance sky130_fd_sc_hd__fill_1_864 r0 *1 0,0
Xsky130_fd_sc_hd__fill_1_864
+ vss
+ vdd
+ vdd
+ sky130_fd_sc_hd__fill_1
* cell instance sky130_fd_sc_hd__fill_1_865 r0 *1 0,0
Xsky130_fd_sc_hd__fill_1_865
+ vss
+ vdd
+ vdd
+ sky130_fd_sc_hd__fill_1
* cell instance sky130_fd_sc_hd__fill_1_866 r0 *1 0,0
Xsky130_fd_sc_hd__fill_1_866
+ vss
+ vdd
+ vdd
+ sky130_fd_sc_hd__fill_1
* cell instance sky130_fd_sc_hd__fill_1_867 r0 *1 0,0
Xsky130_fd_sc_hd__fill_1_867
+ vss
+ vdd
+ vdd
+ sky130_fd_sc_hd__fill_1
* cell instance sky130_fd_sc_hd__fill_1_868 r0 *1 0,0
Xsky130_fd_sc_hd__fill_1_868
+ vss
+ vdd
+ vdd
+ sky130_fd_sc_hd__fill_1
* cell instance sky130_fd_sc_hd__fill_1_869 r0 *1 0,0
Xsky130_fd_sc_hd__fill_1_869
+ vss
+ vdd
+ vdd
+ sky130_fd_sc_hd__fill_1
* cell instance sky130_fd_sc_hd__fill_1_870 r0 *1 0,0
Xsky130_fd_sc_hd__fill_1_870
+ vss
+ vdd
+ vdd
+ sky130_fd_sc_hd__fill_1
* cell instance sky130_fd_sc_hd__fill_1_871 r0 *1 0,0
Xsky130_fd_sc_hd__fill_1_871
+ vss
+ vdd
+ vdd
+ sky130_fd_sc_hd__fill_1
* cell instance sky130_fd_sc_hd__fill_1_872 r0 *1 0,0
Xsky130_fd_sc_hd__fill_1_872
+ vss
+ vdd
+ vdd
+ sky130_fd_sc_hd__fill_1
* cell instance sky130_fd_sc_hd__fill_1_873 r0 *1 0,0
Xsky130_fd_sc_hd__fill_1_873
+ vss
+ vdd
+ vdd
+ sky130_fd_sc_hd__fill_1
* cell instance sky130_fd_sc_hd__fill_1_874 r0 *1 0,0
Xsky130_fd_sc_hd__fill_1_874
+ vss
+ vdd
+ vdd
+ sky130_fd_sc_hd__fill_1
* cell instance sky130_fd_sc_hd__fill_1_875 r0 *1 0,0
Xsky130_fd_sc_hd__fill_1_875
+ vss
+ vdd
+ vdd
+ sky130_fd_sc_hd__fill_1
* cell instance sky130_fd_sc_hd__fill_1_876 r0 *1 0,0
Xsky130_fd_sc_hd__fill_1_876
+ vss
+ vdd
+ vdd
+ sky130_fd_sc_hd__fill_1
* cell instance sky130_fd_sc_hd__fill_1_877 r0 *1 0,0
Xsky130_fd_sc_hd__fill_1_877
+ vss
+ vdd
+ vdd
+ sky130_fd_sc_hd__fill_1
* cell instance sky130_fd_sc_hd__fill_1_878 r0 *1 0,0
Xsky130_fd_sc_hd__fill_1_878
+ vss
+ vdd
+ vdd
+ sky130_fd_sc_hd__fill_1
* cell instance sky130_fd_sc_hd__fill_1_879 r0 *1 0,0
Xsky130_fd_sc_hd__fill_1_879
+ vss
+ vdd
+ vdd
+ sky130_fd_sc_hd__fill_1
* cell instance sky130_fd_sc_hd__fill_1_880 r0 *1 0,0
Xsky130_fd_sc_hd__fill_1_880
+ vss
+ vdd
+ vdd
+ sky130_fd_sc_hd__fill_1
* cell instance sky130_fd_sc_hd__fill_1_881 r0 *1 0,0
Xsky130_fd_sc_hd__fill_1_881
+ vss
+ vdd
+ vdd
+ sky130_fd_sc_hd__fill_1
* cell instance sky130_fd_sc_hd__fill_1_882 r0 *1 0,0
Xsky130_fd_sc_hd__fill_1_882
+ vss
+ vdd
+ vdd
+ sky130_fd_sc_hd__fill_1
* cell instance sky130_fd_sc_hd__fill_1_883 r0 *1 0,0
Xsky130_fd_sc_hd__fill_1_883
+ vss
+ vdd
+ vdd
+ sky130_fd_sc_hd__fill_1
* cell instance sky130_fd_sc_hd__fill_1_884 r0 *1 0,0
Xsky130_fd_sc_hd__fill_1_884
+ vss
+ vdd
+ vdd
+ sky130_fd_sc_hd__fill_1
* cell instance sky130_fd_sc_hd__fill_1_885 r0 *1 0,0
Xsky130_fd_sc_hd__fill_1_885
+ vss
+ vdd
+ vdd
+ sky130_fd_sc_hd__fill_1
* cell instance sky130_fd_sc_hd__fill_1_886 r0 *1 0,0
Xsky130_fd_sc_hd__fill_1_886
+ vss
+ vdd
+ vdd
+ sky130_fd_sc_hd__fill_1
* cell instance sky130_fd_sc_hd__fill_1_887 r0 *1 0,0
Xsky130_fd_sc_hd__fill_1_887
+ vss
+ vdd
+ vdd
+ sky130_fd_sc_hd__fill_1
* cell instance sky130_fd_sc_hd__fill_1_888 r0 *1 0,0
Xsky130_fd_sc_hd__fill_1_888
+ vss
+ vdd
+ vdd
+ sky130_fd_sc_hd__fill_1
* cell instance sky130_fd_sc_hd__fill_1_889 r0 *1 0,0
Xsky130_fd_sc_hd__fill_1_889
+ vss
+ vdd
+ vdd
+ sky130_fd_sc_hd__fill_1
* cell instance sky130_fd_sc_hd__fill_1_890 r0 *1 0,0
Xsky130_fd_sc_hd__fill_1_890
+ vss
+ vdd
+ vdd
+ sky130_fd_sc_hd__fill_1
* cell instance sky130_fd_sc_hd__fill_1_891 r0 *1 0,0
Xsky130_fd_sc_hd__fill_1_891
+ vss
+ vdd
+ vdd
+ sky130_fd_sc_hd__fill_1
* cell instance sky130_fd_sc_hd__fill_1_892 r0 *1 0,0
Xsky130_fd_sc_hd__fill_1_892
+ vss
+ vdd
+ vdd
+ sky130_fd_sc_hd__fill_1
* cell instance sky130_fd_sc_hd__fill_1_893 r0 *1 0,0
Xsky130_fd_sc_hd__fill_1_893
+ vss
+ vdd
+ vdd
+ sky130_fd_sc_hd__fill_1
* cell instance sky130_fd_sc_hd__fill_1_894 r0 *1 0,0
Xsky130_fd_sc_hd__fill_1_894
+ vss
+ vdd
+ vdd
+ sky130_fd_sc_hd__fill_1
* cell instance sky130_fd_sc_hd__fill_1_895 r0 *1 0,0
Xsky130_fd_sc_hd__fill_1_895
+ vss
+ vdd
+ vdd
+ sky130_fd_sc_hd__fill_1
* cell instance sky130_fd_sc_hd__fill_1_896 r0 *1 0,0
Xsky130_fd_sc_hd__fill_1_896
+ vss
+ vdd
+ vdd
+ sky130_fd_sc_hd__fill_1
* cell instance sky130_fd_sc_hd__fill_1_897 r0 *1 0,0
Xsky130_fd_sc_hd__fill_1_897
+ vss
+ vdd
+ vdd
+ sky130_fd_sc_hd__fill_1
* cell instance sky130_fd_sc_hd__fill_1_898 r0 *1 0,0
Xsky130_fd_sc_hd__fill_1_898
+ vss
+ vdd
+ vdd
+ sky130_fd_sc_hd__fill_1
* cell instance sky130_fd_sc_hd__fill_1_899 r0 *1 0,0
Xsky130_fd_sc_hd__fill_1_899
+ vss
+ vdd
+ vdd
+ sky130_fd_sc_hd__fill_1
* cell instance sky130_fd_sc_hd__fill_1_900 r0 *1 0,0
Xsky130_fd_sc_hd__fill_1_900
+ vss
+ vdd
+ vdd
+ sky130_fd_sc_hd__fill_1
* cell instance sky130_fd_sc_hd__fill_1_901 r0 *1 0,0
Xsky130_fd_sc_hd__fill_1_901
+ vss
+ vdd
+ vdd
+ sky130_fd_sc_hd__fill_1
* cell instance sky130_fd_sc_hd__fill_1_902 r0 *1 0,0
Xsky130_fd_sc_hd__fill_1_902
+ vss
+ vdd
+ vdd
+ sky130_fd_sc_hd__fill_1
* cell instance sky130_fd_sc_hd__fill_1_903 r0 *1 0,0
Xsky130_fd_sc_hd__fill_1_903
+ vss
+ vdd
+ vdd
+ sky130_fd_sc_hd__fill_1
* cell instance sky130_fd_sc_hd__fill_1_904 r0 *1 0,0
Xsky130_fd_sc_hd__fill_1_904
+ vss
+ vdd
+ vdd
+ sky130_fd_sc_hd__fill_1
* cell instance sky130_fd_sc_hd__fill_1_905 r0 *1 0,0
Xsky130_fd_sc_hd__fill_1_905
+ vss
+ vdd
+ vdd
+ sky130_fd_sc_hd__fill_1
* cell instance sky130_fd_sc_hd__fill_1_906 r0 *1 0,0
Xsky130_fd_sc_hd__fill_1_906
+ vss
+ vdd
+ vdd
+ sky130_fd_sc_hd__fill_1
* cell instance sky130_fd_sc_hd__fill_1_907 r0 *1 0,0
Xsky130_fd_sc_hd__fill_1_907
+ vss
+ vdd
+ vdd
+ sky130_fd_sc_hd__fill_1
* cell instance sky130_fd_sc_hd__fill_1_908 r0 *1 0,0
Xsky130_fd_sc_hd__fill_1_908
+ vss
+ vdd
+ vdd
+ sky130_fd_sc_hd__fill_1
* cell instance sky130_fd_sc_hd__fill_1_909 r0 *1 0,0
Xsky130_fd_sc_hd__fill_1_909
+ vss
+ vdd
+ vdd
+ sky130_fd_sc_hd__fill_1
* cell instance sky130_fd_sc_hd__fill_1_910 r0 *1 0,0
Xsky130_fd_sc_hd__fill_1_910
+ vss
+ vdd
+ vdd
+ sky130_fd_sc_hd__fill_1
* cell instance sky130_fd_sc_hd__fill_1_911 r0 *1 0,0
Xsky130_fd_sc_hd__fill_1_911
+ vss
+ vdd
+ vdd
+ sky130_fd_sc_hd__fill_1
* cell instance sky130_fd_sc_hd__fill_1_912 r0 *1 0,0
Xsky130_fd_sc_hd__fill_1_912
+ vss
+ vdd
+ vdd
+ sky130_fd_sc_hd__fill_1
* cell instance sky130_fd_sc_hd__fill_1_913 r0 *1 0,0
Xsky130_fd_sc_hd__fill_1_913
+ vss
+ vdd
+ vdd
+ sky130_fd_sc_hd__fill_1
* cell instance sky130_fd_sc_hd__fill_1_914 r0 *1 0,0
Xsky130_fd_sc_hd__fill_1_914
+ vss
+ vdd
+ vdd
+ sky130_fd_sc_hd__fill_1
* cell instance sky130_fd_sc_hd__fill_1_915 r0 *1 0,0
Xsky130_fd_sc_hd__fill_1_915
+ vss
+ vdd
+ vdd
+ sky130_fd_sc_hd__fill_1
* cell instance sky130_fd_sc_hd__fill_1_916 r0 *1 0,0
Xsky130_fd_sc_hd__fill_1_916
+ vss
+ vdd
+ vdd
+ sky130_fd_sc_hd__fill_1
* cell instance sky130_fd_sc_hd__fill_1_917 r0 *1 0,0
Xsky130_fd_sc_hd__fill_1_917
+ vss
+ vdd
+ vdd
+ sky130_fd_sc_hd__fill_1
* cell instance sky130_fd_sc_hd__fill_1_918 r0 *1 0,0
Xsky130_fd_sc_hd__fill_1_918
+ vss
+ vdd
+ vdd
+ sky130_fd_sc_hd__fill_1
* cell instance sky130_fd_sc_hd__fill_1_919 r0 *1 0,0
Xsky130_fd_sc_hd__fill_1_919
+ vss
+ vdd
+ vdd
+ sky130_fd_sc_hd__fill_1
* cell instance sky130_fd_sc_hd__fill_1_920 r0 *1 0,0
Xsky130_fd_sc_hd__fill_1_920
+ vss
+ vdd
+ vdd
+ sky130_fd_sc_hd__fill_1
* cell instance sky130_fd_sc_hd__fill_1_921 r0 *1 0,0
Xsky130_fd_sc_hd__fill_1_921
+ vss
+ vdd
+ vdd
+ sky130_fd_sc_hd__fill_1
* cell instance sky130_fd_sc_hd__fill_1_922 r0 *1 0,0
Xsky130_fd_sc_hd__fill_1_922
+ vss
+ vdd
+ vdd
+ sky130_fd_sc_hd__fill_1
* cell instance sky130_fd_sc_hd__fill_1_923 r0 *1 0,0
Xsky130_fd_sc_hd__fill_1_923
+ vss
+ vdd
+ vdd
+ sky130_fd_sc_hd__fill_1
* cell instance sky130_fd_sc_hd__fill_1_924 r0 *1 0,0
Xsky130_fd_sc_hd__fill_1_924
+ vss
+ vdd
+ vdd
+ sky130_fd_sc_hd__fill_1
* cell instance sky130_fd_sc_hd__fill_1_925 r0 *1 0,0
Xsky130_fd_sc_hd__fill_1_925
+ vss
+ vdd
+ vdd
+ sky130_fd_sc_hd__fill_1
* cell instance sky130_fd_sc_hd__fill_1_926 r0 *1 0,0
Xsky130_fd_sc_hd__fill_1_926
+ vss
+ vdd
+ vdd
+ sky130_fd_sc_hd__fill_1
* cell instance sky130_fd_sc_hd__fill_1_927 r0 *1 0,0
Xsky130_fd_sc_hd__fill_1_927
+ vss
+ vdd
+ vdd
+ sky130_fd_sc_hd__fill_1
* cell instance sky130_fd_sc_hd__fill_1_928 r0 *1 0,0
Xsky130_fd_sc_hd__fill_1_928
+ vss
+ vdd
+ vdd
+ sky130_fd_sc_hd__fill_1
* cell instance sky130_fd_sc_hd__fill_1_929 r0 *1 0,0
Xsky130_fd_sc_hd__fill_1_929
+ vss
+ vdd
+ vdd
+ sky130_fd_sc_hd__fill_1
* cell instance sky130_fd_sc_hd__fill_1_930 r0 *1 0,0
Xsky130_fd_sc_hd__fill_1_930
+ vss
+ vdd
+ vdd
+ sky130_fd_sc_hd__fill_1
* cell instance sky130_fd_sc_hd__fill_1_931 r0 *1 0,0
Xsky130_fd_sc_hd__fill_1_931
+ vss
+ vdd
+ vdd
+ sky130_fd_sc_hd__fill_1
* cell instance sky130_fd_sc_hd__fill_1_932 r0 *1 0,0
Xsky130_fd_sc_hd__fill_1_932
+ vss
+ vdd
+ vdd
+ sky130_fd_sc_hd__fill_1
* cell instance sky130_fd_sc_hd__fill_1_933 r0 *1 0,0
Xsky130_fd_sc_hd__fill_1_933
+ vss
+ vdd
+ vdd
+ sky130_fd_sc_hd__fill_1
* cell instance sky130_fd_sc_hd__fill_1_934 r0 *1 0,0
Xsky130_fd_sc_hd__fill_1_934
+ vss
+ vdd
+ vdd
+ sky130_fd_sc_hd__fill_1
* cell instance sky130_fd_sc_hd__fill_1_935 r0 *1 0,0
Xsky130_fd_sc_hd__fill_1_935
+ vss
+ vdd
+ vdd
+ sky130_fd_sc_hd__fill_1
* cell instance sky130_fd_sc_hd__fill_1_936 r0 *1 0,0
Xsky130_fd_sc_hd__fill_1_936
+ vss
+ vdd
+ vdd
+ sky130_fd_sc_hd__fill_1
* cell instance sky130_fd_sc_hd__fill_1_937 r0 *1 0,0
Xsky130_fd_sc_hd__fill_1_937
+ vss
+ vdd
+ vdd
+ sky130_fd_sc_hd__fill_1
* cell instance sky130_fd_sc_hd__fill_1_938 r0 *1 0,0
Xsky130_fd_sc_hd__fill_1_938
+ vss
+ vdd
+ vdd
+ sky130_fd_sc_hd__fill_1
* cell instance sky130_fd_sc_hd__fill_1_939 r0 *1 0,0
Xsky130_fd_sc_hd__fill_1_939
+ vss
+ vdd
+ vdd
+ sky130_fd_sc_hd__fill_1
* cell instance sky130_fd_sc_hd__fill_1_940 r0 *1 0,0
Xsky130_fd_sc_hd__fill_1_940
+ vss
+ vdd
+ vdd
+ sky130_fd_sc_hd__fill_1
* cell instance sky130_fd_sc_hd__fill_1_941 r0 *1 0,0
Xsky130_fd_sc_hd__fill_1_941
+ vss
+ vdd
+ vdd
+ sky130_fd_sc_hd__fill_1
* cell instance sky130_fd_sc_hd__fill_1_942 r0 *1 0,0
Xsky130_fd_sc_hd__fill_1_942
+ vss
+ vdd
+ vdd
+ sky130_fd_sc_hd__fill_1
* cell instance sky130_fd_sc_hd__fill_1_943 r0 *1 0,0
Xsky130_fd_sc_hd__fill_1_943
+ vss
+ vdd
+ vdd
+ sky130_fd_sc_hd__fill_1
* cell instance sky130_fd_sc_hd__fill_1_944 r0 *1 0,0
Xsky130_fd_sc_hd__fill_1_944
+ vss
+ vdd
+ vdd
+ sky130_fd_sc_hd__fill_1
* cell instance sky130_fd_sc_hd__fill_1_945 r0 *1 0,0
Xsky130_fd_sc_hd__fill_1_945
+ vss
+ vdd
+ vdd
+ sky130_fd_sc_hd__fill_1
* cell instance sky130_fd_sc_hd__fill_1_946 r0 *1 0,0
Xsky130_fd_sc_hd__fill_1_946
+ vss
+ vdd
+ vdd
+ sky130_fd_sc_hd__fill_1
* cell instance sky130_fd_sc_hd__fill_1_947 r0 *1 0,0
Xsky130_fd_sc_hd__fill_1_947
+ vss
+ vdd
+ vdd
+ sky130_fd_sc_hd__fill_1
* cell instance sky130_fd_sc_hd__fill_1_948 r0 *1 0,0
Xsky130_fd_sc_hd__fill_1_948
+ vss
+ vdd
+ vdd
+ sky130_fd_sc_hd__fill_1
* cell instance sky130_fd_sc_hd__fill_1_949 r0 *1 0,0
Xsky130_fd_sc_hd__fill_1_949
+ vss
+ vdd
+ vdd
+ sky130_fd_sc_hd__fill_1
* cell instance sky130_fd_sc_hd__fill_1_950 r0 *1 0,0
Xsky130_fd_sc_hd__fill_1_950
+ vss
+ vdd
+ vdd
+ sky130_fd_sc_hd__fill_1
* cell instance sky130_fd_sc_hd__fill_1_951 r0 *1 0,0
Xsky130_fd_sc_hd__fill_1_951
+ vss
+ vdd
+ vdd
+ sky130_fd_sc_hd__fill_1
* cell instance sky130_fd_sc_hd__fill_1_952 r0 *1 0,0
Xsky130_fd_sc_hd__fill_1_952
+ vss
+ vdd
+ vdd
+ sky130_fd_sc_hd__fill_1
* cell instance sky130_fd_sc_hd__fill_1_953 r0 *1 0,0
Xsky130_fd_sc_hd__fill_1_953
+ vss
+ vdd
+ vdd
+ sky130_fd_sc_hd__fill_1
* cell instance sky130_fd_sc_hd__fill_1_954 r0 *1 0,0
Xsky130_fd_sc_hd__fill_1_954
+ vss
+ vdd
+ vdd
+ sky130_fd_sc_hd__fill_1
* cell instance sky130_fd_sc_hd__fill_1_955 r0 *1 0,0
Xsky130_fd_sc_hd__fill_1_955
+ vss
+ vdd
+ vdd
+ sky130_fd_sc_hd__fill_1
* cell instance sky130_fd_sc_hd__fill_1_956 r0 *1 0,0
Xsky130_fd_sc_hd__fill_1_956
+ vss
+ vdd
+ vdd
+ sky130_fd_sc_hd__fill_1
* cell instance sky130_fd_sc_hd__fill_1_957 r0 *1 0,0
Xsky130_fd_sc_hd__fill_1_957
+ vss
+ vdd
+ vdd
+ sky130_fd_sc_hd__fill_1
* cell instance sky130_fd_sc_hd__fill_1_958 r0 *1 0,0
Xsky130_fd_sc_hd__fill_1_958
+ vss
+ vdd
+ vdd
+ sky130_fd_sc_hd__fill_1
* cell instance sky130_fd_sc_hd__fill_1_959 r0 *1 0,0
Xsky130_fd_sc_hd__fill_1_959
+ vss
+ vdd
+ vdd
+ sky130_fd_sc_hd__fill_1
* cell instance sky130_fd_sc_hd__fill_1_960 r0 *1 0,0
Xsky130_fd_sc_hd__fill_1_960
+ vss
+ vdd
+ vdd
+ sky130_fd_sc_hd__fill_1
* cell instance sky130_fd_sc_hd__fill_1_961 r0 *1 0,0
Xsky130_fd_sc_hd__fill_1_961
+ vss
+ vdd
+ vdd
+ sky130_fd_sc_hd__fill_1
* cell instance sky130_fd_sc_hd__fill_1_962 r0 *1 0,0
Xsky130_fd_sc_hd__fill_1_962
+ vss
+ vdd
+ vdd
+ sky130_fd_sc_hd__fill_1
* cell instance sky130_fd_sc_hd__fill_1_963 r0 *1 0,0
Xsky130_fd_sc_hd__fill_1_963
+ vss
+ vdd
+ vdd
+ sky130_fd_sc_hd__fill_1
* cell instance sky130_fd_sc_hd__fill_1_964 r0 *1 0,0
Xsky130_fd_sc_hd__fill_1_964
+ vss
+ vdd
+ vdd
+ sky130_fd_sc_hd__fill_1
* cell instance sky130_fd_sc_hd__fill_1_965 r0 *1 0,0
Xsky130_fd_sc_hd__fill_1_965
+ vss
+ vdd
+ vdd
+ sky130_fd_sc_hd__fill_1
* cell instance sky130_fd_sc_hd__fill_1_966 r0 *1 0,0
Xsky130_fd_sc_hd__fill_1_966
+ vss
+ vdd
+ vdd
+ sky130_fd_sc_hd__fill_1
* cell instance sky130_fd_sc_hd__fill_1_967 r0 *1 0,0
Xsky130_fd_sc_hd__fill_1_967
+ vss
+ vdd
+ vdd
+ sky130_fd_sc_hd__fill_1
* cell instance sky130_fd_sc_hd__fill_1_968 r0 *1 0,0
Xsky130_fd_sc_hd__fill_1_968
+ vss
+ vdd
+ vdd
+ sky130_fd_sc_hd__fill_1
* cell instance sky130_fd_sc_hd__fill_1_969 r0 *1 0,0
Xsky130_fd_sc_hd__fill_1_969
+ vss
+ vdd
+ vdd
+ sky130_fd_sc_hd__fill_1
* cell instance sky130_fd_sc_hd__fill_1_970 r0 *1 0,0
Xsky130_fd_sc_hd__fill_1_970
+ vss
+ vdd
+ vdd
+ sky130_fd_sc_hd__fill_1
* cell instance sky130_fd_sc_hd__fill_1_971 r0 *1 0,0
Xsky130_fd_sc_hd__fill_1_971
+ vss
+ vdd
+ vdd
+ sky130_fd_sc_hd__fill_1
* cell instance sky130_fd_sc_hd__fill_1_972 r0 *1 0,0
Xsky130_fd_sc_hd__fill_1_972
+ vss
+ vdd
+ vdd
+ sky130_fd_sc_hd__fill_1
* cell instance sky130_fd_sc_hd__fill_1_973 r0 *1 0,0
Xsky130_fd_sc_hd__fill_1_973
+ vss
+ vdd
+ vdd
+ sky130_fd_sc_hd__fill_1
* cell instance sky130_fd_sc_hd__fill_1_974 r0 *1 0,0
Xsky130_fd_sc_hd__fill_1_974
+ vss
+ vdd
+ vdd
+ sky130_fd_sc_hd__fill_1
* cell instance sky130_fd_sc_hd__fill_1_975 r0 *1 0,0
Xsky130_fd_sc_hd__fill_1_975
+ vss
+ vdd
+ vdd
+ sky130_fd_sc_hd__fill_1
* cell instance sky130_fd_sc_hd__fill_1_976 r0 *1 0,0
Xsky130_fd_sc_hd__fill_1_976
+ vss
+ vdd
+ vdd
+ sky130_fd_sc_hd__fill_1
* cell instance sky130_fd_sc_hd__fill_1_977 r0 *1 0,0
Xsky130_fd_sc_hd__fill_1_977
+ vss
+ vdd
+ vdd
+ sky130_fd_sc_hd__fill_1
* cell instance sky130_fd_sc_hd__fill_1_978 r0 *1 0,0
Xsky130_fd_sc_hd__fill_1_978
+ vss
+ vdd
+ vdd
+ sky130_fd_sc_hd__fill_1
* cell instance sky130_fd_sc_hd__fill_1_979 r0 *1 0,0
Xsky130_fd_sc_hd__fill_1_979
+ vss
+ vdd
+ vdd
+ sky130_fd_sc_hd__fill_1
* cell instance sky130_fd_sc_hd__fill_1_980 r0 *1 0,0
Xsky130_fd_sc_hd__fill_1_980
+ vss
+ vdd
+ vdd
+ sky130_fd_sc_hd__fill_1
* cell instance sky130_fd_sc_hd__fill_1_981 r0 *1 0,0
Xsky130_fd_sc_hd__fill_1_981
+ vss
+ vdd
+ vdd
+ sky130_fd_sc_hd__fill_1
* cell instance sky130_fd_sc_hd__fill_1_982 r0 *1 0,0
Xsky130_fd_sc_hd__fill_1_982
+ vss
+ vdd
+ vdd
+ sky130_fd_sc_hd__fill_1
* cell instance sky130_fd_sc_hd__fill_1_983 r0 *1 0,0
Xsky130_fd_sc_hd__fill_1_983
+ vss
+ vdd
+ vdd
+ sky130_fd_sc_hd__fill_1
* cell instance sky130_fd_sc_hd__fill_1_984 r0 *1 0,0
Xsky130_fd_sc_hd__fill_1_984
+ vss
+ vdd
+ vdd
+ sky130_fd_sc_hd__fill_1
* cell instance sky130_fd_sc_hd__fill_1_985 r0 *1 0,0
Xsky130_fd_sc_hd__fill_1_985
+ vss
+ vdd
+ vdd
+ sky130_fd_sc_hd__fill_1
* cell instance sky130_fd_sc_hd__fill_1_986 r0 *1 0,0
Xsky130_fd_sc_hd__fill_1_986
+ vss
+ vdd
+ vdd
+ sky130_fd_sc_hd__fill_1
* cell instance sky130_fd_sc_hd__fill_1_987 r0 *1 0,0
Xsky130_fd_sc_hd__fill_1_987
+ vss
+ vdd
+ vdd
+ sky130_fd_sc_hd__fill_1
* cell instance sky130_fd_sc_hd__fill_1_988 r0 *1 0,0
Xsky130_fd_sc_hd__fill_1_988
+ vss
+ vdd
+ vdd
+ sky130_fd_sc_hd__fill_1
* cell instance sky130_fd_sc_hd__fill_1_989 r0 *1 0,0
Xsky130_fd_sc_hd__fill_1_989
+ vss
+ vdd
+ vdd
+ sky130_fd_sc_hd__fill_1
* cell instance sky130_fd_sc_hd__fill_1_990 r0 *1 0,0
Xsky130_fd_sc_hd__fill_1_990
+ vss
+ vdd
+ vdd
+ sky130_fd_sc_hd__fill_1
* cell instance sky130_fd_sc_hd__fill_1_991 r0 *1 0,0
Xsky130_fd_sc_hd__fill_1_991
+ vss
+ vdd
+ vdd
+ sky130_fd_sc_hd__fill_1
* cell instance sky130_fd_sc_hd__fill_1_992 r0 *1 0,0
Xsky130_fd_sc_hd__fill_1_992
+ vss
+ vdd
+ vdd
+ sky130_fd_sc_hd__fill_1
* cell instance sky130_fd_sc_hd__fill_1_993 r0 *1 0,0
Xsky130_fd_sc_hd__fill_1_993
+ vss
+ vdd
+ vdd
+ sky130_fd_sc_hd__fill_1
* cell instance sky130_fd_sc_hd__fill_1_994 r0 *1 0,0
Xsky130_fd_sc_hd__fill_1_994
+ vss
+ vdd
+ vdd
+ sky130_fd_sc_hd__fill_1
* cell instance sky130_fd_sc_hd__fill_1_995 r0 *1 0,0
Xsky130_fd_sc_hd__fill_1_995
+ vss
+ vdd
+ vdd
+ sky130_fd_sc_hd__fill_1
* cell instance sky130_fd_sc_hd__fill_1_996 r0 *1 0,0
Xsky130_fd_sc_hd__fill_1_996
+ vss
+ vdd
+ vdd
+ sky130_fd_sc_hd__fill_1
* cell instance sky130_fd_sc_hd__fill_1_997 r0 *1 0,0
Xsky130_fd_sc_hd__fill_1_997
+ vss
+ vdd
+ vdd
+ sky130_fd_sc_hd__fill_1
* cell instance sky130_fd_sc_hd__fill_1_998 r0 *1 0,0
Xsky130_fd_sc_hd__fill_1_998
+ vss
+ vdd
+ vdd
+ sky130_fd_sc_hd__fill_1
* cell instance sky130_fd_sc_hd__fill_1_999 r0 *1 0,0
Xsky130_fd_sc_hd__fill_1_999
+ vss
+ vdd
+ vdd
+ sky130_fd_sc_hd__fill_1
* cell instance sky130_fd_sc_hd__fill_1_1000 r0 *1 0,0
Xsky130_fd_sc_hd__fill_1_1000
+ vss
+ vdd
+ vdd
+ sky130_fd_sc_hd__fill_1
* cell instance sky130_fd_sc_hd__fill_1_1001 r0 *1 0,0
Xsky130_fd_sc_hd__fill_1_1001
+ vss
+ vdd
+ vdd
+ sky130_fd_sc_hd__fill_1
* cell instance sky130_fd_sc_hd__fill_1_1002 r0 *1 0,0
Xsky130_fd_sc_hd__fill_1_1002
+ vss
+ vdd
+ vdd
+ sky130_fd_sc_hd__fill_1
* cell instance sky130_fd_sc_hd__fill_1_1003 r0 *1 0,0
Xsky130_fd_sc_hd__fill_1_1003
+ vss
+ vdd
+ vdd
+ sky130_fd_sc_hd__fill_1
* cell instance sky130_fd_sc_hd__fill_1_1004 r0 *1 0,0
Xsky130_fd_sc_hd__fill_1_1004
+ vss
+ vdd
+ vdd
+ sky130_fd_sc_hd__fill_1
* cell instance sky130_fd_sc_hd__fill_1_1005 r0 *1 0,0
Xsky130_fd_sc_hd__fill_1_1005
+ vss
+ vdd
+ vdd
+ sky130_fd_sc_hd__fill_1
* cell instance sky130_fd_sc_hd__fill_1_1006 r0 *1 0,0
Xsky130_fd_sc_hd__fill_1_1006
+ vss
+ vdd
+ vdd
+ sky130_fd_sc_hd__fill_1
* cell instance sky130_fd_sc_hd__fill_1_1007 r0 *1 0,0
Xsky130_fd_sc_hd__fill_1_1007
+ vss
+ vdd
+ vdd
+ sky130_fd_sc_hd__fill_1
* cell instance sky130_fd_sc_hd__fill_1_1008 r0 *1 0,0
Xsky130_fd_sc_hd__fill_1_1008
+ vss
+ vdd
+ vdd
+ sky130_fd_sc_hd__fill_1
* cell instance sky130_fd_sc_hd__fill_1_1009 r0 *1 0,0
Xsky130_fd_sc_hd__fill_1_1009
+ vss
+ vdd
+ vdd
+ sky130_fd_sc_hd__fill_1
* cell instance sky130_fd_sc_hd__fill_1_1010 r0 *1 0,0
Xsky130_fd_sc_hd__fill_1_1010
+ vss
+ vdd
+ vdd
+ sky130_fd_sc_hd__fill_1
* cell instance sky130_fd_sc_hd__fill_1_1011 r0 *1 0,0
Xsky130_fd_sc_hd__fill_1_1011
+ vss
+ vdd
+ vdd
+ sky130_fd_sc_hd__fill_1
* cell instance sky130_fd_sc_hd__fill_1_1012 r0 *1 0,0
Xsky130_fd_sc_hd__fill_1_1012
+ vss
+ vdd
+ vdd
+ sky130_fd_sc_hd__fill_1
* cell instance sky130_fd_sc_hd__fill_1_1013 r0 *1 0,0
Xsky130_fd_sc_hd__fill_1_1013
+ vss
+ vdd
+ vdd
+ sky130_fd_sc_hd__fill_1
* cell instance sky130_fd_sc_hd__fill_1_1014 r0 *1 0,0
Xsky130_fd_sc_hd__fill_1_1014
+ vss
+ vdd
+ vdd
+ sky130_fd_sc_hd__fill_1
* cell instance sky130_fd_sc_hd__fill_1_1015 r0 *1 0,0
Xsky130_fd_sc_hd__fill_1_1015
+ vss
+ vdd
+ vdd
+ sky130_fd_sc_hd__fill_1
* cell instance sky130_fd_sc_hd__fill_1_1016 r0 *1 0,0
Xsky130_fd_sc_hd__fill_1_1016
+ vss
+ vdd
+ vdd
+ sky130_fd_sc_hd__fill_1
* cell instance sky130_fd_sc_hd__fill_1_1017 r0 *1 0,0
Xsky130_fd_sc_hd__fill_1_1017
+ vss
+ vdd
+ vdd
+ sky130_fd_sc_hd__fill_1
* cell instance sky130_fd_sc_hd__fill_1_1018 r0 *1 0,0
Xsky130_fd_sc_hd__fill_1_1018
+ vss
+ vdd
+ vdd
+ sky130_fd_sc_hd__fill_1
* cell instance sky130_fd_sc_hd__fill_1_1019 r0 *1 0,0
Xsky130_fd_sc_hd__fill_1_1019
+ vss
+ vdd
+ vdd
+ sky130_fd_sc_hd__fill_1
* cell instance sky130_fd_sc_hd__fill_1_1020 r0 *1 0,0
Xsky130_fd_sc_hd__fill_1_1020
+ vss
+ vdd
+ vdd
+ sky130_fd_sc_hd__fill_1
* cell instance sky130_fd_sc_hd__fill_1_1021 r0 *1 0,0
Xsky130_fd_sc_hd__fill_1_1021
+ vss
+ vdd
+ vdd
+ sky130_fd_sc_hd__fill_1
* cell instance sky130_fd_sc_hd__fill_1_1022 r0 *1 0,0
Xsky130_fd_sc_hd__fill_1_1022
+ vss
+ vdd
+ vdd
+ sky130_fd_sc_hd__fill_1
* cell instance sky130_fd_sc_hd__fill_1_1023 r0 *1 0,0
Xsky130_fd_sc_hd__fill_1_1023
+ vss
+ vdd
+ vdd
+ sky130_fd_sc_hd__fill_1
* cell instance sky130_fd_sc_hd__fill_1_1024 r0 *1 0,0
Xsky130_fd_sc_hd__fill_1_1024
+ vss
+ vdd
+ vdd
+ sky130_fd_sc_hd__fill_1
* cell instance sky130_fd_sc_hd__fill_1_1025 r0 *1 0,0
Xsky130_fd_sc_hd__fill_1_1025
+ vss
+ vdd
+ vdd
+ sky130_fd_sc_hd__fill_1
* cell instance sky130_fd_sc_hd__fill_1_1026 r0 *1 0,0
Xsky130_fd_sc_hd__fill_1_1026
+ vss
+ vdd
+ vdd
+ sky130_fd_sc_hd__fill_1
* cell instance sky130_fd_sc_hd__fill_1_1027 r0 *1 0,0
Xsky130_fd_sc_hd__fill_1_1027
+ vss
+ vdd
+ vdd
+ sky130_fd_sc_hd__fill_1
* cell instance sky130_fd_sc_hd__fill_1_1028 r0 *1 0,0
Xsky130_fd_sc_hd__fill_1_1028
+ vss
+ vdd
+ vdd
+ sky130_fd_sc_hd__fill_1
* cell instance sky130_fd_sc_hd__fill_1_1029 r0 *1 0,0
Xsky130_fd_sc_hd__fill_1_1029
+ vss
+ vdd
+ vdd
+ sky130_fd_sc_hd__fill_1
* cell instance sky130_fd_sc_hd__fill_1_1030 r0 *1 0,0
Xsky130_fd_sc_hd__fill_1_1030
+ vss
+ vdd
+ vdd
+ sky130_fd_sc_hd__fill_1
* cell instance sky130_fd_sc_hd__fill_1_1031 r0 *1 0,0
Xsky130_fd_sc_hd__fill_1_1031
+ vss
+ vdd
+ vdd
+ sky130_fd_sc_hd__fill_1
* cell instance sky130_fd_sc_hd__fill_1_1032 r0 *1 0,0
Xsky130_fd_sc_hd__fill_1_1032
+ vss
+ vdd
+ vdd
+ sky130_fd_sc_hd__fill_1
* cell instance sky130_fd_sc_hd__fill_1_1033 r0 *1 0,0
Xsky130_fd_sc_hd__fill_1_1033
+ vss
+ vdd
+ vdd
+ sky130_fd_sc_hd__fill_1
* cell instance sky130_fd_sc_hd__fill_1_1034 r0 *1 0,0
Xsky130_fd_sc_hd__fill_1_1034
+ vss
+ vdd
+ vdd
+ sky130_fd_sc_hd__fill_1
* cell instance sky130_fd_sc_hd__fill_1_1035 r0 *1 0,0
Xsky130_fd_sc_hd__fill_1_1035
+ vss
+ vdd
+ vdd
+ sky130_fd_sc_hd__fill_1
* cell instance sky130_fd_sc_hd__fill_1_1036 r0 *1 0,0
Xsky130_fd_sc_hd__fill_1_1036
+ vss
+ vdd
+ vdd
+ sky130_fd_sc_hd__fill_1
* cell instance sky130_fd_sc_hd__fill_1_1037 r0 *1 0,0
Xsky130_fd_sc_hd__fill_1_1037
+ vss
+ vdd
+ vdd
+ sky130_fd_sc_hd__fill_1
* cell instance sky130_fd_sc_hd__fill_1_1038 r0 *1 0,0
Xsky130_fd_sc_hd__fill_1_1038
+ vss
+ vdd
+ vdd
+ sky130_fd_sc_hd__fill_1
* cell instance sky130_fd_sc_hd__fill_1_1039 r0 *1 0,0
Xsky130_fd_sc_hd__fill_1_1039
+ vss
+ vdd
+ vdd
+ sky130_fd_sc_hd__fill_1
* cell instance sky130_fd_sc_hd__fill_1_1040 r0 *1 0,0
Xsky130_fd_sc_hd__fill_1_1040
+ vss
+ vdd
+ vdd
+ sky130_fd_sc_hd__fill_1
* cell instance sky130_fd_sc_hd__fill_1_1041 r0 *1 0,0
Xsky130_fd_sc_hd__fill_1_1041
+ vss
+ vdd
+ vdd
+ sky130_fd_sc_hd__fill_1
* cell instance sky130_fd_sc_hd__fill_1_1042 r0 *1 0,0
Xsky130_fd_sc_hd__fill_1_1042
+ vss
+ vdd
+ vdd
+ sky130_fd_sc_hd__fill_1
* cell instance sky130_fd_sc_hd__fill_1_1043 r0 *1 0,0
Xsky130_fd_sc_hd__fill_1_1043
+ vss
+ vdd
+ vdd
+ sky130_fd_sc_hd__fill_1
* cell instance sky130_fd_sc_hd__fill_1_1044 r0 *1 0,0
Xsky130_fd_sc_hd__fill_1_1044
+ vss
+ vdd
+ vdd
+ sky130_fd_sc_hd__fill_1
* cell instance sky130_fd_sc_hd__fill_1_1045 r0 *1 0,0
Xsky130_fd_sc_hd__fill_1_1045
+ vss
+ vdd
+ vdd
+ sky130_fd_sc_hd__fill_1
* cell instance sky130_fd_sc_hd__fill_1_1046 r0 *1 0,0
Xsky130_fd_sc_hd__fill_1_1046
+ vss
+ vdd
+ vdd
+ sky130_fd_sc_hd__fill_1
* cell instance sky130_fd_sc_hd__fill_1_1047 r0 *1 0,0
Xsky130_fd_sc_hd__fill_1_1047
+ vss
+ vdd
+ vdd
+ sky130_fd_sc_hd__fill_1
* cell instance sky130_fd_sc_hd__fill_1_1048 r0 *1 0,0
Xsky130_fd_sc_hd__fill_1_1048
+ vss
+ vdd
+ vdd
+ sky130_fd_sc_hd__fill_1
* cell instance sky130_fd_sc_hd__fill_1_1049 r0 *1 0,0
Xsky130_fd_sc_hd__fill_1_1049
+ vss
+ vdd
+ vdd
+ sky130_fd_sc_hd__fill_1
* cell instance sky130_fd_sc_hd__fill_1_1050 r0 *1 0,0
Xsky130_fd_sc_hd__fill_1_1050
+ vss
+ vdd
+ vdd
+ sky130_fd_sc_hd__fill_1
* cell instance sky130_fd_sc_hd__fill_1_1051 r0 *1 0,0
Xsky130_fd_sc_hd__fill_1_1051
+ vss
+ vdd
+ vdd
+ sky130_fd_sc_hd__fill_1
* cell instance sky130_fd_sc_hd__fill_1_1052 r0 *1 0,0
Xsky130_fd_sc_hd__fill_1_1052
+ vss
+ vdd
+ vdd
+ sky130_fd_sc_hd__fill_1
* cell instance sky130_fd_sc_hd__fill_1_1053 r0 *1 0,0
Xsky130_fd_sc_hd__fill_1_1053
+ vss
+ vdd
+ vdd
+ sky130_fd_sc_hd__fill_1
* cell instance sky130_fd_sc_hd__fill_1_1054 r0 *1 0,0
Xsky130_fd_sc_hd__fill_1_1054
+ vss
+ vdd
+ vdd
+ sky130_fd_sc_hd__fill_1
* cell instance sky130_fd_sc_hd__fill_1_1055 r0 *1 0,0
Xsky130_fd_sc_hd__fill_1_1055
+ vss
+ vdd
+ vdd
+ sky130_fd_sc_hd__fill_1
* cell instance sky130_fd_sc_hd__fill_1_1056 r0 *1 0,0
Xsky130_fd_sc_hd__fill_1_1056
+ vss
+ vdd
+ vdd
+ sky130_fd_sc_hd__fill_1
* cell instance sky130_fd_sc_hd__fill_1_1057 r0 *1 0,0
Xsky130_fd_sc_hd__fill_1_1057
+ vss
+ vdd
+ vdd
+ sky130_fd_sc_hd__fill_1
* cell instance sky130_fd_sc_hd__fill_1_1058 r0 *1 0,0
Xsky130_fd_sc_hd__fill_1_1058
+ vss
+ vdd
+ vdd
+ sky130_fd_sc_hd__fill_1
* cell instance sky130_fd_sc_hd__fill_1_1059 r0 *1 0,0
Xsky130_fd_sc_hd__fill_1_1059
+ vss
+ vdd
+ vdd
+ sky130_fd_sc_hd__fill_1
* cell instance sky130_fd_sc_hd__fill_1_1060 r0 *1 0,0
Xsky130_fd_sc_hd__fill_1_1060
+ vss
+ vdd
+ vdd
+ sky130_fd_sc_hd__fill_1
* cell instance sky130_fd_sc_hd__fill_1_1061 r0 *1 0,0
Xsky130_fd_sc_hd__fill_1_1061
+ vss
+ vdd
+ vdd
+ sky130_fd_sc_hd__fill_1
* cell instance sky130_fd_sc_hd__fill_1_1062 r0 *1 0,0
Xsky130_fd_sc_hd__fill_1_1062
+ vss
+ vdd
+ vdd
+ sky130_fd_sc_hd__fill_1
* cell instance sky130_fd_sc_hd__fill_1_1063 r0 *1 0,0
Xsky130_fd_sc_hd__fill_1_1063
+ vss
+ vdd
+ vdd
+ sky130_fd_sc_hd__fill_1
* cell instance sky130_fd_sc_hd__fill_1_1064 r0 *1 0,0
Xsky130_fd_sc_hd__fill_1_1064
+ vss
+ vdd
+ vdd
+ sky130_fd_sc_hd__fill_1
* cell instance sky130_fd_sc_hd__fill_1_1065 r0 *1 0,0
Xsky130_fd_sc_hd__fill_1_1065
+ vss
+ vdd
+ vdd
+ sky130_fd_sc_hd__fill_1
* cell instance sky130_fd_sc_hd__fill_1_1066 r0 *1 0,0
Xsky130_fd_sc_hd__fill_1_1066
+ vss
+ vdd
+ vdd
+ sky130_fd_sc_hd__fill_1
* cell instance sky130_fd_sc_hd__fill_1_1067 r0 *1 0,0
Xsky130_fd_sc_hd__fill_1_1067
+ vss
+ vdd
+ vdd
+ sky130_fd_sc_hd__fill_1
* cell instance sky130_fd_sc_hd__fill_1_1068 r0 *1 0,0
Xsky130_fd_sc_hd__fill_1_1068
+ vss
+ vdd
+ vdd
+ sky130_fd_sc_hd__fill_1
* cell instance sky130_fd_sc_hd__fill_1_1069 r0 *1 0,0
Xsky130_fd_sc_hd__fill_1_1069
+ vss
+ vdd
+ vdd
+ sky130_fd_sc_hd__fill_1
* cell instance sky130_fd_sc_hd__fill_1_1070 r0 *1 0,0
Xsky130_fd_sc_hd__fill_1_1070
+ vss
+ vdd
+ vdd
+ sky130_fd_sc_hd__fill_1
* cell instance sky130_fd_sc_hd__fill_1_1071 r0 *1 0,0
Xsky130_fd_sc_hd__fill_1_1071
+ vss
+ vdd
+ vdd
+ sky130_fd_sc_hd__fill_1
* cell instance sky130_fd_sc_hd__fill_1_1072 r0 *1 0,0
Xsky130_fd_sc_hd__fill_1_1072
+ vss
+ vdd
+ vdd
+ sky130_fd_sc_hd__fill_1
* cell instance sky130_fd_sc_hd__fill_1_1073 r0 *1 0,0
Xsky130_fd_sc_hd__fill_1_1073
+ vss
+ vdd
+ vdd
+ sky130_fd_sc_hd__fill_1
* cell instance sky130_fd_sc_hd__fill_1_1074 r0 *1 0,0
Xsky130_fd_sc_hd__fill_1_1074
+ vss
+ vdd
+ vdd
+ sky130_fd_sc_hd__fill_1
* cell instance sky130_fd_sc_hd__fill_1_1075 r0 *1 0,0
Xsky130_fd_sc_hd__fill_1_1075
+ vss
+ vdd
+ vdd
+ sky130_fd_sc_hd__fill_1
* cell instance sky130_fd_sc_hd__fill_1_1076 r0 *1 0,0
Xsky130_fd_sc_hd__fill_1_1076
+ vss
+ vdd
+ vdd
+ sky130_fd_sc_hd__fill_1
* cell instance sky130_fd_sc_hd__fill_1_1077 r0 *1 0,0
Xsky130_fd_sc_hd__fill_1_1077
+ vss
+ vdd
+ vdd
+ sky130_fd_sc_hd__fill_1
* cell instance sky130_fd_sc_hd__fill_1_1078 r0 *1 0,0
Xsky130_fd_sc_hd__fill_1_1078
+ vss
+ vdd
+ vdd
+ sky130_fd_sc_hd__fill_1
* cell instance sky130_fd_sc_hd__fill_1_1079 r0 *1 0,0
Xsky130_fd_sc_hd__fill_1_1079
+ vss
+ vdd
+ vdd
+ sky130_fd_sc_hd__fill_1
* cell instance sky130_fd_sc_hd__fill_1_1080 r0 *1 0,0
Xsky130_fd_sc_hd__fill_1_1080
+ vss
+ vdd
+ vdd
+ sky130_fd_sc_hd__fill_1
* cell instance sky130_fd_sc_hd__fill_1_1081 r0 *1 0,0
Xsky130_fd_sc_hd__fill_1_1081
+ vss
+ vdd
+ vdd
+ sky130_fd_sc_hd__fill_1
* cell instance sky130_fd_sc_hd__fill_1_1082 r0 *1 0,0
Xsky130_fd_sc_hd__fill_1_1082
+ vss
+ vdd
+ vdd
+ sky130_fd_sc_hd__fill_1
* cell instance sky130_fd_sc_hd__fill_1_1083 r0 *1 0,0
Xsky130_fd_sc_hd__fill_1_1083
+ vss
+ vdd
+ vdd
+ sky130_fd_sc_hd__fill_1
* cell instance sky130_fd_sc_hd__fill_1_1084 r0 *1 0,0
Xsky130_fd_sc_hd__fill_1_1084
+ vss
+ vdd
+ vdd
+ sky130_fd_sc_hd__fill_1
* cell instance sky130_fd_sc_hd__fill_1_1085 r0 *1 0,0
Xsky130_fd_sc_hd__fill_1_1085
+ vss
+ vdd
+ vdd
+ sky130_fd_sc_hd__fill_1
* cell instance sky130_fd_sc_hd__fill_1_1086 r0 *1 0,0
Xsky130_fd_sc_hd__fill_1_1086
+ vss
+ vdd
+ vdd
+ sky130_fd_sc_hd__fill_1
* cell instance sky130_fd_sc_hd__fill_1_1087 r0 *1 0,0
Xsky130_fd_sc_hd__fill_1_1087
+ vss
+ vdd
+ vdd
+ sky130_fd_sc_hd__fill_1
* cell instance sky130_fd_sc_hd__fill_1_1088 r0 *1 0,0
Xsky130_fd_sc_hd__fill_1_1088
+ vss
+ vdd
+ vdd
+ sky130_fd_sc_hd__fill_1
* cell instance sky130_fd_sc_hd__fill_1_1089 r0 *1 0,0
Xsky130_fd_sc_hd__fill_1_1089
+ vss
+ vdd
+ vdd
+ sky130_fd_sc_hd__fill_1
* cell instance sky130_fd_sc_hd__fill_1_1090 r0 *1 0,0
Xsky130_fd_sc_hd__fill_1_1090
+ vss
+ vdd
+ vdd
+ sky130_fd_sc_hd__fill_1
* cell instance sky130_fd_sc_hd__fill_1_1091 r0 *1 0,0
Xsky130_fd_sc_hd__fill_1_1091
+ vss
+ vdd
+ vdd
+ sky130_fd_sc_hd__fill_1
* cell instance sky130_fd_sc_hd__fill_1_1092 r0 *1 0,0
Xsky130_fd_sc_hd__fill_1_1092
+ vss
+ vdd
+ vdd
+ sky130_fd_sc_hd__fill_1
* cell instance sky130_fd_sc_hd__fill_1_1093 r0 *1 0,0
Xsky130_fd_sc_hd__fill_1_1093
+ vss
+ vdd
+ vdd
+ sky130_fd_sc_hd__fill_1
* cell instance sky130_fd_sc_hd__fill_1_1094 r0 *1 0,0
Xsky130_fd_sc_hd__fill_1_1094
+ vss
+ vdd
+ vdd
+ sky130_fd_sc_hd__fill_1
* cell instance sky130_fd_sc_hd__fill_1_1095 r0 *1 0,0
Xsky130_fd_sc_hd__fill_1_1095
+ vss
+ vdd
+ vdd
+ sky130_fd_sc_hd__fill_1
* cell instance sky130_fd_sc_hd__fill_1_1096 r0 *1 0,0
Xsky130_fd_sc_hd__fill_1_1096
+ vss
+ vdd
+ vdd
+ sky130_fd_sc_hd__fill_1
* cell instance sky130_fd_sc_hd__fill_1_1097 r0 *1 0,0
Xsky130_fd_sc_hd__fill_1_1097
+ vss
+ vdd
+ vdd
+ sky130_fd_sc_hd__fill_1
* cell instance sky130_fd_sc_hd__fill_1_1098 r0 *1 0,0
Xsky130_fd_sc_hd__fill_1_1098
+ vss
+ vdd
+ vdd
+ sky130_fd_sc_hd__fill_1
* cell instance sky130_fd_sc_hd__fill_1_1099 r0 *1 0,0
Xsky130_fd_sc_hd__fill_1_1099
+ vss
+ vdd
+ vdd
+ sky130_fd_sc_hd__fill_1
* cell instance sky130_fd_sc_hd__fill_1_1100 r0 *1 0,0
Xsky130_fd_sc_hd__fill_1_1100
+ vss
+ vdd
+ vdd
+ sky130_fd_sc_hd__fill_1
* cell instance sky130_fd_sc_hd__fill_1_1101 r0 *1 0,0
Xsky130_fd_sc_hd__fill_1_1101
+ vss
+ vdd
+ vdd
+ sky130_fd_sc_hd__fill_1
* cell instance sky130_fd_sc_hd__fill_1_1102 r0 *1 0,0
Xsky130_fd_sc_hd__fill_1_1102
+ vss
+ vdd
+ vdd
+ sky130_fd_sc_hd__fill_1
* cell instance sky130_fd_sc_hd__fill_1_1103 r0 *1 0,0
Xsky130_fd_sc_hd__fill_1_1103
+ vss
+ vdd
+ vdd
+ sky130_fd_sc_hd__fill_1
* cell instance sky130_fd_sc_hd__fill_1_1104 r0 *1 0,0
Xsky130_fd_sc_hd__fill_1_1104
+ vss
+ vdd
+ vdd
+ sky130_fd_sc_hd__fill_1
* cell instance sky130_fd_sc_hd__fill_1_1105 r0 *1 0,0
Xsky130_fd_sc_hd__fill_1_1105
+ vss
+ vdd
+ vdd
+ sky130_fd_sc_hd__fill_1
* cell instance sky130_fd_sc_hd__fill_1_1106 r0 *1 0,0
Xsky130_fd_sc_hd__fill_1_1106
+ vss
+ vdd
+ vdd
+ sky130_fd_sc_hd__fill_1
* cell instance sky130_fd_sc_hd__fill_1_1107 r0 *1 0,0
Xsky130_fd_sc_hd__fill_1_1107
+ vss
+ vdd
+ vdd
+ sky130_fd_sc_hd__fill_1
* cell instance sky130_fd_sc_hd__fill_1_1108 r0 *1 0,0
Xsky130_fd_sc_hd__fill_1_1108
+ vss
+ vdd
+ vdd
+ sky130_fd_sc_hd__fill_1
* cell instance sky130_fd_sc_hd__fill_1_1109 r0 *1 0,0
Xsky130_fd_sc_hd__fill_1_1109
+ vss
+ vdd
+ vdd
+ sky130_fd_sc_hd__fill_1
* cell instance sky130_fd_sc_hd__fill_1_1110 r0 *1 0,0
Xsky130_fd_sc_hd__fill_1_1110
+ vss
+ vdd
+ vdd
+ sky130_fd_sc_hd__fill_1
* cell instance sky130_fd_sc_hd__fill_1_1111 r0 *1 0,0
Xsky130_fd_sc_hd__fill_1_1111
+ vss
+ vdd
+ vdd
+ sky130_fd_sc_hd__fill_1
* cell instance sky130_fd_sc_hd__fill_1_1112 r0 *1 0,0
Xsky130_fd_sc_hd__fill_1_1112
+ vss
+ vdd
+ vdd
+ sky130_fd_sc_hd__fill_1
* cell instance sky130_fd_sc_hd__fill_1_1113 r0 *1 0,0
Xsky130_fd_sc_hd__fill_1_1113
+ vss
+ vdd
+ vdd
+ sky130_fd_sc_hd__fill_1
* cell instance sky130_fd_sc_hd__fill_1_1114 r0 *1 0,0
Xsky130_fd_sc_hd__fill_1_1114
+ vss
+ vdd
+ vdd
+ sky130_fd_sc_hd__fill_1
* cell instance sky130_fd_sc_hd__fill_1_1115 r0 *1 0,0
Xsky130_fd_sc_hd__fill_1_1115
+ vss
+ vdd
+ vdd
+ sky130_fd_sc_hd__fill_1
* cell instance sky130_fd_sc_hd__fill_1_1116 r0 *1 0,0
Xsky130_fd_sc_hd__fill_1_1116
+ vss
+ vdd
+ vdd
+ sky130_fd_sc_hd__fill_1
* cell instance sky130_fd_sc_hd__fill_1_1117 r0 *1 0,0
Xsky130_fd_sc_hd__fill_1_1117
+ vss
+ vdd
+ vdd
+ sky130_fd_sc_hd__fill_1
* cell instance sky130_fd_sc_hd__fill_1_1118 r0 *1 0,0
Xsky130_fd_sc_hd__fill_1_1118
+ vss
+ vdd
+ vdd
+ sky130_fd_sc_hd__fill_1
* cell instance sky130_fd_sc_hd__fill_1_1119 r0 *1 0,0
Xsky130_fd_sc_hd__fill_1_1119
+ vss
+ vdd
+ vdd
+ sky130_fd_sc_hd__fill_1
* cell instance sky130_fd_sc_hd__fill_1_1120 r0 *1 0,0
Xsky130_fd_sc_hd__fill_1_1120
+ vss
+ vdd
+ vdd
+ sky130_fd_sc_hd__fill_1
* cell instance sky130_fd_sc_hd__fill_1_1121 r0 *1 0,0
Xsky130_fd_sc_hd__fill_1_1121
+ vss
+ vdd
+ vdd
+ sky130_fd_sc_hd__fill_1
* cell instance sky130_fd_sc_hd__fill_1_1122 r0 *1 0,0
Xsky130_fd_sc_hd__fill_1_1122
+ vss
+ vdd
+ vdd
+ sky130_fd_sc_hd__fill_1
* cell instance sky130_fd_sc_hd__fill_1_1123 r0 *1 0,0
Xsky130_fd_sc_hd__fill_1_1123
+ vss
+ vdd
+ vdd
+ sky130_fd_sc_hd__fill_1
* cell instance sky130_fd_sc_hd__fill_1_1124 r0 *1 0,0
Xsky130_fd_sc_hd__fill_1_1124
+ vss
+ vdd
+ vdd
+ sky130_fd_sc_hd__fill_1
* cell instance sky130_fd_sc_hd__fill_1_1125 r0 *1 0,0
Xsky130_fd_sc_hd__fill_1_1125
+ vss
+ vdd
+ vdd
+ sky130_fd_sc_hd__fill_1
* cell instance sky130_fd_sc_hd__fill_1_1126 r0 *1 0,0
Xsky130_fd_sc_hd__fill_1_1126
+ vss
+ vdd
+ vdd
+ sky130_fd_sc_hd__fill_1
* cell instance sky130_fd_sc_hd__fill_1_1127 r0 *1 0,0
Xsky130_fd_sc_hd__fill_1_1127
+ vss
+ vdd
+ vdd
+ sky130_fd_sc_hd__fill_1
* cell instance sky130_fd_sc_hd__fill_1_1128 r0 *1 0,0
Xsky130_fd_sc_hd__fill_1_1128
+ vss
+ vdd
+ vdd
+ sky130_fd_sc_hd__fill_1
* cell instance sky130_fd_sc_hd__fill_1_1129 r0 *1 0,0
Xsky130_fd_sc_hd__fill_1_1129
+ vss
+ vdd
+ vdd
+ sky130_fd_sc_hd__fill_1
* cell instance sky130_fd_sc_hd__fill_1_1130 r0 *1 0,0
Xsky130_fd_sc_hd__fill_1_1130
+ vss
+ vdd
+ vdd
+ sky130_fd_sc_hd__fill_1
* cell instance sky130_fd_sc_hd__fill_1_1131 r0 *1 0,0
Xsky130_fd_sc_hd__fill_1_1131
+ vss
+ vdd
+ vdd
+ sky130_fd_sc_hd__fill_1
* cell instance sky130_fd_sc_hd__fill_1_1132 r0 *1 0,0
Xsky130_fd_sc_hd__fill_1_1132
+ vss
+ vdd
+ vdd
+ sky130_fd_sc_hd__fill_1
* cell instance sky130_fd_sc_hd__fill_1_1133 r0 *1 0,0
Xsky130_fd_sc_hd__fill_1_1133
+ vss
+ vdd
+ vdd
+ sky130_fd_sc_hd__fill_1
* cell instance sky130_fd_sc_hd__fill_1_1134 r0 *1 0,0
Xsky130_fd_sc_hd__fill_1_1134
+ vss
+ vdd
+ vdd
+ sky130_fd_sc_hd__fill_1
* cell instance sky130_fd_sc_hd__fill_1_1135 r0 *1 0,0
Xsky130_fd_sc_hd__fill_1_1135
+ vss
+ vdd
+ vdd
+ sky130_fd_sc_hd__fill_1
* cell instance sky130_fd_sc_hd__fill_1_1136 r0 *1 0,0
Xsky130_fd_sc_hd__fill_1_1136
+ vss
+ vdd
+ vdd
+ sky130_fd_sc_hd__fill_1
* cell instance sky130_fd_sc_hd__fill_1_1137 r0 *1 0,0
Xsky130_fd_sc_hd__fill_1_1137
+ vss
+ vdd
+ vdd
+ sky130_fd_sc_hd__fill_1
* cell instance sky130_fd_sc_hd__fill_1_1138 r0 *1 0,0
Xsky130_fd_sc_hd__fill_1_1138
+ vss
+ vdd
+ vdd
+ sky130_fd_sc_hd__fill_1
* cell instance sky130_fd_sc_hd__fill_1_1139 r0 *1 0,0
Xsky130_fd_sc_hd__fill_1_1139
+ vss
+ vdd
+ vdd
+ sky130_fd_sc_hd__fill_1
* cell instance sky130_fd_sc_hd__fill_1_1140 r0 *1 0,0
Xsky130_fd_sc_hd__fill_1_1140
+ vss
+ vdd
+ vdd
+ sky130_fd_sc_hd__fill_1
* cell instance sky130_fd_sc_hd__fill_1_1141 r0 *1 0,0
Xsky130_fd_sc_hd__fill_1_1141
+ vss
+ vdd
+ vdd
+ sky130_fd_sc_hd__fill_1
* cell instance sky130_fd_sc_hd__fill_1_1142 r0 *1 0,0
Xsky130_fd_sc_hd__fill_1_1142
+ vss
+ vdd
+ vdd
+ sky130_fd_sc_hd__fill_1
* cell instance sky130_fd_sc_hd__fill_1_1143 r0 *1 0,0
Xsky130_fd_sc_hd__fill_1_1143
+ vss
+ vdd
+ vdd
+ sky130_fd_sc_hd__fill_1
* cell instance sky130_fd_sc_hd__fill_1_1144 r0 *1 0,0
Xsky130_fd_sc_hd__fill_1_1144
+ vss
+ vdd
+ vdd
+ sky130_fd_sc_hd__fill_1
* cell instance sky130_fd_sc_hd__fill_1_1145 r0 *1 0,0
Xsky130_fd_sc_hd__fill_1_1145
+ vss
+ vdd
+ vdd
+ sky130_fd_sc_hd__fill_1
* cell instance sky130_fd_sc_hd__fill_1_1146 r0 *1 0,0
Xsky130_fd_sc_hd__fill_1_1146
+ vss
+ vdd
+ vdd
+ sky130_fd_sc_hd__fill_1
* cell instance sky130_fd_sc_hd__fill_1_1147 r0 *1 0,0
Xsky130_fd_sc_hd__fill_1_1147
+ vss
+ vdd
+ vdd
+ sky130_fd_sc_hd__fill_1
* cell instance sky130_fd_sc_hd__fill_1_1148 r0 *1 0,0
Xsky130_fd_sc_hd__fill_1_1148
+ vss
+ vdd
+ vdd
+ sky130_fd_sc_hd__fill_1
* cell instance sky130_fd_sc_hd__fill_1_1149 r0 *1 0,0
Xsky130_fd_sc_hd__fill_1_1149
+ vss
+ vdd
+ vdd
+ sky130_fd_sc_hd__fill_1
* cell instance sky130_fd_sc_hd__fill_1_1150 r0 *1 0,0
Xsky130_fd_sc_hd__fill_1_1150
+ vss
+ vdd
+ vdd
+ sky130_fd_sc_hd__fill_1
* cell instance sky130_fd_sc_hd__fill_1_1151 r0 *1 0,0
Xsky130_fd_sc_hd__fill_1_1151
+ vss
+ vdd
+ vdd
+ sky130_fd_sc_hd__fill_1
* cell instance sky130_fd_sc_hd__fill_1_1152 r0 *1 0,0
Xsky130_fd_sc_hd__fill_1_1152
+ vss
+ vdd
+ vdd
+ sky130_fd_sc_hd__fill_1
* cell instance sky130_fd_sc_hd__fill_1_1153 r0 *1 0,0
Xsky130_fd_sc_hd__fill_1_1153
+ vss
+ vdd
+ vdd
+ sky130_fd_sc_hd__fill_1
* cell instance sky130_fd_sc_hd__fill_1_1154 r0 *1 0,0
Xsky130_fd_sc_hd__fill_1_1154
+ vss
+ vdd
+ vdd
+ sky130_fd_sc_hd__fill_1
* cell instance sky130_fd_sc_hd__fill_1_1155 r0 *1 0,0
Xsky130_fd_sc_hd__fill_1_1155
+ vss
+ vdd
+ vdd
+ sky130_fd_sc_hd__fill_1
* cell instance sky130_fd_sc_hd__fill_1_1156 r0 *1 0,0
Xsky130_fd_sc_hd__fill_1_1156
+ vss
+ vdd
+ vdd
+ sky130_fd_sc_hd__fill_1
* cell instance sky130_fd_sc_hd__fill_1_1157 r0 *1 0,0
Xsky130_fd_sc_hd__fill_1_1157
+ vss
+ vdd
+ vdd
+ sky130_fd_sc_hd__fill_1
* cell instance sky130_fd_sc_hd__fill_1_1158 r0 *1 0,0
Xsky130_fd_sc_hd__fill_1_1158
+ vss
+ vdd
+ vdd
+ sky130_fd_sc_hd__fill_1
* cell instance sky130_fd_sc_hd__fill_1_1159 r0 *1 0,0
Xsky130_fd_sc_hd__fill_1_1159
+ vss
+ vdd
+ vdd
+ sky130_fd_sc_hd__fill_1
* cell instance sky130_fd_sc_hd__fill_1_1160 r0 *1 0,0
Xsky130_fd_sc_hd__fill_1_1160
+ vss
+ vdd
+ vdd
+ sky130_fd_sc_hd__fill_1
* cell instance sky130_fd_sc_hd__fill_1_1161 r0 *1 0,0
Xsky130_fd_sc_hd__fill_1_1161
+ vss
+ vdd
+ vdd
+ sky130_fd_sc_hd__fill_1
* cell instance sky130_fd_sc_hd__fill_1_1162 r0 *1 0,0
Xsky130_fd_sc_hd__fill_1_1162
+ vss
+ vdd
+ vdd
+ sky130_fd_sc_hd__fill_1
* cell instance sky130_fd_sc_hd__fill_1_1163 r0 *1 0,0
Xsky130_fd_sc_hd__fill_1_1163
+ vss
+ vdd
+ vdd
+ sky130_fd_sc_hd__fill_1
* cell instance sky130_fd_sc_hd__fill_1_1164 r0 *1 0,0
Xsky130_fd_sc_hd__fill_1_1164
+ vss
+ vdd
+ vdd
+ sky130_fd_sc_hd__fill_1
* cell instance sky130_fd_sc_hd__fill_1_1165 r0 *1 0,0
Xsky130_fd_sc_hd__fill_1_1165
+ vss
+ vdd
+ vdd
+ sky130_fd_sc_hd__fill_1
* cell instance sky130_fd_sc_hd__fill_1_1166 r0 *1 0,0
Xsky130_fd_sc_hd__fill_1_1166
+ vss
+ vdd
+ vdd
+ sky130_fd_sc_hd__fill_1
* cell instance sky130_fd_sc_hd__fill_1_1167 r0 *1 0,0
Xsky130_fd_sc_hd__fill_1_1167
+ vss
+ vdd
+ vdd
+ sky130_fd_sc_hd__fill_1
* cell instance sky130_fd_sc_hd__fill_1_1168 r0 *1 0,0
Xsky130_fd_sc_hd__fill_1_1168
+ vss
+ vdd
+ vdd
+ sky130_fd_sc_hd__fill_1
* cell instance sky130_fd_sc_hd__fill_1_1169 r0 *1 0,0
Xsky130_fd_sc_hd__fill_1_1169
+ vss
+ vdd
+ vdd
+ sky130_fd_sc_hd__fill_1
* cell instance sky130_fd_sc_hd__fill_1_1170 r0 *1 0,0
Xsky130_fd_sc_hd__fill_1_1170
+ vss
+ vdd
+ vdd
+ sky130_fd_sc_hd__fill_1
* cell instance sky130_fd_sc_hd__fill_1_1171 r0 *1 0,0
Xsky130_fd_sc_hd__fill_1_1171
+ vss
+ vdd
+ vdd
+ sky130_fd_sc_hd__fill_1
* cell instance sky130_fd_sc_hd__fill_1_1172 r0 *1 0,0
Xsky130_fd_sc_hd__fill_1_1172
+ vss
+ vdd
+ vdd
+ sky130_fd_sc_hd__fill_1
* cell instance sky130_fd_sc_hd__fill_1_1173 r0 *1 0,0
Xsky130_fd_sc_hd__fill_1_1173
+ vss
+ vdd
+ vdd
+ sky130_fd_sc_hd__fill_1
* cell instance sky130_fd_sc_hd__fill_1_1174 r0 *1 0,0
Xsky130_fd_sc_hd__fill_1_1174
+ vss
+ vdd
+ vdd
+ sky130_fd_sc_hd__fill_1
* cell instance sky130_fd_sc_hd__fill_1_1175 r0 *1 0,0
Xsky130_fd_sc_hd__fill_1_1175
+ vss
+ vdd
+ vdd
+ sky130_fd_sc_hd__fill_1
* cell instance sky130_fd_sc_hd__fill_1_1176 r0 *1 0,0
Xsky130_fd_sc_hd__fill_1_1176
+ vss
+ vdd
+ vdd
+ sky130_fd_sc_hd__fill_1
* cell instance sky130_fd_sc_hd__fill_1_1177 r0 *1 0,0
Xsky130_fd_sc_hd__fill_1_1177
+ vss
+ vdd
+ vdd
+ sky130_fd_sc_hd__fill_1
* cell instance sky130_fd_sc_hd__fill_1_1178 r0 *1 0,0
Xsky130_fd_sc_hd__fill_1_1178
+ vss
+ vdd
+ vdd
+ sky130_fd_sc_hd__fill_1
* cell instance sky130_fd_sc_hd__fill_1_1179 r0 *1 0,0
Xsky130_fd_sc_hd__fill_1_1179
+ vss
+ vdd
+ vdd
+ sky130_fd_sc_hd__fill_1
* cell instance sky130_fd_sc_hd__fill_1_1180 r0 *1 0,0
Xsky130_fd_sc_hd__fill_1_1180
+ vss
+ vdd
+ vdd
+ sky130_fd_sc_hd__fill_1
* cell instance sky130_fd_sc_hd__fill_1_1181 r0 *1 0,0
Xsky130_fd_sc_hd__fill_1_1181
+ vss
+ vdd
+ vdd
+ sky130_fd_sc_hd__fill_1
* cell instance sky130_fd_sc_hd__fill_1_1182 r0 *1 0,0
Xsky130_fd_sc_hd__fill_1_1182
+ vss
+ vdd
+ vdd
+ sky130_fd_sc_hd__fill_1
* cell instance sky130_fd_sc_hd__fill_1_1183 r0 *1 0,0
Xsky130_fd_sc_hd__fill_1_1183
+ vss
+ vdd
+ vdd
+ sky130_fd_sc_hd__fill_1
* cell instance sky130_fd_sc_hd__fill_1_1184 r0 *1 0,0
Xsky130_fd_sc_hd__fill_1_1184
+ vss
+ vdd
+ vdd
+ sky130_fd_sc_hd__fill_1
* cell instance sky130_fd_sc_hd__fill_1_1185 r0 *1 0,0
Xsky130_fd_sc_hd__fill_1_1185
+ vss
+ vdd
+ vdd
+ sky130_fd_sc_hd__fill_1
* cell instance sky130_fd_sc_hd__fill_1_1186 r0 *1 0,0
Xsky130_fd_sc_hd__fill_1_1186
+ vss
+ vdd
+ vdd
+ sky130_fd_sc_hd__fill_1
* cell instance sky130_fd_sc_hd__fill_1_1187 r0 *1 0,0
Xsky130_fd_sc_hd__fill_1_1187
+ vss
+ vdd
+ vdd
+ sky130_fd_sc_hd__fill_1
* cell instance sky130_fd_sc_hd__fill_1_1188 r0 *1 0,0
Xsky130_fd_sc_hd__fill_1_1188
+ vss
+ vdd
+ vdd
+ sky130_fd_sc_hd__fill_1
* cell instance sky130_fd_sc_hd__fill_1_1189 r0 *1 0,0
Xsky130_fd_sc_hd__fill_1_1189
+ vss
+ vdd
+ vdd
+ sky130_fd_sc_hd__fill_1
* cell instance sky130_fd_sc_hd__fill_1_1190 r0 *1 0,0
Xsky130_fd_sc_hd__fill_1_1190
+ vss
+ vdd
+ vdd
+ sky130_fd_sc_hd__fill_1
* cell instance sky130_fd_sc_hd__fill_1_1191 r0 *1 0,0
Xsky130_fd_sc_hd__fill_1_1191
+ vss
+ vdd
+ vdd
+ sky130_fd_sc_hd__fill_1
* cell instance sky130_fd_sc_hd__fill_1_1192 r0 *1 0,0
Xsky130_fd_sc_hd__fill_1_1192
+ vss
+ vdd
+ vdd
+ sky130_fd_sc_hd__fill_1
* cell instance sky130_fd_sc_hd__fill_1_1193 r0 *1 0,0
Xsky130_fd_sc_hd__fill_1_1193
+ vss
+ vdd
+ vdd
+ sky130_fd_sc_hd__fill_1
* cell instance sky130_fd_sc_hd__fill_1_1194 r0 *1 0,0
Xsky130_fd_sc_hd__fill_1_1194
+ vss
+ vdd
+ vdd
+ sky130_fd_sc_hd__fill_1
* cell instance sky130_fd_sc_hd__fill_1_1195 r0 *1 0,0
Xsky130_fd_sc_hd__fill_1_1195
+ vss
+ vdd
+ vdd
+ sky130_fd_sc_hd__fill_1
* cell instance sky130_fd_sc_hd__fill_1_1196 r0 *1 0,0
Xsky130_fd_sc_hd__fill_1_1196
+ vss
+ vdd
+ vdd
+ sky130_fd_sc_hd__fill_1
* cell instance sky130_fd_sc_hd__fill_1_1197 r0 *1 0,0
Xsky130_fd_sc_hd__fill_1_1197
+ vss
+ vdd
+ vdd
+ sky130_fd_sc_hd__fill_1
* cell instance sky130_fd_sc_hd__fill_1_1198 r0 *1 0,0
Xsky130_fd_sc_hd__fill_1_1198
+ vss
+ vdd
+ vdd
+ sky130_fd_sc_hd__fill_1
* cell instance sky130_fd_sc_hd__fill_1_1199 r0 *1 0,0
Xsky130_fd_sc_hd__fill_1_1199
+ vss
+ vdd
+ vdd
+ sky130_fd_sc_hd__fill_1
* cell instance sky130_fd_sc_hd__fill_1_1200 r0 *1 0,0
Xsky130_fd_sc_hd__fill_1_1200
+ vss
+ vdd
+ vdd
+ sky130_fd_sc_hd__fill_1
* cell instance sky130_fd_sc_hd__fill_1_1201 r0 *1 0,0
Xsky130_fd_sc_hd__fill_1_1201
+ vss
+ vdd
+ vdd
+ sky130_fd_sc_hd__fill_1
* cell instance sky130_fd_sc_hd__fill_1_1202 r0 *1 0,0
Xsky130_fd_sc_hd__fill_1_1202
+ vss
+ vdd
+ vdd
+ sky130_fd_sc_hd__fill_1
* cell instance sky130_fd_sc_hd__fill_1_1203 r0 *1 0,0
Xsky130_fd_sc_hd__fill_1_1203
+ vss
+ vdd
+ vdd
+ sky130_fd_sc_hd__fill_1
* cell instance sky130_fd_sc_hd__fill_1_1204 r0 *1 0,0
Xsky130_fd_sc_hd__fill_1_1204
+ vss
+ vdd
+ vdd
+ sky130_fd_sc_hd__fill_1
* cell instance sky130_fd_sc_hd__fill_1_1205 r0 *1 0,0
Xsky130_fd_sc_hd__fill_1_1205
+ vss
+ vdd
+ vdd
+ sky130_fd_sc_hd__fill_1
* cell instance sky130_fd_sc_hd__fill_1_1206 r0 *1 0,0
Xsky130_fd_sc_hd__fill_1_1206
+ vss
+ vdd
+ vdd
+ sky130_fd_sc_hd__fill_1
* cell instance sky130_fd_sc_hd__fill_1_1207 r0 *1 0,0
Xsky130_fd_sc_hd__fill_1_1207
+ vss
+ vdd
+ vdd
+ sky130_fd_sc_hd__fill_1
* cell instance sky130_fd_sc_hd__fill_1_1208 r0 *1 0,0
Xsky130_fd_sc_hd__fill_1_1208
+ vss
+ vdd
+ vdd
+ sky130_fd_sc_hd__fill_1
* cell instance sky130_fd_sc_hd__fill_1_1209 r0 *1 0,0
Xsky130_fd_sc_hd__fill_1_1209
+ vss
+ vdd
+ vdd
+ sky130_fd_sc_hd__fill_1
* cell instance sky130_fd_sc_hd__fill_1_1210 r0 *1 0,0
Xsky130_fd_sc_hd__fill_1_1210
+ vss
+ vdd
+ vdd
+ sky130_fd_sc_hd__fill_1
* cell instance sky130_fd_sc_hd__fill_1_1211 r0 *1 0,0
Xsky130_fd_sc_hd__fill_1_1211
+ vss
+ vdd
+ vdd
+ sky130_fd_sc_hd__fill_1
* cell instance sky130_fd_sc_hd__fill_1_1212 r0 *1 0,0
Xsky130_fd_sc_hd__fill_1_1212
+ vss
+ vdd
+ vdd
+ sky130_fd_sc_hd__fill_1
* cell instance sky130_fd_sc_hd__fill_1_1213 r0 *1 0,0
Xsky130_fd_sc_hd__fill_1_1213
+ vss
+ vdd
+ vdd
+ sky130_fd_sc_hd__fill_1
* cell instance sky130_fd_sc_hd__fill_1_1214 r0 *1 0,0
Xsky130_fd_sc_hd__fill_1_1214
+ vss
+ vdd
+ vdd
+ sky130_fd_sc_hd__fill_1
* cell instance sky130_fd_sc_hd__fill_1_1215 r0 *1 0,0
Xsky130_fd_sc_hd__fill_1_1215
+ vss
+ vdd
+ vdd
+ sky130_fd_sc_hd__fill_1
* cell instance sky130_fd_sc_hd__fill_1_1216 r0 *1 0,0
Xsky130_fd_sc_hd__fill_1_1216
+ vss
+ vdd
+ vdd
+ sky130_fd_sc_hd__fill_1
* cell instance sky130_fd_sc_hd__fill_1_1217 r0 *1 0,0
Xsky130_fd_sc_hd__fill_1_1217
+ vss
+ vdd
+ vdd
+ sky130_fd_sc_hd__fill_1
* cell instance sky130_fd_sc_hd__fill_1_1218 r0 *1 0,0
Xsky130_fd_sc_hd__fill_1_1218
+ vss
+ vdd
+ vdd
+ sky130_fd_sc_hd__fill_1
* cell instance sky130_fd_sc_hd__fill_1_1219 r0 *1 0,0
Xsky130_fd_sc_hd__fill_1_1219
+ vss
+ vdd
+ vdd
+ sky130_fd_sc_hd__fill_1
* cell instance sky130_fd_sc_hd__fill_1_1220 r0 *1 0,0
Xsky130_fd_sc_hd__fill_1_1220
+ vss
+ vdd
+ vdd
+ sky130_fd_sc_hd__fill_1
* cell instance sky130_fd_sc_hd__fill_1_1221 r0 *1 0,0
Xsky130_fd_sc_hd__fill_1_1221
+ vss
+ vdd
+ vdd
+ sky130_fd_sc_hd__fill_1
* cell instance sky130_fd_sc_hd__fill_1_1222 r0 *1 0,0
Xsky130_fd_sc_hd__fill_1_1222
+ vss
+ vdd
+ vdd
+ sky130_fd_sc_hd__fill_1
* cell instance sky130_fd_sc_hd__fill_1_1223 r0 *1 0,0
Xsky130_fd_sc_hd__fill_1_1223
+ vss
+ vdd
+ vdd
+ sky130_fd_sc_hd__fill_1
* cell instance sky130_fd_sc_hd__fill_1_1224 r0 *1 0,0
Xsky130_fd_sc_hd__fill_1_1224
+ vss
+ vdd
+ vdd
+ sky130_fd_sc_hd__fill_1
* cell instance sky130_fd_sc_hd__fill_1_1225 r0 *1 0,0
Xsky130_fd_sc_hd__fill_1_1225
+ vss
+ vdd
+ vdd
+ sky130_fd_sc_hd__fill_1
* cell instance sky130_fd_sc_hd__fill_1_1226 r0 *1 0,0
Xsky130_fd_sc_hd__fill_1_1226
+ vss
+ vdd
+ vdd
+ sky130_fd_sc_hd__fill_1
* cell instance sky130_fd_sc_hd__fill_1_1227 r0 *1 0,0
Xsky130_fd_sc_hd__fill_1_1227
+ vss
+ vdd
+ vdd
+ sky130_fd_sc_hd__fill_1
* cell instance sky130_fd_sc_hd__fill_1_1228 r0 *1 0,0
Xsky130_fd_sc_hd__fill_1_1228
+ vss
+ vdd
+ vdd
+ sky130_fd_sc_hd__fill_1
* cell instance sky130_fd_sc_hd__fill_1_1229 r0 *1 0,0
Xsky130_fd_sc_hd__fill_1_1229
+ vss
+ vdd
+ vdd
+ sky130_fd_sc_hd__fill_1
* cell instance sky130_fd_sc_hd__fill_1_1230 r0 *1 0,0
Xsky130_fd_sc_hd__fill_1_1230
+ vss
+ vdd
+ vdd
+ sky130_fd_sc_hd__fill_1
* cell instance sky130_fd_sc_hd__fill_1_1231 r0 *1 0,0
Xsky130_fd_sc_hd__fill_1_1231
+ vss
+ vdd
+ vdd
+ sky130_fd_sc_hd__fill_1
* cell instance sky130_fd_sc_hd__fill_1_1232 r0 *1 0,0
Xsky130_fd_sc_hd__fill_1_1232
+ vss
+ vdd
+ vdd
+ sky130_fd_sc_hd__fill_1
* cell instance sky130_fd_sc_hd__fill_1_1233 r0 *1 0,0
Xsky130_fd_sc_hd__fill_1_1233
+ vss
+ vdd
+ vdd
+ sky130_fd_sc_hd__fill_1
* cell instance sky130_fd_sc_hd__fill_1_1234 r0 *1 0,0
Xsky130_fd_sc_hd__fill_1_1234
+ vss
+ vdd
+ vdd
+ sky130_fd_sc_hd__fill_1
* cell instance sky130_fd_sc_hd__fill_1_1235 r0 *1 0,0
Xsky130_fd_sc_hd__fill_1_1235
+ vss
+ vdd
+ vdd
+ sky130_fd_sc_hd__fill_1
* cell instance sky130_fd_sc_hd__fill_1_1236 r0 *1 0,0
Xsky130_fd_sc_hd__fill_1_1236
+ vss
+ vdd
+ vdd
+ sky130_fd_sc_hd__fill_1
* cell instance sky130_fd_sc_hd__fill_1_1237 r0 *1 0,0
Xsky130_fd_sc_hd__fill_1_1237
+ vss
+ vdd
+ vdd
+ sky130_fd_sc_hd__fill_1
* cell instance sky130_fd_sc_hd__fill_1_1238 r0 *1 0,0
Xsky130_fd_sc_hd__fill_1_1238
+ vss
+ vdd
+ vdd
+ sky130_fd_sc_hd__fill_1
* cell instance sky130_fd_sc_hd__fill_1_1239 r0 *1 0,0
Xsky130_fd_sc_hd__fill_1_1239
+ vss
+ vdd
+ vdd
+ sky130_fd_sc_hd__fill_1
* cell instance sky130_fd_sc_hd__fill_1_1240 r0 *1 0,0
Xsky130_fd_sc_hd__fill_1_1240
+ vss
+ vdd
+ vdd
+ sky130_fd_sc_hd__fill_1
* cell instance sky130_fd_sc_hd__fill_1_1241 r0 *1 0,0
Xsky130_fd_sc_hd__fill_1_1241
+ vss
+ vdd
+ vdd
+ sky130_fd_sc_hd__fill_1
* cell instance sky130_fd_sc_hd__fill_1_1242 r0 *1 0,0
Xsky130_fd_sc_hd__fill_1_1242
+ vss
+ vdd
+ vdd
+ sky130_fd_sc_hd__fill_1
* cell instance sky130_fd_sc_hd__fill_1_1243 r0 *1 0,0
Xsky130_fd_sc_hd__fill_1_1243
+ vss
+ vdd
+ vdd
+ sky130_fd_sc_hd__fill_1
* cell instance sky130_fd_sc_hd__fill_1_1244 r0 *1 0,0
Xsky130_fd_sc_hd__fill_1_1244
+ vss
+ vdd
+ vdd
+ sky130_fd_sc_hd__fill_1
* cell instance sky130_fd_sc_hd__fill_1_1245 r0 *1 0,0
Xsky130_fd_sc_hd__fill_1_1245
+ vss
+ vdd
+ vdd
+ sky130_fd_sc_hd__fill_1
* cell instance sky130_fd_sc_hd__fill_1_1246 r0 *1 0,0
Xsky130_fd_sc_hd__fill_1_1246
+ vss
+ vdd
+ vdd
+ sky130_fd_sc_hd__fill_1
* cell instance sky130_fd_sc_hd__fill_1_1247 r0 *1 0,0
Xsky130_fd_sc_hd__fill_1_1247
+ vss
+ vdd
+ vdd
+ sky130_fd_sc_hd__fill_1
* cell instance sky130_fd_sc_hd__fill_1_1248 r0 *1 0,0
Xsky130_fd_sc_hd__fill_1_1248
+ vss
+ vdd
+ vdd
+ sky130_fd_sc_hd__fill_1
* cell instance sky130_fd_sc_hd__fill_1_1249 r0 *1 0,0
Xsky130_fd_sc_hd__fill_1_1249
+ vss
+ vdd
+ vdd
+ sky130_fd_sc_hd__fill_1
* cell instance sky130_fd_sc_hd__fill_1_1250 r0 *1 0,0
Xsky130_fd_sc_hd__fill_1_1250
+ vss
+ vdd
+ vdd
+ sky130_fd_sc_hd__fill_1
* cell instance sky130_fd_sc_hd__fill_1_1251 r0 *1 0,0
Xsky130_fd_sc_hd__fill_1_1251
+ vss
+ vdd
+ vdd
+ sky130_fd_sc_hd__fill_1
* cell instance sky130_fd_sc_hd__fill_1_1252 r0 *1 0,0
Xsky130_fd_sc_hd__fill_1_1252
+ vss
+ vdd
+ vdd
+ sky130_fd_sc_hd__fill_1
* cell instance sky130_fd_sc_hd__fill_1_1253 r0 *1 0,0
Xsky130_fd_sc_hd__fill_1_1253
+ vss
+ vdd
+ vdd
+ sky130_fd_sc_hd__fill_1
* cell instance sky130_fd_sc_hd__fill_1_1254 r0 *1 0,0
Xsky130_fd_sc_hd__fill_1_1254
+ vss
+ vdd
+ vdd
+ sky130_fd_sc_hd__fill_1
* cell instance sky130_fd_sc_hd__fill_1_1255 r0 *1 0,0
Xsky130_fd_sc_hd__fill_1_1255
+ vss
+ vdd
+ vdd
+ sky130_fd_sc_hd__fill_1
* cell instance sky130_fd_sc_hd__fill_1_1256 r0 *1 0,0
Xsky130_fd_sc_hd__fill_1_1256
+ vss
+ vdd
+ vdd
+ sky130_fd_sc_hd__fill_1
* cell instance sky130_fd_sc_hd__fill_1_1257 r0 *1 0,0
Xsky130_fd_sc_hd__fill_1_1257
+ vss
+ vdd
+ vdd
+ sky130_fd_sc_hd__fill_1
* cell instance sky130_fd_sc_hd__fill_1_1258 r0 *1 0,0
Xsky130_fd_sc_hd__fill_1_1258
+ vss
+ vdd
+ vdd
+ sky130_fd_sc_hd__fill_1
* cell instance sky130_fd_sc_hd__fill_1_1259 r0 *1 0,0
Xsky130_fd_sc_hd__fill_1_1259
+ vss
+ vdd
+ vdd
+ sky130_fd_sc_hd__fill_1
* cell instance sky130_fd_sc_hd__fill_1_1260 r0 *1 0,0
Xsky130_fd_sc_hd__fill_1_1260
+ vss
+ vdd
+ vdd
+ sky130_fd_sc_hd__fill_1
* cell instance sky130_fd_sc_hd__fill_1_1261 r0 *1 0,0
Xsky130_fd_sc_hd__fill_1_1261
+ vss
+ vdd
+ vdd
+ sky130_fd_sc_hd__fill_1
* cell instance sky130_fd_sc_hd__fill_1_1262 r0 *1 0,0
Xsky130_fd_sc_hd__fill_1_1262
+ vss
+ vdd
+ vdd
+ sky130_fd_sc_hd__fill_1
* cell instance sky130_fd_sc_hd__fill_1_1263 r0 *1 0,0
Xsky130_fd_sc_hd__fill_1_1263
+ vss
+ vdd
+ vdd
+ sky130_fd_sc_hd__fill_1
* cell instance sky130_fd_sc_hd__fill_1_1264 r0 *1 0,0
Xsky130_fd_sc_hd__fill_1_1264
+ vss
+ vdd
+ vdd
+ sky130_fd_sc_hd__fill_1
* cell instance sky130_fd_sc_hd__fill_1_1265 r0 *1 0,0
Xsky130_fd_sc_hd__fill_1_1265
+ vss
+ vdd
+ vdd
+ sky130_fd_sc_hd__fill_1
* cell instance sky130_fd_sc_hd__fill_1_1266 r0 *1 0,0
Xsky130_fd_sc_hd__fill_1_1266
+ vss
+ vdd
+ vdd
+ sky130_fd_sc_hd__fill_1
* cell instance sky130_fd_sc_hd__fill_1_1267 r0 *1 0,0
Xsky130_fd_sc_hd__fill_1_1267
+ vss
+ vdd
+ vdd
+ sky130_fd_sc_hd__fill_1
* cell instance sky130_fd_sc_hd__fill_1_1268 r0 *1 0,0
Xsky130_fd_sc_hd__fill_1_1268
+ vss
+ vdd
+ vdd
+ sky130_fd_sc_hd__fill_1
* cell instance sky130_fd_sc_hd__fill_1_1269 r0 *1 0,0
Xsky130_fd_sc_hd__fill_1_1269
+ vss
+ vdd
+ vdd
+ sky130_fd_sc_hd__fill_1
* cell instance sky130_fd_sc_hd__fill_1_1270 r0 *1 0,0
Xsky130_fd_sc_hd__fill_1_1270
+ vss
+ vdd
+ vdd
+ sky130_fd_sc_hd__fill_1
* cell instance sky130_fd_sc_hd__fill_1_1271 r0 *1 0,0
Xsky130_fd_sc_hd__fill_1_1271
+ vss
+ vdd
+ vdd
+ sky130_fd_sc_hd__fill_1
* cell instance sky130_fd_sc_hd__fill_1_1272 r0 *1 0,0
Xsky130_fd_sc_hd__fill_1_1272
+ vss
+ vdd
+ vdd
+ sky130_fd_sc_hd__fill_1
* cell instance sky130_fd_sc_hd__fill_1_1273 r0 *1 0,0
Xsky130_fd_sc_hd__fill_1_1273
+ vss
+ vdd
+ vdd
+ sky130_fd_sc_hd__fill_1
* cell instance sky130_fd_sc_hd__fill_1_1274 r0 *1 0,0
Xsky130_fd_sc_hd__fill_1_1274
+ vss
+ vdd
+ vdd
+ sky130_fd_sc_hd__fill_1
* cell instance sky130_fd_sc_hd__fill_1_1275 r0 *1 0,0
Xsky130_fd_sc_hd__fill_1_1275
+ vss
+ vdd
+ vdd
+ sky130_fd_sc_hd__fill_1
* cell instance sky130_fd_sc_hd__fill_1_1276 r0 *1 0,0
Xsky130_fd_sc_hd__fill_1_1276
+ vss
+ vdd
+ vdd
+ sky130_fd_sc_hd__fill_1
* cell instance sky130_fd_sc_hd__fill_1_1277 r0 *1 0,0
Xsky130_fd_sc_hd__fill_1_1277
+ vss
+ vdd
+ vdd
+ sky130_fd_sc_hd__fill_1
* cell instance sky130_fd_sc_hd__fill_1_1278 r0 *1 0,0
Xsky130_fd_sc_hd__fill_1_1278
+ vss
+ vdd
+ vdd
+ sky130_fd_sc_hd__fill_1
* cell instance sky130_fd_sc_hd__fill_1_1279 r0 *1 0,0
Xsky130_fd_sc_hd__fill_1_1279
+ vss
+ vdd
+ vdd
+ sky130_fd_sc_hd__fill_1
* cell instance sky130_fd_sc_hd__fill_1_1280 r0 *1 0,0
Xsky130_fd_sc_hd__fill_1_1280
+ vss
+ vdd
+ vdd
+ sky130_fd_sc_hd__fill_1
* cell instance sky130_fd_sc_hd__fill_1_1281 r0 *1 0,0
Xsky130_fd_sc_hd__fill_1_1281
+ vss
+ vdd
+ vdd
+ sky130_fd_sc_hd__fill_1
* cell instance sky130_fd_sc_hd__fill_1_1282 r0 *1 0,0
Xsky130_fd_sc_hd__fill_1_1282
+ vss
+ vdd
+ vdd
+ sky130_fd_sc_hd__fill_1
* cell instance sky130_fd_sc_hd__fill_1_1283 r0 *1 0,0
Xsky130_fd_sc_hd__fill_1_1283
+ vss
+ vdd
+ vdd
+ sky130_fd_sc_hd__fill_1
* cell instance sky130_fd_sc_hd__fill_1_1284 r0 *1 0,0
Xsky130_fd_sc_hd__fill_1_1284
+ vss
+ vdd
+ vdd
+ sky130_fd_sc_hd__fill_1
* cell instance sky130_fd_sc_hd__fill_1_1285 r0 *1 0,0
Xsky130_fd_sc_hd__fill_1_1285
+ vss
+ vdd
+ vdd
+ sky130_fd_sc_hd__fill_1
* cell instance sky130_fd_sc_hd__fill_1_1286 r0 *1 0,0
Xsky130_fd_sc_hd__fill_1_1286
+ vss
+ vdd
+ vdd
+ sky130_fd_sc_hd__fill_1
* cell instance sky130_fd_sc_hd__fill_1_1287 r0 *1 0,0
Xsky130_fd_sc_hd__fill_1_1287
+ vss
+ vdd
+ vdd
+ sky130_fd_sc_hd__fill_1
* cell instance sky130_fd_sc_hd__fill_1_1288 r0 *1 0,0
Xsky130_fd_sc_hd__fill_1_1288
+ vss
+ vdd
+ vdd
+ sky130_fd_sc_hd__fill_1
* cell instance sky130_fd_sc_hd__fill_1_1289 r0 *1 0,0
Xsky130_fd_sc_hd__fill_1_1289
+ vss
+ vdd
+ vdd
+ sky130_fd_sc_hd__fill_1
* cell instance sky130_fd_sc_hd__fill_1_1290 r0 *1 0,0
Xsky130_fd_sc_hd__fill_1_1290
+ vss
+ vdd
+ vdd
+ sky130_fd_sc_hd__fill_1
* cell instance sky130_fd_sc_hd__fill_1_1291 r0 *1 0,0
Xsky130_fd_sc_hd__fill_1_1291
+ vss
+ vdd
+ vdd
+ sky130_fd_sc_hd__fill_1
* cell instance sky130_fd_sc_hd__fill_1_1292 r0 *1 0,0
Xsky130_fd_sc_hd__fill_1_1292
+ vss
+ vdd
+ vdd
+ sky130_fd_sc_hd__fill_1
* cell instance sky130_fd_sc_hd__fill_1_1293 r0 *1 0,0
Xsky130_fd_sc_hd__fill_1_1293
+ vss
+ vdd
+ vdd
+ sky130_fd_sc_hd__fill_1
* cell instance sky130_fd_sc_hd__fill_1_1294 r0 *1 0,0
Xsky130_fd_sc_hd__fill_1_1294
+ vss
+ vdd
+ vdd
+ sky130_fd_sc_hd__fill_1
* cell instance sky130_fd_sc_hd__fill_1_1295 r0 *1 0,0
Xsky130_fd_sc_hd__fill_1_1295
+ vss
+ vdd
+ vdd
+ sky130_fd_sc_hd__fill_1
* cell instance sky130_fd_sc_hd__fill_1_1296 r0 *1 0,0
Xsky130_fd_sc_hd__fill_1_1296
+ vss
+ vdd
+ vdd
+ sky130_fd_sc_hd__fill_1
* cell instance sky130_fd_sc_hd__fill_1_1297 r0 *1 0,0
Xsky130_fd_sc_hd__fill_1_1297
+ vss
+ vdd
+ vdd
+ sky130_fd_sc_hd__fill_1
* cell instance sky130_fd_sc_hd__fill_1_1298 r0 *1 0,0
Xsky130_fd_sc_hd__fill_1_1298
+ vss
+ vdd
+ vdd
+ sky130_fd_sc_hd__fill_1
* cell instance sky130_fd_sc_hd__fill_1_1299 r0 *1 0,0
Xsky130_fd_sc_hd__fill_1_1299
+ vss
+ vdd
+ vdd
+ sky130_fd_sc_hd__fill_1
* cell instance sky130_fd_sc_hd__fill_1_1300 r0 *1 0,0
Xsky130_fd_sc_hd__fill_1_1300
+ vss
+ vdd
+ vdd
+ sky130_fd_sc_hd__fill_1
* cell instance sky130_fd_sc_hd__fill_1_1301 r0 *1 0,0
Xsky130_fd_sc_hd__fill_1_1301
+ vss
+ vdd
+ vdd
+ sky130_fd_sc_hd__fill_1
* cell instance sky130_fd_sc_hd__fill_1_1302 r0 *1 0,0
Xsky130_fd_sc_hd__fill_1_1302
+ vss
+ vdd
+ vdd
+ sky130_fd_sc_hd__fill_1
* cell instance sky130_fd_sc_hd__fill_1_1303 r0 *1 0,0
Xsky130_fd_sc_hd__fill_1_1303
+ vss
+ vdd
+ vdd
+ sky130_fd_sc_hd__fill_1
* cell instance sky130_fd_sc_hd__fill_1_1304 r0 *1 0,0
Xsky130_fd_sc_hd__fill_1_1304
+ vss
+ vdd
+ vdd
+ sky130_fd_sc_hd__fill_1
* cell instance sky130_fd_sc_hd__fill_1_1305 r0 *1 0,0
Xsky130_fd_sc_hd__fill_1_1305
+ vss
+ vdd
+ vdd
+ sky130_fd_sc_hd__fill_1
* cell instance sky130_fd_sc_hd__fill_1_1306 r0 *1 0,0
Xsky130_fd_sc_hd__fill_1_1306
+ vss
+ vdd
+ vdd
+ sky130_fd_sc_hd__fill_1
* cell instance sky130_fd_sc_hd__fill_1_1307 r0 *1 0,0
Xsky130_fd_sc_hd__fill_1_1307
+ vss
+ vdd
+ vdd
+ sky130_fd_sc_hd__fill_1
* cell instance sky130_fd_sc_hd__fill_1_1308 r0 *1 0,0
Xsky130_fd_sc_hd__fill_1_1308
+ vss
+ vdd
+ vdd
+ sky130_fd_sc_hd__fill_1
* cell instance sky130_fd_sc_hd__fill_1_1309 r0 *1 0,0
Xsky130_fd_sc_hd__fill_1_1309
+ vss
+ vdd
+ vdd
+ sky130_fd_sc_hd__fill_1
* cell instance sky130_fd_sc_hd__fill_1_1310 r0 *1 0,0
Xsky130_fd_sc_hd__fill_1_1310
+ vss
+ vdd
+ vdd
+ sky130_fd_sc_hd__fill_1
* cell instance sky130_fd_sc_hd__fill_1_1311 r0 *1 0,0
Xsky130_fd_sc_hd__fill_1_1311
+ vss
+ vdd
+ vdd
+ sky130_fd_sc_hd__fill_1
* cell instance sky130_fd_sc_hd__fill_1_1312 r0 *1 0,0
Xsky130_fd_sc_hd__fill_1_1312
+ vss
+ vdd
+ vdd
+ sky130_fd_sc_hd__fill_1
* cell instance sky130_fd_sc_hd__fill_1_1313 r0 *1 0,0
Xsky130_fd_sc_hd__fill_1_1313
+ vss
+ vdd
+ vdd
+ sky130_fd_sc_hd__fill_1
* cell instance sky130_fd_sc_hd__fill_1_1314 r0 *1 0,0
Xsky130_fd_sc_hd__fill_1_1314
+ vss
+ vdd
+ vdd
+ sky130_fd_sc_hd__fill_1
* cell instance sky130_fd_sc_hd__fill_1_1315 r0 *1 0,0
Xsky130_fd_sc_hd__fill_1_1315
+ vss
+ vdd
+ vdd
+ sky130_fd_sc_hd__fill_1
* cell instance sky130_fd_sc_hd__fill_1_1316 r0 *1 0,0
Xsky130_fd_sc_hd__fill_1_1316
+ vss
+ vdd
+ vdd
+ sky130_fd_sc_hd__fill_1
* cell instance sky130_fd_sc_hd__fill_1_1317 r0 *1 0,0
Xsky130_fd_sc_hd__fill_1_1317
+ vss
+ vdd
+ vdd
+ sky130_fd_sc_hd__fill_1
* cell instance sky130_fd_sc_hd__fill_1_1318 r0 *1 0,0
Xsky130_fd_sc_hd__fill_1_1318
+ vss
+ vdd
+ vdd
+ sky130_fd_sc_hd__fill_1
* cell instance sky130_fd_sc_hd__fill_1_1319 r0 *1 0,0
Xsky130_fd_sc_hd__fill_1_1319
+ vss
+ vdd
+ vdd
+ sky130_fd_sc_hd__fill_1
* cell instance sky130_fd_sc_hd__fill_1_1320 r0 *1 0,0
Xsky130_fd_sc_hd__fill_1_1320
+ vss
+ vdd
+ vdd
+ sky130_fd_sc_hd__fill_1
* cell instance sky130_fd_sc_hd__fill_1_1321 r0 *1 0,0
Xsky130_fd_sc_hd__fill_1_1321
+ vss
+ vdd
+ vdd
+ sky130_fd_sc_hd__fill_1
* cell instance sky130_fd_sc_hd__fill_1_1322 r0 *1 0,0
Xsky130_fd_sc_hd__fill_1_1322
+ vss
+ vdd
+ vdd
+ sky130_fd_sc_hd__fill_1
* cell instance sky130_fd_sc_hd__fill_1_1323 r0 *1 0,0
Xsky130_fd_sc_hd__fill_1_1323
+ vss
+ vdd
+ vdd
+ sky130_fd_sc_hd__fill_1
* cell instance sky130_fd_sc_hd__fill_1_1324 r0 *1 0,0
Xsky130_fd_sc_hd__fill_1_1324
+ vss
+ vdd
+ vdd
+ sky130_fd_sc_hd__fill_1
* cell instance sky130_fd_sc_hd__fill_1_1325 r0 *1 0,0
Xsky130_fd_sc_hd__fill_1_1325
+ vss
+ vdd
+ vdd
+ sky130_fd_sc_hd__fill_1
* cell instance sky130_fd_sc_hd__fill_1_1326 r0 *1 0,0
Xsky130_fd_sc_hd__fill_1_1326
+ vss
+ vdd
+ vdd
+ sky130_fd_sc_hd__fill_1
* cell instance sky130_fd_sc_hd__fill_1_1327 r0 *1 0,0
Xsky130_fd_sc_hd__fill_1_1327
+ vss
+ vdd
+ vdd
+ sky130_fd_sc_hd__fill_1
* cell instance sky130_fd_sc_hd__fill_1_1328 r0 *1 0,0
Xsky130_fd_sc_hd__fill_1_1328
+ vss
+ vdd
+ vdd
+ sky130_fd_sc_hd__fill_1
* cell instance sky130_fd_sc_hd__fill_2_0 r0 *1 0,0
Xsky130_fd_sc_hd__fill_2_0
+ vss
+ vdd
+ vdd
+ sky130_fd_sc_hd__fill_2
* cell instance sky130_fd_sc_hd__fill_2_1 r0 *1 0,0
Xsky130_fd_sc_hd__fill_2_1
+ vss
+ vdd
+ vdd
+ sky130_fd_sc_hd__fill_2
* cell instance sky130_fd_sc_hd__fill_2_2 r0 *1 0,0
Xsky130_fd_sc_hd__fill_2_2
+ vss
+ vdd
+ vdd
+ sky130_fd_sc_hd__fill_2
* cell instance sky130_fd_sc_hd__fill_2_3 r0 *1 0,0
Xsky130_fd_sc_hd__fill_2_3
+ vss
+ vdd
+ vdd
+ sky130_fd_sc_hd__fill_2
* cell instance sky130_fd_sc_hd__fill_2_4 r0 *1 0,0
Xsky130_fd_sc_hd__fill_2_4
+ vss
+ vdd
+ vdd
+ sky130_fd_sc_hd__fill_2
* cell instance sky130_fd_sc_hd__fill_2_5 r0 *1 0,0
Xsky130_fd_sc_hd__fill_2_5
+ vss
+ vdd
+ vdd
+ sky130_fd_sc_hd__fill_2
* cell instance sky130_fd_sc_hd__fill_2_6 r0 *1 0,0
Xsky130_fd_sc_hd__fill_2_6
+ vss
+ vdd
+ vdd
+ sky130_fd_sc_hd__fill_2
* cell instance sky130_fd_sc_hd__fill_2_7 r0 *1 0,0
Xsky130_fd_sc_hd__fill_2_7
+ vss
+ vdd
+ vdd
+ sky130_fd_sc_hd__fill_2
* cell instance sky130_fd_sc_hd__fill_2_8 r0 *1 0,0
Xsky130_fd_sc_hd__fill_2_8
+ vss
+ vdd
+ vdd
+ sky130_fd_sc_hd__fill_2
* cell instance sky130_fd_sc_hd__fill_2_9 r0 *1 0,0
Xsky130_fd_sc_hd__fill_2_9
+ vss
+ vdd
+ vdd
+ sky130_fd_sc_hd__fill_2
* cell instance sky130_fd_sc_hd__fill_2_10 r0 *1 0,0
Xsky130_fd_sc_hd__fill_2_10
+ vss
+ vdd
+ vdd
+ sky130_fd_sc_hd__fill_2
* cell instance sky130_fd_sc_hd__fill_2_11 r0 *1 0,0
Xsky130_fd_sc_hd__fill_2_11
+ vss
+ vdd
+ vdd
+ sky130_fd_sc_hd__fill_2
* cell instance sky130_fd_sc_hd__fill_2_12 r0 *1 0,0
Xsky130_fd_sc_hd__fill_2_12
+ vss
+ vdd
+ vdd
+ sky130_fd_sc_hd__fill_2
* cell instance sky130_fd_sc_hd__fill_2_13 r0 *1 0,0
Xsky130_fd_sc_hd__fill_2_13
+ vss
+ vdd
+ vdd
+ sky130_fd_sc_hd__fill_2
* cell instance sky130_fd_sc_hd__fill_2_14 r0 *1 0,0
Xsky130_fd_sc_hd__fill_2_14
+ vss
+ vdd
+ vdd
+ sky130_fd_sc_hd__fill_2
* cell instance sky130_fd_sc_hd__fill_2_15 r0 *1 0,0
Xsky130_fd_sc_hd__fill_2_15
+ vss
+ vdd
+ vdd
+ sky130_fd_sc_hd__fill_2
* cell instance sky130_fd_sc_hd__fill_2_16 r0 *1 0,0
Xsky130_fd_sc_hd__fill_2_16
+ vss
+ vdd
+ vdd
+ sky130_fd_sc_hd__fill_2
* cell instance sky130_fd_sc_hd__fill_2_17 r0 *1 0,0
Xsky130_fd_sc_hd__fill_2_17
+ vss
+ vdd
+ vdd
+ sky130_fd_sc_hd__fill_2
* cell instance sky130_fd_sc_hd__fill_2_18 r0 *1 0,0
Xsky130_fd_sc_hd__fill_2_18
+ vss
+ vdd
+ vdd
+ sky130_fd_sc_hd__fill_2
* cell instance sky130_fd_sc_hd__fill_2_19 r0 *1 0,0
Xsky130_fd_sc_hd__fill_2_19
+ vss
+ vdd
+ vdd
+ sky130_fd_sc_hd__fill_2
* cell instance sky130_fd_sc_hd__fill_2_20 r0 *1 0,0
Xsky130_fd_sc_hd__fill_2_20
+ vss
+ vdd
+ vdd
+ sky130_fd_sc_hd__fill_2
* cell instance sky130_fd_sc_hd__fill_2_21 r0 *1 0,0
Xsky130_fd_sc_hd__fill_2_21
+ vss
+ vdd
+ vdd
+ sky130_fd_sc_hd__fill_2
* cell instance sky130_fd_sc_hd__fill_2_22 r0 *1 0,0
Xsky130_fd_sc_hd__fill_2_22
+ vss
+ vdd
+ vdd
+ sky130_fd_sc_hd__fill_2
* cell instance sky130_fd_sc_hd__fill_2_23 r0 *1 0,0
Xsky130_fd_sc_hd__fill_2_23
+ vss
+ vdd
+ vdd
+ sky130_fd_sc_hd__fill_2
* cell instance sky130_fd_sc_hd__fill_2_24 r0 *1 0,0
Xsky130_fd_sc_hd__fill_2_24
+ vss
+ vdd
+ vdd
+ sky130_fd_sc_hd__fill_2
* cell instance sky130_fd_sc_hd__fill_2_25 r0 *1 0,0
Xsky130_fd_sc_hd__fill_2_25
+ vss
+ vdd
+ vdd
+ sky130_fd_sc_hd__fill_2
* cell instance sky130_fd_sc_hd__fill_2_26 r0 *1 0,0
Xsky130_fd_sc_hd__fill_2_26
+ vss
+ vdd
+ vdd
+ sky130_fd_sc_hd__fill_2
* cell instance sky130_fd_sc_hd__fill_2_27 r0 *1 0,0
Xsky130_fd_sc_hd__fill_2_27
+ vss
+ vdd
+ vdd
+ sky130_fd_sc_hd__fill_2
* cell instance sky130_fd_sc_hd__fill_2_28 r0 *1 0,0
Xsky130_fd_sc_hd__fill_2_28
+ vss
+ vdd
+ vdd
+ sky130_fd_sc_hd__fill_2
* cell instance sky130_fd_sc_hd__fill_2_29 r0 *1 0,0
Xsky130_fd_sc_hd__fill_2_29
+ vss
+ vdd
+ vdd
+ sky130_fd_sc_hd__fill_2
* cell instance sky130_fd_sc_hd__fill_2_30 r0 *1 0,0
Xsky130_fd_sc_hd__fill_2_30
+ vss
+ vdd
+ vdd
+ sky130_fd_sc_hd__fill_2
* cell instance sky130_fd_sc_hd__fill_2_31 r0 *1 0,0
Xsky130_fd_sc_hd__fill_2_31
+ vss
+ vdd
+ vdd
+ sky130_fd_sc_hd__fill_2
* cell instance sky130_fd_sc_hd__fill_2_32 r0 *1 0,0
Xsky130_fd_sc_hd__fill_2_32
+ vss
+ vdd
+ vdd
+ sky130_fd_sc_hd__fill_2
* cell instance sky130_fd_sc_hd__fill_2_33 r0 *1 0,0
Xsky130_fd_sc_hd__fill_2_33
+ vss
+ vdd
+ vdd
+ sky130_fd_sc_hd__fill_2
* cell instance sky130_fd_sc_hd__fill_2_34 r0 *1 0,0
Xsky130_fd_sc_hd__fill_2_34
+ vss
+ vdd
+ vdd
+ sky130_fd_sc_hd__fill_2
* cell instance sky130_fd_sc_hd__fill_2_35 r0 *1 0,0
Xsky130_fd_sc_hd__fill_2_35
+ vss
+ vdd
+ vdd
+ sky130_fd_sc_hd__fill_2
* cell instance sky130_fd_sc_hd__fill_2_36 r0 *1 0,0
Xsky130_fd_sc_hd__fill_2_36
+ vss
+ vdd
+ vdd
+ sky130_fd_sc_hd__fill_2
* cell instance sky130_fd_sc_hd__fill_2_37 r0 *1 0,0
Xsky130_fd_sc_hd__fill_2_37
+ vss
+ vdd
+ vdd
+ sky130_fd_sc_hd__fill_2
* cell instance sky130_fd_sc_hd__fill_2_38 r0 *1 0,0
Xsky130_fd_sc_hd__fill_2_38
+ vss
+ vdd
+ vdd
+ sky130_fd_sc_hd__fill_2
* cell instance sky130_fd_sc_hd__fill_2_39 r0 *1 0,0
Xsky130_fd_sc_hd__fill_2_39
+ vss
+ vdd
+ vdd
+ sky130_fd_sc_hd__fill_2
* cell instance sky130_fd_sc_hd__fill_2_40 r0 *1 0,0
Xsky130_fd_sc_hd__fill_2_40
+ vss
+ vdd
+ vdd
+ sky130_fd_sc_hd__fill_2
* cell instance sky130_fd_sc_hd__fill_2_41 r0 *1 0,0
Xsky130_fd_sc_hd__fill_2_41
+ vss
+ vdd
+ vdd
+ sky130_fd_sc_hd__fill_2
* cell instance sky130_fd_sc_hd__fill_2_42 r0 *1 0,0
Xsky130_fd_sc_hd__fill_2_42
+ vss
+ vdd
+ vdd
+ sky130_fd_sc_hd__fill_2
* cell instance sky130_fd_sc_hd__fill_2_43 r0 *1 0,0
Xsky130_fd_sc_hd__fill_2_43
+ vss
+ vdd
+ vdd
+ sky130_fd_sc_hd__fill_2
* cell instance sky130_fd_sc_hd__fill_2_44 r0 *1 0,0
Xsky130_fd_sc_hd__fill_2_44
+ vss
+ vdd
+ vdd
+ sky130_fd_sc_hd__fill_2
* cell instance sky130_fd_sc_hd__fill_2_45 r0 *1 0,0
Xsky130_fd_sc_hd__fill_2_45
+ vss
+ vdd
+ vdd
+ sky130_fd_sc_hd__fill_2
* cell instance sky130_fd_sc_hd__fill_2_46 r0 *1 0,0
Xsky130_fd_sc_hd__fill_2_46
+ vss
+ vdd
+ vdd
+ sky130_fd_sc_hd__fill_2
* cell instance sky130_fd_sc_hd__fill_2_47 r0 *1 0,0
Xsky130_fd_sc_hd__fill_2_47
+ vss
+ vdd
+ vdd
+ sky130_fd_sc_hd__fill_2
* cell instance sky130_fd_sc_hd__fill_2_48 r0 *1 0,0
Xsky130_fd_sc_hd__fill_2_48
+ vss
+ vdd
+ vdd
+ sky130_fd_sc_hd__fill_2
* cell instance sky130_fd_sc_hd__fill_2_49 r0 *1 0,0
Xsky130_fd_sc_hd__fill_2_49
+ vss
+ vdd
+ vdd
+ sky130_fd_sc_hd__fill_2
* cell instance sky130_fd_sc_hd__fill_2_50 r0 *1 0,0
Xsky130_fd_sc_hd__fill_2_50
+ vss
+ vdd
+ vdd
+ sky130_fd_sc_hd__fill_2
* cell instance sky130_fd_sc_hd__fill_2_51 r0 *1 0,0
Xsky130_fd_sc_hd__fill_2_51
+ vss
+ vdd
+ vdd
+ sky130_fd_sc_hd__fill_2
* cell instance sky130_fd_sc_hd__fill_2_52 r0 *1 0,0
Xsky130_fd_sc_hd__fill_2_52
+ vss
+ vdd
+ vdd
+ sky130_fd_sc_hd__fill_2
* cell instance sky130_fd_sc_hd__fill_2_53 r0 *1 0,0
Xsky130_fd_sc_hd__fill_2_53
+ vss
+ vdd
+ vdd
+ sky130_fd_sc_hd__fill_2
* cell instance sky130_fd_sc_hd__fill_2_54 r0 *1 0,0
Xsky130_fd_sc_hd__fill_2_54
+ vss
+ vdd
+ vdd
+ sky130_fd_sc_hd__fill_2
* cell instance sky130_fd_sc_hd__fill_2_55 r0 *1 0,0
Xsky130_fd_sc_hd__fill_2_55
+ vss
+ vdd
+ vdd
+ sky130_fd_sc_hd__fill_2
* cell instance sky130_fd_sc_hd__fill_2_56 r0 *1 0,0
Xsky130_fd_sc_hd__fill_2_56
+ vss
+ vdd
+ vdd
+ sky130_fd_sc_hd__fill_2
* cell instance sky130_fd_sc_hd__fill_2_57 r0 *1 0,0
Xsky130_fd_sc_hd__fill_2_57
+ vss
+ vdd
+ vdd
+ sky130_fd_sc_hd__fill_2
* cell instance sky130_fd_sc_hd__fill_2_58 r0 *1 0,0
Xsky130_fd_sc_hd__fill_2_58
+ vss
+ vdd
+ vdd
+ sky130_fd_sc_hd__fill_2
* cell instance sky130_fd_sc_hd__fill_2_59 r0 *1 0,0
Xsky130_fd_sc_hd__fill_2_59
+ vss
+ vdd
+ vdd
+ sky130_fd_sc_hd__fill_2
* cell instance sky130_fd_sc_hd__fill_2_60 r0 *1 0,0
Xsky130_fd_sc_hd__fill_2_60
+ vss
+ vdd
+ vdd
+ sky130_fd_sc_hd__fill_2
* cell instance sky130_fd_sc_hd__fill_2_61 r0 *1 0,0
Xsky130_fd_sc_hd__fill_2_61
+ vss
+ vdd
+ vdd
+ sky130_fd_sc_hd__fill_2
* cell instance sky130_fd_sc_hd__fill_2_62 r0 *1 0,0
Xsky130_fd_sc_hd__fill_2_62
+ vss
+ vdd
+ vdd
+ sky130_fd_sc_hd__fill_2
* cell instance sky130_fd_sc_hd__fill_2_63 r0 *1 0,0
Xsky130_fd_sc_hd__fill_2_63
+ vss
+ vdd
+ vdd
+ sky130_fd_sc_hd__fill_2
* cell instance sky130_fd_sc_hd__fill_2_64 r0 *1 0,0
Xsky130_fd_sc_hd__fill_2_64
+ vss
+ vdd
+ vdd
+ sky130_fd_sc_hd__fill_2
* cell instance sky130_fd_sc_hd__fill_2_65 r0 *1 0,0
Xsky130_fd_sc_hd__fill_2_65
+ vss
+ vdd
+ vdd
+ sky130_fd_sc_hd__fill_2
* cell instance sky130_fd_sc_hd__fill_2_66 r0 *1 0,0
Xsky130_fd_sc_hd__fill_2_66
+ vss
+ vdd
+ vdd
+ sky130_fd_sc_hd__fill_2
* cell instance sky130_fd_sc_hd__fill_2_67 r0 *1 0,0
Xsky130_fd_sc_hd__fill_2_67
+ vss
+ vdd
+ vdd
+ sky130_fd_sc_hd__fill_2
* cell instance sky130_fd_sc_hd__fill_2_68 r0 *1 0,0
Xsky130_fd_sc_hd__fill_2_68
+ vss
+ vdd
+ vdd
+ sky130_fd_sc_hd__fill_2
* cell instance sky130_fd_sc_hd__fill_2_69 r0 *1 0,0
Xsky130_fd_sc_hd__fill_2_69
+ vss
+ vdd
+ vdd
+ sky130_fd_sc_hd__fill_2
* cell instance sky130_fd_sc_hd__fill_2_70 r0 *1 0,0
Xsky130_fd_sc_hd__fill_2_70
+ vss
+ vdd
+ vdd
+ sky130_fd_sc_hd__fill_2
* cell instance sky130_fd_sc_hd__fill_2_71 r0 *1 0,0
Xsky130_fd_sc_hd__fill_2_71
+ vss
+ vdd
+ vdd
+ sky130_fd_sc_hd__fill_2
* cell instance sky130_fd_sc_hd__fill_2_72 r0 *1 0,0
Xsky130_fd_sc_hd__fill_2_72
+ vss
+ vdd
+ vdd
+ sky130_fd_sc_hd__fill_2
* cell instance sky130_fd_sc_hd__fill_2_73 r0 *1 0,0
Xsky130_fd_sc_hd__fill_2_73
+ vss
+ vdd
+ vdd
+ sky130_fd_sc_hd__fill_2
* cell instance sky130_fd_sc_hd__fill_2_74 r0 *1 0,0
Xsky130_fd_sc_hd__fill_2_74
+ vss
+ vdd
+ vdd
+ sky130_fd_sc_hd__fill_2
* cell instance sky130_fd_sc_hd__fill_2_75 r0 *1 0,0
Xsky130_fd_sc_hd__fill_2_75
+ vss
+ vdd
+ vdd
+ sky130_fd_sc_hd__fill_2
* cell instance sky130_fd_sc_hd__fill_2_76 r0 *1 0,0
Xsky130_fd_sc_hd__fill_2_76
+ vss
+ vdd
+ vdd
+ sky130_fd_sc_hd__fill_2
* cell instance sky130_fd_sc_hd__fill_2_77 r0 *1 0,0
Xsky130_fd_sc_hd__fill_2_77
+ vss
+ vdd
+ vdd
+ sky130_fd_sc_hd__fill_2
* cell instance sky130_fd_sc_hd__fill_2_78 r0 *1 0,0
Xsky130_fd_sc_hd__fill_2_78
+ vss
+ vdd
+ vdd
+ sky130_fd_sc_hd__fill_2
* cell instance sky130_fd_sc_hd__fill_2_79 r0 *1 0,0
Xsky130_fd_sc_hd__fill_2_79
+ vss
+ vdd
+ vdd
+ sky130_fd_sc_hd__fill_2
* cell instance sky130_fd_sc_hd__fill_2_80 r0 *1 0,0
Xsky130_fd_sc_hd__fill_2_80
+ vss
+ vdd
+ vdd
+ sky130_fd_sc_hd__fill_2
* cell instance sky130_fd_sc_hd__fill_2_81 r0 *1 0,0
Xsky130_fd_sc_hd__fill_2_81
+ vss
+ vdd
+ vdd
+ sky130_fd_sc_hd__fill_2
* cell instance sky130_fd_sc_hd__fill_2_82 r0 *1 0,0
Xsky130_fd_sc_hd__fill_2_82
+ vss
+ vdd
+ vdd
+ sky130_fd_sc_hd__fill_2
* cell instance sky130_fd_sc_hd__fill_2_83 r0 *1 0,0
Xsky130_fd_sc_hd__fill_2_83
+ vss
+ vdd
+ vdd
+ sky130_fd_sc_hd__fill_2
* cell instance sky130_fd_sc_hd__fill_2_84 r0 *1 0,0
Xsky130_fd_sc_hd__fill_2_84
+ vss
+ vdd
+ vdd
+ sky130_fd_sc_hd__fill_2
* cell instance sky130_fd_sc_hd__fill_2_85 r0 *1 0,0
Xsky130_fd_sc_hd__fill_2_85
+ vss
+ vdd
+ vdd
+ sky130_fd_sc_hd__fill_2
* cell instance sky130_fd_sc_hd__fill_2_86 r0 *1 0,0
Xsky130_fd_sc_hd__fill_2_86
+ vss
+ vdd
+ vdd
+ sky130_fd_sc_hd__fill_2
* cell instance sky130_fd_sc_hd__fill_2_87 r0 *1 0,0
Xsky130_fd_sc_hd__fill_2_87
+ vss
+ vdd
+ vdd
+ sky130_fd_sc_hd__fill_2
* cell instance sky130_fd_sc_hd__fill_2_88 r0 *1 0,0
Xsky130_fd_sc_hd__fill_2_88
+ vss
+ vdd
+ vdd
+ sky130_fd_sc_hd__fill_2
* cell instance sky130_fd_sc_hd__fill_2_89 r0 *1 0,0
Xsky130_fd_sc_hd__fill_2_89
+ vss
+ vdd
+ vdd
+ sky130_fd_sc_hd__fill_2
* cell instance sky130_fd_sc_hd__fill_2_90 r0 *1 0,0
Xsky130_fd_sc_hd__fill_2_90
+ vss
+ vdd
+ vdd
+ sky130_fd_sc_hd__fill_2
* cell instance sky130_fd_sc_hd__fill_2_91 r0 *1 0,0
Xsky130_fd_sc_hd__fill_2_91
+ vss
+ vdd
+ vdd
+ sky130_fd_sc_hd__fill_2
* cell instance sky130_fd_sc_hd__fill_2_92 r0 *1 0,0
Xsky130_fd_sc_hd__fill_2_92
+ vss
+ vdd
+ vdd
+ sky130_fd_sc_hd__fill_2
* cell instance sky130_fd_sc_hd__fill_2_93 r0 *1 0,0
Xsky130_fd_sc_hd__fill_2_93
+ vss
+ vdd
+ vdd
+ sky130_fd_sc_hd__fill_2
* cell instance sky130_fd_sc_hd__fill_2_94 r0 *1 0,0
Xsky130_fd_sc_hd__fill_2_94
+ vss
+ vdd
+ vdd
+ sky130_fd_sc_hd__fill_2
* cell instance sky130_fd_sc_hd__fill_2_95 r0 *1 0,0
Xsky130_fd_sc_hd__fill_2_95
+ vss
+ vdd
+ vdd
+ sky130_fd_sc_hd__fill_2
* cell instance sky130_fd_sc_hd__fill_2_96 r0 *1 0,0
Xsky130_fd_sc_hd__fill_2_96
+ vss
+ vdd
+ vdd
+ sky130_fd_sc_hd__fill_2
* cell instance sky130_fd_sc_hd__fill_2_97 r0 *1 0,0
Xsky130_fd_sc_hd__fill_2_97
+ vss
+ vdd
+ vdd
+ sky130_fd_sc_hd__fill_2
* cell instance sky130_fd_sc_hd__fill_2_98 r0 *1 0,0
Xsky130_fd_sc_hd__fill_2_98
+ vss
+ vdd
+ vdd
+ sky130_fd_sc_hd__fill_2
* cell instance sky130_fd_sc_hd__fill_2_99 r0 *1 0,0
Xsky130_fd_sc_hd__fill_2_99
+ vss
+ vdd
+ vdd
+ sky130_fd_sc_hd__fill_2
* cell instance sky130_fd_sc_hd__fill_2_100 r0 *1 0,0
Xsky130_fd_sc_hd__fill_2_100
+ vss
+ vdd
+ vdd
+ sky130_fd_sc_hd__fill_2
* cell instance sky130_fd_sc_hd__fill_2_101 r0 *1 0,0
Xsky130_fd_sc_hd__fill_2_101
+ vss
+ vdd
+ vdd
+ sky130_fd_sc_hd__fill_2
* cell instance sky130_fd_sc_hd__fill_2_102 r0 *1 0,0
Xsky130_fd_sc_hd__fill_2_102
+ vss
+ vdd
+ vdd
+ sky130_fd_sc_hd__fill_2
* cell instance sky130_fd_sc_hd__fill_2_103 r0 *1 0,0
Xsky130_fd_sc_hd__fill_2_103
+ vss
+ vdd
+ vdd
+ sky130_fd_sc_hd__fill_2
* cell instance sky130_fd_sc_hd__fill_2_104 r0 *1 0,0
Xsky130_fd_sc_hd__fill_2_104
+ vss
+ vdd
+ vdd
+ sky130_fd_sc_hd__fill_2
* cell instance sky130_fd_sc_hd__fill_2_105 r0 *1 0,0
Xsky130_fd_sc_hd__fill_2_105
+ vss
+ vdd
+ vdd
+ sky130_fd_sc_hd__fill_2
* cell instance sky130_fd_sc_hd__fill_2_106 r0 *1 0,0
Xsky130_fd_sc_hd__fill_2_106
+ vss
+ vdd
+ vdd
+ sky130_fd_sc_hd__fill_2
* cell instance sky130_fd_sc_hd__fill_2_107 r0 *1 0,0
Xsky130_fd_sc_hd__fill_2_107
+ vss
+ vdd
+ vdd
+ sky130_fd_sc_hd__fill_2
* cell instance sky130_fd_sc_hd__fill_2_108 r0 *1 0,0
Xsky130_fd_sc_hd__fill_2_108
+ vss
+ vdd
+ vdd
+ sky130_fd_sc_hd__fill_2
* cell instance sky130_fd_sc_hd__fill_2_109 r0 *1 0,0
Xsky130_fd_sc_hd__fill_2_109
+ vss
+ vdd
+ vdd
+ sky130_fd_sc_hd__fill_2
* cell instance sky130_fd_sc_hd__fill_2_110 r0 *1 0,0
Xsky130_fd_sc_hd__fill_2_110
+ vss
+ vdd
+ vdd
+ sky130_fd_sc_hd__fill_2
* cell instance sky130_fd_sc_hd__fill_2_111 r0 *1 0,0
Xsky130_fd_sc_hd__fill_2_111
+ vss
+ vdd
+ vdd
+ sky130_fd_sc_hd__fill_2
* cell instance sky130_fd_sc_hd__fill_2_112 r0 *1 0,0
Xsky130_fd_sc_hd__fill_2_112
+ vss
+ vdd
+ vdd
+ sky130_fd_sc_hd__fill_2
* cell instance sky130_fd_sc_hd__fill_2_113 r0 *1 0,0
Xsky130_fd_sc_hd__fill_2_113
+ vss
+ vdd
+ vdd
+ sky130_fd_sc_hd__fill_2
* cell instance sky130_fd_sc_hd__fill_2_114 r0 *1 0,0
Xsky130_fd_sc_hd__fill_2_114
+ vss
+ vdd
+ vdd
+ sky130_fd_sc_hd__fill_2
* cell instance sky130_fd_sc_hd__fill_2_115 r0 *1 0,0
Xsky130_fd_sc_hd__fill_2_115
+ vss
+ vdd
+ vdd
+ sky130_fd_sc_hd__fill_2
* cell instance sky130_fd_sc_hd__fill_2_116 r0 *1 0,0
Xsky130_fd_sc_hd__fill_2_116
+ vss
+ vdd
+ vdd
+ sky130_fd_sc_hd__fill_2
* cell instance sky130_fd_sc_hd__fill_2_117 r0 *1 0,0
Xsky130_fd_sc_hd__fill_2_117
+ vss
+ vdd
+ vdd
+ sky130_fd_sc_hd__fill_2
* cell instance sky130_fd_sc_hd__fill_2_118 r0 *1 0,0
Xsky130_fd_sc_hd__fill_2_118
+ vss
+ vdd
+ vdd
+ sky130_fd_sc_hd__fill_2
* cell instance sky130_fd_sc_hd__fill_2_119 r0 *1 0,0
Xsky130_fd_sc_hd__fill_2_119
+ vss
+ vdd
+ vdd
+ sky130_fd_sc_hd__fill_2
* cell instance sky130_fd_sc_hd__fill_2_120 r0 *1 0,0
Xsky130_fd_sc_hd__fill_2_120
+ vss
+ vdd
+ vdd
+ sky130_fd_sc_hd__fill_2
* cell instance sky130_fd_sc_hd__fill_2_121 r0 *1 0,0
Xsky130_fd_sc_hd__fill_2_121
+ vss
+ vdd
+ vdd
+ sky130_fd_sc_hd__fill_2
* cell instance sky130_fd_sc_hd__fill_2_122 r0 *1 0,0
Xsky130_fd_sc_hd__fill_2_122
+ vss
+ vdd
+ vdd
+ sky130_fd_sc_hd__fill_2
* cell instance sky130_fd_sc_hd__fill_2_123 r0 *1 0,0
Xsky130_fd_sc_hd__fill_2_123
+ vss
+ vdd
+ vdd
+ sky130_fd_sc_hd__fill_2
* cell instance sky130_fd_sc_hd__fill_2_124 r0 *1 0,0
Xsky130_fd_sc_hd__fill_2_124
+ vss
+ vdd
+ vdd
+ sky130_fd_sc_hd__fill_2
* cell instance sky130_fd_sc_hd__fill_2_125 r0 *1 0,0
Xsky130_fd_sc_hd__fill_2_125
+ vss
+ vdd
+ vdd
+ sky130_fd_sc_hd__fill_2
* cell instance sky130_fd_sc_hd__fill_2_126 r0 *1 0,0
Xsky130_fd_sc_hd__fill_2_126
+ vss
+ vdd
+ vdd
+ sky130_fd_sc_hd__fill_2
* cell instance sky130_fd_sc_hd__fill_2_127 r0 *1 0,0
Xsky130_fd_sc_hd__fill_2_127
+ vss
+ vdd
+ vdd
+ sky130_fd_sc_hd__fill_2
* cell instance sky130_fd_sc_hd__fill_2_128 r0 *1 0,0
Xsky130_fd_sc_hd__fill_2_128
+ vss
+ vdd
+ vdd
+ sky130_fd_sc_hd__fill_2
* cell instance sky130_fd_sc_hd__fill_2_129 r0 *1 0,0
Xsky130_fd_sc_hd__fill_2_129
+ vss
+ vdd
+ vdd
+ sky130_fd_sc_hd__fill_2
* cell instance sky130_fd_sc_hd__fill_2_130 r0 *1 0,0
Xsky130_fd_sc_hd__fill_2_130
+ vss
+ vdd
+ vdd
+ sky130_fd_sc_hd__fill_2
* cell instance sky130_fd_sc_hd__fill_2_131 r0 *1 0,0
Xsky130_fd_sc_hd__fill_2_131
+ vss
+ vdd
+ vdd
+ sky130_fd_sc_hd__fill_2
* cell instance sky130_fd_sc_hd__fill_2_132 r0 *1 0,0
Xsky130_fd_sc_hd__fill_2_132
+ vss
+ vdd
+ vdd
+ sky130_fd_sc_hd__fill_2
* cell instance sky130_fd_sc_hd__fill_2_133 r0 *1 0,0
Xsky130_fd_sc_hd__fill_2_133
+ vss
+ vdd
+ vdd
+ sky130_fd_sc_hd__fill_2
* cell instance sky130_fd_sc_hd__fill_2_134 r0 *1 0,0
Xsky130_fd_sc_hd__fill_2_134
+ vss
+ vdd
+ vdd
+ sky130_fd_sc_hd__fill_2
* cell instance sky130_fd_sc_hd__fill_2_135 r0 *1 0,0
Xsky130_fd_sc_hd__fill_2_135
+ vss
+ vdd
+ vdd
+ sky130_fd_sc_hd__fill_2
* cell instance sky130_fd_sc_hd__fill_2_136 r0 *1 0,0
Xsky130_fd_sc_hd__fill_2_136
+ vss
+ vdd
+ vdd
+ sky130_fd_sc_hd__fill_2
* cell instance sky130_fd_sc_hd__fill_2_137 r0 *1 0,0
Xsky130_fd_sc_hd__fill_2_137
+ vss
+ vdd
+ vdd
+ sky130_fd_sc_hd__fill_2
* cell instance sky130_fd_sc_hd__fill_2_138 r0 *1 0,0
Xsky130_fd_sc_hd__fill_2_138
+ vss
+ vdd
+ vdd
+ sky130_fd_sc_hd__fill_2
* cell instance sky130_fd_sc_hd__fill_2_139 r0 *1 0,0
Xsky130_fd_sc_hd__fill_2_139
+ vss
+ vdd
+ vdd
+ sky130_fd_sc_hd__fill_2
* cell instance sky130_fd_sc_hd__fill_2_140 r0 *1 0,0
Xsky130_fd_sc_hd__fill_2_140
+ vss
+ vdd
+ vdd
+ sky130_fd_sc_hd__fill_2
* cell instance sky130_fd_sc_hd__fill_2_141 r0 *1 0,0
Xsky130_fd_sc_hd__fill_2_141
+ vss
+ vdd
+ vdd
+ sky130_fd_sc_hd__fill_2
* cell instance sky130_fd_sc_hd__fill_2_142 r0 *1 0,0
Xsky130_fd_sc_hd__fill_2_142
+ vss
+ vdd
+ vdd
+ sky130_fd_sc_hd__fill_2
* cell instance sky130_fd_sc_hd__fill_2_143 r0 *1 0,0
Xsky130_fd_sc_hd__fill_2_143
+ vss
+ vdd
+ vdd
+ sky130_fd_sc_hd__fill_2
* cell instance sky130_fd_sc_hd__fill_2_144 r0 *1 0,0
Xsky130_fd_sc_hd__fill_2_144
+ vss
+ vdd
+ vdd
+ sky130_fd_sc_hd__fill_2
* cell instance sky130_fd_sc_hd__fill_2_145 r0 *1 0,0
Xsky130_fd_sc_hd__fill_2_145
+ vss
+ vdd
+ vdd
+ sky130_fd_sc_hd__fill_2
* cell instance sky130_fd_sc_hd__fill_2_146 r0 *1 0,0
Xsky130_fd_sc_hd__fill_2_146
+ vss
+ vdd
+ vdd
+ sky130_fd_sc_hd__fill_2
* cell instance sky130_fd_sc_hd__fill_2_147 r0 *1 0,0
Xsky130_fd_sc_hd__fill_2_147
+ vss
+ vdd
+ vdd
+ sky130_fd_sc_hd__fill_2
* cell instance sky130_fd_sc_hd__fill_2_148 r0 *1 0,0
Xsky130_fd_sc_hd__fill_2_148
+ vss
+ vdd
+ vdd
+ sky130_fd_sc_hd__fill_2
* cell instance sky130_fd_sc_hd__fill_2_149 r0 *1 0,0
Xsky130_fd_sc_hd__fill_2_149
+ vss
+ vdd
+ vdd
+ sky130_fd_sc_hd__fill_2
* cell instance sky130_fd_sc_hd__fill_2_150 r0 *1 0,0
Xsky130_fd_sc_hd__fill_2_150
+ vss
+ vdd
+ vdd
+ sky130_fd_sc_hd__fill_2
* cell instance sky130_fd_sc_hd__fill_2_151 r0 *1 0,0
Xsky130_fd_sc_hd__fill_2_151
+ vss
+ vdd
+ vdd
+ sky130_fd_sc_hd__fill_2
* cell instance sky130_fd_sc_hd__fill_2_152 r0 *1 0,0
Xsky130_fd_sc_hd__fill_2_152
+ vss
+ vdd
+ vdd
+ sky130_fd_sc_hd__fill_2
* cell instance sky130_fd_sc_hd__fill_2_153 r0 *1 0,0
Xsky130_fd_sc_hd__fill_2_153
+ vss
+ vdd
+ vdd
+ sky130_fd_sc_hd__fill_2
* cell instance sky130_fd_sc_hd__fill_2_154 r0 *1 0,0
Xsky130_fd_sc_hd__fill_2_154
+ vss
+ vdd
+ vdd
+ sky130_fd_sc_hd__fill_2
* cell instance sky130_fd_sc_hd__fill_2_155 r0 *1 0,0
Xsky130_fd_sc_hd__fill_2_155
+ vss
+ vdd
+ vdd
+ sky130_fd_sc_hd__fill_2
* cell instance sky130_fd_sc_hd__fill_2_156 r0 *1 0,0
Xsky130_fd_sc_hd__fill_2_156
+ vss
+ vdd
+ vdd
+ sky130_fd_sc_hd__fill_2
* cell instance sky130_fd_sc_hd__fill_2_157 r0 *1 0,0
Xsky130_fd_sc_hd__fill_2_157
+ vss
+ vdd
+ vdd
+ sky130_fd_sc_hd__fill_2
* cell instance sky130_fd_sc_hd__fill_2_158 r0 *1 0,0
Xsky130_fd_sc_hd__fill_2_158
+ vss
+ vdd
+ vdd
+ sky130_fd_sc_hd__fill_2
* cell instance sky130_fd_sc_hd__fill_2_159 r0 *1 0,0
Xsky130_fd_sc_hd__fill_2_159
+ vss
+ vdd
+ vdd
+ sky130_fd_sc_hd__fill_2
* cell instance sky130_fd_sc_hd__fill_2_160 r0 *1 0,0
Xsky130_fd_sc_hd__fill_2_160
+ vss
+ vdd
+ vdd
+ sky130_fd_sc_hd__fill_2
* cell instance sky130_fd_sc_hd__fill_2_161 r0 *1 0,0
Xsky130_fd_sc_hd__fill_2_161
+ vss
+ vdd
+ vdd
+ sky130_fd_sc_hd__fill_2
* cell instance sky130_fd_sc_hd__fill_2_162 r0 *1 0,0
Xsky130_fd_sc_hd__fill_2_162
+ vss
+ vdd
+ vdd
+ sky130_fd_sc_hd__fill_2
* cell instance sky130_fd_sc_hd__fill_2_163 r0 *1 0,0
Xsky130_fd_sc_hd__fill_2_163
+ vss
+ vdd
+ vdd
+ sky130_fd_sc_hd__fill_2
* cell instance sky130_fd_sc_hd__fill_2_164 r0 *1 0,0
Xsky130_fd_sc_hd__fill_2_164
+ vss
+ vdd
+ vdd
+ sky130_fd_sc_hd__fill_2
* cell instance sky130_fd_sc_hd__fill_2_165 r0 *1 0,0
Xsky130_fd_sc_hd__fill_2_165
+ vss
+ vdd
+ vdd
+ sky130_fd_sc_hd__fill_2
* cell instance sky130_fd_sc_hd__fill_2_166 r0 *1 0,0
Xsky130_fd_sc_hd__fill_2_166
+ vss
+ vdd
+ vdd
+ sky130_fd_sc_hd__fill_2
* cell instance sky130_fd_sc_hd__fill_2_167 r0 *1 0,0
Xsky130_fd_sc_hd__fill_2_167
+ vss
+ vdd
+ vdd
+ sky130_fd_sc_hd__fill_2
* cell instance sky130_fd_sc_hd__fill_2_168 r0 *1 0,0
Xsky130_fd_sc_hd__fill_2_168
+ vss
+ vdd
+ vdd
+ sky130_fd_sc_hd__fill_2
* cell instance sky130_fd_sc_hd__fill_2_169 r0 *1 0,0
Xsky130_fd_sc_hd__fill_2_169
+ vss
+ vdd
+ vdd
+ sky130_fd_sc_hd__fill_2
* cell instance sky130_fd_sc_hd__fill_2_170 r0 *1 0,0
Xsky130_fd_sc_hd__fill_2_170
+ vss
+ vdd
+ vdd
+ sky130_fd_sc_hd__fill_2
* cell instance sky130_fd_sc_hd__fill_2_171 r0 *1 0,0
Xsky130_fd_sc_hd__fill_2_171
+ vss
+ vdd
+ vdd
+ sky130_fd_sc_hd__fill_2
* cell instance sky130_fd_sc_hd__fill_2_172 r0 *1 0,0
Xsky130_fd_sc_hd__fill_2_172
+ vss
+ vdd
+ vdd
+ sky130_fd_sc_hd__fill_2
* cell instance sky130_fd_sc_hd__fill_2_173 r0 *1 0,0
Xsky130_fd_sc_hd__fill_2_173
+ vss
+ vdd
+ vdd
+ sky130_fd_sc_hd__fill_2
* cell instance sky130_fd_sc_hd__fill_2_174 r0 *1 0,0
Xsky130_fd_sc_hd__fill_2_174
+ vss
+ vdd
+ vdd
+ sky130_fd_sc_hd__fill_2
* cell instance sky130_fd_sc_hd__fill_2_175 r0 *1 0,0
Xsky130_fd_sc_hd__fill_2_175
+ vss
+ vdd
+ vdd
+ sky130_fd_sc_hd__fill_2
* cell instance sky130_fd_sc_hd__fill_2_176 r0 *1 0,0
Xsky130_fd_sc_hd__fill_2_176
+ vss
+ vdd
+ vdd
+ sky130_fd_sc_hd__fill_2
* cell instance sky130_fd_sc_hd__fill_2_177 r0 *1 0,0
Xsky130_fd_sc_hd__fill_2_177
+ vss
+ vdd
+ vdd
+ sky130_fd_sc_hd__fill_2
* cell instance sky130_fd_sc_hd__fill_2_178 r0 *1 0,0
Xsky130_fd_sc_hd__fill_2_178
+ vss
+ vdd
+ vdd
+ sky130_fd_sc_hd__fill_2
* cell instance sky130_fd_sc_hd__fill_2_179 r0 *1 0,0
Xsky130_fd_sc_hd__fill_2_179
+ vss
+ vdd
+ vdd
+ sky130_fd_sc_hd__fill_2
* cell instance sky130_fd_sc_hd__fill_2_180 r0 *1 0,0
Xsky130_fd_sc_hd__fill_2_180
+ vss
+ vdd
+ vdd
+ sky130_fd_sc_hd__fill_2
* cell instance sky130_fd_sc_hd__fill_2_181 r0 *1 0,0
Xsky130_fd_sc_hd__fill_2_181
+ vss
+ vdd
+ vdd
+ sky130_fd_sc_hd__fill_2
* cell instance sky130_fd_sc_hd__fill_2_182 r0 *1 0,0
Xsky130_fd_sc_hd__fill_2_182
+ vss
+ vdd
+ vdd
+ sky130_fd_sc_hd__fill_2
* cell instance sky130_fd_sc_hd__fill_2_183 r0 *1 0,0
Xsky130_fd_sc_hd__fill_2_183
+ vss
+ vdd
+ vdd
+ sky130_fd_sc_hd__fill_2
* cell instance sky130_fd_sc_hd__fill_2_184 r0 *1 0,0
Xsky130_fd_sc_hd__fill_2_184
+ vss
+ vdd
+ vdd
+ sky130_fd_sc_hd__fill_2
* cell instance sky130_fd_sc_hd__fill_2_185 r0 *1 0,0
Xsky130_fd_sc_hd__fill_2_185
+ vss
+ vdd
+ vdd
+ sky130_fd_sc_hd__fill_2
* cell instance sky130_fd_sc_hd__fill_2_186 r0 *1 0,0
Xsky130_fd_sc_hd__fill_2_186
+ vss
+ vdd
+ vdd
+ sky130_fd_sc_hd__fill_2
* cell instance sky130_fd_sc_hd__fill_2_187 r0 *1 0,0
Xsky130_fd_sc_hd__fill_2_187
+ vss
+ vdd
+ vdd
+ sky130_fd_sc_hd__fill_2
* cell instance sky130_fd_sc_hd__fill_2_188 r0 *1 0,0
Xsky130_fd_sc_hd__fill_2_188
+ vss
+ vdd
+ vdd
+ sky130_fd_sc_hd__fill_2
* cell instance sky130_fd_sc_hd__fill_2_189 r0 *1 0,0
Xsky130_fd_sc_hd__fill_2_189
+ vss
+ vdd
+ vdd
+ sky130_fd_sc_hd__fill_2
* cell instance sky130_fd_sc_hd__fill_2_190 r0 *1 0,0
Xsky130_fd_sc_hd__fill_2_190
+ vss
+ vdd
+ vdd
+ sky130_fd_sc_hd__fill_2
* cell instance sky130_fd_sc_hd__fill_2_191 r0 *1 0,0
Xsky130_fd_sc_hd__fill_2_191
+ vss
+ vdd
+ vdd
+ sky130_fd_sc_hd__fill_2
* cell instance sky130_fd_sc_hd__fill_2_192 r0 *1 0,0
Xsky130_fd_sc_hd__fill_2_192
+ vss
+ vdd
+ vdd
+ sky130_fd_sc_hd__fill_2
* cell instance sky130_fd_sc_hd__fill_2_193 r0 *1 0,0
Xsky130_fd_sc_hd__fill_2_193
+ vss
+ vdd
+ vdd
+ sky130_fd_sc_hd__fill_2
* cell instance sky130_fd_sc_hd__fill_2_194 r0 *1 0,0
Xsky130_fd_sc_hd__fill_2_194
+ vss
+ vdd
+ vdd
+ sky130_fd_sc_hd__fill_2
* cell instance sky130_fd_sc_hd__fill_2_195 r0 *1 0,0
Xsky130_fd_sc_hd__fill_2_195
+ vss
+ vdd
+ vdd
+ sky130_fd_sc_hd__fill_2
* cell instance sky130_fd_sc_hd__fill_2_196 r0 *1 0,0
Xsky130_fd_sc_hd__fill_2_196
+ vss
+ vdd
+ vdd
+ sky130_fd_sc_hd__fill_2
* cell instance sky130_fd_sc_hd__fill_2_197 r0 *1 0,0
Xsky130_fd_sc_hd__fill_2_197
+ vss
+ vdd
+ vdd
+ sky130_fd_sc_hd__fill_2
* cell instance sky130_fd_sc_hd__fill_2_198 r0 *1 0,0
Xsky130_fd_sc_hd__fill_2_198
+ vss
+ vdd
+ vdd
+ sky130_fd_sc_hd__fill_2
* cell instance sky130_fd_sc_hd__fill_2_199 r0 *1 0,0
Xsky130_fd_sc_hd__fill_2_199
+ vss
+ vdd
+ vdd
+ sky130_fd_sc_hd__fill_2
* cell instance sky130_fd_sc_hd__fill_2_200 r0 *1 0,0
Xsky130_fd_sc_hd__fill_2_200
+ vss
+ vdd
+ vdd
+ sky130_fd_sc_hd__fill_2
* cell instance sky130_fd_sc_hd__fill_2_201 r0 *1 0,0
Xsky130_fd_sc_hd__fill_2_201
+ vss
+ vdd
+ vdd
+ sky130_fd_sc_hd__fill_2
* cell instance sky130_fd_sc_hd__fill_2_202 r0 *1 0,0
Xsky130_fd_sc_hd__fill_2_202
+ vss
+ vdd
+ vdd
+ sky130_fd_sc_hd__fill_2
* cell instance sky130_fd_sc_hd__fill_2_203 r0 *1 0,0
Xsky130_fd_sc_hd__fill_2_203
+ vss
+ vdd
+ vdd
+ sky130_fd_sc_hd__fill_2
* cell instance sky130_fd_sc_hd__fill_2_204 r0 *1 0,0
Xsky130_fd_sc_hd__fill_2_204
+ vss
+ vdd
+ vdd
+ sky130_fd_sc_hd__fill_2
* cell instance sky130_fd_sc_hd__fill_2_205 r0 *1 0,0
Xsky130_fd_sc_hd__fill_2_205
+ vss
+ vdd
+ vdd
+ sky130_fd_sc_hd__fill_2
* cell instance sky130_fd_sc_hd__fill_2_206 r0 *1 0,0
Xsky130_fd_sc_hd__fill_2_206
+ vss
+ vdd
+ vdd
+ sky130_fd_sc_hd__fill_2
* cell instance sky130_fd_sc_hd__fill_2_207 r0 *1 0,0
Xsky130_fd_sc_hd__fill_2_207
+ vss
+ vdd
+ vdd
+ sky130_fd_sc_hd__fill_2
* cell instance sky130_fd_sc_hd__fill_2_208 r0 *1 0,0
Xsky130_fd_sc_hd__fill_2_208
+ vss
+ vdd
+ vdd
+ sky130_fd_sc_hd__fill_2
* cell instance sky130_fd_sc_hd__fill_2_209 r0 *1 0,0
Xsky130_fd_sc_hd__fill_2_209
+ vss
+ vdd
+ vdd
+ sky130_fd_sc_hd__fill_2
* cell instance sky130_fd_sc_hd__fill_2_210 r0 *1 0,0
Xsky130_fd_sc_hd__fill_2_210
+ vss
+ vdd
+ vdd
+ sky130_fd_sc_hd__fill_2
* cell instance sky130_fd_sc_hd__fill_2_211 r0 *1 0,0
Xsky130_fd_sc_hd__fill_2_211
+ vss
+ vdd
+ vdd
+ sky130_fd_sc_hd__fill_2
* cell instance sky130_fd_sc_hd__fill_2_212 r0 *1 0,0
Xsky130_fd_sc_hd__fill_2_212
+ vss
+ vdd
+ vdd
+ sky130_fd_sc_hd__fill_2
* cell instance sky130_fd_sc_hd__fill_2_213 r0 *1 0,0
Xsky130_fd_sc_hd__fill_2_213
+ vss
+ vdd
+ vdd
+ sky130_fd_sc_hd__fill_2
* cell instance sky130_fd_sc_hd__fill_2_214 r0 *1 0,0
Xsky130_fd_sc_hd__fill_2_214
+ vss
+ vdd
+ vdd
+ sky130_fd_sc_hd__fill_2
* cell instance sky130_fd_sc_hd__fill_2_215 r0 *1 0,0
Xsky130_fd_sc_hd__fill_2_215
+ vss
+ vdd
+ vdd
+ sky130_fd_sc_hd__fill_2
* cell instance sky130_fd_sc_hd__fill_2_216 r0 *1 0,0
Xsky130_fd_sc_hd__fill_2_216
+ vss
+ vdd
+ vdd
+ sky130_fd_sc_hd__fill_2
* cell instance sky130_fd_sc_hd__fill_2_217 r0 *1 0,0
Xsky130_fd_sc_hd__fill_2_217
+ vss
+ vdd
+ vdd
+ sky130_fd_sc_hd__fill_2
* cell instance sky130_fd_sc_hd__fill_2_218 r0 *1 0,0
Xsky130_fd_sc_hd__fill_2_218
+ vss
+ vdd
+ vdd
+ sky130_fd_sc_hd__fill_2
* cell instance sky130_fd_sc_hd__fill_2_219 r0 *1 0,0
Xsky130_fd_sc_hd__fill_2_219
+ vss
+ vdd
+ vdd
+ sky130_fd_sc_hd__fill_2
* cell instance sky130_fd_sc_hd__fill_2_220 r0 *1 0,0
Xsky130_fd_sc_hd__fill_2_220
+ vss
+ vdd
+ vdd
+ sky130_fd_sc_hd__fill_2
* cell instance sky130_fd_sc_hd__fill_2_221 r0 *1 0,0
Xsky130_fd_sc_hd__fill_2_221
+ vss
+ vdd
+ vdd
+ sky130_fd_sc_hd__fill_2
* cell instance sky130_fd_sc_hd__fill_2_222 r0 *1 0,0
Xsky130_fd_sc_hd__fill_2_222
+ vss
+ vdd
+ vdd
+ sky130_fd_sc_hd__fill_2
* cell instance sky130_fd_sc_hd__fill_2_223 r0 *1 0,0
Xsky130_fd_sc_hd__fill_2_223
+ vss
+ vdd
+ vdd
+ sky130_fd_sc_hd__fill_2
* cell instance sky130_fd_sc_hd__fill_2_224 r0 *1 0,0
Xsky130_fd_sc_hd__fill_2_224
+ vss
+ vdd
+ vdd
+ sky130_fd_sc_hd__fill_2
* cell instance sky130_fd_sc_hd__fill_2_225 r0 *1 0,0
Xsky130_fd_sc_hd__fill_2_225
+ vss
+ vdd
+ vdd
+ sky130_fd_sc_hd__fill_2
* cell instance sky130_fd_sc_hd__fill_2_226 r0 *1 0,0
Xsky130_fd_sc_hd__fill_2_226
+ vss
+ vdd
+ vdd
+ sky130_fd_sc_hd__fill_2
* cell instance sky130_fd_sc_hd__fill_2_227 r0 *1 0,0
Xsky130_fd_sc_hd__fill_2_227
+ vss
+ vdd
+ vdd
+ sky130_fd_sc_hd__fill_2
* cell instance sky130_fd_sc_hd__fill_2_228 r0 *1 0,0
Xsky130_fd_sc_hd__fill_2_228
+ vss
+ vdd
+ vdd
+ sky130_fd_sc_hd__fill_2
* cell instance sky130_fd_sc_hd__fill_2_229 r0 *1 0,0
Xsky130_fd_sc_hd__fill_2_229
+ vss
+ vdd
+ vdd
+ sky130_fd_sc_hd__fill_2
* cell instance sky130_fd_sc_hd__fill_2_230 r0 *1 0,0
Xsky130_fd_sc_hd__fill_2_230
+ vss
+ vdd
+ vdd
+ sky130_fd_sc_hd__fill_2
* cell instance sky130_fd_sc_hd__fill_2_231 r0 *1 0,0
Xsky130_fd_sc_hd__fill_2_231
+ vss
+ vdd
+ vdd
+ sky130_fd_sc_hd__fill_2
* cell instance sky130_fd_sc_hd__fill_2_232 r0 *1 0,0
Xsky130_fd_sc_hd__fill_2_232
+ vss
+ vdd
+ vdd
+ sky130_fd_sc_hd__fill_2
* cell instance sky130_fd_sc_hd__fill_2_233 r0 *1 0,0
Xsky130_fd_sc_hd__fill_2_233
+ vss
+ vdd
+ vdd
+ sky130_fd_sc_hd__fill_2
* cell instance sky130_fd_sc_hd__fill_2_234 r0 *1 0,0
Xsky130_fd_sc_hd__fill_2_234
+ vss
+ vdd
+ vdd
+ sky130_fd_sc_hd__fill_2
* cell instance sky130_fd_sc_hd__fill_2_235 r0 *1 0,0
Xsky130_fd_sc_hd__fill_2_235
+ vss
+ vdd
+ vdd
+ sky130_fd_sc_hd__fill_2
* cell instance sky130_fd_sc_hd__fill_2_236 r0 *1 0,0
Xsky130_fd_sc_hd__fill_2_236
+ vss
+ vdd
+ vdd
+ sky130_fd_sc_hd__fill_2
* cell instance sky130_fd_sc_hd__fill_2_237 r0 *1 0,0
Xsky130_fd_sc_hd__fill_2_237
+ vss
+ vdd
+ vdd
+ sky130_fd_sc_hd__fill_2
* cell instance sky130_fd_sc_hd__fill_2_238 r0 *1 0,0
Xsky130_fd_sc_hd__fill_2_238
+ vss
+ vdd
+ vdd
+ sky130_fd_sc_hd__fill_2
* cell instance sky130_fd_sc_hd__fill_2_239 r0 *1 0,0
Xsky130_fd_sc_hd__fill_2_239
+ vss
+ vdd
+ vdd
+ sky130_fd_sc_hd__fill_2
* cell instance sky130_fd_sc_hd__fill_2_240 r0 *1 0,0
Xsky130_fd_sc_hd__fill_2_240
+ vss
+ vdd
+ vdd
+ sky130_fd_sc_hd__fill_2
* cell instance sky130_fd_sc_hd__fill_2_241 r0 *1 0,0
Xsky130_fd_sc_hd__fill_2_241
+ vss
+ vdd
+ vdd
+ sky130_fd_sc_hd__fill_2
* cell instance sky130_fd_sc_hd__fill_2_242 r0 *1 0,0
Xsky130_fd_sc_hd__fill_2_242
+ vss
+ vdd
+ vdd
+ sky130_fd_sc_hd__fill_2
* cell instance sky130_fd_sc_hd__fill_2_243 r0 *1 0,0
Xsky130_fd_sc_hd__fill_2_243
+ vss
+ vdd
+ vdd
+ sky130_fd_sc_hd__fill_2
* cell instance sky130_fd_sc_hd__fill_2_244 r0 *1 0,0
Xsky130_fd_sc_hd__fill_2_244
+ vss
+ vdd
+ vdd
+ sky130_fd_sc_hd__fill_2
* cell instance sky130_fd_sc_hd__fill_2_245 r0 *1 0,0
Xsky130_fd_sc_hd__fill_2_245
+ vss
+ vdd
+ vdd
+ sky130_fd_sc_hd__fill_2
* cell instance sky130_fd_sc_hd__fill_2_246 r0 *1 0,0
Xsky130_fd_sc_hd__fill_2_246
+ vss
+ vdd
+ vdd
+ sky130_fd_sc_hd__fill_2
* cell instance sky130_fd_sc_hd__fill_2_247 r0 *1 0,0
Xsky130_fd_sc_hd__fill_2_247
+ vss
+ vdd
+ vdd
+ sky130_fd_sc_hd__fill_2
* cell instance sky130_fd_sc_hd__fill_2_248 r0 *1 0,0
Xsky130_fd_sc_hd__fill_2_248
+ vss
+ vdd
+ vdd
+ sky130_fd_sc_hd__fill_2
* cell instance sky130_fd_sc_hd__fill_2_249 r0 *1 0,0
Xsky130_fd_sc_hd__fill_2_249
+ vss
+ vdd
+ vdd
+ sky130_fd_sc_hd__fill_2
* cell instance sky130_fd_sc_hd__fill_2_250 r0 *1 0,0
Xsky130_fd_sc_hd__fill_2_250
+ vss
+ vdd
+ vdd
+ sky130_fd_sc_hd__fill_2
* cell instance sky130_fd_sc_hd__fill_2_251 r0 *1 0,0
Xsky130_fd_sc_hd__fill_2_251
+ vss
+ vdd
+ vdd
+ sky130_fd_sc_hd__fill_2
* cell instance sky130_fd_sc_hd__fill_2_252 r0 *1 0,0
Xsky130_fd_sc_hd__fill_2_252
+ vss
+ vdd
+ vdd
+ sky130_fd_sc_hd__fill_2
* cell instance sky130_fd_sc_hd__fill_2_253 r0 *1 0,0
Xsky130_fd_sc_hd__fill_2_253
+ vss
+ vdd
+ vdd
+ sky130_fd_sc_hd__fill_2
* cell instance sky130_fd_sc_hd__fill_2_254 r0 *1 0,0
Xsky130_fd_sc_hd__fill_2_254
+ vss
+ vdd
+ vdd
+ sky130_fd_sc_hd__fill_2
* cell instance sky130_fd_sc_hd__fill_2_255 r0 *1 0,0
Xsky130_fd_sc_hd__fill_2_255
+ vss
+ vdd
+ vdd
+ sky130_fd_sc_hd__fill_2
* cell instance sky130_fd_sc_hd__fill_2_256 r0 *1 0,0
Xsky130_fd_sc_hd__fill_2_256
+ vss
+ vdd
+ vdd
+ sky130_fd_sc_hd__fill_2
* cell instance sky130_fd_sc_hd__fill_2_257 r0 *1 0,0
Xsky130_fd_sc_hd__fill_2_257
+ vss
+ vdd
+ vdd
+ sky130_fd_sc_hd__fill_2
* cell instance sky130_fd_sc_hd__fill_2_258 r0 *1 0,0
Xsky130_fd_sc_hd__fill_2_258
+ vss
+ vdd
+ vdd
+ sky130_fd_sc_hd__fill_2
* cell instance sky130_fd_sc_hd__fill_2_259 r0 *1 0,0
Xsky130_fd_sc_hd__fill_2_259
+ vss
+ vdd
+ vdd
+ sky130_fd_sc_hd__fill_2
* cell instance sky130_fd_sc_hd__fill_2_260 r0 *1 0,0
Xsky130_fd_sc_hd__fill_2_260
+ vss
+ vdd
+ vdd
+ sky130_fd_sc_hd__fill_2
* cell instance sky130_fd_sc_hd__fill_2_261 r0 *1 0,0
Xsky130_fd_sc_hd__fill_2_261
+ vss
+ vdd
+ vdd
+ sky130_fd_sc_hd__fill_2
* cell instance sky130_fd_sc_hd__fill_2_262 r0 *1 0,0
Xsky130_fd_sc_hd__fill_2_262
+ vss
+ vdd
+ vdd
+ sky130_fd_sc_hd__fill_2
* cell instance sky130_fd_sc_hd__fill_2_263 r0 *1 0,0
Xsky130_fd_sc_hd__fill_2_263
+ vss
+ vdd
+ vdd
+ sky130_fd_sc_hd__fill_2
* cell instance sky130_fd_sc_hd__fill_2_264 r0 *1 0,0
Xsky130_fd_sc_hd__fill_2_264
+ vss
+ vdd
+ vdd
+ sky130_fd_sc_hd__fill_2
* cell instance sky130_fd_sc_hd__fill_2_265 r0 *1 0,0
Xsky130_fd_sc_hd__fill_2_265
+ vss
+ vdd
+ vdd
+ sky130_fd_sc_hd__fill_2
* cell instance sky130_fd_sc_hd__fill_2_266 r0 *1 0,0
Xsky130_fd_sc_hd__fill_2_266
+ vss
+ vdd
+ vdd
+ sky130_fd_sc_hd__fill_2
* cell instance sky130_fd_sc_hd__fill_2_267 r0 *1 0,0
Xsky130_fd_sc_hd__fill_2_267
+ vss
+ vdd
+ vdd
+ sky130_fd_sc_hd__fill_2
* cell instance sky130_fd_sc_hd__fill_2_268 r0 *1 0,0
Xsky130_fd_sc_hd__fill_2_268
+ vss
+ vdd
+ vdd
+ sky130_fd_sc_hd__fill_2
* cell instance sky130_fd_sc_hd__fill_2_269 r0 *1 0,0
Xsky130_fd_sc_hd__fill_2_269
+ vss
+ vdd
+ vdd
+ sky130_fd_sc_hd__fill_2
* cell instance sky130_fd_sc_hd__fill_2_270 r0 *1 0,0
Xsky130_fd_sc_hd__fill_2_270
+ vss
+ vdd
+ vdd
+ sky130_fd_sc_hd__fill_2
* cell instance sky130_fd_sc_hd__fill_2_271 r0 *1 0,0
Xsky130_fd_sc_hd__fill_2_271
+ vss
+ vdd
+ vdd
+ sky130_fd_sc_hd__fill_2
* cell instance sky130_fd_sc_hd__fill_2_272 r0 *1 0,0
Xsky130_fd_sc_hd__fill_2_272
+ vss
+ vdd
+ vdd
+ sky130_fd_sc_hd__fill_2
* cell instance sky130_fd_sc_hd__fill_2_273 r0 *1 0,0
Xsky130_fd_sc_hd__fill_2_273
+ vss
+ vdd
+ vdd
+ sky130_fd_sc_hd__fill_2
* cell instance sky130_fd_sc_hd__fill_2_274 r0 *1 0,0
Xsky130_fd_sc_hd__fill_2_274
+ vss
+ vdd
+ vdd
+ sky130_fd_sc_hd__fill_2
* cell instance sky130_fd_sc_hd__fill_2_275 r0 *1 0,0
Xsky130_fd_sc_hd__fill_2_275
+ vss
+ vdd
+ vdd
+ sky130_fd_sc_hd__fill_2
* cell instance sky130_fd_sc_hd__fill_2_276 r0 *1 0,0
Xsky130_fd_sc_hd__fill_2_276
+ vss
+ vdd
+ vdd
+ sky130_fd_sc_hd__fill_2
* cell instance sky130_fd_sc_hd__fill_2_277 r0 *1 0,0
Xsky130_fd_sc_hd__fill_2_277
+ vss
+ vdd
+ vdd
+ sky130_fd_sc_hd__fill_2
* cell instance sky130_fd_sc_hd__fill_2_278 r0 *1 0,0
Xsky130_fd_sc_hd__fill_2_278
+ vss
+ vdd
+ vdd
+ sky130_fd_sc_hd__fill_2
* cell instance sky130_fd_sc_hd__fill_2_279 r0 *1 0,0
Xsky130_fd_sc_hd__fill_2_279
+ vss
+ vdd
+ vdd
+ sky130_fd_sc_hd__fill_2
* cell instance sky130_fd_sc_hd__fill_2_280 r0 *1 0,0
Xsky130_fd_sc_hd__fill_2_280
+ vss
+ vdd
+ vdd
+ sky130_fd_sc_hd__fill_2
* cell instance sky130_fd_sc_hd__fill_2_281 r0 *1 0,0
Xsky130_fd_sc_hd__fill_2_281
+ vss
+ vdd
+ vdd
+ sky130_fd_sc_hd__fill_2
* cell instance sky130_fd_sc_hd__fill_2_282 r0 *1 0,0
Xsky130_fd_sc_hd__fill_2_282
+ vss
+ vdd
+ vdd
+ sky130_fd_sc_hd__fill_2
* cell instance sky130_fd_sc_hd__fill_2_283 r0 *1 0,0
Xsky130_fd_sc_hd__fill_2_283
+ vss
+ vdd
+ vdd
+ sky130_fd_sc_hd__fill_2
* cell instance sky130_fd_sc_hd__fill_2_284 r0 *1 0,0
Xsky130_fd_sc_hd__fill_2_284
+ vss
+ vdd
+ vdd
+ sky130_fd_sc_hd__fill_2
* cell instance sky130_fd_sc_hd__fill_2_285 r0 *1 0,0
Xsky130_fd_sc_hd__fill_2_285
+ vss
+ vdd
+ vdd
+ sky130_fd_sc_hd__fill_2
* cell instance sky130_fd_sc_hd__fill_2_286 r0 *1 0,0
Xsky130_fd_sc_hd__fill_2_286
+ vss
+ vdd
+ vdd
+ sky130_fd_sc_hd__fill_2
* cell instance sky130_fd_sc_hd__fill_2_287 r0 *1 0,0
Xsky130_fd_sc_hd__fill_2_287
+ vss
+ vdd
+ vdd
+ sky130_fd_sc_hd__fill_2
* cell instance sky130_fd_sc_hd__fill_2_288 r0 *1 0,0
Xsky130_fd_sc_hd__fill_2_288
+ vss
+ vdd
+ vdd
+ sky130_fd_sc_hd__fill_2
* cell instance sky130_fd_sc_hd__fill_2_289 r0 *1 0,0
Xsky130_fd_sc_hd__fill_2_289
+ vss
+ vdd
+ vdd
+ sky130_fd_sc_hd__fill_2
* cell instance sky130_fd_sc_hd__fill_2_290 r0 *1 0,0
Xsky130_fd_sc_hd__fill_2_290
+ vss
+ vdd
+ vdd
+ sky130_fd_sc_hd__fill_2
* cell instance sky130_fd_sc_hd__fill_2_291 r0 *1 0,0
Xsky130_fd_sc_hd__fill_2_291
+ vss
+ vdd
+ vdd
+ sky130_fd_sc_hd__fill_2
* cell instance sky130_fd_sc_hd__fill_2_292 r0 *1 0,0
Xsky130_fd_sc_hd__fill_2_292
+ vss
+ vdd
+ vdd
+ sky130_fd_sc_hd__fill_2
* cell instance sky130_fd_sc_hd__fill_2_293 r0 *1 0,0
Xsky130_fd_sc_hd__fill_2_293
+ vss
+ vdd
+ vdd
+ sky130_fd_sc_hd__fill_2
* cell instance sky130_fd_sc_hd__fill_2_294 r0 *1 0,0
Xsky130_fd_sc_hd__fill_2_294
+ vss
+ vdd
+ vdd
+ sky130_fd_sc_hd__fill_2
* cell instance sky130_fd_sc_hd__fill_2_295 r0 *1 0,0
Xsky130_fd_sc_hd__fill_2_295
+ vss
+ vdd
+ vdd
+ sky130_fd_sc_hd__fill_2
* cell instance sky130_fd_sc_hd__fill_2_296 r0 *1 0,0
Xsky130_fd_sc_hd__fill_2_296
+ vss
+ vdd
+ vdd
+ sky130_fd_sc_hd__fill_2
* cell instance sky130_fd_sc_hd__fill_2_297 r0 *1 0,0
Xsky130_fd_sc_hd__fill_2_297
+ vss
+ vdd
+ vdd
+ sky130_fd_sc_hd__fill_2
* cell instance sky130_fd_sc_hd__fill_2_298 r0 *1 0,0
Xsky130_fd_sc_hd__fill_2_298
+ vss
+ vdd
+ vdd
+ sky130_fd_sc_hd__fill_2
* cell instance sky130_fd_sc_hd__fill_2_299 r0 *1 0,0
Xsky130_fd_sc_hd__fill_2_299
+ vss
+ vdd
+ vdd
+ sky130_fd_sc_hd__fill_2
* cell instance sky130_fd_sc_hd__fill_2_300 r0 *1 0,0
Xsky130_fd_sc_hd__fill_2_300
+ vss
+ vdd
+ vdd
+ sky130_fd_sc_hd__fill_2
* cell instance sky130_fd_sc_hd__fill_2_301 r0 *1 0,0
Xsky130_fd_sc_hd__fill_2_301
+ vss
+ vdd
+ vdd
+ sky130_fd_sc_hd__fill_2
* cell instance sky130_fd_sc_hd__fill_2_302 r0 *1 0,0
Xsky130_fd_sc_hd__fill_2_302
+ vss
+ vdd
+ vdd
+ sky130_fd_sc_hd__fill_2
* cell instance sky130_fd_sc_hd__fill_2_303 r0 *1 0,0
Xsky130_fd_sc_hd__fill_2_303
+ vss
+ vdd
+ vdd
+ sky130_fd_sc_hd__fill_2
* cell instance sky130_fd_sc_hd__fill_2_304 r0 *1 0,0
Xsky130_fd_sc_hd__fill_2_304
+ vss
+ vdd
+ vdd
+ sky130_fd_sc_hd__fill_2
* cell instance sky130_fd_sc_hd__fill_2_305 r0 *1 0,0
Xsky130_fd_sc_hd__fill_2_305
+ vss
+ vdd
+ vdd
+ sky130_fd_sc_hd__fill_2
* cell instance sky130_fd_sc_hd__fill_2_306 r0 *1 0,0
Xsky130_fd_sc_hd__fill_2_306
+ vss
+ vdd
+ vdd
+ sky130_fd_sc_hd__fill_2
* cell instance sky130_fd_sc_hd__fill_2_307 r0 *1 0,0
Xsky130_fd_sc_hd__fill_2_307
+ vss
+ vdd
+ vdd
+ sky130_fd_sc_hd__fill_2
* cell instance sky130_fd_sc_hd__fill_2_308 r0 *1 0,0
Xsky130_fd_sc_hd__fill_2_308
+ vss
+ vdd
+ vdd
+ sky130_fd_sc_hd__fill_2
* cell instance sky130_fd_sc_hd__fill_2_309 r0 *1 0,0
Xsky130_fd_sc_hd__fill_2_309
+ vss
+ vdd
+ vdd
+ sky130_fd_sc_hd__fill_2
* cell instance sky130_fd_sc_hd__fill_2_310 r0 *1 0,0
Xsky130_fd_sc_hd__fill_2_310
+ vss
+ vdd
+ vdd
+ sky130_fd_sc_hd__fill_2
* cell instance sky130_fd_sc_hd__fill_2_311 r0 *1 0,0
Xsky130_fd_sc_hd__fill_2_311
+ vss
+ vdd
+ vdd
+ sky130_fd_sc_hd__fill_2
* cell instance sky130_fd_sc_hd__fill_2_312 r0 *1 0,0
Xsky130_fd_sc_hd__fill_2_312
+ vss
+ vdd
+ vdd
+ sky130_fd_sc_hd__fill_2
* cell instance sky130_fd_sc_hd__fill_2_313 r0 *1 0,0
Xsky130_fd_sc_hd__fill_2_313
+ vss
+ vdd
+ vdd
+ sky130_fd_sc_hd__fill_2
* cell instance sky130_fd_sc_hd__fill_2_314 r0 *1 0,0
Xsky130_fd_sc_hd__fill_2_314
+ vss
+ vdd
+ vdd
+ sky130_fd_sc_hd__fill_2
* cell instance sky130_fd_sc_hd__fill_2_315 r0 *1 0,0
Xsky130_fd_sc_hd__fill_2_315
+ vss
+ vdd
+ vdd
+ sky130_fd_sc_hd__fill_2
* cell instance sky130_fd_sc_hd__fill_2_316 r0 *1 0,0
Xsky130_fd_sc_hd__fill_2_316
+ vss
+ vdd
+ vdd
+ sky130_fd_sc_hd__fill_2
* cell instance sky130_fd_sc_hd__fill_2_317 r0 *1 0,0
Xsky130_fd_sc_hd__fill_2_317
+ vss
+ vdd
+ vdd
+ sky130_fd_sc_hd__fill_2
* cell instance sky130_fd_sc_hd__fill_2_318 r0 *1 0,0
Xsky130_fd_sc_hd__fill_2_318
+ vss
+ vdd
+ vdd
+ sky130_fd_sc_hd__fill_2
* cell instance sky130_fd_sc_hd__fill_2_319 r0 *1 0,0
Xsky130_fd_sc_hd__fill_2_319
+ vss
+ vdd
+ vdd
+ sky130_fd_sc_hd__fill_2
* cell instance sky130_fd_sc_hd__fill_2_320 r0 *1 0,0
Xsky130_fd_sc_hd__fill_2_320
+ vss
+ vdd
+ vdd
+ sky130_fd_sc_hd__fill_2
* cell instance sky130_fd_sc_hd__fill_2_321 r0 *1 0,0
Xsky130_fd_sc_hd__fill_2_321
+ vss
+ vdd
+ vdd
+ sky130_fd_sc_hd__fill_2
* cell instance sky130_fd_sc_hd__fill_2_322 r0 *1 0,0
Xsky130_fd_sc_hd__fill_2_322
+ vss
+ vdd
+ vdd
+ sky130_fd_sc_hd__fill_2
* cell instance sky130_fd_sc_hd__fill_2_323 r0 *1 0,0
Xsky130_fd_sc_hd__fill_2_323
+ vss
+ vdd
+ vdd
+ sky130_fd_sc_hd__fill_2
* cell instance sky130_fd_sc_hd__fill_2_324 r0 *1 0,0
Xsky130_fd_sc_hd__fill_2_324
+ vss
+ vdd
+ vdd
+ sky130_fd_sc_hd__fill_2
* cell instance sky130_fd_sc_hd__fill_2_325 r0 *1 0,0
Xsky130_fd_sc_hd__fill_2_325
+ vss
+ vdd
+ vdd
+ sky130_fd_sc_hd__fill_2
* cell instance sky130_fd_sc_hd__fill_2_326 r0 *1 0,0
Xsky130_fd_sc_hd__fill_2_326
+ vss
+ vdd
+ vdd
+ sky130_fd_sc_hd__fill_2
* cell instance sky130_fd_sc_hd__fill_2_327 r0 *1 0,0
Xsky130_fd_sc_hd__fill_2_327
+ vss
+ vdd
+ vdd
+ sky130_fd_sc_hd__fill_2
* cell instance sky130_fd_sc_hd__fill_2_328 r0 *1 0,0
Xsky130_fd_sc_hd__fill_2_328
+ vss
+ vdd
+ vdd
+ sky130_fd_sc_hd__fill_2
* cell instance sky130_fd_sc_hd__fill_2_329 r0 *1 0,0
Xsky130_fd_sc_hd__fill_2_329
+ vss
+ vdd
+ vdd
+ sky130_fd_sc_hd__fill_2
* cell instance sky130_fd_sc_hd__fill_2_330 r0 *1 0,0
Xsky130_fd_sc_hd__fill_2_330
+ vss
+ vdd
+ vdd
+ sky130_fd_sc_hd__fill_2
* cell instance sky130_fd_sc_hd__fill_2_331 r0 *1 0,0
Xsky130_fd_sc_hd__fill_2_331
+ vss
+ vdd
+ vdd
+ sky130_fd_sc_hd__fill_2
* cell instance sky130_fd_sc_hd__fill_2_332 r0 *1 0,0
Xsky130_fd_sc_hd__fill_2_332
+ vss
+ vdd
+ vdd
+ sky130_fd_sc_hd__fill_2
* cell instance sky130_fd_sc_hd__fill_2_333 r0 *1 0,0
Xsky130_fd_sc_hd__fill_2_333
+ vss
+ vdd
+ vdd
+ sky130_fd_sc_hd__fill_2
* cell instance sky130_fd_sc_hd__fill_2_334 r0 *1 0,0
Xsky130_fd_sc_hd__fill_2_334
+ vss
+ vdd
+ vdd
+ sky130_fd_sc_hd__fill_2
* cell instance sky130_fd_sc_hd__fill_2_335 r0 *1 0,0
Xsky130_fd_sc_hd__fill_2_335
+ vss
+ vdd
+ vdd
+ sky130_fd_sc_hd__fill_2
* cell instance sky130_fd_sc_hd__fill_2_336 r0 *1 0,0
Xsky130_fd_sc_hd__fill_2_336
+ vss
+ vdd
+ vdd
+ sky130_fd_sc_hd__fill_2
* cell instance sky130_fd_sc_hd__fill_2_337 r0 *1 0,0
Xsky130_fd_sc_hd__fill_2_337
+ vss
+ vdd
+ vdd
+ sky130_fd_sc_hd__fill_2
* cell instance sky130_fd_sc_hd__fill_2_338 r0 *1 0,0
Xsky130_fd_sc_hd__fill_2_338
+ vss
+ vdd
+ vdd
+ sky130_fd_sc_hd__fill_2
* cell instance sky130_fd_sc_hd__fill_2_339 r0 *1 0,0
Xsky130_fd_sc_hd__fill_2_339
+ vss
+ vdd
+ vdd
+ sky130_fd_sc_hd__fill_2
* cell instance sky130_fd_sc_hd__fill_2_340 r0 *1 0,0
Xsky130_fd_sc_hd__fill_2_340
+ vss
+ vdd
+ vdd
+ sky130_fd_sc_hd__fill_2
* cell instance sky130_fd_sc_hd__fill_2_341 r0 *1 0,0
Xsky130_fd_sc_hd__fill_2_341
+ vss
+ vdd
+ vdd
+ sky130_fd_sc_hd__fill_2
* cell instance sky130_fd_sc_hd__fill_2_342 r0 *1 0,0
Xsky130_fd_sc_hd__fill_2_342
+ vss
+ vdd
+ vdd
+ sky130_fd_sc_hd__fill_2
* cell instance sky130_fd_sc_hd__fill_2_343 r0 *1 0,0
Xsky130_fd_sc_hd__fill_2_343
+ vss
+ vdd
+ vdd
+ sky130_fd_sc_hd__fill_2
* cell instance sky130_fd_sc_hd__fill_2_344 r0 *1 0,0
Xsky130_fd_sc_hd__fill_2_344
+ vss
+ vdd
+ vdd
+ sky130_fd_sc_hd__fill_2
* cell instance sky130_fd_sc_hd__fill_2_345 r0 *1 0,0
Xsky130_fd_sc_hd__fill_2_345
+ vss
+ vdd
+ vdd
+ sky130_fd_sc_hd__fill_2
* cell instance sky130_fd_sc_hd__fill_2_346 r0 *1 0,0
Xsky130_fd_sc_hd__fill_2_346
+ vss
+ vdd
+ vdd
+ sky130_fd_sc_hd__fill_2
* cell instance sky130_fd_sc_hd__fill_2_347 r0 *1 0,0
Xsky130_fd_sc_hd__fill_2_347
+ vss
+ vdd
+ vdd
+ sky130_fd_sc_hd__fill_2
* cell instance sky130_fd_sc_hd__fill_2_348 r0 *1 0,0
Xsky130_fd_sc_hd__fill_2_348
+ vss
+ vdd
+ vdd
+ sky130_fd_sc_hd__fill_2
* cell instance sky130_fd_sc_hd__fill_2_349 r0 *1 0,0
Xsky130_fd_sc_hd__fill_2_349
+ vss
+ vdd
+ vdd
+ sky130_fd_sc_hd__fill_2
* cell instance sky130_fd_sc_hd__fill_2_350 r0 *1 0,0
Xsky130_fd_sc_hd__fill_2_350
+ vss
+ vdd
+ vdd
+ sky130_fd_sc_hd__fill_2
* cell instance sky130_fd_sc_hd__fill_2_351 r0 *1 0,0
Xsky130_fd_sc_hd__fill_2_351
+ vss
+ vdd
+ vdd
+ sky130_fd_sc_hd__fill_2
* cell instance sky130_fd_sc_hd__fill_2_352 r0 *1 0,0
Xsky130_fd_sc_hd__fill_2_352
+ vss
+ vdd
+ vdd
+ sky130_fd_sc_hd__fill_2
* cell instance sky130_fd_sc_hd__fill_2_353 r0 *1 0,0
Xsky130_fd_sc_hd__fill_2_353
+ vss
+ vdd
+ vdd
+ sky130_fd_sc_hd__fill_2
* cell instance sky130_fd_sc_hd__fill_2_354 r0 *1 0,0
Xsky130_fd_sc_hd__fill_2_354
+ vss
+ vdd
+ vdd
+ sky130_fd_sc_hd__fill_2
* cell instance sky130_fd_sc_hd__fill_2_355 r0 *1 0,0
Xsky130_fd_sc_hd__fill_2_355
+ vss
+ vdd
+ vdd
+ sky130_fd_sc_hd__fill_2
* cell instance sky130_fd_sc_hd__fill_2_356 r0 *1 0,0
Xsky130_fd_sc_hd__fill_2_356
+ vss
+ vdd
+ vdd
+ sky130_fd_sc_hd__fill_2
* cell instance sky130_fd_sc_hd__fill_2_357 r0 *1 0,0
Xsky130_fd_sc_hd__fill_2_357
+ vss
+ vdd
+ vdd
+ sky130_fd_sc_hd__fill_2
* cell instance sky130_fd_sc_hd__fill_2_358 r0 *1 0,0
Xsky130_fd_sc_hd__fill_2_358
+ vss
+ vdd
+ vdd
+ sky130_fd_sc_hd__fill_2
* cell instance sky130_fd_sc_hd__fill_2_359 r0 *1 0,0
Xsky130_fd_sc_hd__fill_2_359
+ vss
+ vdd
+ vdd
+ sky130_fd_sc_hd__fill_2
* cell instance sky130_fd_sc_hd__fill_2_360 r0 *1 0,0
Xsky130_fd_sc_hd__fill_2_360
+ vss
+ vdd
+ vdd
+ sky130_fd_sc_hd__fill_2
* cell instance sky130_fd_sc_hd__fill_2_361 r0 *1 0,0
Xsky130_fd_sc_hd__fill_2_361
+ vss
+ vdd
+ vdd
+ sky130_fd_sc_hd__fill_2
* cell instance sky130_fd_sc_hd__fill_2_362 r0 *1 0,0
Xsky130_fd_sc_hd__fill_2_362
+ vss
+ vdd
+ vdd
+ sky130_fd_sc_hd__fill_2
* cell instance sky130_fd_sc_hd__fill_2_363 r0 *1 0,0
Xsky130_fd_sc_hd__fill_2_363
+ vss
+ vdd
+ vdd
+ sky130_fd_sc_hd__fill_2
* cell instance sky130_fd_sc_hd__fill_2_364 r0 *1 0,0
Xsky130_fd_sc_hd__fill_2_364
+ vss
+ vdd
+ vdd
+ sky130_fd_sc_hd__fill_2
* cell instance sky130_fd_sc_hd__fill_2_365 r0 *1 0,0
Xsky130_fd_sc_hd__fill_2_365
+ vss
+ vdd
+ vdd
+ sky130_fd_sc_hd__fill_2
* cell instance sky130_fd_sc_hd__fill_2_366 r0 *1 0,0
Xsky130_fd_sc_hd__fill_2_366
+ vss
+ vdd
+ vdd
+ sky130_fd_sc_hd__fill_2
* cell instance sky130_fd_sc_hd__fill_2_367 r0 *1 0,0
Xsky130_fd_sc_hd__fill_2_367
+ vss
+ vdd
+ vdd
+ sky130_fd_sc_hd__fill_2
* cell instance sky130_fd_sc_hd__fill_2_368 r0 *1 0,0
Xsky130_fd_sc_hd__fill_2_368
+ vss
+ vdd
+ vdd
+ sky130_fd_sc_hd__fill_2
* cell instance sky130_fd_sc_hd__fill_2_369 r0 *1 0,0
Xsky130_fd_sc_hd__fill_2_369
+ vss
+ vdd
+ vdd
+ sky130_fd_sc_hd__fill_2
* cell instance sky130_fd_sc_hd__fill_2_370 r0 *1 0,0
Xsky130_fd_sc_hd__fill_2_370
+ vss
+ vdd
+ vdd
+ sky130_fd_sc_hd__fill_2
* cell instance sky130_fd_sc_hd__fill_2_371 r0 *1 0,0
Xsky130_fd_sc_hd__fill_2_371
+ vss
+ vdd
+ vdd
+ sky130_fd_sc_hd__fill_2
* cell instance sky130_fd_sc_hd__fill_2_372 r0 *1 0,0
Xsky130_fd_sc_hd__fill_2_372
+ vss
+ vdd
+ vdd
+ sky130_fd_sc_hd__fill_2
* cell instance sky130_fd_sc_hd__fill_2_373 r0 *1 0,0
Xsky130_fd_sc_hd__fill_2_373
+ vss
+ vdd
+ vdd
+ sky130_fd_sc_hd__fill_2
* cell instance sky130_fd_sc_hd__fill_2_374 r0 *1 0,0
Xsky130_fd_sc_hd__fill_2_374
+ vss
+ vdd
+ vdd
+ sky130_fd_sc_hd__fill_2
* cell instance sky130_fd_sc_hd__fill_2_375 r0 *1 0,0
Xsky130_fd_sc_hd__fill_2_375
+ vss
+ vdd
+ vdd
+ sky130_fd_sc_hd__fill_2
* cell instance sky130_fd_sc_hd__fill_2_376 r0 *1 0,0
Xsky130_fd_sc_hd__fill_2_376
+ vss
+ vdd
+ vdd
+ sky130_fd_sc_hd__fill_2
* cell instance sky130_fd_sc_hd__fill_2_377 r0 *1 0,0
Xsky130_fd_sc_hd__fill_2_377
+ vss
+ vdd
+ vdd
+ sky130_fd_sc_hd__fill_2
* cell instance sky130_fd_sc_hd__fill_2_378 r0 *1 0,0
Xsky130_fd_sc_hd__fill_2_378
+ vss
+ vdd
+ vdd
+ sky130_fd_sc_hd__fill_2
* cell instance sky130_fd_sc_hd__fill_2_379 r0 *1 0,0
Xsky130_fd_sc_hd__fill_2_379
+ vss
+ vdd
+ vdd
+ sky130_fd_sc_hd__fill_2
* cell instance sky130_fd_sc_hd__fill_2_380 r0 *1 0,0
Xsky130_fd_sc_hd__fill_2_380
+ vss
+ vdd
+ vdd
+ sky130_fd_sc_hd__fill_2
* cell instance sky130_fd_sc_hd__fill_2_381 r0 *1 0,0
Xsky130_fd_sc_hd__fill_2_381
+ vss
+ vdd
+ vdd
+ sky130_fd_sc_hd__fill_2
* cell instance sky130_fd_sc_hd__fill_2_382 r0 *1 0,0
Xsky130_fd_sc_hd__fill_2_382
+ vss
+ vdd
+ vdd
+ sky130_fd_sc_hd__fill_2
* cell instance sky130_fd_sc_hd__fill_2_383 r0 *1 0,0
Xsky130_fd_sc_hd__fill_2_383
+ vss
+ vdd
+ vdd
+ sky130_fd_sc_hd__fill_2
* cell instance sky130_fd_sc_hd__fill_2_384 r0 *1 0,0
Xsky130_fd_sc_hd__fill_2_384
+ vss
+ vdd
+ vdd
+ sky130_fd_sc_hd__fill_2
* cell instance sky130_fd_sc_hd__fill_2_385 r0 *1 0,0
Xsky130_fd_sc_hd__fill_2_385
+ vss
+ vdd
+ vdd
+ sky130_fd_sc_hd__fill_2
* cell instance sky130_fd_sc_hd__fill_2_386 r0 *1 0,0
Xsky130_fd_sc_hd__fill_2_386
+ vss
+ vdd
+ vdd
+ sky130_fd_sc_hd__fill_2
* cell instance sky130_fd_sc_hd__fill_2_387 r0 *1 0,0
Xsky130_fd_sc_hd__fill_2_387
+ vss
+ vdd
+ vdd
+ sky130_fd_sc_hd__fill_2
* cell instance sky130_fd_sc_hd__fill_2_388 r0 *1 0,0
Xsky130_fd_sc_hd__fill_2_388
+ vss
+ vdd
+ vdd
+ sky130_fd_sc_hd__fill_2
* cell instance sky130_fd_sc_hd__fill_2_389 r0 *1 0,0
Xsky130_fd_sc_hd__fill_2_389
+ vss
+ vdd
+ vdd
+ sky130_fd_sc_hd__fill_2
* cell instance sky130_fd_sc_hd__fill_2_390 r0 *1 0,0
Xsky130_fd_sc_hd__fill_2_390
+ vss
+ vdd
+ vdd
+ sky130_fd_sc_hd__fill_2
* cell instance sky130_fd_sc_hd__fill_2_391 r0 *1 0,0
Xsky130_fd_sc_hd__fill_2_391
+ vss
+ vdd
+ vdd
+ sky130_fd_sc_hd__fill_2
* cell instance sky130_fd_sc_hd__fill_2_392 r0 *1 0,0
Xsky130_fd_sc_hd__fill_2_392
+ vss
+ vdd
+ vdd
+ sky130_fd_sc_hd__fill_2
* cell instance sky130_fd_sc_hd__fill_2_393 r0 *1 0,0
Xsky130_fd_sc_hd__fill_2_393
+ vss
+ vdd
+ vdd
+ sky130_fd_sc_hd__fill_2
* cell instance sky130_fd_sc_hd__fill_2_394 r0 *1 0,0
Xsky130_fd_sc_hd__fill_2_394
+ vss
+ vdd
+ vdd
+ sky130_fd_sc_hd__fill_2
* cell instance sky130_fd_sc_hd__fill_2_395 r0 *1 0,0
Xsky130_fd_sc_hd__fill_2_395
+ vss
+ vdd
+ vdd
+ sky130_fd_sc_hd__fill_2
* cell instance sky130_fd_sc_hd__fill_2_396 r0 *1 0,0
Xsky130_fd_sc_hd__fill_2_396
+ vss
+ vdd
+ vdd
+ sky130_fd_sc_hd__fill_2
* cell instance sky130_fd_sc_hd__fill_2_397 r0 *1 0,0
Xsky130_fd_sc_hd__fill_2_397
+ vss
+ vdd
+ vdd
+ sky130_fd_sc_hd__fill_2
* cell instance sky130_fd_sc_hd__fill_2_398 r0 *1 0,0
Xsky130_fd_sc_hd__fill_2_398
+ vss
+ vdd
+ vdd
+ sky130_fd_sc_hd__fill_2
* cell instance sky130_fd_sc_hd__fill_2_399 r0 *1 0,0
Xsky130_fd_sc_hd__fill_2_399
+ vss
+ vdd
+ vdd
+ sky130_fd_sc_hd__fill_2
* cell instance sky130_fd_sc_hd__fill_2_400 r0 *1 0,0
Xsky130_fd_sc_hd__fill_2_400
+ vss
+ vdd
+ vdd
+ sky130_fd_sc_hd__fill_2
* cell instance sky130_fd_sc_hd__fill_2_401 r0 *1 0,0
Xsky130_fd_sc_hd__fill_2_401
+ vss
+ vdd
+ vdd
+ sky130_fd_sc_hd__fill_2
* cell instance sky130_fd_sc_hd__fill_2_402 r0 *1 0,0
Xsky130_fd_sc_hd__fill_2_402
+ vss
+ vdd
+ vdd
+ sky130_fd_sc_hd__fill_2
* cell instance sky130_fd_sc_hd__fill_2_403 r0 *1 0,0
Xsky130_fd_sc_hd__fill_2_403
+ vss
+ vdd
+ vdd
+ sky130_fd_sc_hd__fill_2
* cell instance sky130_fd_sc_hd__fill_2_404 r0 *1 0,0
Xsky130_fd_sc_hd__fill_2_404
+ vss
+ vdd
+ vdd
+ sky130_fd_sc_hd__fill_2
* cell instance sky130_fd_sc_hd__fill_2_405 r0 *1 0,0
Xsky130_fd_sc_hd__fill_2_405
+ vss
+ vdd
+ vdd
+ sky130_fd_sc_hd__fill_2
* cell instance sky130_fd_sc_hd__fill_2_406 r0 *1 0,0
Xsky130_fd_sc_hd__fill_2_406
+ vss
+ vdd
+ vdd
+ sky130_fd_sc_hd__fill_2
* cell instance sky130_fd_sc_hd__fill_2_407 r0 *1 0,0
Xsky130_fd_sc_hd__fill_2_407
+ vss
+ vdd
+ vdd
+ sky130_fd_sc_hd__fill_2
* cell instance sky130_fd_sc_hd__fill_2_408 r0 *1 0,0
Xsky130_fd_sc_hd__fill_2_408
+ vss
+ vdd
+ vdd
+ sky130_fd_sc_hd__fill_2
* cell instance sky130_fd_sc_hd__fill_2_409 r0 *1 0,0
Xsky130_fd_sc_hd__fill_2_409
+ vss
+ vdd
+ vdd
+ sky130_fd_sc_hd__fill_2
* cell instance sky130_fd_sc_hd__fill_2_410 r0 *1 0,0
Xsky130_fd_sc_hd__fill_2_410
+ vss
+ vdd
+ vdd
+ sky130_fd_sc_hd__fill_2
* cell instance sky130_fd_sc_hd__fill_2_411 r0 *1 0,0
Xsky130_fd_sc_hd__fill_2_411
+ vss
+ vdd
+ vdd
+ sky130_fd_sc_hd__fill_2
* cell instance sky130_fd_sc_hd__fill_2_412 r0 *1 0,0
Xsky130_fd_sc_hd__fill_2_412
+ vss
+ vdd
+ vdd
+ sky130_fd_sc_hd__fill_2
* cell instance sky130_fd_sc_hd__fill_2_413 r0 *1 0,0
Xsky130_fd_sc_hd__fill_2_413
+ vss
+ vdd
+ vdd
+ sky130_fd_sc_hd__fill_2
* cell instance sky130_fd_sc_hd__fill_2_414 r0 *1 0,0
Xsky130_fd_sc_hd__fill_2_414
+ vss
+ vdd
+ vdd
+ sky130_fd_sc_hd__fill_2
* cell instance sky130_fd_sc_hd__fill_2_415 r0 *1 0,0
Xsky130_fd_sc_hd__fill_2_415
+ vss
+ vdd
+ vdd
+ sky130_fd_sc_hd__fill_2
* cell instance sky130_fd_sc_hd__fill_2_416 r0 *1 0,0
Xsky130_fd_sc_hd__fill_2_416
+ vss
+ vdd
+ vdd
+ sky130_fd_sc_hd__fill_2
* cell instance sky130_fd_sc_hd__fill_2_417 r0 *1 0,0
Xsky130_fd_sc_hd__fill_2_417
+ vss
+ vdd
+ vdd
+ sky130_fd_sc_hd__fill_2
* cell instance sky130_fd_sc_hd__fill_2_418 r0 *1 0,0
Xsky130_fd_sc_hd__fill_2_418
+ vss
+ vdd
+ vdd
+ sky130_fd_sc_hd__fill_2
* cell instance sky130_fd_sc_hd__fill_2_419 r0 *1 0,0
Xsky130_fd_sc_hd__fill_2_419
+ vss
+ vdd
+ vdd
+ sky130_fd_sc_hd__fill_2
* cell instance sky130_fd_sc_hd__fill_2_420 r0 *1 0,0
Xsky130_fd_sc_hd__fill_2_420
+ vss
+ vdd
+ vdd
+ sky130_fd_sc_hd__fill_2
* cell instance sky130_fd_sc_hd__fill_2_421 r0 *1 0,0
Xsky130_fd_sc_hd__fill_2_421
+ vss
+ vdd
+ vdd
+ sky130_fd_sc_hd__fill_2
* cell instance sky130_fd_sc_hd__fill_2_422 r0 *1 0,0
Xsky130_fd_sc_hd__fill_2_422
+ vss
+ vdd
+ vdd
+ sky130_fd_sc_hd__fill_2
* cell instance sky130_fd_sc_hd__fill_2_423 r0 *1 0,0
Xsky130_fd_sc_hd__fill_2_423
+ vss
+ vdd
+ vdd
+ sky130_fd_sc_hd__fill_2
* cell instance sky130_fd_sc_hd__fill_2_424 r0 *1 0,0
Xsky130_fd_sc_hd__fill_2_424
+ vss
+ vdd
+ vdd
+ sky130_fd_sc_hd__fill_2
* cell instance sky130_fd_sc_hd__fill_2_425 r0 *1 0,0
Xsky130_fd_sc_hd__fill_2_425
+ vss
+ vdd
+ vdd
+ sky130_fd_sc_hd__fill_2
* cell instance sky130_fd_sc_hd__fill_2_426 r0 *1 0,0
Xsky130_fd_sc_hd__fill_2_426
+ vss
+ vdd
+ vdd
+ sky130_fd_sc_hd__fill_2
* cell instance sky130_fd_sc_hd__fill_2_427 r0 *1 0,0
Xsky130_fd_sc_hd__fill_2_427
+ vss
+ vdd
+ vdd
+ sky130_fd_sc_hd__fill_2
* cell instance sky130_fd_sc_hd__fill_2_428 r0 *1 0,0
Xsky130_fd_sc_hd__fill_2_428
+ vss
+ vdd
+ vdd
+ sky130_fd_sc_hd__fill_2
* cell instance sky130_fd_sc_hd__fill_2_429 r0 *1 0,0
Xsky130_fd_sc_hd__fill_2_429
+ vss
+ vdd
+ vdd
+ sky130_fd_sc_hd__fill_2
* cell instance sky130_fd_sc_hd__fill_2_430 r0 *1 0,0
Xsky130_fd_sc_hd__fill_2_430
+ vss
+ vdd
+ vdd
+ sky130_fd_sc_hd__fill_2
* cell instance sky130_fd_sc_hd__fill_2_431 r0 *1 0,0
Xsky130_fd_sc_hd__fill_2_431
+ vss
+ vdd
+ vdd
+ sky130_fd_sc_hd__fill_2
* cell instance sky130_fd_sc_hd__fill_2_432 r0 *1 0,0
Xsky130_fd_sc_hd__fill_2_432
+ vss
+ vdd
+ vdd
+ sky130_fd_sc_hd__fill_2
* cell instance sky130_fd_sc_hd__fill_2_433 r0 *1 0,0
Xsky130_fd_sc_hd__fill_2_433
+ vss
+ vdd
+ vdd
+ sky130_fd_sc_hd__fill_2
* cell instance sky130_fd_sc_hd__fill_2_434 r0 *1 0,0
Xsky130_fd_sc_hd__fill_2_434
+ vss
+ vdd
+ vdd
+ sky130_fd_sc_hd__fill_2
* cell instance sky130_fd_sc_hd__fill_2_435 r0 *1 0,0
Xsky130_fd_sc_hd__fill_2_435
+ vss
+ vdd
+ vdd
+ sky130_fd_sc_hd__fill_2
* cell instance sky130_fd_sc_hd__fill_2_436 r0 *1 0,0
Xsky130_fd_sc_hd__fill_2_436
+ vss
+ vdd
+ vdd
+ sky130_fd_sc_hd__fill_2
* cell instance sky130_fd_sc_hd__fill_2_437 r0 *1 0,0
Xsky130_fd_sc_hd__fill_2_437
+ vss
+ vdd
+ vdd
+ sky130_fd_sc_hd__fill_2
* cell instance sky130_fd_sc_hd__fill_2_438 r0 *1 0,0
Xsky130_fd_sc_hd__fill_2_438
+ vss
+ vdd
+ vdd
+ sky130_fd_sc_hd__fill_2
* cell instance sky130_fd_sc_hd__fill_2_439 r0 *1 0,0
Xsky130_fd_sc_hd__fill_2_439
+ vss
+ vdd
+ vdd
+ sky130_fd_sc_hd__fill_2
* cell instance sky130_fd_sc_hd__fill_2_440 r0 *1 0,0
Xsky130_fd_sc_hd__fill_2_440
+ vss
+ vdd
+ vdd
+ sky130_fd_sc_hd__fill_2
* cell instance sky130_fd_sc_hd__fill_2_441 r0 *1 0,0
Xsky130_fd_sc_hd__fill_2_441
+ vss
+ vdd
+ vdd
+ sky130_fd_sc_hd__fill_2
* cell instance sky130_fd_sc_hd__fill_2_442 r0 *1 0,0
Xsky130_fd_sc_hd__fill_2_442
+ vss
+ vdd
+ vdd
+ sky130_fd_sc_hd__fill_2
* cell instance sky130_fd_sc_hd__fill_2_443 r0 *1 0,0
Xsky130_fd_sc_hd__fill_2_443
+ vss
+ vdd
+ vdd
+ sky130_fd_sc_hd__fill_2
* cell instance sky130_fd_sc_hd__fill_2_444 r0 *1 0,0
Xsky130_fd_sc_hd__fill_2_444
+ vss
+ vdd
+ vdd
+ sky130_fd_sc_hd__fill_2
* cell instance sky130_fd_sc_hd__fill_2_445 r0 *1 0,0
Xsky130_fd_sc_hd__fill_2_445
+ vss
+ vdd
+ vdd
+ sky130_fd_sc_hd__fill_2
* cell instance sky130_fd_sc_hd__fill_2_446 r0 *1 0,0
Xsky130_fd_sc_hd__fill_2_446
+ vss
+ vdd
+ vdd
+ sky130_fd_sc_hd__fill_2
* cell instance sky130_fd_sc_hd__fill_2_447 r0 *1 0,0
Xsky130_fd_sc_hd__fill_2_447
+ vss
+ vdd
+ vdd
+ sky130_fd_sc_hd__fill_2
* cell instance sky130_fd_sc_hd__fill_2_448 r0 *1 0,0
Xsky130_fd_sc_hd__fill_2_448
+ vss
+ vdd
+ vdd
+ sky130_fd_sc_hd__fill_2
* cell instance sky130_fd_sc_hd__fill_2_449 r0 *1 0,0
Xsky130_fd_sc_hd__fill_2_449
+ vss
+ vdd
+ vdd
+ sky130_fd_sc_hd__fill_2
* cell instance sky130_fd_sc_hd__fill_2_450 r0 *1 0,0
Xsky130_fd_sc_hd__fill_2_450
+ vss
+ vdd
+ vdd
+ sky130_fd_sc_hd__fill_2
* cell instance sky130_fd_sc_hd__fill_2_451 r0 *1 0,0
Xsky130_fd_sc_hd__fill_2_451
+ vss
+ vdd
+ vdd
+ sky130_fd_sc_hd__fill_2
* cell instance sky130_fd_sc_hd__fill_2_452 r0 *1 0,0
Xsky130_fd_sc_hd__fill_2_452
+ vss
+ vdd
+ vdd
+ sky130_fd_sc_hd__fill_2
* cell instance sky130_fd_sc_hd__fill_2_453 r0 *1 0,0
Xsky130_fd_sc_hd__fill_2_453
+ vss
+ vdd
+ vdd
+ sky130_fd_sc_hd__fill_2
* cell instance sky130_fd_sc_hd__fill_2_454 r0 *1 0,0
Xsky130_fd_sc_hd__fill_2_454
+ vss
+ vdd
+ vdd
+ sky130_fd_sc_hd__fill_2
* cell instance sky130_fd_sc_hd__fill_2_455 r0 *1 0,0
Xsky130_fd_sc_hd__fill_2_455
+ vss
+ vdd
+ vdd
+ sky130_fd_sc_hd__fill_2
* cell instance sky130_fd_sc_hd__fill_2_456 r0 *1 0,0
Xsky130_fd_sc_hd__fill_2_456
+ vss
+ vdd
+ vdd
+ sky130_fd_sc_hd__fill_2
* cell instance sky130_fd_sc_hd__fill_2_457 r0 *1 0,0
Xsky130_fd_sc_hd__fill_2_457
+ vss
+ vdd
+ vdd
+ sky130_fd_sc_hd__fill_2
* cell instance sky130_fd_sc_hd__fill_2_458 r0 *1 0,0
Xsky130_fd_sc_hd__fill_2_458
+ vss
+ vdd
+ vdd
+ sky130_fd_sc_hd__fill_2
* cell instance sky130_fd_sc_hd__fill_2_459 r0 *1 0,0
Xsky130_fd_sc_hd__fill_2_459
+ vss
+ vdd
+ vdd
+ sky130_fd_sc_hd__fill_2
* cell instance sky130_fd_sc_hd__fill_2_460 r0 *1 0,0
Xsky130_fd_sc_hd__fill_2_460
+ vss
+ vdd
+ vdd
+ sky130_fd_sc_hd__fill_2
* cell instance sky130_fd_sc_hd__fill_2_461 r0 *1 0,0
Xsky130_fd_sc_hd__fill_2_461
+ vss
+ vdd
+ vdd
+ sky130_fd_sc_hd__fill_2
* cell instance sky130_fd_sc_hd__fill_2_462 r0 *1 0,0
Xsky130_fd_sc_hd__fill_2_462
+ vss
+ vdd
+ vdd
+ sky130_fd_sc_hd__fill_2
* cell instance sky130_fd_sc_hd__fill_2_463 r0 *1 0,0
Xsky130_fd_sc_hd__fill_2_463
+ vss
+ vdd
+ vdd
+ sky130_fd_sc_hd__fill_2
* cell instance sky130_fd_sc_hd__fill_2_464 r0 *1 0,0
Xsky130_fd_sc_hd__fill_2_464
+ vss
+ vdd
+ vdd
+ sky130_fd_sc_hd__fill_2
* cell instance sky130_fd_sc_hd__fill_2_465 r0 *1 0,0
Xsky130_fd_sc_hd__fill_2_465
+ vss
+ vdd
+ vdd
+ sky130_fd_sc_hd__fill_2
* cell instance sky130_fd_sc_hd__fill_2_466 r0 *1 0,0
Xsky130_fd_sc_hd__fill_2_466
+ vss
+ vdd
+ vdd
+ sky130_fd_sc_hd__fill_2
* cell instance sky130_fd_sc_hd__fill_2_467 r0 *1 0,0
Xsky130_fd_sc_hd__fill_2_467
+ vss
+ vdd
+ vdd
+ sky130_fd_sc_hd__fill_2
* cell instance sky130_fd_sc_hd__fill_2_468 r0 *1 0,0
Xsky130_fd_sc_hd__fill_2_468
+ vss
+ vdd
+ vdd
+ sky130_fd_sc_hd__fill_2
* cell instance sky130_fd_sc_hd__fill_2_469 r0 *1 0,0
Xsky130_fd_sc_hd__fill_2_469
+ vss
+ vdd
+ vdd
+ sky130_fd_sc_hd__fill_2
* cell instance sky130_fd_sc_hd__fill_2_470 r0 *1 0,0
Xsky130_fd_sc_hd__fill_2_470
+ vss
+ vdd
+ vdd
+ sky130_fd_sc_hd__fill_2
* cell instance sky130_fd_sc_hd__fill_2_471 r0 *1 0,0
Xsky130_fd_sc_hd__fill_2_471
+ vss
+ vdd
+ vdd
+ sky130_fd_sc_hd__fill_2
* cell instance sky130_fd_sc_hd__fill_2_472 r0 *1 0,0
Xsky130_fd_sc_hd__fill_2_472
+ vss
+ vdd
+ vdd
+ sky130_fd_sc_hd__fill_2
* cell instance sky130_fd_sc_hd__fill_2_473 r0 *1 0,0
Xsky130_fd_sc_hd__fill_2_473
+ vss
+ vdd
+ vdd
+ sky130_fd_sc_hd__fill_2
* cell instance sky130_fd_sc_hd__fill_2_474 r0 *1 0,0
Xsky130_fd_sc_hd__fill_2_474
+ vss
+ vdd
+ vdd
+ sky130_fd_sc_hd__fill_2
* cell instance sky130_fd_sc_hd__fill_2_475 r0 *1 0,0
Xsky130_fd_sc_hd__fill_2_475
+ vss
+ vdd
+ vdd
+ sky130_fd_sc_hd__fill_2
* cell instance sky130_fd_sc_hd__fill_2_476 r0 *1 0,0
Xsky130_fd_sc_hd__fill_2_476
+ vss
+ vdd
+ vdd
+ sky130_fd_sc_hd__fill_2
* cell instance sky130_fd_sc_hd__fill_2_477 r0 *1 0,0
Xsky130_fd_sc_hd__fill_2_477
+ vss
+ vdd
+ vdd
+ sky130_fd_sc_hd__fill_2
* cell instance sky130_fd_sc_hd__fill_2_478 r0 *1 0,0
Xsky130_fd_sc_hd__fill_2_478
+ vss
+ vdd
+ vdd
+ sky130_fd_sc_hd__fill_2
* cell instance sky130_fd_sc_hd__fill_2_479 r0 *1 0,0
Xsky130_fd_sc_hd__fill_2_479
+ vss
+ vdd
+ vdd
+ sky130_fd_sc_hd__fill_2
* cell instance sky130_fd_sc_hd__fill_2_480 r0 *1 0,0
Xsky130_fd_sc_hd__fill_2_480
+ vss
+ vdd
+ vdd
+ sky130_fd_sc_hd__fill_2
* cell instance sky130_fd_sc_hd__fill_2_481 r0 *1 0,0
Xsky130_fd_sc_hd__fill_2_481
+ vss
+ vdd
+ vdd
+ sky130_fd_sc_hd__fill_2
* cell instance sky130_fd_sc_hd__fill_2_482 r0 *1 0,0
Xsky130_fd_sc_hd__fill_2_482
+ vss
+ vdd
+ vdd
+ sky130_fd_sc_hd__fill_2
* cell instance sky130_fd_sc_hd__fill_2_483 r0 *1 0,0
Xsky130_fd_sc_hd__fill_2_483
+ vss
+ vdd
+ vdd
+ sky130_fd_sc_hd__fill_2
* cell instance sky130_fd_sc_hd__fill_2_484 r0 *1 0,0
Xsky130_fd_sc_hd__fill_2_484
+ vss
+ vdd
+ vdd
+ sky130_fd_sc_hd__fill_2
* cell instance sky130_fd_sc_hd__fill_2_485 r0 *1 0,0
Xsky130_fd_sc_hd__fill_2_485
+ vss
+ vdd
+ vdd
+ sky130_fd_sc_hd__fill_2
* cell instance sky130_fd_sc_hd__fill_2_486 r0 *1 0,0
Xsky130_fd_sc_hd__fill_2_486
+ vss
+ vdd
+ vdd
+ sky130_fd_sc_hd__fill_2
* cell instance sky130_fd_sc_hd__fill_2_487 r0 *1 0,0
Xsky130_fd_sc_hd__fill_2_487
+ vss
+ vdd
+ vdd
+ sky130_fd_sc_hd__fill_2
* cell instance sky130_fd_sc_hd__fill_2_488 r0 *1 0,0
Xsky130_fd_sc_hd__fill_2_488
+ vss
+ vdd
+ vdd
+ sky130_fd_sc_hd__fill_2
* cell instance sky130_fd_sc_hd__fill_2_489 r0 *1 0,0
Xsky130_fd_sc_hd__fill_2_489
+ vss
+ vdd
+ vdd
+ sky130_fd_sc_hd__fill_2
* cell instance sky130_fd_sc_hd__fill_2_490 r0 *1 0,0
Xsky130_fd_sc_hd__fill_2_490
+ vss
+ vdd
+ vdd
+ sky130_fd_sc_hd__fill_2
* cell instance sky130_fd_sc_hd__fill_2_491 r0 *1 0,0
Xsky130_fd_sc_hd__fill_2_491
+ vss
+ vdd
+ vdd
+ sky130_fd_sc_hd__fill_2
* cell instance sky130_fd_sc_hd__fill_2_492 r0 *1 0,0
Xsky130_fd_sc_hd__fill_2_492
+ vss
+ vdd
+ vdd
+ sky130_fd_sc_hd__fill_2
* cell instance sky130_fd_sc_hd__fill_2_493 r0 *1 0,0
Xsky130_fd_sc_hd__fill_2_493
+ vss
+ vdd
+ vdd
+ sky130_fd_sc_hd__fill_2
* cell instance sky130_fd_sc_hd__fill_2_494 r0 *1 0,0
Xsky130_fd_sc_hd__fill_2_494
+ vss
+ vdd
+ vdd
+ sky130_fd_sc_hd__fill_2
* cell instance sky130_fd_sc_hd__fill_2_495 r0 *1 0,0
Xsky130_fd_sc_hd__fill_2_495
+ vss
+ vdd
+ vdd
+ sky130_fd_sc_hd__fill_2
* cell instance sky130_fd_sc_hd__fill_2_496 r0 *1 0,0
Xsky130_fd_sc_hd__fill_2_496
+ vss
+ vdd
+ vdd
+ sky130_fd_sc_hd__fill_2
* cell instance sky130_fd_sc_hd__fill_2_497 r0 *1 0,0
Xsky130_fd_sc_hd__fill_2_497
+ vss
+ vdd
+ vdd
+ sky130_fd_sc_hd__fill_2
* cell instance sky130_fd_sc_hd__fill_2_498 r0 *1 0,0
Xsky130_fd_sc_hd__fill_2_498
+ vss
+ vdd
+ vdd
+ sky130_fd_sc_hd__fill_2
* cell instance sky130_fd_sc_hd__fill_2_499 r0 *1 0,0
Xsky130_fd_sc_hd__fill_2_499
+ vss
+ vdd
+ vdd
+ sky130_fd_sc_hd__fill_2
* cell instance sky130_fd_sc_hd__fill_2_500 r0 *1 0,0
Xsky130_fd_sc_hd__fill_2_500
+ vss
+ vdd
+ vdd
+ sky130_fd_sc_hd__fill_2
* cell instance sky130_fd_sc_hd__fill_2_501 r0 *1 0,0
Xsky130_fd_sc_hd__fill_2_501
+ vss
+ vdd
+ vdd
+ sky130_fd_sc_hd__fill_2
* cell instance sky130_fd_sc_hd__fill_2_502 r0 *1 0,0
Xsky130_fd_sc_hd__fill_2_502
+ vss
+ vdd
+ vdd
+ sky130_fd_sc_hd__fill_2
* cell instance sky130_fd_sc_hd__fill_2_503 r0 *1 0,0
Xsky130_fd_sc_hd__fill_2_503
+ vss
+ vdd
+ vdd
+ sky130_fd_sc_hd__fill_2
* cell instance sky130_fd_sc_hd__fill_2_504 r0 *1 0,0
Xsky130_fd_sc_hd__fill_2_504
+ vss
+ vdd
+ vdd
+ sky130_fd_sc_hd__fill_2
* cell instance sky130_fd_sc_hd__fill_2_505 r0 *1 0,0
Xsky130_fd_sc_hd__fill_2_505
+ vss
+ vdd
+ vdd
+ sky130_fd_sc_hd__fill_2
* cell instance sky130_fd_sc_hd__fill_2_506 r0 *1 0,0
Xsky130_fd_sc_hd__fill_2_506
+ vss
+ vdd
+ vdd
+ sky130_fd_sc_hd__fill_2
* cell instance sky130_fd_sc_hd__fill_2_507 r0 *1 0,0
Xsky130_fd_sc_hd__fill_2_507
+ vss
+ vdd
+ vdd
+ sky130_fd_sc_hd__fill_2
* cell instance sky130_fd_sc_hd__fill_2_508 r0 *1 0,0
Xsky130_fd_sc_hd__fill_2_508
+ vss
+ vdd
+ vdd
+ sky130_fd_sc_hd__fill_2
* cell instance sky130_fd_sc_hd__fill_2_509 r0 *1 0,0
Xsky130_fd_sc_hd__fill_2_509
+ vss
+ vdd
+ vdd
+ sky130_fd_sc_hd__fill_2
* cell instance sky130_fd_sc_hd__fill_2_510 r0 *1 0,0
Xsky130_fd_sc_hd__fill_2_510
+ vss
+ vdd
+ vdd
+ sky130_fd_sc_hd__fill_2
* cell instance sky130_fd_sc_hd__fill_2_511 r0 *1 0,0
Xsky130_fd_sc_hd__fill_2_511
+ vss
+ vdd
+ vdd
+ sky130_fd_sc_hd__fill_2
* cell instance sky130_fd_sc_hd__fill_2_512 r0 *1 0,0
Xsky130_fd_sc_hd__fill_2_512
+ vss
+ vdd
+ vdd
+ sky130_fd_sc_hd__fill_2
* cell instance sky130_fd_sc_hd__fill_2_513 r0 *1 0,0
Xsky130_fd_sc_hd__fill_2_513
+ vss
+ vdd
+ vdd
+ sky130_fd_sc_hd__fill_2
* cell instance sky130_fd_sc_hd__fill_2_514 r0 *1 0,0
Xsky130_fd_sc_hd__fill_2_514
+ vss
+ vdd
+ vdd
+ sky130_fd_sc_hd__fill_2
* cell instance sky130_fd_sc_hd__fill_2_515 r0 *1 0,0
Xsky130_fd_sc_hd__fill_2_515
+ vss
+ vdd
+ vdd
+ sky130_fd_sc_hd__fill_2
* cell instance sky130_fd_sc_hd__fill_2_516 r0 *1 0,0
Xsky130_fd_sc_hd__fill_2_516
+ vss
+ vdd
+ vdd
+ sky130_fd_sc_hd__fill_2
* cell instance sky130_fd_sc_hd__fill_2_517 r0 *1 0,0
Xsky130_fd_sc_hd__fill_2_517
+ vss
+ vdd
+ vdd
+ sky130_fd_sc_hd__fill_2
* cell instance sky130_fd_sc_hd__fill_2_518 r0 *1 0,0
Xsky130_fd_sc_hd__fill_2_518
+ vss
+ vdd
+ vdd
+ sky130_fd_sc_hd__fill_2
* cell instance sky130_fd_sc_hd__fill_2_519 r0 *1 0,0
Xsky130_fd_sc_hd__fill_2_519
+ vss
+ vdd
+ vdd
+ sky130_fd_sc_hd__fill_2
* cell instance sky130_fd_sc_hd__fill_2_520 r0 *1 0,0
Xsky130_fd_sc_hd__fill_2_520
+ vss
+ vdd
+ vdd
+ sky130_fd_sc_hd__fill_2
* cell instance sky130_fd_sc_hd__fill_2_521 r0 *1 0,0
Xsky130_fd_sc_hd__fill_2_521
+ vss
+ vdd
+ vdd
+ sky130_fd_sc_hd__fill_2
* cell instance sky130_fd_sc_hd__fill_2_522 r0 *1 0,0
Xsky130_fd_sc_hd__fill_2_522
+ vss
+ vdd
+ vdd
+ sky130_fd_sc_hd__fill_2
* cell instance sky130_fd_sc_hd__fill_2_523 r0 *1 0,0
Xsky130_fd_sc_hd__fill_2_523
+ vss
+ vdd
+ vdd
+ sky130_fd_sc_hd__fill_2
* cell instance sky130_fd_sc_hd__fill_2_524 r0 *1 0,0
Xsky130_fd_sc_hd__fill_2_524
+ vss
+ vdd
+ vdd
+ sky130_fd_sc_hd__fill_2
* cell instance sky130_fd_sc_hd__fill_2_525 r0 *1 0,0
Xsky130_fd_sc_hd__fill_2_525
+ vss
+ vdd
+ vdd
+ sky130_fd_sc_hd__fill_2
* cell instance sky130_fd_sc_hd__fill_2_526 r0 *1 0,0
Xsky130_fd_sc_hd__fill_2_526
+ vss
+ vdd
+ vdd
+ sky130_fd_sc_hd__fill_2
* cell instance sky130_fd_sc_hd__fill_2_527 r0 *1 0,0
Xsky130_fd_sc_hd__fill_2_527
+ vss
+ vdd
+ vdd
+ sky130_fd_sc_hd__fill_2
* cell instance sky130_fd_sc_hd__fill_2_528 r0 *1 0,0
Xsky130_fd_sc_hd__fill_2_528
+ vss
+ vdd
+ vdd
+ sky130_fd_sc_hd__fill_2
* cell instance sky130_fd_sc_hd__fill_2_529 r0 *1 0,0
Xsky130_fd_sc_hd__fill_2_529
+ vss
+ vdd
+ vdd
+ sky130_fd_sc_hd__fill_2
* cell instance sky130_fd_sc_hd__fill_2_530 r0 *1 0,0
Xsky130_fd_sc_hd__fill_2_530
+ vss
+ vdd
+ vdd
+ sky130_fd_sc_hd__fill_2
* cell instance sky130_fd_sc_hd__fill_2_531 r0 *1 0,0
Xsky130_fd_sc_hd__fill_2_531
+ vss
+ vdd
+ vdd
+ sky130_fd_sc_hd__fill_2
* cell instance sky130_fd_sc_hd__fill_2_532 r0 *1 0,0
Xsky130_fd_sc_hd__fill_2_532
+ vss
+ vdd
+ vdd
+ sky130_fd_sc_hd__fill_2
* cell instance sky130_fd_sc_hd__fill_2_533 r0 *1 0,0
Xsky130_fd_sc_hd__fill_2_533
+ vss
+ vdd
+ vdd
+ sky130_fd_sc_hd__fill_2
* cell instance sky130_fd_sc_hd__fill_2_534 r0 *1 0,0
Xsky130_fd_sc_hd__fill_2_534
+ vss
+ vdd
+ vdd
+ sky130_fd_sc_hd__fill_2
* cell instance sky130_fd_sc_hd__fill_2_535 r0 *1 0,0
Xsky130_fd_sc_hd__fill_2_535
+ vss
+ vdd
+ vdd
+ sky130_fd_sc_hd__fill_2
* cell instance sky130_fd_sc_hd__fill_2_536 r0 *1 0,0
Xsky130_fd_sc_hd__fill_2_536
+ vss
+ vdd
+ vdd
+ sky130_fd_sc_hd__fill_2
* cell instance sky130_fd_sc_hd__fill_2_537 r0 *1 0,0
Xsky130_fd_sc_hd__fill_2_537
+ vss
+ vdd
+ vdd
+ sky130_fd_sc_hd__fill_2
* cell instance sky130_fd_sc_hd__fill_2_538 r0 *1 0,0
Xsky130_fd_sc_hd__fill_2_538
+ vss
+ vdd
+ vdd
+ sky130_fd_sc_hd__fill_2
* cell instance sky130_fd_sc_hd__fill_2_539 r0 *1 0,0
Xsky130_fd_sc_hd__fill_2_539
+ vss
+ vdd
+ vdd
+ sky130_fd_sc_hd__fill_2
* cell instance sky130_fd_sc_hd__fill_2_540 r0 *1 0,0
Xsky130_fd_sc_hd__fill_2_540
+ vss
+ vdd
+ vdd
+ sky130_fd_sc_hd__fill_2
* cell instance sky130_fd_sc_hd__fill_2_541 r0 *1 0,0
Xsky130_fd_sc_hd__fill_2_541
+ vss
+ vdd
+ vdd
+ sky130_fd_sc_hd__fill_2
* cell instance sky130_fd_sc_hd__fill_2_542 r0 *1 0,0
Xsky130_fd_sc_hd__fill_2_542
+ vss
+ vdd
+ vdd
+ sky130_fd_sc_hd__fill_2
* cell instance sky130_fd_sc_hd__fill_2_543 r0 *1 0,0
Xsky130_fd_sc_hd__fill_2_543
+ vss
+ vdd
+ vdd
+ sky130_fd_sc_hd__fill_2
* cell instance sky130_fd_sc_hd__fill_2_544 r0 *1 0,0
Xsky130_fd_sc_hd__fill_2_544
+ vss
+ vdd
+ vdd
+ sky130_fd_sc_hd__fill_2
* cell instance sky130_fd_sc_hd__fill_2_545 r0 *1 0,0
Xsky130_fd_sc_hd__fill_2_545
+ vss
+ vdd
+ vdd
+ sky130_fd_sc_hd__fill_2
* cell instance sky130_fd_sc_hd__fill_2_546 r0 *1 0,0
Xsky130_fd_sc_hd__fill_2_546
+ vss
+ vdd
+ vdd
+ sky130_fd_sc_hd__fill_2
* cell instance sky130_fd_sc_hd__fill_2_547 r0 *1 0,0
Xsky130_fd_sc_hd__fill_2_547
+ vss
+ vdd
+ vdd
+ sky130_fd_sc_hd__fill_2
* cell instance sky130_fd_sc_hd__fill_2_548 r0 *1 0,0
Xsky130_fd_sc_hd__fill_2_548
+ vss
+ vdd
+ vdd
+ sky130_fd_sc_hd__fill_2
* cell instance sky130_fd_sc_hd__fill_2_549 r0 *1 0,0
Xsky130_fd_sc_hd__fill_2_549
+ vss
+ vdd
+ vdd
+ sky130_fd_sc_hd__fill_2
* cell instance sky130_fd_sc_hd__fill_2_550 r0 *1 0,0
Xsky130_fd_sc_hd__fill_2_550
+ vss
+ vdd
+ vdd
+ sky130_fd_sc_hd__fill_2
* cell instance sky130_fd_sc_hd__fill_2_551 r0 *1 0,0
Xsky130_fd_sc_hd__fill_2_551
+ vss
+ vdd
+ vdd
+ sky130_fd_sc_hd__fill_2
* cell instance sky130_fd_sc_hd__fill_2_552 r0 *1 0,0
Xsky130_fd_sc_hd__fill_2_552
+ vss
+ vdd
+ vdd
+ sky130_fd_sc_hd__fill_2
* cell instance sky130_fd_sc_hd__fill_2_553 r0 *1 0,0
Xsky130_fd_sc_hd__fill_2_553
+ vss
+ vdd
+ vdd
+ sky130_fd_sc_hd__fill_2
* cell instance sky130_fd_sc_hd__fill_2_554 r0 *1 0,0
Xsky130_fd_sc_hd__fill_2_554
+ vss
+ vdd
+ vdd
+ sky130_fd_sc_hd__fill_2
* cell instance sky130_fd_sc_hd__fill_2_555 r0 *1 0,0
Xsky130_fd_sc_hd__fill_2_555
+ vss
+ vdd
+ vdd
+ sky130_fd_sc_hd__fill_2
* cell instance sky130_fd_sc_hd__fill_2_556 r0 *1 0,0
Xsky130_fd_sc_hd__fill_2_556
+ vss
+ vdd
+ vdd
+ sky130_fd_sc_hd__fill_2
* cell instance sky130_fd_sc_hd__fill_2_557 r0 *1 0,0
Xsky130_fd_sc_hd__fill_2_557
+ vss
+ vdd
+ vdd
+ sky130_fd_sc_hd__fill_2
* cell instance sky130_fd_sc_hd__fill_2_558 r0 *1 0,0
Xsky130_fd_sc_hd__fill_2_558
+ vss
+ vdd
+ vdd
+ sky130_fd_sc_hd__fill_2
* cell instance sky130_fd_sc_hd__fill_2_559 r0 *1 0,0
Xsky130_fd_sc_hd__fill_2_559
+ vss
+ vdd
+ vdd
+ sky130_fd_sc_hd__fill_2
* cell instance sky130_fd_sc_hd__fill_2_560 r0 *1 0,0
Xsky130_fd_sc_hd__fill_2_560
+ vss
+ vdd
+ vdd
+ sky130_fd_sc_hd__fill_2
* cell instance sky130_fd_sc_hd__fill_2_561 r0 *1 0,0
Xsky130_fd_sc_hd__fill_2_561
+ vss
+ vdd
+ vdd
+ sky130_fd_sc_hd__fill_2
* cell instance sky130_fd_sc_hd__fill_2_562 r0 *1 0,0
Xsky130_fd_sc_hd__fill_2_562
+ vss
+ vdd
+ vdd
+ sky130_fd_sc_hd__fill_2
* cell instance sky130_fd_sc_hd__fill_2_563 r0 *1 0,0
Xsky130_fd_sc_hd__fill_2_563
+ vss
+ vdd
+ vdd
+ sky130_fd_sc_hd__fill_2
* cell instance sky130_fd_sc_hd__fill_2_564 r0 *1 0,0
Xsky130_fd_sc_hd__fill_2_564
+ vss
+ vdd
+ vdd
+ sky130_fd_sc_hd__fill_2
* cell instance sky130_fd_sc_hd__fill_2_565 r0 *1 0,0
Xsky130_fd_sc_hd__fill_2_565
+ vss
+ vdd
+ vdd
+ sky130_fd_sc_hd__fill_2
* cell instance sky130_fd_sc_hd__fill_2_566 r0 *1 0,0
Xsky130_fd_sc_hd__fill_2_566
+ vss
+ vdd
+ vdd
+ sky130_fd_sc_hd__fill_2
* cell instance sky130_fd_sc_hd__fill_2_567 r0 *1 0,0
Xsky130_fd_sc_hd__fill_2_567
+ vss
+ vdd
+ vdd
+ sky130_fd_sc_hd__fill_2
* cell instance sky130_fd_sc_hd__fill_2_568 r0 *1 0,0
Xsky130_fd_sc_hd__fill_2_568
+ vss
+ vdd
+ vdd
+ sky130_fd_sc_hd__fill_2
* cell instance sky130_fd_sc_hd__fill_2_569 r0 *1 0,0
Xsky130_fd_sc_hd__fill_2_569
+ vss
+ vdd
+ vdd
+ sky130_fd_sc_hd__fill_2
* cell instance sky130_fd_sc_hd__fill_2_570 r0 *1 0,0
Xsky130_fd_sc_hd__fill_2_570
+ vss
+ vdd
+ vdd
+ sky130_fd_sc_hd__fill_2
* cell instance sky130_fd_sc_hd__fill_2_571 r0 *1 0,0
Xsky130_fd_sc_hd__fill_2_571
+ vss
+ vdd
+ vdd
+ sky130_fd_sc_hd__fill_2
* cell instance sky130_fd_sc_hd__fill_2_572 r0 *1 0,0
Xsky130_fd_sc_hd__fill_2_572
+ vss
+ vdd
+ vdd
+ sky130_fd_sc_hd__fill_2
* cell instance sky130_fd_sc_hd__fill_2_573 r0 *1 0,0
Xsky130_fd_sc_hd__fill_2_573
+ vss
+ vdd
+ vdd
+ sky130_fd_sc_hd__fill_2
* cell instance sky130_fd_sc_hd__fill_2_574 r0 *1 0,0
Xsky130_fd_sc_hd__fill_2_574
+ vss
+ vdd
+ vdd
+ sky130_fd_sc_hd__fill_2
* cell instance sky130_fd_sc_hd__fill_2_575 r0 *1 0,0
Xsky130_fd_sc_hd__fill_2_575
+ vss
+ vdd
+ vdd
+ sky130_fd_sc_hd__fill_2
* cell instance sky130_fd_sc_hd__fill_2_576 r0 *1 0,0
Xsky130_fd_sc_hd__fill_2_576
+ vss
+ vdd
+ vdd
+ sky130_fd_sc_hd__fill_2
* cell instance sky130_fd_sc_hd__fill_2_577 r0 *1 0,0
Xsky130_fd_sc_hd__fill_2_577
+ vss
+ vdd
+ vdd
+ sky130_fd_sc_hd__fill_2
* cell instance sky130_fd_sc_hd__fill_2_578 r0 *1 0,0
Xsky130_fd_sc_hd__fill_2_578
+ vss
+ vdd
+ vdd
+ sky130_fd_sc_hd__fill_2
* cell instance sky130_fd_sc_hd__fill_2_579 r0 *1 0,0
Xsky130_fd_sc_hd__fill_2_579
+ vss
+ vdd
+ vdd
+ sky130_fd_sc_hd__fill_2
* cell instance sky130_fd_sc_hd__fill_2_580 r0 *1 0,0
Xsky130_fd_sc_hd__fill_2_580
+ vss
+ vdd
+ vdd
+ sky130_fd_sc_hd__fill_2
* cell instance sky130_fd_sc_hd__fill_2_581 r0 *1 0,0
Xsky130_fd_sc_hd__fill_2_581
+ vss
+ vdd
+ vdd
+ sky130_fd_sc_hd__fill_2
* cell instance sky130_fd_sc_hd__fill_2_582 r0 *1 0,0
Xsky130_fd_sc_hd__fill_2_582
+ vss
+ vdd
+ vdd
+ sky130_fd_sc_hd__fill_2
* cell instance sky130_fd_sc_hd__fill_2_583 r0 *1 0,0
Xsky130_fd_sc_hd__fill_2_583
+ vss
+ vdd
+ vdd
+ sky130_fd_sc_hd__fill_2
* cell instance sky130_fd_sc_hd__fill_2_584 r0 *1 0,0
Xsky130_fd_sc_hd__fill_2_584
+ vss
+ vdd
+ vdd
+ sky130_fd_sc_hd__fill_2
* cell instance sky130_fd_sc_hd__fill_2_585 r0 *1 0,0
Xsky130_fd_sc_hd__fill_2_585
+ vss
+ vdd
+ vdd
+ sky130_fd_sc_hd__fill_2
* cell instance sky130_fd_sc_hd__fill_2_586 r0 *1 0,0
Xsky130_fd_sc_hd__fill_2_586
+ vss
+ vdd
+ vdd
+ sky130_fd_sc_hd__fill_2
* cell instance sky130_fd_sc_hd__fill_2_587 r0 *1 0,0
Xsky130_fd_sc_hd__fill_2_587
+ vss
+ vdd
+ vdd
+ sky130_fd_sc_hd__fill_2
* cell instance sky130_fd_sc_hd__fill_2_588 r0 *1 0,0
Xsky130_fd_sc_hd__fill_2_588
+ vss
+ vdd
+ vdd
+ sky130_fd_sc_hd__fill_2
* cell instance sky130_fd_sc_hd__fill_2_589 r0 *1 0,0
Xsky130_fd_sc_hd__fill_2_589
+ vss
+ vdd
+ vdd
+ sky130_fd_sc_hd__fill_2
* cell instance sky130_fd_sc_hd__fill_2_590 r0 *1 0,0
Xsky130_fd_sc_hd__fill_2_590
+ vss
+ vdd
+ vdd
+ sky130_fd_sc_hd__fill_2
* cell instance sky130_fd_sc_hd__fill_2_591 r0 *1 0,0
Xsky130_fd_sc_hd__fill_2_591
+ vss
+ vdd
+ vdd
+ sky130_fd_sc_hd__fill_2
* cell instance sky130_fd_sc_hd__fill_2_592 r0 *1 0,0
Xsky130_fd_sc_hd__fill_2_592
+ vss
+ vdd
+ vdd
+ sky130_fd_sc_hd__fill_2
* cell instance sky130_fd_sc_hd__fill_2_593 r0 *1 0,0
Xsky130_fd_sc_hd__fill_2_593
+ vss
+ vdd
+ vdd
+ sky130_fd_sc_hd__fill_2
* cell instance sky130_fd_sc_hd__fill_2_594 r0 *1 0,0
Xsky130_fd_sc_hd__fill_2_594
+ vss
+ vdd
+ vdd
+ sky130_fd_sc_hd__fill_2
* cell instance sky130_fd_sc_hd__fill_2_595 r0 *1 0,0
Xsky130_fd_sc_hd__fill_2_595
+ vss
+ vdd
+ vdd
+ sky130_fd_sc_hd__fill_2
* cell instance sky130_fd_sc_hd__fill_2_596 r0 *1 0,0
Xsky130_fd_sc_hd__fill_2_596
+ vss
+ vdd
+ vdd
+ sky130_fd_sc_hd__fill_2
* cell instance sky130_fd_sc_hd__fill_2_597 r0 *1 0,0
Xsky130_fd_sc_hd__fill_2_597
+ vss
+ vdd
+ vdd
+ sky130_fd_sc_hd__fill_2
* cell instance sky130_fd_sc_hd__fill_2_598 r0 *1 0,0
Xsky130_fd_sc_hd__fill_2_598
+ vss
+ vdd
+ vdd
+ sky130_fd_sc_hd__fill_2
* cell instance sky130_fd_sc_hd__fill_2_599 r0 *1 0,0
Xsky130_fd_sc_hd__fill_2_599
+ vss
+ vdd
+ vdd
+ sky130_fd_sc_hd__fill_2
* cell instance sky130_fd_sc_hd__fill_2_600 r0 *1 0,0
Xsky130_fd_sc_hd__fill_2_600
+ vss
+ vdd
+ vdd
+ sky130_fd_sc_hd__fill_2
* cell instance sky130_fd_sc_hd__fill_2_601 r0 *1 0,0
Xsky130_fd_sc_hd__fill_2_601
+ vss
+ vdd
+ vdd
+ sky130_fd_sc_hd__fill_2
* cell instance sky130_fd_sc_hd__fill_2_602 r0 *1 0,0
Xsky130_fd_sc_hd__fill_2_602
+ vss
+ vdd
+ vdd
+ sky130_fd_sc_hd__fill_2
* cell instance sky130_fd_sc_hd__fill_2_603 r0 *1 0,0
Xsky130_fd_sc_hd__fill_2_603
+ vss
+ vdd
+ vdd
+ sky130_fd_sc_hd__fill_2
* cell instance sky130_fd_sc_hd__fill_2_604 r0 *1 0,0
Xsky130_fd_sc_hd__fill_2_604
+ vss
+ vdd
+ vdd
+ sky130_fd_sc_hd__fill_2
* cell instance sky130_fd_sc_hd__fill_2_605 r0 *1 0,0
Xsky130_fd_sc_hd__fill_2_605
+ vss
+ vdd
+ vdd
+ sky130_fd_sc_hd__fill_2
* cell instance sky130_fd_sc_hd__fill_2_606 r0 *1 0,0
Xsky130_fd_sc_hd__fill_2_606
+ vss
+ vdd
+ vdd
+ sky130_fd_sc_hd__fill_2
* cell instance sky130_fd_sc_hd__fill_2_607 r0 *1 0,0
Xsky130_fd_sc_hd__fill_2_607
+ vss
+ vdd
+ vdd
+ sky130_fd_sc_hd__fill_2
* cell instance sky130_fd_sc_hd__fill_2_608 r0 *1 0,0
Xsky130_fd_sc_hd__fill_2_608
+ vss
+ vdd
+ vdd
+ sky130_fd_sc_hd__fill_2
* cell instance sky130_fd_sc_hd__fill_2_609 r0 *1 0,0
Xsky130_fd_sc_hd__fill_2_609
+ vss
+ vdd
+ vdd
+ sky130_fd_sc_hd__fill_2
* cell instance sky130_fd_sc_hd__fill_2_610 r0 *1 0,0
Xsky130_fd_sc_hd__fill_2_610
+ vss
+ vdd
+ vdd
+ sky130_fd_sc_hd__fill_2
* cell instance sky130_fd_sc_hd__fill_2_611 r0 *1 0,0
Xsky130_fd_sc_hd__fill_2_611
+ vss
+ vdd
+ vdd
+ sky130_fd_sc_hd__fill_2
* cell instance sky130_fd_sc_hd__fill_2_612 r0 *1 0,0
Xsky130_fd_sc_hd__fill_2_612
+ vss
+ vdd
+ vdd
+ sky130_fd_sc_hd__fill_2
* cell instance sky130_fd_sc_hd__fill_2_613 r0 *1 0,0
Xsky130_fd_sc_hd__fill_2_613
+ vss
+ vdd
+ vdd
+ sky130_fd_sc_hd__fill_2
* cell instance sky130_fd_sc_hd__fill_2_614 r0 *1 0,0
Xsky130_fd_sc_hd__fill_2_614
+ vss
+ vdd
+ vdd
+ sky130_fd_sc_hd__fill_2
* cell instance sky130_fd_sc_hd__fill_2_615 r0 *1 0,0
Xsky130_fd_sc_hd__fill_2_615
+ vss
+ vdd
+ vdd
+ sky130_fd_sc_hd__fill_2
* cell instance sky130_fd_sc_hd__fill_2_616 r0 *1 0,0
Xsky130_fd_sc_hd__fill_2_616
+ vss
+ vdd
+ vdd
+ sky130_fd_sc_hd__fill_2
* cell instance sky130_fd_sc_hd__fill_2_617 r0 *1 0,0
Xsky130_fd_sc_hd__fill_2_617
+ vss
+ vdd
+ vdd
+ sky130_fd_sc_hd__fill_2
* cell instance sky130_fd_sc_hd__fill_2_618 r0 *1 0,0
Xsky130_fd_sc_hd__fill_2_618
+ vss
+ vdd
+ vdd
+ sky130_fd_sc_hd__fill_2
* cell instance sky130_fd_sc_hd__fill_2_619 r0 *1 0,0
Xsky130_fd_sc_hd__fill_2_619
+ vss
+ vdd
+ vdd
+ sky130_fd_sc_hd__fill_2
* cell instance sky130_fd_sc_hd__fill_2_620 r0 *1 0,0
Xsky130_fd_sc_hd__fill_2_620
+ vss
+ vdd
+ vdd
+ sky130_fd_sc_hd__fill_2
* cell instance sky130_fd_sc_hd__fill_2_621 r0 *1 0,0
Xsky130_fd_sc_hd__fill_2_621
+ vss
+ vdd
+ vdd
+ sky130_fd_sc_hd__fill_2
* cell instance sky130_fd_sc_hd__fill_2_622 r0 *1 0,0
Xsky130_fd_sc_hd__fill_2_622
+ vss
+ vdd
+ vdd
+ sky130_fd_sc_hd__fill_2
* cell instance sky130_fd_sc_hd__fill_2_623 r0 *1 0,0
Xsky130_fd_sc_hd__fill_2_623
+ vss
+ vdd
+ vdd
+ sky130_fd_sc_hd__fill_2
* cell instance sky130_fd_sc_hd__fill_2_624 r0 *1 0,0
Xsky130_fd_sc_hd__fill_2_624
+ vss
+ vdd
+ vdd
+ sky130_fd_sc_hd__fill_2
* cell instance sky130_fd_sc_hd__fill_2_625 r0 *1 0,0
Xsky130_fd_sc_hd__fill_2_625
+ vss
+ vdd
+ vdd
+ sky130_fd_sc_hd__fill_2
* cell instance sky130_fd_sc_hd__fill_2_626 r0 *1 0,0
Xsky130_fd_sc_hd__fill_2_626
+ vss
+ vdd
+ vdd
+ sky130_fd_sc_hd__fill_2
* cell instance sky130_fd_sc_hd__fill_2_627 r0 *1 0,0
Xsky130_fd_sc_hd__fill_2_627
+ vss
+ vdd
+ vdd
+ sky130_fd_sc_hd__fill_2
* cell instance sky130_fd_sc_hd__fill_2_628 r0 *1 0,0
Xsky130_fd_sc_hd__fill_2_628
+ vss
+ vdd
+ vdd
+ sky130_fd_sc_hd__fill_2
* cell instance sky130_fd_sc_hd__fill_2_629 r0 *1 0,0
Xsky130_fd_sc_hd__fill_2_629
+ vss
+ vdd
+ vdd
+ sky130_fd_sc_hd__fill_2
* cell instance sky130_fd_sc_hd__fill_2_630 r0 *1 0,0
Xsky130_fd_sc_hd__fill_2_630
+ vss
+ vdd
+ vdd
+ sky130_fd_sc_hd__fill_2
* cell instance sky130_fd_sc_hd__fill_2_631 r0 *1 0,0
Xsky130_fd_sc_hd__fill_2_631
+ vss
+ vdd
+ vdd
+ sky130_fd_sc_hd__fill_2
* cell instance sky130_fd_sc_hd__fill_2_632 r0 *1 0,0
Xsky130_fd_sc_hd__fill_2_632
+ vss
+ vdd
+ vdd
+ sky130_fd_sc_hd__fill_2
* cell instance sky130_fd_sc_hd__fill_2_633 r0 *1 0,0
Xsky130_fd_sc_hd__fill_2_633
+ vss
+ vdd
+ vdd
+ sky130_fd_sc_hd__fill_2
* cell instance sky130_fd_sc_hd__fill_2_634 r0 *1 0,0
Xsky130_fd_sc_hd__fill_2_634
+ vss
+ vdd
+ vdd
+ sky130_fd_sc_hd__fill_2
* cell instance sky130_fd_sc_hd__fill_2_635 r0 *1 0,0
Xsky130_fd_sc_hd__fill_2_635
+ vss
+ vdd
+ vdd
+ sky130_fd_sc_hd__fill_2
* cell instance sky130_fd_sc_hd__fill_2_636 r0 *1 0,0
Xsky130_fd_sc_hd__fill_2_636
+ vss
+ vdd
+ vdd
+ sky130_fd_sc_hd__fill_2
* cell instance sky130_fd_sc_hd__fill_2_637 r0 *1 0,0
Xsky130_fd_sc_hd__fill_2_637
+ vss
+ vdd
+ vdd
+ sky130_fd_sc_hd__fill_2
* cell instance sky130_fd_sc_hd__fill_2_638 r0 *1 0,0
Xsky130_fd_sc_hd__fill_2_638
+ vss
+ vdd
+ vdd
+ sky130_fd_sc_hd__fill_2
* cell instance sky130_fd_sc_hd__fill_2_639 r0 *1 0,0
Xsky130_fd_sc_hd__fill_2_639
+ vss
+ vdd
+ vdd
+ sky130_fd_sc_hd__fill_2
* cell instance sky130_fd_sc_hd__fill_2_640 r0 *1 0,0
Xsky130_fd_sc_hd__fill_2_640
+ vss
+ vdd
+ vdd
+ sky130_fd_sc_hd__fill_2
* cell instance sky130_fd_sc_hd__fill_2_641 r0 *1 0,0
Xsky130_fd_sc_hd__fill_2_641
+ vss
+ vdd
+ vdd
+ sky130_fd_sc_hd__fill_2
* cell instance sky130_fd_sc_hd__fill_2_642 r0 *1 0,0
Xsky130_fd_sc_hd__fill_2_642
+ vss
+ vdd
+ vdd
+ sky130_fd_sc_hd__fill_2
* cell instance sky130_fd_sc_hd__fill_2_643 r0 *1 0,0
Xsky130_fd_sc_hd__fill_2_643
+ vss
+ vdd
+ vdd
+ sky130_fd_sc_hd__fill_2
* cell instance sky130_fd_sc_hd__fill_2_644 r0 *1 0,0
Xsky130_fd_sc_hd__fill_2_644
+ vss
+ vdd
+ vdd
+ sky130_fd_sc_hd__fill_2
* cell instance sky130_fd_sc_hd__fill_2_645 r0 *1 0,0
Xsky130_fd_sc_hd__fill_2_645
+ vss
+ vdd
+ vdd
+ sky130_fd_sc_hd__fill_2
* cell instance sky130_fd_sc_hd__fill_2_646 r0 *1 0,0
Xsky130_fd_sc_hd__fill_2_646
+ vss
+ vdd
+ vdd
+ sky130_fd_sc_hd__fill_2
* cell instance sky130_fd_sc_hd__fill_2_647 r0 *1 0,0
Xsky130_fd_sc_hd__fill_2_647
+ vss
+ vdd
+ vdd
+ sky130_fd_sc_hd__fill_2
* cell instance sky130_fd_sc_hd__fill_2_648 r0 *1 0,0
Xsky130_fd_sc_hd__fill_2_648
+ vss
+ vdd
+ vdd
+ sky130_fd_sc_hd__fill_2
* cell instance sky130_fd_sc_hd__fill_2_649 r0 *1 0,0
Xsky130_fd_sc_hd__fill_2_649
+ vss
+ vdd
+ vdd
+ sky130_fd_sc_hd__fill_2
* cell instance sky130_fd_sc_hd__fill_2_650 r0 *1 0,0
Xsky130_fd_sc_hd__fill_2_650
+ vss
+ vdd
+ vdd
+ sky130_fd_sc_hd__fill_2
* cell instance sky130_fd_sc_hd__fill_2_651 r0 *1 0,0
Xsky130_fd_sc_hd__fill_2_651
+ vss
+ vdd
+ vdd
+ sky130_fd_sc_hd__fill_2
* cell instance sky130_fd_sc_hd__fill_2_652 r0 *1 0,0
Xsky130_fd_sc_hd__fill_2_652
+ vss
+ vdd
+ vdd
+ sky130_fd_sc_hd__fill_2
* cell instance sky130_fd_sc_hd__fill_2_653 r0 *1 0,0
Xsky130_fd_sc_hd__fill_2_653
+ vss
+ vdd
+ vdd
+ sky130_fd_sc_hd__fill_2
* cell instance sky130_fd_sc_hd__fill_2_654 r0 *1 0,0
Xsky130_fd_sc_hd__fill_2_654
+ vss
+ vdd
+ vdd
+ sky130_fd_sc_hd__fill_2
* cell instance sky130_fd_sc_hd__fill_2_655 r0 *1 0,0
Xsky130_fd_sc_hd__fill_2_655
+ vss
+ vdd
+ vdd
+ sky130_fd_sc_hd__fill_2
* cell instance sky130_fd_sc_hd__fill_2_656 r0 *1 0,0
Xsky130_fd_sc_hd__fill_2_656
+ vss
+ vdd
+ vdd
+ sky130_fd_sc_hd__fill_2
* cell instance sky130_fd_sc_hd__fill_2_657 r0 *1 0,0
Xsky130_fd_sc_hd__fill_2_657
+ vss
+ vdd
+ vdd
+ sky130_fd_sc_hd__fill_2
* cell instance sky130_fd_sc_hd__fill_2_658 r0 *1 0,0
Xsky130_fd_sc_hd__fill_2_658
+ vss
+ vdd
+ vdd
+ sky130_fd_sc_hd__fill_2
* cell instance sky130_fd_sc_hd__fill_2_659 r0 *1 0,0
Xsky130_fd_sc_hd__fill_2_659
+ vss
+ vdd
+ vdd
+ sky130_fd_sc_hd__fill_2
* cell instance sky130_fd_sc_hd__fill_2_660 r0 *1 0,0
Xsky130_fd_sc_hd__fill_2_660
+ vss
+ vdd
+ vdd
+ sky130_fd_sc_hd__fill_2
* cell instance sky130_fd_sc_hd__fill_2_661 r0 *1 0,0
Xsky130_fd_sc_hd__fill_2_661
+ vss
+ vdd
+ vdd
+ sky130_fd_sc_hd__fill_2
* cell instance sky130_fd_sc_hd__fill_2_662 r0 *1 0,0
Xsky130_fd_sc_hd__fill_2_662
+ vss
+ vdd
+ vdd
+ sky130_fd_sc_hd__fill_2
* cell instance sky130_fd_sc_hd__fill_2_663 r0 *1 0,0
Xsky130_fd_sc_hd__fill_2_663
+ vss
+ vdd
+ vdd
+ sky130_fd_sc_hd__fill_2
* cell instance sky130_fd_sc_hd__fill_2_664 r0 *1 0,0
Xsky130_fd_sc_hd__fill_2_664
+ vss
+ vdd
+ vdd
+ sky130_fd_sc_hd__fill_2
* cell instance sky130_fd_sc_hd__fill_2_665 r0 *1 0,0
Xsky130_fd_sc_hd__fill_2_665
+ vss
+ vdd
+ vdd
+ sky130_fd_sc_hd__fill_2
* cell instance sky130_fd_sc_hd__fill_2_666 r0 *1 0,0
Xsky130_fd_sc_hd__fill_2_666
+ vss
+ vdd
+ vdd
+ sky130_fd_sc_hd__fill_2
* cell instance sky130_fd_sc_hd__fill_2_667 r0 *1 0,0
Xsky130_fd_sc_hd__fill_2_667
+ vss
+ vdd
+ vdd
+ sky130_fd_sc_hd__fill_2
* cell instance sky130_fd_sc_hd__fill_2_668 r0 *1 0,0
Xsky130_fd_sc_hd__fill_2_668
+ vss
+ vdd
+ vdd
+ sky130_fd_sc_hd__fill_2
* cell instance sky130_fd_sc_hd__fill_2_669 r0 *1 0,0
Xsky130_fd_sc_hd__fill_2_669
+ vss
+ vdd
+ vdd
+ sky130_fd_sc_hd__fill_2
* cell instance sky130_fd_sc_hd__fill_2_670 r0 *1 0,0
Xsky130_fd_sc_hd__fill_2_670
+ vss
+ vdd
+ vdd
+ sky130_fd_sc_hd__fill_2
* cell instance sky130_fd_sc_hd__fill_2_671 r0 *1 0,0
Xsky130_fd_sc_hd__fill_2_671
+ vss
+ vdd
+ vdd
+ sky130_fd_sc_hd__fill_2
* cell instance sky130_fd_sc_hd__fill_2_672 r0 *1 0,0
Xsky130_fd_sc_hd__fill_2_672
+ vss
+ vdd
+ vdd
+ sky130_fd_sc_hd__fill_2
* cell instance sky130_fd_sc_hd__fill_2_673 r0 *1 0,0
Xsky130_fd_sc_hd__fill_2_673
+ vss
+ vdd
+ vdd
+ sky130_fd_sc_hd__fill_2
* cell instance sky130_fd_sc_hd__fill_2_674 r0 *1 0,0
Xsky130_fd_sc_hd__fill_2_674
+ vss
+ vdd
+ vdd
+ sky130_fd_sc_hd__fill_2
* cell instance sky130_fd_sc_hd__fill_2_675 r0 *1 0,0
Xsky130_fd_sc_hd__fill_2_675
+ vss
+ vdd
+ vdd
+ sky130_fd_sc_hd__fill_2
* cell instance sky130_fd_sc_hd__fill_2_676 r0 *1 0,0
Xsky130_fd_sc_hd__fill_2_676
+ vss
+ vdd
+ vdd
+ sky130_fd_sc_hd__fill_2
* cell instance sky130_fd_sc_hd__fill_2_677 r0 *1 0,0
Xsky130_fd_sc_hd__fill_2_677
+ vss
+ vdd
+ vdd
+ sky130_fd_sc_hd__fill_2
* cell instance sky130_fd_sc_hd__fill_2_678 r0 *1 0,0
Xsky130_fd_sc_hd__fill_2_678
+ vss
+ vdd
+ vdd
+ sky130_fd_sc_hd__fill_2
* cell instance sky130_fd_sc_hd__fill_2_679 r0 *1 0,0
Xsky130_fd_sc_hd__fill_2_679
+ vss
+ vdd
+ vdd
+ sky130_fd_sc_hd__fill_2
* cell instance sky130_fd_sc_hd__fill_2_680 r0 *1 0,0
Xsky130_fd_sc_hd__fill_2_680
+ vss
+ vdd
+ vdd
+ sky130_fd_sc_hd__fill_2
* cell instance sky130_fd_sc_hd__fill_2_681 r0 *1 0,0
Xsky130_fd_sc_hd__fill_2_681
+ vss
+ vdd
+ vdd
+ sky130_fd_sc_hd__fill_2
* cell instance sky130_fd_sc_hd__fill_2_682 r0 *1 0,0
Xsky130_fd_sc_hd__fill_2_682
+ vss
+ vdd
+ vdd
+ sky130_fd_sc_hd__fill_2
* cell instance sky130_fd_sc_hd__fill_2_683 r0 *1 0,0
Xsky130_fd_sc_hd__fill_2_683
+ vss
+ vdd
+ vdd
+ sky130_fd_sc_hd__fill_2
* cell instance sky130_fd_sc_hd__fill_2_684 r0 *1 0,0
Xsky130_fd_sc_hd__fill_2_684
+ vss
+ vdd
+ vdd
+ sky130_fd_sc_hd__fill_2
* cell instance sky130_fd_sc_hd__fill_2_685 r0 *1 0,0
Xsky130_fd_sc_hd__fill_2_685
+ vss
+ vdd
+ vdd
+ sky130_fd_sc_hd__fill_2
* cell instance sky130_fd_sc_hd__fill_2_686 r0 *1 0,0
Xsky130_fd_sc_hd__fill_2_686
+ vss
+ vdd
+ vdd
+ sky130_fd_sc_hd__fill_2
* cell instance sky130_fd_sc_hd__fill_2_687 r0 *1 0,0
Xsky130_fd_sc_hd__fill_2_687
+ vss
+ vdd
+ vdd
+ sky130_fd_sc_hd__fill_2
* cell instance sky130_fd_sc_hd__fill_2_688 r0 *1 0,0
Xsky130_fd_sc_hd__fill_2_688
+ vss
+ vdd
+ vdd
+ sky130_fd_sc_hd__fill_2
* cell instance sky130_fd_sc_hd__fill_2_689 r0 *1 0,0
Xsky130_fd_sc_hd__fill_2_689
+ vss
+ vdd
+ vdd
+ sky130_fd_sc_hd__fill_2
* cell instance sky130_fd_sc_hd__fill_2_690 r0 *1 0,0
Xsky130_fd_sc_hd__fill_2_690
+ vss
+ vdd
+ vdd
+ sky130_fd_sc_hd__fill_2
* cell instance sky130_fd_sc_hd__fill_2_691 r0 *1 0,0
Xsky130_fd_sc_hd__fill_2_691
+ vss
+ vdd
+ vdd
+ sky130_fd_sc_hd__fill_2
* cell instance sky130_fd_sc_hd__fill_2_692 r0 *1 0,0
Xsky130_fd_sc_hd__fill_2_692
+ vss
+ vdd
+ vdd
+ sky130_fd_sc_hd__fill_2
* cell instance sky130_fd_sc_hd__fill_2_693 r0 *1 0,0
Xsky130_fd_sc_hd__fill_2_693
+ vss
+ vdd
+ vdd
+ sky130_fd_sc_hd__fill_2
* cell instance sky130_fd_sc_hd__fill_2_694 r0 *1 0,0
Xsky130_fd_sc_hd__fill_2_694
+ vss
+ vdd
+ vdd
+ sky130_fd_sc_hd__fill_2
* cell instance sky130_fd_sc_hd__fill_2_695 r0 *1 0,0
Xsky130_fd_sc_hd__fill_2_695
+ vss
+ vdd
+ vdd
+ sky130_fd_sc_hd__fill_2
* cell instance sky130_fd_sc_hd__fill_2_696 r0 *1 0,0
Xsky130_fd_sc_hd__fill_2_696
+ vss
+ vdd
+ vdd
+ sky130_fd_sc_hd__fill_2
* cell instance sky130_fd_sc_hd__fill_2_697 r0 *1 0,0
Xsky130_fd_sc_hd__fill_2_697
+ vss
+ vdd
+ vdd
+ sky130_fd_sc_hd__fill_2
* cell instance sky130_fd_sc_hd__fill_2_698 r0 *1 0,0
Xsky130_fd_sc_hd__fill_2_698
+ vss
+ vdd
+ vdd
+ sky130_fd_sc_hd__fill_2
* cell instance sky130_fd_sc_hd__fill_2_699 r0 *1 0,0
Xsky130_fd_sc_hd__fill_2_699
+ vss
+ vdd
+ vdd
+ sky130_fd_sc_hd__fill_2
* cell instance sky130_fd_sc_hd__fill_2_700 r0 *1 0,0
Xsky130_fd_sc_hd__fill_2_700
+ vss
+ vdd
+ vdd
+ sky130_fd_sc_hd__fill_2
* cell instance sky130_fd_sc_hd__fill_2_701 r0 *1 0,0
Xsky130_fd_sc_hd__fill_2_701
+ vss
+ vdd
+ vdd
+ sky130_fd_sc_hd__fill_2
* cell instance sky130_fd_sc_hd__fill_2_702 r0 *1 0,0
Xsky130_fd_sc_hd__fill_2_702
+ vss
+ vdd
+ vdd
+ sky130_fd_sc_hd__fill_2
* cell instance sky130_fd_sc_hd__fill_2_703 r0 *1 0,0
Xsky130_fd_sc_hd__fill_2_703
+ vss
+ vdd
+ vdd
+ sky130_fd_sc_hd__fill_2
* cell instance sky130_fd_sc_hd__fill_2_704 r0 *1 0,0
Xsky130_fd_sc_hd__fill_2_704
+ vss
+ vdd
+ vdd
+ sky130_fd_sc_hd__fill_2
* cell instance sky130_fd_sc_hd__fill_2_705 r0 *1 0,0
Xsky130_fd_sc_hd__fill_2_705
+ vss
+ vdd
+ vdd
+ sky130_fd_sc_hd__fill_2
* cell instance sky130_fd_sc_hd__fill_2_706 r0 *1 0,0
Xsky130_fd_sc_hd__fill_2_706
+ vss
+ vdd
+ vdd
+ sky130_fd_sc_hd__fill_2
* cell instance sky130_fd_sc_hd__fill_2_707 r0 *1 0,0
Xsky130_fd_sc_hd__fill_2_707
+ vss
+ vdd
+ vdd
+ sky130_fd_sc_hd__fill_2
* cell instance sky130_fd_sc_hd__fill_2_708 r0 *1 0,0
Xsky130_fd_sc_hd__fill_2_708
+ vss
+ vdd
+ vdd
+ sky130_fd_sc_hd__fill_2
* cell instance sky130_fd_sc_hd__fill_2_709 r0 *1 0,0
Xsky130_fd_sc_hd__fill_2_709
+ vss
+ vdd
+ vdd
+ sky130_fd_sc_hd__fill_2
* cell instance sky130_fd_sc_hd__fill_2_710 r0 *1 0,0
Xsky130_fd_sc_hd__fill_2_710
+ vss
+ vdd
+ vdd
+ sky130_fd_sc_hd__fill_2
* cell instance sky130_fd_sc_hd__fill_2_711 r0 *1 0,0
Xsky130_fd_sc_hd__fill_2_711
+ vss
+ vdd
+ vdd
+ sky130_fd_sc_hd__fill_2
* cell instance sky130_fd_sc_hd__fill_2_712 r0 *1 0,0
Xsky130_fd_sc_hd__fill_2_712
+ vss
+ vdd
+ vdd
+ sky130_fd_sc_hd__fill_2
* cell instance sky130_fd_sc_hd__fill_2_713 r0 *1 0,0
Xsky130_fd_sc_hd__fill_2_713
+ vss
+ vdd
+ vdd
+ sky130_fd_sc_hd__fill_2
* cell instance sky130_fd_sc_hd__fill_2_714 r0 *1 0,0
Xsky130_fd_sc_hd__fill_2_714
+ vss
+ vdd
+ vdd
+ sky130_fd_sc_hd__fill_2
* cell instance sky130_fd_sc_hd__fill_2_715 r0 *1 0,0
Xsky130_fd_sc_hd__fill_2_715
+ vss
+ vdd
+ vdd
+ sky130_fd_sc_hd__fill_2
* cell instance sky130_fd_sc_hd__fill_2_716 r0 *1 0,0
Xsky130_fd_sc_hd__fill_2_716
+ vss
+ vdd
+ vdd
+ sky130_fd_sc_hd__fill_2
* cell instance sky130_fd_sc_hd__fill_2_717 r0 *1 0,0
Xsky130_fd_sc_hd__fill_2_717
+ vss
+ vdd
+ vdd
+ sky130_fd_sc_hd__fill_2
* cell instance sky130_fd_sc_hd__fill_2_718 r0 *1 0,0
Xsky130_fd_sc_hd__fill_2_718
+ vss
+ vdd
+ vdd
+ sky130_fd_sc_hd__fill_2
* cell instance sky130_fd_sc_hd__fill_2_719 r0 *1 0,0
Xsky130_fd_sc_hd__fill_2_719
+ vss
+ vdd
+ vdd
+ sky130_fd_sc_hd__fill_2
* cell instance sky130_fd_sc_hd__fill_2_720 r0 *1 0,0
Xsky130_fd_sc_hd__fill_2_720
+ vss
+ vdd
+ vdd
+ sky130_fd_sc_hd__fill_2
* cell instance sky130_fd_sc_hd__fill_2_721 r0 *1 0,0
Xsky130_fd_sc_hd__fill_2_721
+ vss
+ vdd
+ vdd
+ sky130_fd_sc_hd__fill_2
* cell instance sky130_fd_sc_hd__fill_2_722 r0 *1 0,0
Xsky130_fd_sc_hd__fill_2_722
+ vss
+ vdd
+ vdd
+ sky130_fd_sc_hd__fill_2
* cell instance sky130_fd_sc_hd__fill_2_723 r0 *1 0,0
Xsky130_fd_sc_hd__fill_2_723
+ vss
+ vdd
+ vdd
+ sky130_fd_sc_hd__fill_2
* cell instance sky130_fd_sc_hd__fill_2_724 r0 *1 0,0
Xsky130_fd_sc_hd__fill_2_724
+ vss
+ vdd
+ vdd
+ sky130_fd_sc_hd__fill_2
* cell instance sky130_fd_sc_hd__fill_2_725 r0 *1 0,0
Xsky130_fd_sc_hd__fill_2_725
+ vss
+ vdd
+ vdd
+ sky130_fd_sc_hd__fill_2
* cell instance sky130_fd_sc_hd__fill_2_726 r0 *1 0,0
Xsky130_fd_sc_hd__fill_2_726
+ vss
+ vdd
+ vdd
+ sky130_fd_sc_hd__fill_2
* cell instance sky130_fd_sc_hd__fill_2_727 r0 *1 0,0
Xsky130_fd_sc_hd__fill_2_727
+ vss
+ vdd
+ vdd
+ sky130_fd_sc_hd__fill_2
* cell instance sky130_fd_sc_hd__fill_2_728 r0 *1 0,0
Xsky130_fd_sc_hd__fill_2_728
+ vss
+ vdd
+ vdd
+ sky130_fd_sc_hd__fill_2
* cell instance sky130_fd_sc_hd__fill_2_729 r0 *1 0,0
Xsky130_fd_sc_hd__fill_2_729
+ vss
+ vdd
+ vdd
+ sky130_fd_sc_hd__fill_2
* cell instance sky130_fd_sc_hd__fill_2_730 r0 *1 0,0
Xsky130_fd_sc_hd__fill_2_730
+ vss
+ vdd
+ vdd
+ sky130_fd_sc_hd__fill_2
* cell instance sky130_fd_sc_hd__fill_2_731 r0 *1 0,0
Xsky130_fd_sc_hd__fill_2_731
+ vss
+ vdd
+ vdd
+ sky130_fd_sc_hd__fill_2
* cell instance sky130_fd_sc_hd__fill_2_732 r0 *1 0,0
Xsky130_fd_sc_hd__fill_2_732
+ vss
+ vdd
+ vdd
+ sky130_fd_sc_hd__fill_2
* cell instance sky130_fd_sc_hd__fill_2_733 r0 *1 0,0
Xsky130_fd_sc_hd__fill_2_733
+ vss
+ vdd
+ vdd
+ sky130_fd_sc_hd__fill_2
* cell instance sky130_fd_sc_hd__fill_2_734 r0 *1 0,0
Xsky130_fd_sc_hd__fill_2_734
+ vss
+ vdd
+ vdd
+ sky130_fd_sc_hd__fill_2
* cell instance sky130_fd_sc_hd__fill_2_735 r0 *1 0,0
Xsky130_fd_sc_hd__fill_2_735
+ vss
+ vdd
+ vdd
+ sky130_fd_sc_hd__fill_2
* cell instance sky130_fd_sc_hd__fill_2_736 r0 *1 0,0
Xsky130_fd_sc_hd__fill_2_736
+ vss
+ vdd
+ vdd
+ sky130_fd_sc_hd__fill_2
* cell instance sky130_fd_sc_hd__fill_2_737 r0 *1 0,0
Xsky130_fd_sc_hd__fill_2_737
+ vss
+ vdd
+ vdd
+ sky130_fd_sc_hd__fill_2
* cell instance sky130_fd_sc_hd__fill_2_738 r0 *1 0,0
Xsky130_fd_sc_hd__fill_2_738
+ vss
+ vdd
+ vdd
+ sky130_fd_sc_hd__fill_2
* cell instance sky130_fd_sc_hd__fill_2_739 r0 *1 0,0
Xsky130_fd_sc_hd__fill_2_739
+ vss
+ vdd
+ vdd
+ sky130_fd_sc_hd__fill_2
* cell instance sky130_fd_sc_hd__fill_2_740 r0 *1 0,0
Xsky130_fd_sc_hd__fill_2_740
+ vss
+ vdd
+ vdd
+ sky130_fd_sc_hd__fill_2
* cell instance sky130_fd_sc_hd__fill_2_741 r0 *1 0,0
Xsky130_fd_sc_hd__fill_2_741
+ vss
+ vdd
+ vdd
+ sky130_fd_sc_hd__fill_2
* cell instance sky130_fd_sc_hd__fill_2_742 r0 *1 0,0
Xsky130_fd_sc_hd__fill_2_742
+ vss
+ vdd
+ vdd
+ sky130_fd_sc_hd__fill_2
* cell instance sky130_fd_sc_hd__fill_2_743 r0 *1 0,0
Xsky130_fd_sc_hd__fill_2_743
+ vss
+ vdd
+ vdd
+ sky130_fd_sc_hd__fill_2
* cell instance sky130_fd_sc_hd__fill_2_744 r0 *1 0,0
Xsky130_fd_sc_hd__fill_2_744
+ vss
+ vdd
+ vdd
+ sky130_fd_sc_hd__fill_2
* cell instance sky130_fd_sc_hd__fill_2_745 r0 *1 0,0
Xsky130_fd_sc_hd__fill_2_745
+ vss
+ vdd
+ vdd
+ sky130_fd_sc_hd__fill_2
* cell instance sky130_fd_sc_hd__fill_2_746 r0 *1 0,0
Xsky130_fd_sc_hd__fill_2_746
+ vss
+ vdd
+ vdd
+ sky130_fd_sc_hd__fill_2
* cell instance sky130_fd_sc_hd__fill_2_747 r0 *1 0,0
Xsky130_fd_sc_hd__fill_2_747
+ vss
+ vdd
+ vdd
+ sky130_fd_sc_hd__fill_2
* cell instance sky130_fd_sc_hd__fill_2_748 r0 *1 0,0
Xsky130_fd_sc_hd__fill_2_748
+ vss
+ vdd
+ vdd
+ sky130_fd_sc_hd__fill_2
* cell instance sky130_fd_sc_hd__fill_2_749 r0 *1 0,0
Xsky130_fd_sc_hd__fill_2_749
+ vss
+ vdd
+ vdd
+ sky130_fd_sc_hd__fill_2
* cell instance sky130_fd_sc_hd__fill_2_750 r0 *1 0,0
Xsky130_fd_sc_hd__fill_2_750
+ vss
+ vdd
+ vdd
+ sky130_fd_sc_hd__fill_2
* cell instance sky130_fd_sc_hd__fill_2_751 r0 *1 0,0
Xsky130_fd_sc_hd__fill_2_751
+ vss
+ vdd
+ vdd
+ sky130_fd_sc_hd__fill_2
* cell instance sky130_fd_sc_hd__fill_2_752 r0 *1 0,0
Xsky130_fd_sc_hd__fill_2_752
+ vss
+ vdd
+ vdd
+ sky130_fd_sc_hd__fill_2
* cell instance sky130_fd_sc_hd__fill_2_753 r0 *1 0,0
Xsky130_fd_sc_hd__fill_2_753
+ vss
+ vdd
+ vdd
+ sky130_fd_sc_hd__fill_2
* cell instance sky130_fd_sc_hd__fill_2_754 r0 *1 0,0
Xsky130_fd_sc_hd__fill_2_754
+ vss
+ vdd
+ vdd
+ sky130_fd_sc_hd__fill_2
* cell instance sky130_fd_sc_hd__fill_2_755 r0 *1 0,0
Xsky130_fd_sc_hd__fill_2_755
+ vss
+ vdd
+ vdd
+ sky130_fd_sc_hd__fill_2
* cell instance sky130_fd_sc_hd__fill_2_756 r0 *1 0,0
Xsky130_fd_sc_hd__fill_2_756
+ vss
+ vdd
+ vdd
+ sky130_fd_sc_hd__fill_2
* cell instance sky130_fd_sc_hd__fill_2_757 r0 *1 0,0
Xsky130_fd_sc_hd__fill_2_757
+ vss
+ vdd
+ vdd
+ sky130_fd_sc_hd__fill_2
* cell instance sky130_fd_sc_hd__fill_2_758 r0 *1 0,0
Xsky130_fd_sc_hd__fill_2_758
+ vss
+ vdd
+ vdd
+ sky130_fd_sc_hd__fill_2
* cell instance sky130_fd_sc_hd__fill_2_759 r0 *1 0,0
Xsky130_fd_sc_hd__fill_2_759
+ vss
+ vdd
+ vdd
+ sky130_fd_sc_hd__fill_2
* cell instance sky130_fd_sc_hd__fill_2_760 r0 *1 0,0
Xsky130_fd_sc_hd__fill_2_760
+ vss
+ vdd
+ vdd
+ sky130_fd_sc_hd__fill_2
* cell instance sky130_fd_sc_hd__fill_2_761 r0 *1 0,0
Xsky130_fd_sc_hd__fill_2_761
+ vss
+ vdd
+ vdd
+ sky130_fd_sc_hd__fill_2
* cell instance sky130_fd_sc_hd__fill_2_762 r0 *1 0,0
Xsky130_fd_sc_hd__fill_2_762
+ vss
+ vdd
+ vdd
+ sky130_fd_sc_hd__fill_2
* cell instance sky130_fd_sc_hd__fill_2_763 r0 *1 0,0
Xsky130_fd_sc_hd__fill_2_763
+ vss
+ vdd
+ vdd
+ sky130_fd_sc_hd__fill_2
* cell instance sky130_fd_sc_hd__fill_2_764 r0 *1 0,0
Xsky130_fd_sc_hd__fill_2_764
+ vss
+ vdd
+ vdd
+ sky130_fd_sc_hd__fill_2
* cell instance sky130_fd_sc_hd__fill_2_765 r0 *1 0,0
Xsky130_fd_sc_hd__fill_2_765
+ vss
+ vdd
+ vdd
+ sky130_fd_sc_hd__fill_2
* cell instance sky130_fd_sc_hd__fill_2_766 r0 *1 0,0
Xsky130_fd_sc_hd__fill_2_766
+ vss
+ vdd
+ vdd
+ sky130_fd_sc_hd__fill_2
* cell instance sky130_fd_sc_hd__fill_2_767 r0 *1 0,0
Xsky130_fd_sc_hd__fill_2_767
+ vss
+ vdd
+ vdd
+ sky130_fd_sc_hd__fill_2
* cell instance sky130_fd_sc_hd__fill_2_768 r0 *1 0,0
Xsky130_fd_sc_hd__fill_2_768
+ vss
+ vdd
+ vdd
+ sky130_fd_sc_hd__fill_2
* cell instance sky130_fd_sc_hd__fill_2_769 r0 *1 0,0
Xsky130_fd_sc_hd__fill_2_769
+ vss
+ vdd
+ vdd
+ sky130_fd_sc_hd__fill_2
* cell instance sky130_fd_sc_hd__fill_2_770 r0 *1 0,0
Xsky130_fd_sc_hd__fill_2_770
+ vss
+ vdd
+ vdd
+ sky130_fd_sc_hd__fill_2
* cell instance sky130_fd_sc_hd__fill_2_771 r0 *1 0,0
Xsky130_fd_sc_hd__fill_2_771
+ vss
+ vdd
+ vdd
+ sky130_fd_sc_hd__fill_2
* cell instance sky130_fd_sc_hd__fill_2_772 r0 *1 0,0
Xsky130_fd_sc_hd__fill_2_772
+ vss
+ vdd
+ vdd
+ sky130_fd_sc_hd__fill_2
* cell instance sky130_fd_sc_hd__fill_2_773 r0 *1 0,0
Xsky130_fd_sc_hd__fill_2_773
+ vss
+ vdd
+ vdd
+ sky130_fd_sc_hd__fill_2
* cell instance sky130_fd_sc_hd__fill_2_774 r0 *1 0,0
Xsky130_fd_sc_hd__fill_2_774
+ vss
+ vdd
+ vdd
+ sky130_fd_sc_hd__fill_2
* cell instance sky130_fd_sc_hd__fill_2_775 r0 *1 0,0
Xsky130_fd_sc_hd__fill_2_775
+ vss
+ vdd
+ vdd
+ sky130_fd_sc_hd__fill_2
* cell instance sky130_fd_sc_hd__fill_2_776 r0 *1 0,0
Xsky130_fd_sc_hd__fill_2_776
+ vss
+ vdd
+ vdd
+ sky130_fd_sc_hd__fill_2
* cell instance sky130_fd_sc_hd__fill_2_777 r0 *1 0,0
Xsky130_fd_sc_hd__fill_2_777
+ vss
+ vdd
+ vdd
+ sky130_fd_sc_hd__fill_2
* cell instance sky130_fd_sc_hd__fill_2_778 r0 *1 0,0
Xsky130_fd_sc_hd__fill_2_778
+ vss
+ vdd
+ vdd
+ sky130_fd_sc_hd__fill_2
* cell instance sky130_fd_sc_hd__fill_2_779 r0 *1 0,0
Xsky130_fd_sc_hd__fill_2_779
+ vss
+ vdd
+ vdd
+ sky130_fd_sc_hd__fill_2
* cell instance sky130_fd_sc_hd__fill_2_780 r0 *1 0,0
Xsky130_fd_sc_hd__fill_2_780
+ vss
+ vdd
+ vdd
+ sky130_fd_sc_hd__fill_2
* cell instance sky130_fd_sc_hd__fill_2_781 r0 *1 0,0
Xsky130_fd_sc_hd__fill_2_781
+ vss
+ vdd
+ vdd
+ sky130_fd_sc_hd__fill_2
* cell instance sky130_fd_sc_hd__fill_2_782 r0 *1 0,0
Xsky130_fd_sc_hd__fill_2_782
+ vss
+ vdd
+ vdd
+ sky130_fd_sc_hd__fill_2
* cell instance sky130_fd_sc_hd__fill_2_783 r0 *1 0,0
Xsky130_fd_sc_hd__fill_2_783
+ vss
+ vdd
+ vdd
+ sky130_fd_sc_hd__fill_2
* cell instance sky130_fd_sc_hd__fill_2_784 r0 *1 0,0
Xsky130_fd_sc_hd__fill_2_784
+ vss
+ vdd
+ vdd
+ sky130_fd_sc_hd__fill_2
* cell instance sky130_fd_sc_hd__fill_2_785 r0 *1 0,0
Xsky130_fd_sc_hd__fill_2_785
+ vss
+ vdd
+ vdd
+ sky130_fd_sc_hd__fill_2
* cell instance sky130_fd_sc_hd__fill_2_786 r0 *1 0,0
Xsky130_fd_sc_hd__fill_2_786
+ vss
+ vdd
+ vdd
+ sky130_fd_sc_hd__fill_2
* cell instance sky130_fd_sc_hd__fill_2_787 r0 *1 0,0
Xsky130_fd_sc_hd__fill_2_787
+ vss
+ vdd
+ vdd
+ sky130_fd_sc_hd__fill_2
* cell instance sky130_fd_sc_hd__fill_2_788 r0 *1 0,0
Xsky130_fd_sc_hd__fill_2_788
+ vss
+ vdd
+ vdd
+ sky130_fd_sc_hd__fill_2
* cell instance sky130_fd_sc_hd__fill_2_789 r0 *1 0,0
Xsky130_fd_sc_hd__fill_2_789
+ vss
+ vdd
+ vdd
+ sky130_fd_sc_hd__fill_2
* cell instance sky130_fd_sc_hd__fill_2_790 r0 *1 0,0
Xsky130_fd_sc_hd__fill_2_790
+ vss
+ vdd
+ vdd
+ sky130_fd_sc_hd__fill_2
* cell instance sky130_fd_sc_hd__fill_2_791 r0 *1 0,0
Xsky130_fd_sc_hd__fill_2_791
+ vss
+ vdd
+ vdd
+ sky130_fd_sc_hd__fill_2
* cell instance sky130_fd_sc_hd__fill_2_792 r0 *1 0,0
Xsky130_fd_sc_hd__fill_2_792
+ vss
+ vdd
+ vdd
+ sky130_fd_sc_hd__fill_2
* cell instance sky130_fd_sc_hd__fill_2_793 r0 *1 0,0
Xsky130_fd_sc_hd__fill_2_793
+ vss
+ vdd
+ vdd
+ sky130_fd_sc_hd__fill_2
* cell instance sky130_fd_sc_hd__fill_2_794 r0 *1 0,0
Xsky130_fd_sc_hd__fill_2_794
+ vss
+ vdd
+ vdd
+ sky130_fd_sc_hd__fill_2
* cell instance sky130_fd_sc_hd__fill_2_795 r0 *1 0,0
Xsky130_fd_sc_hd__fill_2_795
+ vss
+ vdd
+ vdd
+ sky130_fd_sc_hd__fill_2
* cell instance sky130_fd_sc_hd__fill_2_796 r0 *1 0,0
Xsky130_fd_sc_hd__fill_2_796
+ vss
+ vdd
+ vdd
+ sky130_fd_sc_hd__fill_2
* cell instance sky130_fd_sc_hd__fill_2_797 r0 *1 0,0
Xsky130_fd_sc_hd__fill_2_797
+ vss
+ vdd
+ vdd
+ sky130_fd_sc_hd__fill_2
* cell instance sky130_fd_sc_hd__fill_2_798 r0 *1 0,0
Xsky130_fd_sc_hd__fill_2_798
+ vss
+ vdd
+ vdd
+ sky130_fd_sc_hd__fill_2
* cell instance sky130_fd_sc_hd__fill_2_799 r0 *1 0,0
Xsky130_fd_sc_hd__fill_2_799
+ vss
+ vdd
+ vdd
+ sky130_fd_sc_hd__fill_2
* cell instance sky130_fd_sc_hd__fill_2_800 r0 *1 0,0
Xsky130_fd_sc_hd__fill_2_800
+ vss
+ vdd
+ vdd
+ sky130_fd_sc_hd__fill_2
* cell instance sky130_fd_sc_hd__fill_2_801 r0 *1 0,0
Xsky130_fd_sc_hd__fill_2_801
+ vss
+ vdd
+ vdd
+ sky130_fd_sc_hd__fill_2
* cell instance sky130_fd_sc_hd__fill_2_802 r0 *1 0,0
Xsky130_fd_sc_hd__fill_2_802
+ vss
+ vdd
+ vdd
+ sky130_fd_sc_hd__fill_2
* cell instance sky130_fd_sc_hd__fill_2_803 r0 *1 0,0
Xsky130_fd_sc_hd__fill_2_803
+ vss
+ vdd
+ vdd
+ sky130_fd_sc_hd__fill_2
* cell instance sky130_fd_sc_hd__fill_2_804 r0 *1 0,0
Xsky130_fd_sc_hd__fill_2_804
+ vss
+ vdd
+ vdd
+ sky130_fd_sc_hd__fill_2
* cell instance sky130_fd_sc_hd__fill_2_805 r0 *1 0,0
Xsky130_fd_sc_hd__fill_2_805
+ vss
+ vdd
+ vdd
+ sky130_fd_sc_hd__fill_2
* cell instance sky130_fd_sc_hd__fill_2_806 r0 *1 0,0
Xsky130_fd_sc_hd__fill_2_806
+ vss
+ vdd
+ vdd
+ sky130_fd_sc_hd__fill_2
* cell instance sky130_fd_sc_hd__fill_2_807 r0 *1 0,0
Xsky130_fd_sc_hd__fill_2_807
+ vss
+ vdd
+ vdd
+ sky130_fd_sc_hd__fill_2
* cell instance sky130_fd_sc_hd__fill_2_808 r0 *1 0,0
Xsky130_fd_sc_hd__fill_2_808
+ vss
+ vdd
+ vdd
+ sky130_fd_sc_hd__fill_2
* cell instance sky130_fd_sc_hd__fill_2_809 r0 *1 0,0
Xsky130_fd_sc_hd__fill_2_809
+ vss
+ vdd
+ vdd
+ sky130_fd_sc_hd__fill_2
* cell instance sky130_fd_sc_hd__fill_2_810 r0 *1 0,0
Xsky130_fd_sc_hd__fill_2_810
+ vss
+ vdd
+ vdd
+ sky130_fd_sc_hd__fill_2
* cell instance sky130_fd_sc_hd__fill_2_811 r0 *1 0,0
Xsky130_fd_sc_hd__fill_2_811
+ vss
+ vdd
+ vdd
+ sky130_fd_sc_hd__fill_2
* cell instance sky130_fd_sc_hd__fill_2_812 r0 *1 0,0
Xsky130_fd_sc_hd__fill_2_812
+ vss
+ vdd
+ vdd
+ sky130_fd_sc_hd__fill_2
* cell instance sky130_fd_sc_hd__fill_2_813 r0 *1 0,0
Xsky130_fd_sc_hd__fill_2_813
+ vss
+ vdd
+ vdd
+ sky130_fd_sc_hd__fill_2
* cell instance sky130_fd_sc_hd__fill_2_814 r0 *1 0,0
Xsky130_fd_sc_hd__fill_2_814
+ vss
+ vdd
+ vdd
+ sky130_fd_sc_hd__fill_2
* cell instance sky130_fd_sc_hd__fill_2_815 r0 *1 0,0
Xsky130_fd_sc_hd__fill_2_815
+ vss
+ vdd
+ vdd
+ sky130_fd_sc_hd__fill_2
* cell instance sky130_fd_sc_hd__fill_2_816 r0 *1 0,0
Xsky130_fd_sc_hd__fill_2_816
+ vss
+ vdd
+ vdd
+ sky130_fd_sc_hd__fill_2
* cell instance sky130_fd_sc_hd__fill_2_817 r0 *1 0,0
Xsky130_fd_sc_hd__fill_2_817
+ vss
+ vdd
+ vdd
+ sky130_fd_sc_hd__fill_2
* cell instance sky130_fd_sc_hd__fill_2_818 r0 *1 0,0
Xsky130_fd_sc_hd__fill_2_818
+ vss
+ vdd
+ vdd
+ sky130_fd_sc_hd__fill_2
* cell instance sky130_fd_sc_hd__fill_2_819 r0 *1 0,0
Xsky130_fd_sc_hd__fill_2_819
+ vss
+ vdd
+ vdd
+ sky130_fd_sc_hd__fill_2
* cell instance sky130_fd_sc_hd__fill_2_820 r0 *1 0,0
Xsky130_fd_sc_hd__fill_2_820
+ vss
+ vdd
+ vdd
+ sky130_fd_sc_hd__fill_2
* cell instance sky130_fd_sc_hd__fill_2_821 r0 *1 0,0
Xsky130_fd_sc_hd__fill_2_821
+ vss
+ vdd
+ vdd
+ sky130_fd_sc_hd__fill_2
* cell instance sky130_fd_sc_hd__fill_2_822 r0 *1 0,0
Xsky130_fd_sc_hd__fill_2_822
+ vss
+ vdd
+ vdd
+ sky130_fd_sc_hd__fill_2
* cell instance sky130_fd_sc_hd__fill_2_823 r0 *1 0,0
Xsky130_fd_sc_hd__fill_2_823
+ vss
+ vdd
+ vdd
+ sky130_fd_sc_hd__fill_2
* cell instance sky130_fd_sc_hd__fill_2_824 r0 *1 0,0
Xsky130_fd_sc_hd__fill_2_824
+ vss
+ vdd
+ vdd
+ sky130_fd_sc_hd__fill_2
* cell instance sky130_fd_sc_hd__fill_2_825 r0 *1 0,0
Xsky130_fd_sc_hd__fill_2_825
+ vss
+ vdd
+ vdd
+ sky130_fd_sc_hd__fill_2
* cell instance sky130_fd_sc_hd__fill_2_826 r0 *1 0,0
Xsky130_fd_sc_hd__fill_2_826
+ vss
+ vdd
+ vdd
+ sky130_fd_sc_hd__fill_2
* cell instance sky130_fd_sc_hd__fill_2_827 r0 *1 0,0
Xsky130_fd_sc_hd__fill_2_827
+ vss
+ vdd
+ vdd
+ sky130_fd_sc_hd__fill_2
* cell instance sky130_fd_sc_hd__fill_2_828 r0 *1 0,0
Xsky130_fd_sc_hd__fill_2_828
+ vss
+ vdd
+ vdd
+ sky130_fd_sc_hd__fill_2
* cell instance sky130_fd_sc_hd__fill_2_829 r0 *1 0,0
Xsky130_fd_sc_hd__fill_2_829
+ vss
+ vdd
+ vdd
+ sky130_fd_sc_hd__fill_2
* cell instance sky130_fd_sc_hd__fill_2_830 r0 *1 0,0
Xsky130_fd_sc_hd__fill_2_830
+ vss
+ vdd
+ vdd
+ sky130_fd_sc_hd__fill_2
* cell instance sky130_fd_sc_hd__fill_2_831 r0 *1 0,0
Xsky130_fd_sc_hd__fill_2_831
+ vss
+ vdd
+ vdd
+ sky130_fd_sc_hd__fill_2
* cell instance sky130_fd_sc_hd__fill_2_832 r0 *1 0,0
Xsky130_fd_sc_hd__fill_2_832
+ vss
+ vdd
+ vdd
+ sky130_fd_sc_hd__fill_2
* cell instance sky130_fd_sc_hd__fill_2_833 r0 *1 0,0
Xsky130_fd_sc_hd__fill_2_833
+ vss
+ vdd
+ vdd
+ sky130_fd_sc_hd__fill_2
* cell instance sky130_fd_sc_hd__fill_2_834 r0 *1 0,0
Xsky130_fd_sc_hd__fill_2_834
+ vss
+ vdd
+ vdd
+ sky130_fd_sc_hd__fill_2
* cell instance sky130_fd_sc_hd__fill_2_835 r0 *1 0,0
Xsky130_fd_sc_hd__fill_2_835
+ vss
+ vdd
+ vdd
+ sky130_fd_sc_hd__fill_2
* cell instance sky130_fd_sc_hd__fill_2_836 r0 *1 0,0
Xsky130_fd_sc_hd__fill_2_836
+ vss
+ vdd
+ vdd
+ sky130_fd_sc_hd__fill_2
* cell instance sky130_fd_sc_hd__fill_2_837 r0 *1 0,0
Xsky130_fd_sc_hd__fill_2_837
+ vss
+ vdd
+ vdd
+ sky130_fd_sc_hd__fill_2
* cell instance sky130_fd_sc_hd__fill_2_838 r0 *1 0,0
Xsky130_fd_sc_hd__fill_2_838
+ vss
+ vdd
+ vdd
+ sky130_fd_sc_hd__fill_2
* cell instance sky130_fd_sc_hd__fill_2_839 r0 *1 0,0
Xsky130_fd_sc_hd__fill_2_839
+ vss
+ vdd
+ vdd
+ sky130_fd_sc_hd__fill_2
* cell instance sky130_fd_sc_hd__fill_2_840 r0 *1 0,0
Xsky130_fd_sc_hd__fill_2_840
+ vss
+ vdd
+ vdd
+ sky130_fd_sc_hd__fill_2
* cell instance sky130_fd_sc_hd__fill_2_841 r0 *1 0,0
Xsky130_fd_sc_hd__fill_2_841
+ vss
+ vdd
+ vdd
+ sky130_fd_sc_hd__fill_2
* cell instance sky130_fd_sc_hd__fill_2_842 r0 *1 0,0
Xsky130_fd_sc_hd__fill_2_842
+ vss
+ vdd
+ vdd
+ sky130_fd_sc_hd__fill_2
* cell instance sky130_fd_sc_hd__fill_2_843 r0 *1 0,0
Xsky130_fd_sc_hd__fill_2_843
+ vss
+ vdd
+ vdd
+ sky130_fd_sc_hd__fill_2
* cell instance sky130_fd_sc_hd__fill_2_844 r0 *1 0,0
Xsky130_fd_sc_hd__fill_2_844
+ vss
+ vdd
+ vdd
+ sky130_fd_sc_hd__fill_2
* cell instance sky130_fd_sc_hd__fill_2_845 r0 *1 0,0
Xsky130_fd_sc_hd__fill_2_845
+ vss
+ vdd
+ vdd
+ sky130_fd_sc_hd__fill_2
* cell instance sky130_fd_sc_hd__fill_2_846 r0 *1 0,0
Xsky130_fd_sc_hd__fill_2_846
+ vss
+ vdd
+ vdd
+ sky130_fd_sc_hd__fill_2
* cell instance sky130_fd_sc_hd__fill_2_847 r0 *1 0,0
Xsky130_fd_sc_hd__fill_2_847
+ vss
+ vdd
+ vdd
+ sky130_fd_sc_hd__fill_2
* cell instance sky130_fd_sc_hd__fill_2_848 r0 *1 0,0
Xsky130_fd_sc_hd__fill_2_848
+ vss
+ vdd
+ vdd
+ sky130_fd_sc_hd__fill_2
* cell instance sky130_fd_sc_hd__fill_2_849 r0 *1 0,0
Xsky130_fd_sc_hd__fill_2_849
+ vss
+ vdd
+ vdd
+ sky130_fd_sc_hd__fill_2
* cell instance sky130_fd_sc_hd__fill_2_850 r0 *1 0,0
Xsky130_fd_sc_hd__fill_2_850
+ vss
+ vdd
+ vdd
+ sky130_fd_sc_hd__fill_2
* cell instance sky130_fd_sc_hd__fill_2_851 r0 *1 0,0
Xsky130_fd_sc_hd__fill_2_851
+ vss
+ vdd
+ vdd
+ sky130_fd_sc_hd__fill_2
* cell instance sky130_fd_sc_hd__fill_2_852 r0 *1 0,0
Xsky130_fd_sc_hd__fill_2_852
+ vss
+ vdd
+ vdd
+ sky130_fd_sc_hd__fill_2
* cell instance sky130_fd_sc_hd__fill_2_853 r0 *1 0,0
Xsky130_fd_sc_hd__fill_2_853
+ vss
+ vdd
+ vdd
+ sky130_fd_sc_hd__fill_2
* cell instance sky130_fd_sc_hd__fill_2_854 r0 *1 0,0
Xsky130_fd_sc_hd__fill_2_854
+ vss
+ vdd
+ vdd
+ sky130_fd_sc_hd__fill_2
* cell instance sky130_fd_sc_hd__fill_2_855 r0 *1 0,0
Xsky130_fd_sc_hd__fill_2_855
+ vss
+ vdd
+ vdd
+ sky130_fd_sc_hd__fill_2
* cell instance sky130_fd_sc_hd__fill_2_856 r0 *1 0,0
Xsky130_fd_sc_hd__fill_2_856
+ vss
+ vdd
+ vdd
+ sky130_fd_sc_hd__fill_2
* cell instance sky130_fd_sc_hd__fill_2_857 r0 *1 0,0
Xsky130_fd_sc_hd__fill_2_857
+ vss
+ vdd
+ vdd
+ sky130_fd_sc_hd__fill_2
* cell instance sky130_fd_sc_hd__fill_2_858 r0 *1 0,0
Xsky130_fd_sc_hd__fill_2_858
+ vss
+ vdd
+ vdd
+ sky130_fd_sc_hd__fill_2
* cell instance sky130_fd_sc_hd__fill_2_859 r0 *1 0,0
Xsky130_fd_sc_hd__fill_2_859
+ vss
+ vdd
+ vdd
+ sky130_fd_sc_hd__fill_2
* cell instance sky130_fd_sc_hd__fill_2_860 r0 *1 0,0
Xsky130_fd_sc_hd__fill_2_860
+ vss
+ vdd
+ vdd
+ sky130_fd_sc_hd__fill_2
* cell instance sky130_fd_sc_hd__fill_2_861 r0 *1 0,0
Xsky130_fd_sc_hd__fill_2_861
+ vss
+ vdd
+ vdd
+ sky130_fd_sc_hd__fill_2
* cell instance sky130_fd_sc_hd__fill_2_862 r0 *1 0,0
Xsky130_fd_sc_hd__fill_2_862
+ vss
+ vdd
+ vdd
+ sky130_fd_sc_hd__fill_2
* cell instance sky130_fd_sc_hd__fill_2_863 r0 *1 0,0
Xsky130_fd_sc_hd__fill_2_863
+ vss
+ vdd
+ vdd
+ sky130_fd_sc_hd__fill_2
* cell instance sky130_fd_sc_hd__fill_2_864 r0 *1 0,0
Xsky130_fd_sc_hd__fill_2_864
+ vss
+ vdd
+ vdd
+ sky130_fd_sc_hd__fill_2
* cell instance sky130_fd_sc_hd__fill_2_865 r0 *1 0,0
Xsky130_fd_sc_hd__fill_2_865
+ vss
+ vdd
+ vdd
+ sky130_fd_sc_hd__fill_2
* cell instance sky130_fd_sc_hd__fill_2_866 r0 *1 0,0
Xsky130_fd_sc_hd__fill_2_866
+ vss
+ vdd
+ vdd
+ sky130_fd_sc_hd__fill_2
* cell instance sky130_fd_sc_hd__fill_2_867 r0 *1 0,0
Xsky130_fd_sc_hd__fill_2_867
+ vss
+ vdd
+ vdd
+ sky130_fd_sc_hd__fill_2
* cell instance sky130_fd_sc_hd__fill_2_868 r0 *1 0,0
Xsky130_fd_sc_hd__fill_2_868
+ vss
+ vdd
+ vdd
+ sky130_fd_sc_hd__fill_2
* cell instance sky130_fd_sc_hd__fill_2_869 r0 *1 0,0
Xsky130_fd_sc_hd__fill_2_869
+ vss
+ vdd
+ vdd
+ sky130_fd_sc_hd__fill_2
* cell instance sky130_fd_sc_hd__fill_2_870 r0 *1 0,0
Xsky130_fd_sc_hd__fill_2_870
+ vss
+ vdd
+ vdd
+ sky130_fd_sc_hd__fill_2
* cell instance sky130_fd_sc_hd__fill_2_871 r0 *1 0,0
Xsky130_fd_sc_hd__fill_2_871
+ vss
+ vdd
+ vdd
+ sky130_fd_sc_hd__fill_2
* cell instance sky130_fd_sc_hd__fill_2_872 r0 *1 0,0
Xsky130_fd_sc_hd__fill_2_872
+ vss
+ vdd
+ vdd
+ sky130_fd_sc_hd__fill_2
* cell instance sky130_fd_sc_hd__fill_2_873 r0 *1 0,0
Xsky130_fd_sc_hd__fill_2_873
+ vss
+ vdd
+ vdd
+ sky130_fd_sc_hd__fill_2
* cell instance sky130_fd_sc_hd__fill_2_874 r0 *1 0,0
Xsky130_fd_sc_hd__fill_2_874
+ vss
+ vdd
+ vdd
+ sky130_fd_sc_hd__fill_2
* cell instance sky130_fd_sc_hd__fill_2_875 r0 *1 0,0
Xsky130_fd_sc_hd__fill_2_875
+ vss
+ vdd
+ vdd
+ sky130_fd_sc_hd__fill_2
* cell instance sky130_fd_sc_hd__fill_2_876 r0 *1 0,0
Xsky130_fd_sc_hd__fill_2_876
+ vss
+ vdd
+ vdd
+ sky130_fd_sc_hd__fill_2
* cell instance sky130_fd_sc_hd__fill_2_877 r0 *1 0,0
Xsky130_fd_sc_hd__fill_2_877
+ vss
+ vdd
+ vdd
+ sky130_fd_sc_hd__fill_2
* cell instance sky130_fd_sc_hd__fill_2_878 r0 *1 0,0
Xsky130_fd_sc_hd__fill_2_878
+ vss
+ vdd
+ vdd
+ sky130_fd_sc_hd__fill_2
* cell instance sky130_fd_sc_hd__fill_2_879 r0 *1 0,0
Xsky130_fd_sc_hd__fill_2_879
+ vss
+ vdd
+ vdd
+ sky130_fd_sc_hd__fill_2
* cell instance sky130_fd_sc_hd__fill_2_880 r0 *1 0,0
Xsky130_fd_sc_hd__fill_2_880
+ vss
+ vdd
+ vdd
+ sky130_fd_sc_hd__fill_2
* cell instance sky130_fd_sc_hd__fill_2_881 r0 *1 0,0
Xsky130_fd_sc_hd__fill_2_881
+ vss
+ vdd
+ vdd
+ sky130_fd_sc_hd__fill_2
* cell instance sky130_fd_sc_hd__fill_2_882 r0 *1 0,0
Xsky130_fd_sc_hd__fill_2_882
+ vss
+ vdd
+ vdd
+ sky130_fd_sc_hd__fill_2
* cell instance sky130_fd_sc_hd__fill_2_883 r0 *1 0,0
Xsky130_fd_sc_hd__fill_2_883
+ vss
+ vdd
+ vdd
+ sky130_fd_sc_hd__fill_2
* cell instance sky130_fd_sc_hd__fill_2_884 r0 *1 0,0
Xsky130_fd_sc_hd__fill_2_884
+ vss
+ vdd
+ vdd
+ sky130_fd_sc_hd__fill_2
* cell instance sky130_fd_sc_hd__fill_2_885 r0 *1 0,0
Xsky130_fd_sc_hd__fill_2_885
+ vss
+ vdd
+ vdd
+ sky130_fd_sc_hd__fill_2
* cell instance sky130_fd_sc_hd__fill_2_886 r0 *1 0,0
Xsky130_fd_sc_hd__fill_2_886
+ vss
+ vdd
+ vdd
+ sky130_fd_sc_hd__fill_2
* cell instance sky130_fd_sc_hd__fill_2_887 r0 *1 0,0
Xsky130_fd_sc_hd__fill_2_887
+ vss
+ vdd
+ vdd
+ sky130_fd_sc_hd__fill_2
* cell instance sky130_fd_sc_hd__fill_2_888 r0 *1 0,0
Xsky130_fd_sc_hd__fill_2_888
+ vss
+ vdd
+ vdd
+ sky130_fd_sc_hd__fill_2
* cell instance sky130_fd_sc_hd__fill_2_889 r0 *1 0,0
Xsky130_fd_sc_hd__fill_2_889
+ vss
+ vdd
+ vdd
+ sky130_fd_sc_hd__fill_2
* cell instance sky130_fd_sc_hd__fill_2_890 r0 *1 0,0
Xsky130_fd_sc_hd__fill_2_890
+ vss
+ vdd
+ vdd
+ sky130_fd_sc_hd__fill_2
* cell instance sky130_fd_sc_hd__fill_2_891 r0 *1 0,0
Xsky130_fd_sc_hd__fill_2_891
+ vss
+ vdd
+ vdd
+ sky130_fd_sc_hd__fill_2
* cell instance sky130_fd_sc_hd__fill_2_892 r0 *1 0,0
Xsky130_fd_sc_hd__fill_2_892
+ vss
+ vdd
+ vdd
+ sky130_fd_sc_hd__fill_2
* cell instance sky130_fd_sc_hd__fill_2_893 r0 *1 0,0
Xsky130_fd_sc_hd__fill_2_893
+ vss
+ vdd
+ vdd
+ sky130_fd_sc_hd__fill_2
* cell instance sky130_fd_sc_hd__fill_2_894 r0 *1 0,0
Xsky130_fd_sc_hd__fill_2_894
+ vss
+ vdd
+ vdd
+ sky130_fd_sc_hd__fill_2
* cell instance sky130_fd_sc_hd__fill_2_895 r0 *1 0,0
Xsky130_fd_sc_hd__fill_2_895
+ vss
+ vdd
+ vdd
+ sky130_fd_sc_hd__fill_2
* cell instance sky130_fd_sc_hd__fill_2_896 r0 *1 0,0
Xsky130_fd_sc_hd__fill_2_896
+ vss
+ vdd
+ vdd
+ sky130_fd_sc_hd__fill_2
* cell instance sky130_fd_sc_hd__fill_2_897 r0 *1 0,0
Xsky130_fd_sc_hd__fill_2_897
+ vss
+ vdd
+ vdd
+ sky130_fd_sc_hd__fill_2
* cell instance sky130_fd_sc_hd__fill_2_898 r0 *1 0,0
Xsky130_fd_sc_hd__fill_2_898
+ vss
+ vdd
+ vdd
+ sky130_fd_sc_hd__fill_2
* cell instance sky130_fd_sc_hd__fill_2_899 r0 *1 0,0
Xsky130_fd_sc_hd__fill_2_899
+ vss
+ vdd
+ vdd
+ sky130_fd_sc_hd__fill_2
* cell instance sky130_fd_sc_hd__fill_2_900 r0 *1 0,0
Xsky130_fd_sc_hd__fill_2_900
+ vss
+ vdd
+ vdd
+ sky130_fd_sc_hd__fill_2
* cell instance sky130_fd_sc_hd__fill_2_901 r0 *1 0,0
Xsky130_fd_sc_hd__fill_2_901
+ vss
+ vdd
+ vdd
+ sky130_fd_sc_hd__fill_2
* cell instance sky130_fd_sc_hd__fill_2_902 r0 *1 0,0
Xsky130_fd_sc_hd__fill_2_902
+ vss
+ vdd
+ vdd
+ sky130_fd_sc_hd__fill_2
* cell instance sky130_fd_sc_hd__fill_2_903 r0 *1 0,0
Xsky130_fd_sc_hd__fill_2_903
+ vss
+ vdd
+ vdd
+ sky130_fd_sc_hd__fill_2
* cell instance sky130_fd_sc_hd__fill_2_904 r0 *1 0,0
Xsky130_fd_sc_hd__fill_2_904
+ vss
+ vdd
+ vdd
+ sky130_fd_sc_hd__fill_2
* cell instance sky130_fd_sc_hd__fill_2_905 r0 *1 0,0
Xsky130_fd_sc_hd__fill_2_905
+ vss
+ vdd
+ vdd
+ sky130_fd_sc_hd__fill_2
* cell instance sky130_fd_sc_hd__fill_2_906 r0 *1 0,0
Xsky130_fd_sc_hd__fill_2_906
+ vss
+ vdd
+ vdd
+ sky130_fd_sc_hd__fill_2
* cell instance sky130_fd_sc_hd__fill_2_907 r0 *1 0,0
Xsky130_fd_sc_hd__fill_2_907
+ vss
+ vdd
+ vdd
+ sky130_fd_sc_hd__fill_2
* cell instance sky130_fd_sc_hd__fill_2_908 r0 *1 0,0
Xsky130_fd_sc_hd__fill_2_908
+ vss
+ vdd
+ vdd
+ sky130_fd_sc_hd__fill_2
* cell instance sky130_fd_sc_hd__fill_2_909 r0 *1 0,0
Xsky130_fd_sc_hd__fill_2_909
+ vss
+ vdd
+ vdd
+ sky130_fd_sc_hd__fill_2
* cell instance sky130_fd_sc_hd__fill_2_910 r0 *1 0,0
Xsky130_fd_sc_hd__fill_2_910
+ vss
+ vdd
+ vdd
+ sky130_fd_sc_hd__fill_2
* cell instance sky130_fd_sc_hd__fill_2_911 r0 *1 0,0
Xsky130_fd_sc_hd__fill_2_911
+ vss
+ vdd
+ vdd
+ sky130_fd_sc_hd__fill_2
* cell instance sky130_fd_sc_hd__fill_2_912 r0 *1 0,0
Xsky130_fd_sc_hd__fill_2_912
+ vss
+ vdd
+ vdd
+ sky130_fd_sc_hd__fill_2
* cell instance sky130_fd_sc_hd__fill_2_913 r0 *1 0,0
Xsky130_fd_sc_hd__fill_2_913
+ vss
+ vdd
+ vdd
+ sky130_fd_sc_hd__fill_2
* cell instance sky130_fd_sc_hd__fill_2_914 r0 *1 0,0
Xsky130_fd_sc_hd__fill_2_914
+ vss
+ vdd
+ vdd
+ sky130_fd_sc_hd__fill_2
* cell instance sky130_fd_sc_hd__fill_2_915 r0 *1 0,0
Xsky130_fd_sc_hd__fill_2_915
+ vss
+ vdd
+ vdd
+ sky130_fd_sc_hd__fill_2
* cell instance sky130_fd_sc_hd__fill_2_916 r0 *1 0,0
Xsky130_fd_sc_hd__fill_2_916
+ vss
+ vdd
+ vdd
+ sky130_fd_sc_hd__fill_2
* cell instance sky130_fd_sc_hd__fill_2_917 r0 *1 0,0
Xsky130_fd_sc_hd__fill_2_917
+ vss
+ vdd
+ vdd
+ sky130_fd_sc_hd__fill_2
* cell instance sky130_fd_sc_hd__fill_2_918 r0 *1 0,0
Xsky130_fd_sc_hd__fill_2_918
+ vss
+ vdd
+ vdd
+ sky130_fd_sc_hd__fill_2
* cell instance sky130_fd_sc_hd__fill_2_919 r0 *1 0,0
Xsky130_fd_sc_hd__fill_2_919
+ vss
+ vdd
+ vdd
+ sky130_fd_sc_hd__fill_2
* cell instance sky130_fd_sc_hd__fill_2_920 r0 *1 0,0
Xsky130_fd_sc_hd__fill_2_920
+ vss
+ vdd
+ vdd
+ sky130_fd_sc_hd__fill_2
* cell instance sky130_fd_sc_hd__fill_2_921 r0 *1 0,0
Xsky130_fd_sc_hd__fill_2_921
+ vss
+ vdd
+ vdd
+ sky130_fd_sc_hd__fill_2
* cell instance sky130_fd_sc_hd__fill_2_922 r0 *1 0,0
Xsky130_fd_sc_hd__fill_2_922
+ vss
+ vdd
+ vdd
+ sky130_fd_sc_hd__fill_2
* cell instance sky130_fd_sc_hd__fill_2_923 r0 *1 0,0
Xsky130_fd_sc_hd__fill_2_923
+ vss
+ vdd
+ vdd
+ sky130_fd_sc_hd__fill_2
* cell instance sky130_fd_sc_hd__fill_2_924 r0 *1 0,0
Xsky130_fd_sc_hd__fill_2_924
+ vss
+ vdd
+ vdd
+ sky130_fd_sc_hd__fill_2
* cell instance sky130_fd_sc_hd__fill_2_925 r0 *1 0,0
Xsky130_fd_sc_hd__fill_2_925
+ vss
+ vdd
+ vdd
+ sky130_fd_sc_hd__fill_2
* cell instance sky130_fd_sc_hd__fill_2_926 r0 *1 0,0
Xsky130_fd_sc_hd__fill_2_926
+ vss
+ vdd
+ vdd
+ sky130_fd_sc_hd__fill_2
* cell instance sky130_fd_sc_hd__fill_2_927 r0 *1 0,0
Xsky130_fd_sc_hd__fill_2_927
+ vss
+ vdd
+ vdd
+ sky130_fd_sc_hd__fill_2
* cell instance sky130_fd_sc_hd__fill_2_928 r0 *1 0,0
Xsky130_fd_sc_hd__fill_2_928
+ vss
+ vdd
+ vdd
+ sky130_fd_sc_hd__fill_2
* cell instance sky130_fd_sc_hd__fill_2_929 r0 *1 0,0
Xsky130_fd_sc_hd__fill_2_929
+ vss
+ vdd
+ vdd
+ sky130_fd_sc_hd__fill_2
* cell instance sky130_fd_sc_hd__fill_2_930 r0 *1 0,0
Xsky130_fd_sc_hd__fill_2_930
+ vss
+ vdd
+ vdd
+ sky130_fd_sc_hd__fill_2
* cell instance sky130_fd_sc_hd__fill_2_931 r0 *1 0,0
Xsky130_fd_sc_hd__fill_2_931
+ vss
+ vdd
+ vdd
+ sky130_fd_sc_hd__fill_2
* cell instance sky130_fd_sc_hd__fill_2_932 r0 *1 0,0
Xsky130_fd_sc_hd__fill_2_932
+ vss
+ vdd
+ vdd
+ sky130_fd_sc_hd__fill_2
* cell instance sky130_fd_sc_hd__fill_2_933 r0 *1 0,0
Xsky130_fd_sc_hd__fill_2_933
+ vss
+ vdd
+ vdd
+ sky130_fd_sc_hd__fill_2
* cell instance sky130_fd_sc_hd__fill_2_934 r0 *1 0,0
Xsky130_fd_sc_hd__fill_2_934
+ vss
+ vdd
+ vdd
+ sky130_fd_sc_hd__fill_2
* cell instance sky130_fd_sc_hd__fill_2_935 r0 *1 0,0
Xsky130_fd_sc_hd__fill_2_935
+ vss
+ vdd
+ vdd
+ sky130_fd_sc_hd__fill_2
* cell instance sky130_fd_sc_hd__fill_2_936 r0 *1 0,0
Xsky130_fd_sc_hd__fill_2_936
+ vss
+ vdd
+ vdd
+ sky130_fd_sc_hd__fill_2
* cell instance sky130_fd_sc_hd__fill_2_937 r0 *1 0,0
Xsky130_fd_sc_hd__fill_2_937
+ vss
+ vdd
+ vdd
+ sky130_fd_sc_hd__fill_2
* cell instance sky130_fd_sc_hd__fill_2_938 r0 *1 0,0
Xsky130_fd_sc_hd__fill_2_938
+ vss
+ vdd
+ vdd
+ sky130_fd_sc_hd__fill_2
* cell instance sky130_fd_sc_hd__fill_2_939 r0 *1 0,0
Xsky130_fd_sc_hd__fill_2_939
+ vss
+ vdd
+ vdd
+ sky130_fd_sc_hd__fill_2
* cell instance sky130_fd_sc_hd__fill_2_940 r0 *1 0,0
Xsky130_fd_sc_hd__fill_2_940
+ vss
+ vdd
+ vdd
+ sky130_fd_sc_hd__fill_2
* cell instance sky130_fd_sc_hd__fill_2_941 r0 *1 0,0
Xsky130_fd_sc_hd__fill_2_941
+ vss
+ vdd
+ vdd
+ sky130_fd_sc_hd__fill_2
* cell instance sky130_fd_sc_hd__fill_2_942 r0 *1 0,0
Xsky130_fd_sc_hd__fill_2_942
+ vss
+ vdd
+ vdd
+ sky130_fd_sc_hd__fill_2
* cell instance sky130_fd_sc_hd__fill_2_943 r0 *1 0,0
Xsky130_fd_sc_hd__fill_2_943
+ vss
+ vdd
+ vdd
+ sky130_fd_sc_hd__fill_2
* cell instance sky130_fd_sc_hd__fill_2_944 r0 *1 0,0
Xsky130_fd_sc_hd__fill_2_944
+ vss
+ vdd
+ vdd
+ sky130_fd_sc_hd__fill_2
* cell instance sky130_fd_sc_hd__fill_2_945 r0 *1 0,0
Xsky130_fd_sc_hd__fill_2_945
+ vss
+ vdd
+ vdd
+ sky130_fd_sc_hd__fill_2
* cell instance sky130_fd_sc_hd__fill_2_946 r0 *1 0,0
Xsky130_fd_sc_hd__fill_2_946
+ vss
+ vdd
+ vdd
+ sky130_fd_sc_hd__fill_2
* cell instance sky130_fd_sc_hd__fill_2_947 r0 *1 0,0
Xsky130_fd_sc_hd__fill_2_947
+ vss
+ vdd
+ vdd
+ sky130_fd_sc_hd__fill_2
* cell instance sky130_fd_sc_hd__fill_2_948 r0 *1 0,0
Xsky130_fd_sc_hd__fill_2_948
+ vss
+ vdd
+ vdd
+ sky130_fd_sc_hd__fill_2
* cell instance sky130_fd_sc_hd__fill_2_949 r0 *1 0,0
Xsky130_fd_sc_hd__fill_2_949
+ vss
+ vdd
+ vdd
+ sky130_fd_sc_hd__fill_2
* cell instance sky130_fd_sc_hd__fill_2_950 r0 *1 0,0
Xsky130_fd_sc_hd__fill_2_950
+ vss
+ vdd
+ vdd
+ sky130_fd_sc_hd__fill_2
* cell instance sky130_fd_sc_hd__fill_2_951 r0 *1 0,0
Xsky130_fd_sc_hd__fill_2_951
+ vss
+ vdd
+ vdd
+ sky130_fd_sc_hd__fill_2
* cell instance sky130_fd_sc_hd__fill_2_952 r0 *1 0,0
Xsky130_fd_sc_hd__fill_2_952
+ vss
+ vdd
+ vdd
+ sky130_fd_sc_hd__fill_2
* cell instance sky130_fd_sc_hd__fill_2_953 r0 *1 0,0
Xsky130_fd_sc_hd__fill_2_953
+ vss
+ vdd
+ vdd
+ sky130_fd_sc_hd__fill_2
* cell instance sky130_fd_sc_hd__fill_2_954 r0 *1 0,0
Xsky130_fd_sc_hd__fill_2_954
+ vss
+ vdd
+ vdd
+ sky130_fd_sc_hd__fill_2
* cell instance sky130_fd_sc_hd__fill_2_955 r0 *1 0,0
Xsky130_fd_sc_hd__fill_2_955
+ vss
+ vdd
+ vdd
+ sky130_fd_sc_hd__fill_2
* cell instance sky130_fd_sc_hd__fill_2_956 r0 *1 0,0
Xsky130_fd_sc_hd__fill_2_956
+ vss
+ vdd
+ vdd
+ sky130_fd_sc_hd__fill_2
* cell instance sky130_fd_sc_hd__fill_2_957 r0 *1 0,0
Xsky130_fd_sc_hd__fill_2_957
+ vss
+ vdd
+ vdd
+ sky130_fd_sc_hd__fill_2
* cell instance sky130_fd_sc_hd__fill_2_958 r0 *1 0,0
Xsky130_fd_sc_hd__fill_2_958
+ vss
+ vdd
+ vdd
+ sky130_fd_sc_hd__fill_2
* cell instance sky130_fd_sc_hd__fill_2_959 r0 *1 0,0
Xsky130_fd_sc_hd__fill_2_959
+ vss
+ vdd
+ vdd
+ sky130_fd_sc_hd__fill_2
* cell instance sky130_fd_sc_hd__fill_2_960 r0 *1 0,0
Xsky130_fd_sc_hd__fill_2_960
+ vss
+ vdd
+ vdd
+ sky130_fd_sc_hd__fill_2
* cell instance sky130_fd_sc_hd__fill_2_961 r0 *1 0,0
Xsky130_fd_sc_hd__fill_2_961
+ vss
+ vdd
+ vdd
+ sky130_fd_sc_hd__fill_2
* cell instance sky130_fd_sc_hd__fill_2_962 r0 *1 0,0
Xsky130_fd_sc_hd__fill_2_962
+ vss
+ vdd
+ vdd
+ sky130_fd_sc_hd__fill_2
* cell instance sky130_fd_sc_hd__fill_2_963 r0 *1 0,0
Xsky130_fd_sc_hd__fill_2_963
+ vss
+ vdd
+ vdd
+ sky130_fd_sc_hd__fill_2
* cell instance sky130_fd_sc_hd__fill_2_964 r0 *1 0,0
Xsky130_fd_sc_hd__fill_2_964
+ vss
+ vdd
+ vdd
+ sky130_fd_sc_hd__fill_2
* cell instance sky130_fd_sc_hd__fill_2_965 r0 *1 0,0
Xsky130_fd_sc_hd__fill_2_965
+ vss
+ vdd
+ vdd
+ sky130_fd_sc_hd__fill_2
* cell instance sky130_fd_sc_hd__fill_2_966 r0 *1 0,0
Xsky130_fd_sc_hd__fill_2_966
+ vss
+ vdd
+ vdd
+ sky130_fd_sc_hd__fill_2
* cell instance sky130_fd_sc_hd__fill_2_967 r0 *1 0,0
Xsky130_fd_sc_hd__fill_2_967
+ vss
+ vdd
+ vdd
+ sky130_fd_sc_hd__fill_2
* cell instance sky130_fd_sc_hd__fill_2_968 r0 *1 0,0
Xsky130_fd_sc_hd__fill_2_968
+ vss
+ vdd
+ vdd
+ sky130_fd_sc_hd__fill_2
* cell instance sky130_fd_sc_hd__fill_2_969 r0 *1 0,0
Xsky130_fd_sc_hd__fill_2_969
+ vss
+ vdd
+ vdd
+ sky130_fd_sc_hd__fill_2
* cell instance sky130_fd_sc_hd__fill_2_970 r0 *1 0,0
Xsky130_fd_sc_hd__fill_2_970
+ vss
+ vdd
+ vdd
+ sky130_fd_sc_hd__fill_2
* cell instance sky130_fd_sc_hd__fill_2_971 r0 *1 0,0
Xsky130_fd_sc_hd__fill_2_971
+ vss
+ vdd
+ vdd
+ sky130_fd_sc_hd__fill_2
* cell instance sky130_fd_sc_hd__fill_2_972 r0 *1 0,0
Xsky130_fd_sc_hd__fill_2_972
+ vss
+ vdd
+ vdd
+ sky130_fd_sc_hd__fill_2
* cell instance sky130_fd_sc_hd__fill_2_973 r0 *1 0,0
Xsky130_fd_sc_hd__fill_2_973
+ vss
+ vdd
+ vdd
+ sky130_fd_sc_hd__fill_2
* cell instance sky130_fd_sc_hd__fill_2_974 r0 *1 0,0
Xsky130_fd_sc_hd__fill_2_974
+ vss
+ vdd
+ vdd
+ sky130_fd_sc_hd__fill_2
* cell instance sky130_fd_sc_hd__fill_2_975 r0 *1 0,0
Xsky130_fd_sc_hd__fill_2_975
+ vss
+ vdd
+ vdd
+ sky130_fd_sc_hd__fill_2
* cell instance sky130_fd_sc_hd__fill_2_976 r0 *1 0,0
Xsky130_fd_sc_hd__fill_2_976
+ vss
+ vdd
+ vdd
+ sky130_fd_sc_hd__fill_2
* cell instance sky130_fd_sc_hd__fill_2_977 r0 *1 0,0
Xsky130_fd_sc_hd__fill_2_977
+ vss
+ vdd
+ vdd
+ sky130_fd_sc_hd__fill_2
* cell instance sky130_fd_sc_hd__fill_2_978 r0 *1 0,0
Xsky130_fd_sc_hd__fill_2_978
+ vss
+ vdd
+ vdd
+ sky130_fd_sc_hd__fill_2
* cell instance sky130_fd_sc_hd__fill_2_979 r0 *1 0,0
Xsky130_fd_sc_hd__fill_2_979
+ vss
+ vdd
+ vdd
+ sky130_fd_sc_hd__fill_2
* cell instance sky130_fd_sc_hd__fill_2_980 r0 *1 0,0
Xsky130_fd_sc_hd__fill_2_980
+ vss
+ vdd
+ vdd
+ sky130_fd_sc_hd__fill_2
* cell instance sky130_fd_sc_hd__fill_2_981 r0 *1 0,0
Xsky130_fd_sc_hd__fill_2_981
+ vss
+ vdd
+ vdd
+ sky130_fd_sc_hd__fill_2
* cell instance sky130_fd_sc_hd__fill_2_982 r0 *1 0,0
Xsky130_fd_sc_hd__fill_2_982
+ vss
+ vdd
+ vdd
+ sky130_fd_sc_hd__fill_2
* cell instance sky130_fd_sc_hd__fill_2_983 r0 *1 0,0
Xsky130_fd_sc_hd__fill_2_983
+ vss
+ vdd
+ vdd
+ sky130_fd_sc_hd__fill_2
* cell instance sky130_fd_sc_hd__fill_2_984 r0 *1 0,0
Xsky130_fd_sc_hd__fill_2_984
+ vss
+ vdd
+ vdd
+ sky130_fd_sc_hd__fill_2
* cell instance sky130_fd_sc_hd__fill_2_985 r0 *1 0,0
Xsky130_fd_sc_hd__fill_2_985
+ vss
+ vdd
+ vdd
+ sky130_fd_sc_hd__fill_2
* cell instance sky130_fd_sc_hd__fill_2_986 r0 *1 0,0
Xsky130_fd_sc_hd__fill_2_986
+ vss
+ vdd
+ vdd
+ sky130_fd_sc_hd__fill_2
* cell instance sky130_fd_sc_hd__fill_2_987 r0 *1 0,0
Xsky130_fd_sc_hd__fill_2_987
+ vss
+ vdd
+ vdd
+ sky130_fd_sc_hd__fill_2
* cell instance sky130_fd_sc_hd__fill_2_988 r0 *1 0,0
Xsky130_fd_sc_hd__fill_2_988
+ vss
+ vdd
+ vdd
+ sky130_fd_sc_hd__fill_2
* cell instance sky130_fd_sc_hd__fill_2_989 r0 *1 0,0
Xsky130_fd_sc_hd__fill_2_989
+ vss
+ vdd
+ vdd
+ sky130_fd_sc_hd__fill_2
* cell instance sky130_fd_sc_hd__fill_2_990 r0 *1 0,0
Xsky130_fd_sc_hd__fill_2_990
+ vss
+ vdd
+ vdd
+ sky130_fd_sc_hd__fill_2
* cell instance sky130_fd_sc_hd__fill_2_991 r0 *1 0,0
Xsky130_fd_sc_hd__fill_2_991
+ vss
+ vdd
+ vdd
+ sky130_fd_sc_hd__fill_2
* cell instance sky130_fd_sc_hd__fill_2_992 r0 *1 0,0
Xsky130_fd_sc_hd__fill_2_992
+ vss
+ vdd
+ vdd
+ sky130_fd_sc_hd__fill_2
* cell instance sky130_fd_sc_hd__fill_2_993 r0 *1 0,0
Xsky130_fd_sc_hd__fill_2_993
+ vss
+ vdd
+ vdd
+ sky130_fd_sc_hd__fill_2
* cell instance sky130_fd_sc_hd__fill_2_994 r0 *1 0,0
Xsky130_fd_sc_hd__fill_2_994
+ vss
+ vdd
+ vdd
+ sky130_fd_sc_hd__fill_2
* cell instance sky130_fd_sc_hd__fill_2_995 r0 *1 0,0
Xsky130_fd_sc_hd__fill_2_995
+ vss
+ vdd
+ vdd
+ sky130_fd_sc_hd__fill_2
* cell instance sky130_fd_sc_hd__fill_2_996 r0 *1 0,0
Xsky130_fd_sc_hd__fill_2_996
+ vss
+ vdd
+ vdd
+ sky130_fd_sc_hd__fill_2
* cell instance sky130_fd_sc_hd__fill_2_997 r0 *1 0,0
Xsky130_fd_sc_hd__fill_2_997
+ vss
+ vdd
+ vdd
+ sky130_fd_sc_hd__fill_2
* cell instance sky130_fd_sc_hd__fill_2_998 r0 *1 0,0
Xsky130_fd_sc_hd__fill_2_998
+ vss
+ vdd
+ vdd
+ sky130_fd_sc_hd__fill_2
* cell instance sky130_fd_sc_hd__fill_2_999 r0 *1 0,0
Xsky130_fd_sc_hd__fill_2_999
+ vss
+ vdd
+ vdd
+ sky130_fd_sc_hd__fill_2
* cell instance sky130_fd_sc_hd__fill_2_1000 r0 *1 0,0
Xsky130_fd_sc_hd__fill_2_1000
+ vss
+ vdd
+ vdd
+ sky130_fd_sc_hd__fill_2
* cell instance sky130_fd_sc_hd__fill_2_1001 r0 *1 0,0
Xsky130_fd_sc_hd__fill_2_1001
+ vss
+ vdd
+ vdd
+ sky130_fd_sc_hd__fill_2
* cell instance sky130_fd_sc_hd__fill_2_1002 r0 *1 0,0
Xsky130_fd_sc_hd__fill_2_1002
+ vss
+ vdd
+ vdd
+ sky130_fd_sc_hd__fill_2
* cell instance sky130_fd_sc_hd__fill_2_1003 r0 *1 0,0
Xsky130_fd_sc_hd__fill_2_1003
+ vss
+ vdd
+ vdd
+ sky130_fd_sc_hd__fill_2
* cell instance sky130_fd_sc_hd__fill_2_1004 r0 *1 0,0
Xsky130_fd_sc_hd__fill_2_1004
+ vss
+ vdd
+ vdd
+ sky130_fd_sc_hd__fill_2
* cell instance sky130_fd_sc_hd__fill_2_1005 r0 *1 0,0
Xsky130_fd_sc_hd__fill_2_1005
+ vss
+ vdd
+ vdd
+ sky130_fd_sc_hd__fill_2
* cell instance sky130_fd_sc_hd__fill_2_1006 r0 *1 0,0
Xsky130_fd_sc_hd__fill_2_1006
+ vss
+ vdd
+ vdd
+ sky130_fd_sc_hd__fill_2
* cell instance sky130_fd_sc_hd__fill_2_1007 r0 *1 0,0
Xsky130_fd_sc_hd__fill_2_1007
+ vss
+ vdd
+ vdd
+ sky130_fd_sc_hd__fill_2
* cell instance sky130_fd_sc_hd__fill_2_1008 r0 *1 0,0
Xsky130_fd_sc_hd__fill_2_1008
+ vss
+ vdd
+ vdd
+ sky130_fd_sc_hd__fill_2
* cell instance sky130_fd_sc_hd__fill_2_1009 r0 *1 0,0
Xsky130_fd_sc_hd__fill_2_1009
+ vss
+ vdd
+ vdd
+ sky130_fd_sc_hd__fill_2
* cell instance sky130_fd_sc_hd__fill_2_1010 r0 *1 0,0
Xsky130_fd_sc_hd__fill_2_1010
+ vss
+ vdd
+ vdd
+ sky130_fd_sc_hd__fill_2
* cell instance sky130_fd_sc_hd__fill_2_1011 r0 *1 0,0
Xsky130_fd_sc_hd__fill_2_1011
+ vss
+ vdd
+ vdd
+ sky130_fd_sc_hd__fill_2
* cell instance sky130_fd_sc_hd__fill_2_1012 r0 *1 0,0
Xsky130_fd_sc_hd__fill_2_1012
+ vss
+ vdd
+ vdd
+ sky130_fd_sc_hd__fill_2
* cell instance sky130_fd_sc_hd__fill_2_1013 r0 *1 0,0
Xsky130_fd_sc_hd__fill_2_1013
+ vss
+ vdd
+ vdd
+ sky130_fd_sc_hd__fill_2
* cell instance sky130_fd_sc_hd__fill_2_1014 r0 *1 0,0
Xsky130_fd_sc_hd__fill_2_1014
+ vss
+ vdd
+ vdd
+ sky130_fd_sc_hd__fill_2
* cell instance sky130_fd_sc_hd__fill_2_1015 r0 *1 0,0
Xsky130_fd_sc_hd__fill_2_1015
+ vss
+ vdd
+ vdd
+ sky130_fd_sc_hd__fill_2
* cell instance sky130_fd_sc_hd__fill_2_1016 r0 *1 0,0
Xsky130_fd_sc_hd__fill_2_1016
+ vss
+ vdd
+ vdd
+ sky130_fd_sc_hd__fill_2
* cell instance sky130_fd_sc_hd__fill_2_1017 r0 *1 0,0
Xsky130_fd_sc_hd__fill_2_1017
+ vss
+ vdd
+ vdd
+ sky130_fd_sc_hd__fill_2
* cell instance sky130_fd_sc_hd__fill_2_1018 r0 *1 0,0
Xsky130_fd_sc_hd__fill_2_1018
+ vss
+ vdd
+ vdd
+ sky130_fd_sc_hd__fill_2
* cell instance sky130_fd_sc_hd__fill_2_1019 r0 *1 0,0
Xsky130_fd_sc_hd__fill_2_1019
+ vss
+ vdd
+ vdd
+ sky130_fd_sc_hd__fill_2
* cell instance sky130_fd_sc_hd__fill_2_1020 r0 *1 0,0
Xsky130_fd_sc_hd__fill_2_1020
+ vss
+ vdd
+ vdd
+ sky130_fd_sc_hd__fill_2
* cell instance sky130_fd_sc_hd__fill_2_1021 r0 *1 0,0
Xsky130_fd_sc_hd__fill_2_1021
+ vss
+ vdd
+ vdd
+ sky130_fd_sc_hd__fill_2
* cell instance sky130_fd_sc_hd__fill_2_1022 r0 *1 0,0
Xsky130_fd_sc_hd__fill_2_1022
+ vss
+ vdd
+ vdd
+ sky130_fd_sc_hd__fill_2
* cell instance sky130_fd_sc_hd__fill_2_1023 r0 *1 0,0
Xsky130_fd_sc_hd__fill_2_1023
+ vss
+ vdd
+ vdd
+ sky130_fd_sc_hd__fill_2
* cell instance sky130_fd_sc_hd__fill_2_1024 r0 *1 0,0
Xsky130_fd_sc_hd__fill_2_1024
+ vss
+ vdd
+ vdd
+ sky130_fd_sc_hd__fill_2
* cell instance sky130_fd_sc_hd__fill_2_1025 r0 *1 0,0
Xsky130_fd_sc_hd__fill_2_1025
+ vss
+ vdd
+ vdd
+ sky130_fd_sc_hd__fill_2
* cell instance sky130_fd_sc_hd__fill_2_1026 r0 *1 0,0
Xsky130_fd_sc_hd__fill_2_1026
+ vss
+ vdd
+ vdd
+ sky130_fd_sc_hd__fill_2
* cell instance sky130_fd_sc_hd__fill_2_1027 r0 *1 0,0
Xsky130_fd_sc_hd__fill_2_1027
+ vss
+ vdd
+ vdd
+ sky130_fd_sc_hd__fill_2
* cell instance sky130_fd_sc_hd__fill_2_1028 r0 *1 0,0
Xsky130_fd_sc_hd__fill_2_1028
+ vss
+ vdd
+ vdd
+ sky130_fd_sc_hd__fill_2
* cell instance sky130_fd_sc_hd__fill_2_1029 r0 *1 0,0
Xsky130_fd_sc_hd__fill_2_1029
+ vss
+ vdd
+ vdd
+ sky130_fd_sc_hd__fill_2
* cell instance sky130_fd_sc_hd__fill_2_1030 r0 *1 0,0
Xsky130_fd_sc_hd__fill_2_1030
+ vss
+ vdd
+ vdd
+ sky130_fd_sc_hd__fill_2
* cell instance sky130_fd_sc_hd__fill_2_1031 r0 *1 0,0
Xsky130_fd_sc_hd__fill_2_1031
+ vss
+ vdd
+ vdd
+ sky130_fd_sc_hd__fill_2
* cell instance sky130_fd_sc_hd__fill_2_1032 r0 *1 0,0
Xsky130_fd_sc_hd__fill_2_1032
+ vss
+ vdd
+ vdd
+ sky130_fd_sc_hd__fill_2
* cell instance sky130_fd_sc_hd__fill_2_1033 r0 *1 0,0
Xsky130_fd_sc_hd__fill_2_1033
+ vss
+ vdd
+ vdd
+ sky130_fd_sc_hd__fill_2
* cell instance sky130_fd_sc_hd__fill_2_1034 r0 *1 0,0
Xsky130_fd_sc_hd__fill_2_1034
+ vss
+ vdd
+ vdd
+ sky130_fd_sc_hd__fill_2
* cell instance sky130_fd_sc_hd__fill_2_1035 r0 *1 0,0
Xsky130_fd_sc_hd__fill_2_1035
+ vss
+ vdd
+ vdd
+ sky130_fd_sc_hd__fill_2
* cell instance sky130_fd_sc_hd__fill_2_1036 r0 *1 0,0
Xsky130_fd_sc_hd__fill_2_1036
+ vss
+ vdd
+ vdd
+ sky130_fd_sc_hd__fill_2
* cell instance sky130_fd_sc_hd__fill_2_1037 r0 *1 0,0
Xsky130_fd_sc_hd__fill_2_1037
+ vss
+ vdd
+ vdd
+ sky130_fd_sc_hd__fill_2
* cell instance sky130_fd_sc_hd__fill_2_1038 r0 *1 0,0
Xsky130_fd_sc_hd__fill_2_1038
+ vss
+ vdd
+ vdd
+ sky130_fd_sc_hd__fill_2
* cell instance sky130_fd_sc_hd__fill_2_1039 r0 *1 0,0
Xsky130_fd_sc_hd__fill_2_1039
+ vss
+ vdd
+ vdd
+ sky130_fd_sc_hd__fill_2
* cell instance sky130_fd_sc_hd__fill_2_1040 r0 *1 0,0
Xsky130_fd_sc_hd__fill_2_1040
+ vss
+ vdd
+ vdd
+ sky130_fd_sc_hd__fill_2
* cell instance sky130_fd_sc_hd__fill_2_1041 r0 *1 0,0
Xsky130_fd_sc_hd__fill_2_1041
+ vss
+ vdd
+ vdd
+ sky130_fd_sc_hd__fill_2
* cell instance sky130_fd_sc_hd__fill_2_1042 r0 *1 0,0
Xsky130_fd_sc_hd__fill_2_1042
+ vss
+ vdd
+ vdd
+ sky130_fd_sc_hd__fill_2
* cell instance sky130_fd_sc_hd__fill_2_1043 r0 *1 0,0
Xsky130_fd_sc_hd__fill_2_1043
+ vss
+ vdd
+ vdd
+ sky130_fd_sc_hd__fill_2
* cell instance sky130_fd_sc_hd__fill_2_1044 r0 *1 0,0
Xsky130_fd_sc_hd__fill_2_1044
+ vss
+ vdd
+ vdd
+ sky130_fd_sc_hd__fill_2
* cell instance sky130_fd_sc_hd__fill_2_1045 r0 *1 0,0
Xsky130_fd_sc_hd__fill_2_1045
+ vss
+ vdd
+ vdd
+ sky130_fd_sc_hd__fill_2
* cell instance sky130_fd_sc_hd__fill_2_1046 r0 *1 0,0
Xsky130_fd_sc_hd__fill_2_1046
+ vss
+ vdd
+ vdd
+ sky130_fd_sc_hd__fill_2
* cell instance sky130_fd_sc_hd__fill_2_1047 r0 *1 0,0
Xsky130_fd_sc_hd__fill_2_1047
+ vss
+ vdd
+ vdd
+ sky130_fd_sc_hd__fill_2
* cell instance sky130_fd_sc_hd__fill_2_1048 r0 *1 0,0
Xsky130_fd_sc_hd__fill_2_1048
+ vss
+ vdd
+ vdd
+ sky130_fd_sc_hd__fill_2
* cell instance sky130_fd_sc_hd__fill_2_1049 r0 *1 0,0
Xsky130_fd_sc_hd__fill_2_1049
+ vss
+ vdd
+ vdd
+ sky130_fd_sc_hd__fill_2
* cell instance sky130_fd_sc_hd__fill_2_1050 r0 *1 0,0
Xsky130_fd_sc_hd__fill_2_1050
+ vss
+ vdd
+ vdd
+ sky130_fd_sc_hd__fill_2
* cell instance sky130_fd_sc_hd__fill_2_1051 r0 *1 0,0
Xsky130_fd_sc_hd__fill_2_1051
+ vss
+ vdd
+ vdd
+ sky130_fd_sc_hd__fill_2
* cell instance sky130_fd_sc_hd__fill_2_1052 r0 *1 0,0
Xsky130_fd_sc_hd__fill_2_1052
+ vss
+ vdd
+ vdd
+ sky130_fd_sc_hd__fill_2
* cell instance sky130_fd_sc_hd__fill_2_1053 r0 *1 0,0
Xsky130_fd_sc_hd__fill_2_1053
+ vss
+ vdd
+ vdd
+ sky130_fd_sc_hd__fill_2
* cell instance sky130_fd_sc_hd__fill_2_1054 r0 *1 0,0
Xsky130_fd_sc_hd__fill_2_1054
+ vss
+ vdd
+ vdd
+ sky130_fd_sc_hd__fill_2
* cell instance sky130_fd_sc_hd__fill_2_1055 r0 *1 0,0
Xsky130_fd_sc_hd__fill_2_1055
+ vss
+ vdd
+ vdd
+ sky130_fd_sc_hd__fill_2
* cell instance sky130_fd_sc_hd__fill_2_1056 r0 *1 0,0
Xsky130_fd_sc_hd__fill_2_1056
+ vss
+ vdd
+ vdd
+ sky130_fd_sc_hd__fill_2
* cell instance sky130_fd_sc_hd__fill_2_1057 r0 *1 0,0
Xsky130_fd_sc_hd__fill_2_1057
+ vss
+ vdd
+ vdd
+ sky130_fd_sc_hd__fill_2
* cell instance sky130_fd_sc_hd__fill_2_1058 r0 *1 0,0
Xsky130_fd_sc_hd__fill_2_1058
+ vss
+ vdd
+ vdd
+ sky130_fd_sc_hd__fill_2
* cell instance sky130_fd_sc_hd__fill_2_1059 r0 *1 0,0
Xsky130_fd_sc_hd__fill_2_1059
+ vss
+ vdd
+ vdd
+ sky130_fd_sc_hd__fill_2
* cell instance sky130_fd_sc_hd__fill_2_1060 r0 *1 0,0
Xsky130_fd_sc_hd__fill_2_1060
+ vss
+ vdd
+ vdd
+ sky130_fd_sc_hd__fill_2
* cell instance sky130_fd_sc_hd__fill_2_1061 r0 *1 0,0
Xsky130_fd_sc_hd__fill_2_1061
+ vss
+ vdd
+ vdd
+ sky130_fd_sc_hd__fill_2
* cell instance sky130_fd_sc_hd__fill_2_1062 r0 *1 0,0
Xsky130_fd_sc_hd__fill_2_1062
+ vss
+ vdd
+ vdd
+ sky130_fd_sc_hd__fill_2
* cell instance sky130_fd_sc_hd__fill_2_1063 r0 *1 0,0
Xsky130_fd_sc_hd__fill_2_1063
+ vss
+ vdd
+ vdd
+ sky130_fd_sc_hd__fill_2
* cell instance sky130_fd_sc_hd__fill_2_1064 r0 *1 0,0
Xsky130_fd_sc_hd__fill_2_1064
+ vss
+ vdd
+ vdd
+ sky130_fd_sc_hd__fill_2
* cell instance sky130_fd_sc_hd__fill_2_1065 r0 *1 0,0
Xsky130_fd_sc_hd__fill_2_1065
+ vss
+ vdd
+ vdd
+ sky130_fd_sc_hd__fill_2
* cell instance sky130_fd_sc_hd__fill_2_1066 r0 *1 0,0
Xsky130_fd_sc_hd__fill_2_1066
+ vss
+ vdd
+ vdd
+ sky130_fd_sc_hd__fill_2
* cell instance sky130_fd_sc_hd__fill_2_1067 r0 *1 0,0
Xsky130_fd_sc_hd__fill_2_1067
+ vss
+ vdd
+ vdd
+ sky130_fd_sc_hd__fill_2
* cell instance sky130_fd_sc_hd__fill_2_1068 r0 *1 0,0
Xsky130_fd_sc_hd__fill_2_1068
+ vss
+ vdd
+ vdd
+ sky130_fd_sc_hd__fill_2
* cell instance sky130_fd_sc_hd__fill_2_1069 r0 *1 0,0
Xsky130_fd_sc_hd__fill_2_1069
+ vss
+ vdd
+ vdd
+ sky130_fd_sc_hd__fill_2
* cell instance sky130_fd_sc_hd__fill_2_1070 r0 *1 0,0
Xsky130_fd_sc_hd__fill_2_1070
+ vss
+ vdd
+ vdd
+ sky130_fd_sc_hd__fill_2
* cell instance sky130_fd_sc_hd__fill_2_1071 r0 *1 0,0
Xsky130_fd_sc_hd__fill_2_1071
+ vss
+ vdd
+ vdd
+ sky130_fd_sc_hd__fill_2
* cell instance sky130_fd_sc_hd__fill_2_1072 r0 *1 0,0
Xsky130_fd_sc_hd__fill_2_1072
+ vss
+ vdd
+ vdd
+ sky130_fd_sc_hd__fill_2
* cell instance sky130_fd_sc_hd__fill_2_1073 r0 *1 0,0
Xsky130_fd_sc_hd__fill_2_1073
+ vss
+ vdd
+ vdd
+ sky130_fd_sc_hd__fill_2
* cell instance sky130_fd_sc_hd__fill_2_1074 r0 *1 0,0
Xsky130_fd_sc_hd__fill_2_1074
+ vss
+ vdd
+ vdd
+ sky130_fd_sc_hd__fill_2
* cell instance sky130_fd_sc_hd__fill_2_1075 r0 *1 0,0
Xsky130_fd_sc_hd__fill_2_1075
+ vss
+ vdd
+ vdd
+ sky130_fd_sc_hd__fill_2
* cell instance sky130_fd_sc_hd__fill_2_1076 r0 *1 0,0
Xsky130_fd_sc_hd__fill_2_1076
+ vss
+ vdd
+ vdd
+ sky130_fd_sc_hd__fill_2
* cell instance sky130_fd_sc_hd__fill_2_1077 r0 *1 0,0
Xsky130_fd_sc_hd__fill_2_1077
+ vss
+ vdd
+ vdd
+ sky130_fd_sc_hd__fill_2
* cell instance sky130_fd_sc_hd__fill_2_1078 r0 *1 0,0
Xsky130_fd_sc_hd__fill_2_1078
+ vss
+ vdd
+ vdd
+ sky130_fd_sc_hd__fill_2
* cell instance sky130_fd_sc_hd__fill_2_1079 r0 *1 0,0
Xsky130_fd_sc_hd__fill_2_1079
+ vss
+ vdd
+ vdd
+ sky130_fd_sc_hd__fill_2
* cell instance sky130_fd_sc_hd__fill_2_1080 r0 *1 0,0
Xsky130_fd_sc_hd__fill_2_1080
+ vss
+ vdd
+ vdd
+ sky130_fd_sc_hd__fill_2
* cell instance sky130_fd_sc_hd__fill_2_1081 r0 *1 0,0
Xsky130_fd_sc_hd__fill_2_1081
+ vss
+ vdd
+ vdd
+ sky130_fd_sc_hd__fill_2
* cell instance sky130_fd_sc_hd__fill_2_1082 r0 *1 0,0
Xsky130_fd_sc_hd__fill_2_1082
+ vss
+ vdd
+ vdd
+ sky130_fd_sc_hd__fill_2
* cell instance sky130_fd_sc_hd__fill_2_1083 r0 *1 0,0
Xsky130_fd_sc_hd__fill_2_1083
+ vss
+ vdd
+ vdd
+ sky130_fd_sc_hd__fill_2
* cell instance sky130_fd_sc_hd__fill_2_1084 r0 *1 0,0
Xsky130_fd_sc_hd__fill_2_1084
+ vss
+ vdd
+ vdd
+ sky130_fd_sc_hd__fill_2
* cell instance sky130_fd_sc_hd__fill_2_1085 r0 *1 0,0
Xsky130_fd_sc_hd__fill_2_1085
+ vss
+ vdd
+ vdd
+ sky130_fd_sc_hd__fill_2
* cell instance sky130_fd_sc_hd__fill_2_1086 r0 *1 0,0
Xsky130_fd_sc_hd__fill_2_1086
+ vss
+ vdd
+ vdd
+ sky130_fd_sc_hd__fill_2
* cell instance sky130_fd_sc_hd__fill_2_1087 r0 *1 0,0
Xsky130_fd_sc_hd__fill_2_1087
+ vss
+ vdd
+ vdd
+ sky130_fd_sc_hd__fill_2
* cell instance sky130_fd_sc_hd__fill_2_1088 r0 *1 0,0
Xsky130_fd_sc_hd__fill_2_1088
+ vss
+ vdd
+ vdd
+ sky130_fd_sc_hd__fill_2
* cell instance sky130_fd_sc_hd__fill_2_1089 r0 *1 0,0
Xsky130_fd_sc_hd__fill_2_1089
+ vss
+ vdd
+ vdd
+ sky130_fd_sc_hd__fill_2
* cell instance sky130_fd_sc_hd__fill_2_1090 r0 *1 0,0
Xsky130_fd_sc_hd__fill_2_1090
+ vss
+ vdd
+ vdd
+ sky130_fd_sc_hd__fill_2
* cell instance sky130_fd_sc_hd__fill_2_1091 r0 *1 0,0
Xsky130_fd_sc_hd__fill_2_1091
+ vss
+ vdd
+ vdd
+ sky130_fd_sc_hd__fill_2
* cell instance sky130_fd_sc_hd__fill_2_1092 r0 *1 0,0
Xsky130_fd_sc_hd__fill_2_1092
+ vss
+ vdd
+ vdd
+ sky130_fd_sc_hd__fill_2
* cell instance sky130_fd_sc_hd__fill_2_1093 r0 *1 0,0
Xsky130_fd_sc_hd__fill_2_1093
+ vss
+ vdd
+ vdd
+ sky130_fd_sc_hd__fill_2
* cell instance sky130_fd_sc_hd__fill_2_1094 r0 *1 0,0
Xsky130_fd_sc_hd__fill_2_1094
+ vss
+ vdd
+ vdd
+ sky130_fd_sc_hd__fill_2
* cell instance sky130_fd_sc_hd__fill_2_1095 r0 *1 0,0
Xsky130_fd_sc_hd__fill_2_1095
+ vss
+ vdd
+ vdd
+ sky130_fd_sc_hd__fill_2
* cell instance sky130_fd_sc_hd__fill_2_1096 r0 *1 0,0
Xsky130_fd_sc_hd__fill_2_1096
+ vss
+ vdd
+ vdd
+ sky130_fd_sc_hd__fill_2
* cell instance sky130_fd_sc_hd__fill_2_1097 r0 *1 0,0
Xsky130_fd_sc_hd__fill_2_1097
+ vss
+ vdd
+ vdd
+ sky130_fd_sc_hd__fill_2
* cell instance sky130_fd_sc_hd__fill_2_1098 r0 *1 0,0
Xsky130_fd_sc_hd__fill_2_1098
+ vss
+ vdd
+ vdd
+ sky130_fd_sc_hd__fill_2
* cell instance sky130_fd_sc_hd__fill_2_1099 r0 *1 0,0
Xsky130_fd_sc_hd__fill_2_1099
+ vss
+ vdd
+ vdd
+ sky130_fd_sc_hd__fill_2
* cell instance sky130_fd_sc_hd__fill_2_1100 r0 *1 0,0
Xsky130_fd_sc_hd__fill_2_1100
+ vss
+ vdd
+ vdd
+ sky130_fd_sc_hd__fill_2
* cell instance sky130_fd_sc_hd__fill_2_1101 r0 *1 0,0
Xsky130_fd_sc_hd__fill_2_1101
+ vss
+ vdd
+ vdd
+ sky130_fd_sc_hd__fill_2
* cell instance sky130_fd_sc_hd__fill_2_1102 r0 *1 0,0
Xsky130_fd_sc_hd__fill_2_1102
+ vss
+ vdd
+ vdd
+ sky130_fd_sc_hd__fill_2
* cell instance sky130_fd_sc_hd__fill_2_1103 r0 *1 0,0
Xsky130_fd_sc_hd__fill_2_1103
+ vss
+ vdd
+ vdd
+ sky130_fd_sc_hd__fill_2
* cell instance sky130_fd_sc_hd__fill_2_1104 r0 *1 0,0
Xsky130_fd_sc_hd__fill_2_1104
+ vss
+ vdd
+ vdd
+ sky130_fd_sc_hd__fill_2
* cell instance sky130_fd_sc_hd__fill_2_1105 r0 *1 0,0
Xsky130_fd_sc_hd__fill_2_1105
+ vss
+ vdd
+ vdd
+ sky130_fd_sc_hd__fill_2
* cell instance sky130_fd_sc_hd__fill_2_1106 r0 *1 0,0
Xsky130_fd_sc_hd__fill_2_1106
+ vss
+ vdd
+ vdd
+ sky130_fd_sc_hd__fill_2
* cell instance sky130_fd_sc_hd__fill_2_1107 r0 *1 0,0
Xsky130_fd_sc_hd__fill_2_1107
+ vss
+ vdd
+ vdd
+ sky130_fd_sc_hd__fill_2
* cell instance sky130_fd_sc_hd__fill_2_1108 r0 *1 0,0
Xsky130_fd_sc_hd__fill_2_1108
+ vss
+ vdd
+ vdd
+ sky130_fd_sc_hd__fill_2
* cell instance sky130_fd_sc_hd__fill_2_1109 r0 *1 0,0
Xsky130_fd_sc_hd__fill_2_1109
+ vss
+ vdd
+ vdd
+ sky130_fd_sc_hd__fill_2
* cell instance sky130_fd_sc_hd__fill_2_1110 r0 *1 0,0
Xsky130_fd_sc_hd__fill_2_1110
+ vss
+ vdd
+ vdd
+ sky130_fd_sc_hd__fill_2
* cell instance sky130_fd_sc_hd__fill_2_1111 r0 *1 0,0
Xsky130_fd_sc_hd__fill_2_1111
+ vss
+ vdd
+ vdd
+ sky130_fd_sc_hd__fill_2
* cell instance sky130_fd_sc_hd__fill_2_1112 r0 *1 0,0
Xsky130_fd_sc_hd__fill_2_1112
+ vss
+ vdd
+ vdd
+ sky130_fd_sc_hd__fill_2
* cell instance sky130_fd_sc_hd__fill_2_1113 r0 *1 0,0
Xsky130_fd_sc_hd__fill_2_1113
+ vss
+ vdd
+ vdd
+ sky130_fd_sc_hd__fill_2
* cell instance sky130_fd_sc_hd__fill_2_1114 r0 *1 0,0
Xsky130_fd_sc_hd__fill_2_1114
+ vss
+ vdd
+ vdd
+ sky130_fd_sc_hd__fill_2
* cell instance sky130_fd_sc_hd__fill_2_1115 r0 *1 0,0
Xsky130_fd_sc_hd__fill_2_1115
+ vss
+ vdd
+ vdd
+ sky130_fd_sc_hd__fill_2
* cell instance sky130_fd_sc_hd__fill_2_1116 r0 *1 0,0
Xsky130_fd_sc_hd__fill_2_1116
+ vss
+ vdd
+ vdd
+ sky130_fd_sc_hd__fill_2
* cell instance sky130_fd_sc_hd__fill_2_1117 r0 *1 0,0
Xsky130_fd_sc_hd__fill_2_1117
+ vss
+ vdd
+ vdd
+ sky130_fd_sc_hd__fill_2
* cell instance sky130_fd_sc_hd__fill_2_1118 r0 *1 0,0
Xsky130_fd_sc_hd__fill_2_1118
+ vss
+ vdd
+ vdd
+ sky130_fd_sc_hd__fill_2
* cell instance sky130_fd_sc_hd__fill_2_1119 r0 *1 0,0
Xsky130_fd_sc_hd__fill_2_1119
+ vss
+ vdd
+ vdd
+ sky130_fd_sc_hd__fill_2
* cell instance sky130_fd_sc_hd__fill_2_1120 r0 *1 0,0
Xsky130_fd_sc_hd__fill_2_1120
+ vss
+ vdd
+ vdd
+ sky130_fd_sc_hd__fill_2
* cell instance sky130_fd_sc_hd__fill_2_1121 r0 *1 0,0
Xsky130_fd_sc_hd__fill_2_1121
+ vss
+ vdd
+ vdd
+ sky130_fd_sc_hd__fill_2
* cell instance sky130_fd_sc_hd__fill_4_0 r0 *1 0,0
Xsky130_fd_sc_hd__fill_4_0
+ vss
+ vdd
+ vdd
+ sky130_fd_sc_hd__fill_4
* cell instance sky130_fd_sc_hd__fill_4_1 r0 *1 0,0
Xsky130_fd_sc_hd__fill_4_1
+ vss
+ vdd
+ vdd
+ sky130_fd_sc_hd__fill_4
* cell instance sky130_fd_sc_hd__fill_4_2 r0 *1 0,0
Xsky130_fd_sc_hd__fill_4_2
+ vss
+ vdd
+ vdd
+ sky130_fd_sc_hd__fill_4
* cell instance sky130_fd_sc_hd__fill_4_3 r0 *1 0,0
Xsky130_fd_sc_hd__fill_4_3
+ vss
+ vdd
+ vdd
+ sky130_fd_sc_hd__fill_4
* cell instance sky130_fd_sc_hd__fill_4_4 r0 *1 0,0
Xsky130_fd_sc_hd__fill_4_4
+ vss
+ vdd
+ vdd
+ sky130_fd_sc_hd__fill_4
* cell instance sky130_fd_sc_hd__fill_4_5 r0 *1 0,0
Xsky130_fd_sc_hd__fill_4_5
+ vss
+ vdd
+ vdd
+ sky130_fd_sc_hd__fill_4
* cell instance sky130_fd_sc_hd__fill_4_6 r0 *1 0,0
Xsky130_fd_sc_hd__fill_4_6
+ vss
+ vdd
+ vdd
+ sky130_fd_sc_hd__fill_4
* cell instance sky130_fd_sc_hd__fill_4_7 r0 *1 0,0
Xsky130_fd_sc_hd__fill_4_7
+ vss
+ vdd
+ vdd
+ sky130_fd_sc_hd__fill_4
* cell instance sky130_fd_sc_hd__fill_4_8 r0 *1 0,0
Xsky130_fd_sc_hd__fill_4_8
+ vss
+ vdd
+ vdd
+ sky130_fd_sc_hd__fill_4
* cell instance sky130_fd_sc_hd__fill_4_9 r0 *1 0,0
Xsky130_fd_sc_hd__fill_4_9
+ vss
+ vdd
+ vdd
+ sky130_fd_sc_hd__fill_4
* cell instance sky130_fd_sc_hd__fill_4_10 r0 *1 0,0
Xsky130_fd_sc_hd__fill_4_10
+ vss
+ vdd
+ vdd
+ sky130_fd_sc_hd__fill_4
* cell instance sky130_fd_sc_hd__fill_4_11 r0 *1 0,0
Xsky130_fd_sc_hd__fill_4_11
+ vss
+ vdd
+ vdd
+ sky130_fd_sc_hd__fill_4
* cell instance sky130_fd_sc_hd__fill_4_12 r0 *1 0,0
Xsky130_fd_sc_hd__fill_4_12
+ vss
+ vdd
+ vdd
+ sky130_fd_sc_hd__fill_4
* cell instance sky130_fd_sc_hd__fill_4_13 r0 *1 0,0
Xsky130_fd_sc_hd__fill_4_13
+ vss
+ vdd
+ vdd
+ sky130_fd_sc_hd__fill_4
* cell instance sky130_fd_sc_hd__fill_4_14 r0 *1 0,0
Xsky130_fd_sc_hd__fill_4_14
+ vss
+ vdd
+ vdd
+ sky130_fd_sc_hd__fill_4
* cell instance sky130_fd_sc_hd__fill_4_15 r0 *1 0,0
Xsky130_fd_sc_hd__fill_4_15
+ vss
+ vdd
+ vdd
+ sky130_fd_sc_hd__fill_4
* cell instance sky130_fd_sc_hd__fill_4_16 r0 *1 0,0
Xsky130_fd_sc_hd__fill_4_16
+ vss
+ vdd
+ vdd
+ sky130_fd_sc_hd__fill_4
* cell instance sky130_fd_sc_hd__fill_4_17 r0 *1 0,0
Xsky130_fd_sc_hd__fill_4_17
+ vss
+ vdd
+ vdd
+ sky130_fd_sc_hd__fill_4
* cell instance sky130_fd_sc_hd__fill_4_18 r0 *1 0,0
Xsky130_fd_sc_hd__fill_4_18
+ vss
+ vdd
+ vdd
+ sky130_fd_sc_hd__fill_4
* cell instance sky130_fd_sc_hd__fill_4_19 r0 *1 0,0
Xsky130_fd_sc_hd__fill_4_19
+ vss
+ vdd
+ vdd
+ sky130_fd_sc_hd__fill_4
* cell instance sky130_fd_sc_hd__fill_4_20 r0 *1 0,0
Xsky130_fd_sc_hd__fill_4_20
+ vss
+ vdd
+ vdd
+ sky130_fd_sc_hd__fill_4
* cell instance sky130_fd_sc_hd__fill_4_21 r0 *1 0,0
Xsky130_fd_sc_hd__fill_4_21
+ vss
+ vdd
+ vdd
+ sky130_fd_sc_hd__fill_4
* cell instance sky130_fd_sc_hd__fill_4_22 r0 *1 0,0
Xsky130_fd_sc_hd__fill_4_22
+ vss
+ vdd
+ vdd
+ sky130_fd_sc_hd__fill_4
* cell instance sky130_fd_sc_hd__fill_4_23 r0 *1 0,0
Xsky130_fd_sc_hd__fill_4_23
+ vss
+ vdd
+ vdd
+ sky130_fd_sc_hd__fill_4
* cell instance sky130_fd_sc_hd__fill_4_24 r0 *1 0,0
Xsky130_fd_sc_hd__fill_4_24
+ vss
+ vdd
+ vdd
+ sky130_fd_sc_hd__fill_4
* cell instance sky130_fd_sc_hd__fill_4_25 r0 *1 0,0
Xsky130_fd_sc_hd__fill_4_25
+ vss
+ vdd
+ vdd
+ sky130_fd_sc_hd__fill_4
* cell instance sky130_fd_sc_hd__fill_4_26 r0 *1 0,0
Xsky130_fd_sc_hd__fill_4_26
+ vss
+ vdd
+ vdd
+ sky130_fd_sc_hd__fill_4
* cell instance sky130_fd_sc_hd__fill_4_27 r0 *1 0,0
Xsky130_fd_sc_hd__fill_4_27
+ vss
+ vdd
+ vdd
+ sky130_fd_sc_hd__fill_4
* cell instance sky130_fd_sc_hd__fill_4_28 r0 *1 0,0
Xsky130_fd_sc_hd__fill_4_28
+ vss
+ vdd
+ vdd
+ sky130_fd_sc_hd__fill_4
* cell instance sky130_fd_sc_hd__fill_4_29 r0 *1 0,0
Xsky130_fd_sc_hd__fill_4_29
+ vss
+ vdd
+ vdd
+ sky130_fd_sc_hd__fill_4
* cell instance sky130_fd_sc_hd__fill_4_30 r0 *1 0,0
Xsky130_fd_sc_hd__fill_4_30
+ vss
+ vdd
+ vdd
+ sky130_fd_sc_hd__fill_4
* cell instance sky130_fd_sc_hd__fill_4_31 r0 *1 0,0
Xsky130_fd_sc_hd__fill_4_31
+ vss
+ vdd
+ vdd
+ sky130_fd_sc_hd__fill_4
* cell instance sky130_fd_sc_hd__fill_4_32 r0 *1 0,0
Xsky130_fd_sc_hd__fill_4_32
+ vss
+ vdd
+ vdd
+ sky130_fd_sc_hd__fill_4
* cell instance sky130_fd_sc_hd__fill_4_33 r0 *1 0,0
Xsky130_fd_sc_hd__fill_4_33
+ vss
+ vdd
+ vdd
+ sky130_fd_sc_hd__fill_4
* cell instance sky130_fd_sc_hd__fill_4_34 r0 *1 0,0
Xsky130_fd_sc_hd__fill_4_34
+ vss
+ vdd
+ vdd
+ sky130_fd_sc_hd__fill_4
* cell instance sky130_fd_sc_hd__fill_4_35 r0 *1 0,0
Xsky130_fd_sc_hd__fill_4_35
+ vss
+ vdd
+ vdd
+ sky130_fd_sc_hd__fill_4
* cell instance sky130_fd_sc_hd__fill_4_36 r0 *1 0,0
Xsky130_fd_sc_hd__fill_4_36
+ vss
+ vdd
+ vdd
+ sky130_fd_sc_hd__fill_4
* cell instance sky130_fd_sc_hd__fill_4_37 r0 *1 0,0
Xsky130_fd_sc_hd__fill_4_37
+ vss
+ vdd
+ vdd
+ sky130_fd_sc_hd__fill_4
* cell instance sky130_fd_sc_hd__fill_4_38 r0 *1 0,0
Xsky130_fd_sc_hd__fill_4_38
+ vss
+ vdd
+ vdd
+ sky130_fd_sc_hd__fill_4
* cell instance sky130_fd_sc_hd__fill_4_39 r0 *1 0,0
Xsky130_fd_sc_hd__fill_4_39
+ vss
+ vdd
+ vdd
+ sky130_fd_sc_hd__fill_4
* cell instance sky130_fd_sc_hd__fill_4_40 r0 *1 0,0
Xsky130_fd_sc_hd__fill_4_40
+ vss
+ vdd
+ vdd
+ sky130_fd_sc_hd__fill_4
* cell instance sky130_fd_sc_hd__fill_4_41 r0 *1 0,0
Xsky130_fd_sc_hd__fill_4_41
+ vss
+ vdd
+ vdd
+ sky130_fd_sc_hd__fill_4
* cell instance sky130_fd_sc_hd__fill_4_42 r0 *1 0,0
Xsky130_fd_sc_hd__fill_4_42
+ vss
+ vdd
+ vdd
+ sky130_fd_sc_hd__fill_4
* cell instance sky130_fd_sc_hd__fill_4_43 r0 *1 0,0
Xsky130_fd_sc_hd__fill_4_43
+ vss
+ vdd
+ vdd
+ sky130_fd_sc_hd__fill_4
* cell instance sky130_fd_sc_hd__fill_4_44 r0 *1 0,0
Xsky130_fd_sc_hd__fill_4_44
+ vss
+ vdd
+ vdd
+ sky130_fd_sc_hd__fill_4
* cell instance sky130_fd_sc_hd__fill_4_45 r0 *1 0,0
Xsky130_fd_sc_hd__fill_4_45
+ vss
+ vdd
+ vdd
+ sky130_fd_sc_hd__fill_4
* cell instance sky130_fd_sc_hd__fill_4_46 r0 *1 0,0
Xsky130_fd_sc_hd__fill_4_46
+ vss
+ vdd
+ vdd
+ sky130_fd_sc_hd__fill_4
* cell instance sky130_fd_sc_hd__fill_4_47 r0 *1 0,0
Xsky130_fd_sc_hd__fill_4_47
+ vss
+ vdd
+ vdd
+ sky130_fd_sc_hd__fill_4
* cell instance sky130_fd_sc_hd__fill_4_48 r0 *1 0,0
Xsky130_fd_sc_hd__fill_4_48
+ vss
+ vdd
+ vdd
+ sky130_fd_sc_hd__fill_4
* cell instance sky130_fd_sc_hd__fill_4_49 r0 *1 0,0
Xsky130_fd_sc_hd__fill_4_49
+ vss
+ vdd
+ vdd
+ sky130_fd_sc_hd__fill_4
* cell instance sky130_fd_sc_hd__fill_4_50 r0 *1 0,0
Xsky130_fd_sc_hd__fill_4_50
+ vss
+ vdd
+ vdd
+ sky130_fd_sc_hd__fill_4
* cell instance sky130_fd_sc_hd__fill_4_51 r0 *1 0,0
Xsky130_fd_sc_hd__fill_4_51
+ vss
+ vdd
+ vdd
+ sky130_fd_sc_hd__fill_4
* cell instance sky130_fd_sc_hd__fill_4_52 r0 *1 0,0
Xsky130_fd_sc_hd__fill_4_52
+ vss
+ vdd
+ vdd
+ sky130_fd_sc_hd__fill_4
* cell instance sky130_fd_sc_hd__fill_4_53 r0 *1 0,0
Xsky130_fd_sc_hd__fill_4_53
+ vss
+ vdd
+ vdd
+ sky130_fd_sc_hd__fill_4
* cell instance sky130_fd_sc_hd__fill_4_54 r0 *1 0,0
Xsky130_fd_sc_hd__fill_4_54
+ vss
+ vdd
+ vdd
+ sky130_fd_sc_hd__fill_4
* cell instance sky130_fd_sc_hd__fill_4_55 r0 *1 0,0
Xsky130_fd_sc_hd__fill_4_55
+ vss
+ vdd
+ vdd
+ sky130_fd_sc_hd__fill_4
* cell instance sky130_fd_sc_hd__fill_4_56 r0 *1 0,0
Xsky130_fd_sc_hd__fill_4_56
+ vss
+ vdd
+ vdd
+ sky130_fd_sc_hd__fill_4
* cell instance sky130_fd_sc_hd__fill_4_57 r0 *1 0,0
Xsky130_fd_sc_hd__fill_4_57
+ vss
+ vdd
+ vdd
+ sky130_fd_sc_hd__fill_4
* cell instance sky130_fd_sc_hd__fill_4_58 r0 *1 0,0
Xsky130_fd_sc_hd__fill_4_58
+ vss
+ vdd
+ vdd
+ sky130_fd_sc_hd__fill_4
* cell instance sky130_fd_sc_hd__fill_4_59 r0 *1 0,0
Xsky130_fd_sc_hd__fill_4_59
+ vss
+ vdd
+ vdd
+ sky130_fd_sc_hd__fill_4
* cell instance sky130_fd_sc_hd__fill_4_60 r0 *1 0,0
Xsky130_fd_sc_hd__fill_4_60
+ vss
+ vdd
+ vdd
+ sky130_fd_sc_hd__fill_4
* cell instance sky130_fd_sc_hd__fill_4_61 r0 *1 0,0
Xsky130_fd_sc_hd__fill_4_61
+ vss
+ vdd
+ vdd
+ sky130_fd_sc_hd__fill_4
* cell instance sky130_fd_sc_hd__fill_4_62 r0 *1 0,0
Xsky130_fd_sc_hd__fill_4_62
+ vss
+ vdd
+ vdd
+ sky130_fd_sc_hd__fill_4
* cell instance sky130_fd_sc_hd__fill_4_63 r0 *1 0,0
Xsky130_fd_sc_hd__fill_4_63
+ vss
+ vdd
+ vdd
+ sky130_fd_sc_hd__fill_4
* cell instance sky130_fd_sc_hd__fill_4_64 r0 *1 0,0
Xsky130_fd_sc_hd__fill_4_64
+ vss
+ vdd
+ vdd
+ sky130_fd_sc_hd__fill_4
* cell instance sky130_fd_sc_hd__fill_4_65 r0 *1 0,0
Xsky130_fd_sc_hd__fill_4_65
+ vss
+ vdd
+ vdd
+ sky130_fd_sc_hd__fill_4
* cell instance sky130_fd_sc_hd__fill_4_66 r0 *1 0,0
Xsky130_fd_sc_hd__fill_4_66
+ vss
+ vdd
+ vdd
+ sky130_fd_sc_hd__fill_4
* cell instance sky130_fd_sc_hd__fill_4_67 r0 *1 0,0
Xsky130_fd_sc_hd__fill_4_67
+ vss
+ vdd
+ vdd
+ sky130_fd_sc_hd__fill_4
* cell instance sky130_fd_sc_hd__fill_4_68 r0 *1 0,0
Xsky130_fd_sc_hd__fill_4_68
+ vss
+ vdd
+ vdd
+ sky130_fd_sc_hd__fill_4
* cell instance sky130_fd_sc_hd__fill_4_69 r0 *1 0,0
Xsky130_fd_sc_hd__fill_4_69
+ vss
+ vdd
+ vdd
+ sky130_fd_sc_hd__fill_4
* cell instance sky130_fd_sc_hd__fill_4_70 r0 *1 0,0
Xsky130_fd_sc_hd__fill_4_70
+ vss
+ vdd
+ vdd
+ sky130_fd_sc_hd__fill_4
* cell instance sky130_fd_sc_hd__fill_4_71 r0 *1 0,0
Xsky130_fd_sc_hd__fill_4_71
+ vss
+ vdd
+ vdd
+ sky130_fd_sc_hd__fill_4
* cell instance sky130_fd_sc_hd__fill_4_72 r0 *1 0,0
Xsky130_fd_sc_hd__fill_4_72
+ vss
+ vdd
+ vdd
+ sky130_fd_sc_hd__fill_4
* cell instance sky130_fd_sc_hd__fill_4_73 r0 *1 0,0
Xsky130_fd_sc_hd__fill_4_73
+ vss
+ vdd
+ vdd
+ sky130_fd_sc_hd__fill_4
* cell instance sky130_fd_sc_hd__fill_4_74 r0 *1 0,0
Xsky130_fd_sc_hd__fill_4_74
+ vss
+ vdd
+ vdd
+ sky130_fd_sc_hd__fill_4
* cell instance sky130_fd_sc_hd__fill_4_75 r0 *1 0,0
Xsky130_fd_sc_hd__fill_4_75
+ vss
+ vdd
+ vdd
+ sky130_fd_sc_hd__fill_4
* cell instance sky130_fd_sc_hd__fill_4_76 r0 *1 0,0
Xsky130_fd_sc_hd__fill_4_76
+ vss
+ vdd
+ vdd
+ sky130_fd_sc_hd__fill_4
* cell instance sky130_fd_sc_hd__fill_4_77 r0 *1 0,0
Xsky130_fd_sc_hd__fill_4_77
+ vss
+ vdd
+ vdd
+ sky130_fd_sc_hd__fill_4
* cell instance sky130_fd_sc_hd__fill_4_78 r0 *1 0,0
Xsky130_fd_sc_hd__fill_4_78
+ vss
+ vdd
+ vdd
+ sky130_fd_sc_hd__fill_4
* cell instance sky130_fd_sc_hd__fill_4_79 r0 *1 0,0
Xsky130_fd_sc_hd__fill_4_79
+ vss
+ vdd
+ vdd
+ sky130_fd_sc_hd__fill_4
* cell instance sky130_fd_sc_hd__fill_4_80 r0 *1 0,0
Xsky130_fd_sc_hd__fill_4_80
+ vss
+ vdd
+ vdd
+ sky130_fd_sc_hd__fill_4
* cell instance sky130_fd_sc_hd__fill_4_81 r0 *1 0,0
Xsky130_fd_sc_hd__fill_4_81
+ vss
+ vdd
+ vdd
+ sky130_fd_sc_hd__fill_4
* cell instance sky130_fd_sc_hd__fill_4_82 r0 *1 0,0
Xsky130_fd_sc_hd__fill_4_82
+ vss
+ vdd
+ vdd
+ sky130_fd_sc_hd__fill_4
* cell instance sky130_fd_sc_hd__fill_4_83 r0 *1 0,0
Xsky130_fd_sc_hd__fill_4_83
+ vss
+ vdd
+ vdd
+ sky130_fd_sc_hd__fill_4
* cell instance sky130_fd_sc_hd__fill_4_84 r0 *1 0,0
Xsky130_fd_sc_hd__fill_4_84
+ vss
+ vdd
+ vdd
+ sky130_fd_sc_hd__fill_4
* cell instance sky130_fd_sc_hd__fill_4_85 r0 *1 0,0
Xsky130_fd_sc_hd__fill_4_85
+ vss
+ vdd
+ vdd
+ sky130_fd_sc_hd__fill_4
* cell instance sky130_fd_sc_hd__fill_4_86 r0 *1 0,0
Xsky130_fd_sc_hd__fill_4_86
+ vss
+ vdd
+ vdd
+ sky130_fd_sc_hd__fill_4
* cell instance sky130_fd_sc_hd__fill_4_87 r0 *1 0,0
Xsky130_fd_sc_hd__fill_4_87
+ vss
+ vdd
+ vdd
+ sky130_fd_sc_hd__fill_4
* cell instance sky130_fd_sc_hd__fill_4_88 r0 *1 0,0
Xsky130_fd_sc_hd__fill_4_88
+ vss
+ vdd
+ vdd
+ sky130_fd_sc_hd__fill_4
* cell instance sky130_fd_sc_hd__fill_4_89 r0 *1 0,0
Xsky130_fd_sc_hd__fill_4_89
+ vss
+ vdd
+ vdd
+ sky130_fd_sc_hd__fill_4
* cell instance sky130_fd_sc_hd__fill_4_90 r0 *1 0,0
Xsky130_fd_sc_hd__fill_4_90
+ vss
+ vdd
+ vdd
+ sky130_fd_sc_hd__fill_4
* cell instance sky130_fd_sc_hd__fill_4_91 r0 *1 0,0
Xsky130_fd_sc_hd__fill_4_91
+ vss
+ vdd
+ vdd
+ sky130_fd_sc_hd__fill_4
* cell instance sky130_fd_sc_hd__fill_4_92 r0 *1 0,0
Xsky130_fd_sc_hd__fill_4_92
+ vss
+ vdd
+ vdd
+ sky130_fd_sc_hd__fill_4
* cell instance sky130_fd_sc_hd__fill_4_93 r0 *1 0,0
Xsky130_fd_sc_hd__fill_4_93
+ vss
+ vdd
+ vdd
+ sky130_fd_sc_hd__fill_4
* cell instance sky130_fd_sc_hd__fill_4_94 r0 *1 0,0
Xsky130_fd_sc_hd__fill_4_94
+ vss
+ vdd
+ vdd
+ sky130_fd_sc_hd__fill_4
* cell instance sky130_fd_sc_hd__fill_4_95 r0 *1 0,0
Xsky130_fd_sc_hd__fill_4_95
+ vss
+ vdd
+ vdd
+ sky130_fd_sc_hd__fill_4
* cell instance sky130_fd_sc_hd__fill_4_96 r0 *1 0,0
Xsky130_fd_sc_hd__fill_4_96
+ vss
+ vdd
+ vdd
+ sky130_fd_sc_hd__fill_4
* cell instance sky130_fd_sc_hd__fill_4_97 r0 *1 0,0
Xsky130_fd_sc_hd__fill_4_97
+ vss
+ vdd
+ vdd
+ sky130_fd_sc_hd__fill_4
* cell instance sky130_fd_sc_hd__fill_4_98 r0 *1 0,0
Xsky130_fd_sc_hd__fill_4_98
+ vss
+ vdd
+ vdd
+ sky130_fd_sc_hd__fill_4
* cell instance sky130_fd_sc_hd__fill_4_99 r0 *1 0,0
Xsky130_fd_sc_hd__fill_4_99
+ vss
+ vdd
+ vdd
+ sky130_fd_sc_hd__fill_4
* cell instance sky130_fd_sc_hd__fill_4_100 r0 *1 0,0
Xsky130_fd_sc_hd__fill_4_100
+ vss
+ vdd
+ vdd
+ sky130_fd_sc_hd__fill_4
* cell instance sky130_fd_sc_hd__fill_4_101 r0 *1 0,0
Xsky130_fd_sc_hd__fill_4_101
+ vss
+ vdd
+ vdd
+ sky130_fd_sc_hd__fill_4
* cell instance sky130_fd_sc_hd__fill_4_102 r0 *1 0,0
Xsky130_fd_sc_hd__fill_4_102
+ vss
+ vdd
+ vdd
+ sky130_fd_sc_hd__fill_4
* cell instance sky130_fd_sc_hd__fill_4_103 r0 *1 0,0
Xsky130_fd_sc_hd__fill_4_103
+ vss
+ vdd
+ vdd
+ sky130_fd_sc_hd__fill_4
* cell instance sky130_fd_sc_hd__fill_4_104 r0 *1 0,0
Xsky130_fd_sc_hd__fill_4_104
+ vss
+ vdd
+ vdd
+ sky130_fd_sc_hd__fill_4
* cell instance sky130_fd_sc_hd__fill_4_105 r0 *1 0,0
Xsky130_fd_sc_hd__fill_4_105
+ vss
+ vdd
+ vdd
+ sky130_fd_sc_hd__fill_4
* cell instance sky130_fd_sc_hd__fill_4_106 r0 *1 0,0
Xsky130_fd_sc_hd__fill_4_106
+ vss
+ vdd
+ vdd
+ sky130_fd_sc_hd__fill_4
* cell instance sky130_fd_sc_hd__fill_4_107 r0 *1 0,0
Xsky130_fd_sc_hd__fill_4_107
+ vss
+ vdd
+ vdd
+ sky130_fd_sc_hd__fill_4
* cell instance sky130_fd_sc_hd__fill_4_108 r0 *1 0,0
Xsky130_fd_sc_hd__fill_4_108
+ vss
+ vdd
+ vdd
+ sky130_fd_sc_hd__fill_4
* cell instance sky130_fd_sc_hd__fill_4_109 r0 *1 0,0
Xsky130_fd_sc_hd__fill_4_109
+ vss
+ vdd
+ vdd
+ sky130_fd_sc_hd__fill_4
* cell instance sky130_fd_sc_hd__fill_4_110 r0 *1 0,0
Xsky130_fd_sc_hd__fill_4_110
+ vss
+ vdd
+ vdd
+ sky130_fd_sc_hd__fill_4
* cell instance sky130_fd_sc_hd__fill_4_111 r0 *1 0,0
Xsky130_fd_sc_hd__fill_4_111
+ vss
+ vdd
+ vdd
+ sky130_fd_sc_hd__fill_4
* cell instance sky130_fd_sc_hd__fill_4_112 r0 *1 0,0
Xsky130_fd_sc_hd__fill_4_112
+ vss
+ vdd
+ vdd
+ sky130_fd_sc_hd__fill_4
* cell instance sky130_fd_sc_hd__fill_4_113 r0 *1 0,0
Xsky130_fd_sc_hd__fill_4_113
+ vss
+ vdd
+ vdd
+ sky130_fd_sc_hd__fill_4
* cell instance sky130_fd_sc_hd__fill_4_114 r0 *1 0,0
Xsky130_fd_sc_hd__fill_4_114
+ vss
+ vdd
+ vdd
+ sky130_fd_sc_hd__fill_4
* cell instance sky130_fd_sc_hd__fill_4_115 r0 *1 0,0
Xsky130_fd_sc_hd__fill_4_115
+ vss
+ vdd
+ vdd
+ sky130_fd_sc_hd__fill_4
* cell instance sky130_fd_sc_hd__fill_4_116 r0 *1 0,0
Xsky130_fd_sc_hd__fill_4_116
+ vss
+ vdd
+ vdd
+ sky130_fd_sc_hd__fill_4
* cell instance sky130_fd_sc_hd__fill_4_117 r0 *1 0,0
Xsky130_fd_sc_hd__fill_4_117
+ vss
+ vdd
+ vdd
+ sky130_fd_sc_hd__fill_4
* cell instance sky130_fd_sc_hd__fill_4_118 r0 *1 0,0
Xsky130_fd_sc_hd__fill_4_118
+ vss
+ vdd
+ vdd
+ sky130_fd_sc_hd__fill_4
* cell instance sky130_fd_sc_hd__fill_4_119 r0 *1 0,0
Xsky130_fd_sc_hd__fill_4_119
+ vss
+ vdd
+ vdd
+ sky130_fd_sc_hd__fill_4
* cell instance sky130_fd_sc_hd__fill_4_120 r0 *1 0,0
Xsky130_fd_sc_hd__fill_4_120
+ vss
+ vdd
+ vdd
+ sky130_fd_sc_hd__fill_4
* cell instance sky130_fd_sc_hd__fill_4_121 r0 *1 0,0
Xsky130_fd_sc_hd__fill_4_121
+ vss
+ vdd
+ vdd
+ sky130_fd_sc_hd__fill_4
* cell instance sky130_fd_sc_hd__fill_4_122 r0 *1 0,0
Xsky130_fd_sc_hd__fill_4_122
+ vss
+ vdd
+ vdd
+ sky130_fd_sc_hd__fill_4
* cell instance sky130_fd_sc_hd__fill_4_123 r0 *1 0,0
Xsky130_fd_sc_hd__fill_4_123
+ vss
+ vdd
+ vdd
+ sky130_fd_sc_hd__fill_4
* cell instance sky130_fd_sc_hd__fill_4_124 r0 *1 0,0
Xsky130_fd_sc_hd__fill_4_124
+ vss
+ vdd
+ vdd
+ sky130_fd_sc_hd__fill_4
* cell instance sky130_fd_sc_hd__fill_4_125 r0 *1 0,0
Xsky130_fd_sc_hd__fill_4_125
+ vss
+ vdd
+ vdd
+ sky130_fd_sc_hd__fill_4
* cell instance sky130_fd_sc_hd__fill_4_126 r0 *1 0,0
Xsky130_fd_sc_hd__fill_4_126
+ vss
+ vdd
+ vdd
+ sky130_fd_sc_hd__fill_4
* cell instance sky130_fd_sc_hd__fill_4_127 r0 *1 0,0
Xsky130_fd_sc_hd__fill_4_127
+ vss
+ vdd
+ vdd
+ sky130_fd_sc_hd__fill_4
* cell instance sky130_fd_sc_hd__fill_4_128 r0 *1 0,0
Xsky130_fd_sc_hd__fill_4_128
+ vss
+ vdd
+ vdd
+ sky130_fd_sc_hd__fill_4
* cell instance sky130_fd_sc_hd__fill_4_129 r0 *1 0,0
Xsky130_fd_sc_hd__fill_4_129
+ vss
+ vdd
+ vdd
+ sky130_fd_sc_hd__fill_4
* cell instance sky130_fd_sc_hd__fill_4_130 r0 *1 0,0
Xsky130_fd_sc_hd__fill_4_130
+ vss
+ vdd
+ vdd
+ sky130_fd_sc_hd__fill_4
* cell instance sky130_fd_sc_hd__fill_4_131 r0 *1 0,0
Xsky130_fd_sc_hd__fill_4_131
+ vss
+ vdd
+ vdd
+ sky130_fd_sc_hd__fill_4
* cell instance sky130_fd_sc_hd__fill_4_132 r0 *1 0,0
Xsky130_fd_sc_hd__fill_4_132
+ vss
+ vdd
+ vdd
+ sky130_fd_sc_hd__fill_4
* cell instance sky130_fd_sc_hd__fill_4_133 r0 *1 0,0
Xsky130_fd_sc_hd__fill_4_133
+ vss
+ vdd
+ vdd
+ sky130_fd_sc_hd__fill_4
* cell instance sky130_fd_sc_hd__fill_4_134 r0 *1 0,0
Xsky130_fd_sc_hd__fill_4_134
+ vss
+ vdd
+ vdd
+ sky130_fd_sc_hd__fill_4
* cell instance sky130_fd_sc_hd__fill_4_135 r0 *1 0,0
Xsky130_fd_sc_hd__fill_4_135
+ vss
+ vdd
+ vdd
+ sky130_fd_sc_hd__fill_4
* cell instance sky130_fd_sc_hd__fill_4_136 r0 *1 0,0
Xsky130_fd_sc_hd__fill_4_136
+ vss
+ vdd
+ vdd
+ sky130_fd_sc_hd__fill_4
* cell instance sky130_fd_sc_hd__fill_4_137 r0 *1 0,0
Xsky130_fd_sc_hd__fill_4_137
+ vss
+ vdd
+ vdd
+ sky130_fd_sc_hd__fill_4
* cell instance sky130_fd_sc_hd__fill_4_138 r0 *1 0,0
Xsky130_fd_sc_hd__fill_4_138
+ vss
+ vdd
+ vdd
+ sky130_fd_sc_hd__fill_4
* cell instance sky130_fd_sc_hd__fill_4_139 r0 *1 0,0
Xsky130_fd_sc_hd__fill_4_139
+ vss
+ vdd
+ vdd
+ sky130_fd_sc_hd__fill_4
* cell instance sky130_fd_sc_hd__fill_4_140 r0 *1 0,0
Xsky130_fd_sc_hd__fill_4_140
+ vss
+ vdd
+ vdd
+ sky130_fd_sc_hd__fill_4
* cell instance sky130_fd_sc_hd__fill_4_141 r0 *1 0,0
Xsky130_fd_sc_hd__fill_4_141
+ vss
+ vdd
+ vdd
+ sky130_fd_sc_hd__fill_4
* cell instance sky130_fd_sc_hd__fill_4_142 r0 *1 0,0
Xsky130_fd_sc_hd__fill_4_142
+ vss
+ vdd
+ vdd
+ sky130_fd_sc_hd__fill_4
* cell instance sky130_fd_sc_hd__fill_4_143 r0 *1 0,0
Xsky130_fd_sc_hd__fill_4_143
+ vss
+ vdd
+ vdd
+ sky130_fd_sc_hd__fill_4
* cell instance sky130_fd_sc_hd__fill_4_144 r0 *1 0,0
Xsky130_fd_sc_hd__fill_4_144
+ vss
+ vdd
+ vdd
+ sky130_fd_sc_hd__fill_4
* cell instance sky130_fd_sc_hd__fill_4_145 r0 *1 0,0
Xsky130_fd_sc_hd__fill_4_145
+ vss
+ vdd
+ vdd
+ sky130_fd_sc_hd__fill_4
* cell instance sky130_fd_sc_hd__fill_4_146 r0 *1 0,0
Xsky130_fd_sc_hd__fill_4_146
+ vss
+ vdd
+ vdd
+ sky130_fd_sc_hd__fill_4
* cell instance sky130_fd_sc_hd__fill_4_147 r0 *1 0,0
Xsky130_fd_sc_hd__fill_4_147
+ vss
+ vdd
+ vdd
+ sky130_fd_sc_hd__fill_4
* cell instance sky130_fd_sc_hd__fill_4_148 r0 *1 0,0
Xsky130_fd_sc_hd__fill_4_148
+ vss
+ vdd
+ vdd
+ sky130_fd_sc_hd__fill_4
* cell instance sky130_fd_sc_hd__fill_4_149 r0 *1 0,0
Xsky130_fd_sc_hd__fill_4_149
+ vss
+ vdd
+ vdd
+ sky130_fd_sc_hd__fill_4
* cell instance sky130_fd_sc_hd__fill_4_150 r0 *1 0,0
Xsky130_fd_sc_hd__fill_4_150
+ vss
+ vdd
+ vdd
+ sky130_fd_sc_hd__fill_4
* cell instance sky130_fd_sc_hd__fill_4_151 r0 *1 0,0
Xsky130_fd_sc_hd__fill_4_151
+ vss
+ vdd
+ vdd
+ sky130_fd_sc_hd__fill_4
* cell instance sky130_fd_sc_hd__fill_4_152 r0 *1 0,0
Xsky130_fd_sc_hd__fill_4_152
+ vss
+ vdd
+ vdd
+ sky130_fd_sc_hd__fill_4
* cell instance sky130_fd_sc_hd__fill_4_153 r0 *1 0,0
Xsky130_fd_sc_hd__fill_4_153
+ vss
+ vdd
+ vdd
+ sky130_fd_sc_hd__fill_4
* cell instance sky130_fd_sc_hd__fill_4_154 r0 *1 0,0
Xsky130_fd_sc_hd__fill_4_154
+ vss
+ vdd
+ vdd
+ sky130_fd_sc_hd__fill_4
* cell instance sky130_fd_sc_hd__fill_4_155 r0 *1 0,0
Xsky130_fd_sc_hd__fill_4_155
+ vss
+ vdd
+ vdd
+ sky130_fd_sc_hd__fill_4
* cell instance sky130_fd_sc_hd__fill_4_156 r0 *1 0,0
Xsky130_fd_sc_hd__fill_4_156
+ vss
+ vdd
+ vdd
+ sky130_fd_sc_hd__fill_4
* cell instance sky130_fd_sc_hd__fill_4_157 r0 *1 0,0
Xsky130_fd_sc_hd__fill_4_157
+ vss
+ vdd
+ vdd
+ sky130_fd_sc_hd__fill_4
* cell instance sky130_fd_sc_hd__fill_4_158 r0 *1 0,0
Xsky130_fd_sc_hd__fill_4_158
+ vss
+ vdd
+ vdd
+ sky130_fd_sc_hd__fill_4
* cell instance sky130_fd_sc_hd__fill_4_159 r0 *1 0,0
Xsky130_fd_sc_hd__fill_4_159
+ vss
+ vdd
+ vdd
+ sky130_fd_sc_hd__fill_4
* cell instance sky130_fd_sc_hd__fill_4_160 r0 *1 0,0
Xsky130_fd_sc_hd__fill_4_160
+ vss
+ vdd
+ vdd
+ sky130_fd_sc_hd__fill_4
* cell instance sky130_fd_sc_hd__fill_4_161 r0 *1 0,0
Xsky130_fd_sc_hd__fill_4_161
+ vss
+ vdd
+ vdd
+ sky130_fd_sc_hd__fill_4
* cell instance sky130_fd_sc_hd__fill_4_162 r0 *1 0,0
Xsky130_fd_sc_hd__fill_4_162
+ vss
+ vdd
+ vdd
+ sky130_fd_sc_hd__fill_4
* cell instance sky130_fd_sc_hd__fill_4_163 r0 *1 0,0
Xsky130_fd_sc_hd__fill_4_163
+ vss
+ vdd
+ vdd
+ sky130_fd_sc_hd__fill_4
* cell instance sky130_fd_sc_hd__fill_4_164 r0 *1 0,0
Xsky130_fd_sc_hd__fill_4_164
+ vss
+ vdd
+ vdd
+ sky130_fd_sc_hd__fill_4
* cell instance sky130_fd_sc_hd__fill_4_165 r0 *1 0,0
Xsky130_fd_sc_hd__fill_4_165
+ vss
+ vdd
+ vdd
+ sky130_fd_sc_hd__fill_4
* cell instance sky130_fd_sc_hd__fill_4_166 r0 *1 0,0
Xsky130_fd_sc_hd__fill_4_166
+ vss
+ vdd
+ vdd
+ sky130_fd_sc_hd__fill_4
* cell instance sky130_fd_sc_hd__fill_4_167 r0 *1 0,0
Xsky130_fd_sc_hd__fill_4_167
+ vss
+ vdd
+ vdd
+ sky130_fd_sc_hd__fill_4
* cell instance sky130_fd_sc_hd__fill_4_168 r0 *1 0,0
Xsky130_fd_sc_hd__fill_4_168
+ vss
+ vdd
+ vdd
+ sky130_fd_sc_hd__fill_4
* cell instance sky130_fd_sc_hd__fill_4_169 r0 *1 0,0
Xsky130_fd_sc_hd__fill_4_169
+ vss
+ vdd
+ vdd
+ sky130_fd_sc_hd__fill_4
* cell instance sky130_fd_sc_hd__fill_4_170 r0 *1 0,0
Xsky130_fd_sc_hd__fill_4_170
+ vss
+ vdd
+ vdd
+ sky130_fd_sc_hd__fill_4
* cell instance sky130_fd_sc_hd__fill_4_171 r0 *1 0,0
Xsky130_fd_sc_hd__fill_4_171
+ vss
+ vdd
+ vdd
+ sky130_fd_sc_hd__fill_4
* cell instance sky130_fd_sc_hd__fill_4_172 r0 *1 0,0
Xsky130_fd_sc_hd__fill_4_172
+ vss
+ vdd
+ vdd
+ sky130_fd_sc_hd__fill_4
* cell instance sky130_fd_sc_hd__fill_4_173 r0 *1 0,0
Xsky130_fd_sc_hd__fill_4_173
+ vss
+ vdd
+ vdd
+ sky130_fd_sc_hd__fill_4
* cell instance sky130_fd_sc_hd__fill_4_174 r0 *1 0,0
Xsky130_fd_sc_hd__fill_4_174
+ vss
+ vdd
+ vdd
+ sky130_fd_sc_hd__fill_4
* cell instance sky130_fd_sc_hd__fill_4_175 r0 *1 0,0
Xsky130_fd_sc_hd__fill_4_175
+ vss
+ vdd
+ vdd
+ sky130_fd_sc_hd__fill_4
* cell instance sky130_fd_sc_hd__fill_4_176 r0 *1 0,0
Xsky130_fd_sc_hd__fill_4_176
+ vss
+ vdd
+ vdd
+ sky130_fd_sc_hd__fill_4
* cell instance sky130_fd_sc_hd__fill_4_177 r0 *1 0,0
Xsky130_fd_sc_hd__fill_4_177
+ vss
+ vdd
+ vdd
+ sky130_fd_sc_hd__fill_4
* cell instance sky130_fd_sc_hd__fill_4_178 r0 *1 0,0
Xsky130_fd_sc_hd__fill_4_178
+ vss
+ vdd
+ vdd
+ sky130_fd_sc_hd__fill_4
* cell instance sky130_fd_sc_hd__fill_4_179 r0 *1 0,0
Xsky130_fd_sc_hd__fill_4_179
+ vss
+ vdd
+ vdd
+ sky130_fd_sc_hd__fill_4
* cell instance sky130_fd_sc_hd__fill_4_180 r0 *1 0,0
Xsky130_fd_sc_hd__fill_4_180
+ vss
+ vdd
+ vdd
+ sky130_fd_sc_hd__fill_4
* cell instance sky130_fd_sc_hd__fill_4_181 r0 *1 0,0
Xsky130_fd_sc_hd__fill_4_181
+ vss
+ vdd
+ vdd
+ sky130_fd_sc_hd__fill_4
* cell instance sky130_fd_sc_hd__fill_4_182 r0 *1 0,0
Xsky130_fd_sc_hd__fill_4_182
+ vss
+ vdd
+ vdd
+ sky130_fd_sc_hd__fill_4
* cell instance sky130_fd_sc_hd__fill_4_183 r0 *1 0,0
Xsky130_fd_sc_hd__fill_4_183
+ vss
+ vdd
+ vdd
+ sky130_fd_sc_hd__fill_4
* cell instance sky130_fd_sc_hd__fill_4_184 r0 *1 0,0
Xsky130_fd_sc_hd__fill_4_184
+ vss
+ vdd
+ vdd
+ sky130_fd_sc_hd__fill_4
* cell instance sky130_fd_sc_hd__fill_4_185 r0 *1 0,0
Xsky130_fd_sc_hd__fill_4_185
+ vss
+ vdd
+ vdd
+ sky130_fd_sc_hd__fill_4
* cell instance sky130_fd_sc_hd__fill_4_186 r0 *1 0,0
Xsky130_fd_sc_hd__fill_4_186
+ vss
+ vdd
+ vdd
+ sky130_fd_sc_hd__fill_4
* cell instance sky130_fd_sc_hd__fill_4_187 r0 *1 0,0
Xsky130_fd_sc_hd__fill_4_187
+ vss
+ vdd
+ vdd
+ sky130_fd_sc_hd__fill_4
* cell instance sky130_fd_sc_hd__fill_4_188 r0 *1 0,0
Xsky130_fd_sc_hd__fill_4_188
+ vss
+ vdd
+ vdd
+ sky130_fd_sc_hd__fill_4
* cell instance sky130_fd_sc_hd__fill_4_189 r0 *1 0,0
Xsky130_fd_sc_hd__fill_4_189
+ vss
+ vdd
+ vdd
+ sky130_fd_sc_hd__fill_4
* cell instance sky130_fd_sc_hd__fill_4_190 r0 *1 0,0
Xsky130_fd_sc_hd__fill_4_190
+ vss
+ vdd
+ vdd
+ sky130_fd_sc_hd__fill_4
* cell instance sky130_fd_sc_hd__fill_4_191 r0 *1 0,0
Xsky130_fd_sc_hd__fill_4_191
+ vss
+ vdd
+ vdd
+ sky130_fd_sc_hd__fill_4
* cell instance sky130_fd_sc_hd__fill_4_192 r0 *1 0,0
Xsky130_fd_sc_hd__fill_4_192
+ vss
+ vdd
+ vdd
+ sky130_fd_sc_hd__fill_4
* cell instance sky130_fd_sc_hd__fill_4_193 r0 *1 0,0
Xsky130_fd_sc_hd__fill_4_193
+ vss
+ vdd
+ vdd
+ sky130_fd_sc_hd__fill_4
* cell instance sky130_fd_sc_hd__fill_4_194 r0 *1 0,0
Xsky130_fd_sc_hd__fill_4_194
+ vss
+ vdd
+ vdd
+ sky130_fd_sc_hd__fill_4
* cell instance sky130_fd_sc_hd__fill_4_195 r0 *1 0,0
Xsky130_fd_sc_hd__fill_4_195
+ vss
+ vdd
+ vdd
+ sky130_fd_sc_hd__fill_4
* cell instance sky130_fd_sc_hd__fill_4_196 r0 *1 0,0
Xsky130_fd_sc_hd__fill_4_196
+ vss
+ vdd
+ vdd
+ sky130_fd_sc_hd__fill_4
* cell instance sky130_fd_sc_hd__fill_4_197 r0 *1 0,0
Xsky130_fd_sc_hd__fill_4_197
+ vss
+ vdd
+ vdd
+ sky130_fd_sc_hd__fill_4
* cell instance sky130_fd_sc_hd__fill_4_198 r0 *1 0,0
Xsky130_fd_sc_hd__fill_4_198
+ vss
+ vdd
+ vdd
+ sky130_fd_sc_hd__fill_4
* cell instance sky130_fd_sc_hd__fill_4_199 r0 *1 0,0
Xsky130_fd_sc_hd__fill_4_199
+ vss
+ vdd
+ vdd
+ sky130_fd_sc_hd__fill_4
* cell instance sky130_fd_sc_hd__fill_4_200 r0 *1 0,0
Xsky130_fd_sc_hd__fill_4_200
+ vss
+ vdd
+ vdd
+ sky130_fd_sc_hd__fill_4
* cell instance sky130_fd_sc_hd__fill_4_201 r0 *1 0,0
Xsky130_fd_sc_hd__fill_4_201
+ vss
+ vdd
+ vdd
+ sky130_fd_sc_hd__fill_4
* cell instance sky130_fd_sc_hd__fill_4_202 r0 *1 0,0
Xsky130_fd_sc_hd__fill_4_202
+ vss
+ vdd
+ vdd
+ sky130_fd_sc_hd__fill_4
* cell instance sky130_fd_sc_hd__fill_4_203 r0 *1 0,0
Xsky130_fd_sc_hd__fill_4_203
+ vss
+ vdd
+ vdd
+ sky130_fd_sc_hd__fill_4
* cell instance sky130_fd_sc_hd__fill_4_204 r0 *1 0,0
Xsky130_fd_sc_hd__fill_4_204
+ vss
+ vdd
+ vdd
+ sky130_fd_sc_hd__fill_4
* cell instance sky130_fd_sc_hd__fill_4_205 r0 *1 0,0
Xsky130_fd_sc_hd__fill_4_205
+ vss
+ vdd
+ vdd
+ sky130_fd_sc_hd__fill_4
* cell instance sky130_fd_sc_hd__fill_4_206 r0 *1 0,0
Xsky130_fd_sc_hd__fill_4_206
+ vss
+ vdd
+ vdd
+ sky130_fd_sc_hd__fill_4
* cell instance sky130_fd_sc_hd__fill_4_207 r0 *1 0,0
Xsky130_fd_sc_hd__fill_4_207
+ vss
+ vdd
+ vdd
+ sky130_fd_sc_hd__fill_4
* cell instance sky130_fd_sc_hd__fill_4_208 r0 *1 0,0
Xsky130_fd_sc_hd__fill_4_208
+ vss
+ vdd
+ vdd
+ sky130_fd_sc_hd__fill_4
* cell instance sky130_fd_sc_hd__fill_4_209 r0 *1 0,0
Xsky130_fd_sc_hd__fill_4_209
+ vss
+ vdd
+ vdd
+ sky130_fd_sc_hd__fill_4
* cell instance sky130_fd_sc_hd__fill_4_210 r0 *1 0,0
Xsky130_fd_sc_hd__fill_4_210
+ vss
+ vdd
+ vdd
+ sky130_fd_sc_hd__fill_4
* cell instance sky130_fd_sc_hd__fill_4_211 r0 *1 0,0
Xsky130_fd_sc_hd__fill_4_211
+ vss
+ vdd
+ vdd
+ sky130_fd_sc_hd__fill_4
* cell instance sky130_fd_sc_hd__fill_4_212 r0 *1 0,0
Xsky130_fd_sc_hd__fill_4_212
+ vss
+ vdd
+ vdd
+ sky130_fd_sc_hd__fill_4
* cell instance sky130_fd_sc_hd__fill_4_213 r0 *1 0,0
Xsky130_fd_sc_hd__fill_4_213
+ vss
+ vdd
+ vdd
+ sky130_fd_sc_hd__fill_4
* cell instance sky130_fd_sc_hd__fill_4_214 r0 *1 0,0
Xsky130_fd_sc_hd__fill_4_214
+ vss
+ vdd
+ vdd
+ sky130_fd_sc_hd__fill_4
* cell instance sky130_fd_sc_hd__fill_4_215 r0 *1 0,0
Xsky130_fd_sc_hd__fill_4_215
+ vss
+ vdd
+ vdd
+ sky130_fd_sc_hd__fill_4
* cell instance sky130_fd_sc_hd__fill_4_216 r0 *1 0,0
Xsky130_fd_sc_hd__fill_4_216
+ vss
+ vdd
+ vdd
+ sky130_fd_sc_hd__fill_4
* cell instance sky130_fd_sc_hd__fill_4_217 r0 *1 0,0
Xsky130_fd_sc_hd__fill_4_217
+ vss
+ vdd
+ vdd
+ sky130_fd_sc_hd__fill_4
* cell instance sky130_fd_sc_hd__fill_4_218 r0 *1 0,0
Xsky130_fd_sc_hd__fill_4_218
+ vss
+ vdd
+ vdd
+ sky130_fd_sc_hd__fill_4
* cell instance sky130_fd_sc_hd__fill_4_219 r0 *1 0,0
Xsky130_fd_sc_hd__fill_4_219
+ vss
+ vdd
+ vdd
+ sky130_fd_sc_hd__fill_4
* cell instance sky130_fd_sc_hd__fill_4_220 r0 *1 0,0
Xsky130_fd_sc_hd__fill_4_220
+ vss
+ vdd
+ vdd
+ sky130_fd_sc_hd__fill_4
* cell instance sky130_fd_sc_hd__fill_4_221 r0 *1 0,0
Xsky130_fd_sc_hd__fill_4_221
+ vss
+ vdd
+ vdd
+ sky130_fd_sc_hd__fill_4
* cell instance sky130_fd_sc_hd__fill_4_222 r0 *1 0,0
Xsky130_fd_sc_hd__fill_4_222
+ vss
+ vdd
+ vdd
+ sky130_fd_sc_hd__fill_4
* cell instance sky130_fd_sc_hd__fill_4_223 r0 *1 0,0
Xsky130_fd_sc_hd__fill_4_223
+ vss
+ vdd
+ vdd
+ sky130_fd_sc_hd__fill_4
* cell instance sky130_fd_sc_hd__fill_4_224 r0 *1 0,0
Xsky130_fd_sc_hd__fill_4_224
+ vss
+ vdd
+ vdd
+ sky130_fd_sc_hd__fill_4
* cell instance sky130_fd_sc_hd__fill_4_225 r0 *1 0,0
Xsky130_fd_sc_hd__fill_4_225
+ vss
+ vdd
+ vdd
+ sky130_fd_sc_hd__fill_4
* cell instance sky130_fd_sc_hd__fill_4_226 r0 *1 0,0
Xsky130_fd_sc_hd__fill_4_226
+ vss
+ vdd
+ vdd
+ sky130_fd_sc_hd__fill_4
* cell instance sky130_fd_sc_hd__fill_4_227 r0 *1 0,0
Xsky130_fd_sc_hd__fill_4_227
+ vss
+ vdd
+ vdd
+ sky130_fd_sc_hd__fill_4
* cell instance sky130_fd_sc_hd__fill_4_228 r0 *1 0,0
Xsky130_fd_sc_hd__fill_4_228
+ vss
+ vdd
+ vdd
+ sky130_fd_sc_hd__fill_4
* cell instance sky130_fd_sc_hd__fill_4_229 r0 *1 0,0
Xsky130_fd_sc_hd__fill_4_229
+ vss
+ vdd
+ vdd
+ sky130_fd_sc_hd__fill_4
* cell instance sky130_fd_sc_hd__fill_4_230 r0 *1 0,0
Xsky130_fd_sc_hd__fill_4_230
+ vss
+ vdd
+ vdd
+ sky130_fd_sc_hd__fill_4
* cell instance sky130_fd_sc_hd__fill_4_231 r0 *1 0,0
Xsky130_fd_sc_hd__fill_4_231
+ vss
+ vdd
+ vdd
+ sky130_fd_sc_hd__fill_4
* cell instance sky130_fd_sc_hd__fill_4_232 r0 *1 0,0
Xsky130_fd_sc_hd__fill_4_232
+ vss
+ vdd
+ vdd
+ sky130_fd_sc_hd__fill_4
* cell instance sky130_fd_sc_hd__fill_4_233 r0 *1 0,0
Xsky130_fd_sc_hd__fill_4_233
+ vss
+ vdd
+ vdd
+ sky130_fd_sc_hd__fill_4
* cell instance sky130_fd_sc_hd__fill_4_234 r0 *1 0,0
Xsky130_fd_sc_hd__fill_4_234
+ vss
+ vdd
+ vdd
+ sky130_fd_sc_hd__fill_4
* cell instance sky130_fd_sc_hd__fill_4_235 r0 *1 0,0
Xsky130_fd_sc_hd__fill_4_235
+ vss
+ vdd
+ vdd
+ sky130_fd_sc_hd__fill_4
* cell instance sky130_fd_sc_hd__fill_4_236 r0 *1 0,0
Xsky130_fd_sc_hd__fill_4_236
+ vss
+ vdd
+ vdd
+ sky130_fd_sc_hd__fill_4
* cell instance sky130_fd_sc_hd__fill_4_237 r0 *1 0,0
Xsky130_fd_sc_hd__fill_4_237
+ vss
+ vdd
+ vdd
+ sky130_fd_sc_hd__fill_4
* cell instance sky130_fd_sc_hd__fill_4_238 r0 *1 0,0
Xsky130_fd_sc_hd__fill_4_238
+ vss
+ vdd
+ vdd
+ sky130_fd_sc_hd__fill_4
* cell instance sky130_fd_sc_hd__fill_4_239 r0 *1 0,0
Xsky130_fd_sc_hd__fill_4_239
+ vss
+ vdd
+ vdd
+ sky130_fd_sc_hd__fill_4
* cell instance sky130_fd_sc_hd__fill_4_240 r0 *1 0,0
Xsky130_fd_sc_hd__fill_4_240
+ vss
+ vdd
+ vdd
+ sky130_fd_sc_hd__fill_4
* cell instance sky130_fd_sc_hd__fill_4_241 r0 *1 0,0
Xsky130_fd_sc_hd__fill_4_241
+ vss
+ vdd
+ vdd
+ sky130_fd_sc_hd__fill_4
* cell instance sky130_fd_sc_hd__fill_4_242 r0 *1 0,0
Xsky130_fd_sc_hd__fill_4_242
+ vss
+ vdd
+ vdd
+ sky130_fd_sc_hd__fill_4
* cell instance sky130_fd_sc_hd__fill_4_243 r0 *1 0,0
Xsky130_fd_sc_hd__fill_4_243
+ vss
+ vdd
+ vdd
+ sky130_fd_sc_hd__fill_4
* cell instance sky130_fd_sc_hd__fill_4_244 r0 *1 0,0
Xsky130_fd_sc_hd__fill_4_244
+ vss
+ vdd
+ vdd
+ sky130_fd_sc_hd__fill_4
* cell instance sky130_fd_sc_hd__fill_4_245 r0 *1 0,0
Xsky130_fd_sc_hd__fill_4_245
+ vss
+ vdd
+ vdd
+ sky130_fd_sc_hd__fill_4
* cell instance sky130_fd_sc_hd__fill_4_246 r0 *1 0,0
Xsky130_fd_sc_hd__fill_4_246
+ vss
+ vdd
+ vdd
+ sky130_fd_sc_hd__fill_4
* cell instance sky130_fd_sc_hd__fill_4_247 r0 *1 0,0
Xsky130_fd_sc_hd__fill_4_247
+ vss
+ vdd
+ vdd
+ sky130_fd_sc_hd__fill_4
* cell instance sky130_fd_sc_hd__fill_4_248 r0 *1 0,0
Xsky130_fd_sc_hd__fill_4_248
+ vss
+ vdd
+ vdd
+ sky130_fd_sc_hd__fill_4
* cell instance sky130_fd_sc_hd__fill_4_249 r0 *1 0,0
Xsky130_fd_sc_hd__fill_4_249
+ vss
+ vdd
+ vdd
+ sky130_fd_sc_hd__fill_4
* cell instance sky130_fd_sc_hd__fill_4_250 r0 *1 0,0
Xsky130_fd_sc_hd__fill_4_250
+ vss
+ vdd
+ vdd
+ sky130_fd_sc_hd__fill_4
* cell instance sky130_fd_sc_hd__fill_4_251 r0 *1 0,0
Xsky130_fd_sc_hd__fill_4_251
+ vss
+ vdd
+ vdd
+ sky130_fd_sc_hd__fill_4
* cell instance sky130_fd_sc_hd__fill_4_252 r0 *1 0,0
Xsky130_fd_sc_hd__fill_4_252
+ vss
+ vdd
+ vdd
+ sky130_fd_sc_hd__fill_4
* cell instance sky130_fd_sc_hd__fill_4_253 r0 *1 0,0
Xsky130_fd_sc_hd__fill_4_253
+ vss
+ vdd
+ vdd
+ sky130_fd_sc_hd__fill_4
* cell instance sky130_fd_sc_hd__fill_4_254 r0 *1 0,0
Xsky130_fd_sc_hd__fill_4_254
+ vss
+ vdd
+ vdd
+ sky130_fd_sc_hd__fill_4
* cell instance sky130_fd_sc_hd__fill_4_255 r0 *1 0,0
Xsky130_fd_sc_hd__fill_4_255
+ vss
+ vdd
+ vdd
+ sky130_fd_sc_hd__fill_4
* cell instance sky130_fd_sc_hd__fill_4_256 r0 *1 0,0
Xsky130_fd_sc_hd__fill_4_256
+ vss
+ vdd
+ vdd
+ sky130_fd_sc_hd__fill_4
* cell instance sky130_fd_sc_hd__fill_4_257 r0 *1 0,0
Xsky130_fd_sc_hd__fill_4_257
+ vss
+ vdd
+ vdd
+ sky130_fd_sc_hd__fill_4
* cell instance sky130_fd_sc_hd__fill_4_258 r0 *1 0,0
Xsky130_fd_sc_hd__fill_4_258
+ vss
+ vdd
+ vdd
+ sky130_fd_sc_hd__fill_4
* cell instance sky130_fd_sc_hd__fill_4_259 r0 *1 0,0
Xsky130_fd_sc_hd__fill_4_259
+ vss
+ vdd
+ vdd
+ sky130_fd_sc_hd__fill_4
* cell instance sky130_fd_sc_hd__fill_4_260 r0 *1 0,0
Xsky130_fd_sc_hd__fill_4_260
+ vss
+ vdd
+ vdd
+ sky130_fd_sc_hd__fill_4
* cell instance sky130_fd_sc_hd__fill_4_261 r0 *1 0,0
Xsky130_fd_sc_hd__fill_4_261
+ vss
+ vdd
+ vdd
+ sky130_fd_sc_hd__fill_4
* cell instance sky130_fd_sc_hd__fill_4_262 r0 *1 0,0
Xsky130_fd_sc_hd__fill_4_262
+ vss
+ vdd
+ vdd
+ sky130_fd_sc_hd__fill_4
* cell instance sky130_fd_sc_hd__fill_4_263 r0 *1 0,0
Xsky130_fd_sc_hd__fill_4_263
+ vss
+ vdd
+ vdd
+ sky130_fd_sc_hd__fill_4
* cell instance sky130_fd_sc_hd__fill_4_264 r0 *1 0,0
Xsky130_fd_sc_hd__fill_4_264
+ vss
+ vdd
+ vdd
+ sky130_fd_sc_hd__fill_4
* cell instance sky130_fd_sc_hd__fill_4_265 r0 *1 0,0
Xsky130_fd_sc_hd__fill_4_265
+ vss
+ vdd
+ vdd
+ sky130_fd_sc_hd__fill_4
* cell instance sky130_fd_sc_hd__fill_4_266 r0 *1 0,0
Xsky130_fd_sc_hd__fill_4_266
+ vss
+ vdd
+ vdd
+ sky130_fd_sc_hd__fill_4
* cell instance sky130_fd_sc_hd__fill_4_267 r0 *1 0,0
Xsky130_fd_sc_hd__fill_4_267
+ vss
+ vdd
+ vdd
+ sky130_fd_sc_hd__fill_4
* cell instance sky130_fd_sc_hd__fill_4_268 r0 *1 0,0
Xsky130_fd_sc_hd__fill_4_268
+ vss
+ vdd
+ vdd
+ sky130_fd_sc_hd__fill_4
* cell instance sky130_fd_sc_hd__fill_4_269 r0 *1 0,0
Xsky130_fd_sc_hd__fill_4_269
+ vss
+ vdd
+ vdd
+ sky130_fd_sc_hd__fill_4
* cell instance sky130_fd_sc_hd__fill_4_270 r0 *1 0,0
Xsky130_fd_sc_hd__fill_4_270
+ vss
+ vdd
+ vdd
+ sky130_fd_sc_hd__fill_4
* cell instance sky130_fd_sc_hd__fill_4_271 r0 *1 0,0
Xsky130_fd_sc_hd__fill_4_271
+ vss
+ vdd
+ vdd
+ sky130_fd_sc_hd__fill_4
* cell instance sky130_fd_sc_hd__fill_4_272 r0 *1 0,0
Xsky130_fd_sc_hd__fill_4_272
+ vss
+ vdd
+ vdd
+ sky130_fd_sc_hd__fill_4
* cell instance sky130_fd_sc_hd__fill_4_273 r0 *1 0,0
Xsky130_fd_sc_hd__fill_4_273
+ vss
+ vdd
+ vdd
+ sky130_fd_sc_hd__fill_4
* cell instance sky130_fd_sc_hd__fill_4_274 r0 *1 0,0
Xsky130_fd_sc_hd__fill_4_274
+ vss
+ vdd
+ vdd
+ sky130_fd_sc_hd__fill_4
* cell instance sky130_fd_sc_hd__fill_4_275 r0 *1 0,0
Xsky130_fd_sc_hd__fill_4_275
+ vss
+ vdd
+ vdd
+ sky130_fd_sc_hd__fill_4
* cell instance sky130_fd_sc_hd__fill_4_276 r0 *1 0,0
Xsky130_fd_sc_hd__fill_4_276
+ vss
+ vdd
+ vdd
+ sky130_fd_sc_hd__fill_4
* cell instance sky130_fd_sc_hd__fill_4_277 r0 *1 0,0
Xsky130_fd_sc_hd__fill_4_277
+ vss
+ vdd
+ vdd
+ sky130_fd_sc_hd__fill_4
* cell instance sky130_fd_sc_hd__fill_4_278 r0 *1 0,0
Xsky130_fd_sc_hd__fill_4_278
+ vss
+ vdd
+ vdd
+ sky130_fd_sc_hd__fill_4
* cell instance sky130_fd_sc_hd__fill_4_279 r0 *1 0,0
Xsky130_fd_sc_hd__fill_4_279
+ vss
+ vdd
+ vdd
+ sky130_fd_sc_hd__fill_4
* cell instance sky130_fd_sc_hd__fill_4_280 r0 *1 0,0
Xsky130_fd_sc_hd__fill_4_280
+ vss
+ vdd
+ vdd
+ sky130_fd_sc_hd__fill_4
* cell instance sky130_fd_sc_hd__fill_4_281 r0 *1 0,0
Xsky130_fd_sc_hd__fill_4_281
+ vss
+ vdd
+ vdd
+ sky130_fd_sc_hd__fill_4
* cell instance sky130_fd_sc_hd__fill_4_282 r0 *1 0,0
Xsky130_fd_sc_hd__fill_4_282
+ vss
+ vdd
+ vdd
+ sky130_fd_sc_hd__fill_4
* cell instance sky130_fd_sc_hd__fill_4_283 r0 *1 0,0
Xsky130_fd_sc_hd__fill_4_283
+ vss
+ vdd
+ vdd
+ sky130_fd_sc_hd__fill_4
* cell instance sky130_fd_sc_hd__fill_4_284 r0 *1 0,0
Xsky130_fd_sc_hd__fill_4_284
+ vss
+ vdd
+ vdd
+ sky130_fd_sc_hd__fill_4
* cell instance sky130_fd_sc_hd__fill_4_285 r0 *1 0,0
Xsky130_fd_sc_hd__fill_4_285
+ vss
+ vdd
+ vdd
+ sky130_fd_sc_hd__fill_4
* cell instance sky130_fd_sc_hd__fill_4_286 r0 *1 0,0
Xsky130_fd_sc_hd__fill_4_286
+ vss
+ vdd
+ vdd
+ sky130_fd_sc_hd__fill_4
* cell instance sky130_fd_sc_hd__fill_4_287 r0 *1 0,0
Xsky130_fd_sc_hd__fill_4_287
+ vss
+ vdd
+ vdd
+ sky130_fd_sc_hd__fill_4
* cell instance sky130_fd_sc_hd__fill_4_288 r0 *1 0,0
Xsky130_fd_sc_hd__fill_4_288
+ vss
+ vdd
+ vdd
+ sky130_fd_sc_hd__fill_4
* cell instance sky130_fd_sc_hd__fill_4_289 r0 *1 0,0
Xsky130_fd_sc_hd__fill_4_289
+ vss
+ vdd
+ vdd
+ sky130_fd_sc_hd__fill_4
* cell instance sky130_fd_sc_hd__fill_4_290 r0 *1 0,0
Xsky130_fd_sc_hd__fill_4_290
+ vss
+ vdd
+ vdd
+ sky130_fd_sc_hd__fill_4
* cell instance sky130_fd_sc_hd__fill_4_291 r0 *1 0,0
Xsky130_fd_sc_hd__fill_4_291
+ vss
+ vdd
+ vdd
+ sky130_fd_sc_hd__fill_4
* cell instance sky130_fd_sc_hd__fill_4_292 r0 *1 0,0
Xsky130_fd_sc_hd__fill_4_292
+ vss
+ vdd
+ vdd
+ sky130_fd_sc_hd__fill_4
* cell instance sky130_fd_sc_hd__fill_4_293 r0 *1 0,0
Xsky130_fd_sc_hd__fill_4_293
+ vss
+ vdd
+ vdd
+ sky130_fd_sc_hd__fill_4
* cell instance sky130_fd_sc_hd__fill_4_294 r0 *1 0,0
Xsky130_fd_sc_hd__fill_4_294
+ vss
+ vdd
+ vdd
+ sky130_fd_sc_hd__fill_4
* cell instance sky130_fd_sc_hd__fill_4_295 r0 *1 0,0
Xsky130_fd_sc_hd__fill_4_295
+ vss
+ vdd
+ vdd
+ sky130_fd_sc_hd__fill_4
* cell instance sky130_fd_sc_hd__fill_4_296 r0 *1 0,0
Xsky130_fd_sc_hd__fill_4_296
+ vss
+ vdd
+ vdd
+ sky130_fd_sc_hd__fill_4
* cell instance sky130_fd_sc_hd__fill_4_297 r0 *1 0,0
Xsky130_fd_sc_hd__fill_4_297
+ vss
+ vdd
+ vdd
+ sky130_fd_sc_hd__fill_4
* cell instance sky130_fd_sc_hd__fill_4_298 r0 *1 0,0
Xsky130_fd_sc_hd__fill_4_298
+ vss
+ vdd
+ vdd
+ sky130_fd_sc_hd__fill_4
* cell instance sky130_fd_sc_hd__fill_4_299 r0 *1 0,0
Xsky130_fd_sc_hd__fill_4_299
+ vss
+ vdd
+ vdd
+ sky130_fd_sc_hd__fill_4
* cell instance sky130_fd_sc_hd__fill_4_300 r0 *1 0,0
Xsky130_fd_sc_hd__fill_4_300
+ vss
+ vdd
+ vdd
+ sky130_fd_sc_hd__fill_4
* cell instance sky130_fd_sc_hd__fill_4_301 r0 *1 0,0
Xsky130_fd_sc_hd__fill_4_301
+ vss
+ vdd
+ vdd
+ sky130_fd_sc_hd__fill_4
* cell instance sky130_fd_sc_hd__fill_4_302 r0 *1 0,0
Xsky130_fd_sc_hd__fill_4_302
+ vss
+ vdd
+ vdd
+ sky130_fd_sc_hd__fill_4
* cell instance sky130_fd_sc_hd__fill_4_303 r0 *1 0,0
Xsky130_fd_sc_hd__fill_4_303
+ vss
+ vdd
+ vdd
+ sky130_fd_sc_hd__fill_4
* cell instance sky130_fd_sc_hd__fill_4_304 r0 *1 0,0
Xsky130_fd_sc_hd__fill_4_304
+ vss
+ vdd
+ vdd
+ sky130_fd_sc_hd__fill_4
* cell instance sky130_fd_sc_hd__fill_4_305 r0 *1 0,0
Xsky130_fd_sc_hd__fill_4_305
+ vss
+ vdd
+ vdd
+ sky130_fd_sc_hd__fill_4
* cell instance sky130_fd_sc_hd__fill_4_306 r0 *1 0,0
Xsky130_fd_sc_hd__fill_4_306
+ vss
+ vdd
+ vdd
+ sky130_fd_sc_hd__fill_4
* cell instance sky130_fd_sc_hd__fill_4_307 r0 *1 0,0
Xsky130_fd_sc_hd__fill_4_307
+ vss
+ vdd
+ vdd
+ sky130_fd_sc_hd__fill_4
* cell instance sky130_fd_sc_hd__fill_4_308 r0 *1 0,0
Xsky130_fd_sc_hd__fill_4_308
+ vss
+ vdd
+ vdd
+ sky130_fd_sc_hd__fill_4
* cell instance sky130_fd_sc_hd__fill_4_309 r0 *1 0,0
Xsky130_fd_sc_hd__fill_4_309
+ vss
+ vdd
+ vdd
+ sky130_fd_sc_hd__fill_4
* cell instance sky130_fd_sc_hd__fill_4_310 r0 *1 0,0
Xsky130_fd_sc_hd__fill_4_310
+ vss
+ vdd
+ vdd
+ sky130_fd_sc_hd__fill_4
* cell instance sky130_fd_sc_hd__fill_4_311 r0 *1 0,0
Xsky130_fd_sc_hd__fill_4_311
+ vss
+ vdd
+ vdd
+ sky130_fd_sc_hd__fill_4
* cell instance sky130_fd_sc_hd__fill_4_312 r0 *1 0,0
Xsky130_fd_sc_hd__fill_4_312
+ vss
+ vdd
+ vdd
+ sky130_fd_sc_hd__fill_4
* cell instance sky130_fd_sc_hd__fill_4_313 r0 *1 0,0
Xsky130_fd_sc_hd__fill_4_313
+ vss
+ vdd
+ vdd
+ sky130_fd_sc_hd__fill_4
* cell instance sky130_fd_sc_hd__fill_4_314 r0 *1 0,0
Xsky130_fd_sc_hd__fill_4_314
+ vss
+ vdd
+ vdd
+ sky130_fd_sc_hd__fill_4
* cell instance sky130_fd_sc_hd__fill_4_315 r0 *1 0,0
Xsky130_fd_sc_hd__fill_4_315
+ vss
+ vdd
+ vdd
+ sky130_fd_sc_hd__fill_4
* cell instance sky130_fd_sc_hd__fill_4_316 r0 *1 0,0
Xsky130_fd_sc_hd__fill_4_316
+ vss
+ vdd
+ vdd
+ sky130_fd_sc_hd__fill_4
* cell instance sky130_fd_sc_hd__fill_4_317 r0 *1 0,0
Xsky130_fd_sc_hd__fill_4_317
+ vss
+ vdd
+ vdd
+ sky130_fd_sc_hd__fill_4
* cell instance sky130_fd_sc_hd__fill_4_318 r0 *1 0,0
Xsky130_fd_sc_hd__fill_4_318
+ vss
+ vdd
+ vdd
+ sky130_fd_sc_hd__fill_4
* cell instance sky130_fd_sc_hd__fill_4_319 r0 *1 0,0
Xsky130_fd_sc_hd__fill_4_319
+ vss
+ vdd
+ vdd
+ sky130_fd_sc_hd__fill_4
* cell instance sky130_fd_sc_hd__fill_4_320 r0 *1 0,0
Xsky130_fd_sc_hd__fill_4_320
+ vss
+ vdd
+ vdd
+ sky130_fd_sc_hd__fill_4
* cell instance sky130_fd_sc_hd__fill_4_321 r0 *1 0,0
Xsky130_fd_sc_hd__fill_4_321
+ vss
+ vdd
+ vdd
+ sky130_fd_sc_hd__fill_4
* cell instance sky130_fd_sc_hd__fill_4_322 r0 *1 0,0
Xsky130_fd_sc_hd__fill_4_322
+ vss
+ vdd
+ vdd
+ sky130_fd_sc_hd__fill_4
* cell instance sky130_fd_sc_hd__fill_4_323 r0 *1 0,0
Xsky130_fd_sc_hd__fill_4_323
+ vss
+ vdd
+ vdd
+ sky130_fd_sc_hd__fill_4
* cell instance sky130_fd_sc_hd__fill_4_324 r0 *1 0,0
Xsky130_fd_sc_hd__fill_4_324
+ vss
+ vdd
+ vdd
+ sky130_fd_sc_hd__fill_4
* cell instance sky130_fd_sc_hd__fill_4_325 r0 *1 0,0
Xsky130_fd_sc_hd__fill_4_325
+ vss
+ vdd
+ vdd
+ sky130_fd_sc_hd__fill_4
* cell instance sky130_fd_sc_hd__fill_4_326 r0 *1 0,0
Xsky130_fd_sc_hd__fill_4_326
+ vss
+ vdd
+ vdd
+ sky130_fd_sc_hd__fill_4
* cell instance sky130_fd_sc_hd__fill_4_327 r0 *1 0,0
Xsky130_fd_sc_hd__fill_4_327
+ vss
+ vdd
+ vdd
+ sky130_fd_sc_hd__fill_4
* cell instance sky130_fd_sc_hd__fill_4_328 r0 *1 0,0
Xsky130_fd_sc_hd__fill_4_328
+ vss
+ vdd
+ vdd
+ sky130_fd_sc_hd__fill_4
* cell instance sky130_fd_sc_hd__fill_4_329 r0 *1 0,0
Xsky130_fd_sc_hd__fill_4_329
+ vss
+ vdd
+ vdd
+ sky130_fd_sc_hd__fill_4
* cell instance sky130_fd_sc_hd__fill_4_330 r0 *1 0,0
Xsky130_fd_sc_hd__fill_4_330
+ vss
+ vdd
+ vdd
+ sky130_fd_sc_hd__fill_4
* cell instance sky130_fd_sc_hd__fill_4_331 r0 *1 0,0
Xsky130_fd_sc_hd__fill_4_331
+ vss
+ vdd
+ vdd
+ sky130_fd_sc_hd__fill_4
* cell instance sky130_fd_sc_hd__fill_4_332 r0 *1 0,0
Xsky130_fd_sc_hd__fill_4_332
+ vss
+ vdd
+ vdd
+ sky130_fd_sc_hd__fill_4
* cell instance sky130_fd_sc_hd__fill_4_333 r0 *1 0,0
Xsky130_fd_sc_hd__fill_4_333
+ vss
+ vdd
+ vdd
+ sky130_fd_sc_hd__fill_4
* cell instance sky130_fd_sc_hd__fill_4_334 r0 *1 0,0
Xsky130_fd_sc_hd__fill_4_334
+ vss
+ vdd
+ vdd
+ sky130_fd_sc_hd__fill_4
* cell instance sky130_fd_sc_hd__fill_4_335 r0 *1 0,0
Xsky130_fd_sc_hd__fill_4_335
+ vss
+ vdd
+ vdd
+ sky130_fd_sc_hd__fill_4
* cell instance sky130_fd_sc_hd__fill_4_336 r0 *1 0,0
Xsky130_fd_sc_hd__fill_4_336
+ vss
+ vdd
+ vdd
+ sky130_fd_sc_hd__fill_4
* cell instance sky130_fd_sc_hd__fill_4_337 r0 *1 0,0
Xsky130_fd_sc_hd__fill_4_337
+ vss
+ vdd
+ vdd
+ sky130_fd_sc_hd__fill_4
* cell instance sky130_fd_sc_hd__fill_4_338 r0 *1 0,0
Xsky130_fd_sc_hd__fill_4_338
+ vss
+ vdd
+ vdd
+ sky130_fd_sc_hd__fill_4
* cell instance sky130_fd_sc_hd__fill_4_339 r0 *1 0,0
Xsky130_fd_sc_hd__fill_4_339
+ vss
+ vdd
+ vdd
+ sky130_fd_sc_hd__fill_4
* cell instance sky130_fd_sc_hd__fill_4_340 r0 *1 0,0
Xsky130_fd_sc_hd__fill_4_340
+ vss
+ vdd
+ vdd
+ sky130_fd_sc_hd__fill_4
* cell instance sky130_fd_sc_hd__fill_4_341 r0 *1 0,0
Xsky130_fd_sc_hd__fill_4_341
+ vss
+ vdd
+ vdd
+ sky130_fd_sc_hd__fill_4
* cell instance sky130_fd_sc_hd__fill_4_342 r0 *1 0,0
Xsky130_fd_sc_hd__fill_4_342
+ vss
+ vdd
+ vdd
+ sky130_fd_sc_hd__fill_4
* cell instance sky130_fd_sc_hd__fill_4_343 r0 *1 0,0
Xsky130_fd_sc_hd__fill_4_343
+ vss
+ vdd
+ vdd
+ sky130_fd_sc_hd__fill_4
* cell instance sky130_fd_sc_hd__fill_4_344 r0 *1 0,0
Xsky130_fd_sc_hd__fill_4_344
+ vss
+ vdd
+ vdd
+ sky130_fd_sc_hd__fill_4
* cell instance sky130_fd_sc_hd__fill_4_345 r0 *1 0,0
Xsky130_fd_sc_hd__fill_4_345
+ vss
+ vdd
+ vdd
+ sky130_fd_sc_hd__fill_4
* cell instance sky130_fd_sc_hd__fill_4_346 r0 *1 0,0
Xsky130_fd_sc_hd__fill_4_346
+ vss
+ vdd
+ vdd
+ sky130_fd_sc_hd__fill_4
* cell instance sky130_fd_sc_hd__fill_4_347 r0 *1 0,0
Xsky130_fd_sc_hd__fill_4_347
+ vss
+ vdd
+ vdd
+ sky130_fd_sc_hd__fill_4
* cell instance sky130_fd_sc_hd__fill_4_348 r0 *1 0,0
Xsky130_fd_sc_hd__fill_4_348
+ vss
+ vdd
+ vdd
+ sky130_fd_sc_hd__fill_4
* cell instance sky130_fd_sc_hd__fill_4_349 r0 *1 0,0
Xsky130_fd_sc_hd__fill_4_349
+ vss
+ vdd
+ vdd
+ sky130_fd_sc_hd__fill_4
* cell instance sky130_fd_sc_hd__fill_4_350 r0 *1 0,0
Xsky130_fd_sc_hd__fill_4_350
+ vss
+ vdd
+ vdd
+ sky130_fd_sc_hd__fill_4
* cell instance sky130_fd_sc_hd__fill_4_351 r0 *1 0,0
Xsky130_fd_sc_hd__fill_4_351
+ vss
+ vdd
+ vdd
+ sky130_fd_sc_hd__fill_4
* cell instance sky130_fd_sc_hd__fill_4_352 r0 *1 0,0
Xsky130_fd_sc_hd__fill_4_352
+ vss
+ vdd
+ vdd
+ sky130_fd_sc_hd__fill_4
* cell instance sky130_fd_sc_hd__fill_4_353 r0 *1 0,0
Xsky130_fd_sc_hd__fill_4_353
+ vss
+ vdd
+ vdd
+ sky130_fd_sc_hd__fill_4
* cell instance sky130_fd_sc_hd__fill_4_354 r0 *1 0,0
Xsky130_fd_sc_hd__fill_4_354
+ vss
+ vdd
+ vdd
+ sky130_fd_sc_hd__fill_4
* cell instance sky130_fd_sc_hd__fill_4_355 r0 *1 0,0
Xsky130_fd_sc_hd__fill_4_355
+ vss
+ vdd
+ vdd
+ sky130_fd_sc_hd__fill_4
* cell instance sky130_fd_sc_hd__fill_4_356 r0 *1 0,0
Xsky130_fd_sc_hd__fill_4_356
+ vss
+ vdd
+ vdd
+ sky130_fd_sc_hd__fill_4
* cell instance sky130_fd_sc_hd__fill_4_357 r0 *1 0,0
Xsky130_fd_sc_hd__fill_4_357
+ vss
+ vdd
+ vdd
+ sky130_fd_sc_hd__fill_4
* cell instance sky130_fd_sc_hd__fill_4_358 r0 *1 0,0
Xsky130_fd_sc_hd__fill_4_358
+ vss
+ vdd
+ vdd
+ sky130_fd_sc_hd__fill_4
* cell instance sky130_fd_sc_hd__fill_4_359 r0 *1 0,0
Xsky130_fd_sc_hd__fill_4_359
+ vss
+ vdd
+ vdd
+ sky130_fd_sc_hd__fill_4
* cell instance sky130_fd_sc_hd__fill_4_360 r0 *1 0,0
Xsky130_fd_sc_hd__fill_4_360
+ vss
+ vdd
+ vdd
+ sky130_fd_sc_hd__fill_4
* cell instance sky130_fd_sc_hd__fill_4_361 r0 *1 0,0
Xsky130_fd_sc_hd__fill_4_361
+ vss
+ vdd
+ vdd
+ sky130_fd_sc_hd__fill_4
* cell instance sky130_fd_sc_hd__fill_4_362 r0 *1 0,0
Xsky130_fd_sc_hd__fill_4_362
+ vss
+ vdd
+ vdd
+ sky130_fd_sc_hd__fill_4
* cell instance sky130_fd_sc_hd__fill_4_363 r0 *1 0,0
Xsky130_fd_sc_hd__fill_4_363
+ vss
+ vdd
+ vdd
+ sky130_fd_sc_hd__fill_4
* cell instance sky130_fd_sc_hd__fill_4_364 r0 *1 0,0
Xsky130_fd_sc_hd__fill_4_364
+ vss
+ vdd
+ vdd
+ sky130_fd_sc_hd__fill_4
* cell instance sky130_fd_sc_hd__fill_4_365 r0 *1 0,0
Xsky130_fd_sc_hd__fill_4_365
+ vss
+ vdd
+ vdd
+ sky130_fd_sc_hd__fill_4
* cell instance sky130_fd_sc_hd__fill_4_366 r0 *1 0,0
Xsky130_fd_sc_hd__fill_4_366
+ vss
+ vdd
+ vdd
+ sky130_fd_sc_hd__fill_4
* cell instance sky130_fd_sc_hd__fill_4_367 r0 *1 0,0
Xsky130_fd_sc_hd__fill_4_367
+ vss
+ vdd
+ vdd
+ sky130_fd_sc_hd__fill_4
* cell instance sky130_fd_sc_hd__fill_4_368 r0 *1 0,0
Xsky130_fd_sc_hd__fill_4_368
+ vss
+ vdd
+ vdd
+ sky130_fd_sc_hd__fill_4
* cell instance sky130_fd_sc_hd__fill_4_369 r0 *1 0,0
Xsky130_fd_sc_hd__fill_4_369
+ vss
+ vdd
+ vdd
+ sky130_fd_sc_hd__fill_4
* cell instance sky130_fd_sc_hd__fill_4_370 r0 *1 0,0
Xsky130_fd_sc_hd__fill_4_370
+ vss
+ vdd
+ vdd
+ sky130_fd_sc_hd__fill_4
* cell instance sky130_fd_sc_hd__fill_4_371 r0 *1 0,0
Xsky130_fd_sc_hd__fill_4_371
+ vss
+ vdd
+ vdd
+ sky130_fd_sc_hd__fill_4
* cell instance sky130_fd_sc_hd__fill_4_372 r0 *1 0,0
Xsky130_fd_sc_hd__fill_4_372
+ vss
+ vdd
+ vdd
+ sky130_fd_sc_hd__fill_4
* cell instance sky130_fd_sc_hd__fill_4_373 r0 *1 0,0
Xsky130_fd_sc_hd__fill_4_373
+ vss
+ vdd
+ vdd
+ sky130_fd_sc_hd__fill_4
* cell instance sky130_fd_sc_hd__fill_4_374 r0 *1 0,0
Xsky130_fd_sc_hd__fill_4_374
+ vss
+ vdd
+ vdd
+ sky130_fd_sc_hd__fill_4
* cell instance sky130_fd_sc_hd__fill_4_375 r0 *1 0,0
Xsky130_fd_sc_hd__fill_4_375
+ vss
+ vdd
+ vdd
+ sky130_fd_sc_hd__fill_4
* cell instance sky130_fd_sc_hd__fill_4_376 r0 *1 0,0
Xsky130_fd_sc_hd__fill_4_376
+ vss
+ vdd
+ vdd
+ sky130_fd_sc_hd__fill_4
* cell instance sky130_fd_sc_hd__fill_4_377 r0 *1 0,0
Xsky130_fd_sc_hd__fill_4_377
+ vss
+ vdd
+ vdd
+ sky130_fd_sc_hd__fill_4
* cell instance sky130_fd_sc_hd__fill_4_378 r0 *1 0,0
Xsky130_fd_sc_hd__fill_4_378
+ vss
+ vdd
+ vdd
+ sky130_fd_sc_hd__fill_4
* cell instance sky130_fd_sc_hd__fill_4_379 r0 *1 0,0
Xsky130_fd_sc_hd__fill_4_379
+ vss
+ vdd
+ vdd
+ sky130_fd_sc_hd__fill_4
* cell instance sky130_fd_sc_hd__fill_4_380 r0 *1 0,0
Xsky130_fd_sc_hd__fill_4_380
+ vss
+ vdd
+ vdd
+ sky130_fd_sc_hd__fill_4
* cell instance sky130_fd_sc_hd__fill_4_381 r0 *1 0,0
Xsky130_fd_sc_hd__fill_4_381
+ vss
+ vdd
+ vdd
+ sky130_fd_sc_hd__fill_4
* cell instance sky130_fd_sc_hd__fill_4_382 r0 *1 0,0
Xsky130_fd_sc_hd__fill_4_382
+ vss
+ vdd
+ vdd
+ sky130_fd_sc_hd__fill_4
* cell instance sky130_fd_sc_hd__fill_4_383 r0 *1 0,0
Xsky130_fd_sc_hd__fill_4_383
+ vss
+ vdd
+ vdd
+ sky130_fd_sc_hd__fill_4
* cell instance sky130_fd_sc_hd__fill_4_384 r0 *1 0,0
Xsky130_fd_sc_hd__fill_4_384
+ vss
+ vdd
+ vdd
+ sky130_fd_sc_hd__fill_4
* cell instance sky130_fd_sc_hd__fill_4_385 r0 *1 0,0
Xsky130_fd_sc_hd__fill_4_385
+ vss
+ vdd
+ vdd
+ sky130_fd_sc_hd__fill_4
* cell instance sky130_fd_sc_hd__fill_4_386 r0 *1 0,0
Xsky130_fd_sc_hd__fill_4_386
+ vss
+ vdd
+ vdd
+ sky130_fd_sc_hd__fill_4
* cell instance sky130_fd_sc_hd__fill_4_387 r0 *1 0,0
Xsky130_fd_sc_hd__fill_4_387
+ vss
+ vdd
+ vdd
+ sky130_fd_sc_hd__fill_4
* cell instance sky130_fd_sc_hd__fill_4_388 r0 *1 0,0
Xsky130_fd_sc_hd__fill_4_388
+ vss
+ vdd
+ vdd
+ sky130_fd_sc_hd__fill_4
* cell instance sky130_fd_sc_hd__fill_4_389 r0 *1 0,0
Xsky130_fd_sc_hd__fill_4_389
+ vss
+ vdd
+ vdd
+ sky130_fd_sc_hd__fill_4
* cell instance sky130_fd_sc_hd__fill_4_390 r0 *1 0,0
Xsky130_fd_sc_hd__fill_4_390
+ vss
+ vdd
+ vdd
+ sky130_fd_sc_hd__fill_4
* cell instance sky130_fd_sc_hd__fill_4_391 r0 *1 0,0
Xsky130_fd_sc_hd__fill_4_391
+ vss
+ vdd
+ vdd
+ sky130_fd_sc_hd__fill_4
* cell instance sky130_fd_sc_hd__fill_4_392 r0 *1 0,0
Xsky130_fd_sc_hd__fill_4_392
+ vss
+ vdd
+ vdd
+ sky130_fd_sc_hd__fill_4
* cell instance sky130_fd_sc_hd__fill_4_393 r0 *1 0,0
Xsky130_fd_sc_hd__fill_4_393
+ vss
+ vdd
+ vdd
+ sky130_fd_sc_hd__fill_4
* cell instance sky130_fd_sc_hd__fill_4_394 r0 *1 0,0
Xsky130_fd_sc_hd__fill_4_394
+ vss
+ vdd
+ vdd
+ sky130_fd_sc_hd__fill_4
* cell instance sky130_fd_sc_hd__fill_4_395 r0 *1 0,0
Xsky130_fd_sc_hd__fill_4_395
+ vss
+ vdd
+ vdd
+ sky130_fd_sc_hd__fill_4
* cell instance sky130_fd_sc_hd__fill_4_396 r0 *1 0,0
Xsky130_fd_sc_hd__fill_4_396
+ vss
+ vdd
+ vdd
+ sky130_fd_sc_hd__fill_4
* cell instance sky130_fd_sc_hd__fill_4_397 r0 *1 0,0
Xsky130_fd_sc_hd__fill_4_397
+ vss
+ vdd
+ vdd
+ sky130_fd_sc_hd__fill_4
* cell instance sky130_fd_sc_hd__fill_4_398 r0 *1 0,0
Xsky130_fd_sc_hd__fill_4_398
+ vss
+ vdd
+ vdd
+ sky130_fd_sc_hd__fill_4
* cell instance sky130_fd_sc_hd__fill_4_399 r0 *1 0,0
Xsky130_fd_sc_hd__fill_4_399
+ vss
+ vdd
+ vdd
+ sky130_fd_sc_hd__fill_4
* cell instance sky130_fd_sc_hd__fill_4_400 r0 *1 0,0
Xsky130_fd_sc_hd__fill_4_400
+ vss
+ vdd
+ vdd
+ sky130_fd_sc_hd__fill_4
* cell instance sky130_fd_sc_hd__fill_4_401 r0 *1 0,0
Xsky130_fd_sc_hd__fill_4_401
+ vss
+ vdd
+ vdd
+ sky130_fd_sc_hd__fill_4
* cell instance sky130_fd_sc_hd__fill_4_402 r0 *1 0,0
Xsky130_fd_sc_hd__fill_4_402
+ vss
+ vdd
+ vdd
+ sky130_fd_sc_hd__fill_4
* cell instance sky130_fd_sc_hd__fill_4_403 r0 *1 0,0
Xsky130_fd_sc_hd__fill_4_403
+ vss
+ vdd
+ vdd
+ sky130_fd_sc_hd__fill_4
* cell instance sky130_fd_sc_hd__fill_4_404 r0 *1 0,0
Xsky130_fd_sc_hd__fill_4_404
+ vss
+ vdd
+ vdd
+ sky130_fd_sc_hd__fill_4
* cell instance sky130_fd_sc_hd__fill_4_405 r0 *1 0,0
Xsky130_fd_sc_hd__fill_4_405
+ vss
+ vdd
+ vdd
+ sky130_fd_sc_hd__fill_4
* cell instance sky130_fd_sc_hd__fill_4_406 r0 *1 0,0
Xsky130_fd_sc_hd__fill_4_406
+ vss
+ vdd
+ vdd
+ sky130_fd_sc_hd__fill_4
* cell instance sky130_fd_sc_hd__fill_4_407 r0 *1 0,0
Xsky130_fd_sc_hd__fill_4_407
+ vss
+ vdd
+ vdd
+ sky130_fd_sc_hd__fill_4
* cell instance sky130_fd_sc_hd__fill_4_408 r0 *1 0,0
Xsky130_fd_sc_hd__fill_4_408
+ vss
+ vdd
+ vdd
+ sky130_fd_sc_hd__fill_4
* cell instance sky130_fd_sc_hd__fill_4_409 r0 *1 0,0
Xsky130_fd_sc_hd__fill_4_409
+ vss
+ vdd
+ vdd
+ sky130_fd_sc_hd__fill_4
* cell instance sky130_fd_sc_hd__fill_4_410 r0 *1 0,0
Xsky130_fd_sc_hd__fill_4_410
+ vss
+ vdd
+ vdd
+ sky130_fd_sc_hd__fill_4
* cell instance sky130_fd_sc_hd__fill_4_411 r0 *1 0,0
Xsky130_fd_sc_hd__fill_4_411
+ vss
+ vdd
+ vdd
+ sky130_fd_sc_hd__fill_4
* cell instance sky130_fd_sc_hd__fill_4_412 r0 *1 0,0
Xsky130_fd_sc_hd__fill_4_412
+ vss
+ vdd
+ vdd
+ sky130_fd_sc_hd__fill_4
* cell instance sky130_fd_sc_hd__fill_4_413 r0 *1 0,0
Xsky130_fd_sc_hd__fill_4_413
+ vss
+ vdd
+ vdd
+ sky130_fd_sc_hd__fill_4
* cell instance sky130_fd_sc_hd__fill_4_414 r0 *1 0,0
Xsky130_fd_sc_hd__fill_4_414
+ vss
+ vdd
+ vdd
+ sky130_fd_sc_hd__fill_4
* cell instance sky130_fd_sc_hd__fill_4_415 r0 *1 0,0
Xsky130_fd_sc_hd__fill_4_415
+ vss
+ vdd
+ vdd
+ sky130_fd_sc_hd__fill_4
* cell instance sky130_fd_sc_hd__fill_4_416 r0 *1 0,0
Xsky130_fd_sc_hd__fill_4_416
+ vss
+ vdd
+ vdd
+ sky130_fd_sc_hd__fill_4
* cell instance sky130_fd_sc_hd__fill_4_417 r0 *1 0,0
Xsky130_fd_sc_hd__fill_4_417
+ vss
+ vdd
+ vdd
+ sky130_fd_sc_hd__fill_4
* cell instance sky130_fd_sc_hd__fill_4_418 r0 *1 0,0
Xsky130_fd_sc_hd__fill_4_418
+ vss
+ vdd
+ vdd
+ sky130_fd_sc_hd__fill_4
* cell instance sky130_fd_sc_hd__fill_4_419 r0 *1 0,0
Xsky130_fd_sc_hd__fill_4_419
+ vss
+ vdd
+ vdd
+ sky130_fd_sc_hd__fill_4
* cell instance sky130_fd_sc_hd__fill_4_420 r0 *1 0,0
Xsky130_fd_sc_hd__fill_4_420
+ vss
+ vdd
+ vdd
+ sky130_fd_sc_hd__fill_4
* cell instance sky130_fd_sc_hd__fill_4_421 r0 *1 0,0
Xsky130_fd_sc_hd__fill_4_421
+ vss
+ vdd
+ vdd
+ sky130_fd_sc_hd__fill_4
* cell instance sky130_fd_sc_hd__fill_4_422 r0 *1 0,0
Xsky130_fd_sc_hd__fill_4_422
+ vss
+ vdd
+ vdd
+ sky130_fd_sc_hd__fill_4
* cell instance sky130_fd_sc_hd__fill_4_423 r0 *1 0,0
Xsky130_fd_sc_hd__fill_4_423
+ vss
+ vdd
+ vdd
+ sky130_fd_sc_hd__fill_4
* cell instance sky130_fd_sc_hd__fill_4_424 r0 *1 0,0
Xsky130_fd_sc_hd__fill_4_424
+ vss
+ vdd
+ vdd
+ sky130_fd_sc_hd__fill_4
* cell instance sky130_fd_sc_hd__fill_4_425 r0 *1 0,0
Xsky130_fd_sc_hd__fill_4_425
+ vss
+ vdd
+ vdd
+ sky130_fd_sc_hd__fill_4
* cell instance sky130_fd_sc_hd__fill_4_426 r0 *1 0,0
Xsky130_fd_sc_hd__fill_4_426
+ vss
+ vdd
+ vdd
+ sky130_fd_sc_hd__fill_4
* cell instance sky130_fd_sc_hd__fill_4_427 r0 *1 0,0
Xsky130_fd_sc_hd__fill_4_427
+ vss
+ vdd
+ vdd
+ sky130_fd_sc_hd__fill_4
* cell instance sky130_fd_sc_hd__fill_4_428 r0 *1 0,0
Xsky130_fd_sc_hd__fill_4_428
+ vss
+ vdd
+ vdd
+ sky130_fd_sc_hd__fill_4
* cell instance sky130_fd_sc_hd__fill_4_429 r0 *1 0,0
Xsky130_fd_sc_hd__fill_4_429
+ vss
+ vdd
+ vdd
+ sky130_fd_sc_hd__fill_4
* cell instance sky130_fd_sc_hd__fill_4_430 r0 *1 0,0
Xsky130_fd_sc_hd__fill_4_430
+ vss
+ vdd
+ vdd
+ sky130_fd_sc_hd__fill_4
* cell instance sky130_fd_sc_hd__fill_4_431 r0 *1 0,0
Xsky130_fd_sc_hd__fill_4_431
+ vss
+ vdd
+ vdd
+ sky130_fd_sc_hd__fill_4
* cell instance sky130_fd_sc_hd__fill_4_432 r0 *1 0,0
Xsky130_fd_sc_hd__fill_4_432
+ vss
+ vdd
+ vdd
+ sky130_fd_sc_hd__fill_4
* cell instance sky130_fd_sc_hd__fill_4_433 r0 *1 0,0
Xsky130_fd_sc_hd__fill_4_433
+ vss
+ vdd
+ vdd
+ sky130_fd_sc_hd__fill_4
* cell instance sky130_fd_sc_hd__fill_4_434 r0 *1 0,0
Xsky130_fd_sc_hd__fill_4_434
+ vss
+ vdd
+ vdd
+ sky130_fd_sc_hd__fill_4
* cell instance sky130_fd_sc_hd__fill_4_435 r0 *1 0,0
Xsky130_fd_sc_hd__fill_4_435
+ vss
+ vdd
+ vdd
+ sky130_fd_sc_hd__fill_4
* cell instance sky130_fd_sc_hd__fill_4_436 r0 *1 0,0
Xsky130_fd_sc_hd__fill_4_436
+ vss
+ vdd
+ vdd
+ sky130_fd_sc_hd__fill_4
* cell instance sky130_fd_sc_hd__fill_4_437 r0 *1 0,0
Xsky130_fd_sc_hd__fill_4_437
+ vss
+ vdd
+ vdd
+ sky130_fd_sc_hd__fill_4
* cell instance sky130_fd_sc_hd__fill_4_438 r0 *1 0,0
Xsky130_fd_sc_hd__fill_4_438
+ vss
+ vdd
+ vdd
+ sky130_fd_sc_hd__fill_4
* cell instance sky130_fd_sc_hd__fill_4_439 r0 *1 0,0
Xsky130_fd_sc_hd__fill_4_439
+ vss
+ vdd
+ vdd
+ sky130_fd_sc_hd__fill_4
* cell instance sky130_fd_sc_hd__fill_4_440 r0 *1 0,0
Xsky130_fd_sc_hd__fill_4_440
+ vss
+ vdd
+ vdd
+ sky130_fd_sc_hd__fill_4
* cell instance sky130_fd_sc_hd__fill_4_441 r0 *1 0,0
Xsky130_fd_sc_hd__fill_4_441
+ vss
+ vdd
+ vdd
+ sky130_fd_sc_hd__fill_4
* cell instance sky130_fd_sc_hd__fill_4_442 r0 *1 0,0
Xsky130_fd_sc_hd__fill_4_442
+ vss
+ vdd
+ vdd
+ sky130_fd_sc_hd__fill_4
* cell instance sky130_fd_sc_hd__fill_4_443 r0 *1 0,0
Xsky130_fd_sc_hd__fill_4_443
+ vss
+ vdd
+ vdd
+ sky130_fd_sc_hd__fill_4
* cell instance sky130_fd_sc_hd__fill_4_444 r0 *1 0,0
Xsky130_fd_sc_hd__fill_4_444
+ vss
+ vdd
+ vdd
+ sky130_fd_sc_hd__fill_4
* cell instance sky130_fd_sc_hd__fill_4_445 r0 *1 0,0
Xsky130_fd_sc_hd__fill_4_445
+ vss
+ vdd
+ vdd
+ sky130_fd_sc_hd__fill_4
* cell instance sky130_fd_sc_hd__fill_4_446 r0 *1 0,0
Xsky130_fd_sc_hd__fill_4_446
+ vss
+ vdd
+ vdd
+ sky130_fd_sc_hd__fill_4
* cell instance sky130_fd_sc_hd__fill_4_447 r0 *1 0,0
Xsky130_fd_sc_hd__fill_4_447
+ vss
+ vdd
+ vdd
+ sky130_fd_sc_hd__fill_4
* cell instance sky130_fd_sc_hd__fill_4_448 r0 *1 0,0
Xsky130_fd_sc_hd__fill_4_448
+ vss
+ vdd
+ vdd
+ sky130_fd_sc_hd__fill_4
* cell instance sky130_fd_sc_hd__fill_4_449 r0 *1 0,0
Xsky130_fd_sc_hd__fill_4_449
+ vss
+ vdd
+ vdd
+ sky130_fd_sc_hd__fill_4
* cell instance sky130_fd_sc_hd__fill_4_450 r0 *1 0,0
Xsky130_fd_sc_hd__fill_4_450
+ vss
+ vdd
+ vdd
+ sky130_fd_sc_hd__fill_4
* cell instance sky130_fd_sc_hd__fill_4_451 r0 *1 0,0
Xsky130_fd_sc_hd__fill_4_451
+ vss
+ vdd
+ vdd
+ sky130_fd_sc_hd__fill_4
* cell instance sky130_fd_sc_hd__fill_4_452 r0 *1 0,0
Xsky130_fd_sc_hd__fill_4_452
+ vss
+ vdd
+ vdd
+ sky130_fd_sc_hd__fill_4
* cell instance sky130_fd_sc_hd__fill_4_453 r0 *1 0,0
Xsky130_fd_sc_hd__fill_4_453
+ vss
+ vdd
+ vdd
+ sky130_fd_sc_hd__fill_4
* cell instance sky130_fd_sc_hd__fill_4_454 r0 *1 0,0
Xsky130_fd_sc_hd__fill_4_454
+ vss
+ vdd
+ vdd
+ sky130_fd_sc_hd__fill_4
* cell instance sky130_fd_sc_hd__fill_4_455 r0 *1 0,0
Xsky130_fd_sc_hd__fill_4_455
+ vss
+ vdd
+ vdd
+ sky130_fd_sc_hd__fill_4
* cell instance sky130_fd_sc_hd__fill_4_456 r0 *1 0,0
Xsky130_fd_sc_hd__fill_4_456
+ vss
+ vdd
+ vdd
+ sky130_fd_sc_hd__fill_4
* cell instance sky130_fd_sc_hd__fill_4_457 r0 *1 0,0
Xsky130_fd_sc_hd__fill_4_457
+ vss
+ vdd
+ vdd
+ sky130_fd_sc_hd__fill_4
* cell instance sky130_fd_sc_hd__fill_4_458 r0 *1 0,0
Xsky130_fd_sc_hd__fill_4_458
+ vss
+ vdd
+ vdd
+ sky130_fd_sc_hd__fill_4
* cell instance sky130_fd_sc_hd__fill_4_459 r0 *1 0,0
Xsky130_fd_sc_hd__fill_4_459
+ vss
+ vdd
+ vdd
+ sky130_fd_sc_hd__fill_4
* cell instance sky130_fd_sc_hd__fill_4_460 r0 *1 0,0
Xsky130_fd_sc_hd__fill_4_460
+ vss
+ vdd
+ vdd
+ sky130_fd_sc_hd__fill_4
* cell instance sky130_fd_sc_hd__fill_4_461 r0 *1 0,0
Xsky130_fd_sc_hd__fill_4_461
+ vss
+ vdd
+ vdd
+ sky130_fd_sc_hd__fill_4
* cell instance sky130_fd_sc_hd__fill_4_462 r0 *1 0,0
Xsky130_fd_sc_hd__fill_4_462
+ vss
+ vdd
+ vdd
+ sky130_fd_sc_hd__fill_4
* cell instance sky130_fd_sc_hd__fill_4_463 r0 *1 0,0
Xsky130_fd_sc_hd__fill_4_463
+ vss
+ vdd
+ vdd
+ sky130_fd_sc_hd__fill_4
* cell instance sky130_fd_sc_hd__fill_4_464 r0 *1 0,0
Xsky130_fd_sc_hd__fill_4_464
+ vss
+ vdd
+ vdd
+ sky130_fd_sc_hd__fill_4
* cell instance sky130_fd_sc_hd__fill_4_465 r0 *1 0,0
Xsky130_fd_sc_hd__fill_4_465
+ vss
+ vdd
+ vdd
+ sky130_fd_sc_hd__fill_4
* cell instance sky130_fd_sc_hd__fill_4_466 r0 *1 0,0
Xsky130_fd_sc_hd__fill_4_466
+ vss
+ vdd
+ vdd
+ sky130_fd_sc_hd__fill_4
* cell instance sky130_fd_sc_hd__fill_4_467 r0 *1 0,0
Xsky130_fd_sc_hd__fill_4_467
+ vss
+ vdd
+ vdd
+ sky130_fd_sc_hd__fill_4
* cell instance sky130_fd_sc_hd__fill_4_468 r0 *1 0,0
Xsky130_fd_sc_hd__fill_4_468
+ vss
+ vdd
+ vdd
+ sky130_fd_sc_hd__fill_4
* cell instance sky130_fd_sc_hd__fill_4_469 r0 *1 0,0
Xsky130_fd_sc_hd__fill_4_469
+ vss
+ vdd
+ vdd
+ sky130_fd_sc_hd__fill_4
* cell instance sky130_fd_sc_hd__fill_4_470 r0 *1 0,0
Xsky130_fd_sc_hd__fill_4_470
+ vss
+ vdd
+ vdd
+ sky130_fd_sc_hd__fill_4
* cell instance sky130_fd_sc_hd__fill_4_471 r0 *1 0,0
Xsky130_fd_sc_hd__fill_4_471
+ vss
+ vdd
+ vdd
+ sky130_fd_sc_hd__fill_4
* cell instance sky130_fd_sc_hd__fill_4_472 r0 *1 0,0
Xsky130_fd_sc_hd__fill_4_472
+ vss
+ vdd
+ vdd
+ sky130_fd_sc_hd__fill_4
* cell instance sky130_fd_sc_hd__fill_4_473 r0 *1 0,0
Xsky130_fd_sc_hd__fill_4_473
+ vss
+ vdd
+ vdd
+ sky130_fd_sc_hd__fill_4
* cell instance sky130_fd_sc_hd__fill_4_474 r0 *1 0,0
Xsky130_fd_sc_hd__fill_4_474
+ vss
+ vdd
+ vdd
+ sky130_fd_sc_hd__fill_4
* cell instance sky130_fd_sc_hd__fill_4_475 r0 *1 0,0
Xsky130_fd_sc_hd__fill_4_475
+ vss
+ vdd
+ vdd
+ sky130_fd_sc_hd__fill_4
* cell instance sky130_fd_sc_hd__fill_4_476 r0 *1 0,0
Xsky130_fd_sc_hd__fill_4_476
+ vss
+ vdd
+ vdd
+ sky130_fd_sc_hd__fill_4
* cell instance sky130_fd_sc_hd__fill_4_477 r0 *1 0,0
Xsky130_fd_sc_hd__fill_4_477
+ vss
+ vdd
+ vdd
+ sky130_fd_sc_hd__fill_4
* cell instance sky130_fd_sc_hd__fill_4_478 r0 *1 0,0
Xsky130_fd_sc_hd__fill_4_478
+ vss
+ vdd
+ vdd
+ sky130_fd_sc_hd__fill_4
* cell instance sky130_fd_sc_hd__fill_4_479 r0 *1 0,0
Xsky130_fd_sc_hd__fill_4_479
+ vss
+ vdd
+ vdd
+ sky130_fd_sc_hd__fill_4
* cell instance sky130_fd_sc_hd__fill_4_480 r0 *1 0,0
Xsky130_fd_sc_hd__fill_4_480
+ vss
+ vdd
+ vdd
+ sky130_fd_sc_hd__fill_4
* cell instance sky130_fd_sc_hd__fill_4_481 r0 *1 0,0
Xsky130_fd_sc_hd__fill_4_481
+ vss
+ vdd
+ vdd
+ sky130_fd_sc_hd__fill_4
* cell instance sky130_fd_sc_hd__fill_4_482 r0 *1 0,0
Xsky130_fd_sc_hd__fill_4_482
+ vss
+ vdd
+ vdd
+ sky130_fd_sc_hd__fill_4
* cell instance sky130_fd_sc_hd__fill_4_483 r0 *1 0,0
Xsky130_fd_sc_hd__fill_4_483
+ vss
+ vdd
+ vdd
+ sky130_fd_sc_hd__fill_4
* cell instance sky130_fd_sc_hd__fill_4_484 r0 *1 0,0
Xsky130_fd_sc_hd__fill_4_484
+ vss
+ vdd
+ vdd
+ sky130_fd_sc_hd__fill_4
* cell instance sky130_fd_sc_hd__fill_4_485 r0 *1 0,0
Xsky130_fd_sc_hd__fill_4_485
+ vss
+ vdd
+ vdd
+ sky130_fd_sc_hd__fill_4
* cell instance sky130_fd_sc_hd__fill_4_486 r0 *1 0,0
Xsky130_fd_sc_hd__fill_4_486
+ vss
+ vdd
+ vdd
+ sky130_fd_sc_hd__fill_4
* cell instance sky130_fd_sc_hd__fill_4_487 r0 *1 0,0
Xsky130_fd_sc_hd__fill_4_487
+ vss
+ vdd
+ vdd
+ sky130_fd_sc_hd__fill_4
* cell instance sky130_fd_sc_hd__fill_4_488 r0 *1 0,0
Xsky130_fd_sc_hd__fill_4_488
+ vss
+ vdd
+ vdd
+ sky130_fd_sc_hd__fill_4
* cell instance sky130_fd_sc_hd__fill_4_489 r0 *1 0,0
Xsky130_fd_sc_hd__fill_4_489
+ vss
+ vdd
+ vdd
+ sky130_fd_sc_hd__fill_4
* cell instance sky130_fd_sc_hd__fill_4_490 r0 *1 0,0
Xsky130_fd_sc_hd__fill_4_490
+ vss
+ vdd
+ vdd
+ sky130_fd_sc_hd__fill_4
* cell instance sky130_fd_sc_hd__fill_4_491 r0 *1 0,0
Xsky130_fd_sc_hd__fill_4_491
+ vss
+ vdd
+ vdd
+ sky130_fd_sc_hd__fill_4
* cell instance sky130_fd_sc_hd__fill_4_492 r0 *1 0,0
Xsky130_fd_sc_hd__fill_4_492
+ vss
+ vdd
+ vdd
+ sky130_fd_sc_hd__fill_4
* cell instance sky130_fd_sc_hd__fill_4_493 r0 *1 0,0
Xsky130_fd_sc_hd__fill_4_493
+ vss
+ vdd
+ vdd
+ sky130_fd_sc_hd__fill_4
* cell instance sky130_fd_sc_hd__fill_4_494 r0 *1 0,0
Xsky130_fd_sc_hd__fill_4_494
+ vss
+ vdd
+ vdd
+ sky130_fd_sc_hd__fill_4
* cell instance sky130_fd_sc_hd__fill_4_495 r0 *1 0,0
Xsky130_fd_sc_hd__fill_4_495
+ vss
+ vdd
+ vdd
+ sky130_fd_sc_hd__fill_4
* cell instance sky130_fd_sc_hd__fill_4_496 r0 *1 0,0
Xsky130_fd_sc_hd__fill_4_496
+ vss
+ vdd
+ vdd
+ sky130_fd_sc_hd__fill_4
* cell instance sky130_fd_sc_hd__fill_4_497 r0 *1 0,0
Xsky130_fd_sc_hd__fill_4_497
+ vss
+ vdd
+ vdd
+ sky130_fd_sc_hd__fill_4
* cell instance sky130_fd_sc_hd__fill_4_498 r0 *1 0,0
Xsky130_fd_sc_hd__fill_4_498
+ vss
+ vdd
+ vdd
+ sky130_fd_sc_hd__fill_4
* cell instance sky130_fd_sc_hd__fill_4_499 r0 *1 0,0
Xsky130_fd_sc_hd__fill_4_499
+ vss
+ vdd
+ vdd
+ sky130_fd_sc_hd__fill_4
* cell instance sky130_fd_sc_hd__fill_4_500 r0 *1 0,0
Xsky130_fd_sc_hd__fill_4_500
+ vss
+ vdd
+ vdd
+ sky130_fd_sc_hd__fill_4
* cell instance sky130_fd_sc_hd__fill_4_501 r0 *1 0,0
Xsky130_fd_sc_hd__fill_4_501
+ vss
+ vdd
+ vdd
+ sky130_fd_sc_hd__fill_4
* cell instance sky130_fd_sc_hd__fill_4_502 r0 *1 0,0
Xsky130_fd_sc_hd__fill_4_502
+ vss
+ vdd
+ vdd
+ sky130_fd_sc_hd__fill_4
* cell instance sky130_fd_sc_hd__fill_4_503 r0 *1 0,0
Xsky130_fd_sc_hd__fill_4_503
+ vss
+ vdd
+ vdd
+ sky130_fd_sc_hd__fill_4
* cell instance sky130_fd_sc_hd__fill_4_504 r0 *1 0,0
Xsky130_fd_sc_hd__fill_4_504
+ vss
+ vdd
+ vdd
+ sky130_fd_sc_hd__fill_4
* cell instance sky130_fd_sc_hd__fill_4_505 r0 *1 0,0
Xsky130_fd_sc_hd__fill_4_505
+ vss
+ vdd
+ vdd
+ sky130_fd_sc_hd__fill_4
* cell instance sky130_fd_sc_hd__fill_4_506 r0 *1 0,0
Xsky130_fd_sc_hd__fill_4_506
+ vss
+ vdd
+ vdd
+ sky130_fd_sc_hd__fill_4
* cell instance sky130_fd_sc_hd__fill_4_507 r0 *1 0,0
Xsky130_fd_sc_hd__fill_4_507
+ vss
+ vdd
+ vdd
+ sky130_fd_sc_hd__fill_4
* cell instance sky130_fd_sc_hd__fill_4_508 r0 *1 0,0
Xsky130_fd_sc_hd__fill_4_508
+ vss
+ vdd
+ vdd
+ sky130_fd_sc_hd__fill_4
* cell instance sky130_fd_sc_hd__fill_4_509 r0 *1 0,0
Xsky130_fd_sc_hd__fill_4_509
+ vss
+ vdd
+ vdd
+ sky130_fd_sc_hd__fill_4
* cell instance sky130_fd_sc_hd__fill_4_510 r0 *1 0,0
Xsky130_fd_sc_hd__fill_4_510
+ vss
+ vdd
+ vdd
+ sky130_fd_sc_hd__fill_4
* cell instance sky130_fd_sc_hd__fill_4_511 r0 *1 0,0
Xsky130_fd_sc_hd__fill_4_511
+ vss
+ vdd
+ vdd
+ sky130_fd_sc_hd__fill_4
* cell instance sky130_fd_sc_hd__fill_4_512 r0 *1 0,0
Xsky130_fd_sc_hd__fill_4_512
+ vss
+ vdd
+ vdd
+ sky130_fd_sc_hd__fill_4
* cell instance sky130_fd_sc_hd__fill_4_513 r0 *1 0,0
Xsky130_fd_sc_hd__fill_4_513
+ vss
+ vdd
+ vdd
+ sky130_fd_sc_hd__fill_4
* cell instance sky130_fd_sc_hd__fill_4_514 r0 *1 0,0
Xsky130_fd_sc_hd__fill_4_514
+ vss
+ vdd
+ vdd
+ sky130_fd_sc_hd__fill_4
* cell instance sky130_fd_sc_hd__fill_4_515 r0 *1 0,0
Xsky130_fd_sc_hd__fill_4_515
+ vss
+ vdd
+ vdd
+ sky130_fd_sc_hd__fill_4
* cell instance sky130_fd_sc_hd__fill_4_516 r0 *1 0,0
Xsky130_fd_sc_hd__fill_4_516
+ vss
+ vdd
+ vdd
+ sky130_fd_sc_hd__fill_4
* cell instance sky130_fd_sc_hd__fill_4_517 r0 *1 0,0
Xsky130_fd_sc_hd__fill_4_517
+ vss
+ vdd
+ vdd
+ sky130_fd_sc_hd__fill_4
* cell instance sky130_fd_sc_hd__fill_4_518 r0 *1 0,0
Xsky130_fd_sc_hd__fill_4_518
+ vss
+ vdd
+ vdd
+ sky130_fd_sc_hd__fill_4
* cell instance sky130_fd_sc_hd__fill_4_519 r0 *1 0,0
Xsky130_fd_sc_hd__fill_4_519
+ vss
+ vdd
+ vdd
+ sky130_fd_sc_hd__fill_4
* cell instance sky130_fd_sc_hd__fill_4_520 r0 *1 0,0
Xsky130_fd_sc_hd__fill_4_520
+ vss
+ vdd
+ vdd
+ sky130_fd_sc_hd__fill_4
* cell instance sky130_fd_sc_hd__fill_4_521 r0 *1 0,0
Xsky130_fd_sc_hd__fill_4_521
+ vss
+ vdd
+ vdd
+ sky130_fd_sc_hd__fill_4
* cell instance sky130_fd_sc_hd__fill_4_522 r0 *1 0,0
Xsky130_fd_sc_hd__fill_4_522
+ vss
+ vdd
+ vdd
+ sky130_fd_sc_hd__fill_4
* cell instance sky130_fd_sc_hd__fill_4_523 r0 *1 0,0
Xsky130_fd_sc_hd__fill_4_523
+ vss
+ vdd
+ vdd
+ sky130_fd_sc_hd__fill_4
* cell instance sky130_fd_sc_hd__fill_4_524 r0 *1 0,0
Xsky130_fd_sc_hd__fill_4_524
+ vss
+ vdd
+ vdd
+ sky130_fd_sc_hd__fill_4
* cell instance sky130_fd_sc_hd__fill_4_525 r0 *1 0,0
Xsky130_fd_sc_hd__fill_4_525
+ vss
+ vdd
+ vdd
+ sky130_fd_sc_hd__fill_4
* cell instance sky130_fd_sc_hd__fill_4_526 r0 *1 0,0
Xsky130_fd_sc_hd__fill_4_526
+ vss
+ vdd
+ vdd
+ sky130_fd_sc_hd__fill_4
* cell instance sky130_fd_sc_hd__fill_4_527 r0 *1 0,0
Xsky130_fd_sc_hd__fill_4_527
+ vss
+ vdd
+ vdd
+ sky130_fd_sc_hd__fill_4
* cell instance sky130_fd_sc_hd__fill_4_528 r0 *1 0,0
Xsky130_fd_sc_hd__fill_4_528
+ vss
+ vdd
+ vdd
+ sky130_fd_sc_hd__fill_4
* cell instance sky130_fd_sc_hd__fill_4_529 r0 *1 0,0
Xsky130_fd_sc_hd__fill_4_529
+ vss
+ vdd
+ vdd
+ sky130_fd_sc_hd__fill_4
* cell instance sky130_fd_sc_hd__fill_4_530 r0 *1 0,0
Xsky130_fd_sc_hd__fill_4_530
+ vss
+ vdd
+ vdd
+ sky130_fd_sc_hd__fill_4
* cell instance sky130_fd_sc_hd__fill_4_531 r0 *1 0,0
Xsky130_fd_sc_hd__fill_4_531
+ vss
+ vdd
+ vdd
+ sky130_fd_sc_hd__fill_4
* cell instance sky130_fd_sc_hd__fill_4_532 r0 *1 0,0
Xsky130_fd_sc_hd__fill_4_532
+ vss
+ vdd
+ vdd
+ sky130_fd_sc_hd__fill_4
* cell instance sky130_fd_sc_hd__fill_4_533 r0 *1 0,0
Xsky130_fd_sc_hd__fill_4_533
+ vss
+ vdd
+ vdd
+ sky130_fd_sc_hd__fill_4
* cell instance sky130_fd_sc_hd__fill_4_534 r0 *1 0,0
Xsky130_fd_sc_hd__fill_4_534
+ vss
+ vdd
+ vdd
+ sky130_fd_sc_hd__fill_4
* cell instance sky130_fd_sc_hd__fill_4_535 r0 *1 0,0
Xsky130_fd_sc_hd__fill_4_535
+ vss
+ vdd
+ vdd
+ sky130_fd_sc_hd__fill_4
* cell instance sky130_fd_sc_hd__fill_4_536 r0 *1 0,0
Xsky130_fd_sc_hd__fill_4_536
+ vss
+ vdd
+ vdd
+ sky130_fd_sc_hd__fill_4
* cell instance sky130_fd_sc_hd__fill_4_537 r0 *1 0,0
Xsky130_fd_sc_hd__fill_4_537
+ vss
+ vdd
+ vdd
+ sky130_fd_sc_hd__fill_4
* cell instance sky130_fd_sc_hd__fill_4_538 r0 *1 0,0
Xsky130_fd_sc_hd__fill_4_538
+ vss
+ vdd
+ vdd
+ sky130_fd_sc_hd__fill_4
* cell instance sky130_fd_sc_hd__fill_4_539 r0 *1 0,0
Xsky130_fd_sc_hd__fill_4_539
+ vss
+ vdd
+ vdd
+ sky130_fd_sc_hd__fill_4
* cell instance sky130_fd_sc_hd__fill_4_540 r0 *1 0,0
Xsky130_fd_sc_hd__fill_4_540
+ vss
+ vdd
+ vdd
+ sky130_fd_sc_hd__fill_4
* cell instance sky130_fd_sc_hd__fill_4_541 r0 *1 0,0
Xsky130_fd_sc_hd__fill_4_541
+ vss
+ vdd
+ vdd
+ sky130_fd_sc_hd__fill_4
* cell instance sky130_fd_sc_hd__fill_4_542 r0 *1 0,0
Xsky130_fd_sc_hd__fill_4_542
+ vss
+ vdd
+ vdd
+ sky130_fd_sc_hd__fill_4
* cell instance sky130_fd_sc_hd__fill_4_543 r0 *1 0,0
Xsky130_fd_sc_hd__fill_4_543
+ vss
+ vdd
+ vdd
+ sky130_fd_sc_hd__fill_4
* cell instance sky130_fd_sc_hd__fill_4_544 r0 *1 0,0
Xsky130_fd_sc_hd__fill_4_544
+ vss
+ vdd
+ vdd
+ sky130_fd_sc_hd__fill_4
* cell instance sky130_fd_sc_hd__fill_4_545 r0 *1 0,0
Xsky130_fd_sc_hd__fill_4_545
+ vss
+ vdd
+ vdd
+ sky130_fd_sc_hd__fill_4
* cell instance sky130_fd_sc_hd__fill_4_546 r0 *1 0,0
Xsky130_fd_sc_hd__fill_4_546
+ vss
+ vdd
+ vdd
+ sky130_fd_sc_hd__fill_4
* cell instance sky130_fd_sc_hd__fill_4_547 r0 *1 0,0
Xsky130_fd_sc_hd__fill_4_547
+ vss
+ vdd
+ vdd
+ sky130_fd_sc_hd__fill_4
* cell instance sky130_fd_sc_hd__fill_4_548 r0 *1 0,0
Xsky130_fd_sc_hd__fill_4_548
+ vss
+ vdd
+ vdd
+ sky130_fd_sc_hd__fill_4
* cell instance sky130_fd_sc_hd__fill_4_549 r0 *1 0,0
Xsky130_fd_sc_hd__fill_4_549
+ vss
+ vdd
+ vdd
+ sky130_fd_sc_hd__fill_4
* cell instance sky130_fd_sc_hd__fill_4_550 r0 *1 0,0
Xsky130_fd_sc_hd__fill_4_550
+ vss
+ vdd
+ vdd
+ sky130_fd_sc_hd__fill_4
* cell instance sky130_fd_sc_hd__fill_4_551 r0 *1 0,0
Xsky130_fd_sc_hd__fill_4_551
+ vss
+ vdd
+ vdd
+ sky130_fd_sc_hd__fill_4
* cell instance sky130_fd_sc_hd__fill_4_552 r0 *1 0,0
Xsky130_fd_sc_hd__fill_4_552
+ vss
+ vdd
+ vdd
+ sky130_fd_sc_hd__fill_4
* cell instance sky130_fd_sc_hd__fill_4_553 r0 *1 0,0
Xsky130_fd_sc_hd__fill_4_553
+ vss
+ vdd
+ vdd
+ sky130_fd_sc_hd__fill_4
* cell instance sky130_fd_sc_hd__fill_4_554 r0 *1 0,0
Xsky130_fd_sc_hd__fill_4_554
+ vss
+ vdd
+ vdd
+ sky130_fd_sc_hd__fill_4
* cell instance sky130_fd_sc_hd__fill_4_555 r0 *1 0,0
Xsky130_fd_sc_hd__fill_4_555
+ vss
+ vdd
+ vdd
+ sky130_fd_sc_hd__fill_4
* cell instance sky130_fd_sc_hd__fill_4_556 r0 *1 0,0
Xsky130_fd_sc_hd__fill_4_556
+ vss
+ vdd
+ vdd
+ sky130_fd_sc_hd__fill_4
* cell instance sky130_fd_sc_hd__fill_4_557 r0 *1 0,0
Xsky130_fd_sc_hd__fill_4_557
+ vss
+ vdd
+ vdd
+ sky130_fd_sc_hd__fill_4
* cell instance sky130_fd_sc_hd__fill_4_558 r0 *1 0,0
Xsky130_fd_sc_hd__fill_4_558
+ vss
+ vdd
+ vdd
+ sky130_fd_sc_hd__fill_4
* cell instance sky130_fd_sc_hd__fill_4_559 r0 *1 0,0
Xsky130_fd_sc_hd__fill_4_559
+ vss
+ vdd
+ vdd
+ sky130_fd_sc_hd__fill_4
* cell instance sky130_fd_sc_hd__fill_4_560 r0 *1 0,0
Xsky130_fd_sc_hd__fill_4_560
+ vss
+ vdd
+ vdd
+ sky130_fd_sc_hd__fill_4
* cell instance sky130_fd_sc_hd__fill_4_561 r0 *1 0,0
Xsky130_fd_sc_hd__fill_4_561
+ vss
+ vdd
+ vdd
+ sky130_fd_sc_hd__fill_4
* cell instance sky130_fd_sc_hd__fill_4_562 r0 *1 0,0
Xsky130_fd_sc_hd__fill_4_562
+ vss
+ vdd
+ vdd
+ sky130_fd_sc_hd__fill_4
* cell instance sky130_fd_sc_hd__fill_4_563 r0 *1 0,0
Xsky130_fd_sc_hd__fill_4_563
+ vss
+ vdd
+ vdd
+ sky130_fd_sc_hd__fill_4
* cell instance sky130_fd_sc_hd__fill_4_564 r0 *1 0,0
Xsky130_fd_sc_hd__fill_4_564
+ vss
+ vdd
+ vdd
+ sky130_fd_sc_hd__fill_4
* cell instance sky130_fd_sc_hd__fill_4_565 r0 *1 0,0
Xsky130_fd_sc_hd__fill_4_565
+ vss
+ vdd
+ vdd
+ sky130_fd_sc_hd__fill_4
* cell instance sky130_fd_sc_hd__fill_4_566 r0 *1 0,0
Xsky130_fd_sc_hd__fill_4_566
+ vss
+ vdd
+ vdd
+ sky130_fd_sc_hd__fill_4
* cell instance sky130_fd_sc_hd__fill_4_567 r0 *1 0,0
Xsky130_fd_sc_hd__fill_4_567
+ vss
+ vdd
+ vdd
+ sky130_fd_sc_hd__fill_4
* cell instance sky130_fd_sc_hd__fill_4_568 r0 *1 0,0
Xsky130_fd_sc_hd__fill_4_568
+ vss
+ vdd
+ vdd
+ sky130_fd_sc_hd__fill_4
* cell instance sky130_fd_sc_hd__fill_4_569 r0 *1 0,0
Xsky130_fd_sc_hd__fill_4_569
+ vss
+ vdd
+ vdd
+ sky130_fd_sc_hd__fill_4
* cell instance sky130_fd_sc_hd__fill_4_570 r0 *1 0,0
Xsky130_fd_sc_hd__fill_4_570
+ vss
+ vdd
+ vdd
+ sky130_fd_sc_hd__fill_4
* cell instance sky130_fd_sc_hd__fill_4_571 r0 *1 0,0
Xsky130_fd_sc_hd__fill_4_571
+ vss
+ vdd
+ vdd
+ sky130_fd_sc_hd__fill_4
* cell instance sky130_fd_sc_hd__fill_4_572 r0 *1 0,0
Xsky130_fd_sc_hd__fill_4_572
+ vss
+ vdd
+ vdd
+ sky130_fd_sc_hd__fill_4
* cell instance sky130_fd_sc_hd__fill_4_573 r0 *1 0,0
Xsky130_fd_sc_hd__fill_4_573
+ vss
+ vdd
+ vdd
+ sky130_fd_sc_hd__fill_4
* cell instance sky130_fd_sc_hd__fill_4_574 r0 *1 0,0
Xsky130_fd_sc_hd__fill_4_574
+ vss
+ vdd
+ vdd
+ sky130_fd_sc_hd__fill_4
* cell instance sky130_fd_sc_hd__fill_4_575 r0 *1 0,0
Xsky130_fd_sc_hd__fill_4_575
+ vss
+ vdd
+ vdd
+ sky130_fd_sc_hd__fill_4
* cell instance sky130_fd_sc_hd__fill_4_576 r0 *1 0,0
Xsky130_fd_sc_hd__fill_4_576
+ vss
+ vdd
+ vdd
+ sky130_fd_sc_hd__fill_4
* cell instance sky130_fd_sc_hd__fill_4_577 r0 *1 0,0
Xsky130_fd_sc_hd__fill_4_577
+ vss
+ vdd
+ vdd
+ sky130_fd_sc_hd__fill_4
* cell instance sky130_fd_sc_hd__fill_4_578 r0 *1 0,0
Xsky130_fd_sc_hd__fill_4_578
+ vss
+ vdd
+ vdd
+ sky130_fd_sc_hd__fill_4
* cell instance sky130_fd_sc_hd__fill_4_579 r0 *1 0,0
Xsky130_fd_sc_hd__fill_4_579
+ vss
+ vdd
+ vdd
+ sky130_fd_sc_hd__fill_4
* cell instance sky130_fd_sc_hd__fill_4_580 r0 *1 0,0
Xsky130_fd_sc_hd__fill_4_580
+ vss
+ vdd
+ vdd
+ sky130_fd_sc_hd__fill_4
* cell instance sky130_fd_sc_hd__fill_4_581 r0 *1 0,0
Xsky130_fd_sc_hd__fill_4_581
+ vss
+ vdd
+ vdd
+ sky130_fd_sc_hd__fill_4
* cell instance sky130_fd_sc_hd__fill_4_582 r0 *1 0,0
Xsky130_fd_sc_hd__fill_4_582
+ vss
+ vdd
+ vdd
+ sky130_fd_sc_hd__fill_4
* cell instance sky130_fd_sc_hd__fill_4_583 r0 *1 0,0
Xsky130_fd_sc_hd__fill_4_583
+ vss
+ vdd
+ vdd
+ sky130_fd_sc_hd__fill_4
* cell instance sky130_fd_sc_hd__fill_4_584 r0 *1 0,0
Xsky130_fd_sc_hd__fill_4_584
+ vss
+ vdd
+ vdd
+ sky130_fd_sc_hd__fill_4
* cell instance sky130_fd_sc_hd__fill_4_585 r0 *1 0,0
Xsky130_fd_sc_hd__fill_4_585
+ vss
+ vdd
+ vdd
+ sky130_fd_sc_hd__fill_4
* cell instance sky130_fd_sc_hd__fill_4_586 r0 *1 0,0
Xsky130_fd_sc_hd__fill_4_586
+ vss
+ vdd
+ vdd
+ sky130_fd_sc_hd__fill_4
* cell instance sky130_fd_sc_hd__fill_4_587 r0 *1 0,0
Xsky130_fd_sc_hd__fill_4_587
+ vss
+ vdd
+ vdd
+ sky130_fd_sc_hd__fill_4
* cell instance sky130_fd_sc_hd__fill_4_588 r0 *1 0,0
Xsky130_fd_sc_hd__fill_4_588
+ vss
+ vdd
+ vdd
+ sky130_fd_sc_hd__fill_4
* cell instance sky130_fd_sc_hd__fill_4_589 r0 *1 0,0
Xsky130_fd_sc_hd__fill_4_589
+ vss
+ vdd
+ vdd
+ sky130_fd_sc_hd__fill_4
* cell instance sky130_fd_sc_hd__fill_4_590 r0 *1 0,0
Xsky130_fd_sc_hd__fill_4_590
+ vss
+ vdd
+ vdd
+ sky130_fd_sc_hd__fill_4
* cell instance sky130_fd_sc_hd__fill_4_591 r0 *1 0,0
Xsky130_fd_sc_hd__fill_4_591
+ vss
+ vdd
+ vdd
+ sky130_fd_sc_hd__fill_4
* cell instance sky130_fd_sc_hd__fill_4_592 r0 *1 0,0
Xsky130_fd_sc_hd__fill_4_592
+ vss
+ vdd
+ vdd
+ sky130_fd_sc_hd__fill_4
* cell instance sky130_fd_sc_hd__fill_4_593 r0 *1 0,0
Xsky130_fd_sc_hd__fill_4_593
+ vss
+ vdd
+ vdd
+ sky130_fd_sc_hd__fill_4
* cell instance sky130_fd_sc_hd__fill_4_594 r0 *1 0,0
Xsky130_fd_sc_hd__fill_4_594
+ vss
+ vdd
+ vdd
+ sky130_fd_sc_hd__fill_4
* cell instance sky130_fd_sc_hd__fill_4_595 r0 *1 0,0
Xsky130_fd_sc_hd__fill_4_595
+ vss
+ vdd
+ vdd
+ sky130_fd_sc_hd__fill_4
* cell instance sky130_fd_sc_hd__fill_4_596 r0 *1 0,0
Xsky130_fd_sc_hd__fill_4_596
+ vss
+ vdd
+ vdd
+ sky130_fd_sc_hd__fill_4
* cell instance sky130_fd_sc_hd__fill_4_597 r0 *1 0,0
Xsky130_fd_sc_hd__fill_4_597
+ vss
+ vdd
+ vdd
+ sky130_fd_sc_hd__fill_4
* cell instance sky130_fd_sc_hd__fill_4_598 r0 *1 0,0
Xsky130_fd_sc_hd__fill_4_598
+ vss
+ vdd
+ vdd
+ sky130_fd_sc_hd__fill_4
* cell instance sky130_fd_sc_hd__fill_4_599 r0 *1 0,0
Xsky130_fd_sc_hd__fill_4_599
+ vss
+ vdd
+ vdd
+ sky130_fd_sc_hd__fill_4
* cell instance sky130_fd_sc_hd__fill_4_600 r0 *1 0,0
Xsky130_fd_sc_hd__fill_4_600
+ vss
+ vdd
+ vdd
+ sky130_fd_sc_hd__fill_4
* cell instance sky130_fd_sc_hd__fill_4_601 r0 *1 0,0
Xsky130_fd_sc_hd__fill_4_601
+ vss
+ vdd
+ vdd
+ sky130_fd_sc_hd__fill_4
* cell instance sky130_fd_sc_hd__fill_4_602 r0 *1 0,0
Xsky130_fd_sc_hd__fill_4_602
+ vss
+ vdd
+ vdd
+ sky130_fd_sc_hd__fill_4
* cell instance sky130_fd_sc_hd__fill_4_603 r0 *1 0,0
Xsky130_fd_sc_hd__fill_4_603
+ vss
+ vdd
+ vdd
+ sky130_fd_sc_hd__fill_4
* cell instance sky130_fd_sc_hd__fill_4_604 r0 *1 0,0
Xsky130_fd_sc_hd__fill_4_604
+ vss
+ vdd
+ vdd
+ sky130_fd_sc_hd__fill_4
* cell instance sky130_fd_sc_hd__fill_4_605 r0 *1 0,0
Xsky130_fd_sc_hd__fill_4_605
+ vss
+ vdd
+ vdd
+ sky130_fd_sc_hd__fill_4
* cell instance sky130_fd_sc_hd__fill_4_606 r0 *1 0,0
Xsky130_fd_sc_hd__fill_4_606
+ vss
+ vdd
+ vdd
+ sky130_fd_sc_hd__fill_4
* cell instance sky130_fd_sc_hd__fill_4_607 r0 *1 0,0
Xsky130_fd_sc_hd__fill_4_607
+ vss
+ vdd
+ vdd
+ sky130_fd_sc_hd__fill_4
* cell instance sky130_fd_sc_hd__fill_4_608 r0 *1 0,0
Xsky130_fd_sc_hd__fill_4_608
+ vss
+ vdd
+ vdd
+ sky130_fd_sc_hd__fill_4
* cell instance sky130_fd_sc_hd__fill_4_609 r0 *1 0,0
Xsky130_fd_sc_hd__fill_4_609
+ vss
+ vdd
+ vdd
+ sky130_fd_sc_hd__fill_4
* cell instance sky130_fd_sc_hd__fill_4_610 r0 *1 0,0
Xsky130_fd_sc_hd__fill_4_610
+ vss
+ vdd
+ vdd
+ sky130_fd_sc_hd__fill_4
* cell instance sky130_fd_sc_hd__fill_4_611 r0 *1 0,0
Xsky130_fd_sc_hd__fill_4_611
+ vss
+ vdd
+ vdd
+ sky130_fd_sc_hd__fill_4
* cell instance sky130_fd_sc_hd__fill_4_612 r0 *1 0,0
Xsky130_fd_sc_hd__fill_4_612
+ vss
+ vdd
+ vdd
+ sky130_fd_sc_hd__fill_4
* cell instance sky130_fd_sc_hd__fill_4_613 r0 *1 0,0
Xsky130_fd_sc_hd__fill_4_613
+ vss
+ vdd
+ vdd
+ sky130_fd_sc_hd__fill_4
* cell instance sky130_fd_sc_hd__fill_4_614 r0 *1 0,0
Xsky130_fd_sc_hd__fill_4_614
+ vss
+ vdd
+ vdd
+ sky130_fd_sc_hd__fill_4
* cell instance sky130_fd_sc_hd__fill_4_615 r0 *1 0,0
Xsky130_fd_sc_hd__fill_4_615
+ vss
+ vdd
+ vdd
+ sky130_fd_sc_hd__fill_4
* cell instance sky130_fd_sc_hd__fill_4_616 r0 *1 0,0
Xsky130_fd_sc_hd__fill_4_616
+ vss
+ vdd
+ vdd
+ sky130_fd_sc_hd__fill_4
* cell instance sky130_fd_sc_hd__fill_4_617 r0 *1 0,0
Xsky130_fd_sc_hd__fill_4_617
+ vss
+ vdd
+ vdd
+ sky130_fd_sc_hd__fill_4
* cell instance sky130_fd_sc_hd__fill_4_618 r0 *1 0,0
Xsky130_fd_sc_hd__fill_4_618
+ vss
+ vdd
+ vdd
+ sky130_fd_sc_hd__fill_4
* cell instance sky130_fd_sc_hd__fill_4_619 r0 *1 0,0
Xsky130_fd_sc_hd__fill_4_619
+ vss
+ vdd
+ vdd
+ sky130_fd_sc_hd__fill_4
* cell instance sky130_fd_sc_hd__fill_4_620 r0 *1 0,0
Xsky130_fd_sc_hd__fill_4_620
+ vss
+ vdd
+ vdd
+ sky130_fd_sc_hd__fill_4
* cell instance sky130_fd_sc_hd__fill_4_621 r0 *1 0,0
Xsky130_fd_sc_hd__fill_4_621
+ vss
+ vdd
+ vdd
+ sky130_fd_sc_hd__fill_4
* cell instance sky130_fd_sc_hd__fill_4_622 r0 *1 0,0
Xsky130_fd_sc_hd__fill_4_622
+ vss
+ vdd
+ vdd
+ sky130_fd_sc_hd__fill_4
* cell instance sky130_fd_sc_hd__fill_4_623 r0 *1 0,0
Xsky130_fd_sc_hd__fill_4_623
+ vss
+ vdd
+ vdd
+ sky130_fd_sc_hd__fill_4
* cell instance sky130_fd_sc_hd__fill_4_624 r0 *1 0,0
Xsky130_fd_sc_hd__fill_4_624
+ vss
+ vdd
+ vdd
+ sky130_fd_sc_hd__fill_4
* cell instance sky130_fd_sc_hd__fill_4_625 r0 *1 0,0
Xsky130_fd_sc_hd__fill_4_625
+ vss
+ vdd
+ vdd
+ sky130_fd_sc_hd__fill_4
* cell instance sky130_fd_sc_hd__fill_4_626 r0 *1 0,0
Xsky130_fd_sc_hd__fill_4_626
+ vss
+ vdd
+ vdd
+ sky130_fd_sc_hd__fill_4
* cell instance sky130_fd_sc_hd__fill_4_627 r0 *1 0,0
Xsky130_fd_sc_hd__fill_4_627
+ vss
+ vdd
+ vdd
+ sky130_fd_sc_hd__fill_4
* cell instance sky130_fd_sc_hd__fill_4_628 r0 *1 0,0
Xsky130_fd_sc_hd__fill_4_628
+ vss
+ vdd
+ vdd
+ sky130_fd_sc_hd__fill_4
* cell instance sky130_fd_sc_hd__fill_4_629 r0 *1 0,0
Xsky130_fd_sc_hd__fill_4_629
+ vss
+ vdd
+ vdd
+ sky130_fd_sc_hd__fill_4
* cell instance sky130_fd_sc_hd__fill_4_630 r0 *1 0,0
Xsky130_fd_sc_hd__fill_4_630
+ vss
+ vdd
+ vdd
+ sky130_fd_sc_hd__fill_4
* cell instance sky130_fd_sc_hd__fill_4_631 r0 *1 0,0
Xsky130_fd_sc_hd__fill_4_631
+ vss
+ vdd
+ vdd
+ sky130_fd_sc_hd__fill_4
* cell instance sky130_fd_sc_hd__fill_4_632 r0 *1 0,0
Xsky130_fd_sc_hd__fill_4_632
+ vss
+ vdd
+ vdd
+ sky130_fd_sc_hd__fill_4
* cell instance sky130_fd_sc_hd__fill_4_633 r0 *1 0,0
Xsky130_fd_sc_hd__fill_4_633
+ vss
+ vdd
+ vdd
+ sky130_fd_sc_hd__fill_4
* cell instance sky130_fd_sc_hd__fill_4_634 r0 *1 0,0
Xsky130_fd_sc_hd__fill_4_634
+ vss
+ vdd
+ vdd
+ sky130_fd_sc_hd__fill_4
* cell instance sky130_fd_sc_hd__fill_4_635 r0 *1 0,0
Xsky130_fd_sc_hd__fill_4_635
+ vss
+ vdd
+ vdd
+ sky130_fd_sc_hd__fill_4
* cell instance sky130_fd_sc_hd__fill_4_636 r0 *1 0,0
Xsky130_fd_sc_hd__fill_4_636
+ vss
+ vdd
+ vdd
+ sky130_fd_sc_hd__fill_4
* cell instance sky130_fd_sc_hd__fill_4_637 r0 *1 0,0
Xsky130_fd_sc_hd__fill_4_637
+ vss
+ vdd
+ vdd
+ sky130_fd_sc_hd__fill_4
* cell instance sky130_fd_sc_hd__fill_4_638 r0 *1 0,0
Xsky130_fd_sc_hd__fill_4_638
+ vss
+ vdd
+ vdd
+ sky130_fd_sc_hd__fill_4
* cell instance sky130_fd_sc_hd__fill_4_639 r0 *1 0,0
Xsky130_fd_sc_hd__fill_4_639
+ vss
+ vdd
+ vdd
+ sky130_fd_sc_hd__fill_4
* cell instance sky130_fd_sc_hd__fill_4_640 r0 *1 0,0
Xsky130_fd_sc_hd__fill_4_640
+ vss
+ vdd
+ vdd
+ sky130_fd_sc_hd__fill_4
* cell instance sky130_fd_sc_hd__fill_4_641 r0 *1 0,0
Xsky130_fd_sc_hd__fill_4_641
+ vss
+ vdd
+ vdd
+ sky130_fd_sc_hd__fill_4
* cell instance sky130_fd_sc_hd__fill_4_642 r0 *1 0,0
Xsky130_fd_sc_hd__fill_4_642
+ vss
+ vdd
+ vdd
+ sky130_fd_sc_hd__fill_4
* cell instance sky130_fd_sc_hd__fill_4_643 r0 *1 0,0
Xsky130_fd_sc_hd__fill_4_643
+ vss
+ vdd
+ vdd
+ sky130_fd_sc_hd__fill_4
* cell instance sky130_fd_sc_hd__fill_4_644 r0 *1 0,0
Xsky130_fd_sc_hd__fill_4_644
+ vss
+ vdd
+ vdd
+ sky130_fd_sc_hd__fill_4
* cell instance sky130_fd_sc_hd__fill_4_645 r0 *1 0,0
Xsky130_fd_sc_hd__fill_4_645
+ vss
+ vdd
+ vdd
+ sky130_fd_sc_hd__fill_4
* cell instance sky130_fd_sc_hd__fill_4_646 r0 *1 0,0
Xsky130_fd_sc_hd__fill_4_646
+ vss
+ vdd
+ vdd
+ sky130_fd_sc_hd__fill_4
* cell instance sky130_fd_sc_hd__fill_4_647 r0 *1 0,0
Xsky130_fd_sc_hd__fill_4_647
+ vss
+ vdd
+ vdd
+ sky130_fd_sc_hd__fill_4
* cell instance sky130_fd_sc_hd__fill_4_648 r0 *1 0,0
Xsky130_fd_sc_hd__fill_4_648
+ vss
+ vdd
+ vdd
+ sky130_fd_sc_hd__fill_4
* cell instance sky130_fd_sc_hd__fill_4_649 r0 *1 0,0
Xsky130_fd_sc_hd__fill_4_649
+ vss
+ vdd
+ vdd
+ sky130_fd_sc_hd__fill_4
* cell instance sky130_fd_sc_hd__fill_4_650 r0 *1 0,0
Xsky130_fd_sc_hd__fill_4_650
+ vss
+ vdd
+ vdd
+ sky130_fd_sc_hd__fill_4
* cell instance sky130_fd_sc_hd__fill_4_651 r0 *1 0,0
Xsky130_fd_sc_hd__fill_4_651
+ vss
+ vdd
+ vdd
+ sky130_fd_sc_hd__fill_4
* cell instance sky130_fd_sc_hd__fill_4_652 r0 *1 0,0
Xsky130_fd_sc_hd__fill_4_652
+ vss
+ vdd
+ vdd
+ sky130_fd_sc_hd__fill_4
* cell instance sky130_fd_sc_hd__fill_4_653 r0 *1 0,0
Xsky130_fd_sc_hd__fill_4_653
+ vss
+ vdd
+ vdd
+ sky130_fd_sc_hd__fill_4
* cell instance sky130_fd_sc_hd__fill_4_654 r0 *1 0,0
Xsky130_fd_sc_hd__fill_4_654
+ vss
+ vdd
+ vdd
+ sky130_fd_sc_hd__fill_4
* cell instance sky130_fd_sc_hd__fill_4_655 r0 *1 0,0
Xsky130_fd_sc_hd__fill_4_655
+ vss
+ vdd
+ vdd
+ sky130_fd_sc_hd__fill_4
* cell instance sky130_fd_sc_hd__fill_4_656 r0 *1 0,0
Xsky130_fd_sc_hd__fill_4_656
+ vss
+ vdd
+ vdd
+ sky130_fd_sc_hd__fill_4
* cell instance sky130_fd_sc_hd__fill_4_657 r0 *1 0,0
Xsky130_fd_sc_hd__fill_4_657
+ vss
+ vdd
+ vdd
+ sky130_fd_sc_hd__fill_4
* cell instance sky130_fd_sc_hd__fill_4_658 r0 *1 0,0
Xsky130_fd_sc_hd__fill_4_658
+ vss
+ vdd
+ vdd
+ sky130_fd_sc_hd__fill_4
* cell instance sky130_fd_sc_hd__fill_4_659 r0 *1 0,0
Xsky130_fd_sc_hd__fill_4_659
+ vss
+ vdd
+ vdd
+ sky130_fd_sc_hd__fill_4
* cell instance sky130_fd_sc_hd__fill_4_660 r0 *1 0,0
Xsky130_fd_sc_hd__fill_4_660
+ vss
+ vdd
+ vdd
+ sky130_fd_sc_hd__fill_4
* cell instance sky130_fd_sc_hd__fill_4_661 r0 *1 0,0
Xsky130_fd_sc_hd__fill_4_661
+ vss
+ vdd
+ vdd
+ sky130_fd_sc_hd__fill_4
* cell instance sky130_fd_sc_hd__fill_4_662 r0 *1 0,0
Xsky130_fd_sc_hd__fill_4_662
+ vss
+ vdd
+ vdd
+ sky130_fd_sc_hd__fill_4
* cell instance sky130_fd_sc_hd__fill_4_663 r0 *1 0,0
Xsky130_fd_sc_hd__fill_4_663
+ vss
+ vdd
+ vdd
+ sky130_fd_sc_hd__fill_4
* cell instance sky130_fd_sc_hd__fill_4_664 r0 *1 0,0
Xsky130_fd_sc_hd__fill_4_664
+ vss
+ vdd
+ vdd
+ sky130_fd_sc_hd__fill_4
* cell instance sky130_fd_sc_hd__fill_4_665 r0 *1 0,0
Xsky130_fd_sc_hd__fill_4_665
+ vss
+ vdd
+ vdd
+ sky130_fd_sc_hd__fill_4
* cell instance sky130_fd_sc_hd__fill_4_666 r0 *1 0,0
Xsky130_fd_sc_hd__fill_4_666
+ vss
+ vdd
+ vdd
+ sky130_fd_sc_hd__fill_4
* cell instance sky130_fd_sc_hd__fill_4_667 r0 *1 0,0
Xsky130_fd_sc_hd__fill_4_667
+ vss
+ vdd
+ vdd
+ sky130_fd_sc_hd__fill_4
* cell instance sky130_fd_sc_hd__fill_4_668 r0 *1 0,0
Xsky130_fd_sc_hd__fill_4_668
+ vss
+ vdd
+ vdd
+ sky130_fd_sc_hd__fill_4
* cell instance sky130_fd_sc_hd__fill_4_669 r0 *1 0,0
Xsky130_fd_sc_hd__fill_4_669
+ vss
+ vdd
+ vdd
+ sky130_fd_sc_hd__fill_4
* cell instance sky130_fd_sc_hd__fill_4_670 r0 *1 0,0
Xsky130_fd_sc_hd__fill_4_670
+ vss
+ vdd
+ vdd
+ sky130_fd_sc_hd__fill_4
* cell instance sky130_fd_sc_hd__fill_4_671 r0 *1 0,0
Xsky130_fd_sc_hd__fill_4_671
+ vss
+ vdd
+ vdd
+ sky130_fd_sc_hd__fill_4
* cell instance sky130_fd_sc_hd__fill_4_672 r0 *1 0,0
Xsky130_fd_sc_hd__fill_4_672
+ vss
+ vdd
+ vdd
+ sky130_fd_sc_hd__fill_4
* cell instance sky130_fd_sc_hd__fill_4_673 r0 *1 0,0
Xsky130_fd_sc_hd__fill_4_673
+ vss
+ vdd
+ vdd
+ sky130_fd_sc_hd__fill_4
* cell instance sky130_fd_sc_hd__fill_4_674 r0 *1 0,0
Xsky130_fd_sc_hd__fill_4_674
+ vss
+ vdd
+ vdd
+ sky130_fd_sc_hd__fill_4
* cell instance sky130_fd_sc_hd__fill_4_675 r0 *1 0,0
Xsky130_fd_sc_hd__fill_4_675
+ vss
+ vdd
+ vdd
+ sky130_fd_sc_hd__fill_4
* cell instance sky130_fd_sc_hd__fill_4_676 r0 *1 0,0
Xsky130_fd_sc_hd__fill_4_676
+ vss
+ vdd
+ vdd
+ sky130_fd_sc_hd__fill_4
* cell instance sky130_fd_sc_hd__fill_4_677 r0 *1 0,0
Xsky130_fd_sc_hd__fill_4_677
+ vss
+ vdd
+ vdd
+ sky130_fd_sc_hd__fill_4
* cell instance sky130_fd_sc_hd__fill_4_678 r0 *1 0,0
Xsky130_fd_sc_hd__fill_4_678
+ vss
+ vdd
+ vdd
+ sky130_fd_sc_hd__fill_4
* cell instance sky130_fd_sc_hd__fill_4_679 r0 *1 0,0
Xsky130_fd_sc_hd__fill_4_679
+ vss
+ vdd
+ vdd
+ sky130_fd_sc_hd__fill_4
* cell instance sky130_fd_sc_hd__fill_4_680 r0 *1 0,0
Xsky130_fd_sc_hd__fill_4_680
+ vss
+ vdd
+ vdd
+ sky130_fd_sc_hd__fill_4
* cell instance sky130_fd_sc_hd__fill_4_681 r0 *1 0,0
Xsky130_fd_sc_hd__fill_4_681
+ vss
+ vdd
+ vdd
+ sky130_fd_sc_hd__fill_4
* cell instance sky130_fd_sc_hd__fill_4_682 r0 *1 0,0
Xsky130_fd_sc_hd__fill_4_682
+ vss
+ vdd
+ vdd
+ sky130_fd_sc_hd__fill_4
* cell instance sky130_fd_sc_hd__fill_4_683 r0 *1 0,0
Xsky130_fd_sc_hd__fill_4_683
+ vss
+ vdd
+ vdd
+ sky130_fd_sc_hd__fill_4
* cell instance sky130_fd_sc_hd__fill_4_684 r0 *1 0,0
Xsky130_fd_sc_hd__fill_4_684
+ vss
+ vdd
+ vdd
+ sky130_fd_sc_hd__fill_4
* cell instance sky130_fd_sc_hd__fill_4_685 r0 *1 0,0
Xsky130_fd_sc_hd__fill_4_685
+ vss
+ vdd
+ vdd
+ sky130_fd_sc_hd__fill_4
* cell instance sky130_fd_sc_hd__fill_4_686 r0 *1 0,0
Xsky130_fd_sc_hd__fill_4_686
+ vss
+ vdd
+ vdd
+ sky130_fd_sc_hd__fill_4
* cell instance sky130_fd_sc_hd__fill_4_687 r0 *1 0,0
Xsky130_fd_sc_hd__fill_4_687
+ vss
+ vdd
+ vdd
+ sky130_fd_sc_hd__fill_4
* cell instance sky130_fd_sc_hd__fill_4_688 r0 *1 0,0
Xsky130_fd_sc_hd__fill_4_688
+ vss
+ vdd
+ vdd
+ sky130_fd_sc_hd__fill_4
* cell instance sky130_fd_sc_hd__fill_4_689 r0 *1 0,0
Xsky130_fd_sc_hd__fill_4_689
+ vss
+ vdd
+ vdd
+ sky130_fd_sc_hd__fill_4
* cell instance sky130_fd_sc_hd__fill_4_690 r0 *1 0,0
Xsky130_fd_sc_hd__fill_4_690
+ vss
+ vdd
+ vdd
+ sky130_fd_sc_hd__fill_4
* cell instance sky130_fd_sc_hd__fill_4_691 r0 *1 0,0
Xsky130_fd_sc_hd__fill_4_691
+ vss
+ vdd
+ vdd
+ sky130_fd_sc_hd__fill_4
* cell instance sky130_fd_sc_hd__fill_4_692 r0 *1 0,0
Xsky130_fd_sc_hd__fill_4_692
+ vss
+ vdd
+ vdd
+ sky130_fd_sc_hd__fill_4
* cell instance sky130_fd_sc_hd__fill_4_693 r0 *1 0,0
Xsky130_fd_sc_hd__fill_4_693
+ vss
+ vdd
+ vdd
+ sky130_fd_sc_hd__fill_4
* cell instance sky130_fd_sc_hd__fill_4_694 r0 *1 0,0
Xsky130_fd_sc_hd__fill_4_694
+ vss
+ vdd
+ vdd
+ sky130_fd_sc_hd__fill_4
* cell instance sky130_fd_sc_hd__fill_4_695 r0 *1 0,0
Xsky130_fd_sc_hd__fill_4_695
+ vss
+ vdd
+ vdd
+ sky130_fd_sc_hd__fill_4
* cell instance sky130_fd_sc_hd__fill_4_696 r0 *1 0,0
Xsky130_fd_sc_hd__fill_4_696
+ vss
+ vdd
+ vdd
+ sky130_fd_sc_hd__fill_4
* cell instance sky130_fd_sc_hd__fill_4_697 r0 *1 0,0
Xsky130_fd_sc_hd__fill_4_697
+ vss
+ vdd
+ vdd
+ sky130_fd_sc_hd__fill_4
* cell instance sky130_fd_sc_hd__fill_4_698 r0 *1 0,0
Xsky130_fd_sc_hd__fill_4_698
+ vss
+ vdd
+ vdd
+ sky130_fd_sc_hd__fill_4
* cell instance sky130_fd_sc_hd__fill_4_699 r0 *1 0,0
Xsky130_fd_sc_hd__fill_4_699
+ vss
+ vdd
+ vdd
+ sky130_fd_sc_hd__fill_4
* cell instance sky130_fd_sc_hd__fill_4_700 r0 *1 0,0
Xsky130_fd_sc_hd__fill_4_700
+ vss
+ vdd
+ vdd
+ sky130_fd_sc_hd__fill_4
* cell instance sky130_fd_sc_hd__fill_4_701 r0 *1 0,0
Xsky130_fd_sc_hd__fill_4_701
+ vss
+ vdd
+ vdd
+ sky130_fd_sc_hd__fill_4
* cell instance sky130_fd_sc_hd__fill_4_702 r0 *1 0,0
Xsky130_fd_sc_hd__fill_4_702
+ vss
+ vdd
+ vdd
+ sky130_fd_sc_hd__fill_4
* cell instance sky130_fd_sc_hd__fill_4_703 r0 *1 0,0
Xsky130_fd_sc_hd__fill_4_703
+ vss
+ vdd
+ vdd
+ sky130_fd_sc_hd__fill_4
* cell instance sky130_fd_sc_hd__fill_4_704 r0 *1 0,0
Xsky130_fd_sc_hd__fill_4_704
+ vss
+ vdd
+ vdd
+ sky130_fd_sc_hd__fill_4
* cell instance sky130_fd_sc_hd__fill_4_705 r0 *1 0,0
Xsky130_fd_sc_hd__fill_4_705
+ vss
+ vdd
+ vdd
+ sky130_fd_sc_hd__fill_4
* cell instance sky130_fd_sc_hd__fill_4_706 r0 *1 0,0
Xsky130_fd_sc_hd__fill_4_706
+ vss
+ vdd
+ vdd
+ sky130_fd_sc_hd__fill_4
* cell instance sky130_fd_sc_hd__fill_4_707 r0 *1 0,0
Xsky130_fd_sc_hd__fill_4_707
+ vss
+ vdd
+ vdd
+ sky130_fd_sc_hd__fill_4
* cell instance sky130_fd_sc_hd__fill_4_708 r0 *1 0,0
Xsky130_fd_sc_hd__fill_4_708
+ vss
+ vdd
+ vdd
+ sky130_fd_sc_hd__fill_4
* cell instance sky130_fd_sc_hd__fill_4_709 r0 *1 0,0
Xsky130_fd_sc_hd__fill_4_709
+ vss
+ vdd
+ vdd
+ sky130_fd_sc_hd__fill_4
* cell instance sky130_fd_sc_hd__fill_4_710 r0 *1 0,0
Xsky130_fd_sc_hd__fill_4_710
+ vss
+ vdd
+ vdd
+ sky130_fd_sc_hd__fill_4
* cell instance sky130_fd_sc_hd__fill_4_711 r0 *1 0,0
Xsky130_fd_sc_hd__fill_4_711
+ vss
+ vdd
+ vdd
+ sky130_fd_sc_hd__fill_4
* cell instance sky130_fd_sc_hd__fill_4_712 r0 *1 0,0
Xsky130_fd_sc_hd__fill_4_712
+ vss
+ vdd
+ vdd
+ sky130_fd_sc_hd__fill_4
* cell instance sky130_fd_sc_hd__fill_4_713 r0 *1 0,0
Xsky130_fd_sc_hd__fill_4_713
+ vss
+ vdd
+ vdd
+ sky130_fd_sc_hd__fill_4
* cell instance sky130_fd_sc_hd__fill_4_714 r0 *1 0,0
Xsky130_fd_sc_hd__fill_4_714
+ vss
+ vdd
+ vdd
+ sky130_fd_sc_hd__fill_4
* cell instance sky130_fd_sc_hd__fill_4_715 r0 *1 0,0
Xsky130_fd_sc_hd__fill_4_715
+ vss
+ vdd
+ vdd
+ sky130_fd_sc_hd__fill_4
* cell instance sky130_fd_sc_hd__fill_4_716 r0 *1 0,0
Xsky130_fd_sc_hd__fill_4_716
+ vss
+ vdd
+ vdd
+ sky130_fd_sc_hd__fill_4
* cell instance sky130_fd_sc_hd__fill_4_717 r0 *1 0,0
Xsky130_fd_sc_hd__fill_4_717
+ vss
+ vdd
+ vdd
+ sky130_fd_sc_hd__fill_4
* cell instance sky130_fd_sc_hd__fill_4_718 r0 *1 0,0
Xsky130_fd_sc_hd__fill_4_718
+ vss
+ vdd
+ vdd
+ sky130_fd_sc_hd__fill_4
* cell instance sky130_fd_sc_hd__fill_4_719 r0 *1 0,0
Xsky130_fd_sc_hd__fill_4_719
+ vss
+ vdd
+ vdd
+ sky130_fd_sc_hd__fill_4
* cell instance sky130_fd_sc_hd__fill_4_720 r0 *1 0,0
Xsky130_fd_sc_hd__fill_4_720
+ vss
+ vdd
+ vdd
+ sky130_fd_sc_hd__fill_4
* cell instance sky130_fd_sc_hd__fill_4_721 r0 *1 0,0
Xsky130_fd_sc_hd__fill_4_721
+ vss
+ vdd
+ vdd
+ sky130_fd_sc_hd__fill_4
* cell instance sky130_fd_sc_hd__fill_4_722 r0 *1 0,0
Xsky130_fd_sc_hd__fill_4_722
+ vss
+ vdd
+ vdd
+ sky130_fd_sc_hd__fill_4
* cell instance sky130_fd_sc_hd__fill_4_723 r0 *1 0,0
Xsky130_fd_sc_hd__fill_4_723
+ vss
+ vdd
+ vdd
+ sky130_fd_sc_hd__fill_4
* cell instance sky130_fd_sc_hd__fill_4_724 r0 *1 0,0
Xsky130_fd_sc_hd__fill_4_724
+ vss
+ vdd
+ vdd
+ sky130_fd_sc_hd__fill_4
* cell instance sky130_fd_sc_hd__fill_4_725 r0 *1 0,0
Xsky130_fd_sc_hd__fill_4_725
+ vss
+ vdd
+ vdd
+ sky130_fd_sc_hd__fill_4
* cell instance sky130_fd_sc_hd__fill_4_726 r0 *1 0,0
Xsky130_fd_sc_hd__fill_4_726
+ vss
+ vdd
+ vdd
+ sky130_fd_sc_hd__fill_4
* cell instance sky130_fd_sc_hd__fill_4_727 r0 *1 0,0
Xsky130_fd_sc_hd__fill_4_727
+ vss
+ vdd
+ vdd
+ sky130_fd_sc_hd__fill_4
* cell instance sky130_fd_sc_hd__fill_4_728 r0 *1 0,0
Xsky130_fd_sc_hd__fill_4_728
+ vss
+ vdd
+ vdd
+ sky130_fd_sc_hd__fill_4
* cell instance sky130_fd_sc_hd__fill_4_729 r0 *1 0,0
Xsky130_fd_sc_hd__fill_4_729
+ vss
+ vdd
+ vdd
+ sky130_fd_sc_hd__fill_4
* cell instance sky130_fd_sc_hd__fill_4_730 r0 *1 0,0
Xsky130_fd_sc_hd__fill_4_730
+ vss
+ vdd
+ vdd
+ sky130_fd_sc_hd__fill_4
* cell instance sky130_fd_sc_hd__fill_4_731 r0 *1 0,0
Xsky130_fd_sc_hd__fill_4_731
+ vss
+ vdd
+ vdd
+ sky130_fd_sc_hd__fill_4
* cell instance sky130_fd_sc_hd__fill_4_732 r0 *1 0,0
Xsky130_fd_sc_hd__fill_4_732
+ vss
+ vdd
+ vdd
+ sky130_fd_sc_hd__fill_4
* cell instance sky130_fd_sc_hd__fill_4_733 r0 *1 0,0
Xsky130_fd_sc_hd__fill_4_733
+ vss
+ vdd
+ vdd
+ sky130_fd_sc_hd__fill_4
* cell instance sky130_fd_sc_hd__fill_4_734 r0 *1 0,0
Xsky130_fd_sc_hd__fill_4_734
+ vss
+ vdd
+ vdd
+ sky130_fd_sc_hd__fill_4
* cell instance sky130_fd_sc_hd__fill_4_735 r0 *1 0,0
Xsky130_fd_sc_hd__fill_4_735
+ vss
+ vdd
+ vdd
+ sky130_fd_sc_hd__fill_4
* cell instance sky130_fd_sc_hd__fill_4_736 r0 *1 0,0
Xsky130_fd_sc_hd__fill_4_736
+ vss
+ vdd
+ vdd
+ sky130_fd_sc_hd__fill_4
* cell instance sky130_fd_sc_hd__fill_4_737 r0 *1 0,0
Xsky130_fd_sc_hd__fill_4_737
+ vss
+ vdd
+ vdd
+ sky130_fd_sc_hd__fill_4
* cell instance sky130_fd_sc_hd__fill_4_738 r0 *1 0,0
Xsky130_fd_sc_hd__fill_4_738
+ vss
+ vdd
+ vdd
+ sky130_fd_sc_hd__fill_4
* cell instance sky130_fd_sc_hd__fill_4_739 r0 *1 0,0
Xsky130_fd_sc_hd__fill_4_739
+ vss
+ vdd
+ vdd
+ sky130_fd_sc_hd__fill_4
* cell instance sky130_fd_sc_hd__fill_4_740 r0 *1 0,0
Xsky130_fd_sc_hd__fill_4_740
+ vss
+ vdd
+ vdd
+ sky130_fd_sc_hd__fill_4
* cell instance sky130_fd_sc_hd__fill_4_741 r0 *1 0,0
Xsky130_fd_sc_hd__fill_4_741
+ vss
+ vdd
+ vdd
+ sky130_fd_sc_hd__fill_4
* cell instance sky130_fd_sc_hd__fill_4_742 r0 *1 0,0
Xsky130_fd_sc_hd__fill_4_742
+ vss
+ vdd
+ vdd
+ sky130_fd_sc_hd__fill_4
* cell instance sky130_fd_sc_hd__fill_4_743 r0 *1 0,0
Xsky130_fd_sc_hd__fill_4_743
+ vss
+ vdd
+ vdd
+ sky130_fd_sc_hd__fill_4
* cell instance sky130_fd_sc_hd__fill_4_744 r0 *1 0,0
Xsky130_fd_sc_hd__fill_4_744
+ vss
+ vdd
+ vdd
+ sky130_fd_sc_hd__fill_4
* cell instance sky130_fd_sc_hd__fill_4_745 r0 *1 0,0
Xsky130_fd_sc_hd__fill_4_745
+ vss
+ vdd
+ vdd
+ sky130_fd_sc_hd__fill_4
* cell instance sky130_fd_sc_hd__fill_4_746 r0 *1 0,0
Xsky130_fd_sc_hd__fill_4_746
+ vss
+ vdd
+ vdd
+ sky130_fd_sc_hd__fill_4
* cell instance sky130_fd_sc_hd__fill_4_747 r0 *1 0,0
Xsky130_fd_sc_hd__fill_4_747
+ vss
+ vdd
+ vdd
+ sky130_fd_sc_hd__fill_4
* cell instance sky130_fd_sc_hd__fill_4_748 r0 *1 0,0
Xsky130_fd_sc_hd__fill_4_748
+ vss
+ vdd
+ vdd
+ sky130_fd_sc_hd__fill_4
* cell instance sky130_fd_sc_hd__fill_4_749 r0 *1 0,0
Xsky130_fd_sc_hd__fill_4_749
+ vss
+ vdd
+ vdd
+ sky130_fd_sc_hd__fill_4
* cell instance sky130_fd_sc_hd__fill_4_750 r0 *1 0,0
Xsky130_fd_sc_hd__fill_4_750
+ vss
+ vdd
+ vdd
+ sky130_fd_sc_hd__fill_4
* cell instance sky130_fd_sc_hd__fill_4_751 r0 *1 0,0
Xsky130_fd_sc_hd__fill_4_751
+ vss
+ vdd
+ vdd
+ sky130_fd_sc_hd__fill_4
* cell instance sky130_fd_sc_hd__fill_4_752 r0 *1 0,0
Xsky130_fd_sc_hd__fill_4_752
+ vss
+ vdd
+ vdd
+ sky130_fd_sc_hd__fill_4
* cell instance sky130_fd_sc_hd__fill_4_753 r0 *1 0,0
Xsky130_fd_sc_hd__fill_4_753
+ vss
+ vdd
+ vdd
+ sky130_fd_sc_hd__fill_4
* cell instance sky130_fd_sc_hd__fill_4_754 r0 *1 0,0
Xsky130_fd_sc_hd__fill_4_754
+ vss
+ vdd
+ vdd
+ sky130_fd_sc_hd__fill_4
* cell instance sky130_fd_sc_hd__fill_4_755 r0 *1 0,0
Xsky130_fd_sc_hd__fill_4_755
+ vss
+ vdd
+ vdd
+ sky130_fd_sc_hd__fill_4
* cell instance sky130_fd_sc_hd__fill_4_756 r0 *1 0,0
Xsky130_fd_sc_hd__fill_4_756
+ vss
+ vdd
+ vdd
+ sky130_fd_sc_hd__fill_4
* cell instance sky130_fd_sc_hd__fill_4_757 r0 *1 0,0
Xsky130_fd_sc_hd__fill_4_757
+ vss
+ vdd
+ vdd
+ sky130_fd_sc_hd__fill_4
* cell instance sky130_fd_sc_hd__fill_4_758 r0 *1 0,0
Xsky130_fd_sc_hd__fill_4_758
+ vss
+ vdd
+ vdd
+ sky130_fd_sc_hd__fill_4
* cell instance sky130_fd_sc_hd__fill_4_759 r0 *1 0,0
Xsky130_fd_sc_hd__fill_4_759
+ vss
+ vdd
+ vdd
+ sky130_fd_sc_hd__fill_4
* cell instance sky130_fd_sc_hd__fill_4_760 r0 *1 0,0
Xsky130_fd_sc_hd__fill_4_760
+ vss
+ vdd
+ vdd
+ sky130_fd_sc_hd__fill_4
* cell instance sky130_fd_sc_hd__fill_4_761 r0 *1 0,0
Xsky130_fd_sc_hd__fill_4_761
+ vss
+ vdd
+ vdd
+ sky130_fd_sc_hd__fill_4
* cell instance sky130_fd_sc_hd__fill_4_762 r0 *1 0,0
Xsky130_fd_sc_hd__fill_4_762
+ vss
+ vdd
+ vdd
+ sky130_fd_sc_hd__fill_4
* cell instance sky130_fd_sc_hd__fill_4_763 r0 *1 0,0
Xsky130_fd_sc_hd__fill_4_763
+ vss
+ vdd
+ vdd
+ sky130_fd_sc_hd__fill_4
* cell instance sky130_fd_sc_hd__fill_4_764 r0 *1 0,0
Xsky130_fd_sc_hd__fill_4_764
+ vss
+ vdd
+ vdd
+ sky130_fd_sc_hd__fill_4
* cell instance sky130_fd_sc_hd__fill_4_765 r0 *1 0,0
Xsky130_fd_sc_hd__fill_4_765
+ vss
+ vdd
+ vdd
+ sky130_fd_sc_hd__fill_4
* cell instance sky130_fd_sc_hd__fill_4_766 r0 *1 0,0
Xsky130_fd_sc_hd__fill_4_766
+ vss
+ vdd
+ vdd
+ sky130_fd_sc_hd__fill_4
* cell instance sky130_fd_sc_hd__fill_4_767 r0 *1 0,0
Xsky130_fd_sc_hd__fill_4_767
+ vss
+ vdd
+ vdd
+ sky130_fd_sc_hd__fill_4
* cell instance sky130_fd_sc_hd__fill_4_768 r0 *1 0,0
Xsky130_fd_sc_hd__fill_4_768
+ vss
+ vdd
+ vdd
+ sky130_fd_sc_hd__fill_4
* cell instance sky130_fd_sc_hd__fill_4_769 r0 *1 0,0
Xsky130_fd_sc_hd__fill_4_769
+ vss
+ vdd
+ vdd
+ sky130_fd_sc_hd__fill_4
* cell instance sky130_fd_sc_hd__fill_4_770 r0 *1 0,0
Xsky130_fd_sc_hd__fill_4_770
+ vss
+ vdd
+ vdd
+ sky130_fd_sc_hd__fill_4
* cell instance sky130_fd_sc_hd__fill_4_771 r0 *1 0,0
Xsky130_fd_sc_hd__fill_4_771
+ vss
+ vdd
+ vdd
+ sky130_fd_sc_hd__fill_4
* cell instance sky130_fd_sc_hd__fill_4_772 r0 *1 0,0
Xsky130_fd_sc_hd__fill_4_772
+ vss
+ vdd
+ vdd
+ sky130_fd_sc_hd__fill_4
* cell instance sky130_fd_sc_hd__fill_4_773 r0 *1 0,0
Xsky130_fd_sc_hd__fill_4_773
+ vss
+ vdd
+ vdd
+ sky130_fd_sc_hd__fill_4
* cell instance sky130_fd_sc_hd__fill_4_774 r0 *1 0,0
Xsky130_fd_sc_hd__fill_4_774
+ vss
+ vdd
+ vdd
+ sky130_fd_sc_hd__fill_4
* cell instance sky130_fd_sc_hd__fill_4_775 r0 *1 0,0
Xsky130_fd_sc_hd__fill_4_775
+ vss
+ vdd
+ vdd
+ sky130_fd_sc_hd__fill_4
* cell instance sky130_fd_sc_hd__fill_4_776 r0 *1 0,0
Xsky130_fd_sc_hd__fill_4_776
+ vss
+ vdd
+ vdd
+ sky130_fd_sc_hd__fill_4
* cell instance sky130_fd_sc_hd__fill_4_777 r0 *1 0,0
Xsky130_fd_sc_hd__fill_4_777
+ vss
+ vdd
+ vdd
+ sky130_fd_sc_hd__fill_4
* cell instance sky130_fd_sc_hd__fill_4_778 r0 *1 0,0
Xsky130_fd_sc_hd__fill_4_778
+ vss
+ vdd
+ vdd
+ sky130_fd_sc_hd__fill_4
* cell instance sky130_fd_sc_hd__fill_4_779 r0 *1 0,0
Xsky130_fd_sc_hd__fill_4_779
+ vss
+ vdd
+ vdd
+ sky130_fd_sc_hd__fill_4
* cell instance sky130_fd_sc_hd__fill_4_780 r0 *1 0,0
Xsky130_fd_sc_hd__fill_4_780
+ vss
+ vdd
+ vdd
+ sky130_fd_sc_hd__fill_4
* cell instance sky130_fd_sc_hd__fill_4_781 r0 *1 0,0
Xsky130_fd_sc_hd__fill_4_781
+ vss
+ vdd
+ vdd
+ sky130_fd_sc_hd__fill_4
* cell instance sky130_fd_sc_hd__fill_4_782 r0 *1 0,0
Xsky130_fd_sc_hd__fill_4_782
+ vss
+ vdd
+ vdd
+ sky130_fd_sc_hd__fill_4
* cell instance sky130_fd_sc_hd__fill_4_783 r0 *1 0,0
Xsky130_fd_sc_hd__fill_4_783
+ vss
+ vdd
+ vdd
+ sky130_fd_sc_hd__fill_4
* cell instance sky130_fd_sc_hd__fill_4_784 r0 *1 0,0
Xsky130_fd_sc_hd__fill_4_784
+ vss
+ vdd
+ vdd
+ sky130_fd_sc_hd__fill_4
* cell instance sky130_fd_sc_hd__fill_4_785 r0 *1 0,0
Xsky130_fd_sc_hd__fill_4_785
+ vss
+ vdd
+ vdd
+ sky130_fd_sc_hd__fill_4
* cell instance sky130_fd_sc_hd__fill_4_786 r0 *1 0,0
Xsky130_fd_sc_hd__fill_4_786
+ vss
+ vdd
+ vdd
+ sky130_fd_sc_hd__fill_4
* cell instance sky130_fd_sc_hd__fill_4_787 r0 *1 0,0
Xsky130_fd_sc_hd__fill_4_787
+ vss
+ vdd
+ vdd
+ sky130_fd_sc_hd__fill_4
* cell instance sky130_fd_sc_hd__fill_4_788 r0 *1 0,0
Xsky130_fd_sc_hd__fill_4_788
+ vss
+ vdd
+ vdd
+ sky130_fd_sc_hd__fill_4
* cell instance sky130_fd_sc_hd__fill_4_789 r0 *1 0,0
Xsky130_fd_sc_hd__fill_4_789
+ vss
+ vdd
+ vdd
+ sky130_fd_sc_hd__fill_4
* cell instance sky130_fd_sc_hd__fill_4_790 r0 *1 0,0
Xsky130_fd_sc_hd__fill_4_790
+ vss
+ vdd
+ vdd
+ sky130_fd_sc_hd__fill_4
* cell instance sky130_fd_sc_hd__fill_4_791 r0 *1 0,0
Xsky130_fd_sc_hd__fill_4_791
+ vss
+ vdd
+ vdd
+ sky130_fd_sc_hd__fill_4
* cell instance sky130_fd_sc_hd__fill_4_792 r0 *1 0,0
Xsky130_fd_sc_hd__fill_4_792
+ vss
+ vdd
+ vdd
+ sky130_fd_sc_hd__fill_4
* cell instance sky130_fd_sc_hd__fill_4_793 r0 *1 0,0
Xsky130_fd_sc_hd__fill_4_793
+ vss
+ vdd
+ vdd
+ sky130_fd_sc_hd__fill_4
* cell instance sky130_fd_sc_hd__fill_4_794 r0 *1 0,0
Xsky130_fd_sc_hd__fill_4_794
+ vss
+ vdd
+ vdd
+ sky130_fd_sc_hd__fill_4
* cell instance sky130_fd_sc_hd__fill_4_795 r0 *1 0,0
Xsky130_fd_sc_hd__fill_4_795
+ vss
+ vdd
+ vdd
+ sky130_fd_sc_hd__fill_4
* cell instance sky130_fd_sc_hd__fill_4_796 r0 *1 0,0
Xsky130_fd_sc_hd__fill_4_796
+ vss
+ vdd
+ vdd
+ sky130_fd_sc_hd__fill_4
* cell instance sky130_fd_sc_hd__fill_4_797 r0 *1 0,0
Xsky130_fd_sc_hd__fill_4_797
+ vss
+ vdd
+ vdd
+ sky130_fd_sc_hd__fill_4
* cell instance sky130_fd_sc_hd__fill_4_798 r0 *1 0,0
Xsky130_fd_sc_hd__fill_4_798
+ vss
+ vdd
+ vdd
+ sky130_fd_sc_hd__fill_4
* cell instance sky130_fd_sc_hd__fill_4_799 r0 *1 0,0
Xsky130_fd_sc_hd__fill_4_799
+ vss
+ vdd
+ vdd
+ sky130_fd_sc_hd__fill_4
* cell instance sky130_fd_sc_hd__fill_4_800 r0 *1 0,0
Xsky130_fd_sc_hd__fill_4_800
+ vss
+ vdd
+ vdd
+ sky130_fd_sc_hd__fill_4
* cell instance sky130_fd_sc_hd__fill_4_801 r0 *1 0,0
Xsky130_fd_sc_hd__fill_4_801
+ vss
+ vdd
+ vdd
+ sky130_fd_sc_hd__fill_4
* cell instance sky130_fd_sc_hd__fill_4_802 r0 *1 0,0
Xsky130_fd_sc_hd__fill_4_802
+ vss
+ vdd
+ vdd
+ sky130_fd_sc_hd__fill_4
* cell instance sky130_fd_sc_hd__fill_4_803 r0 *1 0,0
Xsky130_fd_sc_hd__fill_4_803
+ vss
+ vdd
+ vdd
+ sky130_fd_sc_hd__fill_4
* cell instance sky130_fd_sc_hd__fill_4_804 r0 *1 0,0
Xsky130_fd_sc_hd__fill_4_804
+ vss
+ vdd
+ vdd
+ sky130_fd_sc_hd__fill_4
* cell instance sky130_fd_sc_hd__fill_4_805 r0 *1 0,0
Xsky130_fd_sc_hd__fill_4_805
+ vss
+ vdd
+ vdd
+ sky130_fd_sc_hd__fill_4
* cell instance sky130_fd_sc_hd__fill_4_806 r0 *1 0,0
Xsky130_fd_sc_hd__fill_4_806
+ vss
+ vdd
+ vdd
+ sky130_fd_sc_hd__fill_4
* cell instance sky130_fd_sc_hd__fill_4_807 r0 *1 0,0
Xsky130_fd_sc_hd__fill_4_807
+ vss
+ vdd
+ vdd
+ sky130_fd_sc_hd__fill_4
* cell instance sky130_fd_sc_hd__fill_4_808 r0 *1 0,0
Xsky130_fd_sc_hd__fill_4_808
+ vss
+ vdd
+ vdd
+ sky130_fd_sc_hd__fill_4
* cell instance sky130_fd_sc_hd__fill_4_809 r0 *1 0,0
Xsky130_fd_sc_hd__fill_4_809
+ vss
+ vdd
+ vdd
+ sky130_fd_sc_hd__fill_4
* cell instance sky130_fd_sc_hd__fill_4_810 r0 *1 0,0
Xsky130_fd_sc_hd__fill_4_810
+ vss
+ vdd
+ vdd
+ sky130_fd_sc_hd__fill_4
* cell instance sky130_fd_sc_hd__fill_4_811 r0 *1 0,0
Xsky130_fd_sc_hd__fill_4_811
+ vss
+ vdd
+ vdd
+ sky130_fd_sc_hd__fill_4
* cell instance sky130_fd_sc_hd__fill_4_812 r0 *1 0,0
Xsky130_fd_sc_hd__fill_4_812
+ vss
+ vdd
+ vdd
+ sky130_fd_sc_hd__fill_4
* cell instance sky130_fd_sc_hd__fill_4_813 r0 *1 0,0
Xsky130_fd_sc_hd__fill_4_813
+ vss
+ vdd
+ vdd
+ sky130_fd_sc_hd__fill_4
* cell instance sky130_fd_sc_hd__fill_4_814 r0 *1 0,0
Xsky130_fd_sc_hd__fill_4_814
+ vss
+ vdd
+ vdd
+ sky130_fd_sc_hd__fill_4
* cell instance sky130_fd_sc_hd__fill_4_815 r0 *1 0,0
Xsky130_fd_sc_hd__fill_4_815
+ vss
+ vdd
+ vdd
+ sky130_fd_sc_hd__fill_4
* cell instance sky130_fd_sc_hd__fill_4_816 r0 *1 0,0
Xsky130_fd_sc_hd__fill_4_816
+ vss
+ vdd
+ vdd
+ sky130_fd_sc_hd__fill_4
* cell instance sky130_fd_sc_hd__fill_4_817 r0 *1 0,0
Xsky130_fd_sc_hd__fill_4_817
+ vss
+ vdd
+ vdd
+ sky130_fd_sc_hd__fill_4
* cell instance sky130_fd_sc_hd__fill_4_818 r0 *1 0,0
Xsky130_fd_sc_hd__fill_4_818
+ vss
+ vdd
+ vdd
+ sky130_fd_sc_hd__fill_4
* cell instance sky130_fd_sc_hd__fill_4_819 r0 *1 0,0
Xsky130_fd_sc_hd__fill_4_819
+ vss
+ vdd
+ vdd
+ sky130_fd_sc_hd__fill_4
* cell instance sky130_fd_sc_hd__fill_4_820 r0 *1 0,0
Xsky130_fd_sc_hd__fill_4_820
+ vss
+ vdd
+ vdd
+ sky130_fd_sc_hd__fill_4
* cell instance sky130_fd_sc_hd__fill_4_821 r0 *1 0,0
Xsky130_fd_sc_hd__fill_4_821
+ vss
+ vdd
+ vdd
+ sky130_fd_sc_hd__fill_4
* cell instance sky130_fd_sc_hd__fill_4_822 r0 *1 0,0
Xsky130_fd_sc_hd__fill_4_822
+ vss
+ vdd
+ vdd
+ sky130_fd_sc_hd__fill_4
* cell instance sky130_fd_sc_hd__fill_4_823 r0 *1 0,0
Xsky130_fd_sc_hd__fill_4_823
+ vss
+ vdd
+ vdd
+ sky130_fd_sc_hd__fill_4
* cell instance sky130_fd_sc_hd__fill_4_824 r0 *1 0,0
Xsky130_fd_sc_hd__fill_4_824
+ vss
+ vdd
+ vdd
+ sky130_fd_sc_hd__fill_4
* cell instance sky130_fd_sc_hd__fill_4_825 r0 *1 0,0
Xsky130_fd_sc_hd__fill_4_825
+ vss
+ vdd
+ vdd
+ sky130_fd_sc_hd__fill_4
* cell instance sky130_fd_sc_hd__fill_4_826 r0 *1 0,0
Xsky130_fd_sc_hd__fill_4_826
+ vss
+ vdd
+ vdd
+ sky130_fd_sc_hd__fill_4
* cell instance sky130_fd_sc_hd__fill_4_827 r0 *1 0,0
Xsky130_fd_sc_hd__fill_4_827
+ vss
+ vdd
+ vdd
+ sky130_fd_sc_hd__fill_4
* cell instance sky130_fd_sc_hd__fill_4_828 r0 *1 0,0
Xsky130_fd_sc_hd__fill_4_828
+ vss
+ vdd
+ vdd
+ sky130_fd_sc_hd__fill_4
* cell instance sky130_fd_sc_hd__fill_4_829 r0 *1 0,0
Xsky130_fd_sc_hd__fill_4_829
+ vss
+ vdd
+ vdd
+ sky130_fd_sc_hd__fill_4
* cell instance sky130_fd_sc_hd__fill_4_830 r0 *1 0,0
Xsky130_fd_sc_hd__fill_4_830
+ vss
+ vdd
+ vdd
+ sky130_fd_sc_hd__fill_4
* cell instance sky130_fd_sc_hd__fill_4_831 r0 *1 0,0
Xsky130_fd_sc_hd__fill_4_831
+ vss
+ vdd
+ vdd
+ sky130_fd_sc_hd__fill_4
* cell instance sky130_fd_sc_hd__fill_4_832 r0 *1 0,0
Xsky130_fd_sc_hd__fill_4_832
+ vss
+ vdd
+ vdd
+ sky130_fd_sc_hd__fill_4
* cell instance sky130_fd_sc_hd__fill_4_833 r0 *1 0,0
Xsky130_fd_sc_hd__fill_4_833
+ vss
+ vdd
+ vdd
+ sky130_fd_sc_hd__fill_4
* cell instance sky130_fd_sc_hd__fill_4_834 r0 *1 0,0
Xsky130_fd_sc_hd__fill_4_834
+ vss
+ vdd
+ vdd
+ sky130_fd_sc_hd__fill_4
* cell instance sky130_fd_sc_hd__fill_4_835 r0 *1 0,0
Xsky130_fd_sc_hd__fill_4_835
+ vss
+ vdd
+ vdd
+ sky130_fd_sc_hd__fill_4
* cell instance sky130_fd_sc_hd__fill_4_836 r0 *1 0,0
Xsky130_fd_sc_hd__fill_4_836
+ vss
+ vdd
+ vdd
+ sky130_fd_sc_hd__fill_4
* cell instance sky130_fd_sc_hd__fill_4_837 r0 *1 0,0
Xsky130_fd_sc_hd__fill_4_837
+ vss
+ vdd
+ vdd
+ sky130_fd_sc_hd__fill_4
* cell instance sky130_fd_sc_hd__fill_4_838 r0 *1 0,0
Xsky130_fd_sc_hd__fill_4_838
+ vss
+ vdd
+ vdd
+ sky130_fd_sc_hd__fill_4
* cell instance sky130_fd_sc_hd__fill_4_839 r0 *1 0,0
Xsky130_fd_sc_hd__fill_4_839
+ vss
+ vdd
+ vdd
+ sky130_fd_sc_hd__fill_4
* cell instance sky130_fd_sc_hd__fill_4_840 r0 *1 0,0
Xsky130_fd_sc_hd__fill_4_840
+ vss
+ vdd
+ vdd
+ sky130_fd_sc_hd__fill_4
* cell instance sky130_fd_sc_hd__fill_4_841 r0 *1 0,0
Xsky130_fd_sc_hd__fill_4_841
+ vss
+ vdd
+ vdd
+ sky130_fd_sc_hd__fill_4
* cell instance sky130_fd_sc_hd__fill_4_842 r0 *1 0,0
Xsky130_fd_sc_hd__fill_4_842
+ vss
+ vdd
+ vdd
+ sky130_fd_sc_hd__fill_4
* cell instance sky130_fd_sc_hd__fill_4_843 r0 *1 0,0
Xsky130_fd_sc_hd__fill_4_843
+ vss
+ vdd
+ vdd
+ sky130_fd_sc_hd__fill_4
* cell instance sky130_fd_sc_hd__fill_4_844 r0 *1 0,0
Xsky130_fd_sc_hd__fill_4_844
+ vss
+ vdd
+ vdd
+ sky130_fd_sc_hd__fill_4
* cell instance sky130_fd_sc_hd__fill_4_845 r0 *1 0,0
Xsky130_fd_sc_hd__fill_4_845
+ vss
+ vdd
+ vdd
+ sky130_fd_sc_hd__fill_4
* cell instance sky130_fd_sc_hd__fill_4_846 r0 *1 0,0
Xsky130_fd_sc_hd__fill_4_846
+ vss
+ vdd
+ vdd
+ sky130_fd_sc_hd__fill_4
* cell instance sky130_fd_sc_hd__fill_4_847 r0 *1 0,0
Xsky130_fd_sc_hd__fill_4_847
+ vss
+ vdd
+ vdd
+ sky130_fd_sc_hd__fill_4
* cell instance sky130_fd_sc_hd__fill_4_848 r0 *1 0,0
Xsky130_fd_sc_hd__fill_4_848
+ vss
+ vdd
+ vdd
+ sky130_fd_sc_hd__fill_4
* cell instance sky130_fd_sc_hd__fill_4_849 r0 *1 0,0
Xsky130_fd_sc_hd__fill_4_849
+ vss
+ vdd
+ vdd
+ sky130_fd_sc_hd__fill_4
* cell instance sky130_fd_sc_hd__fill_4_850 r0 *1 0,0
Xsky130_fd_sc_hd__fill_4_850
+ vss
+ vdd
+ vdd
+ sky130_fd_sc_hd__fill_4
* cell instance sky130_fd_sc_hd__fill_4_851 r0 *1 0,0
Xsky130_fd_sc_hd__fill_4_851
+ vss
+ vdd
+ vdd
+ sky130_fd_sc_hd__fill_4
* cell instance sky130_fd_sc_hd__fill_4_852 r0 *1 0,0
Xsky130_fd_sc_hd__fill_4_852
+ vss
+ vdd
+ vdd
+ sky130_fd_sc_hd__fill_4
* cell instance sky130_fd_sc_hd__fill_4_853 r0 *1 0,0
Xsky130_fd_sc_hd__fill_4_853
+ vss
+ vdd
+ vdd
+ sky130_fd_sc_hd__fill_4
* cell instance sky130_fd_sc_hd__fill_4_854 r0 *1 0,0
Xsky130_fd_sc_hd__fill_4_854
+ vss
+ vdd
+ vdd
+ sky130_fd_sc_hd__fill_4
* cell instance sky130_fd_sc_hd__fill_4_855 r0 *1 0,0
Xsky130_fd_sc_hd__fill_4_855
+ vss
+ vdd
+ vdd
+ sky130_fd_sc_hd__fill_4
* cell instance sky130_fd_sc_hd__fill_4_856 r0 *1 0,0
Xsky130_fd_sc_hd__fill_4_856
+ vss
+ vdd
+ vdd
+ sky130_fd_sc_hd__fill_4
* cell instance sky130_fd_sc_hd__fill_4_857 r0 *1 0,0
Xsky130_fd_sc_hd__fill_4_857
+ vss
+ vdd
+ vdd
+ sky130_fd_sc_hd__fill_4
* cell instance sky130_fd_sc_hd__fill_4_858 r0 *1 0,0
Xsky130_fd_sc_hd__fill_4_858
+ vss
+ vdd
+ vdd
+ sky130_fd_sc_hd__fill_4
* cell instance sky130_fd_sc_hd__fill_4_859 r0 *1 0,0
Xsky130_fd_sc_hd__fill_4_859
+ vss
+ vdd
+ vdd
+ sky130_fd_sc_hd__fill_4
* cell instance sky130_fd_sc_hd__fill_4_860 r0 *1 0,0
Xsky130_fd_sc_hd__fill_4_860
+ vss
+ vdd
+ vdd
+ sky130_fd_sc_hd__fill_4
* cell instance sky130_fd_sc_hd__fill_8_0 r0 *1 0,0
Xsky130_fd_sc_hd__fill_8_0
+ vss
+ vdd
+ vdd
+ sky130_fd_sc_hd__fill_8
* cell instance sky130_fd_sc_hd__fill_8_1 r0 *1 0,0
Xsky130_fd_sc_hd__fill_8_1
+ vss
+ vdd
+ vdd
+ sky130_fd_sc_hd__fill_8
* cell instance sky130_fd_sc_hd__fill_8_2 r0 *1 0,0
Xsky130_fd_sc_hd__fill_8_2
+ vss
+ vdd
+ vdd
+ sky130_fd_sc_hd__fill_8
* cell instance sky130_fd_sc_hd__fill_8_3 r0 *1 0,0
Xsky130_fd_sc_hd__fill_8_3
+ vss
+ vdd
+ vdd
+ sky130_fd_sc_hd__fill_8
* cell instance sky130_fd_sc_hd__fill_8_4 r0 *1 0,0
Xsky130_fd_sc_hd__fill_8_4
+ vss
+ vdd
+ vdd
+ sky130_fd_sc_hd__fill_8
* cell instance sky130_fd_sc_hd__fill_8_5 r0 *1 0,0
Xsky130_fd_sc_hd__fill_8_5
+ vss
+ vdd
+ vdd
+ sky130_fd_sc_hd__fill_8
* cell instance sky130_fd_sc_hd__fill_8_6 r0 *1 0,0
Xsky130_fd_sc_hd__fill_8_6
+ vss
+ vdd
+ vdd
+ sky130_fd_sc_hd__fill_8
* cell instance sky130_fd_sc_hd__fill_8_7 r0 *1 0,0
Xsky130_fd_sc_hd__fill_8_7
+ vss
+ vdd
+ vdd
+ sky130_fd_sc_hd__fill_8
* cell instance sky130_fd_sc_hd__fill_8_8 r0 *1 0,0
Xsky130_fd_sc_hd__fill_8_8
+ vss
+ vdd
+ vdd
+ sky130_fd_sc_hd__fill_8
* cell instance sky130_fd_sc_hd__fill_8_9 r0 *1 0,0
Xsky130_fd_sc_hd__fill_8_9
+ vss
+ vdd
+ vdd
+ sky130_fd_sc_hd__fill_8
* cell instance sky130_fd_sc_hd__fill_8_10 r0 *1 0,0
Xsky130_fd_sc_hd__fill_8_10
+ vss
+ vdd
+ vdd
+ sky130_fd_sc_hd__fill_8
* cell instance sky130_fd_sc_hd__fill_8_11 r0 *1 0,0
Xsky130_fd_sc_hd__fill_8_11
+ vss
+ vdd
+ vdd
+ sky130_fd_sc_hd__fill_8
* cell instance sky130_fd_sc_hd__fill_8_12 r0 *1 0,0
Xsky130_fd_sc_hd__fill_8_12
+ vss
+ vdd
+ vdd
+ sky130_fd_sc_hd__fill_8
* cell instance sky130_fd_sc_hd__fill_8_13 r0 *1 0,0
Xsky130_fd_sc_hd__fill_8_13
+ vss
+ vdd
+ vdd
+ sky130_fd_sc_hd__fill_8
* cell instance sky130_fd_sc_hd__fill_8_14 r0 *1 0,0
Xsky130_fd_sc_hd__fill_8_14
+ vss
+ vdd
+ vdd
+ sky130_fd_sc_hd__fill_8
* cell instance sky130_fd_sc_hd__fill_8_15 r0 *1 0,0
Xsky130_fd_sc_hd__fill_8_15
+ vss
+ vdd
+ vdd
+ sky130_fd_sc_hd__fill_8
* cell instance sky130_fd_sc_hd__fill_8_16 r0 *1 0,0
Xsky130_fd_sc_hd__fill_8_16
+ vss
+ vdd
+ vdd
+ sky130_fd_sc_hd__fill_8
* cell instance sky130_fd_sc_hd__fill_8_17 r0 *1 0,0
Xsky130_fd_sc_hd__fill_8_17
+ vss
+ vdd
+ vdd
+ sky130_fd_sc_hd__fill_8
* cell instance sky130_fd_sc_hd__fill_8_18 r0 *1 0,0
Xsky130_fd_sc_hd__fill_8_18
+ vss
+ vdd
+ vdd
+ sky130_fd_sc_hd__fill_8
* cell instance sky130_fd_sc_hd__fill_8_19 r0 *1 0,0
Xsky130_fd_sc_hd__fill_8_19
+ vss
+ vdd
+ vdd
+ sky130_fd_sc_hd__fill_8
* cell instance sky130_fd_sc_hd__fill_8_20 r0 *1 0,0
Xsky130_fd_sc_hd__fill_8_20
+ vss
+ vdd
+ vdd
+ sky130_fd_sc_hd__fill_8
* cell instance sky130_fd_sc_hd__fill_8_21 r0 *1 0,0
Xsky130_fd_sc_hd__fill_8_21
+ vss
+ vdd
+ vdd
+ sky130_fd_sc_hd__fill_8
* cell instance sky130_fd_sc_hd__fill_8_22 r0 *1 0,0
Xsky130_fd_sc_hd__fill_8_22
+ vss
+ vdd
+ vdd
+ sky130_fd_sc_hd__fill_8
* cell instance sky130_fd_sc_hd__fill_8_23 r0 *1 0,0
Xsky130_fd_sc_hd__fill_8_23
+ vss
+ vdd
+ vdd
+ sky130_fd_sc_hd__fill_8
* cell instance sky130_fd_sc_hd__fill_8_24 r0 *1 0,0
Xsky130_fd_sc_hd__fill_8_24
+ vss
+ vdd
+ vdd
+ sky130_fd_sc_hd__fill_8
* cell instance sky130_fd_sc_hd__fill_8_25 r0 *1 0,0
Xsky130_fd_sc_hd__fill_8_25
+ vss
+ vdd
+ vdd
+ sky130_fd_sc_hd__fill_8
* cell instance sky130_fd_sc_hd__fill_8_26 r0 *1 0,0
Xsky130_fd_sc_hd__fill_8_26
+ vss
+ vdd
+ vdd
+ sky130_fd_sc_hd__fill_8
* cell instance sky130_fd_sc_hd__fill_8_27 r0 *1 0,0
Xsky130_fd_sc_hd__fill_8_27
+ vss
+ vdd
+ vdd
+ sky130_fd_sc_hd__fill_8
* cell instance sky130_fd_sc_hd__fill_8_28 r0 *1 0,0
Xsky130_fd_sc_hd__fill_8_28
+ vss
+ vdd
+ vdd
+ sky130_fd_sc_hd__fill_8
* cell instance sky130_fd_sc_hd__fill_8_29 r0 *1 0,0
Xsky130_fd_sc_hd__fill_8_29
+ vss
+ vdd
+ vdd
+ sky130_fd_sc_hd__fill_8
* cell instance sky130_fd_sc_hd__fill_8_30 r0 *1 0,0
Xsky130_fd_sc_hd__fill_8_30
+ vss
+ vdd
+ vdd
+ sky130_fd_sc_hd__fill_8
* cell instance sky130_fd_sc_hd__fill_8_31 r0 *1 0,0
Xsky130_fd_sc_hd__fill_8_31
+ vss
+ vdd
+ vdd
+ sky130_fd_sc_hd__fill_8
* cell instance sky130_fd_sc_hd__fill_8_32 r0 *1 0,0
Xsky130_fd_sc_hd__fill_8_32
+ vss
+ vdd
+ vdd
+ sky130_fd_sc_hd__fill_8
* cell instance sky130_fd_sc_hd__fill_8_33 r0 *1 0,0
Xsky130_fd_sc_hd__fill_8_33
+ vss
+ vdd
+ vdd
+ sky130_fd_sc_hd__fill_8
* cell instance sky130_fd_sc_hd__fill_8_34 r0 *1 0,0
Xsky130_fd_sc_hd__fill_8_34
+ vss
+ vdd
+ vdd
+ sky130_fd_sc_hd__fill_8
* cell instance sky130_fd_sc_hd__fill_8_35 r0 *1 0,0
Xsky130_fd_sc_hd__fill_8_35
+ vss
+ vdd
+ vdd
+ sky130_fd_sc_hd__fill_8
* cell instance sky130_fd_sc_hd__fill_8_36 r0 *1 0,0
Xsky130_fd_sc_hd__fill_8_36
+ vss
+ vdd
+ vdd
+ sky130_fd_sc_hd__fill_8
* cell instance sky130_fd_sc_hd__fill_8_37 r0 *1 0,0
Xsky130_fd_sc_hd__fill_8_37
+ vss
+ vdd
+ vdd
+ sky130_fd_sc_hd__fill_8
* cell instance sky130_fd_sc_hd__fill_8_38 r0 *1 0,0
Xsky130_fd_sc_hd__fill_8_38
+ vss
+ vdd
+ vdd
+ sky130_fd_sc_hd__fill_8
* cell instance sky130_fd_sc_hd__fill_8_39 r0 *1 0,0
Xsky130_fd_sc_hd__fill_8_39
+ vss
+ vdd
+ vdd
+ sky130_fd_sc_hd__fill_8
* cell instance sky130_fd_sc_hd__fill_8_40 r0 *1 0,0
Xsky130_fd_sc_hd__fill_8_40
+ vss
+ vdd
+ vdd
+ sky130_fd_sc_hd__fill_8
* cell instance sky130_fd_sc_hd__fill_8_41 r0 *1 0,0
Xsky130_fd_sc_hd__fill_8_41
+ vss
+ vdd
+ vdd
+ sky130_fd_sc_hd__fill_8
* cell instance sky130_fd_sc_hd__fill_8_42 r0 *1 0,0
Xsky130_fd_sc_hd__fill_8_42
+ vss
+ vdd
+ vdd
+ sky130_fd_sc_hd__fill_8
* cell instance sky130_fd_sc_hd__fill_8_43 r0 *1 0,0
Xsky130_fd_sc_hd__fill_8_43
+ vss
+ vdd
+ vdd
+ sky130_fd_sc_hd__fill_8
* cell instance sky130_fd_sc_hd__fill_8_44 r0 *1 0,0
Xsky130_fd_sc_hd__fill_8_44
+ vss
+ vdd
+ vdd
+ sky130_fd_sc_hd__fill_8
* cell instance sky130_fd_sc_hd__fill_8_45 r0 *1 0,0
Xsky130_fd_sc_hd__fill_8_45
+ vss
+ vdd
+ vdd
+ sky130_fd_sc_hd__fill_8
* cell instance sky130_fd_sc_hd__fill_8_46 r0 *1 0,0
Xsky130_fd_sc_hd__fill_8_46
+ vss
+ vdd
+ vdd
+ sky130_fd_sc_hd__fill_8
* cell instance sky130_fd_sc_hd__fill_8_47 r0 *1 0,0
Xsky130_fd_sc_hd__fill_8_47
+ vss
+ vdd
+ vdd
+ sky130_fd_sc_hd__fill_8
* cell instance sky130_fd_sc_hd__fill_8_48 r0 *1 0,0
Xsky130_fd_sc_hd__fill_8_48
+ vss
+ vdd
+ vdd
+ sky130_fd_sc_hd__fill_8
* cell instance sky130_fd_sc_hd__fill_8_49 r0 *1 0,0
Xsky130_fd_sc_hd__fill_8_49
+ vss
+ vdd
+ vdd
+ sky130_fd_sc_hd__fill_8
* cell instance sky130_fd_sc_hd__fill_8_50 r0 *1 0,0
Xsky130_fd_sc_hd__fill_8_50
+ vss
+ vdd
+ vdd
+ sky130_fd_sc_hd__fill_8
* cell instance sky130_fd_sc_hd__fill_8_51 r0 *1 0,0
Xsky130_fd_sc_hd__fill_8_51
+ vss
+ vdd
+ vdd
+ sky130_fd_sc_hd__fill_8
* cell instance sky130_fd_sc_hd__fill_8_52 r0 *1 0,0
Xsky130_fd_sc_hd__fill_8_52
+ vss
+ vdd
+ vdd
+ sky130_fd_sc_hd__fill_8
* cell instance sky130_fd_sc_hd__fill_8_53 r0 *1 0,0
Xsky130_fd_sc_hd__fill_8_53
+ vss
+ vdd
+ vdd
+ sky130_fd_sc_hd__fill_8
* cell instance sky130_fd_sc_hd__fill_8_54 r0 *1 0,0
Xsky130_fd_sc_hd__fill_8_54
+ vss
+ vdd
+ vdd
+ sky130_fd_sc_hd__fill_8
* cell instance sky130_fd_sc_hd__fill_8_55 r0 *1 0,0
Xsky130_fd_sc_hd__fill_8_55
+ vss
+ vdd
+ vdd
+ sky130_fd_sc_hd__fill_8
* cell instance sky130_fd_sc_hd__fill_8_56 r0 *1 0,0
Xsky130_fd_sc_hd__fill_8_56
+ vss
+ vdd
+ vdd
+ sky130_fd_sc_hd__fill_8
* cell instance sky130_fd_sc_hd__fill_8_57 r0 *1 0,0
Xsky130_fd_sc_hd__fill_8_57
+ vss
+ vdd
+ vdd
+ sky130_fd_sc_hd__fill_8
* cell instance sky130_fd_sc_hd__fill_8_58 r0 *1 0,0
Xsky130_fd_sc_hd__fill_8_58
+ vss
+ vdd
+ vdd
+ sky130_fd_sc_hd__fill_8
* cell instance sky130_fd_sc_hd__fill_8_59 r0 *1 0,0
Xsky130_fd_sc_hd__fill_8_59
+ vss
+ vdd
+ vdd
+ sky130_fd_sc_hd__fill_8
* cell instance sky130_fd_sc_hd__fill_8_60 r0 *1 0,0
Xsky130_fd_sc_hd__fill_8_60
+ vss
+ vdd
+ vdd
+ sky130_fd_sc_hd__fill_8
* cell instance sky130_fd_sc_hd__fill_8_61 r0 *1 0,0
Xsky130_fd_sc_hd__fill_8_61
+ vss
+ vdd
+ vdd
+ sky130_fd_sc_hd__fill_8
* cell instance sky130_fd_sc_hd__fill_8_62 r0 *1 0,0
Xsky130_fd_sc_hd__fill_8_62
+ vss
+ vdd
+ vdd
+ sky130_fd_sc_hd__fill_8
* cell instance sky130_fd_sc_hd__fill_8_63 r0 *1 0,0
Xsky130_fd_sc_hd__fill_8_63
+ vss
+ vdd
+ vdd
+ sky130_fd_sc_hd__fill_8
* cell instance sky130_fd_sc_hd__fill_8_64 r0 *1 0,0
Xsky130_fd_sc_hd__fill_8_64
+ vss
+ vdd
+ vdd
+ sky130_fd_sc_hd__fill_8
* cell instance sky130_fd_sc_hd__fill_8_65 r0 *1 0,0
Xsky130_fd_sc_hd__fill_8_65
+ vss
+ vdd
+ vdd
+ sky130_fd_sc_hd__fill_8
* cell instance sky130_fd_sc_hd__fill_8_66 r0 *1 0,0
Xsky130_fd_sc_hd__fill_8_66
+ vss
+ vdd
+ vdd
+ sky130_fd_sc_hd__fill_8
* cell instance sky130_fd_sc_hd__fill_8_67 r0 *1 0,0
Xsky130_fd_sc_hd__fill_8_67
+ vss
+ vdd
+ vdd
+ sky130_fd_sc_hd__fill_8
* cell instance sky130_fd_sc_hd__fill_8_68 r0 *1 0,0
Xsky130_fd_sc_hd__fill_8_68
+ vss
+ vdd
+ vdd
+ sky130_fd_sc_hd__fill_8
* cell instance sky130_fd_sc_hd__fill_8_69 r0 *1 0,0
Xsky130_fd_sc_hd__fill_8_69
+ vss
+ vdd
+ vdd
+ sky130_fd_sc_hd__fill_8
* cell instance sky130_fd_sc_hd__fill_8_70 r0 *1 0,0
Xsky130_fd_sc_hd__fill_8_70
+ vss
+ vdd
+ vdd
+ sky130_fd_sc_hd__fill_8
* cell instance sky130_fd_sc_hd__fill_8_71 r0 *1 0,0
Xsky130_fd_sc_hd__fill_8_71
+ vss
+ vdd
+ vdd
+ sky130_fd_sc_hd__fill_8
* cell instance sky130_fd_sc_hd__fill_8_72 r0 *1 0,0
Xsky130_fd_sc_hd__fill_8_72
+ vss
+ vdd
+ vdd
+ sky130_fd_sc_hd__fill_8
* cell instance sky130_fd_sc_hd__fill_8_73 r0 *1 0,0
Xsky130_fd_sc_hd__fill_8_73
+ vss
+ vdd
+ vdd
+ sky130_fd_sc_hd__fill_8
* cell instance sky130_fd_sc_hd__fill_8_74 r0 *1 0,0
Xsky130_fd_sc_hd__fill_8_74
+ vss
+ vdd
+ vdd
+ sky130_fd_sc_hd__fill_8
* cell instance sky130_fd_sc_hd__fill_8_75 r0 *1 0,0
Xsky130_fd_sc_hd__fill_8_75
+ vss
+ vdd
+ vdd
+ sky130_fd_sc_hd__fill_8
* cell instance sky130_fd_sc_hd__fill_8_76 r0 *1 0,0
Xsky130_fd_sc_hd__fill_8_76
+ vss
+ vdd
+ vdd
+ sky130_fd_sc_hd__fill_8
* cell instance sky130_fd_sc_hd__fill_8_77 r0 *1 0,0
Xsky130_fd_sc_hd__fill_8_77
+ vss
+ vdd
+ vdd
+ sky130_fd_sc_hd__fill_8
* cell instance sky130_fd_sc_hd__fill_8_78 r0 *1 0,0
Xsky130_fd_sc_hd__fill_8_78
+ vss
+ vdd
+ vdd
+ sky130_fd_sc_hd__fill_8
* cell instance sky130_fd_sc_hd__fill_8_79 r0 *1 0,0
Xsky130_fd_sc_hd__fill_8_79
+ vss
+ vdd
+ vdd
+ sky130_fd_sc_hd__fill_8
* cell instance sky130_fd_sc_hd__fill_8_80 r0 *1 0,0
Xsky130_fd_sc_hd__fill_8_80
+ vss
+ vdd
+ vdd
+ sky130_fd_sc_hd__fill_8
* cell instance sky130_fd_sc_hd__fill_8_81 r0 *1 0,0
Xsky130_fd_sc_hd__fill_8_81
+ vss
+ vdd
+ vdd
+ sky130_fd_sc_hd__fill_8
* cell instance sky130_fd_sc_hd__fill_8_82 r0 *1 0,0
Xsky130_fd_sc_hd__fill_8_82
+ vss
+ vdd
+ vdd
+ sky130_fd_sc_hd__fill_8
* cell instance sky130_fd_sc_hd__fill_8_83 r0 *1 0,0
Xsky130_fd_sc_hd__fill_8_83
+ vss
+ vdd
+ vdd
+ sky130_fd_sc_hd__fill_8
* cell instance sky130_fd_sc_hd__fill_8_84 r0 *1 0,0
Xsky130_fd_sc_hd__fill_8_84
+ vss
+ vdd
+ vdd
+ sky130_fd_sc_hd__fill_8
* cell instance sky130_fd_sc_hd__fill_8_85 r0 *1 0,0
Xsky130_fd_sc_hd__fill_8_85
+ vss
+ vdd
+ vdd
+ sky130_fd_sc_hd__fill_8
* cell instance sky130_fd_sc_hd__fill_8_86 r0 *1 0,0
Xsky130_fd_sc_hd__fill_8_86
+ vss
+ vdd
+ vdd
+ sky130_fd_sc_hd__fill_8
* cell instance sky130_fd_sc_hd__fill_8_87 r0 *1 0,0
Xsky130_fd_sc_hd__fill_8_87
+ vss
+ vdd
+ vdd
+ sky130_fd_sc_hd__fill_8
* cell instance sky130_fd_sc_hd__fill_8_88 r0 *1 0,0
Xsky130_fd_sc_hd__fill_8_88
+ vss
+ vdd
+ vdd
+ sky130_fd_sc_hd__fill_8
* cell instance sky130_fd_sc_hd__fill_8_89 r0 *1 0,0
Xsky130_fd_sc_hd__fill_8_89
+ vss
+ vdd
+ vdd
+ sky130_fd_sc_hd__fill_8
* cell instance sky130_fd_sc_hd__fill_8_90 r0 *1 0,0
Xsky130_fd_sc_hd__fill_8_90
+ vss
+ vdd
+ vdd
+ sky130_fd_sc_hd__fill_8
* cell instance sky130_fd_sc_hd__fill_8_91 r0 *1 0,0
Xsky130_fd_sc_hd__fill_8_91
+ vss
+ vdd
+ vdd
+ sky130_fd_sc_hd__fill_8
* cell instance sky130_fd_sc_hd__fill_8_92 r0 *1 0,0
Xsky130_fd_sc_hd__fill_8_92
+ vss
+ vdd
+ vdd
+ sky130_fd_sc_hd__fill_8
* cell instance sky130_fd_sc_hd__fill_8_93 r0 *1 0,0
Xsky130_fd_sc_hd__fill_8_93
+ vss
+ vdd
+ vdd
+ sky130_fd_sc_hd__fill_8
* cell instance sky130_fd_sc_hd__fill_8_94 r0 *1 0,0
Xsky130_fd_sc_hd__fill_8_94
+ vss
+ vdd
+ vdd
+ sky130_fd_sc_hd__fill_8
* cell instance sky130_fd_sc_hd__fill_8_95 r0 *1 0,0
Xsky130_fd_sc_hd__fill_8_95
+ vss
+ vdd
+ vdd
+ sky130_fd_sc_hd__fill_8
* cell instance sky130_fd_sc_hd__fill_8_96 r0 *1 0,0
Xsky130_fd_sc_hd__fill_8_96
+ vss
+ vdd
+ vdd
+ sky130_fd_sc_hd__fill_8
* cell instance sky130_fd_sc_hd__fill_8_97 r0 *1 0,0
Xsky130_fd_sc_hd__fill_8_97
+ vss
+ vdd
+ vdd
+ sky130_fd_sc_hd__fill_8
* cell instance sky130_fd_sc_hd__fill_8_98 r0 *1 0,0
Xsky130_fd_sc_hd__fill_8_98
+ vss
+ vdd
+ vdd
+ sky130_fd_sc_hd__fill_8
* cell instance sky130_fd_sc_hd__fill_8_99 r0 *1 0,0
Xsky130_fd_sc_hd__fill_8_99
+ vss
+ vdd
+ vdd
+ sky130_fd_sc_hd__fill_8
* cell instance sky130_fd_sc_hd__fill_8_100 r0 *1 0,0
Xsky130_fd_sc_hd__fill_8_100
+ vss
+ vdd
+ vdd
+ sky130_fd_sc_hd__fill_8
* cell instance sky130_fd_sc_hd__fill_8_101 r0 *1 0,0
Xsky130_fd_sc_hd__fill_8_101
+ vss
+ vdd
+ vdd
+ sky130_fd_sc_hd__fill_8
* cell instance sky130_fd_sc_hd__fill_8_102 r0 *1 0,0
Xsky130_fd_sc_hd__fill_8_102
+ vss
+ vdd
+ vdd
+ sky130_fd_sc_hd__fill_8
* cell instance sky130_fd_sc_hd__fill_8_103 r0 *1 0,0
Xsky130_fd_sc_hd__fill_8_103
+ vss
+ vdd
+ vdd
+ sky130_fd_sc_hd__fill_8
* cell instance sky130_fd_sc_hd__fill_8_104 r0 *1 0,0
Xsky130_fd_sc_hd__fill_8_104
+ vss
+ vdd
+ vdd
+ sky130_fd_sc_hd__fill_8
* cell instance sky130_fd_sc_hd__fill_8_105 r0 *1 0,0
Xsky130_fd_sc_hd__fill_8_105
+ vss
+ vdd
+ vdd
+ sky130_fd_sc_hd__fill_8
* cell instance sky130_fd_sc_hd__fill_8_106 r0 *1 0,0
Xsky130_fd_sc_hd__fill_8_106
+ vss
+ vdd
+ vdd
+ sky130_fd_sc_hd__fill_8
* cell instance sky130_fd_sc_hd__fill_8_107 r0 *1 0,0
Xsky130_fd_sc_hd__fill_8_107
+ vss
+ vdd
+ vdd
+ sky130_fd_sc_hd__fill_8
* cell instance sky130_fd_sc_hd__fill_8_108 r0 *1 0,0
Xsky130_fd_sc_hd__fill_8_108
+ vss
+ vdd
+ vdd
+ sky130_fd_sc_hd__fill_8
* cell instance sky130_fd_sc_hd__fill_8_109 r0 *1 0,0
Xsky130_fd_sc_hd__fill_8_109
+ vss
+ vdd
+ vdd
+ sky130_fd_sc_hd__fill_8
* cell instance sky130_fd_sc_hd__fill_8_110 r0 *1 0,0
Xsky130_fd_sc_hd__fill_8_110
+ vss
+ vdd
+ vdd
+ sky130_fd_sc_hd__fill_8
* cell instance sky130_fd_sc_hd__fill_8_111 r0 *1 0,0
Xsky130_fd_sc_hd__fill_8_111
+ vss
+ vdd
+ vdd
+ sky130_fd_sc_hd__fill_8
* cell instance sky130_fd_sc_hd__fill_8_112 r0 *1 0,0
Xsky130_fd_sc_hd__fill_8_112
+ vss
+ vdd
+ vdd
+ sky130_fd_sc_hd__fill_8
* cell instance sky130_fd_sc_hd__fill_8_113 r0 *1 0,0
Xsky130_fd_sc_hd__fill_8_113
+ vss
+ vdd
+ vdd
+ sky130_fd_sc_hd__fill_8
* cell instance sky130_fd_sc_hd__fill_8_114 r0 *1 0,0
Xsky130_fd_sc_hd__fill_8_114
+ vss
+ vdd
+ vdd
+ sky130_fd_sc_hd__fill_8
* cell instance sky130_fd_sc_hd__fill_8_115 r0 *1 0,0
Xsky130_fd_sc_hd__fill_8_115
+ vss
+ vdd
+ vdd
+ sky130_fd_sc_hd__fill_8
* cell instance sky130_fd_sc_hd__fill_8_116 r0 *1 0,0
Xsky130_fd_sc_hd__fill_8_116
+ vss
+ vdd
+ vdd
+ sky130_fd_sc_hd__fill_8
* cell instance sky130_fd_sc_hd__fill_8_117 r0 *1 0,0
Xsky130_fd_sc_hd__fill_8_117
+ vss
+ vdd
+ vdd
+ sky130_fd_sc_hd__fill_8
* cell instance sky130_fd_sc_hd__fill_8_118 r0 *1 0,0
Xsky130_fd_sc_hd__fill_8_118
+ vss
+ vdd
+ vdd
+ sky130_fd_sc_hd__fill_8
* cell instance sky130_fd_sc_hd__fill_8_119 r0 *1 0,0
Xsky130_fd_sc_hd__fill_8_119
+ vss
+ vdd
+ vdd
+ sky130_fd_sc_hd__fill_8
* cell instance sky130_fd_sc_hd__fill_8_120 r0 *1 0,0
Xsky130_fd_sc_hd__fill_8_120
+ vss
+ vdd
+ vdd
+ sky130_fd_sc_hd__fill_8
* cell instance sky130_fd_sc_hd__fill_8_121 r0 *1 0,0
Xsky130_fd_sc_hd__fill_8_121
+ vss
+ vdd
+ vdd
+ sky130_fd_sc_hd__fill_8
* cell instance sky130_fd_sc_hd__fill_8_122 r0 *1 0,0
Xsky130_fd_sc_hd__fill_8_122
+ vss
+ vdd
+ vdd
+ sky130_fd_sc_hd__fill_8
* cell instance sky130_fd_sc_hd__fill_8_123 r0 *1 0,0
Xsky130_fd_sc_hd__fill_8_123
+ vss
+ vdd
+ vdd
+ sky130_fd_sc_hd__fill_8
* cell instance sky130_fd_sc_hd__fill_8_124 r0 *1 0,0
Xsky130_fd_sc_hd__fill_8_124
+ vss
+ vdd
+ vdd
+ sky130_fd_sc_hd__fill_8
* cell instance sky130_fd_sc_hd__fill_8_125 r0 *1 0,0
Xsky130_fd_sc_hd__fill_8_125
+ vss
+ vdd
+ vdd
+ sky130_fd_sc_hd__fill_8
* cell instance sky130_fd_sc_hd__fill_8_126 r0 *1 0,0
Xsky130_fd_sc_hd__fill_8_126
+ vss
+ vdd
+ vdd
+ sky130_fd_sc_hd__fill_8
* cell instance sky130_fd_sc_hd__fill_8_127 r0 *1 0,0
Xsky130_fd_sc_hd__fill_8_127
+ vss
+ vdd
+ vdd
+ sky130_fd_sc_hd__fill_8
* cell instance sky130_fd_sc_hd__fill_8_128 r0 *1 0,0
Xsky130_fd_sc_hd__fill_8_128
+ vss
+ vdd
+ vdd
+ sky130_fd_sc_hd__fill_8
* cell instance sky130_fd_sc_hd__fill_8_129 r0 *1 0,0
Xsky130_fd_sc_hd__fill_8_129
+ vss
+ vdd
+ vdd
+ sky130_fd_sc_hd__fill_8
* cell instance sky130_fd_sc_hd__fill_8_130 r0 *1 0,0
Xsky130_fd_sc_hd__fill_8_130
+ vss
+ vdd
+ vdd
+ sky130_fd_sc_hd__fill_8
* cell instance sky130_fd_sc_hd__fill_8_131 r0 *1 0,0
Xsky130_fd_sc_hd__fill_8_131
+ vss
+ vdd
+ vdd
+ sky130_fd_sc_hd__fill_8
* cell instance sky130_fd_sc_hd__fill_8_132 r0 *1 0,0
Xsky130_fd_sc_hd__fill_8_132
+ vss
+ vdd
+ vdd
+ sky130_fd_sc_hd__fill_8
* cell instance sky130_fd_sc_hd__fill_8_133 r0 *1 0,0
Xsky130_fd_sc_hd__fill_8_133
+ vss
+ vdd
+ vdd
+ sky130_fd_sc_hd__fill_8
* cell instance sky130_fd_sc_hd__fill_8_134 r0 *1 0,0
Xsky130_fd_sc_hd__fill_8_134
+ vss
+ vdd
+ vdd
+ sky130_fd_sc_hd__fill_8
* cell instance sky130_fd_sc_hd__fill_8_135 r0 *1 0,0
Xsky130_fd_sc_hd__fill_8_135
+ vss
+ vdd
+ vdd
+ sky130_fd_sc_hd__fill_8
* cell instance sky130_fd_sc_hd__fill_8_136 r0 *1 0,0
Xsky130_fd_sc_hd__fill_8_136
+ vss
+ vdd
+ vdd
+ sky130_fd_sc_hd__fill_8
* cell instance sky130_fd_sc_hd__fill_8_137 r0 *1 0,0
Xsky130_fd_sc_hd__fill_8_137
+ vss
+ vdd
+ vdd
+ sky130_fd_sc_hd__fill_8
* cell instance sky130_fd_sc_hd__fill_8_138 r0 *1 0,0
Xsky130_fd_sc_hd__fill_8_138
+ vss
+ vdd
+ vdd
+ sky130_fd_sc_hd__fill_8
* cell instance sky130_fd_sc_hd__fill_8_139 r0 *1 0,0
Xsky130_fd_sc_hd__fill_8_139
+ vss
+ vdd
+ vdd
+ sky130_fd_sc_hd__fill_8
* cell instance sky130_fd_sc_hd__fill_8_140 r0 *1 0,0
Xsky130_fd_sc_hd__fill_8_140
+ vss
+ vdd
+ vdd
+ sky130_fd_sc_hd__fill_8
* cell instance sky130_fd_sc_hd__fill_8_141 r0 *1 0,0
Xsky130_fd_sc_hd__fill_8_141
+ vss
+ vdd
+ vdd
+ sky130_fd_sc_hd__fill_8
* cell instance sky130_fd_sc_hd__fill_8_142 r0 *1 0,0
Xsky130_fd_sc_hd__fill_8_142
+ vss
+ vdd
+ vdd
+ sky130_fd_sc_hd__fill_8
* cell instance sky130_fd_sc_hd__fill_8_143 r0 *1 0,0
Xsky130_fd_sc_hd__fill_8_143
+ vss
+ vdd
+ vdd
+ sky130_fd_sc_hd__fill_8
* cell instance sky130_fd_sc_hd__fill_8_144 r0 *1 0,0
Xsky130_fd_sc_hd__fill_8_144
+ vss
+ vdd
+ vdd
+ sky130_fd_sc_hd__fill_8
* cell instance sky130_fd_sc_hd__fill_8_145 r0 *1 0,0
Xsky130_fd_sc_hd__fill_8_145
+ vss
+ vdd
+ vdd
+ sky130_fd_sc_hd__fill_8
* cell instance sky130_fd_sc_hd__fill_8_146 r0 *1 0,0
Xsky130_fd_sc_hd__fill_8_146
+ vss
+ vdd
+ vdd
+ sky130_fd_sc_hd__fill_8
* cell instance sky130_fd_sc_hd__fill_8_147 r0 *1 0,0
Xsky130_fd_sc_hd__fill_8_147
+ vss
+ vdd
+ vdd
+ sky130_fd_sc_hd__fill_8
* cell instance sky130_fd_sc_hd__fill_8_148 r0 *1 0,0
Xsky130_fd_sc_hd__fill_8_148
+ vss
+ vdd
+ vdd
+ sky130_fd_sc_hd__fill_8
* cell instance sky130_fd_sc_hd__fill_8_149 r0 *1 0,0
Xsky130_fd_sc_hd__fill_8_149
+ vss
+ vdd
+ vdd
+ sky130_fd_sc_hd__fill_8
* cell instance sky130_fd_sc_hd__fill_8_150 r0 *1 0,0
Xsky130_fd_sc_hd__fill_8_150
+ vss
+ vdd
+ vdd
+ sky130_fd_sc_hd__fill_8
* cell instance sky130_fd_sc_hd__fill_8_151 r0 *1 0,0
Xsky130_fd_sc_hd__fill_8_151
+ vss
+ vdd
+ vdd
+ sky130_fd_sc_hd__fill_8
* cell instance sky130_fd_sc_hd__fill_8_152 r0 *1 0,0
Xsky130_fd_sc_hd__fill_8_152
+ vss
+ vdd
+ vdd
+ sky130_fd_sc_hd__fill_8
* cell instance sky130_fd_sc_hd__fill_8_153 r0 *1 0,0
Xsky130_fd_sc_hd__fill_8_153
+ vss
+ vdd
+ vdd
+ sky130_fd_sc_hd__fill_8
* cell instance sky130_fd_sc_hd__fill_8_154 r0 *1 0,0
Xsky130_fd_sc_hd__fill_8_154
+ vss
+ vdd
+ vdd
+ sky130_fd_sc_hd__fill_8
* cell instance sky130_fd_sc_hd__fill_8_155 r0 *1 0,0
Xsky130_fd_sc_hd__fill_8_155
+ vss
+ vdd
+ vdd
+ sky130_fd_sc_hd__fill_8
* cell instance sky130_fd_sc_hd__fill_8_156 r0 *1 0,0
Xsky130_fd_sc_hd__fill_8_156
+ vss
+ vdd
+ vdd
+ sky130_fd_sc_hd__fill_8
* cell instance sky130_fd_sc_hd__fill_8_157 r0 *1 0,0
Xsky130_fd_sc_hd__fill_8_157
+ vss
+ vdd
+ vdd
+ sky130_fd_sc_hd__fill_8
* cell instance sky130_fd_sc_hd__fill_8_158 r0 *1 0,0
Xsky130_fd_sc_hd__fill_8_158
+ vss
+ vdd
+ vdd
+ sky130_fd_sc_hd__fill_8
* cell instance sky130_fd_sc_hd__fill_8_159 r0 *1 0,0
Xsky130_fd_sc_hd__fill_8_159
+ vss
+ vdd
+ vdd
+ sky130_fd_sc_hd__fill_8
* cell instance sky130_fd_sc_hd__fill_8_160 r0 *1 0,0
Xsky130_fd_sc_hd__fill_8_160
+ vss
+ vdd
+ vdd
+ sky130_fd_sc_hd__fill_8
* cell instance sky130_fd_sc_hd__fill_8_161 r0 *1 0,0
Xsky130_fd_sc_hd__fill_8_161
+ vss
+ vdd
+ vdd
+ sky130_fd_sc_hd__fill_8
* cell instance sky130_fd_sc_hd__fill_8_162 r0 *1 0,0
Xsky130_fd_sc_hd__fill_8_162
+ vss
+ vdd
+ vdd
+ sky130_fd_sc_hd__fill_8
* cell instance sky130_fd_sc_hd__fill_8_163 r0 *1 0,0
Xsky130_fd_sc_hd__fill_8_163
+ vss
+ vdd
+ vdd
+ sky130_fd_sc_hd__fill_8
* cell instance sky130_fd_sc_hd__fill_8_164 r0 *1 0,0
Xsky130_fd_sc_hd__fill_8_164
+ vss
+ vdd
+ vdd
+ sky130_fd_sc_hd__fill_8
* cell instance sky130_fd_sc_hd__fill_8_165 r0 *1 0,0
Xsky130_fd_sc_hd__fill_8_165
+ vss
+ vdd
+ vdd
+ sky130_fd_sc_hd__fill_8
* cell instance sky130_fd_sc_hd__fill_8_166 r0 *1 0,0
Xsky130_fd_sc_hd__fill_8_166
+ vss
+ vdd
+ vdd
+ sky130_fd_sc_hd__fill_8
* cell instance sky130_fd_sc_hd__fill_8_167 r0 *1 0,0
Xsky130_fd_sc_hd__fill_8_167
+ vss
+ vdd
+ vdd
+ sky130_fd_sc_hd__fill_8
* cell instance sky130_fd_sc_hd__fill_8_168 r0 *1 0,0
Xsky130_fd_sc_hd__fill_8_168
+ vss
+ vdd
+ vdd
+ sky130_fd_sc_hd__fill_8
* cell instance sky130_fd_sc_hd__fill_8_169 r0 *1 0,0
Xsky130_fd_sc_hd__fill_8_169
+ vss
+ vdd
+ vdd
+ sky130_fd_sc_hd__fill_8
* cell instance sky130_fd_sc_hd__fill_8_170 r0 *1 0,0
Xsky130_fd_sc_hd__fill_8_170
+ vss
+ vdd
+ vdd
+ sky130_fd_sc_hd__fill_8
* cell instance sky130_fd_sc_hd__fill_8_171 r0 *1 0,0
Xsky130_fd_sc_hd__fill_8_171
+ vss
+ vdd
+ vdd
+ sky130_fd_sc_hd__fill_8
* cell instance sky130_fd_sc_hd__fill_8_172 r0 *1 0,0
Xsky130_fd_sc_hd__fill_8_172
+ vss
+ vdd
+ vdd
+ sky130_fd_sc_hd__fill_8
* cell instance sky130_fd_sc_hd__fill_8_173 r0 *1 0,0
Xsky130_fd_sc_hd__fill_8_173
+ vss
+ vdd
+ vdd
+ sky130_fd_sc_hd__fill_8
* cell instance sky130_fd_sc_hd__fill_8_174 r0 *1 0,0
Xsky130_fd_sc_hd__fill_8_174
+ vss
+ vdd
+ vdd
+ sky130_fd_sc_hd__fill_8
* cell instance sky130_fd_sc_hd__fill_8_175 r0 *1 0,0
Xsky130_fd_sc_hd__fill_8_175
+ vss
+ vdd
+ vdd
+ sky130_fd_sc_hd__fill_8
* cell instance sky130_fd_sc_hd__fill_8_176 r0 *1 0,0
Xsky130_fd_sc_hd__fill_8_176
+ vss
+ vdd
+ vdd
+ sky130_fd_sc_hd__fill_8
* cell instance sky130_fd_sc_hd__fill_8_177 r0 *1 0,0
Xsky130_fd_sc_hd__fill_8_177
+ vss
+ vdd
+ vdd
+ sky130_fd_sc_hd__fill_8
* cell instance sky130_fd_sc_hd__fill_8_178 r0 *1 0,0
Xsky130_fd_sc_hd__fill_8_178
+ vss
+ vdd
+ vdd
+ sky130_fd_sc_hd__fill_8
* cell instance sky130_fd_sc_hd__fill_8_179 r0 *1 0,0
Xsky130_fd_sc_hd__fill_8_179
+ vss
+ vdd
+ vdd
+ sky130_fd_sc_hd__fill_8
* cell instance sky130_fd_sc_hd__fill_8_180 r0 *1 0,0
Xsky130_fd_sc_hd__fill_8_180
+ vss
+ vdd
+ vdd
+ sky130_fd_sc_hd__fill_8
* cell instance sky130_fd_sc_hd__fill_8_181 r0 *1 0,0
Xsky130_fd_sc_hd__fill_8_181
+ vss
+ vdd
+ vdd
+ sky130_fd_sc_hd__fill_8
* cell instance sky130_fd_sc_hd__fill_8_182 r0 *1 0,0
Xsky130_fd_sc_hd__fill_8_182
+ vss
+ vdd
+ vdd
+ sky130_fd_sc_hd__fill_8
* cell instance sky130_fd_sc_hd__fill_8_183 r0 *1 0,0
Xsky130_fd_sc_hd__fill_8_183
+ vss
+ vdd
+ vdd
+ sky130_fd_sc_hd__fill_8
* cell instance sky130_fd_sc_hd__fill_8_184 r0 *1 0,0
Xsky130_fd_sc_hd__fill_8_184
+ vss
+ vdd
+ vdd
+ sky130_fd_sc_hd__fill_8
* cell instance sky130_fd_sc_hd__fill_8_185 r0 *1 0,0
Xsky130_fd_sc_hd__fill_8_185
+ vss
+ vdd
+ vdd
+ sky130_fd_sc_hd__fill_8
* cell instance sky130_fd_sc_hd__fill_8_186 r0 *1 0,0
Xsky130_fd_sc_hd__fill_8_186
+ vss
+ vdd
+ vdd
+ sky130_fd_sc_hd__fill_8
* cell instance sky130_fd_sc_hd__fill_8_187 r0 *1 0,0
Xsky130_fd_sc_hd__fill_8_187
+ vss
+ vdd
+ vdd
+ sky130_fd_sc_hd__fill_8
* cell instance sky130_fd_sc_hd__fill_8_188 r0 *1 0,0
Xsky130_fd_sc_hd__fill_8_188
+ vss
+ vdd
+ vdd
+ sky130_fd_sc_hd__fill_8
* cell instance sky130_fd_sc_hd__fill_8_189 r0 *1 0,0
Xsky130_fd_sc_hd__fill_8_189
+ vss
+ vdd
+ vdd
+ sky130_fd_sc_hd__fill_8
* cell instance sky130_fd_sc_hd__fill_8_190 r0 *1 0,0
Xsky130_fd_sc_hd__fill_8_190
+ vss
+ vdd
+ vdd
+ sky130_fd_sc_hd__fill_8
* cell instance sky130_fd_sc_hd__fill_8_191 r0 *1 0,0
Xsky130_fd_sc_hd__fill_8_191
+ vss
+ vdd
+ vdd
+ sky130_fd_sc_hd__fill_8
* cell instance sky130_fd_sc_hd__fill_8_192 r0 *1 0,0
Xsky130_fd_sc_hd__fill_8_192
+ vss
+ vdd
+ vdd
+ sky130_fd_sc_hd__fill_8
* cell instance sky130_fd_sc_hd__fill_8_193 r0 *1 0,0
Xsky130_fd_sc_hd__fill_8_193
+ vss
+ vdd
+ vdd
+ sky130_fd_sc_hd__fill_8
* cell instance sky130_fd_sc_hd__fill_8_194 r0 *1 0,0
Xsky130_fd_sc_hd__fill_8_194
+ vss
+ vdd
+ vdd
+ sky130_fd_sc_hd__fill_8
* cell instance sky130_fd_sc_hd__fill_8_195 r0 *1 0,0
Xsky130_fd_sc_hd__fill_8_195
+ vss
+ vdd
+ vdd
+ sky130_fd_sc_hd__fill_8
* cell instance sky130_fd_sc_hd__fill_8_196 r0 *1 0,0
Xsky130_fd_sc_hd__fill_8_196
+ vss
+ vdd
+ vdd
+ sky130_fd_sc_hd__fill_8
* cell instance sky130_fd_sc_hd__fill_8_197 r0 *1 0,0
Xsky130_fd_sc_hd__fill_8_197
+ vss
+ vdd
+ vdd
+ sky130_fd_sc_hd__fill_8
* cell instance sky130_fd_sc_hd__fill_8_198 r0 *1 0,0
Xsky130_fd_sc_hd__fill_8_198
+ vss
+ vdd
+ vdd
+ sky130_fd_sc_hd__fill_8
* cell instance sky130_fd_sc_hd__fill_8_199 r0 *1 0,0
Xsky130_fd_sc_hd__fill_8_199
+ vss
+ vdd
+ vdd
+ sky130_fd_sc_hd__fill_8
* cell instance sky130_fd_sc_hd__fill_8_200 r0 *1 0,0
Xsky130_fd_sc_hd__fill_8_200
+ vss
+ vdd
+ vdd
+ sky130_fd_sc_hd__fill_8
* cell instance sky130_fd_sc_hd__fill_8_201 r0 *1 0,0
Xsky130_fd_sc_hd__fill_8_201
+ vss
+ vdd
+ vdd
+ sky130_fd_sc_hd__fill_8
* cell instance sky130_fd_sc_hd__fill_8_202 r0 *1 0,0
Xsky130_fd_sc_hd__fill_8_202
+ vss
+ vdd
+ vdd
+ sky130_fd_sc_hd__fill_8
* cell instance sky130_fd_sc_hd__fill_8_203 r0 *1 0,0
Xsky130_fd_sc_hd__fill_8_203
+ vss
+ vdd
+ vdd
+ sky130_fd_sc_hd__fill_8
* cell instance sky130_fd_sc_hd__fill_8_204 r0 *1 0,0
Xsky130_fd_sc_hd__fill_8_204
+ vss
+ vdd
+ vdd
+ sky130_fd_sc_hd__fill_8
* cell instance sky130_fd_sc_hd__fill_8_205 r0 *1 0,0
Xsky130_fd_sc_hd__fill_8_205
+ vss
+ vdd
+ vdd
+ sky130_fd_sc_hd__fill_8
* cell instance sky130_fd_sc_hd__fill_8_206 r0 *1 0,0
Xsky130_fd_sc_hd__fill_8_206
+ vss
+ vdd
+ vdd
+ sky130_fd_sc_hd__fill_8
* cell instance sky130_fd_sc_hd__fill_8_207 r0 *1 0,0
Xsky130_fd_sc_hd__fill_8_207
+ vss
+ vdd
+ vdd
+ sky130_fd_sc_hd__fill_8
* cell instance sky130_fd_sc_hd__fill_8_208 r0 *1 0,0
Xsky130_fd_sc_hd__fill_8_208
+ vss
+ vdd
+ vdd
+ sky130_fd_sc_hd__fill_8
* cell instance sky130_fd_sc_hd__fill_8_209 r0 *1 0,0
Xsky130_fd_sc_hd__fill_8_209
+ vss
+ vdd
+ vdd
+ sky130_fd_sc_hd__fill_8
* cell instance sky130_fd_sc_hd__fill_8_210 r0 *1 0,0
Xsky130_fd_sc_hd__fill_8_210
+ vss
+ vdd
+ vdd
+ sky130_fd_sc_hd__fill_8
* cell instance sky130_fd_sc_hd__fill_8_211 r0 *1 0,0
Xsky130_fd_sc_hd__fill_8_211
+ vss
+ vdd
+ vdd
+ sky130_fd_sc_hd__fill_8
* cell instance sky130_fd_sc_hd__fill_8_212 r0 *1 0,0
Xsky130_fd_sc_hd__fill_8_212
+ vss
+ vdd
+ vdd
+ sky130_fd_sc_hd__fill_8
* cell instance sky130_fd_sc_hd__fill_8_213 r0 *1 0,0
Xsky130_fd_sc_hd__fill_8_213
+ vss
+ vdd
+ vdd
+ sky130_fd_sc_hd__fill_8
* cell instance sky130_fd_sc_hd__fill_8_214 r0 *1 0,0
Xsky130_fd_sc_hd__fill_8_214
+ vss
+ vdd
+ vdd
+ sky130_fd_sc_hd__fill_8
* cell instance sky130_fd_sc_hd__fill_8_215 r0 *1 0,0
Xsky130_fd_sc_hd__fill_8_215
+ vss
+ vdd
+ vdd
+ sky130_fd_sc_hd__fill_8
* cell instance sky130_fd_sc_hd__fill_8_216 r0 *1 0,0
Xsky130_fd_sc_hd__fill_8_216
+ vss
+ vdd
+ vdd
+ sky130_fd_sc_hd__fill_8
* cell instance sky130_fd_sc_hd__fill_8_217 r0 *1 0,0
Xsky130_fd_sc_hd__fill_8_217
+ vss
+ vdd
+ vdd
+ sky130_fd_sc_hd__fill_8
* cell instance sky130_fd_sc_hd__fill_8_218 r0 *1 0,0
Xsky130_fd_sc_hd__fill_8_218
+ vss
+ vdd
+ vdd
+ sky130_fd_sc_hd__fill_8
* cell instance sky130_fd_sc_hd__fill_8_219 r0 *1 0,0
Xsky130_fd_sc_hd__fill_8_219
+ vss
+ vdd
+ vdd
+ sky130_fd_sc_hd__fill_8
* cell instance sky130_fd_sc_hd__fill_8_220 r0 *1 0,0
Xsky130_fd_sc_hd__fill_8_220
+ vss
+ vdd
+ vdd
+ sky130_fd_sc_hd__fill_8
* cell instance sky130_fd_sc_hd__fill_8_221 r0 *1 0,0
Xsky130_fd_sc_hd__fill_8_221
+ vss
+ vdd
+ vdd
+ sky130_fd_sc_hd__fill_8
* cell instance sky130_fd_sc_hd__fill_8_222 r0 *1 0,0
Xsky130_fd_sc_hd__fill_8_222
+ vss
+ vdd
+ vdd
+ sky130_fd_sc_hd__fill_8
* cell instance sky130_fd_sc_hd__fill_8_223 r0 *1 0,0
Xsky130_fd_sc_hd__fill_8_223
+ vss
+ vdd
+ vdd
+ sky130_fd_sc_hd__fill_8
* cell instance sky130_fd_sc_hd__fill_8_224 r0 *1 0,0
Xsky130_fd_sc_hd__fill_8_224
+ vss
+ vdd
+ vdd
+ sky130_fd_sc_hd__fill_8
* cell instance sky130_fd_sc_hd__fill_8_225 r0 *1 0,0
Xsky130_fd_sc_hd__fill_8_225
+ vss
+ vdd
+ vdd
+ sky130_fd_sc_hd__fill_8
* cell instance sky130_fd_sc_hd__fill_8_226 r0 *1 0,0
Xsky130_fd_sc_hd__fill_8_226
+ vss
+ vdd
+ vdd
+ sky130_fd_sc_hd__fill_8
* cell instance sky130_fd_sc_hd__fill_8_227 r0 *1 0,0
Xsky130_fd_sc_hd__fill_8_227
+ vss
+ vdd
+ vdd
+ sky130_fd_sc_hd__fill_8
* cell instance sky130_fd_sc_hd__fill_8_228 r0 *1 0,0
Xsky130_fd_sc_hd__fill_8_228
+ vss
+ vdd
+ vdd
+ sky130_fd_sc_hd__fill_8
* cell instance sky130_fd_sc_hd__fill_8_229 r0 *1 0,0
Xsky130_fd_sc_hd__fill_8_229
+ vss
+ vdd
+ vdd
+ sky130_fd_sc_hd__fill_8
* cell instance sky130_fd_sc_hd__fill_8_230 r0 *1 0,0
Xsky130_fd_sc_hd__fill_8_230
+ vss
+ vdd
+ vdd
+ sky130_fd_sc_hd__fill_8
* cell instance sky130_fd_sc_hd__fill_8_231 r0 *1 0,0
Xsky130_fd_sc_hd__fill_8_231
+ vss
+ vdd
+ vdd
+ sky130_fd_sc_hd__fill_8
* cell instance sky130_fd_sc_hd__fill_8_232 r0 *1 0,0
Xsky130_fd_sc_hd__fill_8_232
+ vss
+ vdd
+ vdd
+ sky130_fd_sc_hd__fill_8
* cell instance sky130_fd_sc_hd__fill_8_233 r0 *1 0,0
Xsky130_fd_sc_hd__fill_8_233
+ vss
+ vdd
+ vdd
+ sky130_fd_sc_hd__fill_8
* cell instance sky130_fd_sc_hd__fill_8_234 r0 *1 0,0
Xsky130_fd_sc_hd__fill_8_234
+ vss
+ vdd
+ vdd
+ sky130_fd_sc_hd__fill_8
* cell instance sky130_fd_sc_hd__fill_8_235 r0 *1 0,0
Xsky130_fd_sc_hd__fill_8_235
+ vss
+ vdd
+ vdd
+ sky130_fd_sc_hd__fill_8
* cell instance sky130_fd_sc_hd__fill_8_236 r0 *1 0,0
Xsky130_fd_sc_hd__fill_8_236
+ vss
+ vdd
+ vdd
+ sky130_fd_sc_hd__fill_8
* cell instance sky130_fd_sc_hd__fill_8_237 r0 *1 0,0
Xsky130_fd_sc_hd__fill_8_237
+ vss
+ vdd
+ vdd
+ sky130_fd_sc_hd__fill_8
* cell instance sky130_fd_sc_hd__fill_8_238 r0 *1 0,0
Xsky130_fd_sc_hd__fill_8_238
+ vss
+ vdd
+ vdd
+ sky130_fd_sc_hd__fill_8
* cell instance sky130_fd_sc_hd__fill_8_239 r0 *1 0,0
Xsky130_fd_sc_hd__fill_8_239
+ vss
+ vdd
+ vdd
+ sky130_fd_sc_hd__fill_8
* cell instance sky130_fd_sc_hd__fill_8_240 r0 *1 0,0
Xsky130_fd_sc_hd__fill_8_240
+ vss
+ vdd
+ vdd
+ sky130_fd_sc_hd__fill_8
* cell instance sky130_fd_sc_hd__fill_8_241 r0 *1 0,0
Xsky130_fd_sc_hd__fill_8_241
+ vss
+ vdd
+ vdd
+ sky130_fd_sc_hd__fill_8
* cell instance sky130_fd_sc_hd__fill_8_242 r0 *1 0,0
Xsky130_fd_sc_hd__fill_8_242
+ vss
+ vdd
+ vdd
+ sky130_fd_sc_hd__fill_8
* cell instance sky130_fd_sc_hd__fill_8_243 r0 *1 0,0
Xsky130_fd_sc_hd__fill_8_243
+ vss
+ vdd
+ vdd
+ sky130_fd_sc_hd__fill_8
* cell instance sky130_fd_sc_hd__fill_8_244 r0 *1 0,0
Xsky130_fd_sc_hd__fill_8_244
+ vss
+ vdd
+ vdd
+ sky130_fd_sc_hd__fill_8
* cell instance sky130_fd_sc_hd__fill_8_245 r0 *1 0,0
Xsky130_fd_sc_hd__fill_8_245
+ vss
+ vdd
+ vdd
+ sky130_fd_sc_hd__fill_8
* cell instance sky130_fd_sc_hd__fill_8_246 r0 *1 0,0
Xsky130_fd_sc_hd__fill_8_246
+ vss
+ vdd
+ vdd
+ sky130_fd_sc_hd__fill_8
* cell instance sky130_fd_sc_hd__fill_8_247 r0 *1 0,0
Xsky130_fd_sc_hd__fill_8_247
+ vss
+ vdd
+ vdd
+ sky130_fd_sc_hd__fill_8
* cell instance sky130_fd_sc_hd__fill_8_248 r0 *1 0,0
Xsky130_fd_sc_hd__fill_8_248
+ vss
+ vdd
+ vdd
+ sky130_fd_sc_hd__fill_8
* cell instance sky130_fd_sc_hd__fill_8_249 r0 *1 0,0
Xsky130_fd_sc_hd__fill_8_249
+ vss
+ vdd
+ vdd
+ sky130_fd_sc_hd__fill_8
* cell instance sky130_fd_sc_hd__fill_8_250 r0 *1 0,0
Xsky130_fd_sc_hd__fill_8_250
+ vss
+ vdd
+ vdd
+ sky130_fd_sc_hd__fill_8
* cell instance sky130_fd_sc_hd__fill_8_251 r0 *1 0,0
Xsky130_fd_sc_hd__fill_8_251
+ vss
+ vdd
+ vdd
+ sky130_fd_sc_hd__fill_8
* cell instance sky130_fd_sc_hd__fill_8_252 r0 *1 0,0
Xsky130_fd_sc_hd__fill_8_252
+ vss
+ vdd
+ vdd
+ sky130_fd_sc_hd__fill_8
* cell instance sky130_fd_sc_hd__fill_8_253 r0 *1 0,0
Xsky130_fd_sc_hd__fill_8_253
+ vss
+ vdd
+ vdd
+ sky130_fd_sc_hd__fill_8
* cell instance sky130_fd_sc_hd__fill_8_254 r0 *1 0,0
Xsky130_fd_sc_hd__fill_8_254
+ vss
+ vdd
+ vdd
+ sky130_fd_sc_hd__fill_8
* cell instance sky130_fd_sc_hd__fill_8_255 r0 *1 0,0
Xsky130_fd_sc_hd__fill_8_255
+ vss
+ vdd
+ vdd
+ sky130_fd_sc_hd__fill_8
* cell instance sky130_fd_sc_hd__fill_8_256 r0 *1 0,0
Xsky130_fd_sc_hd__fill_8_256
+ vss
+ vdd
+ vdd
+ sky130_fd_sc_hd__fill_8
* cell instance sky130_fd_sc_hd__fill_8_257 r0 *1 0,0
Xsky130_fd_sc_hd__fill_8_257
+ vss
+ vdd
+ vdd
+ sky130_fd_sc_hd__fill_8
* cell instance sky130_fd_sc_hd__fill_8_258 r0 *1 0,0
Xsky130_fd_sc_hd__fill_8_258
+ vss
+ vdd
+ vdd
+ sky130_fd_sc_hd__fill_8
* cell instance sky130_fd_sc_hd__fill_8_259 r0 *1 0,0
Xsky130_fd_sc_hd__fill_8_259
+ vss
+ vdd
+ vdd
+ sky130_fd_sc_hd__fill_8
* cell instance sky130_fd_sc_hd__fill_8_260 r0 *1 0,0
Xsky130_fd_sc_hd__fill_8_260
+ vss
+ vdd
+ vdd
+ sky130_fd_sc_hd__fill_8
* cell instance sky130_fd_sc_hd__fill_8_261 r0 *1 0,0
Xsky130_fd_sc_hd__fill_8_261
+ vss
+ vdd
+ vdd
+ sky130_fd_sc_hd__fill_8
* cell instance sky130_fd_sc_hd__fill_8_262 r0 *1 0,0
Xsky130_fd_sc_hd__fill_8_262
+ vss
+ vdd
+ vdd
+ sky130_fd_sc_hd__fill_8
* cell instance sky130_fd_sc_hd__fill_8_263 r0 *1 0,0
Xsky130_fd_sc_hd__fill_8_263
+ vss
+ vdd
+ vdd
+ sky130_fd_sc_hd__fill_8
* cell instance sky130_fd_sc_hd__fill_8_264 r0 *1 0,0
Xsky130_fd_sc_hd__fill_8_264
+ vss
+ vdd
+ vdd
+ sky130_fd_sc_hd__fill_8
* cell instance sky130_fd_sc_hd__fill_8_265 r0 *1 0,0
Xsky130_fd_sc_hd__fill_8_265
+ vss
+ vdd
+ vdd
+ sky130_fd_sc_hd__fill_8
* cell instance sky130_fd_sc_hd__fill_8_266 r0 *1 0,0
Xsky130_fd_sc_hd__fill_8_266
+ vss
+ vdd
+ vdd
+ sky130_fd_sc_hd__fill_8
* cell instance sky130_fd_sc_hd__fill_8_267 r0 *1 0,0
Xsky130_fd_sc_hd__fill_8_267
+ vss
+ vdd
+ vdd
+ sky130_fd_sc_hd__fill_8
* cell instance sky130_fd_sc_hd__fill_8_268 r0 *1 0,0
Xsky130_fd_sc_hd__fill_8_268
+ vss
+ vdd
+ vdd
+ sky130_fd_sc_hd__fill_8
* cell instance sky130_fd_sc_hd__fill_8_269 r0 *1 0,0
Xsky130_fd_sc_hd__fill_8_269
+ vss
+ vdd
+ vdd
+ sky130_fd_sc_hd__fill_8
* cell instance sky130_fd_sc_hd__fill_8_270 r0 *1 0,0
Xsky130_fd_sc_hd__fill_8_270
+ vss
+ vdd
+ vdd
+ sky130_fd_sc_hd__fill_8
* cell instance sky130_fd_sc_hd__fill_8_271 r0 *1 0,0
Xsky130_fd_sc_hd__fill_8_271
+ vss
+ vdd
+ vdd
+ sky130_fd_sc_hd__fill_8
* cell instance sky130_fd_sc_hd__fill_8_272 r0 *1 0,0
Xsky130_fd_sc_hd__fill_8_272
+ vss
+ vdd
+ vdd
+ sky130_fd_sc_hd__fill_8
* cell instance sky130_fd_sc_hd__fill_8_273 r0 *1 0,0
Xsky130_fd_sc_hd__fill_8_273
+ vss
+ vdd
+ vdd
+ sky130_fd_sc_hd__fill_8
* cell instance sky130_fd_sc_hd__fill_8_274 r0 *1 0,0
Xsky130_fd_sc_hd__fill_8_274
+ vss
+ vdd
+ vdd
+ sky130_fd_sc_hd__fill_8
* cell instance sky130_fd_sc_hd__fill_8_275 r0 *1 0,0
Xsky130_fd_sc_hd__fill_8_275
+ vss
+ vdd
+ vdd
+ sky130_fd_sc_hd__fill_8
* cell instance sky130_fd_sc_hd__fill_8_276 r0 *1 0,0
Xsky130_fd_sc_hd__fill_8_276
+ vss
+ vdd
+ vdd
+ sky130_fd_sc_hd__fill_8
* cell instance sky130_fd_sc_hd__fill_8_277 r0 *1 0,0
Xsky130_fd_sc_hd__fill_8_277
+ vss
+ vdd
+ vdd
+ sky130_fd_sc_hd__fill_8
* cell instance sky130_fd_sc_hd__fill_8_278 r0 *1 0,0
Xsky130_fd_sc_hd__fill_8_278
+ vss
+ vdd
+ vdd
+ sky130_fd_sc_hd__fill_8
* cell instance sky130_fd_sc_hd__fill_8_279 r0 *1 0,0
Xsky130_fd_sc_hd__fill_8_279
+ vss
+ vdd
+ vdd
+ sky130_fd_sc_hd__fill_8
* cell instance sky130_fd_sc_hd__fill_8_280 r0 *1 0,0
Xsky130_fd_sc_hd__fill_8_280
+ vss
+ vdd
+ vdd
+ sky130_fd_sc_hd__fill_8
* cell instance sky130_fd_sc_hd__fill_8_281 r0 *1 0,0
Xsky130_fd_sc_hd__fill_8_281
+ vss
+ vdd
+ vdd
+ sky130_fd_sc_hd__fill_8
* cell instance sky130_fd_sc_hd__fill_8_282 r0 *1 0,0
Xsky130_fd_sc_hd__fill_8_282
+ vss
+ vdd
+ vdd
+ sky130_fd_sc_hd__fill_8
* cell instance sky130_fd_sc_hd__fill_8_283 r0 *1 0,0
Xsky130_fd_sc_hd__fill_8_283
+ vss
+ vdd
+ vdd
+ sky130_fd_sc_hd__fill_8
* cell instance sky130_fd_sc_hd__fill_8_284 r0 *1 0,0
Xsky130_fd_sc_hd__fill_8_284
+ vss
+ vdd
+ vdd
+ sky130_fd_sc_hd__fill_8
* cell instance sky130_fd_sc_hd__fill_8_285 r0 *1 0,0
Xsky130_fd_sc_hd__fill_8_285
+ vss
+ vdd
+ vdd
+ sky130_fd_sc_hd__fill_8
* cell instance sky130_fd_sc_hd__fill_8_286 r0 *1 0,0
Xsky130_fd_sc_hd__fill_8_286
+ vss
+ vdd
+ vdd
+ sky130_fd_sc_hd__fill_8
* cell instance sky130_fd_sc_hd__fill_8_287 r0 *1 0,0
Xsky130_fd_sc_hd__fill_8_287
+ vss
+ vdd
+ vdd
+ sky130_fd_sc_hd__fill_8
* cell instance sky130_fd_sc_hd__fill_8_288 r0 *1 0,0
Xsky130_fd_sc_hd__fill_8_288
+ vss
+ vdd
+ vdd
+ sky130_fd_sc_hd__fill_8
* cell instance sky130_fd_sc_hd__fill_8_289 r0 *1 0,0
Xsky130_fd_sc_hd__fill_8_289
+ vss
+ vdd
+ vdd
+ sky130_fd_sc_hd__fill_8
* cell instance sky130_fd_sc_hd__fill_8_290 r0 *1 0,0
Xsky130_fd_sc_hd__fill_8_290
+ vss
+ vdd
+ vdd
+ sky130_fd_sc_hd__fill_8
* cell instance sky130_fd_sc_hd__fill_8_291 r0 *1 0,0
Xsky130_fd_sc_hd__fill_8_291
+ vss
+ vdd
+ vdd
+ sky130_fd_sc_hd__fill_8
* cell instance sky130_fd_sc_hd__fill_8_292 r0 *1 0,0
Xsky130_fd_sc_hd__fill_8_292
+ vss
+ vdd
+ vdd
+ sky130_fd_sc_hd__fill_8
* cell instance sky130_fd_sc_hd__fill_8_293 r0 *1 0,0
Xsky130_fd_sc_hd__fill_8_293
+ vss
+ vdd
+ vdd
+ sky130_fd_sc_hd__fill_8
* cell instance sky130_fd_sc_hd__fill_8_294 r0 *1 0,0
Xsky130_fd_sc_hd__fill_8_294
+ vss
+ vdd
+ vdd
+ sky130_fd_sc_hd__fill_8
* cell instance sky130_fd_sc_hd__fill_8_295 r0 *1 0,0
Xsky130_fd_sc_hd__fill_8_295
+ vss
+ vdd
+ vdd
+ sky130_fd_sc_hd__fill_8
* cell instance sky130_fd_sc_hd__fill_8_296 r0 *1 0,0
Xsky130_fd_sc_hd__fill_8_296
+ vss
+ vdd
+ vdd
+ sky130_fd_sc_hd__fill_8
* cell instance sky130_fd_sc_hd__fill_8_297 r0 *1 0,0
Xsky130_fd_sc_hd__fill_8_297
+ vss
+ vdd
+ vdd
+ sky130_fd_sc_hd__fill_8
* cell instance sky130_fd_sc_hd__fill_8_298 r0 *1 0,0
Xsky130_fd_sc_hd__fill_8_298
+ vss
+ vdd
+ vdd
+ sky130_fd_sc_hd__fill_8
* cell instance sky130_fd_sc_hd__fill_8_299 r0 *1 0,0
Xsky130_fd_sc_hd__fill_8_299
+ vss
+ vdd
+ vdd
+ sky130_fd_sc_hd__fill_8
* cell instance sky130_fd_sc_hd__fill_8_300 r0 *1 0,0
Xsky130_fd_sc_hd__fill_8_300
+ vss
+ vdd
+ vdd
+ sky130_fd_sc_hd__fill_8
* cell instance sky130_fd_sc_hd__fill_8_301 r0 *1 0,0
Xsky130_fd_sc_hd__fill_8_301
+ vss
+ vdd
+ vdd
+ sky130_fd_sc_hd__fill_8
* cell instance sky130_fd_sc_hd__fill_8_302 r0 *1 0,0
Xsky130_fd_sc_hd__fill_8_302
+ vss
+ vdd
+ vdd
+ sky130_fd_sc_hd__fill_8
* cell instance sky130_fd_sc_hd__fill_8_303 r0 *1 0,0
Xsky130_fd_sc_hd__fill_8_303
+ vss
+ vdd
+ vdd
+ sky130_fd_sc_hd__fill_8
* cell instance sky130_fd_sc_hd__fill_8_304 r0 *1 0,0
Xsky130_fd_sc_hd__fill_8_304
+ vss
+ vdd
+ vdd
+ sky130_fd_sc_hd__fill_8
* cell instance sky130_fd_sc_hd__fill_8_305 r0 *1 0,0
Xsky130_fd_sc_hd__fill_8_305
+ vss
+ vdd
+ vdd
+ sky130_fd_sc_hd__fill_8
* cell instance sky130_fd_sc_hd__fill_8_306 r0 *1 0,0
Xsky130_fd_sc_hd__fill_8_306
+ vss
+ vdd
+ vdd
+ sky130_fd_sc_hd__fill_8
* cell instance sky130_fd_sc_hd__fill_8_307 r0 *1 0,0
Xsky130_fd_sc_hd__fill_8_307
+ vss
+ vdd
+ vdd
+ sky130_fd_sc_hd__fill_8
* cell instance sky130_fd_sc_hd__fill_8_308 r0 *1 0,0
Xsky130_fd_sc_hd__fill_8_308
+ vss
+ vdd
+ vdd
+ sky130_fd_sc_hd__fill_8
* cell instance sky130_fd_sc_hd__fill_8_309 r0 *1 0,0
Xsky130_fd_sc_hd__fill_8_309
+ vss
+ vdd
+ vdd
+ sky130_fd_sc_hd__fill_8
* cell instance sky130_fd_sc_hd__fill_8_310 r0 *1 0,0
Xsky130_fd_sc_hd__fill_8_310
+ vss
+ vdd
+ vdd
+ sky130_fd_sc_hd__fill_8
* cell instance sky130_fd_sc_hd__fill_8_311 r0 *1 0,0
Xsky130_fd_sc_hd__fill_8_311
+ vss
+ vdd
+ vdd
+ sky130_fd_sc_hd__fill_8
* cell instance sky130_fd_sc_hd__fill_8_312 r0 *1 0,0
Xsky130_fd_sc_hd__fill_8_312
+ vss
+ vdd
+ vdd
+ sky130_fd_sc_hd__fill_8
* cell instance sky130_fd_sc_hd__fill_8_313 r0 *1 0,0
Xsky130_fd_sc_hd__fill_8_313
+ vss
+ vdd
+ vdd
+ sky130_fd_sc_hd__fill_8
* cell instance sky130_fd_sc_hd__fill_8_314 r0 *1 0,0
Xsky130_fd_sc_hd__fill_8_314
+ vss
+ vdd
+ vdd
+ sky130_fd_sc_hd__fill_8
* cell instance sky130_fd_sc_hd__fill_8_315 r0 *1 0,0
Xsky130_fd_sc_hd__fill_8_315
+ vss
+ vdd
+ vdd
+ sky130_fd_sc_hd__fill_8
* cell instance sky130_fd_sc_hd__fill_8_316 r0 *1 0,0
Xsky130_fd_sc_hd__fill_8_316
+ vss
+ vdd
+ vdd
+ sky130_fd_sc_hd__fill_8
* cell instance sky130_fd_sc_hd__fill_8_317 r0 *1 0,0
Xsky130_fd_sc_hd__fill_8_317
+ vss
+ vdd
+ vdd
+ sky130_fd_sc_hd__fill_8
* cell instance sky130_fd_sc_hd__fill_8_318 r0 *1 0,0
Xsky130_fd_sc_hd__fill_8_318
+ vss
+ vdd
+ vdd
+ sky130_fd_sc_hd__fill_8
* cell instance sky130_fd_sc_hd__fill_8_319 r0 *1 0,0
Xsky130_fd_sc_hd__fill_8_319
+ vss
+ vdd
+ vdd
+ sky130_fd_sc_hd__fill_8
* cell instance sky130_fd_sc_hd__fill_8_320 r0 *1 0,0
Xsky130_fd_sc_hd__fill_8_320
+ vss
+ vdd
+ vdd
+ sky130_fd_sc_hd__fill_8
* cell instance sky130_fd_sc_hd__fill_8_321 r0 *1 0,0
Xsky130_fd_sc_hd__fill_8_321
+ vss
+ vdd
+ vdd
+ sky130_fd_sc_hd__fill_8
* cell instance sky130_fd_sc_hd__fill_8_322 r0 *1 0,0
Xsky130_fd_sc_hd__fill_8_322
+ vss
+ vdd
+ vdd
+ sky130_fd_sc_hd__fill_8
* cell instance sky130_fd_sc_hd__fill_8_323 r0 *1 0,0
Xsky130_fd_sc_hd__fill_8_323
+ vss
+ vdd
+ vdd
+ sky130_fd_sc_hd__fill_8
* cell instance sky130_fd_sc_hd__fill_8_324 r0 *1 0,0
Xsky130_fd_sc_hd__fill_8_324
+ vss
+ vdd
+ vdd
+ sky130_fd_sc_hd__fill_8
* cell instance sky130_fd_sc_hd__fill_8_325 r0 *1 0,0
Xsky130_fd_sc_hd__fill_8_325
+ vss
+ vdd
+ vdd
+ sky130_fd_sc_hd__fill_8
* cell instance sky130_fd_sc_hd__fill_8_326 r0 *1 0,0
Xsky130_fd_sc_hd__fill_8_326
+ vss
+ vdd
+ vdd
+ sky130_fd_sc_hd__fill_8
* cell instance sky130_fd_sc_hd__fill_8_327 r0 *1 0,0
Xsky130_fd_sc_hd__fill_8_327
+ vss
+ vdd
+ vdd
+ sky130_fd_sc_hd__fill_8
* cell instance sky130_fd_sc_hd__fill_8_328 r0 *1 0,0
Xsky130_fd_sc_hd__fill_8_328
+ vss
+ vdd
+ vdd
+ sky130_fd_sc_hd__fill_8
* cell instance sky130_fd_sc_hd__fill_8_329 r0 *1 0,0
Xsky130_fd_sc_hd__fill_8_329
+ vss
+ vdd
+ vdd
+ sky130_fd_sc_hd__fill_8
* cell instance sky130_fd_sc_hd__fill_8_330 r0 *1 0,0
Xsky130_fd_sc_hd__fill_8_330
+ vss
+ vdd
+ vdd
+ sky130_fd_sc_hd__fill_8
* cell instance sky130_fd_sc_hd__fill_8_331 r0 *1 0,0
Xsky130_fd_sc_hd__fill_8_331
+ vss
+ vdd
+ vdd
+ sky130_fd_sc_hd__fill_8
* cell instance sky130_fd_sc_hd__fill_8_332 r0 *1 0,0
Xsky130_fd_sc_hd__fill_8_332
+ vss
+ vdd
+ vdd
+ sky130_fd_sc_hd__fill_8
* cell instance sky130_fd_sc_hd__fill_8_333 r0 *1 0,0
Xsky130_fd_sc_hd__fill_8_333
+ vss
+ vdd
+ vdd
+ sky130_fd_sc_hd__fill_8
* cell instance sky130_fd_sc_hd__fill_8_334 r0 *1 0,0
Xsky130_fd_sc_hd__fill_8_334
+ vss
+ vdd
+ vdd
+ sky130_fd_sc_hd__fill_8
* cell instance sky130_fd_sc_hd__fill_8_335 r0 *1 0,0
Xsky130_fd_sc_hd__fill_8_335
+ vss
+ vdd
+ vdd
+ sky130_fd_sc_hd__fill_8
* cell instance sky130_fd_sc_hd__fill_8_336 r0 *1 0,0
Xsky130_fd_sc_hd__fill_8_336
+ vss
+ vdd
+ vdd
+ sky130_fd_sc_hd__fill_8
* cell instance sky130_fd_sc_hd__fill_8_337 r0 *1 0,0
Xsky130_fd_sc_hd__fill_8_337
+ vss
+ vdd
+ vdd
+ sky130_fd_sc_hd__fill_8
* cell instance sky130_fd_sc_hd__fill_8_338 r0 *1 0,0
Xsky130_fd_sc_hd__fill_8_338
+ vss
+ vdd
+ vdd
+ sky130_fd_sc_hd__fill_8
* cell instance sky130_fd_sc_hd__fill_8_339 r0 *1 0,0
Xsky130_fd_sc_hd__fill_8_339
+ vss
+ vdd
+ vdd
+ sky130_fd_sc_hd__fill_8
* cell instance sky130_fd_sc_hd__fill_8_340 r0 *1 0,0
Xsky130_fd_sc_hd__fill_8_340
+ vss
+ vdd
+ vdd
+ sky130_fd_sc_hd__fill_8
* cell instance sky130_fd_sc_hd__fill_8_341 r0 *1 0,0
Xsky130_fd_sc_hd__fill_8_341
+ vss
+ vdd
+ vdd
+ sky130_fd_sc_hd__fill_8
* cell instance sky130_fd_sc_hd__fill_8_342 r0 *1 0,0
Xsky130_fd_sc_hd__fill_8_342
+ vss
+ vdd
+ vdd
+ sky130_fd_sc_hd__fill_8
* cell instance sky130_fd_sc_hd__fill_8_343 r0 *1 0,0
Xsky130_fd_sc_hd__fill_8_343
+ vss
+ vdd
+ vdd
+ sky130_fd_sc_hd__fill_8
* cell instance sky130_fd_sc_hd__fill_8_344 r0 *1 0,0
Xsky130_fd_sc_hd__fill_8_344
+ vss
+ vdd
+ vdd
+ sky130_fd_sc_hd__fill_8
* cell instance sky130_fd_sc_hd__fill_8_345 r0 *1 0,0
Xsky130_fd_sc_hd__fill_8_345
+ vss
+ vdd
+ vdd
+ sky130_fd_sc_hd__fill_8
* cell instance sky130_fd_sc_hd__fill_8_346 r0 *1 0,0
Xsky130_fd_sc_hd__fill_8_346
+ vss
+ vdd
+ vdd
+ sky130_fd_sc_hd__fill_8
* cell instance sky130_fd_sc_hd__fill_8_347 r0 *1 0,0
Xsky130_fd_sc_hd__fill_8_347
+ vss
+ vdd
+ vdd
+ sky130_fd_sc_hd__fill_8
* cell instance sky130_fd_sc_hd__fill_8_348 r0 *1 0,0
Xsky130_fd_sc_hd__fill_8_348
+ vss
+ vdd
+ vdd
+ sky130_fd_sc_hd__fill_8
* cell instance sky130_fd_sc_hd__fill_8_349 r0 *1 0,0
Xsky130_fd_sc_hd__fill_8_349
+ vss
+ vdd
+ vdd
+ sky130_fd_sc_hd__fill_8
* cell instance sky130_fd_sc_hd__fill_8_350 r0 *1 0,0
Xsky130_fd_sc_hd__fill_8_350
+ vss
+ vdd
+ vdd
+ sky130_fd_sc_hd__fill_8
* cell instance sky130_fd_sc_hd__fill_8_351 r0 *1 0,0
Xsky130_fd_sc_hd__fill_8_351
+ vss
+ vdd
+ vdd
+ sky130_fd_sc_hd__fill_8
* cell instance sky130_fd_sc_hd__fill_8_352 r0 *1 0,0
Xsky130_fd_sc_hd__fill_8_352
+ vss
+ vdd
+ vdd
+ sky130_fd_sc_hd__fill_8
* cell instance sky130_fd_sc_hd__fill_8_353 r0 *1 0,0
Xsky130_fd_sc_hd__fill_8_353
+ vss
+ vdd
+ vdd
+ sky130_fd_sc_hd__fill_8
* cell instance sky130_fd_sc_hd__fill_8_354 r0 *1 0,0
Xsky130_fd_sc_hd__fill_8_354
+ vss
+ vdd
+ vdd
+ sky130_fd_sc_hd__fill_8
* cell instance sky130_fd_sc_hd__fill_8_355 r0 *1 0,0
Xsky130_fd_sc_hd__fill_8_355
+ vss
+ vdd
+ vdd
+ sky130_fd_sc_hd__fill_8
* cell instance sky130_fd_sc_hd__fill_8_356 r0 *1 0,0
Xsky130_fd_sc_hd__fill_8_356
+ vss
+ vdd
+ vdd
+ sky130_fd_sc_hd__fill_8
* cell instance sky130_fd_sc_hd__fill_8_357 r0 *1 0,0
Xsky130_fd_sc_hd__fill_8_357
+ vss
+ vdd
+ vdd
+ sky130_fd_sc_hd__fill_8
* cell instance sky130_fd_sc_hd__fill_8_358 r0 *1 0,0
Xsky130_fd_sc_hd__fill_8_358
+ vss
+ vdd
+ vdd
+ sky130_fd_sc_hd__fill_8
* cell instance sky130_fd_sc_hd__fill_8_359 r0 *1 0,0
Xsky130_fd_sc_hd__fill_8_359
+ vss
+ vdd
+ vdd
+ sky130_fd_sc_hd__fill_8
* cell instance sky130_fd_sc_hd__fill_8_360 r0 *1 0,0
Xsky130_fd_sc_hd__fill_8_360
+ vss
+ vdd
+ vdd
+ sky130_fd_sc_hd__fill_8
* cell instance sky130_fd_sc_hd__fill_8_361 r0 *1 0,0
Xsky130_fd_sc_hd__fill_8_361
+ vss
+ vdd
+ vdd
+ sky130_fd_sc_hd__fill_8
* cell instance sky130_fd_sc_hd__fill_8_362 r0 *1 0,0
Xsky130_fd_sc_hd__fill_8_362
+ vss
+ vdd
+ vdd
+ sky130_fd_sc_hd__fill_8
* cell instance sky130_fd_sc_hd__fill_8_363 r0 *1 0,0
Xsky130_fd_sc_hd__fill_8_363
+ vss
+ vdd
+ vdd
+ sky130_fd_sc_hd__fill_8
* cell instance sky130_fd_sc_hd__fill_8_364 r0 *1 0,0
Xsky130_fd_sc_hd__fill_8_364
+ vss
+ vdd
+ vdd
+ sky130_fd_sc_hd__fill_8
* cell instance sky130_fd_sc_hd__fill_8_365 r0 *1 0,0
Xsky130_fd_sc_hd__fill_8_365
+ vss
+ vdd
+ vdd
+ sky130_fd_sc_hd__fill_8
* cell instance sky130_fd_sc_hd__fill_8_366 r0 *1 0,0
Xsky130_fd_sc_hd__fill_8_366
+ vss
+ vdd
+ vdd
+ sky130_fd_sc_hd__fill_8
* cell instance sky130_fd_sc_hd__fill_8_367 r0 *1 0,0
Xsky130_fd_sc_hd__fill_8_367
+ vss
+ vdd
+ vdd
+ sky130_fd_sc_hd__fill_8
* cell instance sky130_fd_sc_hd__fill_8_368 r0 *1 0,0
Xsky130_fd_sc_hd__fill_8_368
+ vss
+ vdd
+ vdd
+ sky130_fd_sc_hd__fill_8
* cell instance sky130_fd_sc_hd__fill_8_369 r0 *1 0,0
Xsky130_fd_sc_hd__fill_8_369
+ vss
+ vdd
+ vdd
+ sky130_fd_sc_hd__fill_8
* cell instance sky130_fd_sc_hd__fill_8_370 r0 *1 0,0
Xsky130_fd_sc_hd__fill_8_370
+ vss
+ vdd
+ vdd
+ sky130_fd_sc_hd__fill_8
* cell instance sky130_fd_sc_hd__fill_8_371 r0 *1 0,0
Xsky130_fd_sc_hd__fill_8_371
+ vss
+ vdd
+ vdd
+ sky130_fd_sc_hd__fill_8
* cell instance sky130_fd_sc_hd__fill_8_372 r0 *1 0,0
Xsky130_fd_sc_hd__fill_8_372
+ vss
+ vdd
+ vdd
+ sky130_fd_sc_hd__fill_8
* cell instance sky130_fd_sc_hd__fill_8_373 r0 *1 0,0
Xsky130_fd_sc_hd__fill_8_373
+ vss
+ vdd
+ vdd
+ sky130_fd_sc_hd__fill_8
* cell instance sky130_fd_sc_hd__fill_8_374 r0 *1 0,0
Xsky130_fd_sc_hd__fill_8_374
+ vss
+ vdd
+ vdd
+ sky130_fd_sc_hd__fill_8
* cell instance sky130_fd_sc_hd__fill_8_375 r0 *1 0,0
Xsky130_fd_sc_hd__fill_8_375
+ vss
+ vdd
+ vdd
+ sky130_fd_sc_hd__fill_8
* cell instance sky130_fd_sc_hd__fill_8_376 r0 *1 0,0
Xsky130_fd_sc_hd__fill_8_376
+ vss
+ vdd
+ vdd
+ sky130_fd_sc_hd__fill_8
* cell instance sky130_fd_sc_hd__fill_8_377 r0 *1 0,0
Xsky130_fd_sc_hd__fill_8_377
+ vss
+ vdd
+ vdd
+ sky130_fd_sc_hd__fill_8
* cell instance sky130_fd_sc_hd__fill_8_378 r0 *1 0,0
Xsky130_fd_sc_hd__fill_8_378
+ vss
+ vdd
+ vdd
+ sky130_fd_sc_hd__fill_8
* cell instance sky130_fd_sc_hd__fill_8_379 r0 *1 0,0
Xsky130_fd_sc_hd__fill_8_379
+ vss
+ vdd
+ vdd
+ sky130_fd_sc_hd__fill_8
* cell instance sky130_fd_sc_hd__fill_8_380 r0 *1 0,0
Xsky130_fd_sc_hd__fill_8_380
+ vss
+ vdd
+ vdd
+ sky130_fd_sc_hd__fill_8
* cell instance sky130_fd_sc_hd__fill_8_381 r0 *1 0,0
Xsky130_fd_sc_hd__fill_8_381
+ vss
+ vdd
+ vdd
+ sky130_fd_sc_hd__fill_8
* cell instance sky130_fd_sc_hd__fill_8_382 r0 *1 0,0
Xsky130_fd_sc_hd__fill_8_382
+ vss
+ vdd
+ vdd
+ sky130_fd_sc_hd__fill_8
* cell instance sky130_fd_sc_hd__fill_8_383 r0 *1 0,0
Xsky130_fd_sc_hd__fill_8_383
+ vss
+ vdd
+ vdd
+ sky130_fd_sc_hd__fill_8
* cell instance sky130_fd_sc_hd__fill_8_384 r0 *1 0,0
Xsky130_fd_sc_hd__fill_8_384
+ vss
+ vdd
+ vdd
+ sky130_fd_sc_hd__fill_8
* cell instance sky130_fd_sc_hd__fill_8_385 r0 *1 0,0
Xsky130_fd_sc_hd__fill_8_385
+ vss
+ vdd
+ vdd
+ sky130_fd_sc_hd__fill_8
* cell instance sky130_fd_sc_hd__fill_8_386 r0 *1 0,0
Xsky130_fd_sc_hd__fill_8_386
+ vss
+ vdd
+ vdd
+ sky130_fd_sc_hd__fill_8
* cell instance sky130_fd_sc_hd__fill_8_387 r0 *1 0,0
Xsky130_fd_sc_hd__fill_8_387
+ vss
+ vdd
+ vdd
+ sky130_fd_sc_hd__fill_8
* cell instance sky130_fd_sc_hd__fill_8_388 r0 *1 0,0
Xsky130_fd_sc_hd__fill_8_388
+ vss
+ vdd
+ vdd
+ sky130_fd_sc_hd__fill_8
* cell instance sky130_fd_sc_hd__fill_8_389 r0 *1 0,0
Xsky130_fd_sc_hd__fill_8_389
+ vss
+ vdd
+ vdd
+ sky130_fd_sc_hd__fill_8
* cell instance sky130_fd_sc_hd__fill_8_390 r0 *1 0,0
Xsky130_fd_sc_hd__fill_8_390
+ vss
+ vdd
+ vdd
+ sky130_fd_sc_hd__fill_8
* cell instance sky130_fd_sc_hd__fill_8_391 r0 *1 0,0
Xsky130_fd_sc_hd__fill_8_391
+ vss
+ vdd
+ vdd
+ sky130_fd_sc_hd__fill_8
* cell instance sky130_fd_sc_hd__fill_8_392 r0 *1 0,0
Xsky130_fd_sc_hd__fill_8_392
+ vss
+ vdd
+ vdd
+ sky130_fd_sc_hd__fill_8
* cell instance sky130_fd_sc_hd__fill_8_393 r0 *1 0,0
Xsky130_fd_sc_hd__fill_8_393
+ vss
+ vdd
+ vdd
+ sky130_fd_sc_hd__fill_8
* cell instance sky130_fd_sc_hd__fill_8_394 r0 *1 0,0
Xsky130_fd_sc_hd__fill_8_394
+ vss
+ vdd
+ vdd
+ sky130_fd_sc_hd__fill_8
* cell instance sky130_fd_sc_hd__fill_8_395 r0 *1 0,0
Xsky130_fd_sc_hd__fill_8_395
+ vss
+ vdd
+ vdd
+ sky130_fd_sc_hd__fill_8
* cell instance sky130_fd_sc_hd__fill_8_396 r0 *1 0,0
Xsky130_fd_sc_hd__fill_8_396
+ vss
+ vdd
+ vdd
+ sky130_fd_sc_hd__fill_8
* cell instance sky130_fd_sc_hd__fill_8_397 r0 *1 0,0
Xsky130_fd_sc_hd__fill_8_397
+ vss
+ vdd
+ vdd
+ sky130_fd_sc_hd__fill_8
* cell instance sky130_fd_sc_hd__fill_8_398 r0 *1 0,0
Xsky130_fd_sc_hd__fill_8_398
+ vss
+ vdd
+ vdd
+ sky130_fd_sc_hd__fill_8
* cell instance sky130_fd_sc_hd__fill_8_399 r0 *1 0,0
Xsky130_fd_sc_hd__fill_8_399
+ vss
+ vdd
+ vdd
+ sky130_fd_sc_hd__fill_8
* cell instance sky130_fd_sc_hd__fill_8_400 r0 *1 0,0
Xsky130_fd_sc_hd__fill_8_400
+ vss
+ vdd
+ vdd
+ sky130_fd_sc_hd__fill_8
* cell instance sky130_fd_sc_hd__fill_8_401 r0 *1 0,0
Xsky130_fd_sc_hd__fill_8_401
+ vss
+ vdd
+ vdd
+ sky130_fd_sc_hd__fill_8
* cell instance sky130_fd_sc_hd__fill_8_402 r0 *1 0,0
Xsky130_fd_sc_hd__fill_8_402
+ vss
+ vdd
+ vdd
+ sky130_fd_sc_hd__fill_8
* cell instance sky130_fd_sc_hd__fill_8_403 r0 *1 0,0
Xsky130_fd_sc_hd__fill_8_403
+ vss
+ vdd
+ vdd
+ sky130_fd_sc_hd__fill_8
* cell instance sky130_fd_sc_hd__fill_8_404 r0 *1 0,0
Xsky130_fd_sc_hd__fill_8_404
+ vss
+ vdd
+ vdd
+ sky130_fd_sc_hd__fill_8
* cell instance sky130_fd_sc_hd__fill_8_405 r0 *1 0,0
Xsky130_fd_sc_hd__fill_8_405
+ vss
+ vdd
+ vdd
+ sky130_fd_sc_hd__fill_8
* cell instance sky130_fd_sc_hd__fill_8_406 r0 *1 0,0
Xsky130_fd_sc_hd__fill_8_406
+ vss
+ vdd
+ vdd
+ sky130_fd_sc_hd__fill_8
* cell instance sky130_fd_sc_hd__fill_8_407 r0 *1 0,0
Xsky130_fd_sc_hd__fill_8_407
+ vss
+ vdd
+ vdd
+ sky130_fd_sc_hd__fill_8
* cell instance sky130_fd_sc_hd__fill_8_408 r0 *1 0,0
Xsky130_fd_sc_hd__fill_8_408
+ vss
+ vdd
+ vdd
+ sky130_fd_sc_hd__fill_8
* cell instance sky130_fd_sc_hd__fill_8_409 r0 *1 0,0
Xsky130_fd_sc_hd__fill_8_409
+ vss
+ vdd
+ vdd
+ sky130_fd_sc_hd__fill_8
* cell instance sky130_fd_sc_hd__fill_8_410 r0 *1 0,0
Xsky130_fd_sc_hd__fill_8_410
+ vss
+ vdd
+ vdd
+ sky130_fd_sc_hd__fill_8
* cell instance sky130_fd_sc_hd__fill_8_411 r0 *1 0,0
Xsky130_fd_sc_hd__fill_8_411
+ vss
+ vdd
+ vdd
+ sky130_fd_sc_hd__fill_8
* cell instance sky130_fd_sc_hd__fill_8_412 r0 *1 0,0
Xsky130_fd_sc_hd__fill_8_412
+ vss
+ vdd
+ vdd
+ sky130_fd_sc_hd__fill_8
* cell instance sky130_fd_sc_hd__fill_8_413 r0 *1 0,0
Xsky130_fd_sc_hd__fill_8_413
+ vss
+ vdd
+ vdd
+ sky130_fd_sc_hd__fill_8
* cell instance sky130_fd_sc_hd__fill_8_414 r0 *1 0,0
Xsky130_fd_sc_hd__fill_8_414
+ vss
+ vdd
+ vdd
+ sky130_fd_sc_hd__fill_8
* cell instance sky130_fd_sc_hd__fill_8_415 r0 *1 0,0
Xsky130_fd_sc_hd__fill_8_415
+ vss
+ vdd
+ vdd
+ sky130_fd_sc_hd__fill_8
* cell instance sky130_fd_sc_hd__fill_8_416 r0 *1 0,0
Xsky130_fd_sc_hd__fill_8_416
+ vss
+ vdd
+ vdd
+ sky130_fd_sc_hd__fill_8
* cell instance sky130_fd_sc_hd__fill_8_417 r0 *1 0,0
Xsky130_fd_sc_hd__fill_8_417
+ vss
+ vdd
+ vdd
+ sky130_fd_sc_hd__fill_8
* cell instance sky130_fd_sc_hd__fill_8_418 r0 *1 0,0
Xsky130_fd_sc_hd__fill_8_418
+ vss
+ vdd
+ vdd
+ sky130_fd_sc_hd__fill_8
* cell instance sky130_fd_sc_hd__fill_8_419 r0 *1 0,0
Xsky130_fd_sc_hd__fill_8_419
+ vss
+ vdd
+ vdd
+ sky130_fd_sc_hd__fill_8
* cell instance sky130_fd_sc_hd__fill_8_420 r0 *1 0,0
Xsky130_fd_sc_hd__fill_8_420
+ vss
+ vdd
+ vdd
+ sky130_fd_sc_hd__fill_8
* cell instance sky130_fd_sc_hd__fill_8_421 r0 *1 0,0
Xsky130_fd_sc_hd__fill_8_421
+ vss
+ vdd
+ vdd
+ sky130_fd_sc_hd__fill_8
* cell instance sky130_fd_sc_hd__fill_8_422 r0 *1 0,0
Xsky130_fd_sc_hd__fill_8_422
+ vss
+ vdd
+ vdd
+ sky130_fd_sc_hd__fill_8
* cell instance sky130_fd_sc_hd__fill_8_423 r0 *1 0,0
Xsky130_fd_sc_hd__fill_8_423
+ vss
+ vdd
+ vdd
+ sky130_fd_sc_hd__fill_8
* cell instance sky130_fd_sc_hd__fill_8_424 r0 *1 0,0
Xsky130_fd_sc_hd__fill_8_424
+ vss
+ vdd
+ vdd
+ sky130_fd_sc_hd__fill_8
* cell instance sky130_fd_sc_hd__fill_8_425 r0 *1 0,0
Xsky130_fd_sc_hd__fill_8_425
+ vss
+ vdd
+ vdd
+ sky130_fd_sc_hd__fill_8
* cell instance sky130_fd_sc_hd__fill_8_426 r0 *1 0,0
Xsky130_fd_sc_hd__fill_8_426
+ vss
+ vdd
+ vdd
+ sky130_fd_sc_hd__fill_8
* cell instance sky130_fd_sc_hd__fill_8_427 r0 *1 0,0
Xsky130_fd_sc_hd__fill_8_427
+ vss
+ vdd
+ vdd
+ sky130_fd_sc_hd__fill_8
* cell instance sky130_fd_sc_hd__fill_8_428 r0 *1 0,0
Xsky130_fd_sc_hd__fill_8_428
+ vss
+ vdd
+ vdd
+ sky130_fd_sc_hd__fill_8
* cell instance sky130_fd_sc_hd__fill_8_429 r0 *1 0,0
Xsky130_fd_sc_hd__fill_8_429
+ vss
+ vdd
+ vdd
+ sky130_fd_sc_hd__fill_8
* cell instance sky130_fd_sc_hd__fill_8_430 r0 *1 0,0
Xsky130_fd_sc_hd__fill_8_430
+ vss
+ vdd
+ vdd
+ sky130_fd_sc_hd__fill_8
* cell instance sky130_fd_sc_hd__fill_8_431 r0 *1 0,0
Xsky130_fd_sc_hd__fill_8_431
+ vss
+ vdd
+ vdd
+ sky130_fd_sc_hd__fill_8
* cell instance sky130_fd_sc_hd__fill_8_432 r0 *1 0,0
Xsky130_fd_sc_hd__fill_8_432
+ vss
+ vdd
+ vdd
+ sky130_fd_sc_hd__fill_8
* cell instance sky130_fd_sc_hd__fill_8_433 r0 *1 0,0
Xsky130_fd_sc_hd__fill_8_433
+ vss
+ vdd
+ vdd
+ sky130_fd_sc_hd__fill_8
* cell instance sky130_fd_sc_hd__fill_8_434 r0 *1 0,0
Xsky130_fd_sc_hd__fill_8_434
+ vss
+ vdd
+ vdd
+ sky130_fd_sc_hd__fill_8
* cell instance sky130_fd_sc_hd__fill_8_435 r0 *1 0,0
Xsky130_fd_sc_hd__fill_8_435
+ vss
+ vdd
+ vdd
+ sky130_fd_sc_hd__fill_8
* cell instance sky130_fd_sc_hd__fill_8_436 r0 *1 0,0
Xsky130_fd_sc_hd__fill_8_436
+ vss
+ vdd
+ vdd
+ sky130_fd_sc_hd__fill_8
* cell instance sky130_fd_sc_hd__fill_8_437 r0 *1 0,0
Xsky130_fd_sc_hd__fill_8_437
+ vss
+ vdd
+ vdd
+ sky130_fd_sc_hd__fill_8
* cell instance sky130_fd_sc_hd__fill_8_438 r0 *1 0,0
Xsky130_fd_sc_hd__fill_8_438
+ vss
+ vdd
+ vdd
+ sky130_fd_sc_hd__fill_8
* cell instance sky130_fd_sc_hd__fill_8_439 r0 *1 0,0
Xsky130_fd_sc_hd__fill_8_439
+ vss
+ vdd
+ vdd
+ sky130_fd_sc_hd__fill_8
* cell instance sky130_fd_sc_hd__fill_8_440 r0 *1 0,0
Xsky130_fd_sc_hd__fill_8_440
+ vss
+ vdd
+ vdd
+ sky130_fd_sc_hd__fill_8
* cell instance sky130_fd_sc_hd__fill_8_441 r0 *1 0,0
Xsky130_fd_sc_hd__fill_8_441
+ vss
+ vdd
+ vdd
+ sky130_fd_sc_hd__fill_8
* cell instance sky130_fd_sc_hd__fill_8_442 r0 *1 0,0
Xsky130_fd_sc_hd__fill_8_442
+ vss
+ vdd
+ vdd
+ sky130_fd_sc_hd__fill_8
* cell instance sky130_fd_sc_hd__fill_8_443 r0 *1 0,0
Xsky130_fd_sc_hd__fill_8_443
+ vss
+ vdd
+ vdd
+ sky130_fd_sc_hd__fill_8
* cell instance sky130_fd_sc_hd__fill_8_444 r0 *1 0,0
Xsky130_fd_sc_hd__fill_8_444
+ vss
+ vdd
+ vdd
+ sky130_fd_sc_hd__fill_8
* cell instance sky130_fd_sc_hd__fill_8_445 r0 *1 0,0
Xsky130_fd_sc_hd__fill_8_445
+ vss
+ vdd
+ vdd
+ sky130_fd_sc_hd__fill_8
* cell instance sky130_fd_sc_hd__fill_8_446 r0 *1 0,0
Xsky130_fd_sc_hd__fill_8_446
+ vss
+ vdd
+ vdd
+ sky130_fd_sc_hd__fill_8
* cell instance sky130_fd_sc_hd__fill_8_447 r0 *1 0,0
Xsky130_fd_sc_hd__fill_8_447
+ vss
+ vdd
+ vdd
+ sky130_fd_sc_hd__fill_8
* cell instance sky130_fd_sc_hd__fill_8_448 r0 *1 0,0
Xsky130_fd_sc_hd__fill_8_448
+ vss
+ vdd
+ vdd
+ sky130_fd_sc_hd__fill_8
* cell instance sky130_fd_sc_hd__fill_8_449 r0 *1 0,0
Xsky130_fd_sc_hd__fill_8_449
+ vss
+ vdd
+ vdd
+ sky130_fd_sc_hd__fill_8
* cell instance sky130_fd_sc_hd__fill_8_450 r0 *1 0,0
Xsky130_fd_sc_hd__fill_8_450
+ vss
+ vdd
+ vdd
+ sky130_fd_sc_hd__fill_8
* cell instance sky130_fd_sc_hd__fill_8_451 r0 *1 0,0
Xsky130_fd_sc_hd__fill_8_451
+ vss
+ vdd
+ vdd
+ sky130_fd_sc_hd__fill_8
* cell instance sky130_fd_sc_hd__fill_8_452 r0 *1 0,0
Xsky130_fd_sc_hd__fill_8_452
+ vss
+ vdd
+ vdd
+ sky130_fd_sc_hd__fill_8
* cell instance sky130_fd_sc_hd__fill_8_453 r0 *1 0,0
Xsky130_fd_sc_hd__fill_8_453
+ vss
+ vdd
+ vdd
+ sky130_fd_sc_hd__fill_8
* cell instance sky130_fd_sc_hd__fill_8_454 r0 *1 0,0
Xsky130_fd_sc_hd__fill_8_454
+ vss
+ vdd
+ vdd
+ sky130_fd_sc_hd__fill_8
* cell instance sky130_fd_sc_hd__fill_8_455 r0 *1 0,0
Xsky130_fd_sc_hd__fill_8_455
+ vss
+ vdd
+ vdd
+ sky130_fd_sc_hd__fill_8
* cell instance sky130_fd_sc_hd__fill_8_456 r0 *1 0,0
Xsky130_fd_sc_hd__fill_8_456
+ vss
+ vdd
+ vdd
+ sky130_fd_sc_hd__fill_8
* cell instance sky130_fd_sc_hd__fill_8_457 r0 *1 0,0
Xsky130_fd_sc_hd__fill_8_457
+ vss
+ vdd
+ vdd
+ sky130_fd_sc_hd__fill_8
* cell instance sky130_fd_sc_hd__fill_8_458 r0 *1 0,0
Xsky130_fd_sc_hd__fill_8_458
+ vss
+ vdd
+ vdd
+ sky130_fd_sc_hd__fill_8
* cell instance sky130_fd_sc_hd__fill_8_459 r0 *1 0,0
Xsky130_fd_sc_hd__fill_8_459
+ vss
+ vdd
+ vdd
+ sky130_fd_sc_hd__fill_8
* cell instance sky130_fd_sc_hd__fill_8_460 r0 *1 0,0
Xsky130_fd_sc_hd__fill_8_460
+ vss
+ vdd
+ vdd
+ sky130_fd_sc_hd__fill_8
* cell instance sky130_fd_sc_hd__fill_8_461 r0 *1 0,0
Xsky130_fd_sc_hd__fill_8_461
+ vss
+ vdd
+ vdd
+ sky130_fd_sc_hd__fill_8
* cell instance sky130_fd_sc_hd__fill_8_462 r0 *1 0,0
Xsky130_fd_sc_hd__fill_8_462
+ vss
+ vdd
+ vdd
+ sky130_fd_sc_hd__fill_8
* cell instance sky130_fd_sc_hd__fill_8_463 r0 *1 0,0
Xsky130_fd_sc_hd__fill_8_463
+ vss
+ vdd
+ vdd
+ sky130_fd_sc_hd__fill_8
* cell instance sky130_fd_sc_hd__fill_8_464 r0 *1 0,0
Xsky130_fd_sc_hd__fill_8_464
+ vss
+ vdd
+ vdd
+ sky130_fd_sc_hd__fill_8
* cell instance sky130_fd_sc_hd__fill_8_465 r0 *1 0,0
Xsky130_fd_sc_hd__fill_8_465
+ vss
+ vdd
+ vdd
+ sky130_fd_sc_hd__fill_8
* cell instance sky130_fd_sc_hd__fill_8_466 r0 *1 0,0
Xsky130_fd_sc_hd__fill_8_466
+ vss
+ vdd
+ vdd
+ sky130_fd_sc_hd__fill_8
* cell instance sky130_fd_sc_hd__fill_8_467 r0 *1 0,0
Xsky130_fd_sc_hd__fill_8_467
+ vss
+ vdd
+ vdd
+ sky130_fd_sc_hd__fill_8
* cell instance sky130_fd_sc_hd__fill_8_468 r0 *1 0,0
Xsky130_fd_sc_hd__fill_8_468
+ vss
+ vdd
+ vdd
+ sky130_fd_sc_hd__fill_8
* cell instance sky130_fd_sc_hd__fill_8_469 r0 *1 0,0
Xsky130_fd_sc_hd__fill_8_469
+ vss
+ vdd
+ vdd
+ sky130_fd_sc_hd__fill_8
* cell instance sky130_fd_sc_hd__fill_8_470 r0 *1 0,0
Xsky130_fd_sc_hd__fill_8_470
+ vss
+ vdd
+ vdd
+ sky130_fd_sc_hd__fill_8
* cell instance sky130_fd_sc_hd__fill_8_471 r0 *1 0,0
Xsky130_fd_sc_hd__fill_8_471
+ vss
+ vdd
+ vdd
+ sky130_fd_sc_hd__fill_8
* cell instance sky130_fd_sc_hd__fill_8_472 r0 *1 0,0
Xsky130_fd_sc_hd__fill_8_472
+ vss
+ vdd
+ vdd
+ sky130_fd_sc_hd__fill_8
* cell instance sky130_fd_sc_hd__fill_8_473 r0 *1 0,0
Xsky130_fd_sc_hd__fill_8_473
+ vss
+ vdd
+ vdd
+ sky130_fd_sc_hd__fill_8
* cell instance sky130_fd_sc_hd__fill_8_474 r0 *1 0,0
Xsky130_fd_sc_hd__fill_8_474
+ vss
+ vdd
+ vdd
+ sky130_fd_sc_hd__fill_8
* cell instance sky130_fd_sc_hd__fill_8_475 r0 *1 0,0
Xsky130_fd_sc_hd__fill_8_475
+ vss
+ vdd
+ vdd
+ sky130_fd_sc_hd__fill_8
* cell instance sky130_fd_sc_hd__fill_8_476 r0 *1 0,0
Xsky130_fd_sc_hd__fill_8_476
+ vss
+ vdd
+ vdd
+ sky130_fd_sc_hd__fill_8
* cell instance sky130_fd_sc_hd__fill_8_477 r0 *1 0,0
Xsky130_fd_sc_hd__fill_8_477
+ vss
+ vdd
+ vdd
+ sky130_fd_sc_hd__fill_8
* cell instance sky130_fd_sc_hd__fill_8_478 r0 *1 0,0
Xsky130_fd_sc_hd__fill_8_478
+ vss
+ vdd
+ vdd
+ sky130_fd_sc_hd__fill_8
* cell instance sky130_fd_sc_hd__fill_8_479 r0 *1 0,0
Xsky130_fd_sc_hd__fill_8_479
+ vss
+ vdd
+ vdd
+ sky130_fd_sc_hd__fill_8
* cell instance sky130_fd_sc_hd__fill_8_480 r0 *1 0,0
Xsky130_fd_sc_hd__fill_8_480
+ vss
+ vdd
+ vdd
+ sky130_fd_sc_hd__fill_8
* cell instance sky130_fd_sc_hd__fill_8_481 r0 *1 0,0
Xsky130_fd_sc_hd__fill_8_481
+ vss
+ vdd
+ vdd
+ sky130_fd_sc_hd__fill_8
* cell instance sky130_fd_sc_hd__fill_8_482 r0 *1 0,0
Xsky130_fd_sc_hd__fill_8_482
+ vss
+ vdd
+ vdd
+ sky130_fd_sc_hd__fill_8
* cell instance sky130_fd_sc_hd__fill_8_483 r0 *1 0,0
Xsky130_fd_sc_hd__fill_8_483
+ vss
+ vdd
+ vdd
+ sky130_fd_sc_hd__fill_8
* cell instance sky130_fd_sc_hd__fill_8_484 r0 *1 0,0
Xsky130_fd_sc_hd__fill_8_484
+ vss
+ vdd
+ vdd
+ sky130_fd_sc_hd__fill_8
* cell instance sky130_fd_sc_hd__fill_8_485 r0 *1 0,0
Xsky130_fd_sc_hd__fill_8_485
+ vss
+ vdd
+ vdd
+ sky130_fd_sc_hd__fill_8
* cell instance sky130_fd_sc_hd__fill_8_486 r0 *1 0,0
Xsky130_fd_sc_hd__fill_8_486
+ vss
+ vdd
+ vdd
+ sky130_fd_sc_hd__fill_8
* cell instance sky130_fd_sc_hd__fill_8_487 r0 *1 0,0
Xsky130_fd_sc_hd__fill_8_487
+ vss
+ vdd
+ vdd
+ sky130_fd_sc_hd__fill_8
* cell instance sky130_fd_sc_hd__fill_8_488 r0 *1 0,0
Xsky130_fd_sc_hd__fill_8_488
+ vss
+ vdd
+ vdd
+ sky130_fd_sc_hd__fill_8
* cell instance sky130_fd_sc_hd__fill_8_489 r0 *1 0,0
Xsky130_fd_sc_hd__fill_8_489
+ vss
+ vdd
+ vdd
+ sky130_fd_sc_hd__fill_8
* cell instance sky130_fd_sc_hd__fill_8_490 r0 *1 0,0
Xsky130_fd_sc_hd__fill_8_490
+ vss
+ vdd
+ vdd
+ sky130_fd_sc_hd__fill_8
* cell instance sky130_fd_sc_hd__fill_8_491 r0 *1 0,0
Xsky130_fd_sc_hd__fill_8_491
+ vss
+ vdd
+ vdd
+ sky130_fd_sc_hd__fill_8
* cell instance sky130_fd_sc_hd__fill_8_492 r0 *1 0,0
Xsky130_fd_sc_hd__fill_8_492
+ vss
+ vdd
+ vdd
+ sky130_fd_sc_hd__fill_8
* cell instance sky130_fd_sc_hd__fill_8_493 r0 *1 0,0
Xsky130_fd_sc_hd__fill_8_493
+ vss
+ vdd
+ vdd
+ sky130_fd_sc_hd__fill_8
* cell instance sky130_fd_sc_hd__fill_8_494 r0 *1 0,0
Xsky130_fd_sc_hd__fill_8_494
+ vss
+ vdd
+ vdd
+ sky130_fd_sc_hd__fill_8
* cell instance sky130_fd_sc_hd__fill_8_495 r0 *1 0,0
Xsky130_fd_sc_hd__fill_8_495
+ vss
+ vdd
+ vdd
+ sky130_fd_sc_hd__fill_8
* cell instance sky130_fd_sc_hd__fill_8_496 r0 *1 0,0
Xsky130_fd_sc_hd__fill_8_496
+ vss
+ vdd
+ vdd
+ sky130_fd_sc_hd__fill_8
* cell instance sky130_fd_sc_hd__fill_8_497 r0 *1 0,0
Xsky130_fd_sc_hd__fill_8_497
+ vss
+ vdd
+ vdd
+ sky130_fd_sc_hd__fill_8
* cell instance sky130_fd_sc_hd__fill_8_498 r0 *1 0,0
Xsky130_fd_sc_hd__fill_8_498
+ vss
+ vdd
+ vdd
+ sky130_fd_sc_hd__fill_8
* cell instance sky130_fd_sc_hd__fill_8_499 r0 *1 0,0
Xsky130_fd_sc_hd__fill_8_499
+ vss
+ vdd
+ vdd
+ sky130_fd_sc_hd__fill_8
* cell instance sky130_fd_sc_hd__fill_8_500 r0 *1 0,0
Xsky130_fd_sc_hd__fill_8_500
+ vss
+ vdd
+ vdd
+ sky130_fd_sc_hd__fill_8
* cell instance sky130_fd_sc_hd__fill_8_501 r0 *1 0,0
Xsky130_fd_sc_hd__fill_8_501
+ vss
+ vdd
+ vdd
+ sky130_fd_sc_hd__fill_8
* cell instance sky130_fd_sc_hd__fill_8_502 r0 *1 0,0
Xsky130_fd_sc_hd__fill_8_502
+ vss
+ vdd
+ vdd
+ sky130_fd_sc_hd__fill_8
* cell instance sky130_fd_sc_hd__fill_8_503 r0 *1 0,0
Xsky130_fd_sc_hd__fill_8_503
+ vss
+ vdd
+ vdd
+ sky130_fd_sc_hd__fill_8
* cell instance sky130_fd_sc_hd__fill_8_504 r0 *1 0,0
Xsky130_fd_sc_hd__fill_8_504
+ vss
+ vdd
+ vdd
+ sky130_fd_sc_hd__fill_8
* cell instance sky130_fd_sc_hd__fill_8_505 r0 *1 0,0
Xsky130_fd_sc_hd__fill_8_505
+ vss
+ vdd
+ vdd
+ sky130_fd_sc_hd__fill_8
* cell instance sky130_fd_sc_hd__fill_8_506 r0 *1 0,0
Xsky130_fd_sc_hd__fill_8_506
+ vss
+ vdd
+ vdd
+ sky130_fd_sc_hd__fill_8
* cell instance sky130_fd_sc_hd__fill_8_507 r0 *1 0,0
Xsky130_fd_sc_hd__fill_8_507
+ vss
+ vdd
+ vdd
+ sky130_fd_sc_hd__fill_8
* cell instance sky130_fd_sc_hd__fill_8_508 r0 *1 0,0
Xsky130_fd_sc_hd__fill_8_508
+ vss
+ vdd
+ vdd
+ sky130_fd_sc_hd__fill_8
* cell instance sky130_fd_sc_hd__fill_8_509 r0 *1 0,0
Xsky130_fd_sc_hd__fill_8_509
+ vss
+ vdd
+ vdd
+ sky130_fd_sc_hd__fill_8
* cell instance sky130_fd_sc_hd__fill_8_510 r0 *1 0,0
Xsky130_fd_sc_hd__fill_8_510
+ vss
+ vdd
+ vdd
+ sky130_fd_sc_hd__fill_8
* cell instance sky130_fd_sc_hd__fill_8_511 r0 *1 0,0
Xsky130_fd_sc_hd__fill_8_511
+ vss
+ vdd
+ vdd
+ sky130_fd_sc_hd__fill_8
* cell instance sky130_fd_sc_hd__fill_8_512 r0 *1 0,0
Xsky130_fd_sc_hd__fill_8_512
+ vss
+ vdd
+ vdd
+ sky130_fd_sc_hd__fill_8
* cell instance sky130_fd_sc_hd__fill_8_513 r0 *1 0,0
Xsky130_fd_sc_hd__fill_8_513
+ vss
+ vdd
+ vdd
+ sky130_fd_sc_hd__fill_8
* cell instance sky130_fd_sc_hd__fill_8_514 r0 *1 0,0
Xsky130_fd_sc_hd__fill_8_514
+ vss
+ vdd
+ vdd
+ sky130_fd_sc_hd__fill_8
* cell instance sky130_fd_sc_hd__fill_8_515 r0 *1 0,0
Xsky130_fd_sc_hd__fill_8_515
+ vss
+ vdd
+ vdd
+ sky130_fd_sc_hd__fill_8
* cell instance sky130_fd_sc_hd__fill_8_516 r0 *1 0,0
Xsky130_fd_sc_hd__fill_8_516
+ vss
+ vdd
+ vdd
+ sky130_fd_sc_hd__fill_8
* cell instance sky130_fd_sc_hd__fill_8_517 r0 *1 0,0
Xsky130_fd_sc_hd__fill_8_517
+ vss
+ vdd
+ vdd
+ sky130_fd_sc_hd__fill_8
* cell instance sky130_fd_sc_hd__fill_8_518 r0 *1 0,0
Xsky130_fd_sc_hd__fill_8_518
+ vss
+ vdd
+ vdd
+ sky130_fd_sc_hd__fill_8
* cell instance sky130_fd_sc_hd__fill_8_519 r0 *1 0,0
Xsky130_fd_sc_hd__fill_8_519
+ vss
+ vdd
+ vdd
+ sky130_fd_sc_hd__fill_8
* cell instance sky130_fd_sc_hd__fill_8_520 r0 *1 0,0
Xsky130_fd_sc_hd__fill_8_520
+ vss
+ vdd
+ vdd
+ sky130_fd_sc_hd__fill_8
* cell instance sky130_fd_sc_hd__fill_8_521 r0 *1 0,0
Xsky130_fd_sc_hd__fill_8_521
+ vss
+ vdd
+ vdd
+ sky130_fd_sc_hd__fill_8
* cell instance sky130_fd_sc_hd__fill_8_522 r0 *1 0,0
Xsky130_fd_sc_hd__fill_8_522
+ vss
+ vdd
+ vdd
+ sky130_fd_sc_hd__fill_8
* cell instance sky130_fd_sc_hd__fill_8_523 r0 *1 0,0
Xsky130_fd_sc_hd__fill_8_523
+ vss
+ vdd
+ vdd
+ sky130_fd_sc_hd__fill_8
* cell instance sky130_fd_sc_hd__fill_8_524 r0 *1 0,0
Xsky130_fd_sc_hd__fill_8_524
+ vss
+ vdd
+ vdd
+ sky130_fd_sc_hd__fill_8
* cell instance sky130_fd_sc_hd__fill_8_525 r0 *1 0,0
Xsky130_fd_sc_hd__fill_8_525
+ vss
+ vdd
+ vdd
+ sky130_fd_sc_hd__fill_8
* cell instance sky130_fd_sc_hd__fill_8_526 r0 *1 0,0
Xsky130_fd_sc_hd__fill_8_526
+ vss
+ vdd
+ vdd
+ sky130_fd_sc_hd__fill_8
* cell instance sky130_fd_sc_hd__fill_8_527 r0 *1 0,0
Xsky130_fd_sc_hd__fill_8_527
+ vss
+ vdd
+ vdd
+ sky130_fd_sc_hd__fill_8
* cell instance sky130_fd_sc_hd__fill_8_528 r0 *1 0,0
Xsky130_fd_sc_hd__fill_8_528
+ vss
+ vdd
+ vdd
+ sky130_fd_sc_hd__fill_8
* cell instance sky130_fd_sc_hd__fill_8_529 r0 *1 0,0
Xsky130_fd_sc_hd__fill_8_529
+ vss
+ vdd
+ vdd
+ sky130_fd_sc_hd__fill_8
* cell instance sky130_fd_sc_hd__fill_8_530 r0 *1 0,0
Xsky130_fd_sc_hd__fill_8_530
+ vss
+ vdd
+ vdd
+ sky130_fd_sc_hd__fill_8
* cell instance sky130_fd_sc_hd__fill_8_531 r0 *1 0,0
Xsky130_fd_sc_hd__fill_8_531
+ vss
+ vdd
+ vdd
+ sky130_fd_sc_hd__fill_8
* cell instance sky130_fd_sc_hd__fill_8_532 r0 *1 0,0
Xsky130_fd_sc_hd__fill_8_532
+ vss
+ vdd
+ vdd
+ sky130_fd_sc_hd__fill_8
* cell instance sky130_fd_sc_hd__fill_8_533 r0 *1 0,0
Xsky130_fd_sc_hd__fill_8_533
+ vss
+ vdd
+ vdd
+ sky130_fd_sc_hd__fill_8
* cell instance sky130_fd_sc_hd__fill_8_534 r0 *1 0,0
Xsky130_fd_sc_hd__fill_8_534
+ vss
+ vdd
+ vdd
+ sky130_fd_sc_hd__fill_8
* cell instance sky130_fd_sc_hd__fill_8_535 r0 *1 0,0
Xsky130_fd_sc_hd__fill_8_535
+ vss
+ vdd
+ vdd
+ sky130_fd_sc_hd__fill_8
* cell instance sky130_fd_sc_hd__fill_8_536 r0 *1 0,0
Xsky130_fd_sc_hd__fill_8_536
+ vss
+ vdd
+ vdd
+ sky130_fd_sc_hd__fill_8
* cell instance sky130_fd_sc_hd__fill_8_537 r0 *1 0,0
Xsky130_fd_sc_hd__fill_8_537
+ vss
+ vdd
+ vdd
+ sky130_fd_sc_hd__fill_8
* cell instance sky130_fd_sc_hd__fill_8_538 r0 *1 0,0
Xsky130_fd_sc_hd__fill_8_538
+ vss
+ vdd
+ vdd
+ sky130_fd_sc_hd__fill_8
* cell instance sky130_fd_sc_hd__fill_8_539 r0 *1 0,0
Xsky130_fd_sc_hd__fill_8_539
+ vss
+ vdd
+ vdd
+ sky130_fd_sc_hd__fill_8
* cell instance sky130_fd_sc_hd__fill_8_540 r0 *1 0,0
Xsky130_fd_sc_hd__fill_8_540
+ vss
+ vdd
+ vdd
+ sky130_fd_sc_hd__fill_8
* cell instance sky130_fd_sc_hd__fill_8_541 r0 *1 0,0
Xsky130_fd_sc_hd__fill_8_541
+ vss
+ vdd
+ vdd
+ sky130_fd_sc_hd__fill_8
* cell instance sky130_fd_sc_hd__fill_8_542 r0 *1 0,0
Xsky130_fd_sc_hd__fill_8_542
+ vss
+ vdd
+ vdd
+ sky130_fd_sc_hd__fill_8
* cell instance sky130_fd_sc_hd__fill_8_543 r0 *1 0,0
Xsky130_fd_sc_hd__fill_8_543
+ vss
+ vdd
+ vdd
+ sky130_fd_sc_hd__fill_8
* cell instance sky130_fd_sc_hd__fill_8_544 r0 *1 0,0
Xsky130_fd_sc_hd__fill_8_544
+ vss
+ vdd
+ vdd
+ sky130_fd_sc_hd__fill_8
* cell instance sky130_fd_sc_hd__fill_8_545 r0 *1 0,0
Xsky130_fd_sc_hd__fill_8_545
+ vss
+ vdd
+ vdd
+ sky130_fd_sc_hd__fill_8
* cell instance sky130_fd_sc_hd__fill_8_546 r0 *1 0,0
Xsky130_fd_sc_hd__fill_8_546
+ vss
+ vdd
+ vdd
+ sky130_fd_sc_hd__fill_8
* cell instance sky130_fd_sc_hd__fill_8_547 r0 *1 0,0
Xsky130_fd_sc_hd__fill_8_547
+ vss
+ vdd
+ vdd
+ sky130_fd_sc_hd__fill_8
* cell instance sky130_fd_sc_hd__fill_8_548 r0 *1 0,0
Xsky130_fd_sc_hd__fill_8_548
+ vss
+ vdd
+ vdd
+ sky130_fd_sc_hd__fill_8
* cell instance sky130_fd_sc_hd__fill_8_549 r0 *1 0,0
Xsky130_fd_sc_hd__fill_8_549
+ vss
+ vdd
+ vdd
+ sky130_fd_sc_hd__fill_8
* cell instance sky130_fd_sc_hd__fill_8_550 r0 *1 0,0
Xsky130_fd_sc_hd__fill_8_550
+ vss
+ vdd
+ vdd
+ sky130_fd_sc_hd__fill_8
* cell instance sky130_fd_sc_hd__fill_8_551 r0 *1 0,0
Xsky130_fd_sc_hd__fill_8_551
+ vss
+ vdd
+ vdd
+ sky130_fd_sc_hd__fill_8
* cell instance sky130_fd_sc_hd__fill_8_552 r0 *1 0,0
Xsky130_fd_sc_hd__fill_8_552
+ vss
+ vdd
+ vdd
+ sky130_fd_sc_hd__fill_8
* cell instance sky130_fd_sc_hd__fill_8_553 r0 *1 0,0
Xsky130_fd_sc_hd__fill_8_553
+ vss
+ vdd
+ vdd
+ sky130_fd_sc_hd__fill_8
* cell instance sky130_fd_sc_hd__fill_8_554 r0 *1 0,0
Xsky130_fd_sc_hd__fill_8_554
+ vss
+ vdd
+ vdd
+ sky130_fd_sc_hd__fill_8
* cell instance sky130_fd_sc_hd__fill_8_555 r0 *1 0,0
Xsky130_fd_sc_hd__fill_8_555
+ vss
+ vdd
+ vdd
+ sky130_fd_sc_hd__fill_8
* cell instance sky130_fd_sc_hd__fill_8_556 r0 *1 0,0
Xsky130_fd_sc_hd__fill_8_556
+ vss
+ vdd
+ vdd
+ sky130_fd_sc_hd__fill_8
* cell instance sky130_fd_sc_hd__fill_8_557 r0 *1 0,0
Xsky130_fd_sc_hd__fill_8_557
+ vss
+ vdd
+ vdd
+ sky130_fd_sc_hd__fill_8
* cell instance sky130_fd_sc_hd__fill_8_558 r0 *1 0,0
Xsky130_fd_sc_hd__fill_8_558
+ vss
+ vdd
+ vdd
+ sky130_fd_sc_hd__fill_8
* cell instance sky130_fd_sc_hd__fill_8_559 r0 *1 0,0
Xsky130_fd_sc_hd__fill_8_559
+ vss
+ vdd
+ vdd
+ sky130_fd_sc_hd__fill_8
* cell instance sky130_fd_sc_hd__fill_8_560 r0 *1 0,0
Xsky130_fd_sc_hd__fill_8_560
+ vss
+ vdd
+ vdd
+ sky130_fd_sc_hd__fill_8
* cell instance sky130_fd_sc_hd__fill_8_561 r0 *1 0,0
Xsky130_fd_sc_hd__fill_8_561
+ vss
+ vdd
+ vdd
+ sky130_fd_sc_hd__fill_8
* cell instance sky130_fd_sc_hd__fill_8_562 r0 *1 0,0
Xsky130_fd_sc_hd__fill_8_562
+ vss
+ vdd
+ vdd
+ sky130_fd_sc_hd__fill_8
* cell instance sky130_fd_sc_hd__fill_8_563 r0 *1 0,0
Xsky130_fd_sc_hd__fill_8_563
+ vss
+ vdd
+ vdd
+ sky130_fd_sc_hd__fill_8
* cell instance sky130_fd_sc_hd__fill_8_564 r0 *1 0,0
Xsky130_fd_sc_hd__fill_8_564
+ vss
+ vdd
+ vdd
+ sky130_fd_sc_hd__fill_8
* cell instance sky130_fd_sc_hd__fill_8_565 r0 *1 0,0
Xsky130_fd_sc_hd__fill_8_565
+ vss
+ vdd
+ vdd
+ sky130_fd_sc_hd__fill_8
* cell instance sky130_fd_sc_hd__fill_8_566 r0 *1 0,0
Xsky130_fd_sc_hd__fill_8_566
+ vss
+ vdd
+ vdd
+ sky130_fd_sc_hd__fill_8
* cell instance sky130_fd_sc_hd__fill_8_567 r0 *1 0,0
Xsky130_fd_sc_hd__fill_8_567
+ vss
+ vdd
+ vdd
+ sky130_fd_sc_hd__fill_8
* cell instance sky130_fd_sc_hd__fill_8_568 r0 *1 0,0
Xsky130_fd_sc_hd__fill_8_568
+ vss
+ vdd
+ vdd
+ sky130_fd_sc_hd__fill_8
* cell instance sky130_fd_sc_hd__fill_8_569 r0 *1 0,0
Xsky130_fd_sc_hd__fill_8_569
+ vss
+ vdd
+ vdd
+ sky130_fd_sc_hd__fill_8
* cell instance sky130_fd_sc_hd__fill_8_570 r0 *1 0,0
Xsky130_fd_sc_hd__fill_8_570
+ vss
+ vdd
+ vdd
+ sky130_fd_sc_hd__fill_8
* cell instance sky130_fd_sc_hd__fill_8_571 r0 *1 0,0
Xsky130_fd_sc_hd__fill_8_571
+ vss
+ vdd
+ vdd
+ sky130_fd_sc_hd__fill_8
* cell instance sky130_fd_sc_hd__fill_8_572 r0 *1 0,0
Xsky130_fd_sc_hd__fill_8_572
+ vss
+ vdd
+ vdd
+ sky130_fd_sc_hd__fill_8
* cell instance sky130_fd_sc_hd__fill_8_573 r0 *1 0,0
Xsky130_fd_sc_hd__fill_8_573
+ vss
+ vdd
+ vdd
+ sky130_fd_sc_hd__fill_8
* cell instance sky130_fd_sc_hd__fill_8_574 r0 *1 0,0
Xsky130_fd_sc_hd__fill_8_574
+ vss
+ vdd
+ vdd
+ sky130_fd_sc_hd__fill_8
* cell instance sky130_fd_sc_hd__fill_8_575 r0 *1 0,0
Xsky130_fd_sc_hd__fill_8_575
+ vss
+ vdd
+ vdd
+ sky130_fd_sc_hd__fill_8
* cell instance sky130_fd_sc_hd__fill_8_576 r0 *1 0,0
Xsky130_fd_sc_hd__fill_8_576
+ vss
+ vdd
+ vdd
+ sky130_fd_sc_hd__fill_8
* cell instance sky130_fd_sc_hd__fill_8_577 r0 *1 0,0
Xsky130_fd_sc_hd__fill_8_577
+ vss
+ vdd
+ vdd
+ sky130_fd_sc_hd__fill_8
* cell instance sky130_fd_sc_hd__fill_8_578 r0 *1 0,0
Xsky130_fd_sc_hd__fill_8_578
+ vss
+ vdd
+ vdd
+ sky130_fd_sc_hd__fill_8
* cell instance sky130_fd_sc_hd__fill_8_579 r0 *1 0,0
Xsky130_fd_sc_hd__fill_8_579
+ vss
+ vdd
+ vdd
+ sky130_fd_sc_hd__fill_8
* cell instance sky130_fd_sc_hd__fill_8_580 r0 *1 0,0
Xsky130_fd_sc_hd__fill_8_580
+ vss
+ vdd
+ vdd
+ sky130_fd_sc_hd__fill_8
* cell instance sky130_fd_sc_hd__fill_8_581 r0 *1 0,0
Xsky130_fd_sc_hd__fill_8_581
+ vss
+ vdd
+ vdd
+ sky130_fd_sc_hd__fill_8
* cell instance sky130_fd_sc_hd__fill_8_582 r0 *1 0,0
Xsky130_fd_sc_hd__fill_8_582
+ vss
+ vdd
+ vdd
+ sky130_fd_sc_hd__fill_8
* cell instance sky130_fd_sc_hd__fill_8_583 r0 *1 0,0
Xsky130_fd_sc_hd__fill_8_583
+ vss
+ vdd
+ vdd
+ sky130_fd_sc_hd__fill_8
* cell instance sky130_fd_sc_hd__fill_8_584 r0 *1 0,0
Xsky130_fd_sc_hd__fill_8_584
+ vss
+ vdd
+ vdd
+ sky130_fd_sc_hd__fill_8
* cell instance sky130_fd_sc_hd__fill_8_585 r0 *1 0,0
Xsky130_fd_sc_hd__fill_8_585
+ vss
+ vdd
+ vdd
+ sky130_fd_sc_hd__fill_8
* cell instance sky130_fd_sc_hd__fill_8_586 r0 *1 0,0
Xsky130_fd_sc_hd__fill_8_586
+ vss
+ vdd
+ vdd
+ sky130_fd_sc_hd__fill_8
* cell instance sky130_fd_sc_hd__fill_8_587 r0 *1 0,0
Xsky130_fd_sc_hd__fill_8_587
+ vss
+ vdd
+ vdd
+ sky130_fd_sc_hd__fill_8
* cell instance sky130_fd_sc_hd__fill_8_588 r0 *1 0,0
Xsky130_fd_sc_hd__fill_8_588
+ vss
+ vdd
+ vdd
+ sky130_fd_sc_hd__fill_8
* cell instance sky130_fd_sc_hd__fill_8_589 r0 *1 0,0
Xsky130_fd_sc_hd__fill_8_589
+ vss
+ vdd
+ vdd
+ sky130_fd_sc_hd__fill_8
* cell instance sky130_fd_sc_hd__fill_8_590 r0 *1 0,0
Xsky130_fd_sc_hd__fill_8_590
+ vss
+ vdd
+ vdd
+ sky130_fd_sc_hd__fill_8
* cell instance sky130_fd_sc_hd__fill_8_591 r0 *1 0,0
Xsky130_fd_sc_hd__fill_8_591
+ vss
+ vdd
+ vdd
+ sky130_fd_sc_hd__fill_8
* cell instance sky130_fd_sc_hd__fill_8_592 r0 *1 0,0
Xsky130_fd_sc_hd__fill_8_592
+ vss
+ vdd
+ vdd
+ sky130_fd_sc_hd__fill_8
* cell instance sky130_fd_sc_hd__fill_8_593 r0 *1 0,0
Xsky130_fd_sc_hd__fill_8_593
+ vss
+ vdd
+ vdd
+ sky130_fd_sc_hd__fill_8
* cell instance sky130_fd_sc_hd__fill_8_594 r0 *1 0,0
Xsky130_fd_sc_hd__fill_8_594
+ vss
+ vdd
+ vdd
+ sky130_fd_sc_hd__fill_8
* cell instance sky130_fd_sc_hd__fill_8_595 r0 *1 0,0
Xsky130_fd_sc_hd__fill_8_595
+ vss
+ vdd
+ vdd
+ sky130_fd_sc_hd__fill_8
* cell instance sky130_fd_sc_hd__fill_8_596 r0 *1 0,0
Xsky130_fd_sc_hd__fill_8_596
+ vss
+ vdd
+ vdd
+ sky130_fd_sc_hd__fill_8
* cell instance sky130_fd_sc_hd__fill_8_597 r0 *1 0,0
Xsky130_fd_sc_hd__fill_8_597
+ vss
+ vdd
+ vdd
+ sky130_fd_sc_hd__fill_8
* cell instance sky130_fd_sc_hd__fill_8_598 r0 *1 0,0
Xsky130_fd_sc_hd__fill_8_598
+ vss
+ vdd
+ vdd
+ sky130_fd_sc_hd__fill_8
* cell instance sky130_fd_sc_hd__fill_8_599 r0 *1 0,0
Xsky130_fd_sc_hd__fill_8_599
+ vss
+ vdd
+ vdd
+ sky130_fd_sc_hd__fill_8
* cell instance sky130_fd_sc_hd__fill_8_600 r0 *1 0,0
Xsky130_fd_sc_hd__fill_8_600
+ vss
+ vdd
+ vdd
+ sky130_fd_sc_hd__fill_8
* cell instance sky130_fd_sc_hd__fill_8_601 r0 *1 0,0
Xsky130_fd_sc_hd__fill_8_601
+ vss
+ vdd
+ vdd
+ sky130_fd_sc_hd__fill_8
* cell instance sky130_fd_sc_hd__fill_8_602 r0 *1 0,0
Xsky130_fd_sc_hd__fill_8_602
+ vss
+ vdd
+ vdd
+ sky130_fd_sc_hd__fill_8
* cell instance sky130_fd_sc_hd__fill_8_603 r0 *1 0,0
Xsky130_fd_sc_hd__fill_8_603
+ vss
+ vdd
+ vdd
+ sky130_fd_sc_hd__fill_8
* cell instance sky130_fd_sc_hd__fill_8_604 r0 *1 0,0
Xsky130_fd_sc_hd__fill_8_604
+ vss
+ vdd
+ vdd
+ sky130_fd_sc_hd__fill_8
* cell instance sky130_fd_sc_hd__fill_8_605 r0 *1 0,0
Xsky130_fd_sc_hd__fill_8_605
+ vss
+ vdd
+ vdd
+ sky130_fd_sc_hd__fill_8
* cell instance sky130_fd_sc_hd__fill_8_606 r0 *1 0,0
Xsky130_fd_sc_hd__fill_8_606
+ vss
+ vdd
+ vdd
+ sky130_fd_sc_hd__fill_8
* cell instance sky130_fd_sc_hd__fill_8_607 r0 *1 0,0
Xsky130_fd_sc_hd__fill_8_607
+ vss
+ vdd
+ vdd
+ sky130_fd_sc_hd__fill_8
* cell instance sky130_fd_sc_hd__fill_8_608 r0 *1 0,0
Xsky130_fd_sc_hd__fill_8_608
+ vss
+ vdd
+ vdd
+ sky130_fd_sc_hd__fill_8
* cell instance sky130_fd_sc_hd__fill_8_609 r0 *1 0,0
Xsky130_fd_sc_hd__fill_8_609
+ vss
+ vdd
+ vdd
+ sky130_fd_sc_hd__fill_8
* cell instance sky130_fd_sc_hd__fill_8_610 r0 *1 0,0
Xsky130_fd_sc_hd__fill_8_610
+ vss
+ vdd
+ vdd
+ sky130_fd_sc_hd__fill_8
* cell instance sky130_fd_sc_hd__fill_8_611 r0 *1 0,0
Xsky130_fd_sc_hd__fill_8_611
+ vss
+ vdd
+ vdd
+ sky130_fd_sc_hd__fill_8
* cell instance sky130_fd_sc_hd__fill_8_612 r0 *1 0,0
Xsky130_fd_sc_hd__fill_8_612
+ vss
+ vdd
+ vdd
+ sky130_fd_sc_hd__fill_8
* cell instance sky130_fd_sc_hd__fill_8_613 r0 *1 0,0
Xsky130_fd_sc_hd__fill_8_613
+ vss
+ vdd
+ vdd
+ sky130_fd_sc_hd__fill_8
* cell instance sky130_fd_sc_hd__fill_8_614 r0 *1 0,0
Xsky130_fd_sc_hd__fill_8_614
+ vss
+ vdd
+ vdd
+ sky130_fd_sc_hd__fill_8
* cell instance sky130_fd_sc_hd__fill_8_615 r0 *1 0,0
Xsky130_fd_sc_hd__fill_8_615
+ vss
+ vdd
+ vdd
+ sky130_fd_sc_hd__fill_8
* cell instance sky130_fd_sc_hd__fill_8_616 r0 *1 0,0
Xsky130_fd_sc_hd__fill_8_616
+ vss
+ vdd
+ vdd
+ sky130_fd_sc_hd__fill_8
* cell instance sky130_fd_sc_hd__fill_8_617 r0 *1 0,0
Xsky130_fd_sc_hd__fill_8_617
+ vss
+ vdd
+ vdd
+ sky130_fd_sc_hd__fill_8
* cell instance sky130_fd_sc_hd__fill_8_618 r0 *1 0,0
Xsky130_fd_sc_hd__fill_8_618
+ vss
+ vdd
+ vdd
+ sky130_fd_sc_hd__fill_8
* cell instance sky130_fd_sc_hd__fill_8_619 r0 *1 0,0
Xsky130_fd_sc_hd__fill_8_619
+ vss
+ vdd
+ vdd
+ sky130_fd_sc_hd__fill_8
* cell instance sky130_fd_sc_hd__fill_8_620 r0 *1 0,0
Xsky130_fd_sc_hd__fill_8_620
+ vss
+ vdd
+ vdd
+ sky130_fd_sc_hd__fill_8
* cell instance sky130_fd_sc_hd__fill_8_621 r0 *1 0,0
Xsky130_fd_sc_hd__fill_8_621
+ vss
+ vdd
+ vdd
+ sky130_fd_sc_hd__fill_8
* cell instance sky130_fd_sc_hd__fill_8_622 r0 *1 0,0
Xsky130_fd_sc_hd__fill_8_622
+ vss
+ vdd
+ vdd
+ sky130_fd_sc_hd__fill_8
* cell instance sky130_fd_sc_hd__fill_8_623 r0 *1 0,0
Xsky130_fd_sc_hd__fill_8_623
+ vss
+ vdd
+ vdd
+ sky130_fd_sc_hd__fill_8
* cell instance sky130_fd_sc_hd__fill_8_624 r0 *1 0,0
Xsky130_fd_sc_hd__fill_8_624
+ vss
+ vdd
+ vdd
+ sky130_fd_sc_hd__fill_8
* cell instance sky130_fd_sc_hd__fill_8_625 r0 *1 0,0
Xsky130_fd_sc_hd__fill_8_625
+ vss
+ vdd
+ vdd
+ sky130_fd_sc_hd__fill_8
* cell instance sky130_fd_sc_hd__fill_8_626 r0 *1 0,0
Xsky130_fd_sc_hd__fill_8_626
+ vss
+ vdd
+ vdd
+ sky130_fd_sc_hd__fill_8
* cell instance sky130_fd_sc_hd__fill_8_627 r0 *1 0,0
Xsky130_fd_sc_hd__fill_8_627
+ vss
+ vdd
+ vdd
+ sky130_fd_sc_hd__fill_8
* cell instance sky130_fd_sc_hd__fill_8_628 r0 *1 0,0
Xsky130_fd_sc_hd__fill_8_628
+ vss
+ vdd
+ vdd
+ sky130_fd_sc_hd__fill_8
* cell instance sky130_fd_sc_hd__fill_8_629 r0 *1 0,0
Xsky130_fd_sc_hd__fill_8_629
+ vss
+ vdd
+ vdd
+ sky130_fd_sc_hd__fill_8
* cell instance sky130_fd_sc_hd__fill_8_630 r0 *1 0,0
Xsky130_fd_sc_hd__fill_8_630
+ vss
+ vdd
+ vdd
+ sky130_fd_sc_hd__fill_8
* cell instance sky130_fd_sc_hd__fill_8_631 r0 *1 0,0
Xsky130_fd_sc_hd__fill_8_631
+ vss
+ vdd
+ vdd
+ sky130_fd_sc_hd__fill_8
* cell instance sky130_fd_sc_hd__fill_8_632 r0 *1 0,0
Xsky130_fd_sc_hd__fill_8_632
+ vss
+ vdd
+ vdd
+ sky130_fd_sc_hd__fill_8
* cell instance sky130_fd_sc_hd__fill_8_633 r0 *1 0,0
Xsky130_fd_sc_hd__fill_8_633
+ vss
+ vdd
+ vdd
+ sky130_fd_sc_hd__fill_8
* cell instance sky130_fd_sc_hd__fill_8_634 r0 *1 0,0
Xsky130_fd_sc_hd__fill_8_634
+ vss
+ vdd
+ vdd
+ sky130_fd_sc_hd__fill_8
* cell instance sky130_fd_sc_hd__fill_8_635 r0 *1 0,0
Xsky130_fd_sc_hd__fill_8_635
+ vss
+ vdd
+ vdd
+ sky130_fd_sc_hd__fill_8
* cell instance sky130_fd_sc_hd__fill_8_636 r0 *1 0,0
Xsky130_fd_sc_hd__fill_8_636
+ vss
+ vdd
+ vdd
+ sky130_fd_sc_hd__fill_8
* cell instance sky130_fd_sc_hd__fill_8_637 r0 *1 0,0
Xsky130_fd_sc_hd__fill_8_637
+ vss
+ vdd
+ vdd
+ sky130_fd_sc_hd__fill_8
* cell instance sky130_fd_sc_hd__fill_8_638 r0 *1 0,0
Xsky130_fd_sc_hd__fill_8_638
+ vss
+ vdd
+ vdd
+ sky130_fd_sc_hd__fill_8
* cell instance sky130_fd_sc_hd__fill_8_639 r0 *1 0,0
Xsky130_fd_sc_hd__fill_8_639
+ vss
+ vdd
+ vdd
+ sky130_fd_sc_hd__fill_8
* cell instance sky130_fd_sc_hd__fill_8_640 r0 *1 0,0
Xsky130_fd_sc_hd__fill_8_640
+ vss
+ vdd
+ vdd
+ sky130_fd_sc_hd__fill_8
* cell instance sky130_fd_sc_hd__fill_8_641 r0 *1 0,0
Xsky130_fd_sc_hd__fill_8_641
+ vss
+ vdd
+ vdd
+ sky130_fd_sc_hd__fill_8
* cell instance sky130_fd_sc_hd__fill_8_642 r0 *1 0,0
Xsky130_fd_sc_hd__fill_8_642
+ vss
+ vdd
+ vdd
+ sky130_fd_sc_hd__fill_8
* cell instance sky130_fd_sc_hd__fill_8_643 r0 *1 0,0
Xsky130_fd_sc_hd__fill_8_643
+ vss
+ vdd
+ vdd
+ sky130_fd_sc_hd__fill_8
* cell instance sky130_fd_sc_hd__fill_8_644 r0 *1 0,0
Xsky130_fd_sc_hd__fill_8_644
+ vss
+ vdd
+ vdd
+ sky130_fd_sc_hd__fill_8
* cell instance sky130_fd_sc_hd__fill_8_645 r0 *1 0,0
Xsky130_fd_sc_hd__fill_8_645
+ vss
+ vdd
+ vdd
+ sky130_fd_sc_hd__fill_8
* cell instance sky130_fd_sc_hd__fill_8_646 r0 *1 0,0
Xsky130_fd_sc_hd__fill_8_646
+ vss
+ vdd
+ vdd
+ sky130_fd_sc_hd__fill_8
* cell instance sky130_fd_sc_hd__fill_8_647 r0 *1 0,0
Xsky130_fd_sc_hd__fill_8_647
+ vss
+ vdd
+ vdd
+ sky130_fd_sc_hd__fill_8
* cell instance sky130_fd_sc_hd__fill_8_648 r0 *1 0,0
Xsky130_fd_sc_hd__fill_8_648
+ vss
+ vdd
+ vdd
+ sky130_fd_sc_hd__fill_8
* cell instance sky130_fd_sc_hd__fill_8_649 r0 *1 0,0
Xsky130_fd_sc_hd__fill_8_649
+ vss
+ vdd
+ vdd
+ sky130_fd_sc_hd__fill_8
* cell instance sky130_fd_sc_hd__fill_8_650 r0 *1 0,0
Xsky130_fd_sc_hd__fill_8_650
+ vss
+ vdd
+ vdd
+ sky130_fd_sc_hd__fill_8
* cell instance sky130_fd_sc_hd__fill_8_651 r0 *1 0,0
Xsky130_fd_sc_hd__fill_8_651
+ vss
+ vdd
+ vdd
+ sky130_fd_sc_hd__fill_8
* cell instance sky130_fd_sc_hd__fill_8_652 r0 *1 0,0
Xsky130_fd_sc_hd__fill_8_652
+ vss
+ vdd
+ vdd
+ sky130_fd_sc_hd__fill_8
* cell instance sky130_fd_sc_hd__fill_8_653 r0 *1 0,0
Xsky130_fd_sc_hd__fill_8_653
+ vss
+ vdd
+ vdd
+ sky130_fd_sc_hd__fill_8
* cell instance sky130_fd_sc_hd__fill_8_654 r0 *1 0,0
Xsky130_fd_sc_hd__fill_8_654
+ vss
+ vdd
+ vdd
+ sky130_fd_sc_hd__fill_8
* cell instance sky130_fd_sc_hd__fill_8_655 r0 *1 0,0
Xsky130_fd_sc_hd__fill_8_655
+ vss
+ vdd
+ vdd
+ sky130_fd_sc_hd__fill_8
* cell instance sky130_fd_sc_hd__fill_8_656 r0 *1 0,0
Xsky130_fd_sc_hd__fill_8_656
+ vss
+ vdd
+ vdd
+ sky130_fd_sc_hd__fill_8
* cell instance sky130_fd_sc_hd__fill_8_657 r0 *1 0,0
Xsky130_fd_sc_hd__fill_8_657
+ vss
+ vdd
+ vdd
+ sky130_fd_sc_hd__fill_8
* cell instance sky130_fd_sc_hd__fill_8_658 r0 *1 0,0
Xsky130_fd_sc_hd__fill_8_658
+ vss
+ vdd
+ vdd
+ sky130_fd_sc_hd__fill_8
* cell instance sky130_fd_sc_hd__fill_8_659 r0 *1 0,0
Xsky130_fd_sc_hd__fill_8_659
+ vss
+ vdd
+ vdd
+ sky130_fd_sc_hd__fill_8
* cell instance sky130_fd_sc_hd__fill_8_660 r0 *1 0,0
Xsky130_fd_sc_hd__fill_8_660
+ vss
+ vdd
+ vdd
+ sky130_fd_sc_hd__fill_8
* cell instance sky130_fd_sc_hd__fill_8_661 r0 *1 0,0
Xsky130_fd_sc_hd__fill_8_661
+ vss
+ vdd
+ vdd
+ sky130_fd_sc_hd__fill_8
* cell instance sky130_fd_sc_hd__fill_8_662 r0 *1 0,0
Xsky130_fd_sc_hd__fill_8_662
+ vss
+ vdd
+ vdd
+ sky130_fd_sc_hd__fill_8
* cell instance sky130_fd_sc_hd__fill_8_663 r0 *1 0,0
Xsky130_fd_sc_hd__fill_8_663
+ vss
+ vdd
+ vdd
+ sky130_fd_sc_hd__fill_8
* cell instance sky130_fd_sc_hd__fill_8_664 r0 *1 0,0
Xsky130_fd_sc_hd__fill_8_664
+ vss
+ vdd
+ vdd
+ sky130_fd_sc_hd__fill_8
* cell instance sky130_fd_sc_hd__fill_8_665 r0 *1 0,0
Xsky130_fd_sc_hd__fill_8_665
+ vss
+ vdd
+ vdd
+ sky130_fd_sc_hd__fill_8
* cell instance sky130_fd_sc_hd__fill_8_666 r0 *1 0,0
Xsky130_fd_sc_hd__fill_8_666
+ vss
+ vdd
+ vdd
+ sky130_fd_sc_hd__fill_8
* cell instance sky130_fd_sc_hd__fill_8_667 r0 *1 0,0
Xsky130_fd_sc_hd__fill_8_667
+ vss
+ vdd
+ vdd
+ sky130_fd_sc_hd__fill_8
* cell instance sky130_fd_sc_hd__fill_8_668 r0 *1 0,0
Xsky130_fd_sc_hd__fill_8_668
+ vss
+ vdd
+ vdd
+ sky130_fd_sc_hd__fill_8
* cell instance sky130_fd_sc_hd__fill_8_669 r0 *1 0,0
Xsky130_fd_sc_hd__fill_8_669
+ vss
+ vdd
+ vdd
+ sky130_fd_sc_hd__fill_8
* cell instance sky130_fd_sc_hd__fill_8_670 r0 *1 0,0
Xsky130_fd_sc_hd__fill_8_670
+ vss
+ vdd
+ vdd
+ sky130_fd_sc_hd__fill_8
* cell instance sky130_fd_sc_hd__fill_8_671 r0 *1 0,0
Xsky130_fd_sc_hd__fill_8_671
+ vss
+ vdd
+ vdd
+ sky130_fd_sc_hd__fill_8
* cell instance sky130_fd_sc_hd__fill_8_672 r0 *1 0,0
Xsky130_fd_sc_hd__fill_8_672
+ vss
+ vdd
+ vdd
+ sky130_fd_sc_hd__fill_8
* cell instance sky130_fd_sc_hd__fill_8_673 r0 *1 0,0
Xsky130_fd_sc_hd__fill_8_673
+ vss
+ vdd
+ vdd
+ sky130_fd_sc_hd__fill_8
* cell instance sky130_fd_sc_hd__fill_8_674 r0 *1 0,0
Xsky130_fd_sc_hd__fill_8_674
+ vss
+ vdd
+ vdd
+ sky130_fd_sc_hd__fill_8
* cell instance sky130_fd_sc_hd__fill_8_675 r0 *1 0,0
Xsky130_fd_sc_hd__fill_8_675
+ vss
+ vdd
+ vdd
+ sky130_fd_sc_hd__fill_8
* cell instance sky130_fd_sc_hd__fill_8_676 r0 *1 0,0
Xsky130_fd_sc_hd__fill_8_676
+ vss
+ vdd
+ vdd
+ sky130_fd_sc_hd__fill_8
* cell instance sky130_fd_sc_hd__fill_8_677 r0 *1 0,0
Xsky130_fd_sc_hd__fill_8_677
+ vss
+ vdd
+ vdd
+ sky130_fd_sc_hd__fill_8
* cell instance sky130_fd_sc_hd__fill_8_678 r0 *1 0,0
Xsky130_fd_sc_hd__fill_8_678
+ vss
+ vdd
+ vdd
+ sky130_fd_sc_hd__fill_8
* cell instance sky130_fd_sc_hd__fill_8_679 r0 *1 0,0
Xsky130_fd_sc_hd__fill_8_679
+ vss
+ vdd
+ vdd
+ sky130_fd_sc_hd__fill_8
* cell instance sky130_fd_sc_hd__fill_8_680 r0 *1 0,0
Xsky130_fd_sc_hd__fill_8_680
+ vss
+ vdd
+ vdd
+ sky130_fd_sc_hd__fill_8
* cell instance sky130_fd_sc_hd__fill_8_681 r0 *1 0,0
Xsky130_fd_sc_hd__fill_8_681
+ vss
+ vdd
+ vdd
+ sky130_fd_sc_hd__fill_8
* cell instance sky130_fd_sc_hd__fill_8_682 r0 *1 0,0
Xsky130_fd_sc_hd__fill_8_682
+ vss
+ vdd
+ vdd
+ sky130_fd_sc_hd__fill_8
* cell instance sky130_fd_sc_hd__fill_8_683 r0 *1 0,0
Xsky130_fd_sc_hd__fill_8_683
+ vss
+ vdd
+ vdd
+ sky130_fd_sc_hd__fill_8
* cell instance sky130_fd_sc_hd__fill_8_684 r0 *1 0,0
Xsky130_fd_sc_hd__fill_8_684
+ vss
+ vdd
+ vdd
+ sky130_fd_sc_hd__fill_8
* cell instance sky130_fd_sc_hd__fill_8_685 r0 *1 0,0
Xsky130_fd_sc_hd__fill_8_685
+ vss
+ vdd
+ vdd
+ sky130_fd_sc_hd__fill_8
* cell instance sky130_fd_sc_hd__fill_8_686 r0 *1 0,0
Xsky130_fd_sc_hd__fill_8_686
+ vss
+ vdd
+ vdd
+ sky130_fd_sc_hd__fill_8
* cell instance sky130_fd_sc_hd__fill_8_687 r0 *1 0,0
Xsky130_fd_sc_hd__fill_8_687
+ vss
+ vdd
+ vdd
+ sky130_fd_sc_hd__fill_8
* cell instance sky130_fd_sc_hd__fill_8_688 r0 *1 0,0
Xsky130_fd_sc_hd__fill_8_688
+ vss
+ vdd
+ vdd
+ sky130_fd_sc_hd__fill_8
* cell instance sky130_fd_sc_hd__fill_8_689 r0 *1 0,0
Xsky130_fd_sc_hd__fill_8_689
+ vss
+ vdd
+ vdd
+ sky130_fd_sc_hd__fill_8
* cell instance sky130_fd_sc_hd__fill_8_690 r0 *1 0,0
Xsky130_fd_sc_hd__fill_8_690
+ vss
+ vdd
+ vdd
+ sky130_fd_sc_hd__fill_8
* cell instance sky130_fd_sc_hd__fill_8_691 r0 *1 0,0
Xsky130_fd_sc_hd__fill_8_691
+ vss
+ vdd
+ vdd
+ sky130_fd_sc_hd__fill_8
* cell instance sky130_fd_sc_hd__fill_8_692 r0 *1 0,0
Xsky130_fd_sc_hd__fill_8_692
+ vss
+ vdd
+ vdd
+ sky130_fd_sc_hd__fill_8
* cell instance sky130_fd_sc_hd__fill_8_693 r0 *1 0,0
Xsky130_fd_sc_hd__fill_8_693
+ vss
+ vdd
+ vdd
+ sky130_fd_sc_hd__fill_8
* cell instance sky130_fd_sc_hd__fill_8_694 r0 *1 0,0
Xsky130_fd_sc_hd__fill_8_694
+ vss
+ vdd
+ vdd
+ sky130_fd_sc_hd__fill_8
* cell instance sky130_fd_sc_hd__fill_8_695 r0 *1 0,0
Xsky130_fd_sc_hd__fill_8_695
+ vss
+ vdd
+ vdd
+ sky130_fd_sc_hd__fill_8
* cell instance sky130_fd_sc_hd__fill_8_696 r0 *1 0,0
Xsky130_fd_sc_hd__fill_8_696
+ vss
+ vdd
+ vdd
+ sky130_fd_sc_hd__fill_8
* cell instance sky130_fd_sc_hd__fill_8_697 r0 *1 0,0
Xsky130_fd_sc_hd__fill_8_697
+ vss
+ vdd
+ vdd
+ sky130_fd_sc_hd__fill_8
* cell instance sky130_fd_sc_hd__fill_8_698 r0 *1 0,0
Xsky130_fd_sc_hd__fill_8_698
+ vss
+ vdd
+ vdd
+ sky130_fd_sc_hd__fill_8
* cell instance sky130_fd_sc_hd__fill_8_699 r0 *1 0,0
Xsky130_fd_sc_hd__fill_8_699
+ vss
+ vdd
+ vdd
+ sky130_fd_sc_hd__fill_8
* cell instance sky130_fd_sc_hd__fill_8_700 r0 *1 0,0
Xsky130_fd_sc_hd__fill_8_700
+ vss
+ vdd
+ vdd
+ sky130_fd_sc_hd__fill_8
* cell instance sky130_fd_sc_hd__fill_8_701 r0 *1 0,0
Xsky130_fd_sc_hd__fill_8_701
+ vss
+ vdd
+ vdd
+ sky130_fd_sc_hd__fill_8
* cell instance sky130_fd_sc_hd__fill_8_702 r0 *1 0,0
Xsky130_fd_sc_hd__fill_8_702
+ vss
+ vdd
+ vdd
+ sky130_fd_sc_hd__fill_8
* cell instance sky130_fd_sc_hd__fill_8_703 r0 *1 0,0
Xsky130_fd_sc_hd__fill_8_703
+ vss
+ vdd
+ vdd
+ sky130_fd_sc_hd__fill_8
* cell instance sky130_fd_sc_hd__fill_8_704 r0 *1 0,0
Xsky130_fd_sc_hd__fill_8_704
+ vss
+ vdd
+ vdd
+ sky130_fd_sc_hd__fill_8
* cell instance sky130_fd_sc_hd__fill_8_705 r0 *1 0,0
Xsky130_fd_sc_hd__fill_8_705
+ vss
+ vdd
+ vdd
+ sky130_fd_sc_hd__fill_8
* cell instance sky130_fd_sc_hd__fill_8_706 r0 *1 0,0
Xsky130_fd_sc_hd__fill_8_706
+ vss
+ vdd
+ vdd
+ sky130_fd_sc_hd__fill_8
* cell instance sky130_fd_sc_hd__fill_8_707 r0 *1 0,0
Xsky130_fd_sc_hd__fill_8_707
+ vss
+ vdd
+ vdd
+ sky130_fd_sc_hd__fill_8
* cell instance sky130_fd_sc_hd__fill_8_708 r0 *1 0,0
Xsky130_fd_sc_hd__fill_8_708
+ vss
+ vdd
+ vdd
+ sky130_fd_sc_hd__fill_8
* cell instance sky130_fd_sc_hd__fill_8_709 r0 *1 0,0
Xsky130_fd_sc_hd__fill_8_709
+ vss
+ vdd
+ vdd
+ sky130_fd_sc_hd__fill_8
* cell instance sky130_fd_sc_hd__fill_8_710 r0 *1 0,0
Xsky130_fd_sc_hd__fill_8_710
+ vss
+ vdd
+ vdd
+ sky130_fd_sc_hd__fill_8
* cell instance sky130_fd_sc_hd__fill_8_711 r0 *1 0,0
Xsky130_fd_sc_hd__fill_8_711
+ vss
+ vdd
+ vdd
+ sky130_fd_sc_hd__fill_8
* cell instance sky130_fd_sc_hd__fill_8_712 r0 *1 0,0
Xsky130_fd_sc_hd__fill_8_712
+ vss
+ vdd
+ vdd
+ sky130_fd_sc_hd__fill_8
* cell instance sky130_fd_sc_hd__fill_8_713 r0 *1 0,0
Xsky130_fd_sc_hd__fill_8_713
+ vss
+ vdd
+ vdd
+ sky130_fd_sc_hd__fill_8
* cell instance sky130_fd_sc_hd__fill_8_714 r0 *1 0,0
Xsky130_fd_sc_hd__fill_8_714
+ vss
+ vdd
+ vdd
+ sky130_fd_sc_hd__fill_8
* cell instance sky130_fd_sc_hd__fill_8_715 r0 *1 0,0
Xsky130_fd_sc_hd__fill_8_715
+ vss
+ vdd
+ vdd
+ sky130_fd_sc_hd__fill_8
* cell instance sky130_fd_sc_hd__fill_8_716 r0 *1 0,0
Xsky130_fd_sc_hd__fill_8_716
+ vss
+ vdd
+ vdd
+ sky130_fd_sc_hd__fill_8
* cell instance sky130_fd_sc_hd__fill_8_717 r0 *1 0,0
Xsky130_fd_sc_hd__fill_8_717
+ vss
+ vdd
+ vdd
+ sky130_fd_sc_hd__fill_8
* cell instance sky130_fd_sc_hd__fill_8_718 r0 *1 0,0
Xsky130_fd_sc_hd__fill_8_718
+ vss
+ vdd
+ vdd
+ sky130_fd_sc_hd__fill_8
* cell instance sky130_fd_sc_hd__fill_8_719 r0 *1 0,0
Xsky130_fd_sc_hd__fill_8_719
+ vss
+ vdd
+ vdd
+ sky130_fd_sc_hd__fill_8
* cell instance sky130_fd_sc_hd__fill_8_720 r0 *1 0,0
Xsky130_fd_sc_hd__fill_8_720
+ vss
+ vdd
+ vdd
+ sky130_fd_sc_hd__fill_8
* cell instance sky130_fd_sc_hd__fill_8_721 r0 *1 0,0
Xsky130_fd_sc_hd__fill_8_721
+ vss
+ vdd
+ vdd
+ sky130_fd_sc_hd__fill_8
* cell instance sky130_fd_sc_hd__fill_8_722 r0 *1 0,0
Xsky130_fd_sc_hd__fill_8_722
+ vss
+ vdd
+ vdd
+ sky130_fd_sc_hd__fill_8
* cell instance sky130_fd_sc_hd__fill_8_723 r0 *1 0,0
Xsky130_fd_sc_hd__fill_8_723
+ vss
+ vdd
+ vdd
+ sky130_fd_sc_hd__fill_8
* cell instance sky130_fd_sc_hd__fill_8_724 r0 *1 0,0
Xsky130_fd_sc_hd__fill_8_724
+ vss
+ vdd
+ vdd
+ sky130_fd_sc_hd__fill_8
* cell instance sky130_fd_sc_hd__fill_8_725 r0 *1 0,0
Xsky130_fd_sc_hd__fill_8_725
+ vss
+ vdd
+ vdd
+ sky130_fd_sc_hd__fill_8
* cell instance sky130_fd_sc_hd__fill_8_726 r0 *1 0,0
Xsky130_fd_sc_hd__fill_8_726
+ vss
+ vdd
+ vdd
+ sky130_fd_sc_hd__fill_8
* cell instance sky130_fd_sc_hd__fill_8_727 r0 *1 0,0
Xsky130_fd_sc_hd__fill_8_727
+ vss
+ vdd
+ vdd
+ sky130_fd_sc_hd__fill_8
* cell instance sky130_fd_sc_hd__fill_8_728 r0 *1 0,0
Xsky130_fd_sc_hd__fill_8_728
+ vss
+ vdd
+ vdd
+ sky130_fd_sc_hd__fill_8
* cell instance sky130_fd_sc_hd__fill_8_729 r0 *1 0,0
Xsky130_fd_sc_hd__fill_8_729
+ vss
+ vdd
+ vdd
+ sky130_fd_sc_hd__fill_8
* cell instance sky130_fd_sc_hd__fill_8_730 r0 *1 0,0
Xsky130_fd_sc_hd__fill_8_730
+ vss
+ vdd
+ vdd
+ sky130_fd_sc_hd__fill_8
* cell instance sky130_fd_sc_hd__fill_8_731 r0 *1 0,0
Xsky130_fd_sc_hd__fill_8_731
+ vss
+ vdd
+ vdd
+ sky130_fd_sc_hd__fill_8
* cell instance sky130_fd_sc_hd__fill_8_732 r0 *1 0,0
Xsky130_fd_sc_hd__fill_8_732
+ vss
+ vdd
+ vdd
+ sky130_fd_sc_hd__fill_8
* cell instance sky130_fd_sc_hd__fill_8_733 r0 *1 0,0
Xsky130_fd_sc_hd__fill_8_733
+ vss
+ vdd
+ vdd
+ sky130_fd_sc_hd__fill_8
* cell instance sky130_fd_sc_hd__fill_8_734 r0 *1 0,0
Xsky130_fd_sc_hd__fill_8_734
+ vss
+ vdd
+ vdd
+ sky130_fd_sc_hd__fill_8
* cell instance sky130_fd_sc_hd__fill_8_735 r0 *1 0,0
Xsky130_fd_sc_hd__fill_8_735
+ vss
+ vdd
+ vdd
+ sky130_fd_sc_hd__fill_8
* cell instance sky130_fd_sc_hd__fill_8_736 r0 *1 0,0
Xsky130_fd_sc_hd__fill_8_736
+ vss
+ vdd
+ vdd
+ sky130_fd_sc_hd__fill_8
* cell instance sky130_fd_sc_hd__fill_8_737 r0 *1 0,0
Xsky130_fd_sc_hd__fill_8_737
+ vss
+ vdd
+ vdd
+ sky130_fd_sc_hd__fill_8
* cell instance sky130_fd_sc_hd__fill_8_738 r0 *1 0,0
Xsky130_fd_sc_hd__fill_8_738
+ vss
+ vdd
+ vdd
+ sky130_fd_sc_hd__fill_8
* cell instance sky130_fd_sc_hd__fill_8_739 r0 *1 0,0
Xsky130_fd_sc_hd__fill_8_739
+ vss
+ vdd
+ vdd
+ sky130_fd_sc_hd__fill_8
* cell instance sky130_fd_sc_hd__fill_8_740 r0 *1 0,0
Xsky130_fd_sc_hd__fill_8_740
+ vss
+ vdd
+ vdd
+ sky130_fd_sc_hd__fill_8
* cell instance sky130_fd_sc_hd__fill_8_741 r0 *1 0,0
Xsky130_fd_sc_hd__fill_8_741
+ vss
+ vdd
+ vdd
+ sky130_fd_sc_hd__fill_8
* cell instance sky130_fd_sc_hd__fill_8_742 r0 *1 0,0
Xsky130_fd_sc_hd__fill_8_742
+ vss
+ vdd
+ vdd
+ sky130_fd_sc_hd__fill_8
* cell instance sky130_fd_sc_hd__fill_8_743 r0 *1 0,0
Xsky130_fd_sc_hd__fill_8_743
+ vss
+ vdd
+ vdd
+ sky130_fd_sc_hd__fill_8
* cell instance sky130_fd_sc_hd__fill_8_744 r0 *1 0,0
Xsky130_fd_sc_hd__fill_8_744
+ vss
+ vdd
+ vdd
+ sky130_fd_sc_hd__fill_8
* cell instance sky130_fd_sc_hd__fill_8_745 r0 *1 0,0
Xsky130_fd_sc_hd__fill_8_745
+ vss
+ vdd
+ vdd
+ sky130_fd_sc_hd__fill_8
* cell instance sky130_fd_sc_hd__fill_8_746 r0 *1 0,0
Xsky130_fd_sc_hd__fill_8_746
+ vss
+ vdd
+ vdd
+ sky130_fd_sc_hd__fill_8
* cell instance sky130_fd_sc_hd__fill_8_747 r0 *1 0,0
Xsky130_fd_sc_hd__fill_8_747
+ vss
+ vdd
+ vdd
+ sky130_fd_sc_hd__fill_8
* cell instance sky130_fd_sc_hd__fill_8_748 r0 *1 0,0
Xsky130_fd_sc_hd__fill_8_748
+ vss
+ vdd
+ vdd
+ sky130_fd_sc_hd__fill_8
* cell instance sky130_fd_sc_hd__fill_8_749 r0 *1 0,0
Xsky130_fd_sc_hd__fill_8_749
+ vss
+ vdd
+ vdd
+ sky130_fd_sc_hd__fill_8
* cell instance sky130_fd_sc_hd__fill_8_750 r0 *1 0,0
Xsky130_fd_sc_hd__fill_8_750
+ vss
+ vdd
+ vdd
+ sky130_fd_sc_hd__fill_8
* cell instance sky130_fd_sc_hd__fill_8_751 r0 *1 0,0
Xsky130_fd_sc_hd__fill_8_751
+ vss
+ vdd
+ vdd
+ sky130_fd_sc_hd__fill_8
* cell instance sky130_fd_sc_hd__fill_8_752 r0 *1 0,0
Xsky130_fd_sc_hd__fill_8_752
+ vss
+ vdd
+ vdd
+ sky130_fd_sc_hd__fill_8
* cell instance sky130_fd_sc_hd__fill_8_753 r0 *1 0,0
Xsky130_fd_sc_hd__fill_8_753
+ vss
+ vdd
+ vdd
+ sky130_fd_sc_hd__fill_8
* cell instance sky130_fd_sc_hd__fill_8_754 r0 *1 0,0
Xsky130_fd_sc_hd__fill_8_754
+ vss
+ vdd
+ vdd
+ sky130_fd_sc_hd__fill_8
* cell instance sky130_fd_sc_hd__fill_8_755 r0 *1 0,0
Xsky130_fd_sc_hd__fill_8_755
+ vss
+ vdd
+ vdd
+ sky130_fd_sc_hd__fill_8
* cell instance sky130_fd_sc_hd__fill_8_756 r0 *1 0,0
Xsky130_fd_sc_hd__fill_8_756
+ vss
+ vdd
+ vdd
+ sky130_fd_sc_hd__fill_8
* cell instance sky130_fd_sc_hd__fill_8_757 r0 *1 0,0
Xsky130_fd_sc_hd__fill_8_757
+ vss
+ vdd
+ vdd
+ sky130_fd_sc_hd__fill_8
* cell instance sky130_fd_sc_hd__fill_8_758 r0 *1 0,0
Xsky130_fd_sc_hd__fill_8_758
+ vss
+ vdd
+ vdd
+ sky130_fd_sc_hd__fill_8
* cell instance sky130_fd_sc_hd__fill_8_759 r0 *1 0,0
Xsky130_fd_sc_hd__fill_8_759
+ vss
+ vdd
+ vdd
+ sky130_fd_sc_hd__fill_8
* cell instance sky130_fd_sc_hd__fill_8_760 r0 *1 0,0
Xsky130_fd_sc_hd__fill_8_760
+ vss
+ vdd
+ vdd
+ sky130_fd_sc_hd__fill_8
* cell instance sky130_fd_sc_hd__fill_8_761 r0 *1 0,0
Xsky130_fd_sc_hd__fill_8_761
+ vss
+ vdd
+ vdd
+ sky130_fd_sc_hd__fill_8
* cell instance sky130_fd_sc_hd__fill_8_762 r0 *1 0,0
Xsky130_fd_sc_hd__fill_8_762
+ vss
+ vdd
+ vdd
+ sky130_fd_sc_hd__fill_8
* cell instance sky130_fd_sc_hd__fill_8_763 r0 *1 0,0
Xsky130_fd_sc_hd__fill_8_763
+ vss
+ vdd
+ vdd
+ sky130_fd_sc_hd__fill_8
* cell instance sky130_fd_sc_hd__fill_8_764 r0 *1 0,0
Xsky130_fd_sc_hd__fill_8_764
+ vss
+ vdd
+ vdd
+ sky130_fd_sc_hd__fill_8
* cell instance sky130_fd_sc_hd__fill_8_765 r0 *1 0,0
Xsky130_fd_sc_hd__fill_8_765
+ vss
+ vdd
+ vdd
+ sky130_fd_sc_hd__fill_8
* cell instance sky130_fd_sc_hd__fill_8_766 r0 *1 0,0
Xsky130_fd_sc_hd__fill_8_766
+ vss
+ vdd
+ vdd
+ sky130_fd_sc_hd__fill_8
* cell instance sky130_fd_sc_hd__fill_8_767 r0 *1 0,0
Xsky130_fd_sc_hd__fill_8_767
+ vss
+ vdd
+ vdd
+ sky130_fd_sc_hd__fill_8
* cell instance sky130_fd_sc_hd__fill_8_768 r0 *1 0,0
Xsky130_fd_sc_hd__fill_8_768
+ vss
+ vdd
+ vdd
+ sky130_fd_sc_hd__fill_8
* cell instance sky130_fd_sc_hd__fill_8_769 r0 *1 0,0
Xsky130_fd_sc_hd__fill_8_769
+ vss
+ vdd
+ vdd
+ sky130_fd_sc_hd__fill_8
* cell instance sky130_fd_sc_hd__fill_8_770 r0 *1 0,0
Xsky130_fd_sc_hd__fill_8_770
+ vss
+ vdd
+ vdd
+ sky130_fd_sc_hd__fill_8
* cell instance sky130_fd_sc_hd__fill_8_771 r0 *1 0,0
Xsky130_fd_sc_hd__fill_8_771
+ vss
+ vdd
+ vdd
+ sky130_fd_sc_hd__fill_8
* cell instance sky130_fd_sc_hd__fill_8_772 r0 *1 0,0
Xsky130_fd_sc_hd__fill_8_772
+ vss
+ vdd
+ vdd
+ sky130_fd_sc_hd__fill_8
* cell instance sky130_fd_sc_hd__fill_8_773 r0 *1 0,0
Xsky130_fd_sc_hd__fill_8_773
+ vss
+ vdd
+ vdd
+ sky130_fd_sc_hd__fill_8
* cell instance sky130_fd_sc_hd__fill_8_774 r0 *1 0,0
Xsky130_fd_sc_hd__fill_8_774
+ vss
+ vdd
+ vdd
+ sky130_fd_sc_hd__fill_8
* cell instance sky130_fd_sc_hd__fill_8_775 r0 *1 0,0
Xsky130_fd_sc_hd__fill_8_775
+ vss
+ vdd
+ vdd
+ sky130_fd_sc_hd__fill_8
* cell instance sky130_fd_sc_hd__fill_8_776 r0 *1 0,0
Xsky130_fd_sc_hd__fill_8_776
+ vss
+ vdd
+ vdd
+ sky130_fd_sc_hd__fill_8
* cell instance sky130_fd_sc_hd__fill_8_777 r0 *1 0,0
Xsky130_fd_sc_hd__fill_8_777
+ vss
+ vdd
+ vdd
+ sky130_fd_sc_hd__fill_8
* cell instance sky130_fd_sc_hd__fill_8_778 r0 *1 0,0
Xsky130_fd_sc_hd__fill_8_778
+ vss
+ vdd
+ vdd
+ sky130_fd_sc_hd__fill_8
* cell instance sky130_fd_sc_hd__fill_8_779 r0 *1 0,0
Xsky130_fd_sc_hd__fill_8_779
+ vss
+ vdd
+ vdd
+ sky130_fd_sc_hd__fill_8
* cell instance sky130_fd_sc_hd__fill_8_780 r0 *1 0,0
Xsky130_fd_sc_hd__fill_8_780
+ vss
+ vdd
+ vdd
+ sky130_fd_sc_hd__fill_8
* cell instance sky130_fd_sc_hd__fill_8_781 r0 *1 0,0
Xsky130_fd_sc_hd__fill_8_781
+ vss
+ vdd
+ vdd
+ sky130_fd_sc_hd__fill_8
* cell instance sky130_fd_sc_hd__fill_8_782 r0 *1 0,0
Xsky130_fd_sc_hd__fill_8_782
+ vss
+ vdd
+ vdd
+ sky130_fd_sc_hd__fill_8
* cell instance sky130_fd_sc_hd__fill_8_783 r0 *1 0,0
Xsky130_fd_sc_hd__fill_8_783
+ vss
+ vdd
+ vdd
+ sky130_fd_sc_hd__fill_8
* cell instance sky130_fd_sc_hd__fill_8_784 r0 *1 0,0
Xsky130_fd_sc_hd__fill_8_784
+ vss
+ vdd
+ vdd
+ sky130_fd_sc_hd__fill_8
* cell instance sky130_fd_sc_hd__fill_8_785 r0 *1 0,0
Xsky130_fd_sc_hd__fill_8_785
+ vss
+ vdd
+ vdd
+ sky130_fd_sc_hd__fill_8
* cell instance sky130_fd_sc_hd__fill_8_786 r0 *1 0,0
Xsky130_fd_sc_hd__fill_8_786
+ vss
+ vdd
+ vdd
+ sky130_fd_sc_hd__fill_8
* cell instance sky130_fd_sc_hd__fill_8_787 r0 *1 0,0
Xsky130_fd_sc_hd__fill_8_787
+ vss
+ vdd
+ vdd
+ sky130_fd_sc_hd__fill_8
* cell instance sky130_fd_sc_hd__fill_8_788 r0 *1 0,0
Xsky130_fd_sc_hd__fill_8_788
+ vss
+ vdd
+ vdd
+ sky130_fd_sc_hd__fill_8
* cell instance sky130_fd_sc_hd__fill_8_789 r0 *1 0,0
Xsky130_fd_sc_hd__fill_8_789
+ vss
+ vdd
+ vdd
+ sky130_fd_sc_hd__fill_8
* cell instance sky130_fd_sc_hd__fill_8_790 r0 *1 0,0
Xsky130_fd_sc_hd__fill_8_790
+ vss
+ vdd
+ vdd
+ sky130_fd_sc_hd__fill_8
* cell instance sky130_fd_sc_hd__fill_8_791 r0 *1 0,0
Xsky130_fd_sc_hd__fill_8_791
+ vss
+ vdd
+ vdd
+ sky130_fd_sc_hd__fill_8
* cell instance sky130_fd_sc_hd__fill_8_792 r0 *1 0,0
Xsky130_fd_sc_hd__fill_8_792
+ vss
+ vdd
+ vdd
+ sky130_fd_sc_hd__fill_8
* cell instance sky130_fd_sc_hd__fill_8_793 r0 *1 0,0
Xsky130_fd_sc_hd__fill_8_793
+ vss
+ vdd
+ vdd
+ sky130_fd_sc_hd__fill_8
* cell instance sky130_fd_sc_hd__fill_8_794 r0 *1 0,0
Xsky130_fd_sc_hd__fill_8_794
+ vss
+ vdd
+ vdd
+ sky130_fd_sc_hd__fill_8
* cell instance sky130_fd_sc_hd__fill_8_795 r0 *1 0,0
Xsky130_fd_sc_hd__fill_8_795
+ vss
+ vdd
+ vdd
+ sky130_fd_sc_hd__fill_8
* cell instance sky130_fd_sc_hd__fill_8_796 r0 *1 0,0
Xsky130_fd_sc_hd__fill_8_796
+ vss
+ vdd
+ vdd
+ sky130_fd_sc_hd__fill_8
* cell instance sky130_fd_sc_hd__fill_8_797 r0 *1 0,0
Xsky130_fd_sc_hd__fill_8_797
+ vss
+ vdd
+ vdd
+ sky130_fd_sc_hd__fill_8
* cell instance sky130_fd_sc_hd__fill_8_798 r0 *1 0,0
Xsky130_fd_sc_hd__fill_8_798
+ vss
+ vdd
+ vdd
+ sky130_fd_sc_hd__fill_8
* cell instance sky130_fd_sc_hd__fill_8_799 r0 *1 0,0
Xsky130_fd_sc_hd__fill_8_799
+ vss
+ vdd
+ vdd
+ sky130_fd_sc_hd__fill_8
* cell instance sky130_fd_sc_hd__fill_8_800 r0 *1 0,0
Xsky130_fd_sc_hd__fill_8_800
+ vss
+ vdd
+ vdd
+ sky130_fd_sc_hd__fill_8
* cell instance sky130_fd_sc_hd__fill_8_801 r0 *1 0,0
Xsky130_fd_sc_hd__fill_8_801
+ vss
+ vdd
+ vdd
+ sky130_fd_sc_hd__fill_8
* cell instance sky130_fd_sc_hd__fill_8_802 r0 *1 0,0
Xsky130_fd_sc_hd__fill_8_802
+ vss
+ vdd
+ vdd
+ sky130_fd_sc_hd__fill_8
* cell instance sky130_fd_sc_hd__fill_8_803 r0 *1 0,0
Xsky130_fd_sc_hd__fill_8_803
+ vss
+ vdd
+ vdd
+ sky130_fd_sc_hd__fill_8
* cell instance sky130_fd_sc_hd__fill_8_804 r0 *1 0,0
Xsky130_fd_sc_hd__fill_8_804
+ vss
+ vdd
+ vdd
+ sky130_fd_sc_hd__fill_8
* cell instance sky130_fd_sc_hd__fill_8_805 r0 *1 0,0
Xsky130_fd_sc_hd__fill_8_805
+ vss
+ vdd
+ vdd
+ sky130_fd_sc_hd__fill_8
* cell instance sky130_fd_sc_hd__fill_8_806 r0 *1 0,0
Xsky130_fd_sc_hd__fill_8_806
+ vss
+ vdd
+ vdd
+ sky130_fd_sc_hd__fill_8
* cell instance sky130_fd_sc_hd__fill_8_807 r0 *1 0,0
Xsky130_fd_sc_hd__fill_8_807
+ vss
+ vdd
+ vdd
+ sky130_fd_sc_hd__fill_8
* cell instance sky130_fd_sc_hd__fill_8_808 r0 *1 0,0
Xsky130_fd_sc_hd__fill_8_808
+ vss
+ vdd
+ vdd
+ sky130_fd_sc_hd__fill_8
* cell instance sky130_fd_sc_hd__fill_8_809 r0 *1 0,0
Xsky130_fd_sc_hd__fill_8_809
+ vss
+ vdd
+ vdd
+ sky130_fd_sc_hd__fill_8
* cell instance sky130_fd_sc_hd__fill_8_810 r0 *1 0,0
Xsky130_fd_sc_hd__fill_8_810
+ vss
+ vdd
+ vdd
+ sky130_fd_sc_hd__fill_8
* cell instance sky130_fd_sc_hd__fill_8_811 r0 *1 0,0
Xsky130_fd_sc_hd__fill_8_811
+ vss
+ vdd
+ vdd
+ sky130_fd_sc_hd__fill_8
* cell instance sky130_fd_sc_hd__fill_8_812 r0 *1 0,0
Xsky130_fd_sc_hd__fill_8_812
+ vss
+ vdd
+ vdd
+ sky130_fd_sc_hd__fill_8
* cell instance sky130_fd_sc_hd__fill_8_813 r0 *1 0,0
Xsky130_fd_sc_hd__fill_8_813
+ vss
+ vdd
+ vdd
+ sky130_fd_sc_hd__fill_8
* cell instance sky130_fd_sc_hd__fill_8_814 r0 *1 0,0
Xsky130_fd_sc_hd__fill_8_814
+ vss
+ vdd
+ vdd
+ sky130_fd_sc_hd__fill_8
* cell instance sky130_fd_sc_hd__fill_8_815 r0 *1 0,0
Xsky130_fd_sc_hd__fill_8_815
+ vss
+ vdd
+ vdd
+ sky130_fd_sc_hd__fill_8
* cell instance sky130_fd_sc_hd__fill_8_816 r0 *1 0,0
Xsky130_fd_sc_hd__fill_8_816
+ vss
+ vdd
+ vdd
+ sky130_fd_sc_hd__fill_8
* cell instance sky130_fd_sc_hd__fill_8_817 r0 *1 0,0
Xsky130_fd_sc_hd__fill_8_817
+ vss
+ vdd
+ vdd
+ sky130_fd_sc_hd__fill_8
* cell instance sky130_fd_sc_hd__fill_8_818 r0 *1 0,0
Xsky130_fd_sc_hd__fill_8_818
+ vss
+ vdd
+ vdd
+ sky130_fd_sc_hd__fill_8
* cell instance sky130_fd_sc_hd__fill_8_819 r0 *1 0,0
Xsky130_fd_sc_hd__fill_8_819
+ vss
+ vdd
+ vdd
+ sky130_fd_sc_hd__fill_8
* cell instance sky130_fd_sc_hd__fill_8_820 r0 *1 0,0
Xsky130_fd_sc_hd__fill_8_820
+ vss
+ vdd
+ vdd
+ sky130_fd_sc_hd__fill_8
* cell instance sky130_fd_sc_hd__fill_8_821 r0 *1 0,0
Xsky130_fd_sc_hd__fill_8_821
+ vss
+ vdd
+ vdd
+ sky130_fd_sc_hd__fill_8
* cell instance sky130_fd_sc_hd__fill_8_822 r0 *1 0,0
Xsky130_fd_sc_hd__fill_8_822
+ vss
+ vdd
+ vdd
+ sky130_fd_sc_hd__fill_8
* cell instance sky130_fd_sc_hd__fill_8_823 r0 *1 0,0
Xsky130_fd_sc_hd__fill_8_823
+ vss
+ vdd
+ vdd
+ sky130_fd_sc_hd__fill_8
* cell instance sky130_fd_sc_hd__fill_8_824 r0 *1 0,0
Xsky130_fd_sc_hd__fill_8_824
+ vss
+ vdd
+ vdd
+ sky130_fd_sc_hd__fill_8
* cell instance sky130_fd_sc_hd__fill_8_825 r0 *1 0,0
Xsky130_fd_sc_hd__fill_8_825
+ vss
+ vdd
+ vdd
+ sky130_fd_sc_hd__fill_8
* cell instance sky130_fd_sc_hd__fill_8_826 r0 *1 0,0
Xsky130_fd_sc_hd__fill_8_826
+ vss
+ vdd
+ vdd
+ sky130_fd_sc_hd__fill_8
* cell instance sky130_fd_sc_hd__fill_8_827 r0 *1 0,0
Xsky130_fd_sc_hd__fill_8_827
+ vss
+ vdd
+ vdd
+ sky130_fd_sc_hd__fill_8
* cell instance sky130_fd_sc_hd__fill_8_828 r0 *1 0,0
Xsky130_fd_sc_hd__fill_8_828
+ vss
+ vdd
+ vdd
+ sky130_fd_sc_hd__fill_8
* cell instance sky130_fd_sc_hd__fill_8_829 r0 *1 0,0
Xsky130_fd_sc_hd__fill_8_829
+ vss
+ vdd
+ vdd
+ sky130_fd_sc_hd__fill_8
* cell instance sky130_fd_sc_hd__fill_8_830 r0 *1 0,0
Xsky130_fd_sc_hd__fill_8_830
+ vss
+ vdd
+ vdd
+ sky130_fd_sc_hd__fill_8
* cell instance sky130_fd_sc_hd__fill_8_831 r0 *1 0,0
Xsky130_fd_sc_hd__fill_8_831
+ vss
+ vdd
+ vdd
+ sky130_fd_sc_hd__fill_8
* cell instance sky130_fd_sc_hd__fill_8_832 r0 *1 0,0
Xsky130_fd_sc_hd__fill_8_832
+ vss
+ vdd
+ vdd
+ sky130_fd_sc_hd__fill_8
* cell instance sky130_fd_sc_hd__fill_8_833 r0 *1 0,0
Xsky130_fd_sc_hd__fill_8_833
+ vss
+ vdd
+ vdd
+ sky130_fd_sc_hd__fill_8
* cell instance sky130_fd_sc_hd__fill_8_834 r0 *1 0,0
Xsky130_fd_sc_hd__fill_8_834
+ vss
+ vdd
+ vdd
+ sky130_fd_sc_hd__fill_8
* cell instance sky130_fd_sc_hd__fill_8_835 r0 *1 0,0
Xsky130_fd_sc_hd__fill_8_835
+ vss
+ vdd
+ vdd
+ sky130_fd_sc_hd__fill_8
* cell instance sky130_fd_sc_hd__fill_8_836 r0 *1 0,0
Xsky130_fd_sc_hd__fill_8_836
+ vss
+ vdd
+ vdd
+ sky130_fd_sc_hd__fill_8
* cell instance sky130_fd_sc_hd__fill_8_837 r0 *1 0,0
Xsky130_fd_sc_hd__fill_8_837
+ vss
+ vdd
+ vdd
+ sky130_fd_sc_hd__fill_8
* cell instance sky130_fd_sc_hd__fill_8_838 r0 *1 0,0
Xsky130_fd_sc_hd__fill_8_838
+ vss
+ vdd
+ vdd
+ sky130_fd_sc_hd__fill_8
* cell instance sky130_fd_sc_hd__fill_8_839 r0 *1 0,0
Xsky130_fd_sc_hd__fill_8_839
+ vss
+ vdd
+ vdd
+ sky130_fd_sc_hd__fill_8
* cell instance sky130_fd_sc_hd__fill_8_840 r0 *1 0,0
Xsky130_fd_sc_hd__fill_8_840
+ vss
+ vdd
+ vdd
+ sky130_fd_sc_hd__fill_8
* cell instance sky130_fd_sc_hd__fill_8_841 r0 *1 0,0
Xsky130_fd_sc_hd__fill_8_841
+ vss
+ vdd
+ vdd
+ sky130_fd_sc_hd__fill_8
* cell instance sky130_fd_sc_hd__fill_8_842 r0 *1 0,0
Xsky130_fd_sc_hd__fill_8_842
+ vss
+ vdd
+ vdd
+ sky130_fd_sc_hd__fill_8
* cell instance sky130_fd_sc_hd__fill_8_843 r0 *1 0,0
Xsky130_fd_sc_hd__fill_8_843
+ vss
+ vdd
+ vdd
+ sky130_fd_sc_hd__fill_8
* cell instance sky130_fd_sc_hd__fill_8_844 r0 *1 0,0
Xsky130_fd_sc_hd__fill_8_844
+ vss
+ vdd
+ vdd
+ sky130_fd_sc_hd__fill_8
* cell instance sky130_fd_sc_hd__fill_8_845 r0 *1 0,0
Xsky130_fd_sc_hd__fill_8_845
+ vss
+ vdd
+ vdd
+ sky130_fd_sc_hd__fill_8
* cell instance sky130_fd_sc_hd__fill_8_846 r0 *1 0,0
Xsky130_fd_sc_hd__fill_8_846
+ vss
+ vdd
+ vdd
+ sky130_fd_sc_hd__fill_8
* cell instance sky130_fd_sc_hd__fill_8_847 r0 *1 0,0
Xsky130_fd_sc_hd__fill_8_847
+ vss
+ vdd
+ vdd
+ sky130_fd_sc_hd__fill_8
* cell instance sky130_fd_sc_hd__fill_8_848 r0 *1 0,0
Xsky130_fd_sc_hd__fill_8_848
+ vss
+ vdd
+ vdd
+ sky130_fd_sc_hd__fill_8
* cell instance sky130_fd_sc_hd__fill_8_849 r0 *1 0,0
Xsky130_fd_sc_hd__fill_8_849
+ vss
+ vdd
+ vdd
+ sky130_fd_sc_hd__fill_8
* cell instance sky130_fd_sc_hd__fill_8_850 r0 *1 0,0
Xsky130_fd_sc_hd__fill_8_850
+ vss
+ vdd
+ vdd
+ sky130_fd_sc_hd__fill_8
* cell instance sky130_fd_sc_hd__fill_8_851 r0 *1 0,0
Xsky130_fd_sc_hd__fill_8_851
+ vss
+ vdd
+ vdd
+ sky130_fd_sc_hd__fill_8
* cell instance sky130_fd_sc_hd__fill_8_852 r0 *1 0,0
Xsky130_fd_sc_hd__fill_8_852
+ vss
+ vdd
+ vdd
+ sky130_fd_sc_hd__fill_8
* cell instance sky130_fd_sc_hd__fill_8_853 r0 *1 0,0
Xsky130_fd_sc_hd__fill_8_853
+ vss
+ vdd
+ vdd
+ sky130_fd_sc_hd__fill_8
* cell instance sky130_fd_sc_hd__fill_8_854 r0 *1 0,0
Xsky130_fd_sc_hd__fill_8_854
+ vss
+ vdd
+ vdd
+ sky130_fd_sc_hd__fill_8
* cell instance sky130_fd_sc_hd__fill_8_855 r0 *1 0,0
Xsky130_fd_sc_hd__fill_8_855
+ vss
+ vdd
+ vdd
+ sky130_fd_sc_hd__fill_8
* cell instance sky130_fd_sc_hd__fill_8_856 r0 *1 0,0
Xsky130_fd_sc_hd__fill_8_856
+ vss
+ vdd
+ vdd
+ sky130_fd_sc_hd__fill_8
* cell instance sky130_fd_sc_hd__fill_8_857 r0 *1 0,0
Xsky130_fd_sc_hd__fill_8_857
+ vss
+ vdd
+ vdd
+ sky130_fd_sc_hd__fill_8
* cell instance sky130_fd_sc_hd__fill_8_858 r0 *1 0,0
Xsky130_fd_sc_hd__fill_8_858
+ vss
+ vdd
+ vdd
+ sky130_fd_sc_hd__fill_8
* cell instance sky130_fd_sc_hd__fill_8_859 r0 *1 0,0
Xsky130_fd_sc_hd__fill_8_859
+ vss
+ vdd
+ vdd
+ sky130_fd_sc_hd__fill_8
* cell instance sky130_fd_sc_hd__fill_8_860 r0 *1 0,0
Xsky130_fd_sc_hd__fill_8_860
+ vss
+ vdd
+ vdd
+ sky130_fd_sc_hd__fill_8
* cell instance sky130_fd_sc_hd__fill_8_861 r0 *1 0,0
Xsky130_fd_sc_hd__fill_8_861
+ vss
+ vdd
+ vdd
+ sky130_fd_sc_hd__fill_8
* cell instance sky130_fd_sc_hd__fill_8_862 r0 *1 0,0
Xsky130_fd_sc_hd__fill_8_862
+ vss
+ vdd
+ vdd
+ sky130_fd_sc_hd__fill_8
* cell instance sky130_fd_sc_hd__fill_8_863 r0 *1 0,0
Xsky130_fd_sc_hd__fill_8_863
+ vss
+ vdd
+ vdd
+ sky130_fd_sc_hd__fill_8
* cell instance sky130_fd_sc_hd__fill_8_864 r0 *1 0,0
Xsky130_fd_sc_hd__fill_8_864
+ vss
+ vdd
+ vdd
+ sky130_fd_sc_hd__fill_8
* cell instance sky130_fd_sc_hd__fill_8_865 r0 *1 0,0
Xsky130_fd_sc_hd__fill_8_865
+ vss
+ vdd
+ vdd
+ sky130_fd_sc_hd__fill_8
* cell instance sky130_fd_sc_hd__fill_8_866 r0 *1 0,0
Xsky130_fd_sc_hd__fill_8_866
+ vss
+ vdd
+ vdd
+ sky130_fd_sc_hd__fill_8
* cell instance sky130_fd_sc_hd__fill_8_867 r0 *1 0,0
Xsky130_fd_sc_hd__fill_8_867
+ vss
+ vdd
+ vdd
+ sky130_fd_sc_hd__fill_8
* cell instance sky130_fd_sc_hd__fill_8_868 r0 *1 0,0
Xsky130_fd_sc_hd__fill_8_868
+ vss
+ vdd
+ vdd
+ sky130_fd_sc_hd__fill_8
* cell instance sky130_fd_sc_hd__fill_8_869 r0 *1 0,0
Xsky130_fd_sc_hd__fill_8_869
+ vss
+ vdd
+ vdd
+ sky130_fd_sc_hd__fill_8
* cell instance sky130_fd_sc_hd__fill_8_870 r0 *1 0,0
Xsky130_fd_sc_hd__fill_8_870
+ vss
+ vdd
+ vdd
+ sky130_fd_sc_hd__fill_8
* cell instance sky130_fd_sc_hd__fill_8_871 r0 *1 0,0
Xsky130_fd_sc_hd__fill_8_871
+ vss
+ vdd
+ vdd
+ sky130_fd_sc_hd__fill_8
* cell instance sky130_fd_sc_hd__fill_8_872 r0 *1 0,0
Xsky130_fd_sc_hd__fill_8_872
+ vss
+ vdd
+ vdd
+ sky130_fd_sc_hd__fill_8
* cell instance sky130_fd_sc_hd__fill_8_873 r0 *1 0,0
Xsky130_fd_sc_hd__fill_8_873
+ vss
+ vdd
+ vdd
+ sky130_fd_sc_hd__fill_8
* cell instance sky130_fd_sc_hd__fill_8_874 r0 *1 0,0
Xsky130_fd_sc_hd__fill_8_874
+ vss
+ vdd
+ vdd
+ sky130_fd_sc_hd__fill_8
* cell instance sky130_fd_sc_hd__fill_8_875 r0 *1 0,0
Xsky130_fd_sc_hd__fill_8_875
+ vss
+ vdd
+ vdd
+ sky130_fd_sc_hd__fill_8
* cell instance sky130_fd_sc_hd__fill_8_876 r0 *1 0,0
Xsky130_fd_sc_hd__fill_8_876
+ vss
+ vdd
+ vdd
+ sky130_fd_sc_hd__fill_8
* cell instance sky130_fd_sc_hd__fill_8_877 r0 *1 0,0
Xsky130_fd_sc_hd__fill_8_877
+ vss
+ vdd
+ vdd
+ sky130_fd_sc_hd__fill_8
* cell instance sky130_fd_sc_hd__fill_8_878 r0 *1 0,0
Xsky130_fd_sc_hd__fill_8_878
+ vss
+ vdd
+ vdd
+ sky130_fd_sc_hd__fill_8
* cell instance sky130_fd_sc_hd__fill_8_879 r0 *1 0,0
Xsky130_fd_sc_hd__fill_8_879
+ vss
+ vdd
+ vdd
+ sky130_fd_sc_hd__fill_8
* cell instance sky130_fd_sc_hd__fill_8_880 r0 *1 0,0
Xsky130_fd_sc_hd__fill_8_880
+ vss
+ vdd
+ vdd
+ sky130_fd_sc_hd__fill_8
* cell instance sky130_fd_sc_hd__fill_8_881 r0 *1 0,0
Xsky130_fd_sc_hd__fill_8_881
+ vss
+ vdd
+ vdd
+ sky130_fd_sc_hd__fill_8
* cell instance sky130_fd_sc_hd__fill_8_882 r0 *1 0,0
Xsky130_fd_sc_hd__fill_8_882
+ vss
+ vdd
+ vdd
+ sky130_fd_sc_hd__fill_8
* cell instance sky130_fd_sc_hd__fill_8_883 r0 *1 0,0
Xsky130_fd_sc_hd__fill_8_883
+ vss
+ vdd
+ vdd
+ sky130_fd_sc_hd__fill_8
* cell instance sky130_fd_sc_hd__fill_8_884 r0 *1 0,0
Xsky130_fd_sc_hd__fill_8_884
+ vss
+ vdd
+ vdd
+ sky130_fd_sc_hd__fill_8
* cell instance sky130_fd_sc_hd__fill_8_885 r0 *1 0,0
Xsky130_fd_sc_hd__fill_8_885
+ vss
+ vdd
+ vdd
+ sky130_fd_sc_hd__fill_8
* cell instance sky130_fd_sc_hd__fill_8_886 r0 *1 0,0
Xsky130_fd_sc_hd__fill_8_886
+ vss
+ vdd
+ vdd
+ sky130_fd_sc_hd__fill_8
* cell instance sky130_fd_sc_hd__fill_8_887 r0 *1 0,0
Xsky130_fd_sc_hd__fill_8_887
+ vss
+ vdd
+ vdd
+ sky130_fd_sc_hd__fill_8
* cell instance sky130_fd_sc_hd__fill_8_888 r0 *1 0,0
Xsky130_fd_sc_hd__fill_8_888
+ vss
+ vdd
+ vdd
+ sky130_fd_sc_hd__fill_8
* cell instance sky130_fd_sc_hd__fill_8_889 r0 *1 0,0
Xsky130_fd_sc_hd__fill_8_889
+ vss
+ vdd
+ vdd
+ sky130_fd_sc_hd__fill_8
* cell instance sky130_fd_sc_hd__fill_8_890 r0 *1 0,0
Xsky130_fd_sc_hd__fill_8_890
+ vss
+ vdd
+ vdd
+ sky130_fd_sc_hd__fill_8
* cell instance sky130_fd_sc_hd__fill_8_891 r0 *1 0,0
Xsky130_fd_sc_hd__fill_8_891
+ vss
+ vdd
+ vdd
+ sky130_fd_sc_hd__fill_8
* cell instance sky130_fd_sc_hd__fill_8_892 r0 *1 0,0
Xsky130_fd_sc_hd__fill_8_892
+ vss
+ vdd
+ vdd
+ sky130_fd_sc_hd__fill_8
* cell instance sky130_fd_sc_hd__fill_8_893 r0 *1 0,0
Xsky130_fd_sc_hd__fill_8_893
+ vss
+ vdd
+ vdd
+ sky130_fd_sc_hd__fill_8
* cell instance sky130_fd_sc_hd__fill_8_894 r0 *1 0,0
Xsky130_fd_sc_hd__fill_8_894
+ vss
+ vdd
+ vdd
+ sky130_fd_sc_hd__fill_8
* cell instance sky130_fd_sc_hd__fill_8_895 r0 *1 0,0
Xsky130_fd_sc_hd__fill_8_895
+ vss
+ vdd
+ vdd
+ sky130_fd_sc_hd__fill_8
* cell instance sky130_fd_sc_hd__fill_8_896 r0 *1 0,0
Xsky130_fd_sc_hd__fill_8_896
+ vss
+ vdd
+ vdd
+ sky130_fd_sc_hd__fill_8
* cell instance sky130_fd_sc_hd__fill_8_897 r0 *1 0,0
Xsky130_fd_sc_hd__fill_8_897
+ vss
+ vdd
+ vdd
+ sky130_fd_sc_hd__fill_8
* cell instance sky130_fd_sc_hd__fill_8_898 r0 *1 0,0
Xsky130_fd_sc_hd__fill_8_898
+ vss
+ vdd
+ vdd
+ sky130_fd_sc_hd__fill_8
* cell instance sky130_fd_sc_hd__fill_8_899 r0 *1 0,0
Xsky130_fd_sc_hd__fill_8_899
+ vss
+ vdd
+ vdd
+ sky130_fd_sc_hd__fill_8
* cell instance sky130_fd_sc_hd__fill_8_900 r0 *1 0,0
Xsky130_fd_sc_hd__fill_8_900
+ vss
+ vdd
+ vdd
+ sky130_fd_sc_hd__fill_8
* cell instance sky130_fd_sc_hd__fill_8_901 r0 *1 0,0
Xsky130_fd_sc_hd__fill_8_901
+ vss
+ vdd
+ vdd
+ sky130_fd_sc_hd__fill_8
* cell instance sky130_fd_sc_hd__fill_8_902 r0 *1 0,0
Xsky130_fd_sc_hd__fill_8_902
+ vss
+ vdd
+ vdd
+ sky130_fd_sc_hd__fill_8
* cell instance sky130_fd_sc_hd__fill_8_903 r0 *1 0,0
Xsky130_fd_sc_hd__fill_8_903
+ vss
+ vdd
+ vdd
+ sky130_fd_sc_hd__fill_8
* cell instance sky130_fd_sc_hd__fill_8_904 r0 *1 0,0
Xsky130_fd_sc_hd__fill_8_904
+ vss
+ vdd
+ vdd
+ sky130_fd_sc_hd__fill_8
* cell instance sky130_fd_sc_hd__fill_8_905 r0 *1 0,0
Xsky130_fd_sc_hd__fill_8_905
+ vss
+ vdd
+ vdd
+ sky130_fd_sc_hd__fill_8
* cell instance sky130_fd_sc_hd__fill_8_906 r0 *1 0,0
Xsky130_fd_sc_hd__fill_8_906
+ vss
+ vdd
+ vdd
+ sky130_fd_sc_hd__fill_8
* cell instance sky130_fd_sc_hd__fill_8_907 r0 *1 0,0
Xsky130_fd_sc_hd__fill_8_907
+ vss
+ vdd
+ vdd
+ sky130_fd_sc_hd__fill_8
* cell instance sky130_fd_sc_hd__fill_8_908 r0 *1 0,0
Xsky130_fd_sc_hd__fill_8_908
+ vss
+ vdd
+ vdd
+ sky130_fd_sc_hd__fill_8
* cell instance sky130_fd_sc_hd__fill_8_909 r0 *1 0,0
Xsky130_fd_sc_hd__fill_8_909
+ vss
+ vdd
+ vdd
+ sky130_fd_sc_hd__fill_8
* cell instance sky130_fd_sc_hd__fill_8_910 r0 *1 0,0
Xsky130_fd_sc_hd__fill_8_910
+ vss
+ vdd
+ vdd
+ sky130_fd_sc_hd__fill_8
* cell instance sky130_fd_sc_hd__fill_8_911 r0 *1 0,0
Xsky130_fd_sc_hd__fill_8_911
+ vss
+ vdd
+ vdd
+ sky130_fd_sc_hd__fill_8
* cell instance sky130_fd_sc_hd__fill_8_912 r0 *1 0,0
Xsky130_fd_sc_hd__fill_8_912
+ vss
+ vdd
+ vdd
+ sky130_fd_sc_hd__fill_8
* cell instance sky130_fd_sc_hd__fill_8_913 r0 *1 0,0
Xsky130_fd_sc_hd__fill_8_913
+ vss
+ vdd
+ vdd
+ sky130_fd_sc_hd__fill_8
* cell instance sky130_fd_sc_hd__fill_8_914 r0 *1 0,0
Xsky130_fd_sc_hd__fill_8_914
+ vss
+ vdd
+ vdd
+ sky130_fd_sc_hd__fill_8
* cell instance sky130_fd_sc_hd__fill_8_915 r0 *1 0,0
Xsky130_fd_sc_hd__fill_8_915
+ vss
+ vdd
+ vdd
+ sky130_fd_sc_hd__fill_8
* cell instance sky130_fd_sc_hd__fill_8_916 r0 *1 0,0
Xsky130_fd_sc_hd__fill_8_916
+ vss
+ vdd
+ vdd
+ sky130_fd_sc_hd__fill_8
* cell instance sky130_fd_sc_hd__fill_8_917 r0 *1 0,0
Xsky130_fd_sc_hd__fill_8_917
+ vss
+ vdd
+ vdd
+ sky130_fd_sc_hd__fill_8
* cell instance sky130_fd_sc_hd__fill_8_918 r0 *1 0,0
Xsky130_fd_sc_hd__fill_8_918
+ vss
+ vdd
+ vdd
+ sky130_fd_sc_hd__fill_8
* cell instance sky130_fd_sc_hd__fill_8_919 r0 *1 0,0
Xsky130_fd_sc_hd__fill_8_919
+ vss
+ vdd
+ vdd
+ sky130_fd_sc_hd__fill_8
* cell instance sky130_fd_sc_hd__fill_8_920 r0 *1 0,0
Xsky130_fd_sc_hd__fill_8_920
+ vss
+ vdd
+ vdd
+ sky130_fd_sc_hd__fill_8
* cell instance sky130_fd_sc_hd__fill_8_921 r0 *1 0,0
Xsky130_fd_sc_hd__fill_8_921
+ vss
+ vdd
+ vdd
+ sky130_fd_sc_hd__fill_8
* cell instance sky130_fd_sc_hd__fill_8_922 r0 *1 0,0
Xsky130_fd_sc_hd__fill_8_922
+ vss
+ vdd
+ vdd
+ sky130_fd_sc_hd__fill_8
* cell instance sky130_fd_sc_hd__fill_8_923 r0 *1 0,0
Xsky130_fd_sc_hd__fill_8_923
+ vss
+ vdd
+ vdd
+ sky130_fd_sc_hd__fill_8
* cell instance sky130_fd_sc_hd__fill_8_924 r0 *1 0,0
Xsky130_fd_sc_hd__fill_8_924
+ vss
+ vdd
+ vdd
+ sky130_fd_sc_hd__fill_8
* cell instance sky130_fd_sc_hd__fill_8_925 r0 *1 0,0
Xsky130_fd_sc_hd__fill_8_925
+ vss
+ vdd
+ vdd
+ sky130_fd_sc_hd__fill_8
* cell instance sky130_fd_sc_hd__fill_8_926 r0 *1 0,0
Xsky130_fd_sc_hd__fill_8_926
+ vss
+ vdd
+ vdd
+ sky130_fd_sc_hd__fill_8
* cell instance sky130_fd_sc_hd__fill_8_927 r0 *1 0,0
Xsky130_fd_sc_hd__fill_8_927
+ vss
+ vdd
+ vdd
+ sky130_fd_sc_hd__fill_8
* cell instance sky130_fd_sc_hd__fill_8_928 r0 *1 0,0
Xsky130_fd_sc_hd__fill_8_928
+ vss
+ vdd
+ vdd
+ sky130_fd_sc_hd__fill_8
* cell instance sky130_fd_sc_hd__fill_8_929 r0 *1 0,0
Xsky130_fd_sc_hd__fill_8_929
+ vss
+ vdd
+ vdd
+ sky130_fd_sc_hd__fill_8
* cell instance sky130_fd_sc_hd__fill_8_930 r0 *1 0,0
Xsky130_fd_sc_hd__fill_8_930
+ vss
+ vdd
+ vdd
+ sky130_fd_sc_hd__fill_8
* cell instance sky130_fd_sc_hd__fill_8_931 r0 *1 0,0
Xsky130_fd_sc_hd__fill_8_931
+ vss
+ vdd
+ vdd
+ sky130_fd_sc_hd__fill_8
* cell instance sky130_fd_sc_hd__fill_8_932 r0 *1 0,0
Xsky130_fd_sc_hd__fill_8_932
+ vss
+ vdd
+ vdd
+ sky130_fd_sc_hd__fill_8
* cell instance sky130_fd_sc_hd__fill_8_933 r0 *1 0,0
Xsky130_fd_sc_hd__fill_8_933
+ vss
+ vdd
+ vdd
+ sky130_fd_sc_hd__fill_8
* cell instance sky130_fd_sc_hd__fill_8_934 r0 *1 0,0
Xsky130_fd_sc_hd__fill_8_934
+ vss
+ vdd
+ vdd
+ sky130_fd_sc_hd__fill_8
* cell instance sky130_fd_sc_hd__fill_8_935 r0 *1 0,0
Xsky130_fd_sc_hd__fill_8_935
+ vss
+ vdd
+ vdd
+ sky130_fd_sc_hd__fill_8
* cell instance sky130_fd_sc_hd__fill_8_936 r0 *1 0,0
Xsky130_fd_sc_hd__fill_8_936
+ vss
+ vdd
+ vdd
+ sky130_fd_sc_hd__fill_8
* cell instance sky130_fd_sc_hd__fill_8_937 r0 *1 0,0
Xsky130_fd_sc_hd__fill_8_937
+ vss
+ vdd
+ vdd
+ sky130_fd_sc_hd__fill_8
* cell instance sky130_fd_sc_hd__fill_8_938 r0 *1 0,0
Xsky130_fd_sc_hd__fill_8_938
+ vss
+ vdd
+ vdd
+ sky130_fd_sc_hd__fill_8
* cell instance sky130_fd_sc_hd__fill_8_939 r0 *1 0,0
Xsky130_fd_sc_hd__fill_8_939
+ vss
+ vdd
+ vdd
+ sky130_fd_sc_hd__fill_8
* cell instance sky130_fd_sc_hd__fill_8_940 r0 *1 0,0
Xsky130_fd_sc_hd__fill_8_940
+ vss
+ vdd
+ vdd
+ sky130_fd_sc_hd__fill_8
* cell instance sky130_fd_sc_hd__fill_8_941 r0 *1 0,0
Xsky130_fd_sc_hd__fill_8_941
+ vss
+ vdd
+ vdd
+ sky130_fd_sc_hd__fill_8
* cell instance sky130_fd_sc_hd__fill_8_942 r0 *1 0,0
Xsky130_fd_sc_hd__fill_8_942
+ vss
+ vdd
+ vdd
+ sky130_fd_sc_hd__fill_8
* cell instance sky130_fd_sc_hd__fill_8_943 r0 *1 0,0
Xsky130_fd_sc_hd__fill_8_943
+ vss
+ vdd
+ vdd
+ sky130_fd_sc_hd__fill_8
* cell instance sky130_fd_sc_hd__fill_8_944 r0 *1 0,0
Xsky130_fd_sc_hd__fill_8_944
+ vss
+ vdd
+ vdd
+ sky130_fd_sc_hd__fill_8
* cell instance sky130_fd_sc_hd__fill_8_945 r0 *1 0,0
Xsky130_fd_sc_hd__fill_8_945
+ vss
+ vdd
+ vdd
+ sky130_fd_sc_hd__fill_8
* cell instance sky130_fd_sc_hd__fill_8_946 r0 *1 0,0
Xsky130_fd_sc_hd__fill_8_946
+ vss
+ vdd
+ vdd
+ sky130_fd_sc_hd__fill_8
* cell instance sky130_fd_sc_hd__fill_8_947 r0 *1 0,0
Xsky130_fd_sc_hd__fill_8_947
+ vss
+ vdd
+ vdd
+ sky130_fd_sc_hd__fill_8
* cell instance sky130_fd_sc_hd__fill_8_948 r0 *1 0,0
Xsky130_fd_sc_hd__fill_8_948
+ vss
+ vdd
+ vdd
+ sky130_fd_sc_hd__fill_8
* cell instance sky130_fd_sc_hd__fill_8_949 r0 *1 0,0
Xsky130_fd_sc_hd__fill_8_949
+ vss
+ vdd
+ vdd
+ sky130_fd_sc_hd__fill_8
* cell instance sky130_fd_sc_hd__fill_8_950 r0 *1 0,0
Xsky130_fd_sc_hd__fill_8_950
+ vss
+ vdd
+ vdd
+ sky130_fd_sc_hd__fill_8
* cell instance sky130_fd_sc_hd__fill_8_951 r0 *1 0,0
Xsky130_fd_sc_hd__fill_8_951
+ vss
+ vdd
+ vdd
+ sky130_fd_sc_hd__fill_8
* cell instance sky130_fd_sc_hd__fill_8_952 r0 *1 0,0
Xsky130_fd_sc_hd__fill_8_952
+ vss
+ vdd
+ vdd
+ sky130_fd_sc_hd__fill_8
* cell instance sky130_fd_sc_hd__fill_8_953 r0 *1 0,0
Xsky130_fd_sc_hd__fill_8_953
+ vss
+ vdd
+ vdd
+ sky130_fd_sc_hd__fill_8
* cell instance sky130_fd_sc_hd__fill_8_954 r0 *1 0,0
Xsky130_fd_sc_hd__fill_8_954
+ vss
+ vdd
+ vdd
+ sky130_fd_sc_hd__fill_8
* cell instance sky130_fd_sc_hd__fill_8_955 r0 *1 0,0
Xsky130_fd_sc_hd__fill_8_955
+ vss
+ vdd
+ vdd
+ sky130_fd_sc_hd__fill_8
* cell instance sky130_fd_sc_hd__fill_8_956 r0 *1 0,0
Xsky130_fd_sc_hd__fill_8_956
+ vss
+ vdd
+ vdd
+ sky130_fd_sc_hd__fill_8
* cell instance sky130_fd_sc_hd__fill_8_957 r0 *1 0,0
Xsky130_fd_sc_hd__fill_8_957
+ vss
+ vdd
+ vdd
+ sky130_fd_sc_hd__fill_8
* cell instance sky130_fd_sc_hd__fill_8_958 r0 *1 0,0
Xsky130_fd_sc_hd__fill_8_958
+ vss
+ vdd
+ vdd
+ sky130_fd_sc_hd__fill_8
* cell instance sky130_fd_sc_hd__fill_8_959 r0 *1 0,0
Xsky130_fd_sc_hd__fill_8_959
+ vss
+ vdd
+ vdd
+ sky130_fd_sc_hd__fill_8
* cell instance sky130_fd_sc_hd__fill_8_960 r0 *1 0,0
Xsky130_fd_sc_hd__fill_8_960
+ vss
+ vdd
+ vdd
+ sky130_fd_sc_hd__fill_8
* cell instance sky130_fd_sc_hd__fill_8_961 r0 *1 0,0
Xsky130_fd_sc_hd__fill_8_961
+ vss
+ vdd
+ vdd
+ sky130_fd_sc_hd__fill_8
* cell instance sky130_fd_sc_hd__fill_8_962 r0 *1 0,0
Xsky130_fd_sc_hd__fill_8_962
+ vss
+ vdd
+ vdd
+ sky130_fd_sc_hd__fill_8
* cell instance sky130_fd_sc_hd__fill_8_963 r0 *1 0,0
Xsky130_fd_sc_hd__fill_8_963
+ vss
+ vdd
+ vdd
+ sky130_fd_sc_hd__fill_8
* cell instance sky130_fd_sc_hd__fill_8_964 r0 *1 0,0
Xsky130_fd_sc_hd__fill_8_964
+ vss
+ vdd
+ vdd
+ sky130_fd_sc_hd__fill_8
* cell instance sky130_fd_sc_hd__fill_8_965 r0 *1 0,0
Xsky130_fd_sc_hd__fill_8_965
+ vss
+ vdd
+ vdd
+ sky130_fd_sc_hd__fill_8
* cell instance sky130_fd_sc_hd__fill_8_966 r0 *1 0,0
Xsky130_fd_sc_hd__fill_8_966
+ vss
+ vdd
+ vdd
+ sky130_fd_sc_hd__fill_8
* cell instance sky130_fd_sc_hd__fill_8_967 r0 *1 0,0
Xsky130_fd_sc_hd__fill_8_967
+ vss
+ vdd
+ vdd
+ sky130_fd_sc_hd__fill_8
* cell instance sky130_fd_sc_hd__fill_8_968 r0 *1 0,0
Xsky130_fd_sc_hd__fill_8_968
+ vss
+ vdd
+ vdd
+ sky130_fd_sc_hd__fill_8
* cell instance sky130_fd_sc_hd__fill_8_969 r0 *1 0,0
Xsky130_fd_sc_hd__fill_8_969
+ vss
+ vdd
+ vdd
+ sky130_fd_sc_hd__fill_8
* cell instance sky130_fd_sc_hd__fill_8_970 r0 *1 0,0
Xsky130_fd_sc_hd__fill_8_970
+ vss
+ vdd
+ vdd
+ sky130_fd_sc_hd__fill_8
* cell instance sky130_fd_sc_hd__fill_8_971 r0 *1 0,0
Xsky130_fd_sc_hd__fill_8_971
+ vss
+ vdd
+ vdd
+ sky130_fd_sc_hd__fill_8
* cell instance sky130_fd_sc_hd__fill_8_972 r0 *1 0,0
Xsky130_fd_sc_hd__fill_8_972
+ vss
+ vdd
+ vdd
+ sky130_fd_sc_hd__fill_8
* cell instance sky130_fd_sc_hd__fill_8_973 r0 *1 0,0
Xsky130_fd_sc_hd__fill_8_973
+ vss
+ vdd
+ vdd
+ sky130_fd_sc_hd__fill_8
* cell instance sky130_fd_sc_hd__fill_8_974 r0 *1 0,0
Xsky130_fd_sc_hd__fill_8_974
+ vss
+ vdd
+ vdd
+ sky130_fd_sc_hd__fill_8
* cell instance sky130_fd_sc_hd__fill_8_975 r0 *1 0,0
Xsky130_fd_sc_hd__fill_8_975
+ vss
+ vdd
+ vdd
+ sky130_fd_sc_hd__fill_8
* cell instance sky130_fd_sc_hd__fill_8_976 r0 *1 0,0
Xsky130_fd_sc_hd__fill_8_976
+ vss
+ vdd
+ vdd
+ sky130_fd_sc_hd__fill_8
* cell instance sky130_fd_sc_hd__fill_8_977 r0 *1 0,0
Xsky130_fd_sc_hd__fill_8_977
+ vss
+ vdd
+ vdd
+ sky130_fd_sc_hd__fill_8
* cell instance sky130_fd_sc_hd__fill_8_978 r0 *1 0,0
Xsky130_fd_sc_hd__fill_8_978
+ vss
+ vdd
+ vdd
+ sky130_fd_sc_hd__fill_8
* cell instance sky130_fd_sc_hd__fill_8_979 r0 *1 0,0
Xsky130_fd_sc_hd__fill_8_979
+ vss
+ vdd
+ vdd
+ sky130_fd_sc_hd__fill_8
* cell instance sky130_fd_sc_hd__fill_8_980 r0 *1 0,0
Xsky130_fd_sc_hd__fill_8_980
+ vss
+ vdd
+ vdd
+ sky130_fd_sc_hd__fill_8
* cell instance sky130_fd_sc_hd__fill_8_981 r0 *1 0,0
Xsky130_fd_sc_hd__fill_8_981
+ vss
+ vdd
+ vdd
+ sky130_fd_sc_hd__fill_8
* cell instance sky130_fd_sc_hd__fill_8_982 r0 *1 0,0
Xsky130_fd_sc_hd__fill_8_982
+ vss
+ vdd
+ vdd
+ sky130_fd_sc_hd__fill_8
* cell instance sky130_fd_sc_hd__fill_8_983 r0 *1 0,0
Xsky130_fd_sc_hd__fill_8_983
+ vss
+ vdd
+ vdd
+ sky130_fd_sc_hd__fill_8
* cell instance sky130_fd_sc_hd__fill_8_984 r0 *1 0,0
Xsky130_fd_sc_hd__fill_8_984
+ vss
+ vdd
+ vdd
+ sky130_fd_sc_hd__fill_8
* cell instance sky130_fd_sc_hd__fill_8_985 r0 *1 0,0
Xsky130_fd_sc_hd__fill_8_985
+ vss
+ vdd
+ vdd
+ sky130_fd_sc_hd__fill_8
* cell instance sky130_fd_sc_hd__fill_8_986 r0 *1 0,0
Xsky130_fd_sc_hd__fill_8_986
+ vss
+ vdd
+ vdd
+ sky130_fd_sc_hd__fill_8
* cell instance sky130_fd_sc_hd__fill_8_987 r0 *1 0,0
Xsky130_fd_sc_hd__fill_8_987
+ vss
+ vdd
+ vdd
+ sky130_fd_sc_hd__fill_8
* cell instance sky130_fd_sc_hd__fill_8_988 r0 *1 0,0
Xsky130_fd_sc_hd__fill_8_988
+ vss
+ vdd
+ vdd
+ sky130_fd_sc_hd__fill_8
* cell instance sky130_fd_sc_hd__fill_8_989 r0 *1 0,0
Xsky130_fd_sc_hd__fill_8_989
+ vss
+ vdd
+ vdd
+ sky130_fd_sc_hd__fill_8
* cell instance sky130_fd_sc_hd__fill_8_990 r0 *1 0,0
Xsky130_fd_sc_hd__fill_8_990
+ vss
+ vdd
+ vdd
+ sky130_fd_sc_hd__fill_8
* cell instance sky130_fd_sc_hd__fill_8_991 r0 *1 0,0
Xsky130_fd_sc_hd__fill_8_991
+ vss
+ vdd
+ vdd
+ sky130_fd_sc_hd__fill_8
* cell instance sky130_fd_sc_hd__fill_8_992 r0 *1 0,0
Xsky130_fd_sc_hd__fill_8_992
+ vss
+ vdd
+ vdd
+ sky130_fd_sc_hd__fill_8
* cell instance sky130_fd_sc_hd__fill_8_993 r0 *1 0,0
Xsky130_fd_sc_hd__fill_8_993
+ vss
+ vdd
+ vdd
+ sky130_fd_sc_hd__fill_8
* cell instance sky130_fd_sc_hd__fill_8_994 r0 *1 0,0
Xsky130_fd_sc_hd__fill_8_994
+ vss
+ vdd
+ vdd
+ sky130_fd_sc_hd__fill_8
* cell instance sky130_fd_sc_hd__fill_8_995 r0 *1 0,0
Xsky130_fd_sc_hd__fill_8_995
+ vss
+ vdd
+ vdd
+ sky130_fd_sc_hd__fill_8
* cell instance sky130_fd_sc_hd__fill_8_996 r0 *1 0,0
Xsky130_fd_sc_hd__fill_8_996
+ vss
+ vdd
+ vdd
+ sky130_fd_sc_hd__fill_8
* cell instance sky130_fd_sc_hd__fill_8_997 r0 *1 0,0
Xsky130_fd_sc_hd__fill_8_997
+ vss
+ vdd
+ vdd
+ sky130_fd_sc_hd__fill_8
* cell instance sky130_fd_sc_hd__fill_8_998 r0 *1 0,0
Xsky130_fd_sc_hd__fill_8_998
+ vss
+ vdd
+ vdd
+ sky130_fd_sc_hd__fill_8
* cell instance sky130_fd_sc_hd__fill_8_999 r0 *1 0,0
Xsky130_fd_sc_hd__fill_8_999
+ vss
+ vdd
+ vdd
+ sky130_fd_sc_hd__fill_8
* cell instance sky130_fd_sc_hd__fill_8_1000 r0 *1 0,0
Xsky130_fd_sc_hd__fill_8_1000
+ vss
+ vdd
+ vdd
+ sky130_fd_sc_hd__fill_8
* cell instance sky130_fd_sc_hd__fill_8_1001 r0 *1 0,0
Xsky130_fd_sc_hd__fill_8_1001
+ vss
+ vdd
+ vdd
+ sky130_fd_sc_hd__fill_8
* cell instance sky130_fd_sc_hd__fill_8_1002 r0 *1 0,0
Xsky130_fd_sc_hd__fill_8_1002
+ vss
+ vdd
+ vdd
+ sky130_fd_sc_hd__fill_8
* cell instance sky130_fd_sc_hd__fill_8_1003 r0 *1 0,0
Xsky130_fd_sc_hd__fill_8_1003
+ vss
+ vdd
+ vdd
+ sky130_fd_sc_hd__fill_8
* cell instance sky130_fd_sc_hd__fill_8_1004 r0 *1 0,0
Xsky130_fd_sc_hd__fill_8_1004
+ vss
+ vdd
+ vdd
+ sky130_fd_sc_hd__fill_8
* cell instance sky130_fd_sc_hd__fill_8_1005 r0 *1 0,0
Xsky130_fd_sc_hd__fill_8_1005
+ vss
+ vdd
+ vdd
+ sky130_fd_sc_hd__fill_8
* cell instance sky130_fd_sc_hd__fill_8_1006 r0 *1 0,0
Xsky130_fd_sc_hd__fill_8_1006
+ vss
+ vdd
+ vdd
+ sky130_fd_sc_hd__fill_8
* cell instance sky130_fd_sc_hd__fill_8_1007 r0 *1 0,0
Xsky130_fd_sc_hd__fill_8_1007
+ vss
+ vdd
+ vdd
+ sky130_fd_sc_hd__fill_8
* cell instance sky130_fd_sc_hd__fill_8_1008 r0 *1 0,0
Xsky130_fd_sc_hd__fill_8_1008
+ vss
+ vdd
+ vdd
+ sky130_fd_sc_hd__fill_8
* cell instance sky130_fd_sc_hd__fill_8_1009 r0 *1 0,0
Xsky130_fd_sc_hd__fill_8_1009
+ vss
+ vdd
+ vdd
+ sky130_fd_sc_hd__fill_8
* cell instance sky130_fd_sc_hd__fill_8_1010 r0 *1 0,0
Xsky130_fd_sc_hd__fill_8_1010
+ vss
+ vdd
+ vdd
+ sky130_fd_sc_hd__fill_8
* cell instance sky130_fd_sc_hd__fill_8_1011 r0 *1 0,0
Xsky130_fd_sc_hd__fill_8_1011
+ vss
+ vdd
+ vdd
+ sky130_fd_sc_hd__fill_8
* cell instance sky130_fd_sc_hd__fill_8_1012 r0 *1 0,0
Xsky130_fd_sc_hd__fill_8_1012
+ vss
+ vdd
+ vdd
+ sky130_fd_sc_hd__fill_8
* cell instance sky130_fd_sc_hd__fill_8_1013 r0 *1 0,0
Xsky130_fd_sc_hd__fill_8_1013
+ vss
+ vdd
+ vdd
+ sky130_fd_sc_hd__fill_8
* cell instance sky130_fd_sc_hd__fill_8_1014 r0 *1 0,0
Xsky130_fd_sc_hd__fill_8_1014
+ vss
+ vdd
+ vdd
+ sky130_fd_sc_hd__fill_8
* cell instance sky130_fd_sc_hd__fill_8_1015 r0 *1 0,0
Xsky130_fd_sc_hd__fill_8_1015
+ vss
+ vdd
+ vdd
+ sky130_fd_sc_hd__fill_8
* cell instance sky130_fd_sc_hd__fill_8_1016 r0 *1 0,0
Xsky130_fd_sc_hd__fill_8_1016
+ vss
+ vdd
+ vdd
+ sky130_fd_sc_hd__fill_8
* cell instance sky130_fd_sc_hd__fill_8_1017 r0 *1 0,0
Xsky130_fd_sc_hd__fill_8_1017
+ vss
+ vdd
+ vdd
+ sky130_fd_sc_hd__fill_8
* cell instance sky130_fd_sc_hd__fill_8_1018 r0 *1 0,0
Xsky130_fd_sc_hd__fill_8_1018
+ vss
+ vdd
+ vdd
+ sky130_fd_sc_hd__fill_8
* cell instance sky130_fd_sc_hd__fill_8_1019 r0 *1 0,0
Xsky130_fd_sc_hd__fill_8_1019
+ vss
+ vdd
+ vdd
+ sky130_fd_sc_hd__fill_8
* cell instance sky130_fd_sc_hd__fill_8_1020 r0 *1 0,0
Xsky130_fd_sc_hd__fill_8_1020
+ vss
+ vdd
+ vdd
+ sky130_fd_sc_hd__fill_8
* cell instance sky130_fd_sc_hd__fill_8_1021 r0 *1 0,0
Xsky130_fd_sc_hd__fill_8_1021
+ vss
+ vdd
+ vdd
+ sky130_fd_sc_hd__fill_8
* cell instance sky130_fd_sc_hd__fill_8_1022 r0 *1 0,0
Xsky130_fd_sc_hd__fill_8_1022
+ vss
+ vdd
+ vdd
+ sky130_fd_sc_hd__fill_8
* cell instance sky130_fd_sc_hd__fill_8_1023 r0 *1 0,0
Xsky130_fd_sc_hd__fill_8_1023
+ vss
+ vdd
+ vdd
+ sky130_fd_sc_hd__fill_8
* cell instance sky130_fd_sc_hd__fill_8_1024 r0 *1 0,0
Xsky130_fd_sc_hd__fill_8_1024
+ vss
+ vdd
+ vdd
+ sky130_fd_sc_hd__fill_8
* cell instance sky130_fd_sc_hd__fill_8_1025 r0 *1 0,0
Xsky130_fd_sc_hd__fill_8_1025
+ vss
+ vdd
+ vdd
+ sky130_fd_sc_hd__fill_8
* cell instance sky130_fd_sc_hd__fill_8_1026 r0 *1 0,0
Xsky130_fd_sc_hd__fill_8_1026
+ vss
+ vdd
+ vdd
+ sky130_fd_sc_hd__fill_8
* cell instance sky130_fd_sc_hd__fill_8_1027 r0 *1 0,0
Xsky130_fd_sc_hd__fill_8_1027
+ vss
+ vdd
+ vdd
+ sky130_fd_sc_hd__fill_8
* cell instance sky130_fd_sc_hd__fill_8_1028 r0 *1 0,0
Xsky130_fd_sc_hd__fill_8_1028
+ vss
+ vdd
+ vdd
+ sky130_fd_sc_hd__fill_8
* cell instance sky130_fd_sc_hd__fill_8_1029 r0 *1 0,0
Xsky130_fd_sc_hd__fill_8_1029
+ vss
+ vdd
+ vdd
+ sky130_fd_sc_hd__fill_8
* cell instance sky130_fd_sc_hd__fill_8_1030 r0 *1 0,0
Xsky130_fd_sc_hd__fill_8_1030
+ vss
+ vdd
+ vdd
+ sky130_fd_sc_hd__fill_8
* cell instance sky130_fd_sc_hd__fill_8_1031 r0 *1 0,0
Xsky130_fd_sc_hd__fill_8_1031
+ vss
+ vdd
+ vdd
+ sky130_fd_sc_hd__fill_8
* cell instance sky130_fd_sc_hd__fill_8_1032 r0 *1 0,0
Xsky130_fd_sc_hd__fill_8_1032
+ vss
+ vdd
+ vdd
+ sky130_fd_sc_hd__fill_8
* cell instance sky130_fd_sc_hd__fill_8_1033 r0 *1 0,0
Xsky130_fd_sc_hd__fill_8_1033
+ vss
+ vdd
+ vdd
+ sky130_fd_sc_hd__fill_8
* cell instance sky130_fd_sc_hd__fill_8_1034 r0 *1 0,0
Xsky130_fd_sc_hd__fill_8_1034
+ vss
+ vdd
+ vdd
+ sky130_fd_sc_hd__fill_8
* cell instance sky130_fd_sc_hd__fill_8_1035 r0 *1 0,0
Xsky130_fd_sc_hd__fill_8_1035
+ vss
+ vdd
+ vdd
+ sky130_fd_sc_hd__fill_8
* cell instance sky130_fd_sc_hd__fill_8_1036 r0 *1 0,0
Xsky130_fd_sc_hd__fill_8_1036
+ vss
+ vdd
+ vdd
+ sky130_fd_sc_hd__fill_8
* cell instance sky130_fd_sc_hd__fill_8_1037 r0 *1 0,0
Xsky130_fd_sc_hd__fill_8_1037
+ vss
+ vdd
+ vdd
+ sky130_fd_sc_hd__fill_8
* cell instance sky130_fd_sc_hd__fill_8_1038 r0 *1 0,0
Xsky130_fd_sc_hd__fill_8_1038
+ vss
+ vdd
+ vdd
+ sky130_fd_sc_hd__fill_8
* cell instance sky130_fd_sc_hd__fill_8_1039 r0 *1 0,0
Xsky130_fd_sc_hd__fill_8_1039
+ vss
+ vdd
+ vdd
+ sky130_fd_sc_hd__fill_8
* cell instance sky130_fd_sc_hd__fill_8_1040 r0 *1 0,0
Xsky130_fd_sc_hd__fill_8_1040
+ vss
+ vdd
+ vdd
+ sky130_fd_sc_hd__fill_8
* cell instance sky130_fd_sc_hd__fill_8_1041 r0 *1 0,0
Xsky130_fd_sc_hd__fill_8_1041
+ vss
+ vdd
+ vdd
+ sky130_fd_sc_hd__fill_8
* cell instance sky130_fd_sc_hd__fill_8_1042 r0 *1 0,0
Xsky130_fd_sc_hd__fill_8_1042
+ vss
+ vdd
+ vdd
+ sky130_fd_sc_hd__fill_8
* cell instance sky130_fd_sc_hd__fill_8_1043 r0 *1 0,0
Xsky130_fd_sc_hd__fill_8_1043
+ vss
+ vdd
+ vdd
+ sky130_fd_sc_hd__fill_8
* cell instance sky130_fd_sc_hd__fill_8_1044 r0 *1 0,0
Xsky130_fd_sc_hd__fill_8_1044
+ vss
+ vdd
+ vdd
+ sky130_fd_sc_hd__fill_8
* cell instance sky130_fd_sc_hd__fill_8_1045 r0 *1 0,0
Xsky130_fd_sc_hd__fill_8_1045
+ vss
+ vdd
+ vdd
+ sky130_fd_sc_hd__fill_8
* cell instance sky130_fd_sc_hd__fill_8_1046 r0 *1 0,0
Xsky130_fd_sc_hd__fill_8_1046
+ vss
+ vdd
+ vdd
+ sky130_fd_sc_hd__fill_8
* cell instance sky130_fd_sc_hd__fill_8_1047 r0 *1 0,0
Xsky130_fd_sc_hd__fill_8_1047
+ vss
+ vdd
+ vdd
+ sky130_fd_sc_hd__fill_8
* cell instance sky130_fd_sc_hd__fill_8_1048 r0 *1 0,0
Xsky130_fd_sc_hd__fill_8_1048
+ vss
+ vdd
+ vdd
+ sky130_fd_sc_hd__fill_8
* cell instance sky130_fd_sc_hd__fill_8_1049 r0 *1 0,0
Xsky130_fd_sc_hd__fill_8_1049
+ vss
+ vdd
+ vdd
+ sky130_fd_sc_hd__fill_8
* cell instance sky130_fd_sc_hd__fill_8_1050 r0 *1 0,0
Xsky130_fd_sc_hd__fill_8_1050
+ vss
+ vdd
+ vdd
+ sky130_fd_sc_hd__fill_8
* cell instance sky130_fd_sc_hd__fill_8_1051 r0 *1 0,0
Xsky130_fd_sc_hd__fill_8_1051
+ vss
+ vdd
+ vdd
+ sky130_fd_sc_hd__fill_8
* cell instance sky130_fd_sc_hd__fill_8_1052 r0 *1 0,0
Xsky130_fd_sc_hd__fill_8_1052
+ vss
+ vdd
+ vdd
+ sky130_fd_sc_hd__fill_8
* cell instance sky130_fd_sc_hd__fill_8_1053 r0 *1 0,0
Xsky130_fd_sc_hd__fill_8_1053
+ vss
+ vdd
+ vdd
+ sky130_fd_sc_hd__fill_8
* cell instance sky130_fd_sc_hd__fill_8_1054 r0 *1 0,0
Xsky130_fd_sc_hd__fill_8_1054
+ vss
+ vdd
+ vdd
+ sky130_fd_sc_hd__fill_8
* cell instance sky130_fd_sc_hd__fill_8_1055 r0 *1 0,0
Xsky130_fd_sc_hd__fill_8_1055
+ vss
+ vdd
+ vdd
+ sky130_fd_sc_hd__fill_8
* cell instance sky130_fd_sc_hd__fill_8_1056 r0 *1 0,0
Xsky130_fd_sc_hd__fill_8_1056
+ vss
+ vdd
+ vdd
+ sky130_fd_sc_hd__fill_8
* cell instance sky130_fd_sc_hd__fill_8_1057 r0 *1 0,0
Xsky130_fd_sc_hd__fill_8_1057
+ vss
+ vdd
+ vdd
+ sky130_fd_sc_hd__fill_8
* cell instance sky130_fd_sc_hd__fill_8_1058 r0 *1 0,0
Xsky130_fd_sc_hd__fill_8_1058
+ vss
+ vdd
+ vdd
+ sky130_fd_sc_hd__fill_8
* cell instance sky130_fd_sc_hd__fill_8_1059 r0 *1 0,0
Xsky130_fd_sc_hd__fill_8_1059
+ vss
+ vdd
+ vdd
+ sky130_fd_sc_hd__fill_8
* cell instance sky130_fd_sc_hd__fill_8_1060 r0 *1 0,0
Xsky130_fd_sc_hd__fill_8_1060
+ vss
+ vdd
+ vdd
+ sky130_fd_sc_hd__fill_8
* cell instance sky130_fd_sc_hd__fill_8_1061 r0 *1 0,0
Xsky130_fd_sc_hd__fill_8_1061
+ vss
+ vdd
+ vdd
+ sky130_fd_sc_hd__fill_8
* cell instance sky130_fd_sc_hd__fill_8_1062 r0 *1 0,0
Xsky130_fd_sc_hd__fill_8_1062
+ vss
+ vdd
+ vdd
+ sky130_fd_sc_hd__fill_8
* cell instance sky130_fd_sc_hd__fill_8_1063 r0 *1 0,0
Xsky130_fd_sc_hd__fill_8_1063
+ vss
+ vdd
+ vdd
+ sky130_fd_sc_hd__fill_8
* cell instance sky130_fd_sc_hd__fill_8_1064 r0 *1 0,0
Xsky130_fd_sc_hd__fill_8_1064
+ vss
+ vdd
+ vdd
+ sky130_fd_sc_hd__fill_8
* cell instance sky130_fd_sc_hd__fill_8_1065 r0 *1 0,0
Xsky130_fd_sc_hd__fill_8_1065
+ vss
+ vdd
+ vdd
+ sky130_fd_sc_hd__fill_8
* cell instance sky130_fd_sc_hd__fill_8_1066 r0 *1 0,0
Xsky130_fd_sc_hd__fill_8_1066
+ vss
+ vdd
+ vdd
+ sky130_fd_sc_hd__fill_8
* cell instance sky130_fd_sc_hd__fill_8_1067 r0 *1 0,0
Xsky130_fd_sc_hd__fill_8_1067
+ vss
+ vdd
+ vdd
+ sky130_fd_sc_hd__fill_8
* cell instance sky130_fd_sc_hd__fill_8_1068 r0 *1 0,0
Xsky130_fd_sc_hd__fill_8_1068
+ vss
+ vdd
+ vdd
+ sky130_fd_sc_hd__fill_8
* cell instance sky130_fd_sc_hd__fill_8_1069 r0 *1 0,0
Xsky130_fd_sc_hd__fill_8_1069
+ vss
+ vdd
+ vdd
+ sky130_fd_sc_hd__fill_8
* cell instance sky130_fd_sc_hd__fill_8_1070 r0 *1 0,0
Xsky130_fd_sc_hd__fill_8_1070
+ vss
+ vdd
+ vdd
+ sky130_fd_sc_hd__fill_8
* cell instance sky130_fd_sc_hd__fill_8_1071 r0 *1 0,0
Xsky130_fd_sc_hd__fill_8_1071
+ vss
+ vdd
+ vdd
+ sky130_fd_sc_hd__fill_8
* cell instance sky130_fd_sc_hd__fill_8_1072 r0 *1 0,0
Xsky130_fd_sc_hd__fill_8_1072
+ vss
+ vdd
+ vdd
+ sky130_fd_sc_hd__fill_8
* cell instance sky130_fd_sc_hd__fill_8_1073 r0 *1 0,0
Xsky130_fd_sc_hd__fill_8_1073
+ vss
+ vdd
+ vdd
+ sky130_fd_sc_hd__fill_8
* cell instance sky130_fd_sc_hd__fill_8_1074 r0 *1 0,0
Xsky130_fd_sc_hd__fill_8_1074
+ vss
+ vdd
+ vdd
+ sky130_fd_sc_hd__fill_8
* cell instance sky130_fd_sc_hd__fill_8_1075 r0 *1 0,0
Xsky130_fd_sc_hd__fill_8_1075
+ vss
+ vdd
+ vdd
+ sky130_fd_sc_hd__fill_8
* cell instance sky130_fd_sc_hd__fill_8_1076 r0 *1 0,0
Xsky130_fd_sc_hd__fill_8_1076
+ vss
+ vdd
+ vdd
+ sky130_fd_sc_hd__fill_8
* cell instance sky130_fd_sc_hd__fill_8_1077 r0 *1 0,0
Xsky130_fd_sc_hd__fill_8_1077
+ vss
+ vdd
+ vdd
+ sky130_fd_sc_hd__fill_8
* cell instance sky130_fd_sc_hd__fill_8_1078 r0 *1 0,0
Xsky130_fd_sc_hd__fill_8_1078
+ vss
+ vdd
+ vdd
+ sky130_fd_sc_hd__fill_8
* cell instance sky130_fd_sc_hd__fill_8_1079 r0 *1 0,0
Xsky130_fd_sc_hd__fill_8_1079
+ vss
+ vdd
+ vdd
+ sky130_fd_sc_hd__fill_8
* cell instance sky130_fd_sc_hd__fill_8_1080 r0 *1 0,0
Xsky130_fd_sc_hd__fill_8_1080
+ vss
+ vdd
+ vdd
+ sky130_fd_sc_hd__fill_8
* cell instance sky130_fd_sc_hd__fill_8_1081 r0 *1 0,0
Xsky130_fd_sc_hd__fill_8_1081
+ vss
+ vdd
+ vdd
+ sky130_fd_sc_hd__fill_8
* cell instance sky130_fd_sc_hd__fill_8_1082 r0 *1 0,0
Xsky130_fd_sc_hd__fill_8_1082
+ vss
+ vdd
+ vdd
+ sky130_fd_sc_hd__fill_8
* cell instance sky130_fd_sc_hd__fill_8_1083 r0 *1 0,0
Xsky130_fd_sc_hd__fill_8_1083
+ vss
+ vdd
+ vdd
+ sky130_fd_sc_hd__fill_8
* cell instance sky130_fd_sc_hd__fill_8_1084 r0 *1 0,0
Xsky130_fd_sc_hd__fill_8_1084
+ vss
+ vdd
+ vdd
+ sky130_fd_sc_hd__fill_8
* cell instance sky130_fd_sc_hd__fill_8_1085 r0 *1 0,0
Xsky130_fd_sc_hd__fill_8_1085
+ vss
+ vdd
+ vdd
+ sky130_fd_sc_hd__fill_8
* cell instance sky130_fd_sc_hd__fill_8_1086 r0 *1 0,0
Xsky130_fd_sc_hd__fill_8_1086
+ vss
+ vdd
+ vdd
+ sky130_fd_sc_hd__fill_8
* cell instance sky130_fd_sc_hd__fill_8_1087 r0 *1 0,0
Xsky130_fd_sc_hd__fill_8_1087
+ vss
+ vdd
+ vdd
+ sky130_fd_sc_hd__fill_8
* cell instance sky130_fd_sc_hd__fill_8_1088 r0 *1 0,0
Xsky130_fd_sc_hd__fill_8_1088
+ vss
+ vdd
+ vdd
+ sky130_fd_sc_hd__fill_8
* cell instance sky130_fd_sc_hd__fill_8_1089 r0 *1 0,0
Xsky130_fd_sc_hd__fill_8_1089
+ vss
+ vdd
+ vdd
+ sky130_fd_sc_hd__fill_8
* cell instance sky130_fd_sc_hd__fill_8_1090 r0 *1 0,0
Xsky130_fd_sc_hd__fill_8_1090
+ vss
+ vdd
+ vdd
+ sky130_fd_sc_hd__fill_8
* cell instance sky130_fd_sc_hd__fill_8_1091 r0 *1 0,0
Xsky130_fd_sc_hd__fill_8_1091
+ vss
+ vdd
+ vdd
+ sky130_fd_sc_hd__fill_8
* cell instance sky130_fd_sc_hd__fill_8_1092 r0 *1 0,0
Xsky130_fd_sc_hd__fill_8_1092
+ vss
+ vdd
+ vdd
+ sky130_fd_sc_hd__fill_8
* cell instance sky130_fd_sc_hd__fill_8_1093 r0 *1 0,0
Xsky130_fd_sc_hd__fill_8_1093
+ vss
+ vdd
+ vdd
+ sky130_fd_sc_hd__fill_8
* cell instance sky130_fd_sc_hd__fill_8_1094 r0 *1 0,0
Xsky130_fd_sc_hd__fill_8_1094
+ vss
+ vdd
+ vdd
+ sky130_fd_sc_hd__fill_8
* cell instance sky130_fd_sc_hd__fill_8_1095 r0 *1 0,0
Xsky130_fd_sc_hd__fill_8_1095
+ vss
+ vdd
+ vdd
+ sky130_fd_sc_hd__fill_8
* cell instance sky130_fd_sc_hd__fill_8_1096 r0 *1 0,0
Xsky130_fd_sc_hd__fill_8_1096
+ vss
+ vdd
+ vdd
+ sky130_fd_sc_hd__fill_8
* cell instance sky130_fd_sc_hd__fill_8_1097 r0 *1 0,0
Xsky130_fd_sc_hd__fill_8_1097
+ vss
+ vdd
+ vdd
+ sky130_fd_sc_hd__fill_8
* cell instance sky130_fd_sc_hd__fill_8_1098 r0 *1 0,0
Xsky130_fd_sc_hd__fill_8_1098
+ vss
+ vdd
+ vdd
+ sky130_fd_sc_hd__fill_8
* cell instance sky130_fd_sc_hd__fill_8_1099 r0 *1 0,0
Xsky130_fd_sc_hd__fill_8_1099
+ vss
+ vdd
+ vdd
+ sky130_fd_sc_hd__fill_8
* cell instance sky130_fd_sc_hd__fill_8_1100 r0 *1 0,0
Xsky130_fd_sc_hd__fill_8_1100
+ vss
+ vdd
+ vdd
+ sky130_fd_sc_hd__fill_8
* cell instance sky130_fd_sc_hd__fill_8_1101 r0 *1 0,0
Xsky130_fd_sc_hd__fill_8_1101
+ vss
+ vdd
+ vdd
+ sky130_fd_sc_hd__fill_8
* cell instance sky130_fd_sc_hd__fill_8_1102 r0 *1 0,0
Xsky130_fd_sc_hd__fill_8_1102
+ vss
+ vdd
+ vdd
+ sky130_fd_sc_hd__fill_8
* cell instance sky130_fd_sc_hd__fill_8_1103 r0 *1 0,0
Xsky130_fd_sc_hd__fill_8_1103
+ vss
+ vdd
+ vdd
+ sky130_fd_sc_hd__fill_8
* cell instance sky130_fd_sc_hd__fill_8_1104 r0 *1 0,0
Xsky130_fd_sc_hd__fill_8_1104
+ vss
+ vdd
+ vdd
+ sky130_fd_sc_hd__fill_8
* cell instance sky130_fd_sc_hd__fill_8_1105 r0 *1 0,0
Xsky130_fd_sc_hd__fill_8_1105
+ vss
+ vdd
+ vdd
+ sky130_fd_sc_hd__fill_8
* cell instance sky130_fd_sc_hd__fill_8_1106 r0 *1 0,0
Xsky130_fd_sc_hd__fill_8_1106
+ vss
+ vdd
+ vdd
+ sky130_fd_sc_hd__fill_8
* cell instance sky130_fd_sc_hd__fill_8_1107 r0 *1 0,0
Xsky130_fd_sc_hd__fill_8_1107
+ vss
+ vdd
+ vdd
+ sky130_fd_sc_hd__fill_8
* cell instance sky130_fd_sc_hd__fill_8_1108 r0 *1 0,0
Xsky130_fd_sc_hd__fill_8_1108
+ vss
+ vdd
+ vdd
+ sky130_fd_sc_hd__fill_8
* cell instance sky130_fd_sc_hd__fill_8_1109 r0 *1 0,0
Xsky130_fd_sc_hd__fill_8_1109
+ vss
+ vdd
+ vdd
+ sky130_fd_sc_hd__fill_8
* cell instance sky130_fd_sc_hd__fill_8_1110 r0 *1 0,0
Xsky130_fd_sc_hd__fill_8_1110
+ vss
+ vdd
+ vdd
+ sky130_fd_sc_hd__fill_8
* cell instance sky130_fd_sc_hd__fill_8_1111 r0 *1 0,0
Xsky130_fd_sc_hd__fill_8_1111
+ vss
+ vdd
+ vdd
+ sky130_fd_sc_hd__fill_8
* cell instance sky130_fd_sc_hd__fill_8_1112 r0 *1 0,0
Xsky130_fd_sc_hd__fill_8_1112
+ vss
+ vdd
+ vdd
+ sky130_fd_sc_hd__fill_8
* cell instance sky130_fd_sc_hd__fill_8_1113 r0 *1 0,0
Xsky130_fd_sc_hd__fill_8_1113
+ vss
+ vdd
+ vdd
+ sky130_fd_sc_hd__fill_8
* cell instance sky130_fd_sc_hd__fill_8_1114 r0 *1 0,0
Xsky130_fd_sc_hd__fill_8_1114
+ vss
+ vdd
+ vdd
+ sky130_fd_sc_hd__fill_8
* cell instance sky130_fd_sc_hd__fill_8_1115 r0 *1 0,0
Xsky130_fd_sc_hd__fill_8_1115
+ vss
+ vdd
+ vdd
+ sky130_fd_sc_hd__fill_8
* cell instance sky130_fd_sc_hd__fill_8_1116 r0 *1 0,0
Xsky130_fd_sc_hd__fill_8_1116
+ vss
+ vdd
+ vdd
+ sky130_fd_sc_hd__fill_8
* cell instance sky130_fd_sc_hd__fill_8_1117 r0 *1 0,0
Xsky130_fd_sc_hd__fill_8_1117
+ vss
+ vdd
+ vdd
+ sky130_fd_sc_hd__fill_8
* cell instance sky130_fd_sc_hd__fill_8_1118 r0 *1 0,0
Xsky130_fd_sc_hd__fill_8_1118
+ vss
+ vdd
+ vdd
+ sky130_fd_sc_hd__fill_8
* cell instance sky130_fd_sc_hd__fill_8_1119 r0 *1 0,0
Xsky130_fd_sc_hd__fill_8_1119
+ vss
+ vdd
+ vdd
+ sky130_fd_sc_hd__fill_8
* cell instance sky130_fd_sc_hd__fill_8_1120 r0 *1 0,0
Xsky130_fd_sc_hd__fill_8_1120
+ vss
+ vdd
+ vdd
+ sky130_fd_sc_hd__fill_8
* cell instance sky130_fd_sc_hd__fill_8_1121 r0 *1 0,0
Xsky130_fd_sc_hd__fill_8_1121
+ vss
+ vdd
+ vdd
+ sky130_fd_sc_hd__fill_8
* cell instance sky130_fd_sc_hd__fill_8_1122 r0 *1 0,0
Xsky130_fd_sc_hd__fill_8_1122
+ vss
+ vdd
+ vdd
+ sky130_fd_sc_hd__fill_8
* cell instance sky130_fd_sc_hd__fill_8_1123 r0 *1 0,0
Xsky130_fd_sc_hd__fill_8_1123
+ vss
+ vdd
+ vdd
+ sky130_fd_sc_hd__fill_8
* cell instance sky130_fd_sc_hd__fill_8_1124 r0 *1 0,0
Xsky130_fd_sc_hd__fill_8_1124
+ vss
+ vdd
+ vdd
+ sky130_fd_sc_hd__fill_8
* cell instance sky130_fd_sc_hd__fill_8_1125 r0 *1 0,0
Xsky130_fd_sc_hd__fill_8_1125
+ vss
+ vdd
+ vdd
+ sky130_fd_sc_hd__fill_8
* cell instance sky130_fd_sc_hd__fill_8_1126 r0 *1 0,0
Xsky130_fd_sc_hd__fill_8_1126
+ vss
+ vdd
+ vdd
+ sky130_fd_sc_hd__fill_8
* cell instance sky130_fd_sc_hd__fill_8_1127 r0 *1 0,0
Xsky130_fd_sc_hd__fill_8_1127
+ vss
+ vdd
+ vdd
+ sky130_fd_sc_hd__fill_8
* cell instance sky130_fd_sc_hd__fill_8_1128 r0 *1 0,0
Xsky130_fd_sc_hd__fill_8_1128
+ vss
+ vdd
+ vdd
+ sky130_fd_sc_hd__fill_8
* cell instance sky130_fd_sc_hd__fill_8_1129 r0 *1 0,0
Xsky130_fd_sc_hd__fill_8_1129
+ vss
+ vdd
+ vdd
+ sky130_fd_sc_hd__fill_8
* cell instance sky130_fd_sc_hd__fill_8_1130 r0 *1 0,0
Xsky130_fd_sc_hd__fill_8_1130
+ vss
+ vdd
+ vdd
+ sky130_fd_sc_hd__fill_8
* cell instance sky130_fd_sc_hd__fill_8_1131 r0 *1 0,0
Xsky130_fd_sc_hd__fill_8_1131
+ vss
+ vdd
+ vdd
+ sky130_fd_sc_hd__fill_8
* cell instance sky130_fd_sc_hd__fill_8_1132 r0 *1 0,0
Xsky130_fd_sc_hd__fill_8_1132
+ vss
+ vdd
+ vdd
+ sky130_fd_sc_hd__fill_8
* cell instance sky130_fd_sc_hd__fill_8_1133 r0 *1 0,0
Xsky130_fd_sc_hd__fill_8_1133
+ vss
+ vdd
+ vdd
+ sky130_fd_sc_hd__fill_8
* cell instance sky130_fd_sc_hd__fill_8_1134 r0 *1 0,0
Xsky130_fd_sc_hd__fill_8_1134
+ vss
+ vdd
+ vdd
+ sky130_fd_sc_hd__fill_8
* cell instance sky130_fd_sc_hd__fill_8_1135 r0 *1 0,0
Xsky130_fd_sc_hd__fill_8_1135
+ vss
+ vdd
+ vdd
+ sky130_fd_sc_hd__fill_8
* cell instance sky130_fd_sc_hd__fill_8_1136 r0 *1 0,0
Xsky130_fd_sc_hd__fill_8_1136
+ vss
+ vdd
+ vdd
+ sky130_fd_sc_hd__fill_8
* cell instance sky130_fd_sc_hd__fill_8_1137 r0 *1 0,0
Xsky130_fd_sc_hd__fill_8_1137
+ vss
+ vdd
+ vdd
+ sky130_fd_sc_hd__fill_8
* cell instance sky130_fd_sc_hd__fill_8_1138 r0 *1 0,0
Xsky130_fd_sc_hd__fill_8_1138
+ vss
+ vdd
+ vdd
+ sky130_fd_sc_hd__fill_8
* cell instance sky130_fd_sc_hd__fill_8_1139 r0 *1 0,0
Xsky130_fd_sc_hd__fill_8_1139
+ vss
+ vdd
+ vdd
+ sky130_fd_sc_hd__fill_8
* cell instance sky130_fd_sc_hd__fill_8_1140 r0 *1 0,0
Xsky130_fd_sc_hd__fill_8_1140
+ vss
+ vdd
+ vdd
+ sky130_fd_sc_hd__fill_8
* cell instance sky130_fd_sc_hd__fill_8_1141 r0 *1 0,0
Xsky130_fd_sc_hd__fill_8_1141
+ vss
+ vdd
+ vdd
+ sky130_fd_sc_hd__fill_8
* cell instance sky130_fd_sc_hd__fill_8_1142 r0 *1 0,0
Xsky130_fd_sc_hd__fill_8_1142
+ vss
+ vdd
+ vdd
+ sky130_fd_sc_hd__fill_8
* cell instance sky130_fd_sc_hd__fill_8_1143 r0 *1 0,0
Xsky130_fd_sc_hd__fill_8_1143
+ vss
+ vdd
+ vdd
+ sky130_fd_sc_hd__fill_8
* cell instance sky130_fd_sc_hd__fill_8_1144 r0 *1 0,0
Xsky130_fd_sc_hd__fill_8_1144
+ vss
+ vdd
+ vdd
+ sky130_fd_sc_hd__fill_8
* cell instance sky130_fd_sc_hd__fill_8_1145 r0 *1 0,0
Xsky130_fd_sc_hd__fill_8_1145
+ vss
+ vdd
+ vdd
+ sky130_fd_sc_hd__fill_8
* cell instance sky130_fd_sc_hd__fill_8_1146 r0 *1 0,0
Xsky130_fd_sc_hd__fill_8_1146
+ vss
+ vdd
+ vdd
+ sky130_fd_sc_hd__fill_8
* cell instance sky130_fd_sc_hd__fill_8_1147 r0 *1 0,0
Xsky130_fd_sc_hd__fill_8_1147
+ vss
+ vdd
+ vdd
+ sky130_fd_sc_hd__fill_8
* cell instance sky130_fd_sc_hd__fill_8_1148 r0 *1 0,0
Xsky130_fd_sc_hd__fill_8_1148
+ vss
+ vdd
+ vdd
+ sky130_fd_sc_hd__fill_8
* cell instance sky130_fd_sc_hd__fill_8_1149 r0 *1 0,0
Xsky130_fd_sc_hd__fill_8_1149
+ vss
+ vdd
+ vdd
+ sky130_fd_sc_hd__fill_8
* cell instance sky130_fd_sc_hd__fill_8_1150 r0 *1 0,0
Xsky130_fd_sc_hd__fill_8_1150
+ vss
+ vdd
+ vdd
+ sky130_fd_sc_hd__fill_8
* cell instance sky130_fd_sc_hd__fill_8_1151 r0 *1 0,0
Xsky130_fd_sc_hd__fill_8_1151
+ vss
+ vdd
+ vdd
+ sky130_fd_sc_hd__fill_8
* cell instance sky130_fd_sc_hd__fill_8_1152 r0 *1 0,0
Xsky130_fd_sc_hd__fill_8_1152
+ vss
+ vdd
+ vdd
+ sky130_fd_sc_hd__fill_8
* cell instance sky130_fd_sc_hd__fill_8_1153 r0 *1 0,0
Xsky130_fd_sc_hd__fill_8_1153
+ vss
+ vdd
+ vdd
+ sky130_fd_sc_hd__fill_8
* cell instance sky130_fd_sc_hd__fill_8_1154 r0 *1 0,0
Xsky130_fd_sc_hd__fill_8_1154
+ vss
+ vdd
+ vdd
+ sky130_fd_sc_hd__fill_8
* cell instance sky130_fd_sc_hd__fill_8_1155 r0 *1 0,0
Xsky130_fd_sc_hd__fill_8_1155
+ vss
+ vdd
+ vdd
+ sky130_fd_sc_hd__fill_8
* cell instance sky130_fd_sc_hd__fill_8_1156 r0 *1 0,0
Xsky130_fd_sc_hd__fill_8_1156
+ vss
+ vdd
+ vdd
+ sky130_fd_sc_hd__fill_8
* cell instance sky130_fd_sc_hd__fill_8_1157 r0 *1 0,0
Xsky130_fd_sc_hd__fill_8_1157
+ vss
+ vdd
+ vdd
+ sky130_fd_sc_hd__fill_8
* cell instance sky130_fd_sc_hd__fill_8_1158 r0 *1 0,0
Xsky130_fd_sc_hd__fill_8_1158
+ vss
+ vdd
+ vdd
+ sky130_fd_sc_hd__fill_8
* cell instance sky130_fd_sc_hd__fill_8_1159 r0 *1 0,0
Xsky130_fd_sc_hd__fill_8_1159
+ vss
+ vdd
+ vdd
+ sky130_fd_sc_hd__fill_8
* cell instance sky130_fd_sc_hd__fill_8_1160 r0 *1 0,0
Xsky130_fd_sc_hd__fill_8_1160
+ vss
+ vdd
+ vdd
+ sky130_fd_sc_hd__fill_8
* cell instance sky130_fd_sc_hd__fill_8_1161 r0 *1 0,0
Xsky130_fd_sc_hd__fill_8_1161
+ vss
+ vdd
+ vdd
+ sky130_fd_sc_hd__fill_8
* cell instance sky130_fd_sc_hd__fill_8_1162 r0 *1 0,0
Xsky130_fd_sc_hd__fill_8_1162
+ vss
+ vdd
+ vdd
+ sky130_fd_sc_hd__fill_8
* cell instance sky130_fd_sc_hd__fill_8_1163 r0 *1 0,0
Xsky130_fd_sc_hd__fill_8_1163
+ vss
+ vdd
+ vdd
+ sky130_fd_sc_hd__fill_8
* cell instance sky130_fd_sc_hd__fill_8_1164 r0 *1 0,0
Xsky130_fd_sc_hd__fill_8_1164
+ vss
+ vdd
+ vdd
+ sky130_fd_sc_hd__fill_8
* cell instance sky130_fd_sc_hd__fill_8_1165 r0 *1 0,0
Xsky130_fd_sc_hd__fill_8_1165
+ vss
+ vdd
+ vdd
+ sky130_fd_sc_hd__fill_8
* cell instance sky130_fd_sc_hd__fill_8_1166 r0 *1 0,0
Xsky130_fd_sc_hd__fill_8_1166
+ vss
+ vdd
+ vdd
+ sky130_fd_sc_hd__fill_8
* cell instance sky130_fd_sc_hd__fill_8_1167 r0 *1 0,0
Xsky130_fd_sc_hd__fill_8_1167
+ vss
+ vdd
+ vdd
+ sky130_fd_sc_hd__fill_8
* cell instance sky130_fd_sc_hd__fill_8_1168 r0 *1 0,0
Xsky130_fd_sc_hd__fill_8_1168
+ vss
+ vdd
+ vdd
+ sky130_fd_sc_hd__fill_8
* cell instance sky130_fd_sc_hd__fill_8_1169 r0 *1 0,0
Xsky130_fd_sc_hd__fill_8_1169
+ vss
+ vdd
+ vdd
+ sky130_fd_sc_hd__fill_8
* cell instance sky130_fd_sc_hd__fill_8_1170 r0 *1 0,0
Xsky130_fd_sc_hd__fill_8_1170
+ vss
+ vdd
+ vdd
+ sky130_fd_sc_hd__fill_8
* cell instance sky130_fd_sc_hd__fill_8_1171 r0 *1 0,0
Xsky130_fd_sc_hd__fill_8_1171
+ vss
+ vdd
+ vdd
+ sky130_fd_sc_hd__fill_8
* cell instance sky130_fd_sc_hd__fill_8_1172 r0 *1 0,0
Xsky130_fd_sc_hd__fill_8_1172
+ vss
+ vdd
+ vdd
+ sky130_fd_sc_hd__fill_8
* cell instance sky130_fd_sc_hd__fill_8_1173 r0 *1 0,0
Xsky130_fd_sc_hd__fill_8_1173
+ vss
+ vdd
+ vdd
+ sky130_fd_sc_hd__fill_8
* cell instance sky130_fd_sc_hd__fill_8_1174 r0 *1 0,0
Xsky130_fd_sc_hd__fill_8_1174
+ vss
+ vdd
+ vdd
+ sky130_fd_sc_hd__fill_8
* cell instance sky130_fd_sc_hd__fill_8_1175 r0 *1 0,0
Xsky130_fd_sc_hd__fill_8_1175
+ vss
+ vdd
+ vdd
+ sky130_fd_sc_hd__fill_8
* cell instance sky130_fd_sc_hd__fill_8_1176 r0 *1 0,0
Xsky130_fd_sc_hd__fill_8_1176
+ vss
+ vdd
+ vdd
+ sky130_fd_sc_hd__fill_8
* cell instance sky130_fd_sc_hd__fill_8_1177 r0 *1 0,0
Xsky130_fd_sc_hd__fill_8_1177
+ vss
+ vdd
+ vdd
+ sky130_fd_sc_hd__fill_8
* cell instance sky130_fd_sc_hd__fill_8_1178 r0 *1 0,0
Xsky130_fd_sc_hd__fill_8_1178
+ vss
+ vdd
+ vdd
+ sky130_fd_sc_hd__fill_8
* cell instance sky130_fd_sc_hd__fill_8_1179 r0 *1 0,0
Xsky130_fd_sc_hd__fill_8_1179
+ vss
+ vdd
+ vdd
+ sky130_fd_sc_hd__fill_8
* cell instance sky130_fd_sc_hd__fill_8_1180 r0 *1 0,0
Xsky130_fd_sc_hd__fill_8_1180
+ vss
+ vdd
+ vdd
+ sky130_fd_sc_hd__fill_8
* cell instance sky130_fd_sc_hd__fill_8_1181 r0 *1 0,0
Xsky130_fd_sc_hd__fill_8_1181
+ vss
+ vdd
+ vdd
+ sky130_fd_sc_hd__fill_8
* cell instance sky130_fd_sc_hd__fill_8_1182 r0 *1 0,0
Xsky130_fd_sc_hd__fill_8_1182
+ vss
+ vdd
+ vdd
+ sky130_fd_sc_hd__fill_8
* cell instance sky130_fd_sc_hd__fill_8_1183 r0 *1 0,0
Xsky130_fd_sc_hd__fill_8_1183
+ vss
+ vdd
+ vdd
+ sky130_fd_sc_hd__fill_8
* cell instance sky130_fd_sc_hd__fill_8_1184 r0 *1 0,0
Xsky130_fd_sc_hd__fill_8_1184
+ vss
+ vdd
+ vdd
+ sky130_fd_sc_hd__fill_8
* cell instance sky130_fd_sc_hd__fill_8_1185 r0 *1 0,0
Xsky130_fd_sc_hd__fill_8_1185
+ vss
+ vdd
+ vdd
+ sky130_fd_sc_hd__fill_8
* cell instance sky130_fd_sc_hd__fill_8_1186 r0 *1 0,0
Xsky130_fd_sc_hd__fill_8_1186
+ vss
+ vdd
+ vdd
+ sky130_fd_sc_hd__fill_8
* cell instance sky130_fd_sc_hd__fill_8_1187 r0 *1 0,0
Xsky130_fd_sc_hd__fill_8_1187
+ vss
+ vdd
+ vdd
+ sky130_fd_sc_hd__fill_8
* cell instance sky130_fd_sc_hd__fill_8_1188 r0 *1 0,0
Xsky130_fd_sc_hd__fill_8_1188
+ vss
+ vdd
+ vdd
+ sky130_fd_sc_hd__fill_8
* cell instance sky130_fd_sc_hd__fill_8_1189 r0 *1 0,0
Xsky130_fd_sc_hd__fill_8_1189
+ vss
+ vdd
+ vdd
+ sky130_fd_sc_hd__fill_8
* cell instance sky130_fd_sc_hd__fill_8_1190 r0 *1 0,0
Xsky130_fd_sc_hd__fill_8_1190
+ vss
+ vdd
+ vdd
+ sky130_fd_sc_hd__fill_8
* cell instance sky130_fd_sc_hd__fill_8_1191 r0 *1 0,0
Xsky130_fd_sc_hd__fill_8_1191
+ vss
+ vdd
+ vdd
+ sky130_fd_sc_hd__fill_8
* cell instance sky130_fd_sc_hd__fill_8_1192 r0 *1 0,0
Xsky130_fd_sc_hd__fill_8_1192
+ vss
+ vdd
+ vdd
+ sky130_fd_sc_hd__fill_8
* cell instance sky130_fd_sc_hd__fill_8_1193 r0 *1 0,0
Xsky130_fd_sc_hd__fill_8_1193
+ vss
+ vdd
+ vdd
+ sky130_fd_sc_hd__fill_8
* cell instance sky130_fd_sc_hd__fill_8_1194 r0 *1 0,0
Xsky130_fd_sc_hd__fill_8_1194
+ vss
+ vdd
+ vdd
+ sky130_fd_sc_hd__fill_8
* cell instance sky130_fd_sc_hd__fill_8_1195 r0 *1 0,0
Xsky130_fd_sc_hd__fill_8_1195
+ vss
+ vdd
+ vdd
+ sky130_fd_sc_hd__fill_8
* cell instance sky130_fd_sc_hd__fill_8_1196 r0 *1 0,0
Xsky130_fd_sc_hd__fill_8_1196
+ vss
+ vdd
+ vdd
+ sky130_fd_sc_hd__fill_8
* cell instance sky130_fd_sc_hd__fill_8_1197 r0 *1 0,0
Xsky130_fd_sc_hd__fill_8_1197
+ vss
+ vdd
+ vdd
+ sky130_fd_sc_hd__fill_8
* cell instance sky130_fd_sc_hd__fill_8_1198 r0 *1 0,0
Xsky130_fd_sc_hd__fill_8_1198
+ vss
+ vdd
+ vdd
+ sky130_fd_sc_hd__fill_8
* cell instance sky130_fd_sc_hd__fill_8_1199 r0 *1 0,0
Xsky130_fd_sc_hd__fill_8_1199
+ vss
+ vdd
+ vdd
+ sky130_fd_sc_hd__fill_8
* cell instance sky130_fd_sc_hd__fill_8_1200 r0 *1 0,0
Xsky130_fd_sc_hd__fill_8_1200
+ vss
+ vdd
+ vdd
+ sky130_fd_sc_hd__fill_8
* cell instance sky130_fd_sc_hd__fill_8_1201 r0 *1 0,0
Xsky130_fd_sc_hd__fill_8_1201
+ vss
+ vdd
+ vdd
+ sky130_fd_sc_hd__fill_8
* cell instance sky130_fd_sc_hd__fill_8_1202 r0 *1 0,0
Xsky130_fd_sc_hd__fill_8_1202
+ vss
+ vdd
+ vdd
+ sky130_fd_sc_hd__fill_8
* cell instance sky130_fd_sc_hd__fill_8_1203 r0 *1 0,0
Xsky130_fd_sc_hd__fill_8_1203
+ vss
+ vdd
+ vdd
+ sky130_fd_sc_hd__fill_8
* cell instance sky130_fd_sc_hd__fill_8_1204 r0 *1 0,0
Xsky130_fd_sc_hd__fill_8_1204
+ vss
+ vdd
+ vdd
+ sky130_fd_sc_hd__fill_8
* cell instance sky130_fd_sc_hd__fill_8_1205 r0 *1 0,0
Xsky130_fd_sc_hd__fill_8_1205
+ vss
+ vdd
+ vdd
+ sky130_fd_sc_hd__fill_8
* cell instance sky130_fd_sc_hd__fill_8_1206 r0 *1 0,0
Xsky130_fd_sc_hd__fill_8_1206
+ vss
+ vdd
+ vdd
+ sky130_fd_sc_hd__fill_8
* cell instance sky130_fd_sc_hd__fill_8_1207 r0 *1 0,0
Xsky130_fd_sc_hd__fill_8_1207
+ vss
+ vdd
+ vdd
+ sky130_fd_sc_hd__fill_8
* cell instance sky130_fd_sc_hd__fill_8_1208 r0 *1 0,0
Xsky130_fd_sc_hd__fill_8_1208
+ vss
+ vdd
+ vdd
+ sky130_fd_sc_hd__fill_8
* cell instance sky130_fd_sc_hd__fill_8_1209 r0 *1 0,0
Xsky130_fd_sc_hd__fill_8_1209
+ vss
+ vdd
+ vdd
+ sky130_fd_sc_hd__fill_8
* cell instance sky130_fd_sc_hd__fill_8_1210 r0 *1 0,0
Xsky130_fd_sc_hd__fill_8_1210
+ vss
+ vdd
+ vdd
+ sky130_fd_sc_hd__fill_8
* cell instance sky130_fd_sc_hd__fill_8_1211 r0 *1 0,0
Xsky130_fd_sc_hd__fill_8_1211
+ vss
+ vdd
+ vdd
+ sky130_fd_sc_hd__fill_8
* cell instance sky130_fd_sc_hd__fill_8_1212 r0 *1 0,0
Xsky130_fd_sc_hd__fill_8_1212
+ vss
+ vdd
+ vdd
+ sky130_fd_sc_hd__fill_8
* cell instance sky130_fd_sc_hd__fill_8_1213 r0 *1 0,0
Xsky130_fd_sc_hd__fill_8_1213
+ vss
+ vdd
+ vdd
+ sky130_fd_sc_hd__fill_8
* cell instance sky130_fd_sc_hd__fill_8_1214 r0 *1 0,0
Xsky130_fd_sc_hd__fill_8_1214
+ vss
+ vdd
+ vdd
+ sky130_fd_sc_hd__fill_8
* cell instance sky130_fd_sc_hd__fill_8_1215 r0 *1 0,0
Xsky130_fd_sc_hd__fill_8_1215
+ vss
+ vdd
+ vdd
+ sky130_fd_sc_hd__fill_8
* cell instance sky130_fd_sc_hd__fill_8_1216 r0 *1 0,0
Xsky130_fd_sc_hd__fill_8_1216
+ vss
+ vdd
+ vdd
+ sky130_fd_sc_hd__fill_8
* cell instance sky130_fd_sc_hd__fill_8_1217 r0 *1 0,0
Xsky130_fd_sc_hd__fill_8_1217
+ vss
+ vdd
+ vdd
+ sky130_fd_sc_hd__fill_8
* cell instance sky130_fd_sc_hd__fill_8_1218 r0 *1 0,0
Xsky130_fd_sc_hd__fill_8_1218
+ vss
+ vdd
+ vdd
+ sky130_fd_sc_hd__fill_8
* cell instance sky130_fd_sc_hd__fill_8_1219 r0 *1 0,0
Xsky130_fd_sc_hd__fill_8_1219
+ vss
+ vdd
+ vdd
+ sky130_fd_sc_hd__fill_8
* cell instance sky130_fd_sc_hd__fill_8_1220 r0 *1 0,0
Xsky130_fd_sc_hd__fill_8_1220
+ vss
+ vdd
+ vdd
+ sky130_fd_sc_hd__fill_8
* cell instance sky130_fd_sc_hd__fill_8_1221 r0 *1 0,0
Xsky130_fd_sc_hd__fill_8_1221
+ vss
+ vdd
+ vdd
+ sky130_fd_sc_hd__fill_8
* cell instance sky130_fd_sc_hd__fill_8_1222 r0 *1 0,0
Xsky130_fd_sc_hd__fill_8_1222
+ vss
+ vdd
+ vdd
+ sky130_fd_sc_hd__fill_8
* cell instance sky130_fd_sc_hd__fill_8_1223 r0 *1 0,0
Xsky130_fd_sc_hd__fill_8_1223
+ vss
+ vdd
+ vdd
+ sky130_fd_sc_hd__fill_8
* cell instance sky130_fd_sc_hd__fill_8_1224 r0 *1 0,0
Xsky130_fd_sc_hd__fill_8_1224
+ vss
+ vdd
+ vdd
+ sky130_fd_sc_hd__fill_8
* cell instance sky130_fd_sc_hd__fill_8_1225 r0 *1 0,0
Xsky130_fd_sc_hd__fill_8_1225
+ vss
+ vdd
+ vdd
+ sky130_fd_sc_hd__fill_8
* cell instance sky130_fd_sc_hd__fill_8_1226 r0 *1 0,0
Xsky130_fd_sc_hd__fill_8_1226
+ vss
+ vdd
+ vdd
+ sky130_fd_sc_hd__fill_8
* cell instance sky130_fd_sc_hd__fill_8_1227 r0 *1 0,0
Xsky130_fd_sc_hd__fill_8_1227
+ vss
+ vdd
+ vdd
+ sky130_fd_sc_hd__fill_8
* cell instance sky130_fd_sc_hd__fill_8_1228 r0 *1 0,0
Xsky130_fd_sc_hd__fill_8_1228
+ vss
+ vdd
+ vdd
+ sky130_fd_sc_hd__fill_8
* cell instance sky130_fd_sc_hd__fill_8_1229 r0 *1 0,0
Xsky130_fd_sc_hd__fill_8_1229
+ vss
+ vdd
+ vdd
+ sky130_fd_sc_hd__fill_8
* cell instance sky130_fd_sc_hd__fill_8_1230 r0 *1 0,0
Xsky130_fd_sc_hd__fill_8_1230
+ vss
+ vdd
+ vdd
+ sky130_fd_sc_hd__fill_8
* cell instance sky130_fd_sc_hd__fill_8_1231 r0 *1 0,0
Xsky130_fd_sc_hd__fill_8_1231
+ vss
+ vdd
+ vdd
+ sky130_fd_sc_hd__fill_8
* cell instance sky130_fd_sc_hd__fill_8_1232 r0 *1 0,0
Xsky130_fd_sc_hd__fill_8_1232
+ vss
+ vdd
+ vdd
+ sky130_fd_sc_hd__fill_8
* cell instance sky130_fd_sc_hd__fill_8_1233 r0 *1 0,0
Xsky130_fd_sc_hd__fill_8_1233
+ vss
+ vdd
+ vdd
+ sky130_fd_sc_hd__fill_8
* cell instance sky130_fd_sc_hd__fill_8_1234 r0 *1 0,0
Xsky130_fd_sc_hd__fill_8_1234
+ vss
+ vdd
+ vdd
+ sky130_fd_sc_hd__fill_8
* cell instance sky130_fd_sc_hd__fill_8_1235 r0 *1 0,0
Xsky130_fd_sc_hd__fill_8_1235
+ vss
+ vdd
+ vdd
+ sky130_fd_sc_hd__fill_8
* cell instance sky130_fd_sc_hd__fill_8_1236 r0 *1 0,0
Xsky130_fd_sc_hd__fill_8_1236
+ vss
+ vdd
+ vdd
+ sky130_fd_sc_hd__fill_8
* cell instance sky130_fd_sc_hd__fill_8_1237 r0 *1 0,0
Xsky130_fd_sc_hd__fill_8_1237
+ vss
+ vdd
+ vdd
+ sky130_fd_sc_hd__fill_8
* cell instance sky130_fd_sc_hd__fill_8_1238 r0 *1 0,0
Xsky130_fd_sc_hd__fill_8_1238
+ vss
+ vdd
+ vdd
+ sky130_fd_sc_hd__fill_8
* cell instance sky130_fd_sc_hd__fill_8_1239 r0 *1 0,0
Xsky130_fd_sc_hd__fill_8_1239
+ vss
+ vdd
+ vdd
+ sky130_fd_sc_hd__fill_8
* cell instance sky130_fd_sc_hd__fill_8_1240 r0 *1 0,0
Xsky130_fd_sc_hd__fill_8_1240
+ vss
+ vdd
+ vdd
+ sky130_fd_sc_hd__fill_8
* cell instance sky130_fd_sc_hd__fill_8_1241 r0 *1 0,0
Xsky130_fd_sc_hd__fill_8_1241
+ vss
+ vdd
+ vdd
+ sky130_fd_sc_hd__fill_8
* cell instance sky130_fd_sc_hd__fill_8_1242 r0 *1 0,0
Xsky130_fd_sc_hd__fill_8_1242
+ vss
+ vdd
+ vdd
+ sky130_fd_sc_hd__fill_8
* cell instance sky130_fd_sc_hd__fill_8_1243 r0 *1 0,0
Xsky130_fd_sc_hd__fill_8_1243
+ vss
+ vdd
+ vdd
+ sky130_fd_sc_hd__fill_8
* cell instance sky130_fd_sc_hd__fill_8_1244 r0 *1 0,0
Xsky130_fd_sc_hd__fill_8_1244
+ vss
+ vdd
+ vdd
+ sky130_fd_sc_hd__fill_8
* cell instance sky130_fd_sc_hd__fill_8_1245 r0 *1 0,0
Xsky130_fd_sc_hd__fill_8_1245
+ vss
+ vdd
+ vdd
+ sky130_fd_sc_hd__fill_8
* cell instance sky130_fd_sc_hd__fill_8_1246 r0 *1 0,0
Xsky130_fd_sc_hd__fill_8_1246
+ vss
+ vdd
+ vdd
+ sky130_fd_sc_hd__fill_8
* cell instance sky130_fd_sc_hd__fill_8_1247 r0 *1 0,0
Xsky130_fd_sc_hd__fill_8_1247
+ vss
+ vdd
+ vdd
+ sky130_fd_sc_hd__fill_8
* cell instance sky130_fd_sc_hd__fill_8_1248 r0 *1 0,0
Xsky130_fd_sc_hd__fill_8_1248
+ vss
+ vdd
+ vdd
+ sky130_fd_sc_hd__fill_8
* cell instance sky130_fd_sc_hd__fill_8_1249 r0 *1 0,0
Xsky130_fd_sc_hd__fill_8_1249
+ vss
+ vdd
+ vdd
+ sky130_fd_sc_hd__fill_8
* cell instance sky130_fd_sc_hd__fill_8_1250 r0 *1 0,0
Xsky130_fd_sc_hd__fill_8_1250
+ vss
+ vdd
+ vdd
+ sky130_fd_sc_hd__fill_8
* cell instance sky130_fd_sc_hd__fill_8_1251 r0 *1 0,0
Xsky130_fd_sc_hd__fill_8_1251
+ vss
+ vdd
+ vdd
+ sky130_fd_sc_hd__fill_8
* cell instance sky130_fd_sc_hd__fill_8_1252 r0 *1 0,0
Xsky130_fd_sc_hd__fill_8_1252
+ vss
+ vdd
+ vdd
+ sky130_fd_sc_hd__fill_8
* cell instance sky130_fd_sc_hd__fill_8_1253 r0 *1 0,0
Xsky130_fd_sc_hd__fill_8_1253
+ vss
+ vdd
+ vdd
+ sky130_fd_sc_hd__fill_8
* cell instance sky130_fd_sc_hd__fill_8_1254 r0 *1 0,0
Xsky130_fd_sc_hd__fill_8_1254
+ vss
+ vdd
+ vdd
+ sky130_fd_sc_hd__fill_8
* cell instance sky130_fd_sc_hd__fill_8_1255 r0 *1 0,0
Xsky130_fd_sc_hd__fill_8_1255
+ vss
+ vdd
+ vdd
+ sky130_fd_sc_hd__fill_8
* cell instance sky130_fd_sc_hd__fill_8_1256 r0 *1 0,0
Xsky130_fd_sc_hd__fill_8_1256
+ vss
+ vdd
+ vdd
+ sky130_fd_sc_hd__fill_8
* cell instance sky130_fd_sc_hd__fill_8_1257 r0 *1 0,0
Xsky130_fd_sc_hd__fill_8_1257
+ vss
+ vdd
+ vdd
+ sky130_fd_sc_hd__fill_8
* cell instance sky130_fd_sc_hd__fill_8_1258 r0 *1 0,0
Xsky130_fd_sc_hd__fill_8_1258
+ vss
+ vdd
+ vdd
+ sky130_fd_sc_hd__fill_8
* cell instance sky130_fd_sc_hd__fill_8_1259 r0 *1 0,0
Xsky130_fd_sc_hd__fill_8_1259
+ vss
+ vdd
+ vdd
+ sky130_fd_sc_hd__fill_8
* cell instance sky130_fd_sc_hd__fill_8_1260 r0 *1 0,0
Xsky130_fd_sc_hd__fill_8_1260
+ vss
+ vdd
+ vdd
+ sky130_fd_sc_hd__fill_8
* cell instance sky130_fd_sc_hd__fill_8_1261 r0 *1 0,0
Xsky130_fd_sc_hd__fill_8_1261
+ vss
+ vdd
+ vdd
+ sky130_fd_sc_hd__fill_8
* cell instance sky130_fd_sc_hd__fill_8_1262 r0 *1 0,0
Xsky130_fd_sc_hd__fill_8_1262
+ vss
+ vdd
+ vdd
+ sky130_fd_sc_hd__fill_8
* cell instance sky130_fd_sc_hd__fill_8_1263 r0 *1 0,0
Xsky130_fd_sc_hd__fill_8_1263
+ vss
+ vdd
+ vdd
+ sky130_fd_sc_hd__fill_8
* cell instance sky130_fd_sc_hd__fill_8_1264 r0 *1 0,0
Xsky130_fd_sc_hd__fill_8_1264
+ vss
+ vdd
+ vdd
+ sky130_fd_sc_hd__fill_8
* cell instance sky130_fd_sc_hd__fill_8_1265 r0 *1 0,0
Xsky130_fd_sc_hd__fill_8_1265
+ vss
+ vdd
+ vdd
+ sky130_fd_sc_hd__fill_8
* cell instance sky130_fd_sc_hd__fill_8_1266 r0 *1 0,0
Xsky130_fd_sc_hd__fill_8_1266
+ vss
+ vdd
+ vdd
+ sky130_fd_sc_hd__fill_8
* cell instance sky130_fd_sc_hd__fill_8_1267 r0 *1 0,0
Xsky130_fd_sc_hd__fill_8_1267
+ vss
+ vdd
+ vdd
+ sky130_fd_sc_hd__fill_8
* cell instance sky130_fd_sc_hd__fill_8_1268 r0 *1 0,0
Xsky130_fd_sc_hd__fill_8_1268
+ vss
+ vdd
+ vdd
+ sky130_fd_sc_hd__fill_8
* cell instance sky130_fd_sc_hd__fill_8_1269 r0 *1 0,0
Xsky130_fd_sc_hd__fill_8_1269
+ vss
+ vdd
+ vdd
+ sky130_fd_sc_hd__fill_8
* cell instance sky130_fd_sc_hd__fill_8_1270 r0 *1 0,0
Xsky130_fd_sc_hd__fill_8_1270
+ vss
+ vdd
+ vdd
+ sky130_fd_sc_hd__fill_8
* cell instance sky130_fd_sc_hd__fill_8_1271 r0 *1 0,0
Xsky130_fd_sc_hd__fill_8_1271
+ vss
+ vdd
+ vdd
+ sky130_fd_sc_hd__fill_8
* cell instance sky130_fd_sc_hd__fill_8_1272 r0 *1 0,0
Xsky130_fd_sc_hd__fill_8_1272
+ vss
+ vdd
+ vdd
+ sky130_fd_sc_hd__fill_8
* cell instance sky130_fd_sc_hd__fill_8_1273 r0 *1 0,0
Xsky130_fd_sc_hd__fill_8_1273
+ vss
+ vdd
+ vdd
+ sky130_fd_sc_hd__fill_8
* cell instance sky130_fd_sc_hd__fill_8_1274 r0 *1 0,0
Xsky130_fd_sc_hd__fill_8_1274
+ vss
+ vdd
+ vdd
+ sky130_fd_sc_hd__fill_8
* cell instance sky130_fd_sc_hd__fill_8_1275 r0 *1 0,0
Xsky130_fd_sc_hd__fill_8_1275
+ vss
+ vdd
+ vdd
+ sky130_fd_sc_hd__fill_8
* cell instance sky130_fd_sc_hd__fill_8_1276 r0 *1 0,0
Xsky130_fd_sc_hd__fill_8_1276
+ vss
+ vdd
+ vdd
+ sky130_fd_sc_hd__fill_8
* cell instance sky130_fd_sc_hd__fill_8_1277 r0 *1 0,0
Xsky130_fd_sc_hd__fill_8_1277
+ vss
+ vdd
+ vdd
+ sky130_fd_sc_hd__fill_8
* cell instance sky130_fd_sc_hd__fill_8_1278 r0 *1 0,0
Xsky130_fd_sc_hd__fill_8_1278
+ vss
+ vdd
+ vdd
+ sky130_fd_sc_hd__fill_8
* cell instance sky130_fd_sc_hd__fill_8_1279 r0 *1 0,0
Xsky130_fd_sc_hd__fill_8_1279
+ vss
+ vdd
+ vdd
+ sky130_fd_sc_hd__fill_8
* cell instance sky130_fd_sc_hd__fill_8_1280 r0 *1 0,0
Xsky130_fd_sc_hd__fill_8_1280
+ vss
+ vdd
+ vdd
+ sky130_fd_sc_hd__fill_8
* cell instance sky130_fd_sc_hd__fill_8_1281 r0 *1 0,0
Xsky130_fd_sc_hd__fill_8_1281
+ vss
+ vdd
+ vdd
+ sky130_fd_sc_hd__fill_8
* cell instance sky130_fd_sc_hd__fill_8_1282 r0 *1 0,0
Xsky130_fd_sc_hd__fill_8_1282
+ vss
+ vdd
+ vdd
+ sky130_fd_sc_hd__fill_8
* cell instance sky130_fd_sc_hd__fill_8_1283 r0 *1 0,0
Xsky130_fd_sc_hd__fill_8_1283
+ vss
+ vdd
+ vdd
+ sky130_fd_sc_hd__fill_8
* cell instance sky130_fd_sc_hd__fill_8_1284 r0 *1 0,0
Xsky130_fd_sc_hd__fill_8_1284
+ vss
+ vdd
+ vdd
+ sky130_fd_sc_hd__fill_8
* cell instance sky130_fd_sc_hd__fill_8_1285 r0 *1 0,0
Xsky130_fd_sc_hd__fill_8_1285
+ vss
+ vdd
+ vdd
+ sky130_fd_sc_hd__fill_8
* cell instance sky130_fd_sc_hd__fill_8_1286 r0 *1 0,0
Xsky130_fd_sc_hd__fill_8_1286
+ vss
+ vdd
+ vdd
+ sky130_fd_sc_hd__fill_8
* cell instance sky130_fd_sc_hd__fill_8_1287 r0 *1 0,0
Xsky130_fd_sc_hd__fill_8_1287
+ vss
+ vdd
+ vdd
+ sky130_fd_sc_hd__fill_8
* cell instance sky130_fd_sc_hd__fill_8_1288 r0 *1 0,0
Xsky130_fd_sc_hd__fill_8_1288
+ vss
+ vdd
+ vdd
+ sky130_fd_sc_hd__fill_8
* cell instance sky130_fd_sc_hd__fill_8_1289 r0 *1 0,0
Xsky130_fd_sc_hd__fill_8_1289
+ vss
+ vdd
+ vdd
+ sky130_fd_sc_hd__fill_8
* cell instance sky130_fd_sc_hd__fill_8_1290 r0 *1 0,0
Xsky130_fd_sc_hd__fill_8_1290
+ vss
+ vdd
+ vdd
+ sky130_fd_sc_hd__fill_8
* cell instance sky130_fd_sc_hd__fill_8_1291 r0 *1 0,0
Xsky130_fd_sc_hd__fill_8_1291
+ vss
+ vdd
+ vdd
+ sky130_fd_sc_hd__fill_8
* cell instance sky130_fd_sc_hd__fill_8_1292 r0 *1 0,0
Xsky130_fd_sc_hd__fill_8_1292
+ vss
+ vdd
+ vdd
+ sky130_fd_sc_hd__fill_8
* cell instance sky130_fd_sc_hd__fill_8_1293 r0 *1 0,0
Xsky130_fd_sc_hd__fill_8_1293
+ vss
+ vdd
+ vdd
+ sky130_fd_sc_hd__fill_8
* cell instance sky130_fd_sc_hd__fill_8_1294 r0 *1 0,0
Xsky130_fd_sc_hd__fill_8_1294
+ vss
+ vdd
+ vdd
+ sky130_fd_sc_hd__fill_8
* cell instance sky130_fd_sc_hd__fill_8_1295 r0 *1 0,0
Xsky130_fd_sc_hd__fill_8_1295
+ vss
+ vdd
+ vdd
+ sky130_fd_sc_hd__fill_8
* cell instance sky130_fd_sc_hd__fill_8_1296 r0 *1 0,0
Xsky130_fd_sc_hd__fill_8_1296
+ vss
+ vdd
+ vdd
+ sky130_fd_sc_hd__fill_8
* cell instance sky130_fd_sc_hd__fill_8_1297 r0 *1 0,0
Xsky130_fd_sc_hd__fill_8_1297
+ vss
+ vdd
+ vdd
+ sky130_fd_sc_hd__fill_8
* cell instance sky130_fd_sc_hd__fill_8_1298 r0 *1 0,0
Xsky130_fd_sc_hd__fill_8_1298
+ vss
+ vdd
+ vdd
+ sky130_fd_sc_hd__fill_8
* cell instance sky130_fd_sc_hd__fill_8_1299 r0 *1 0,0
Xsky130_fd_sc_hd__fill_8_1299
+ vss
+ vdd
+ vdd
+ sky130_fd_sc_hd__fill_8
* cell instance sky130_fd_sc_hd__fill_8_1300 r0 *1 0,0
Xsky130_fd_sc_hd__fill_8_1300
+ vss
+ vdd
+ vdd
+ sky130_fd_sc_hd__fill_8
* cell instance sky130_fd_sc_hd__fill_8_1301 r0 *1 0,0
Xsky130_fd_sc_hd__fill_8_1301
+ vss
+ vdd
+ vdd
+ sky130_fd_sc_hd__fill_8
* cell instance sky130_fd_sc_hd__fill_8_1302 r0 *1 0,0
Xsky130_fd_sc_hd__fill_8_1302
+ vss
+ vdd
+ vdd
+ sky130_fd_sc_hd__fill_8
* cell instance sky130_fd_sc_hd__fill_8_1303 r0 *1 0,0
Xsky130_fd_sc_hd__fill_8_1303
+ vss
+ vdd
+ vdd
+ sky130_fd_sc_hd__fill_8
* cell instance sky130_fd_sc_hd__fill_8_1304 r0 *1 0,0
Xsky130_fd_sc_hd__fill_8_1304
+ vss
+ vdd
+ vdd
+ sky130_fd_sc_hd__fill_8
* cell instance sky130_fd_sc_hd__fill_8_1305 r0 *1 0,0
Xsky130_fd_sc_hd__fill_8_1305
+ vss
+ vdd
+ vdd
+ sky130_fd_sc_hd__fill_8
* cell instance sky130_fd_sc_hd__fill_8_1306 r0 *1 0,0
Xsky130_fd_sc_hd__fill_8_1306
+ vss
+ vdd
+ vdd
+ sky130_fd_sc_hd__fill_8
* cell instance sky130_fd_sc_hd__fill_8_1307 r0 *1 0,0
Xsky130_fd_sc_hd__fill_8_1307
+ vss
+ vdd
+ vdd
+ sky130_fd_sc_hd__fill_8
* cell instance sky130_fd_sc_hd__fill_8_1308 r0 *1 0,0
Xsky130_fd_sc_hd__fill_8_1308
+ vss
+ vdd
+ vdd
+ sky130_fd_sc_hd__fill_8
* cell instance sky130_fd_sc_hd__fill_8_1309 r0 *1 0,0
Xsky130_fd_sc_hd__fill_8_1309
+ vss
+ vdd
+ vdd
+ sky130_fd_sc_hd__fill_8
* cell instance sky130_fd_sc_hd__fill_8_1310 r0 *1 0,0
Xsky130_fd_sc_hd__fill_8_1310
+ vss
+ vdd
+ vdd
+ sky130_fd_sc_hd__fill_8
* cell instance sky130_fd_sc_hd__fill_8_1311 r0 *1 0,0
Xsky130_fd_sc_hd__fill_8_1311
+ vss
+ vdd
+ vdd
+ sky130_fd_sc_hd__fill_8
* cell instance sky130_fd_sc_hd__fill_8_1312 r0 *1 0,0
Xsky130_fd_sc_hd__fill_8_1312
+ vss
+ vdd
+ vdd
+ sky130_fd_sc_hd__fill_8
* cell instance sky130_fd_sc_hd__fill_8_1313 r0 *1 0,0
Xsky130_fd_sc_hd__fill_8_1313
+ vss
+ vdd
+ vdd
+ sky130_fd_sc_hd__fill_8
* cell instance sky130_fd_sc_hd__fill_8_1314 r0 *1 0,0
Xsky130_fd_sc_hd__fill_8_1314
+ vss
+ vdd
+ vdd
+ sky130_fd_sc_hd__fill_8
* cell instance sky130_fd_sc_hd__fill_8_1315 r0 *1 0,0
Xsky130_fd_sc_hd__fill_8_1315
+ vss
+ vdd
+ vdd
+ sky130_fd_sc_hd__fill_8
* cell instance sky130_fd_sc_hd__fill_8_1316 r0 *1 0,0
Xsky130_fd_sc_hd__fill_8_1316
+ vss
+ vdd
+ vdd
+ sky130_fd_sc_hd__fill_8
* cell instance sky130_fd_sc_hd__fill_8_1317 r0 *1 0,0
Xsky130_fd_sc_hd__fill_8_1317
+ vss
+ vdd
+ vdd
+ sky130_fd_sc_hd__fill_8
* cell instance sky130_fd_sc_hd__fill_8_1318 r0 *1 0,0
Xsky130_fd_sc_hd__fill_8_1318
+ vss
+ vdd
+ vdd
+ sky130_fd_sc_hd__fill_8
* cell instance sky130_fd_sc_hd__fill_8_1319 r0 *1 0,0
Xsky130_fd_sc_hd__fill_8_1319
+ vss
+ vdd
+ vdd
+ sky130_fd_sc_hd__fill_8
* cell instance sky130_fd_sc_hd__fill_8_1320 r0 *1 0,0
Xsky130_fd_sc_hd__fill_8_1320
+ vss
+ vdd
+ vdd
+ sky130_fd_sc_hd__fill_8
* cell instance sky130_fd_sc_hd__fill_8_1321 r0 *1 0,0
Xsky130_fd_sc_hd__fill_8_1321
+ vss
+ vdd
+ vdd
+ sky130_fd_sc_hd__fill_8
* cell instance sky130_fd_sc_hd__fill_8_1322 r0 *1 0,0
Xsky130_fd_sc_hd__fill_8_1322
+ vss
+ vdd
+ vdd
+ sky130_fd_sc_hd__fill_8
* cell instance sky130_fd_sc_hd__fill_8_1323 r0 *1 0,0
Xsky130_fd_sc_hd__fill_8_1323
+ vss
+ vdd
+ vdd
+ sky130_fd_sc_hd__fill_8
* cell instance sky130_fd_sc_hd__fill_8_1324 r0 *1 0,0
Xsky130_fd_sc_hd__fill_8_1324
+ vss
+ vdd
+ vdd
+ sky130_fd_sc_hd__fill_8
* cell instance sky130_fd_sc_hd__fill_8_1325 r0 *1 0,0
Xsky130_fd_sc_hd__fill_8_1325
+ vss
+ vdd
+ vdd
+ sky130_fd_sc_hd__fill_8
* cell instance sky130_fd_sc_hd__fill_8_1326 r0 *1 0,0
Xsky130_fd_sc_hd__fill_8_1326
+ vss
+ vdd
+ vdd
+ sky130_fd_sc_hd__fill_8
* cell instance sky130_fd_sc_hd__fill_8_1327 r0 *1 0,0
Xsky130_fd_sc_hd__fill_8_1327
+ vss
+ vdd
+ vdd
+ sky130_fd_sc_hd__fill_8
* cell instance sky130_fd_sc_hd__fill_8_1328 r0 *1 0,0
Xsky130_fd_sc_hd__fill_8_1328
+ vss
+ vdd
+ vdd
+ sky130_fd_sc_hd__fill_8
* cell instance sky130_fd_sc_hd__fill_8_1329 r0 *1 0,0
Xsky130_fd_sc_hd__fill_8_1329
+ vss
+ vdd
+ vdd
+ sky130_fd_sc_hd__fill_8
* cell instance sky130_fd_sc_hd__fill_8_1330 r0 *1 0,0
Xsky130_fd_sc_hd__fill_8_1330
+ vss
+ vdd
+ vdd
+ sky130_fd_sc_hd__fill_8
* cell instance sky130_fd_sc_hd__fill_8_1331 r0 *1 0,0
Xsky130_fd_sc_hd__fill_8_1331
+ vss
+ vdd
+ vdd
+ sky130_fd_sc_hd__fill_8
* cell instance sky130_fd_sc_hd__fill_8_1332 r0 *1 0,0
Xsky130_fd_sc_hd__fill_8_1332
+ vss
+ vdd
+ vdd
+ sky130_fd_sc_hd__fill_8
* cell instance sky130_fd_sc_hd__fill_8_1333 r0 *1 0,0
Xsky130_fd_sc_hd__fill_8_1333
+ vss
+ vdd
+ vdd
+ sky130_fd_sc_hd__fill_8
* cell instance sky130_fd_sc_hd__fill_8_1334 r0 *1 0,0
Xsky130_fd_sc_hd__fill_8_1334
+ vss
+ vdd
+ vdd
+ sky130_fd_sc_hd__fill_8
* cell instance sky130_fd_sc_hd__fill_8_1335 r0 *1 0,0
Xsky130_fd_sc_hd__fill_8_1335
+ vss
+ vdd
+ vdd
+ sky130_fd_sc_hd__fill_8
* cell instance sky130_fd_sc_hd__fill_8_1336 r0 *1 0,0
Xsky130_fd_sc_hd__fill_8_1336
+ vss
+ vdd
+ vdd
+ sky130_fd_sc_hd__fill_8
* cell instance sky130_fd_sc_hd__fill_8_1337 r0 *1 0,0
Xsky130_fd_sc_hd__fill_8_1337
+ vss
+ vdd
+ vdd
+ sky130_fd_sc_hd__fill_8
* cell instance sky130_fd_sc_hd__fill_8_1338 r0 *1 0,0
Xsky130_fd_sc_hd__fill_8_1338
+ vss
+ vdd
+ vdd
+ sky130_fd_sc_hd__fill_8
* cell instance sky130_fd_sc_hd__fill_8_1339 r0 *1 0,0
Xsky130_fd_sc_hd__fill_8_1339
+ vss
+ vdd
+ vdd
+ sky130_fd_sc_hd__fill_8
* cell instance sky130_fd_sc_hd__fill_8_1340 r0 *1 0,0
Xsky130_fd_sc_hd__fill_8_1340
+ vss
+ vdd
+ vdd
+ sky130_fd_sc_hd__fill_8
* cell instance sky130_fd_sc_hd__fill_8_1341 r0 *1 0,0
Xsky130_fd_sc_hd__fill_8_1341
+ vss
+ vdd
+ vdd
+ sky130_fd_sc_hd__fill_8
* cell instance sky130_fd_sc_hd__fill_8_1342 r0 *1 0,0
Xsky130_fd_sc_hd__fill_8_1342
+ vss
+ vdd
+ vdd
+ sky130_fd_sc_hd__fill_8
* cell instance sky130_fd_sc_hd__fill_8_1343 r0 *1 0,0
Xsky130_fd_sc_hd__fill_8_1343
+ vss
+ vdd
+ vdd
+ sky130_fd_sc_hd__fill_8
* cell instance sky130_fd_sc_hd__fill_8_1344 r0 *1 0,0
Xsky130_fd_sc_hd__fill_8_1344
+ vss
+ vdd
+ vdd
+ sky130_fd_sc_hd__fill_8
* cell instance sky130_fd_sc_hd__fill_8_1345 r0 *1 0,0
Xsky130_fd_sc_hd__fill_8_1345
+ vss
+ vdd
+ vdd
+ sky130_fd_sc_hd__fill_8
* cell instance sky130_fd_sc_hd__fill_8_1346 r0 *1 0,0
Xsky130_fd_sc_hd__fill_8_1346
+ vss
+ vdd
+ vdd
+ sky130_fd_sc_hd__fill_8
* cell instance sky130_fd_sc_hd__fill_8_1347 r0 *1 0,0
Xsky130_fd_sc_hd__fill_8_1347
+ vss
+ vdd
+ vdd
+ sky130_fd_sc_hd__fill_8
* cell instance sky130_fd_sc_hd__fill_8_1348 r0 *1 0,0
Xsky130_fd_sc_hd__fill_8_1348
+ vss
+ vdd
+ vdd
+ sky130_fd_sc_hd__fill_8
* cell instance sky130_fd_sc_hd__fill_8_1349 r0 *1 0,0
Xsky130_fd_sc_hd__fill_8_1349
+ vss
+ vdd
+ vdd
+ sky130_fd_sc_hd__fill_8
* cell instance sky130_fd_sc_hd__fill_8_1350 r0 *1 0,0
Xsky130_fd_sc_hd__fill_8_1350
+ vss
+ vdd
+ vdd
+ sky130_fd_sc_hd__fill_8
* cell instance sky130_fd_sc_hd__fill_8_1351 r0 *1 0,0
Xsky130_fd_sc_hd__fill_8_1351
+ vss
+ vdd
+ vdd
+ sky130_fd_sc_hd__fill_8
* cell instance sky130_fd_sc_hd__fill_8_1352 r0 *1 0,0
Xsky130_fd_sc_hd__fill_8_1352
+ vss
+ vdd
+ vdd
+ sky130_fd_sc_hd__fill_8
* cell instance sky130_fd_sc_hd__fill_8_1353 r0 *1 0,0
Xsky130_fd_sc_hd__fill_8_1353
+ vss
+ vdd
+ vdd
+ sky130_fd_sc_hd__fill_8
* cell instance sky130_fd_sc_hd__fill_8_1354 r0 *1 0,0
Xsky130_fd_sc_hd__fill_8_1354
+ vss
+ vdd
+ vdd
+ sky130_fd_sc_hd__fill_8
* cell instance sky130_fd_sc_hd__fill_8_1355 r0 *1 0,0
Xsky130_fd_sc_hd__fill_8_1355
+ vss
+ vdd
+ vdd
+ sky130_fd_sc_hd__fill_8
* cell instance sky130_fd_sc_hd__fill_8_1356 r0 *1 0,0
Xsky130_fd_sc_hd__fill_8_1356
+ vss
+ vdd
+ vdd
+ sky130_fd_sc_hd__fill_8
* cell instance sky130_fd_sc_hd__fill_8_1357 r0 *1 0,0
Xsky130_fd_sc_hd__fill_8_1357
+ vss
+ vdd
+ vdd
+ sky130_fd_sc_hd__fill_8
* cell instance sky130_fd_sc_hd__fill_8_1358 r0 *1 0,0
Xsky130_fd_sc_hd__fill_8_1358
+ vss
+ vdd
+ vdd
+ sky130_fd_sc_hd__fill_8
* cell instance sky130_fd_sc_hd__fill_8_1359 r0 *1 0,0
Xsky130_fd_sc_hd__fill_8_1359
+ vss
+ vdd
+ vdd
+ sky130_fd_sc_hd__fill_8
* cell instance sky130_fd_sc_hd__fill_8_1360 r0 *1 0,0
Xsky130_fd_sc_hd__fill_8_1360
+ vss
+ vdd
+ vdd
+ sky130_fd_sc_hd__fill_8
* cell instance sky130_fd_sc_hd__fill_8_1361 r0 *1 0,0
Xsky130_fd_sc_hd__fill_8_1361
+ vss
+ vdd
+ vdd
+ sky130_fd_sc_hd__fill_8
* cell instance sky130_fd_sc_hd__fill_8_1362 r0 *1 0,0
Xsky130_fd_sc_hd__fill_8_1362
+ vss
+ vdd
+ vdd
+ sky130_fd_sc_hd__fill_8
* cell instance sky130_fd_sc_hd__fill_8_1363 r0 *1 0,0
Xsky130_fd_sc_hd__fill_8_1363
+ vss
+ vdd
+ vdd
+ sky130_fd_sc_hd__fill_8
* cell instance sky130_fd_sc_hd__fill_8_1364 r0 *1 0,0
Xsky130_fd_sc_hd__fill_8_1364
+ vss
+ vdd
+ vdd
+ sky130_fd_sc_hd__fill_8
* cell instance sky130_fd_sc_hd__fill_8_1365 r0 *1 0,0
Xsky130_fd_sc_hd__fill_8_1365
+ vss
+ vdd
+ vdd
+ sky130_fd_sc_hd__fill_8
* cell instance sky130_fd_sc_hd__fill_8_1366 r0 *1 0,0
Xsky130_fd_sc_hd__fill_8_1366
+ vss
+ vdd
+ vdd
+ sky130_fd_sc_hd__fill_8
* cell instance sky130_fd_sc_hd__fill_8_1367 r0 *1 0,0
Xsky130_fd_sc_hd__fill_8_1367
+ vss
+ vdd
+ vdd
+ sky130_fd_sc_hd__fill_8
* cell instance sky130_fd_sc_hd__fill_8_1368 r0 *1 0,0
Xsky130_fd_sc_hd__fill_8_1368
+ vss
+ vdd
+ vdd
+ sky130_fd_sc_hd__fill_8
* cell instance sky130_fd_sc_hd__fill_8_1369 r0 *1 0,0
Xsky130_fd_sc_hd__fill_8_1369
+ vss
+ vdd
+ vdd
+ sky130_fd_sc_hd__fill_8
* cell instance sky130_fd_sc_hd__fill_8_1370 r0 *1 0,0
Xsky130_fd_sc_hd__fill_8_1370
+ vss
+ vdd
+ vdd
+ sky130_fd_sc_hd__fill_8
* cell instance sky130_fd_sc_hd__fill_8_1371 r0 *1 0,0
Xsky130_fd_sc_hd__fill_8_1371
+ vss
+ vdd
+ vdd
+ sky130_fd_sc_hd__fill_8
* cell instance sky130_fd_sc_hd__fill_8_1372 r0 *1 0,0
Xsky130_fd_sc_hd__fill_8_1372
+ vss
+ vdd
+ vdd
+ sky130_fd_sc_hd__fill_8
* cell instance sky130_fd_sc_hd__fill_8_1373 r0 *1 0,0
Xsky130_fd_sc_hd__fill_8_1373
+ vss
+ vdd
+ vdd
+ sky130_fd_sc_hd__fill_8
* cell instance sky130_fd_sc_hd__fill_8_1374 r0 *1 0,0
Xsky130_fd_sc_hd__fill_8_1374
+ vss
+ vdd
+ vdd
+ sky130_fd_sc_hd__fill_8
* cell instance sky130_fd_sc_hd__fill_8_1375 r0 *1 0,0
Xsky130_fd_sc_hd__fill_8_1375
+ vss
+ vdd
+ vdd
+ sky130_fd_sc_hd__fill_8
* cell instance sky130_fd_sc_hd__fill_8_1376 r0 *1 0,0
Xsky130_fd_sc_hd__fill_8_1376
+ vss
+ vdd
+ vdd
+ sky130_fd_sc_hd__fill_8
* cell instance sky130_fd_sc_hd__fill_8_1377 r0 *1 0,0
Xsky130_fd_sc_hd__fill_8_1377
+ vss
+ vdd
+ vdd
+ sky130_fd_sc_hd__fill_8
* cell instance sky130_fd_sc_hd__fill_8_1378 r0 *1 0,0
Xsky130_fd_sc_hd__fill_8_1378
+ vss
+ vdd
+ vdd
+ sky130_fd_sc_hd__fill_8
* cell instance sky130_fd_sc_hd__fill_8_1379 r0 *1 0,0
Xsky130_fd_sc_hd__fill_8_1379
+ vss
+ vdd
+ vdd
+ sky130_fd_sc_hd__fill_8
* cell instance sky130_fd_sc_hd__fill_8_1380 r0 *1 0,0
Xsky130_fd_sc_hd__fill_8_1380
+ vss
+ vdd
+ vdd
+ sky130_fd_sc_hd__fill_8
* cell instance sky130_fd_sc_hd__fill_8_1381 r0 *1 0,0
Xsky130_fd_sc_hd__fill_8_1381
+ vss
+ vdd
+ vdd
+ sky130_fd_sc_hd__fill_8
* cell instance sky130_fd_sc_hd__fill_8_1382 r0 *1 0,0
Xsky130_fd_sc_hd__fill_8_1382
+ vss
+ vdd
+ vdd
+ sky130_fd_sc_hd__fill_8
* cell instance sky130_fd_sc_hd__fill_8_1383 r0 *1 0,0
Xsky130_fd_sc_hd__fill_8_1383
+ vss
+ vdd
+ vdd
+ sky130_fd_sc_hd__fill_8
* cell instance sky130_fd_sc_hd__fill_8_1384 r0 *1 0,0
Xsky130_fd_sc_hd__fill_8_1384
+ vss
+ vdd
+ vdd
+ sky130_fd_sc_hd__fill_8
* cell instance sky130_fd_sc_hd__fill_8_1385 r0 *1 0,0
Xsky130_fd_sc_hd__fill_8_1385
+ vss
+ vdd
+ vdd
+ sky130_fd_sc_hd__fill_8
* cell instance sky130_fd_sc_hd__fill_8_1386 r0 *1 0,0
Xsky130_fd_sc_hd__fill_8_1386
+ vss
+ vdd
+ vdd
+ sky130_fd_sc_hd__fill_8
* cell instance sky130_fd_sc_hd__fill_8_1387 r0 *1 0,0
Xsky130_fd_sc_hd__fill_8_1387
+ vss
+ vdd
+ vdd
+ sky130_fd_sc_hd__fill_8
* cell instance sky130_fd_sc_hd__fill_8_1388 r0 *1 0,0
Xsky130_fd_sc_hd__fill_8_1388
+ vss
+ vdd
+ vdd
+ sky130_fd_sc_hd__fill_8
* cell instance sky130_fd_sc_hd__fill_8_1389 r0 *1 0,0
Xsky130_fd_sc_hd__fill_8_1389
+ vss
+ vdd
+ vdd
+ sky130_fd_sc_hd__fill_8
* cell instance sky130_fd_sc_hd__fill_8_1390 r0 *1 0,0
Xsky130_fd_sc_hd__fill_8_1390
+ vss
+ vdd
+ vdd
+ sky130_fd_sc_hd__fill_8
* cell instance sky130_fd_sc_hd__fill_8_1391 r0 *1 0,0
Xsky130_fd_sc_hd__fill_8_1391
+ vss
+ vdd
+ vdd
+ sky130_fd_sc_hd__fill_8
* cell instance sky130_fd_sc_hd__fill_8_1392 r0 *1 0,0
Xsky130_fd_sc_hd__fill_8_1392
+ vss
+ vdd
+ vdd
+ sky130_fd_sc_hd__fill_8
* cell instance sky130_fd_sc_hd__fill_8_1393 r0 *1 0,0
Xsky130_fd_sc_hd__fill_8_1393
+ vss
+ vdd
+ vdd
+ sky130_fd_sc_hd__fill_8
* cell instance sky130_fd_sc_hd__fill_8_1394 r0 *1 0,0
Xsky130_fd_sc_hd__fill_8_1394
+ vss
+ vdd
+ vdd
+ sky130_fd_sc_hd__fill_8
* cell instance sky130_fd_sc_hd__fill_8_1395 r0 *1 0,0
Xsky130_fd_sc_hd__fill_8_1395
+ vss
+ vdd
+ vdd
+ sky130_fd_sc_hd__fill_8
* cell instance sky130_fd_sc_hd__fill_8_1396 r0 *1 0,0
Xsky130_fd_sc_hd__fill_8_1396
+ vss
+ vdd
+ vdd
+ sky130_fd_sc_hd__fill_8
* cell instance sky130_fd_sc_hd__fill_8_1397 r0 *1 0,0
Xsky130_fd_sc_hd__fill_8_1397
+ vss
+ vdd
+ vdd
+ sky130_fd_sc_hd__fill_8
* cell instance sky130_fd_sc_hd__fill_8_1398 r0 *1 0,0
Xsky130_fd_sc_hd__fill_8_1398
+ vss
+ vdd
+ vdd
+ sky130_fd_sc_hd__fill_8
* cell instance sky130_fd_sc_hd__fill_8_1399 r0 *1 0,0
Xsky130_fd_sc_hd__fill_8_1399
+ vss
+ vdd
+ vdd
+ sky130_fd_sc_hd__fill_8
* cell instance sky130_fd_sc_hd__fill_8_1400 r0 *1 0,0
Xsky130_fd_sc_hd__fill_8_1400
+ vss
+ vdd
+ vdd
+ sky130_fd_sc_hd__fill_8
* cell instance sky130_fd_sc_hd__fill_8_1401 r0 *1 0,0
Xsky130_fd_sc_hd__fill_8_1401
+ vss
+ vdd
+ vdd
+ sky130_fd_sc_hd__fill_8
* cell instance sky130_fd_sc_hd__fill_8_1402 r0 *1 0,0
Xsky130_fd_sc_hd__fill_8_1402
+ vss
+ vdd
+ vdd
+ sky130_fd_sc_hd__fill_8
* cell instance sky130_fd_sc_hd__fill_8_1403 r0 *1 0,0
Xsky130_fd_sc_hd__fill_8_1403
+ vss
+ vdd
+ vdd
+ sky130_fd_sc_hd__fill_8
* cell instance sky130_fd_sc_hd__fill_8_1404 r0 *1 0,0
Xsky130_fd_sc_hd__fill_8_1404
+ vss
+ vdd
+ vdd
+ sky130_fd_sc_hd__fill_8
* cell instance sky130_fd_sc_hd__fill_8_1405 r0 *1 0,0
Xsky130_fd_sc_hd__fill_8_1405
+ vss
+ vdd
+ vdd
+ sky130_fd_sc_hd__fill_8
* cell instance sky130_fd_sc_hd__fill_8_1406 r0 *1 0,0
Xsky130_fd_sc_hd__fill_8_1406
+ vss
+ vdd
+ vdd
+ sky130_fd_sc_hd__fill_8
* cell instance sky130_fd_sc_hd__fill_8_1407 r0 *1 0,0
Xsky130_fd_sc_hd__fill_8_1407
+ vss
+ vdd
+ vdd
+ sky130_fd_sc_hd__fill_8
* cell instance sky130_fd_sc_hd__fill_8_1408 r0 *1 0,0
Xsky130_fd_sc_hd__fill_8_1408
+ vss
+ vdd
+ vdd
+ sky130_fd_sc_hd__fill_8
* cell instance sky130_fd_sc_hd__fill_8_1409 r0 *1 0,0
Xsky130_fd_sc_hd__fill_8_1409
+ vss
+ vdd
+ vdd
+ sky130_fd_sc_hd__fill_8
* cell instance sky130_fd_sc_hd__fill_8_1410 r0 *1 0,0
Xsky130_fd_sc_hd__fill_8_1410
+ vss
+ vdd
+ vdd
+ sky130_fd_sc_hd__fill_8
* cell instance sky130_fd_sc_hd__fill_8_1411 r0 *1 0,0
Xsky130_fd_sc_hd__fill_8_1411
+ vss
+ vdd
+ vdd
+ sky130_fd_sc_hd__fill_8
* cell instance sky130_fd_sc_hd__fill_8_1412 r0 *1 0,0
Xsky130_fd_sc_hd__fill_8_1412
+ vss
+ vdd
+ vdd
+ sky130_fd_sc_hd__fill_8
* cell instance sky130_fd_sc_hd__fill_8_1413 r0 *1 0,0
Xsky130_fd_sc_hd__fill_8_1413
+ vss
+ vdd
+ vdd
+ sky130_fd_sc_hd__fill_8
* cell instance sky130_fd_sc_hd__fill_8_1414 r0 *1 0,0
Xsky130_fd_sc_hd__fill_8_1414
+ vss
+ vdd
+ vdd
+ sky130_fd_sc_hd__fill_8
* cell instance sky130_fd_sc_hd__fill_8_1415 r0 *1 0,0
Xsky130_fd_sc_hd__fill_8_1415
+ vss
+ vdd
+ vdd
+ sky130_fd_sc_hd__fill_8
* cell instance sky130_fd_sc_hd__fill_8_1416 r0 *1 0,0
Xsky130_fd_sc_hd__fill_8_1416
+ vss
+ vdd
+ vdd
+ sky130_fd_sc_hd__fill_8
* cell instance sky130_fd_sc_hd__fill_8_1417 r0 *1 0,0
Xsky130_fd_sc_hd__fill_8_1417
+ vss
+ vdd
+ vdd
+ sky130_fd_sc_hd__fill_8
* cell instance sky130_fd_sc_hd__fill_8_1418 r0 *1 0,0
Xsky130_fd_sc_hd__fill_8_1418
+ vss
+ vdd
+ vdd
+ sky130_fd_sc_hd__fill_8
* cell instance sky130_fd_sc_hd__fill_8_1419 r0 *1 0,0
Xsky130_fd_sc_hd__fill_8_1419
+ vss
+ vdd
+ vdd
+ sky130_fd_sc_hd__fill_8
* cell instance sky130_fd_sc_hd__fill_8_1420 r0 *1 0,0
Xsky130_fd_sc_hd__fill_8_1420
+ vss
+ vdd
+ vdd
+ sky130_fd_sc_hd__fill_8
* cell instance sky130_fd_sc_hd__fill_8_1421 r0 *1 0,0
Xsky130_fd_sc_hd__fill_8_1421
+ vss
+ vdd
+ vdd
+ sky130_fd_sc_hd__fill_8
* cell instance sky130_fd_sc_hd__fill_8_1422 r0 *1 0,0
Xsky130_fd_sc_hd__fill_8_1422
+ vss
+ vdd
+ vdd
+ sky130_fd_sc_hd__fill_8
* cell instance sky130_fd_sc_hd__fill_8_1423 r0 *1 0,0
Xsky130_fd_sc_hd__fill_8_1423
+ vss
+ vdd
+ vdd
+ sky130_fd_sc_hd__fill_8
* cell instance sky130_fd_sc_hd__fill_8_1424 r0 *1 0,0
Xsky130_fd_sc_hd__fill_8_1424
+ vss
+ vdd
+ vdd
+ sky130_fd_sc_hd__fill_8
* cell instance sky130_fd_sc_hd__fill_8_1425 r0 *1 0,0
Xsky130_fd_sc_hd__fill_8_1425
+ vss
+ vdd
+ vdd
+ sky130_fd_sc_hd__fill_8
* cell instance sky130_fd_sc_hd__fill_8_1426 r0 *1 0,0
Xsky130_fd_sc_hd__fill_8_1426
+ vss
+ vdd
+ vdd
+ sky130_fd_sc_hd__fill_8
* cell instance sky130_fd_sc_hd__fill_8_1427 r0 *1 0,0
Xsky130_fd_sc_hd__fill_8_1427
+ vss
+ vdd
+ vdd
+ sky130_fd_sc_hd__fill_8
* cell instance sky130_fd_sc_hd__fill_8_1428 r0 *1 0,0
Xsky130_fd_sc_hd__fill_8_1428
+ vss
+ vdd
+ vdd
+ sky130_fd_sc_hd__fill_8
* cell instance sky130_fd_sc_hd__fill_8_1429 r0 *1 0,0
Xsky130_fd_sc_hd__fill_8_1429
+ vss
+ vdd
+ vdd
+ sky130_fd_sc_hd__fill_8
* cell instance sky130_fd_sc_hd__fill_8_1430 r0 *1 0,0
Xsky130_fd_sc_hd__fill_8_1430
+ vss
+ vdd
+ vdd
+ sky130_fd_sc_hd__fill_8
* cell instance sky130_fd_sc_hd__fill_8_1431 r0 *1 0,0
Xsky130_fd_sc_hd__fill_8_1431
+ vss
+ vdd
+ vdd
+ sky130_fd_sc_hd__fill_8
* cell instance sky130_fd_sc_hd__fill_8_1432 r0 *1 0,0
Xsky130_fd_sc_hd__fill_8_1432
+ vss
+ vdd
+ vdd
+ sky130_fd_sc_hd__fill_8
* cell instance sky130_fd_sc_hd__fill_8_1433 r0 *1 0,0
Xsky130_fd_sc_hd__fill_8_1433
+ vss
+ vdd
+ vdd
+ sky130_fd_sc_hd__fill_8
* cell instance sky130_fd_sc_hd__fill_8_1434 r0 *1 0,0
Xsky130_fd_sc_hd__fill_8_1434
+ vss
+ vdd
+ vdd
+ sky130_fd_sc_hd__fill_8
* cell instance sky130_fd_sc_hd__fill_8_1435 r0 *1 0,0
Xsky130_fd_sc_hd__fill_8_1435
+ vss
+ vdd
+ vdd
+ sky130_fd_sc_hd__fill_8
* cell instance sky130_fd_sc_hd__fill_8_1436 r0 *1 0,0
Xsky130_fd_sc_hd__fill_8_1436
+ vss
+ vdd
+ vdd
+ sky130_fd_sc_hd__fill_8
* cell instance sky130_fd_sc_hd__fill_8_1437 r0 *1 0,0
Xsky130_fd_sc_hd__fill_8_1437
+ vss
+ vdd
+ vdd
+ sky130_fd_sc_hd__fill_8
* cell instance sky130_fd_sc_hd__fill_8_1438 r0 *1 0,0
Xsky130_fd_sc_hd__fill_8_1438
+ vss
+ vdd
+ vdd
+ sky130_fd_sc_hd__fill_8
* cell instance sky130_fd_sc_hd__fill_8_1439 r0 *1 0,0
Xsky130_fd_sc_hd__fill_8_1439
+ vss
+ vdd
+ vdd
+ sky130_fd_sc_hd__fill_8
* cell instance sky130_fd_sc_hd__fill_8_1440 r0 *1 0,0
Xsky130_fd_sc_hd__fill_8_1440
+ vss
+ vdd
+ vdd
+ sky130_fd_sc_hd__fill_8
* cell instance sky130_fd_sc_hd__fill_8_1441 r0 *1 0,0
Xsky130_fd_sc_hd__fill_8_1441
+ vss
+ vdd
+ vdd
+ sky130_fd_sc_hd__fill_8
* cell instance sky130_fd_sc_hd__fill_8_1442 r0 *1 0,0
Xsky130_fd_sc_hd__fill_8_1442
+ vss
+ vdd
+ vdd
+ sky130_fd_sc_hd__fill_8
* cell instance sky130_fd_sc_hd__fill_8_1443 r0 *1 0,0
Xsky130_fd_sc_hd__fill_8_1443
+ vss
+ vdd
+ vdd
+ sky130_fd_sc_hd__fill_8
* cell instance sky130_fd_sc_hd__fill_8_1444 r0 *1 0,0
Xsky130_fd_sc_hd__fill_8_1444
+ vss
+ vdd
+ vdd
+ sky130_fd_sc_hd__fill_8
* cell instance sky130_fd_sc_hd__fill_8_1445 r0 *1 0,0
Xsky130_fd_sc_hd__fill_8_1445
+ vss
+ vdd
+ vdd
+ sky130_fd_sc_hd__fill_8
* cell instance sky130_fd_sc_hd__fill_8_1446 r0 *1 0,0
Xsky130_fd_sc_hd__fill_8_1446
+ vss
+ vdd
+ vdd
+ sky130_fd_sc_hd__fill_8
* cell instance sky130_fd_sc_hd__fill_8_1447 r0 *1 0,0
Xsky130_fd_sc_hd__fill_8_1447
+ vss
+ vdd
+ vdd
+ sky130_fd_sc_hd__fill_8
* cell instance sky130_fd_sc_hd__fill_8_1448 r0 *1 0,0
Xsky130_fd_sc_hd__fill_8_1448
+ vss
+ vdd
+ vdd
+ sky130_fd_sc_hd__fill_8
* cell instance sky130_fd_sc_hd__fill_8_1449 r0 *1 0,0
Xsky130_fd_sc_hd__fill_8_1449
+ vss
+ vdd
+ vdd
+ sky130_fd_sc_hd__fill_8
* cell instance sky130_fd_sc_hd__fill_8_1450 r0 *1 0,0
Xsky130_fd_sc_hd__fill_8_1450
+ vss
+ vdd
+ vdd
+ sky130_fd_sc_hd__fill_8
* cell instance sky130_fd_sc_hd__fill_8_1451 r0 *1 0,0
Xsky130_fd_sc_hd__fill_8_1451
+ vss
+ vdd
+ vdd
+ sky130_fd_sc_hd__fill_8
* cell instance sky130_fd_sc_hd__fill_8_1452 r0 *1 0,0
Xsky130_fd_sc_hd__fill_8_1452
+ vss
+ vdd
+ vdd
+ sky130_fd_sc_hd__fill_8
* cell instance sky130_fd_sc_hd__fill_8_1453 r0 *1 0,0
Xsky130_fd_sc_hd__fill_8_1453
+ vss
+ vdd
+ vdd
+ sky130_fd_sc_hd__fill_8
* cell instance sky130_fd_sc_hd__fill_8_1454 r0 *1 0,0
Xsky130_fd_sc_hd__fill_8_1454
+ vss
+ vdd
+ vdd
+ sky130_fd_sc_hd__fill_8
* cell instance sky130_fd_sc_hd__fill_8_1455 r0 *1 0,0
Xsky130_fd_sc_hd__fill_8_1455
+ vss
+ vdd
+ vdd
+ sky130_fd_sc_hd__fill_8
* cell instance sky130_fd_sc_hd__fill_8_1456 r0 *1 0,0
Xsky130_fd_sc_hd__fill_8_1456
+ vss
+ vdd
+ vdd
+ sky130_fd_sc_hd__fill_8
* cell instance sky130_fd_sc_hd__fill_8_1457 r0 *1 0,0
Xsky130_fd_sc_hd__fill_8_1457
+ vss
+ vdd
+ vdd
+ sky130_fd_sc_hd__fill_8
* cell instance sky130_fd_sc_hd__fill_8_1458 r0 *1 0,0
Xsky130_fd_sc_hd__fill_8_1458
+ vss
+ vdd
+ vdd
+ sky130_fd_sc_hd__fill_8
* cell instance sky130_fd_sc_hd__fill_8_1459 r0 *1 0,0
Xsky130_fd_sc_hd__fill_8_1459
+ vss
+ vdd
+ vdd
+ sky130_fd_sc_hd__fill_8
* cell instance sky130_fd_sc_hd__fill_8_1460 r0 *1 0,0
Xsky130_fd_sc_hd__fill_8_1460
+ vss
+ vdd
+ vdd
+ sky130_fd_sc_hd__fill_8
* cell instance sky130_fd_sc_hd__fill_8_1461 r0 *1 0,0
Xsky130_fd_sc_hd__fill_8_1461
+ vss
+ vdd
+ vdd
+ sky130_fd_sc_hd__fill_8
* cell instance sky130_fd_sc_hd__fill_8_1462 r0 *1 0,0
Xsky130_fd_sc_hd__fill_8_1462
+ vss
+ vdd
+ vdd
+ sky130_fd_sc_hd__fill_8
* cell instance sky130_fd_sc_hd__fill_8_1463 r0 *1 0,0
Xsky130_fd_sc_hd__fill_8_1463
+ vss
+ vdd
+ vdd
+ sky130_fd_sc_hd__fill_8
* cell instance sky130_fd_sc_hd__fill_8_1464 r0 *1 0,0
Xsky130_fd_sc_hd__fill_8_1464
+ vss
+ vdd
+ vdd
+ sky130_fd_sc_hd__fill_8
* cell instance sky130_fd_sc_hd__fill_8_1465 r0 *1 0,0
Xsky130_fd_sc_hd__fill_8_1465
+ vss
+ vdd
+ vdd
+ sky130_fd_sc_hd__fill_8
* cell instance sky130_fd_sc_hd__fill_8_1466 r0 *1 0,0
Xsky130_fd_sc_hd__fill_8_1466
+ vss
+ vdd
+ vdd
+ sky130_fd_sc_hd__fill_8
* cell instance sky130_fd_sc_hd__fill_8_1467 r0 *1 0,0
Xsky130_fd_sc_hd__fill_8_1467
+ vss
+ vdd
+ vdd
+ sky130_fd_sc_hd__fill_8
* cell instance sky130_fd_sc_hd__fill_8_1468 r0 *1 0,0
Xsky130_fd_sc_hd__fill_8_1468
+ vss
+ vdd
+ vdd
+ sky130_fd_sc_hd__fill_8
* cell instance sky130_fd_sc_hd__fill_8_1469 r0 *1 0,0
Xsky130_fd_sc_hd__fill_8_1469
+ vss
+ vdd
+ vdd
+ sky130_fd_sc_hd__fill_8
* cell instance sky130_fd_sc_hd__fill_8_1470 r0 *1 0,0
Xsky130_fd_sc_hd__fill_8_1470
+ vss
+ vdd
+ vdd
+ sky130_fd_sc_hd__fill_8
* cell instance sky130_fd_sc_hd__fill_8_1471 r0 *1 0,0
Xsky130_fd_sc_hd__fill_8_1471
+ vss
+ vdd
+ vdd
+ sky130_fd_sc_hd__fill_8
* cell instance sky130_fd_sc_hd__fill_8_1472 r0 *1 0,0
Xsky130_fd_sc_hd__fill_8_1472
+ vss
+ vdd
+ vdd
+ sky130_fd_sc_hd__fill_8
* cell instance sky130_fd_sc_hd__fill_8_1473 r0 *1 0,0
Xsky130_fd_sc_hd__fill_8_1473
+ vss
+ vdd
+ vdd
+ sky130_fd_sc_hd__fill_8
* cell instance sky130_fd_sc_hd__fill_8_1474 r0 *1 0,0
Xsky130_fd_sc_hd__fill_8_1474
+ vss
+ vdd
+ vdd
+ sky130_fd_sc_hd__fill_8
* cell instance sky130_fd_sc_hd__fill_8_1475 r0 *1 0,0
Xsky130_fd_sc_hd__fill_8_1475
+ vss
+ vdd
+ vdd
+ sky130_fd_sc_hd__fill_8
* cell instance sky130_fd_sc_hd__fill_8_1476 r0 *1 0,0
Xsky130_fd_sc_hd__fill_8_1476
+ vss
+ vdd
+ vdd
+ sky130_fd_sc_hd__fill_8
* cell instance sky130_fd_sc_hd__fill_8_1477 r0 *1 0,0
Xsky130_fd_sc_hd__fill_8_1477
+ vss
+ vdd
+ vdd
+ sky130_fd_sc_hd__fill_8
* cell instance sky130_fd_sc_hd__fill_8_1478 r0 *1 0,0
Xsky130_fd_sc_hd__fill_8_1478
+ vss
+ vdd
+ vdd
+ sky130_fd_sc_hd__fill_8
* cell instance sky130_fd_sc_hd__fill_8_1479 r0 *1 0,0
Xsky130_fd_sc_hd__fill_8_1479
+ vss
+ vdd
+ vdd
+ sky130_fd_sc_hd__fill_8
* cell instance sky130_fd_sc_hd__fill_8_1480 r0 *1 0,0
Xsky130_fd_sc_hd__fill_8_1480
+ vss
+ vdd
+ vdd
+ sky130_fd_sc_hd__fill_8
* cell instance sky130_fd_sc_hd__fill_8_1481 r0 *1 0,0
Xsky130_fd_sc_hd__fill_8_1481
+ vss
+ vdd
+ vdd
+ sky130_fd_sc_hd__fill_8
* cell instance sky130_fd_sc_hd__fill_8_1482 r0 *1 0,0
Xsky130_fd_sc_hd__fill_8_1482
+ vss
+ vdd
+ vdd
+ sky130_fd_sc_hd__fill_8
* cell instance sky130_fd_sc_hd__fill_8_1483 r0 *1 0,0
Xsky130_fd_sc_hd__fill_8_1483
+ vss
+ vdd
+ vdd
+ sky130_fd_sc_hd__fill_8
* cell instance sky130_fd_sc_hd__fill_8_1484 r0 *1 0,0
Xsky130_fd_sc_hd__fill_8_1484
+ vss
+ vdd
+ vdd
+ sky130_fd_sc_hd__fill_8
* cell instance sky130_fd_sc_hd__fill_8_1485 r0 *1 0,0
Xsky130_fd_sc_hd__fill_8_1485
+ vss
+ vdd
+ vdd
+ sky130_fd_sc_hd__fill_8
* cell instance sky130_fd_sc_hd__fill_8_1486 r0 *1 0,0
Xsky130_fd_sc_hd__fill_8_1486
+ vss
+ vdd
+ vdd
+ sky130_fd_sc_hd__fill_8
* cell instance sky130_fd_sc_hd__fill_8_1487 r0 *1 0,0
Xsky130_fd_sc_hd__fill_8_1487
+ vss
+ vdd
+ vdd
+ sky130_fd_sc_hd__fill_8
* cell instance sky130_fd_sc_hd__fill_8_1488 r0 *1 0,0
Xsky130_fd_sc_hd__fill_8_1488
+ vss
+ vdd
+ vdd
+ sky130_fd_sc_hd__fill_8
* cell instance sky130_fd_sc_hd__fill_8_1489 r0 *1 0,0
Xsky130_fd_sc_hd__fill_8_1489
+ vss
+ vdd
+ vdd
+ sky130_fd_sc_hd__fill_8
* cell instance sky130_fd_sc_hd__fill_8_1490 r0 *1 0,0
Xsky130_fd_sc_hd__fill_8_1490
+ vss
+ vdd
+ vdd
+ sky130_fd_sc_hd__fill_8
* cell instance sky130_fd_sc_hd__fill_8_1491 r0 *1 0,0
Xsky130_fd_sc_hd__fill_8_1491
+ vss
+ vdd
+ vdd
+ sky130_fd_sc_hd__fill_8
* cell instance sky130_fd_sc_hd__fill_8_1492 r0 *1 0,0
Xsky130_fd_sc_hd__fill_8_1492
+ vss
+ vdd
+ vdd
+ sky130_fd_sc_hd__fill_8
* cell instance sky130_fd_sc_hd__fill_8_1493 r0 *1 0,0
Xsky130_fd_sc_hd__fill_8_1493
+ vss
+ vdd
+ vdd
+ sky130_fd_sc_hd__fill_8
* cell instance sky130_fd_sc_hd__fill_8_1494 r0 *1 0,0
Xsky130_fd_sc_hd__fill_8_1494
+ vss
+ vdd
+ vdd
+ sky130_fd_sc_hd__fill_8
* cell instance sky130_fd_sc_hd__fill_8_1495 r0 *1 0,0
Xsky130_fd_sc_hd__fill_8_1495
+ vss
+ vdd
+ vdd
+ sky130_fd_sc_hd__fill_8
* cell instance sky130_fd_sc_hd__fill_8_1496 r0 *1 0,0
Xsky130_fd_sc_hd__fill_8_1496
+ vss
+ vdd
+ vdd
+ sky130_fd_sc_hd__fill_8
* cell instance sky130_fd_sc_hd__fill_8_1497 r0 *1 0,0
Xsky130_fd_sc_hd__fill_8_1497
+ vss
+ vdd
+ vdd
+ sky130_fd_sc_hd__fill_8
* cell instance sky130_fd_sc_hd__fill_8_1498 r0 *1 0,0
Xsky130_fd_sc_hd__fill_8_1498
+ vss
+ vdd
+ vdd
+ sky130_fd_sc_hd__fill_8
* cell instance sky130_fd_sc_hd__fill_8_1499 r0 *1 0,0
Xsky130_fd_sc_hd__fill_8_1499
+ vss
+ vdd
+ vdd
+ sky130_fd_sc_hd__fill_8
* cell instance sky130_fd_sc_hd__fill_8_1500 r0 *1 0,0
Xsky130_fd_sc_hd__fill_8_1500
+ vss
+ vdd
+ vdd
+ sky130_fd_sc_hd__fill_8
* cell instance sky130_fd_sc_hd__fill_8_1501 r0 *1 0,0
Xsky130_fd_sc_hd__fill_8_1501
+ vss
+ vdd
+ vdd
+ sky130_fd_sc_hd__fill_8
* cell instance sky130_fd_sc_hd__fill_8_1502 r0 *1 0,0
Xsky130_fd_sc_hd__fill_8_1502
+ vss
+ vdd
+ vdd
+ sky130_fd_sc_hd__fill_8
* cell instance sky130_fd_sc_hd__fill_8_1503 r0 *1 0,0
Xsky130_fd_sc_hd__fill_8_1503
+ vss
+ vdd
+ vdd
+ sky130_fd_sc_hd__fill_8
* cell instance sky130_fd_sc_hd__fill_8_1504 r0 *1 0,0
Xsky130_fd_sc_hd__fill_8_1504
+ vss
+ vdd
+ vdd
+ sky130_fd_sc_hd__fill_8
* cell instance sky130_fd_sc_hd__fill_8_1505 r0 *1 0,0
Xsky130_fd_sc_hd__fill_8_1505
+ vss
+ vdd
+ vdd
+ sky130_fd_sc_hd__fill_8
* cell instance sky130_fd_sc_hd__fill_8_1506 r0 *1 0,0
Xsky130_fd_sc_hd__fill_8_1506
+ vss
+ vdd
+ vdd
+ sky130_fd_sc_hd__fill_8
* cell instance sky130_fd_sc_hd__fill_8_1507 r0 *1 0,0
Xsky130_fd_sc_hd__fill_8_1507
+ vss
+ vdd
+ vdd
+ sky130_fd_sc_hd__fill_8
* cell instance sky130_fd_sc_hd__fill_8_1508 r0 *1 0,0
Xsky130_fd_sc_hd__fill_8_1508
+ vss
+ vdd
+ vdd
+ sky130_fd_sc_hd__fill_8
* cell instance sky130_fd_sc_hd__fill_8_1509 r0 *1 0,0
Xsky130_fd_sc_hd__fill_8_1509
+ vss
+ vdd
+ vdd
+ sky130_fd_sc_hd__fill_8
* cell instance sky130_fd_sc_hd__fill_8_1510 r0 *1 0,0
Xsky130_fd_sc_hd__fill_8_1510
+ vss
+ vdd
+ vdd
+ sky130_fd_sc_hd__fill_8
* cell instance sky130_fd_sc_hd__fill_8_1511 r0 *1 0,0
Xsky130_fd_sc_hd__fill_8_1511
+ vss
+ vdd
+ vdd
+ sky130_fd_sc_hd__fill_8
* cell instance sky130_fd_sc_hd__fill_8_1512 r0 *1 0,0
Xsky130_fd_sc_hd__fill_8_1512
+ vss
+ vdd
+ vdd
+ sky130_fd_sc_hd__fill_8
* cell instance sky130_fd_sc_hd__fill_8_1513 r0 *1 0,0
Xsky130_fd_sc_hd__fill_8_1513
+ vss
+ vdd
+ vdd
+ sky130_fd_sc_hd__fill_8
* cell instance sky130_fd_sc_hd__fill_8_1514 r0 *1 0,0
Xsky130_fd_sc_hd__fill_8_1514
+ vss
+ vdd
+ vdd
+ sky130_fd_sc_hd__fill_8
* cell instance sky130_fd_sc_hd__fill_8_1515 r0 *1 0,0
Xsky130_fd_sc_hd__fill_8_1515
+ vss
+ vdd
+ vdd
+ sky130_fd_sc_hd__fill_8
* cell instance sky130_fd_sc_hd__fill_8_1516 r0 *1 0,0
Xsky130_fd_sc_hd__fill_8_1516
+ vss
+ vdd
+ vdd
+ sky130_fd_sc_hd__fill_8
* cell instance sky130_fd_sc_hd__fill_8_1517 r0 *1 0,0
Xsky130_fd_sc_hd__fill_8_1517
+ vss
+ vdd
+ vdd
+ sky130_fd_sc_hd__fill_8
* cell instance sky130_fd_sc_hd__fill_8_1518 r0 *1 0,0
Xsky130_fd_sc_hd__fill_8_1518
+ vss
+ vdd
+ vdd
+ sky130_fd_sc_hd__fill_8
* cell instance sky130_fd_sc_hd__fill_8_1519 r0 *1 0,0
Xsky130_fd_sc_hd__fill_8_1519
+ vss
+ vdd
+ vdd
+ sky130_fd_sc_hd__fill_8
* cell instance sky130_fd_sc_hd__fill_8_1520 r0 *1 0,0
Xsky130_fd_sc_hd__fill_8_1520
+ vss
+ vdd
+ vdd
+ sky130_fd_sc_hd__fill_8
* cell instance sky130_fd_sc_hd__fill_8_1521 r0 *1 0,0
Xsky130_fd_sc_hd__fill_8_1521
+ vss
+ vdd
+ vdd
+ sky130_fd_sc_hd__fill_8
* cell instance sky130_fd_sc_hd__fill_8_1522 r0 *1 0,0
Xsky130_fd_sc_hd__fill_8_1522
+ vss
+ vdd
+ vdd
+ sky130_fd_sc_hd__fill_8
* cell instance sky130_fd_sc_hd__fill_8_1523 r0 *1 0,0
Xsky130_fd_sc_hd__fill_8_1523
+ vss
+ vdd
+ vdd
+ sky130_fd_sc_hd__fill_8
* cell instance sky130_fd_sc_hd__fill_8_1524 r0 *1 0,0
Xsky130_fd_sc_hd__fill_8_1524
+ vss
+ vdd
+ vdd
+ sky130_fd_sc_hd__fill_8
* cell instance sky130_fd_sc_hd__fill_8_1525 r0 *1 0,0
Xsky130_fd_sc_hd__fill_8_1525
+ vss
+ vdd
+ vdd
+ sky130_fd_sc_hd__fill_8
* cell instance sky130_fd_sc_hd__fill_8_1526 r0 *1 0,0
Xsky130_fd_sc_hd__fill_8_1526
+ vss
+ vdd
+ vdd
+ sky130_fd_sc_hd__fill_8
* cell instance sky130_fd_sc_hd__fill_8_1527 r0 *1 0,0
Xsky130_fd_sc_hd__fill_8_1527
+ vss
+ vdd
+ vdd
+ sky130_fd_sc_hd__fill_8
* cell instance sky130_fd_sc_hd__fill_8_1528 r0 *1 0,0
Xsky130_fd_sc_hd__fill_8_1528
+ vss
+ vdd
+ vdd
+ sky130_fd_sc_hd__fill_8
* cell instance sky130_fd_sc_hd__fill_8_1529 r0 *1 0,0
Xsky130_fd_sc_hd__fill_8_1529
+ vss
+ vdd
+ vdd
+ sky130_fd_sc_hd__fill_8
* cell instance sky130_fd_sc_hd__fill_8_1530 r0 *1 0,0
Xsky130_fd_sc_hd__fill_8_1530
+ vss
+ vdd
+ vdd
+ sky130_fd_sc_hd__fill_8
* cell instance sky130_fd_sc_hd__fill_8_1531 r0 *1 0,0
Xsky130_fd_sc_hd__fill_8_1531
+ vss
+ vdd
+ vdd
+ sky130_fd_sc_hd__fill_8
* cell instance sky130_fd_sc_hd__fill_8_1532 r0 *1 0,0
Xsky130_fd_sc_hd__fill_8_1532
+ vss
+ vdd
+ vdd
+ sky130_fd_sc_hd__fill_8
* cell instance sky130_fd_sc_hd__fill_8_1533 r0 *1 0,0
Xsky130_fd_sc_hd__fill_8_1533
+ vss
+ vdd
+ vdd
+ sky130_fd_sc_hd__fill_8
* cell instance sky130_fd_sc_hd__fill_8_1534 r0 *1 0,0
Xsky130_fd_sc_hd__fill_8_1534
+ vss
+ vdd
+ vdd
+ sky130_fd_sc_hd__fill_8
* cell instance sky130_fd_sc_hd__fill_8_1535 r0 *1 0,0
Xsky130_fd_sc_hd__fill_8_1535
+ vss
+ vdd
+ vdd
+ sky130_fd_sc_hd__fill_8
* cell instance sky130_fd_sc_hd__fill_8_1536 r0 *1 0,0
Xsky130_fd_sc_hd__fill_8_1536
+ vss
+ vdd
+ vdd
+ sky130_fd_sc_hd__fill_8
* cell instance sky130_fd_sc_hd__fill_8_1537 r0 *1 0,0
Xsky130_fd_sc_hd__fill_8_1537
+ vss
+ vdd
+ vdd
+ sky130_fd_sc_hd__fill_8
* cell instance sky130_fd_sc_hd__fill_8_1538 r0 *1 0,0
Xsky130_fd_sc_hd__fill_8_1538
+ vss
+ vdd
+ vdd
+ sky130_fd_sc_hd__fill_8
* cell instance sky130_fd_sc_hd__fill_8_1539 r0 *1 0,0
Xsky130_fd_sc_hd__fill_8_1539
+ vss
+ vdd
+ vdd
+ sky130_fd_sc_hd__fill_8
* cell instance sky130_fd_sc_hd__fill_8_1540 r0 *1 0,0
Xsky130_fd_sc_hd__fill_8_1540
+ vss
+ vdd
+ vdd
+ sky130_fd_sc_hd__fill_8
* cell instance sky130_fd_sc_hd__fill_8_1541 r0 *1 0,0
Xsky130_fd_sc_hd__fill_8_1541
+ vss
+ vdd
+ vdd
+ sky130_fd_sc_hd__fill_8
* cell instance sky130_fd_sc_hd__fill_8_1542 r0 *1 0,0
Xsky130_fd_sc_hd__fill_8_1542
+ vss
+ vdd
+ vdd
+ sky130_fd_sc_hd__fill_8
* cell instance sky130_fd_sc_hd__fill_8_1543 r0 *1 0,0
Xsky130_fd_sc_hd__fill_8_1543
+ vss
+ vdd
+ vdd
+ sky130_fd_sc_hd__fill_8
* cell instance sky130_fd_sc_hd__fill_8_1544 r0 *1 0,0
Xsky130_fd_sc_hd__fill_8_1544
+ vss
+ vdd
+ vdd
+ sky130_fd_sc_hd__fill_8
* cell instance sky130_fd_sc_hd__fill_8_1545 r0 *1 0,0
Xsky130_fd_sc_hd__fill_8_1545
+ vss
+ vdd
+ vdd
+ sky130_fd_sc_hd__fill_8
* cell instance sky130_fd_sc_hd__fill_8_1546 r0 *1 0,0
Xsky130_fd_sc_hd__fill_8_1546
+ vss
+ vdd
+ vdd
+ sky130_fd_sc_hd__fill_8
* cell instance sky130_fd_sc_hd__fill_8_1547 r0 *1 0,0
Xsky130_fd_sc_hd__fill_8_1547
+ vss
+ vdd
+ vdd
+ sky130_fd_sc_hd__fill_8
* cell instance sky130_fd_sc_hd__fill_8_1548 r0 *1 0,0
Xsky130_fd_sc_hd__fill_8_1548
+ vss
+ vdd
+ vdd
+ sky130_fd_sc_hd__fill_8
* cell instance sky130_fd_sc_hd__fill_8_1549 r0 *1 0,0
Xsky130_fd_sc_hd__fill_8_1549
+ vss
+ vdd
+ vdd
+ sky130_fd_sc_hd__fill_8
* cell instance sky130_fd_sc_hd__fill_8_1550 r0 *1 0,0
Xsky130_fd_sc_hd__fill_8_1550
+ vss
+ vdd
+ vdd
+ sky130_fd_sc_hd__fill_8
* cell instance sky130_fd_sc_hd__fill_8_1551 r0 *1 0,0
Xsky130_fd_sc_hd__fill_8_1551
+ vss
+ vdd
+ vdd
+ sky130_fd_sc_hd__fill_8
* cell instance sky130_fd_sc_hd__fill_8_1552 r0 *1 0,0
Xsky130_fd_sc_hd__fill_8_1552
+ vss
+ vdd
+ vdd
+ sky130_fd_sc_hd__fill_8
* cell instance sky130_fd_sc_hd__fill_8_1553 r0 *1 0,0
Xsky130_fd_sc_hd__fill_8_1553
+ vss
+ vdd
+ vdd
+ sky130_fd_sc_hd__fill_8
* cell instance sky130_fd_sc_hd__fill_8_1554 r0 *1 0,0
Xsky130_fd_sc_hd__fill_8_1554
+ vss
+ vdd
+ vdd
+ sky130_fd_sc_hd__fill_8
* cell instance sky130_fd_sc_hd__fill_8_1555 r0 *1 0,0
Xsky130_fd_sc_hd__fill_8_1555
+ vss
+ vdd
+ vdd
+ sky130_fd_sc_hd__fill_8
* cell instance sky130_fd_sc_hd__fill_8_1556 r0 *1 0,0
Xsky130_fd_sc_hd__fill_8_1556
+ vss
+ vdd
+ vdd
+ sky130_fd_sc_hd__fill_8
* cell instance sky130_fd_sc_hd__fill_8_1557 r0 *1 0,0
Xsky130_fd_sc_hd__fill_8_1557
+ vss
+ vdd
+ vdd
+ sky130_fd_sc_hd__fill_8
* cell instance sky130_fd_sc_hd__fill_8_1558 r0 *1 0,0
Xsky130_fd_sc_hd__fill_8_1558
+ vss
+ vdd
+ vdd
+ sky130_fd_sc_hd__fill_8
* cell instance sky130_fd_sc_hd__fill_8_1559 r0 *1 0,0
Xsky130_fd_sc_hd__fill_8_1559
+ vss
+ vdd
+ vdd
+ sky130_fd_sc_hd__fill_8
* cell instance sky130_fd_sc_hd__fill_8_1560 r0 *1 0,0
Xsky130_fd_sc_hd__fill_8_1560
+ vss
+ vdd
+ vdd
+ sky130_fd_sc_hd__fill_8
* cell instance sky130_fd_sc_hd__fill_8_1561 r0 *1 0,0
Xsky130_fd_sc_hd__fill_8_1561
+ vss
+ vdd
+ vdd
+ sky130_fd_sc_hd__fill_8
* cell instance sky130_fd_sc_hd__fill_8_1562 r0 *1 0,0
Xsky130_fd_sc_hd__fill_8_1562
+ vss
+ vdd
+ vdd
+ sky130_fd_sc_hd__fill_8
* cell instance sky130_fd_sc_hd__fill_8_1563 r0 *1 0,0
Xsky130_fd_sc_hd__fill_8_1563
+ vss
+ vdd
+ vdd
+ sky130_fd_sc_hd__fill_8
* cell instance sky130_fd_sc_hd__fill_8_1564 r0 *1 0,0
Xsky130_fd_sc_hd__fill_8_1564
+ vss
+ vdd
+ vdd
+ sky130_fd_sc_hd__fill_8
* cell instance sky130_fd_sc_hd__fill_8_1565 r0 *1 0,0
Xsky130_fd_sc_hd__fill_8_1565
+ vss
+ vdd
+ vdd
+ sky130_fd_sc_hd__fill_8
* cell instance sky130_fd_sc_hd__fill_8_1566 r0 *1 0,0
Xsky130_fd_sc_hd__fill_8_1566
+ vss
+ vdd
+ vdd
+ sky130_fd_sc_hd__fill_8
* cell instance sky130_fd_sc_hd__fill_8_1567 r0 *1 0,0
Xsky130_fd_sc_hd__fill_8_1567
+ vss
+ vdd
+ vdd
+ sky130_fd_sc_hd__fill_8
* cell instance sky130_fd_sc_hd__fill_8_1568 r0 *1 0,0
Xsky130_fd_sc_hd__fill_8_1568
+ vss
+ vdd
+ vdd
+ sky130_fd_sc_hd__fill_8
* cell instance sky130_fd_sc_hd__fill_8_1569 r0 *1 0,0
Xsky130_fd_sc_hd__fill_8_1569
+ vss
+ vdd
+ vdd
+ sky130_fd_sc_hd__fill_8
* cell instance sky130_fd_sc_hd__fill_8_1570 r0 *1 0,0
Xsky130_fd_sc_hd__fill_8_1570
+ vss
+ vdd
+ vdd
+ sky130_fd_sc_hd__fill_8
* cell instance sky130_fd_sc_hd__fill_8_1571 r0 *1 0,0
Xsky130_fd_sc_hd__fill_8_1571
+ vss
+ vdd
+ vdd
+ sky130_fd_sc_hd__fill_8
* cell instance sky130_fd_sc_hd__fill_8_1572 r0 *1 0,0
Xsky130_fd_sc_hd__fill_8_1572
+ vss
+ vdd
+ vdd
+ sky130_fd_sc_hd__fill_8
* cell instance sky130_fd_sc_hd__fill_8_1573 r0 *1 0,0
Xsky130_fd_sc_hd__fill_8_1573
+ vss
+ vdd
+ vdd
+ sky130_fd_sc_hd__fill_8
* cell instance sky130_fd_sc_hd__fill_8_1574 r0 *1 0,0
Xsky130_fd_sc_hd__fill_8_1574
+ vss
+ vdd
+ vdd
+ sky130_fd_sc_hd__fill_8
* cell instance sky130_fd_sc_hd__fill_8_1575 r0 *1 0,0
Xsky130_fd_sc_hd__fill_8_1575
+ vss
+ vdd
+ vdd
+ sky130_fd_sc_hd__fill_8
* cell instance sky130_fd_sc_hd__fill_8_1576 r0 *1 0,0
Xsky130_fd_sc_hd__fill_8_1576
+ vss
+ vdd
+ vdd
+ sky130_fd_sc_hd__fill_8
* cell instance sky130_fd_sc_hd__fill_8_1577 r0 *1 0,0
Xsky130_fd_sc_hd__fill_8_1577
+ vss
+ vdd
+ vdd
+ sky130_fd_sc_hd__fill_8
* cell instance sky130_fd_sc_hd__fill_8_1578 r0 *1 0,0
Xsky130_fd_sc_hd__fill_8_1578
+ vss
+ vdd
+ vdd
+ sky130_fd_sc_hd__fill_8
* cell instance sky130_fd_sc_hd__fill_8_1579 r0 *1 0,0
Xsky130_fd_sc_hd__fill_8_1579
+ vss
+ vdd
+ vdd
+ sky130_fd_sc_hd__fill_8
* cell instance sky130_fd_sc_hd__fill_8_1580 r0 *1 0,0
Xsky130_fd_sc_hd__fill_8_1580
+ vss
+ vdd
+ vdd
+ sky130_fd_sc_hd__fill_8
* cell instance sky130_fd_sc_hd__fill_8_1581 r0 *1 0,0
Xsky130_fd_sc_hd__fill_8_1581
+ vss
+ vdd
+ vdd
+ sky130_fd_sc_hd__fill_8
* cell instance sky130_fd_sc_hd__fill_8_1582 r0 *1 0,0
Xsky130_fd_sc_hd__fill_8_1582
+ vss
+ vdd
+ vdd
+ sky130_fd_sc_hd__fill_8
* cell instance sky130_fd_sc_hd__fill_8_1583 r0 *1 0,0
Xsky130_fd_sc_hd__fill_8_1583
+ vss
+ vdd
+ vdd
+ sky130_fd_sc_hd__fill_8
* cell instance sky130_fd_sc_hd__fill_8_1584 r0 *1 0,0
Xsky130_fd_sc_hd__fill_8_1584
+ vss
+ vdd
+ vdd
+ sky130_fd_sc_hd__fill_8
* cell instance sky130_fd_sc_hd__fill_8_1585 r0 *1 0,0
Xsky130_fd_sc_hd__fill_8_1585
+ vss
+ vdd
+ vdd
+ sky130_fd_sc_hd__fill_8
* cell instance sky130_fd_sc_hd__fill_8_1586 r0 *1 0,0
Xsky130_fd_sc_hd__fill_8_1586
+ vss
+ vdd
+ vdd
+ sky130_fd_sc_hd__fill_8
* cell instance sky130_fd_sc_hd__fill_8_1587 r0 *1 0,0
Xsky130_fd_sc_hd__fill_8_1587
+ vss
+ vdd
+ vdd
+ sky130_fd_sc_hd__fill_8
* cell instance sky130_fd_sc_hd__fill_8_1588 r0 *1 0,0
Xsky130_fd_sc_hd__fill_8_1588
+ vss
+ vdd
+ vdd
+ sky130_fd_sc_hd__fill_8
* cell instance sky130_fd_sc_hd__fill_8_1589 r0 *1 0,0
Xsky130_fd_sc_hd__fill_8_1589
+ vss
+ vdd
+ vdd
+ sky130_fd_sc_hd__fill_8
* cell instance sky130_fd_sc_hd__fill_8_1590 r0 *1 0,0
Xsky130_fd_sc_hd__fill_8_1590
+ vss
+ vdd
+ vdd
+ sky130_fd_sc_hd__fill_8
* cell instance sky130_fd_sc_hd__fill_8_1591 r0 *1 0,0
Xsky130_fd_sc_hd__fill_8_1591
+ vss
+ vdd
+ vdd
+ sky130_fd_sc_hd__fill_8
* cell instance sky130_fd_sc_hd__fill_8_1592 r0 *1 0,0
Xsky130_fd_sc_hd__fill_8_1592
+ vss
+ vdd
+ vdd
+ sky130_fd_sc_hd__fill_8
* cell instance sky130_fd_sc_hd__fill_8_1593 r0 *1 0,0
Xsky130_fd_sc_hd__fill_8_1593
+ vss
+ vdd
+ vdd
+ sky130_fd_sc_hd__fill_8
* cell instance sky130_fd_sc_hd__fill_8_1594 r0 *1 0,0
Xsky130_fd_sc_hd__fill_8_1594
+ vss
+ vdd
+ vdd
+ sky130_fd_sc_hd__fill_8
* cell instance sky130_fd_sc_hd__fill_8_1595 r0 *1 0,0
Xsky130_fd_sc_hd__fill_8_1595
+ vss
+ vdd
+ vdd
+ sky130_fd_sc_hd__fill_8
* cell instance sky130_fd_sc_hd__fill_8_1596 r0 *1 0,0
Xsky130_fd_sc_hd__fill_8_1596
+ vss
+ vdd
+ vdd
+ sky130_fd_sc_hd__fill_8
* cell instance sky130_fd_sc_hd__fill_8_1597 r0 *1 0,0
Xsky130_fd_sc_hd__fill_8_1597
+ vss
+ vdd
+ vdd
+ sky130_fd_sc_hd__fill_8
* cell instance sky130_fd_sc_hd__fill_8_1598 r0 *1 0,0
Xsky130_fd_sc_hd__fill_8_1598
+ vss
+ vdd
+ vdd
+ sky130_fd_sc_hd__fill_8
* cell instance sky130_fd_sc_hd__fill_8_1599 r0 *1 0,0
Xsky130_fd_sc_hd__fill_8_1599
+ vss
+ vdd
+ vdd
+ sky130_fd_sc_hd__fill_8
* cell instance sky130_fd_sc_hd__fill_8_1600 r0 *1 0,0
Xsky130_fd_sc_hd__fill_8_1600
+ vss
+ vdd
+ vdd
+ sky130_fd_sc_hd__fill_8
* cell instance sky130_fd_sc_hd__fill_8_1601 r0 *1 0,0
Xsky130_fd_sc_hd__fill_8_1601
+ vss
+ vdd
+ vdd
+ sky130_fd_sc_hd__fill_8
* cell instance sky130_fd_sc_hd__fill_8_1602 r0 *1 0,0
Xsky130_fd_sc_hd__fill_8_1602
+ vss
+ vdd
+ vdd
+ sky130_fd_sc_hd__fill_8
* cell instance sky130_fd_sc_hd__fill_8_1603 r0 *1 0,0
Xsky130_fd_sc_hd__fill_8_1603
+ vss
+ vdd
+ vdd
+ sky130_fd_sc_hd__fill_8
* cell instance sky130_fd_sc_hd__fill_8_1604 r0 *1 0,0
Xsky130_fd_sc_hd__fill_8_1604
+ vss
+ vdd
+ vdd
+ sky130_fd_sc_hd__fill_8
* cell instance sky130_fd_sc_hd__fill_8_1605 r0 *1 0,0
Xsky130_fd_sc_hd__fill_8_1605
+ vss
+ vdd
+ vdd
+ sky130_fd_sc_hd__fill_8
* cell instance sky130_fd_sc_hd__fill_8_1606 r0 *1 0,0
Xsky130_fd_sc_hd__fill_8_1606
+ vss
+ vdd
+ vdd
+ sky130_fd_sc_hd__fill_8
* cell instance sky130_fd_sc_hd__fill_8_1607 r0 *1 0,0
Xsky130_fd_sc_hd__fill_8_1607
+ vss
+ vdd
+ vdd
+ sky130_fd_sc_hd__fill_8
* cell instance sky130_fd_sc_hd__fill_8_1608 r0 *1 0,0
Xsky130_fd_sc_hd__fill_8_1608
+ vss
+ vdd
+ vdd
+ sky130_fd_sc_hd__fill_8
* cell instance sky130_fd_sc_hd__fill_8_1609 r0 *1 0,0
Xsky130_fd_sc_hd__fill_8_1609
+ vss
+ vdd
+ vdd
+ sky130_fd_sc_hd__fill_8
* cell instance sky130_fd_sc_hd__fill_8_1610 r0 *1 0,0
Xsky130_fd_sc_hd__fill_8_1610
+ vss
+ vdd
+ vdd
+ sky130_fd_sc_hd__fill_8
* cell instance sky130_fd_sc_hd__fill_8_1611 r0 *1 0,0
Xsky130_fd_sc_hd__fill_8_1611
+ vss
+ vdd
+ vdd
+ sky130_fd_sc_hd__fill_8
* cell instance sky130_fd_sc_hd__fill_8_1612 r0 *1 0,0
Xsky130_fd_sc_hd__fill_8_1612
+ vss
+ vdd
+ vdd
+ sky130_fd_sc_hd__fill_8
* cell instance sky130_fd_sc_hd__fill_8_1613 r0 *1 0,0
Xsky130_fd_sc_hd__fill_8_1613
+ vss
+ vdd
+ vdd
+ sky130_fd_sc_hd__fill_8
* cell instance sky130_fd_sc_hd__fill_8_1614 r0 *1 0,0
Xsky130_fd_sc_hd__fill_8_1614
+ vss
+ vdd
+ vdd
+ sky130_fd_sc_hd__fill_8
* cell instance sky130_fd_sc_hd__fill_8_1615 r0 *1 0,0
Xsky130_fd_sc_hd__fill_8_1615
+ vss
+ vdd
+ vdd
+ sky130_fd_sc_hd__fill_8
* cell instance sky130_fd_sc_hd__fill_8_1616 r0 *1 0,0
Xsky130_fd_sc_hd__fill_8_1616
+ vss
+ vdd
+ vdd
+ sky130_fd_sc_hd__fill_8
* cell instance sky130_fd_sc_hd__fill_8_1617 r0 *1 0,0
Xsky130_fd_sc_hd__fill_8_1617
+ vss
+ vdd
+ vdd
+ sky130_fd_sc_hd__fill_8
* cell instance sky130_fd_sc_hd__fill_8_1618 r0 *1 0,0
Xsky130_fd_sc_hd__fill_8_1618
+ vss
+ vdd
+ vdd
+ sky130_fd_sc_hd__fill_8
* cell instance sky130_fd_sc_hd__fill_8_1619 r0 *1 0,0
Xsky130_fd_sc_hd__fill_8_1619
+ vss
+ vdd
+ vdd
+ sky130_fd_sc_hd__fill_8
* cell instance sky130_fd_sc_hd__fill_8_1620 r0 *1 0,0
Xsky130_fd_sc_hd__fill_8_1620
+ vss
+ vdd
+ vdd
+ sky130_fd_sc_hd__fill_8
* cell instance sky130_fd_sc_hd__fill_8_1621 r0 *1 0,0
Xsky130_fd_sc_hd__fill_8_1621
+ vss
+ vdd
+ vdd
+ sky130_fd_sc_hd__fill_8
* cell instance sky130_fd_sc_hd__fill_8_1622 r0 *1 0,0
Xsky130_fd_sc_hd__fill_8_1622
+ vss
+ vdd
+ vdd
+ sky130_fd_sc_hd__fill_8
* cell instance sky130_fd_sc_hd__fill_8_1623 r0 *1 0,0
Xsky130_fd_sc_hd__fill_8_1623
+ vss
+ vdd
+ vdd
+ sky130_fd_sc_hd__fill_8
* cell instance sky130_fd_sc_hd__fill_8_1624 r0 *1 0,0
Xsky130_fd_sc_hd__fill_8_1624
+ vss
+ vdd
+ vdd
+ sky130_fd_sc_hd__fill_8
* cell instance sky130_fd_sc_hd__fill_8_1625 r0 *1 0,0
Xsky130_fd_sc_hd__fill_8_1625
+ vss
+ vdd
+ vdd
+ sky130_fd_sc_hd__fill_8
* cell instance sky130_fd_sc_hd__fill_8_1626 r0 *1 0,0
Xsky130_fd_sc_hd__fill_8_1626
+ vss
+ vdd
+ vdd
+ sky130_fd_sc_hd__fill_8
* cell instance sky130_fd_sc_hd__fill_8_1627 r0 *1 0,0
Xsky130_fd_sc_hd__fill_8_1627
+ vss
+ vdd
+ vdd
+ sky130_fd_sc_hd__fill_8
* cell instance sky130_fd_sc_hd__fill_8_1628 r0 *1 0,0
Xsky130_fd_sc_hd__fill_8_1628
+ vss
+ vdd
+ vdd
+ sky130_fd_sc_hd__fill_8
* cell instance sky130_fd_sc_hd__fill_8_1629 r0 *1 0,0
Xsky130_fd_sc_hd__fill_8_1629
+ vss
+ vdd
+ vdd
+ sky130_fd_sc_hd__fill_8
* cell instance sky130_fd_sc_hd__fill_8_1630 r0 *1 0,0
Xsky130_fd_sc_hd__fill_8_1630
+ vss
+ vdd
+ vdd
+ sky130_fd_sc_hd__fill_8
* cell instance sky130_fd_sc_hd__fill_8_1631 r0 *1 0,0
Xsky130_fd_sc_hd__fill_8_1631
+ vss
+ vdd
+ vdd
+ sky130_fd_sc_hd__fill_8
* cell instance sky130_fd_sc_hd__fill_8_1632 r0 *1 0,0
Xsky130_fd_sc_hd__fill_8_1632
+ vss
+ vdd
+ vdd
+ sky130_fd_sc_hd__fill_8
* cell instance sky130_fd_sc_hd__fill_8_1633 r0 *1 0,0
Xsky130_fd_sc_hd__fill_8_1633
+ vss
+ vdd
+ vdd
+ sky130_fd_sc_hd__fill_8
* cell instance sky130_fd_sc_hd__fill_8_1634 r0 *1 0,0
Xsky130_fd_sc_hd__fill_8_1634
+ vss
+ vdd
+ vdd
+ sky130_fd_sc_hd__fill_8
* cell instance sky130_fd_sc_hd__fill_8_1635 r0 *1 0,0
Xsky130_fd_sc_hd__fill_8_1635
+ vss
+ vdd
+ vdd
+ sky130_fd_sc_hd__fill_8
* cell instance sky130_fd_sc_hd__fill_8_1636 r0 *1 0,0
Xsky130_fd_sc_hd__fill_8_1636
+ vss
+ vdd
+ vdd
+ sky130_fd_sc_hd__fill_8
* cell instance sky130_fd_sc_hd__fill_8_1637 r0 *1 0,0
Xsky130_fd_sc_hd__fill_8_1637
+ vss
+ vdd
+ vdd
+ sky130_fd_sc_hd__fill_8
* cell instance sky130_fd_sc_hd__fill_8_1638 r0 *1 0,0
Xsky130_fd_sc_hd__fill_8_1638
+ vss
+ vdd
+ vdd
+ sky130_fd_sc_hd__fill_8
* cell instance sky130_fd_sc_hd__fill_8_1639 r0 *1 0,0
Xsky130_fd_sc_hd__fill_8_1639
+ vss
+ vdd
+ vdd
+ sky130_fd_sc_hd__fill_8
* cell instance sky130_fd_sc_hd__fill_8_1640 r0 *1 0,0
Xsky130_fd_sc_hd__fill_8_1640
+ vss
+ vdd
+ vdd
+ sky130_fd_sc_hd__fill_8
* cell instance sky130_fd_sc_hd__fill_8_1641 r0 *1 0,0
Xsky130_fd_sc_hd__fill_8_1641
+ vss
+ vdd
+ vdd
+ sky130_fd_sc_hd__fill_8
* cell instance sky130_fd_sc_hd__fill_8_1642 r0 *1 0,0
Xsky130_fd_sc_hd__fill_8_1642
+ vss
+ vdd
+ vdd
+ sky130_fd_sc_hd__fill_8
* cell instance sky130_fd_sc_hd__fill_8_1643 r0 *1 0,0
Xsky130_fd_sc_hd__fill_8_1643
+ vss
+ vdd
+ vdd
+ sky130_fd_sc_hd__fill_8
* cell instance sky130_fd_sc_hd__fill_8_1644 r0 *1 0,0
Xsky130_fd_sc_hd__fill_8_1644
+ vss
+ vdd
+ vdd
+ sky130_fd_sc_hd__fill_8
* cell instance sky130_fd_sc_hd__fill_8_1645 r0 *1 0,0
Xsky130_fd_sc_hd__fill_8_1645
+ vss
+ vdd
+ vdd
+ sky130_fd_sc_hd__fill_8
* cell instance sky130_fd_sc_hd__fill_8_1646 r0 *1 0,0
Xsky130_fd_sc_hd__fill_8_1646
+ vss
+ vdd
+ vdd
+ sky130_fd_sc_hd__fill_8
* cell instance sky130_fd_sc_hd__fill_8_1647 r0 *1 0,0
Xsky130_fd_sc_hd__fill_8_1647
+ vss
+ vdd
+ vdd
+ sky130_fd_sc_hd__fill_8
* cell instance sky130_fd_sc_hd__fill_8_1648 r0 *1 0,0
Xsky130_fd_sc_hd__fill_8_1648
+ vss
+ vdd
+ vdd
+ sky130_fd_sc_hd__fill_8
* cell instance sky130_fd_sc_hd__fill_8_1649 r0 *1 0,0
Xsky130_fd_sc_hd__fill_8_1649
+ vss
+ vdd
+ vdd
+ sky130_fd_sc_hd__fill_8
* cell instance sky130_fd_sc_hd__fill_8_1650 r0 *1 0,0
Xsky130_fd_sc_hd__fill_8_1650
+ vss
+ vdd
+ vdd
+ sky130_fd_sc_hd__fill_8
* cell instance sky130_fd_sc_hd__fill_8_1651 r0 *1 0,0
Xsky130_fd_sc_hd__fill_8_1651
+ vss
+ vdd
+ vdd
+ sky130_fd_sc_hd__fill_8
* cell instance sky130_fd_sc_hd__fill_8_1652 r0 *1 0,0
Xsky130_fd_sc_hd__fill_8_1652
+ vss
+ vdd
+ vdd
+ sky130_fd_sc_hd__fill_8
* cell instance sky130_fd_sc_hd__fill_8_1653 r0 *1 0,0
Xsky130_fd_sc_hd__fill_8_1653
+ vss
+ vdd
+ vdd
+ sky130_fd_sc_hd__fill_8
* cell instance sky130_fd_sc_hd__fill_8_1654 r0 *1 0,0
Xsky130_fd_sc_hd__fill_8_1654
+ vss
+ vdd
+ vdd
+ sky130_fd_sc_hd__fill_8
* cell instance sky130_fd_sc_hd__fill_8_1655 r0 *1 0,0
Xsky130_fd_sc_hd__fill_8_1655
+ vss
+ vdd
+ vdd
+ sky130_fd_sc_hd__fill_8
* cell instance sky130_fd_sc_hd__fill_8_1656 r0 *1 0,0
Xsky130_fd_sc_hd__fill_8_1656
+ vss
+ vdd
+ vdd
+ sky130_fd_sc_hd__fill_8
* cell instance sky130_fd_sc_hd__fill_8_1657 r0 *1 0,0
Xsky130_fd_sc_hd__fill_8_1657
+ vss
+ vdd
+ vdd
+ sky130_fd_sc_hd__fill_8
* cell instance sky130_fd_sc_hd__fill_8_1658 r0 *1 0,0
Xsky130_fd_sc_hd__fill_8_1658
+ vss
+ vdd
+ vdd
+ sky130_fd_sc_hd__fill_8
* cell instance sky130_fd_sc_hd__fill_8_1659 r0 *1 0,0
Xsky130_fd_sc_hd__fill_8_1659
+ vss
+ vdd
+ vdd
+ sky130_fd_sc_hd__fill_8
* cell instance sky130_fd_sc_hd__fill_8_1660 r0 *1 0,0
Xsky130_fd_sc_hd__fill_8_1660
+ vss
+ vdd
+ vdd
+ sky130_fd_sc_hd__fill_8
* cell instance sky130_fd_sc_hd__fill_8_1661 r0 *1 0,0
Xsky130_fd_sc_hd__fill_8_1661
+ vss
+ vdd
+ vdd
+ sky130_fd_sc_hd__fill_8
* cell instance sky130_fd_sc_hd__fill_8_1662 r0 *1 0,0
Xsky130_fd_sc_hd__fill_8_1662
+ vss
+ vdd
+ vdd
+ sky130_fd_sc_hd__fill_8
* cell instance sky130_fd_sc_hd__fill_8_1663 r0 *1 0,0
Xsky130_fd_sc_hd__fill_8_1663
+ vss
+ vdd
+ vdd
+ sky130_fd_sc_hd__fill_8
* cell instance sky130_fd_sc_hd__fill_8_1664 r0 *1 0,0
Xsky130_fd_sc_hd__fill_8_1664
+ vss
+ vdd
+ vdd
+ sky130_fd_sc_hd__fill_8
* cell instance sky130_fd_sc_hd__fill_8_1665 r0 *1 0,0
Xsky130_fd_sc_hd__fill_8_1665
+ vss
+ vdd
+ vdd
+ sky130_fd_sc_hd__fill_8
* cell instance sky130_fd_sc_hd__fill_8_1666 r0 *1 0,0
Xsky130_fd_sc_hd__fill_8_1666
+ vss
+ vdd
+ vdd
+ sky130_fd_sc_hd__fill_8
* cell instance sky130_fd_sc_hd__fill_8_1667 r0 *1 0,0
Xsky130_fd_sc_hd__fill_8_1667
+ vss
+ vdd
+ vdd
+ sky130_fd_sc_hd__fill_8
* cell instance sky130_fd_sc_hd__fill_8_1668 r0 *1 0,0
Xsky130_fd_sc_hd__fill_8_1668
+ vss
+ vdd
+ vdd
+ sky130_fd_sc_hd__fill_8
* cell instance sky130_fd_sc_hd__fill_8_1669 r0 *1 0,0
Xsky130_fd_sc_hd__fill_8_1669
+ vss
+ vdd
+ vdd
+ sky130_fd_sc_hd__fill_8
* cell instance sky130_fd_sc_hd__fill_8_1670 r0 *1 0,0
Xsky130_fd_sc_hd__fill_8_1670
+ vss
+ vdd
+ vdd
+ sky130_fd_sc_hd__fill_8
* cell instance sky130_fd_sc_hd__fill_8_1671 r0 *1 0,0
Xsky130_fd_sc_hd__fill_8_1671
+ vss
+ vdd
+ vdd
+ sky130_fd_sc_hd__fill_8
* cell instance sky130_fd_sc_hd__fill_8_1672 r0 *1 0,0
Xsky130_fd_sc_hd__fill_8_1672
+ vss
+ vdd
+ vdd
+ sky130_fd_sc_hd__fill_8
* cell instance sky130_fd_sc_hd__fill_8_1673 r0 *1 0,0
Xsky130_fd_sc_hd__fill_8_1673
+ vss
+ vdd
+ vdd
+ sky130_fd_sc_hd__fill_8
* cell instance sky130_fd_sc_hd__fill_8_1674 r0 *1 0,0
Xsky130_fd_sc_hd__fill_8_1674
+ vss
+ vdd
+ vdd
+ sky130_fd_sc_hd__fill_8
* cell instance sky130_fd_sc_hd__fill_8_1675 r0 *1 0,0
Xsky130_fd_sc_hd__fill_8_1675
+ vss
+ vdd
+ vdd
+ sky130_fd_sc_hd__fill_8
* cell instance sky130_fd_sc_hd__fill_8_1676 r0 *1 0,0
Xsky130_fd_sc_hd__fill_8_1676
+ vss
+ vdd
+ vdd
+ sky130_fd_sc_hd__fill_8
* cell instance sky130_fd_sc_hd__fill_8_1677 r0 *1 0,0
Xsky130_fd_sc_hd__fill_8_1677
+ vss
+ vdd
+ vdd
+ sky130_fd_sc_hd__fill_8
* cell instance sky130_fd_sc_hd__fill_8_1678 r0 *1 0,0
Xsky130_fd_sc_hd__fill_8_1678
+ vss
+ vdd
+ vdd
+ sky130_fd_sc_hd__fill_8
* cell instance sky130_fd_sc_hd__fill_8_1679 r0 *1 0,0
Xsky130_fd_sc_hd__fill_8_1679
+ vss
+ vdd
+ vdd
+ sky130_fd_sc_hd__fill_8
* cell instance sky130_fd_sc_hd__fill_8_1680 r0 *1 0,0
Xsky130_fd_sc_hd__fill_8_1680
+ vss
+ vdd
+ vdd
+ sky130_fd_sc_hd__fill_8
* cell instance sky130_fd_sc_hd__fill_8_1681 r0 *1 0,0
Xsky130_fd_sc_hd__fill_8_1681
+ vss
+ vdd
+ vdd
+ sky130_fd_sc_hd__fill_8
* cell instance sky130_fd_sc_hd__fill_8_1682 r0 *1 0,0
Xsky130_fd_sc_hd__fill_8_1682
+ vss
+ vdd
+ vdd
+ sky130_fd_sc_hd__fill_8
* cell instance sky130_fd_sc_hd__fill_8_1683 r0 *1 0,0
Xsky130_fd_sc_hd__fill_8_1683
+ vss
+ vdd
+ vdd
+ sky130_fd_sc_hd__fill_8
* cell instance sky130_fd_sc_hd__fill_8_1684 r0 *1 0,0
Xsky130_fd_sc_hd__fill_8_1684
+ vss
+ vdd
+ vdd
+ sky130_fd_sc_hd__fill_8
* cell instance sky130_fd_sc_hd__fill_8_1685 r0 *1 0,0
Xsky130_fd_sc_hd__fill_8_1685
+ vss
+ vdd
+ vdd
+ sky130_fd_sc_hd__fill_8
* cell instance sky130_fd_sc_hd__fill_8_1686 r0 *1 0,0
Xsky130_fd_sc_hd__fill_8_1686
+ vss
+ vdd
+ vdd
+ sky130_fd_sc_hd__fill_8
* cell instance sky130_fd_sc_hd__fill_8_1687 r0 *1 0,0
Xsky130_fd_sc_hd__fill_8_1687
+ vss
+ vdd
+ vdd
+ sky130_fd_sc_hd__fill_8
* cell instance sky130_fd_sc_hd__fill_8_1688 r0 *1 0,0
Xsky130_fd_sc_hd__fill_8_1688
+ vss
+ vdd
+ vdd
+ sky130_fd_sc_hd__fill_8
* cell instance sky130_fd_sc_hd__fill_8_1689 r0 *1 0,0
Xsky130_fd_sc_hd__fill_8_1689
+ vss
+ vdd
+ vdd
+ sky130_fd_sc_hd__fill_8
* cell instance sky130_fd_sc_hd__fill_8_1690 r0 *1 0,0
Xsky130_fd_sc_hd__fill_8_1690
+ vss
+ vdd
+ vdd
+ sky130_fd_sc_hd__fill_8
* cell instance sky130_fd_sc_hd__fill_8_1691 r0 *1 0,0
Xsky130_fd_sc_hd__fill_8_1691
+ vss
+ vdd
+ vdd
+ sky130_fd_sc_hd__fill_8
* cell instance sky130_fd_sc_hd__fill_8_1692 r0 *1 0,0
Xsky130_fd_sc_hd__fill_8_1692
+ vss
+ vdd
+ vdd
+ sky130_fd_sc_hd__fill_8
* cell instance sky130_fd_sc_hd__fill_8_1693 r0 *1 0,0
Xsky130_fd_sc_hd__fill_8_1693
+ vss
+ vdd
+ vdd
+ sky130_fd_sc_hd__fill_8
* cell instance sky130_fd_sc_hd__fill_8_1694 r0 *1 0,0
Xsky130_fd_sc_hd__fill_8_1694
+ vss
+ vdd
+ vdd
+ sky130_fd_sc_hd__fill_8
* cell instance sky130_fd_sc_hd__fill_8_1695 r0 *1 0,0
Xsky130_fd_sc_hd__fill_8_1695
+ vss
+ vdd
+ vdd
+ sky130_fd_sc_hd__fill_8
* cell instance sky130_fd_sc_hd__fill_8_1696 r0 *1 0,0
Xsky130_fd_sc_hd__fill_8_1696
+ vss
+ vdd
+ vdd
+ sky130_fd_sc_hd__fill_8
* cell instance sky130_fd_sc_hd__fill_8_1697 r0 *1 0,0
Xsky130_fd_sc_hd__fill_8_1697
+ vss
+ vdd
+ vdd
+ sky130_fd_sc_hd__fill_8
* cell instance sky130_fd_sc_hd__fill_8_1698 r0 *1 0,0
Xsky130_fd_sc_hd__fill_8_1698
+ vss
+ vdd
+ vdd
+ sky130_fd_sc_hd__fill_8
* cell instance sky130_fd_sc_hd__fill_8_1699 r0 *1 0,0
Xsky130_fd_sc_hd__fill_8_1699
+ vss
+ vdd
+ vdd
+ sky130_fd_sc_hd__fill_8
* cell instance sky130_fd_sc_hd__fill_8_1700 r0 *1 0,0
Xsky130_fd_sc_hd__fill_8_1700
+ vss
+ vdd
+ vdd
+ sky130_fd_sc_hd__fill_8
* cell instance sky130_fd_sc_hd__fill_8_1701 r0 *1 0,0
Xsky130_fd_sc_hd__fill_8_1701
+ vss
+ vdd
+ vdd
+ sky130_fd_sc_hd__fill_8
* cell instance sky130_fd_sc_hd__fill_8_1702 r0 *1 0,0
Xsky130_fd_sc_hd__fill_8_1702
+ vss
+ vdd
+ vdd
+ sky130_fd_sc_hd__fill_8
* cell instance sky130_fd_sc_hd__fill_8_1703 r0 *1 0,0
Xsky130_fd_sc_hd__fill_8_1703
+ vss
+ vdd
+ vdd
+ sky130_fd_sc_hd__fill_8
* cell instance sky130_fd_sc_hd__fill_8_1704 r0 *1 0,0
Xsky130_fd_sc_hd__fill_8_1704
+ vss
+ vdd
+ vdd
+ sky130_fd_sc_hd__fill_8
* cell instance sky130_fd_sc_hd__fill_8_1705 r0 *1 0,0
Xsky130_fd_sc_hd__fill_8_1705
+ vss
+ vdd
+ vdd
+ sky130_fd_sc_hd__fill_8
* cell instance sky130_fd_sc_hd__fill_8_1706 r0 *1 0,0
Xsky130_fd_sc_hd__fill_8_1706
+ vss
+ vdd
+ vdd
+ sky130_fd_sc_hd__fill_8
* cell instance sky130_fd_sc_hd__fill_8_1707 r0 *1 0,0
Xsky130_fd_sc_hd__fill_8_1707
+ vss
+ vdd
+ vdd
+ sky130_fd_sc_hd__fill_8
* cell instance sky130_fd_sc_hd__fill_8_1708 r0 *1 0,0
Xsky130_fd_sc_hd__fill_8_1708
+ vss
+ vdd
+ vdd
+ sky130_fd_sc_hd__fill_8
* cell instance sky130_fd_sc_hd__fill_8_1709 r0 *1 0,0
Xsky130_fd_sc_hd__fill_8_1709
+ vss
+ vdd
+ vdd
+ sky130_fd_sc_hd__fill_8
* cell instance sky130_fd_sc_hd__fill_8_1710 r0 *1 0,0
Xsky130_fd_sc_hd__fill_8_1710
+ vss
+ vdd
+ vdd
+ sky130_fd_sc_hd__fill_8
* cell instance sky130_fd_sc_hd__fill_8_1711 r0 *1 0,0
Xsky130_fd_sc_hd__fill_8_1711
+ vss
+ vdd
+ vdd
+ sky130_fd_sc_hd__fill_8
* cell instance sky130_fd_sc_hd__fill_8_1712 r0 *1 0,0
Xsky130_fd_sc_hd__fill_8_1712
+ vss
+ vdd
+ vdd
+ sky130_fd_sc_hd__fill_8
* cell instance sky130_fd_sc_hd__fill_8_1713 r0 *1 0,0
Xsky130_fd_sc_hd__fill_8_1713
+ vss
+ vdd
+ vdd
+ sky130_fd_sc_hd__fill_8
* cell instance sky130_fd_sc_hd__fill_8_1714 r0 *1 0,0
Xsky130_fd_sc_hd__fill_8_1714
+ vss
+ vdd
+ vdd
+ sky130_fd_sc_hd__fill_8
* cell instance sky130_fd_sc_hd__fill_8_1715 r0 *1 0,0
Xsky130_fd_sc_hd__fill_8_1715
+ vss
+ vdd
+ vdd
+ sky130_fd_sc_hd__fill_8
* cell instance sky130_fd_sc_hd__fill_8_1716 r0 *1 0,0
Xsky130_fd_sc_hd__fill_8_1716
+ vss
+ vdd
+ vdd
+ sky130_fd_sc_hd__fill_8
* cell instance sky130_fd_sc_hd__fill_8_1717 r0 *1 0,0
Xsky130_fd_sc_hd__fill_8_1717
+ vss
+ vdd
+ vdd
+ sky130_fd_sc_hd__fill_8
* cell instance sky130_fd_sc_hd__fill_8_1718 r0 *1 0,0
Xsky130_fd_sc_hd__fill_8_1718
+ vss
+ vdd
+ vdd
+ sky130_fd_sc_hd__fill_8
* cell instance sky130_fd_sc_hd__fill_8_1719 r0 *1 0,0
Xsky130_fd_sc_hd__fill_8_1719
+ vss
+ vdd
+ vdd
+ sky130_fd_sc_hd__fill_8
* cell instance sky130_fd_sc_hd__fill_8_1720 r0 *1 0,0
Xsky130_fd_sc_hd__fill_8_1720
+ vss
+ vdd
+ vdd
+ sky130_fd_sc_hd__fill_8
* cell instance sky130_fd_sc_hd__fill_8_1721 r0 *1 0,0
Xsky130_fd_sc_hd__fill_8_1721
+ vss
+ vdd
+ vdd
+ sky130_fd_sc_hd__fill_8
* cell instance sky130_fd_sc_hd__fill_8_1722 r0 *1 0,0
Xsky130_fd_sc_hd__fill_8_1722
+ vss
+ vdd
+ vdd
+ sky130_fd_sc_hd__fill_8
* cell instance sky130_fd_sc_hd__fill_8_1723 r0 *1 0,0
Xsky130_fd_sc_hd__fill_8_1723
+ vss
+ vdd
+ vdd
+ sky130_fd_sc_hd__fill_8
* cell instance sky130_fd_sc_hd__fill_8_1724 r0 *1 0,0
Xsky130_fd_sc_hd__fill_8_1724
+ vss
+ vdd
+ vdd
+ sky130_fd_sc_hd__fill_8
* cell instance sky130_fd_sc_hd__fill_8_1725 r0 *1 0,0
Xsky130_fd_sc_hd__fill_8_1725
+ vss
+ vdd
+ vdd
+ sky130_fd_sc_hd__fill_8
* cell instance sky130_fd_sc_hd__fill_8_1726 r0 *1 0,0
Xsky130_fd_sc_hd__fill_8_1726
+ vss
+ vdd
+ vdd
+ sky130_fd_sc_hd__fill_8
* cell instance sky130_fd_sc_hd__fill_8_1727 r0 *1 0,0
Xsky130_fd_sc_hd__fill_8_1727
+ vss
+ vdd
+ vdd
+ sky130_fd_sc_hd__fill_8
* cell instance sky130_fd_sc_hd__fill_8_1728 r0 *1 0,0
Xsky130_fd_sc_hd__fill_8_1728
+ vss
+ vdd
+ vdd
+ sky130_fd_sc_hd__fill_8
* cell instance sky130_fd_sc_hd__fill_8_1729 r0 *1 0,0
Xsky130_fd_sc_hd__fill_8_1729
+ vss
+ vdd
+ vdd
+ sky130_fd_sc_hd__fill_8
* cell instance sky130_fd_sc_hd__fill_8_1730 r0 *1 0,0
Xsky130_fd_sc_hd__fill_8_1730
+ vss
+ vdd
+ vdd
+ sky130_fd_sc_hd__fill_8
* cell instance sky130_fd_sc_hd__fill_8_1731 r0 *1 0,0
Xsky130_fd_sc_hd__fill_8_1731
+ vss
+ vdd
+ vdd
+ sky130_fd_sc_hd__fill_8
* cell instance sky130_fd_sc_hd__fill_8_1732 r0 *1 0,0
Xsky130_fd_sc_hd__fill_8_1732
+ vss
+ vdd
+ vdd
+ sky130_fd_sc_hd__fill_8
* cell instance sky130_fd_sc_hd__fill_8_1733 r0 *1 0,0
Xsky130_fd_sc_hd__fill_8_1733
+ vss
+ vdd
+ vdd
+ sky130_fd_sc_hd__fill_8
* cell instance sky130_fd_sc_hd__fill_8_1734 r0 *1 0,0
Xsky130_fd_sc_hd__fill_8_1734
+ vss
+ vdd
+ vdd
+ sky130_fd_sc_hd__fill_8
* cell instance sky130_fd_sc_hd__fill_8_1735 r0 *1 0,0
Xsky130_fd_sc_hd__fill_8_1735
+ vss
+ vdd
+ vdd
+ sky130_fd_sc_hd__fill_8
* cell instance sky130_fd_sc_hd__fill_8_1736 r0 *1 0,0
Xsky130_fd_sc_hd__fill_8_1736
+ vss
+ vdd
+ vdd
+ sky130_fd_sc_hd__fill_8
* cell instance sky130_fd_sc_hd__fill_8_1737 r0 *1 0,0
Xsky130_fd_sc_hd__fill_8_1737
+ vss
+ vdd
+ vdd
+ sky130_fd_sc_hd__fill_8
* cell instance sky130_fd_sc_hd__fill_8_1738 r0 *1 0,0
Xsky130_fd_sc_hd__fill_8_1738
+ vss
+ vdd
+ vdd
+ sky130_fd_sc_hd__fill_8
* cell instance sky130_fd_sc_hd__fill_8_1739 r0 *1 0,0
Xsky130_fd_sc_hd__fill_8_1739
+ vss
+ vdd
+ vdd
+ sky130_fd_sc_hd__fill_8
* cell instance sky130_fd_sc_hd__fill_8_1740 r0 *1 0,0
Xsky130_fd_sc_hd__fill_8_1740
+ vss
+ vdd
+ vdd
+ sky130_fd_sc_hd__fill_8
* cell instance sky130_fd_sc_hd__fill_8_1741 r0 *1 0,0
Xsky130_fd_sc_hd__fill_8_1741
+ vss
+ vdd
+ vdd
+ sky130_fd_sc_hd__fill_8
* cell instance sky130_fd_sc_hd__fill_8_1742 r0 *1 0,0
Xsky130_fd_sc_hd__fill_8_1742
+ vss
+ vdd
+ vdd
+ sky130_fd_sc_hd__fill_8
* cell instance sky130_fd_sc_hd__fill_8_1743 r0 *1 0,0
Xsky130_fd_sc_hd__fill_8_1743
+ vss
+ vdd
+ vdd
+ sky130_fd_sc_hd__fill_8
* cell instance sky130_fd_sc_hd__fill_8_1744 r0 *1 0,0
Xsky130_fd_sc_hd__fill_8_1744
+ vss
+ vdd
+ vdd
+ sky130_fd_sc_hd__fill_8
* cell instance sky130_fd_sc_hd__fill_8_1745 r0 *1 0,0
Xsky130_fd_sc_hd__fill_8_1745
+ vss
+ vdd
+ vdd
+ sky130_fd_sc_hd__fill_8
* cell instance sky130_fd_sc_hd__fill_8_1746 r0 *1 0,0
Xsky130_fd_sc_hd__fill_8_1746
+ vss
+ vdd
+ vdd
+ sky130_fd_sc_hd__fill_8
* cell instance sky130_fd_sc_hd__fill_8_1747 r0 *1 0,0
Xsky130_fd_sc_hd__fill_8_1747
+ vss
+ vdd
+ vdd
+ sky130_fd_sc_hd__fill_8
* cell instance sky130_fd_sc_hd__fill_8_1748 r0 *1 0,0
Xsky130_fd_sc_hd__fill_8_1748
+ vss
+ vdd
+ vdd
+ sky130_fd_sc_hd__fill_8
* cell instance sky130_fd_sc_hd__fill_8_1749 r0 *1 0,0
Xsky130_fd_sc_hd__fill_8_1749
+ vss
+ vdd
+ vdd
+ sky130_fd_sc_hd__fill_8
* cell instance sky130_fd_sc_hd__fill_8_1750 r0 *1 0,0
Xsky130_fd_sc_hd__fill_8_1750
+ vss
+ vdd
+ vdd
+ sky130_fd_sc_hd__fill_8
* cell instance sky130_fd_sc_hd__fill_8_1751 r0 *1 0,0
Xsky130_fd_sc_hd__fill_8_1751
+ vss
+ vdd
+ vdd
+ sky130_fd_sc_hd__fill_8
* cell instance sky130_fd_sc_hd__fill_8_1752 r0 *1 0,0
Xsky130_fd_sc_hd__fill_8_1752
+ vss
+ vdd
+ vdd
+ sky130_fd_sc_hd__fill_8
* cell instance sky130_fd_sc_hd__fill_8_1753 r0 *1 0,0
Xsky130_fd_sc_hd__fill_8_1753
+ vss
+ vdd
+ vdd
+ sky130_fd_sc_hd__fill_8
* cell instance sky130_fd_sc_hd__fill_8_1754 r0 *1 0,0
Xsky130_fd_sc_hd__fill_8_1754
+ vss
+ vdd
+ vdd
+ sky130_fd_sc_hd__fill_8
* cell instance sky130_fd_sc_hd__fill_8_1755 r0 *1 0,0
Xsky130_fd_sc_hd__fill_8_1755
+ vss
+ vdd
+ vdd
+ sky130_fd_sc_hd__fill_8
* cell instance sky130_fd_sc_hd__fill_8_1756 r0 *1 0,0
Xsky130_fd_sc_hd__fill_8_1756
+ vss
+ vdd
+ vdd
+ sky130_fd_sc_hd__fill_8
* cell instance sky130_fd_sc_hd__fill_8_1757 r0 *1 0,0
Xsky130_fd_sc_hd__fill_8_1757
+ vss
+ vdd
+ vdd
+ sky130_fd_sc_hd__fill_8
* cell instance sky130_fd_sc_hd__fill_8_1758 r0 *1 0,0
Xsky130_fd_sc_hd__fill_8_1758
+ vss
+ vdd
+ vdd
+ sky130_fd_sc_hd__fill_8
* cell instance sky130_fd_sc_hd__fill_8_1759 r0 *1 0,0
Xsky130_fd_sc_hd__fill_8_1759
+ vss
+ vdd
+ vdd
+ sky130_fd_sc_hd__fill_8
* cell instance sky130_fd_sc_hd__fill_8_1760 r0 *1 0,0
Xsky130_fd_sc_hd__fill_8_1760
+ vss
+ vdd
+ vdd
+ sky130_fd_sc_hd__fill_8
* cell instance sky130_fd_sc_hd__fill_8_1761 r0 *1 0,0
Xsky130_fd_sc_hd__fill_8_1761
+ vss
+ vdd
+ vdd
+ sky130_fd_sc_hd__fill_8
* cell instance sky130_fd_sc_hd__fill_8_1762 r0 *1 0,0
Xsky130_fd_sc_hd__fill_8_1762
+ vss
+ vdd
+ vdd
+ sky130_fd_sc_hd__fill_8
* cell instance sky130_fd_sc_hd__fill_8_1763 r0 *1 0,0
Xsky130_fd_sc_hd__fill_8_1763
+ vss
+ vdd
+ vdd
+ sky130_fd_sc_hd__fill_8
* cell instance sky130_fd_sc_hd__fill_8_1764 r0 *1 0,0
Xsky130_fd_sc_hd__fill_8_1764
+ vss
+ vdd
+ vdd
+ sky130_fd_sc_hd__fill_8
* cell instance sky130_fd_sc_hd__fill_8_1765 r0 *1 0,0
Xsky130_fd_sc_hd__fill_8_1765
+ vss
+ vdd
+ vdd
+ sky130_fd_sc_hd__fill_8
* cell instance sky130_fd_sc_hd__fill_8_1766 r0 *1 0,0
Xsky130_fd_sc_hd__fill_8_1766
+ vss
+ vdd
+ vdd
+ sky130_fd_sc_hd__fill_8
* cell instance sky130_fd_sc_hd__fill_8_1767 r0 *1 0,0
Xsky130_fd_sc_hd__fill_8_1767
+ vss
+ vdd
+ vdd
+ sky130_fd_sc_hd__fill_8
* cell instance sky130_fd_sc_hd__fill_8_1768 r0 *1 0,0
Xsky130_fd_sc_hd__fill_8_1768
+ vss
+ vdd
+ vdd
+ sky130_fd_sc_hd__fill_8
* cell instance sky130_fd_sc_hd__fill_8_1769 r0 *1 0,0
Xsky130_fd_sc_hd__fill_8_1769
+ vss
+ vdd
+ vdd
+ sky130_fd_sc_hd__fill_8
* cell instance sky130_fd_sc_hd__fill_8_1770 r0 *1 0,0
Xsky130_fd_sc_hd__fill_8_1770
+ vss
+ vdd
+ vdd
+ sky130_fd_sc_hd__fill_8
* cell instance sky130_fd_sc_hd__fill_8_1771 r0 *1 0,0
Xsky130_fd_sc_hd__fill_8_1771
+ vss
+ vdd
+ vdd
+ sky130_fd_sc_hd__fill_8
* cell instance sky130_fd_sc_hd__fill_8_1772 r0 *1 0,0
Xsky130_fd_sc_hd__fill_8_1772
+ vss
+ vdd
+ vdd
+ sky130_fd_sc_hd__fill_8
* cell instance sky130_fd_sc_hd__fill_8_1773 r0 *1 0,0
Xsky130_fd_sc_hd__fill_8_1773
+ vss
+ vdd
+ vdd
+ sky130_fd_sc_hd__fill_8
* cell instance sky130_fd_sc_hd__fill_8_1774 r0 *1 0,0
Xsky130_fd_sc_hd__fill_8_1774
+ vss
+ vdd
+ vdd
+ sky130_fd_sc_hd__fill_8
* cell instance sky130_fd_sc_hd__fill_8_1775 r0 *1 0,0
Xsky130_fd_sc_hd__fill_8_1775
+ vss
+ vdd
+ vdd
+ sky130_fd_sc_hd__fill_8
* cell instance sky130_fd_sc_hd__fill_8_1776 r0 *1 0,0
Xsky130_fd_sc_hd__fill_8_1776
+ vss
+ vdd
+ vdd
+ sky130_fd_sc_hd__fill_8
* cell instance sky130_fd_sc_hd__fill_8_1777 r0 *1 0,0
Xsky130_fd_sc_hd__fill_8_1777
+ vss
+ vdd
+ vdd
+ sky130_fd_sc_hd__fill_8
* cell instance sky130_fd_sc_hd__fill_8_1778 r0 *1 0,0
Xsky130_fd_sc_hd__fill_8_1778
+ vss
+ vdd
+ vdd
+ sky130_fd_sc_hd__fill_8
* cell instance sky130_fd_sc_hd__fill_8_1779 r0 *1 0,0
Xsky130_fd_sc_hd__fill_8_1779
+ vss
+ vdd
+ vdd
+ sky130_fd_sc_hd__fill_8
* cell instance sky130_fd_sc_hd__fill_8_1780 r0 *1 0,0
Xsky130_fd_sc_hd__fill_8_1780
+ vss
+ vdd
+ vdd
+ sky130_fd_sc_hd__fill_8
* cell instance sky130_fd_sc_hd__fill_8_1781 r0 *1 0,0
Xsky130_fd_sc_hd__fill_8_1781
+ vss
+ vdd
+ vdd
+ sky130_fd_sc_hd__fill_8
* cell instance sky130_fd_sc_hd__fill_8_1782 r0 *1 0,0
Xsky130_fd_sc_hd__fill_8_1782
+ vss
+ vdd
+ vdd
+ sky130_fd_sc_hd__fill_8
* cell instance sky130_fd_sc_hd__fill_8_1783 r0 *1 0,0
Xsky130_fd_sc_hd__fill_8_1783
+ vss
+ vdd
+ vdd
+ sky130_fd_sc_hd__fill_8
* cell instance sky130_fd_sc_hd__fill_8_1784 r0 *1 0,0
Xsky130_fd_sc_hd__fill_8_1784
+ vss
+ vdd
+ vdd
+ sky130_fd_sc_hd__fill_8
* cell instance sky130_fd_sc_hd__fill_8_1785 r0 *1 0,0
Xsky130_fd_sc_hd__fill_8_1785
+ vss
+ vdd
+ vdd
+ sky130_fd_sc_hd__fill_8
* cell instance sky130_fd_sc_hd__fill_8_1786 r0 *1 0,0
Xsky130_fd_sc_hd__fill_8_1786
+ vss
+ vdd
+ vdd
+ sky130_fd_sc_hd__fill_8
* cell instance sky130_fd_sc_hd__fill_8_1787 r0 *1 0,0
Xsky130_fd_sc_hd__fill_8_1787
+ vss
+ vdd
+ vdd
+ sky130_fd_sc_hd__fill_8
* cell instance sky130_fd_sc_hd__fill_8_1788 r0 *1 0,0
Xsky130_fd_sc_hd__fill_8_1788
+ vss
+ vdd
+ vdd
+ sky130_fd_sc_hd__fill_8
* cell instance sky130_fd_sc_hd__fill_8_1789 r0 *1 0,0
Xsky130_fd_sc_hd__fill_8_1789
+ vss
+ vdd
+ vdd
+ sky130_fd_sc_hd__fill_8
* cell instance sky130_fd_sc_hd__fill_8_1790 r0 *1 0,0
Xsky130_fd_sc_hd__fill_8_1790
+ vss
+ vdd
+ vdd
+ sky130_fd_sc_hd__fill_8
* cell instance sky130_fd_sc_hd__fill_8_1791 r0 *1 0,0
Xsky130_fd_sc_hd__fill_8_1791
+ vss
+ vdd
+ vdd
+ sky130_fd_sc_hd__fill_8
* cell instance sky130_fd_sc_hd__fill_8_1792 r0 *1 0,0
Xsky130_fd_sc_hd__fill_8_1792
+ vss
+ vdd
+ vdd
+ sky130_fd_sc_hd__fill_8
* cell instance sky130_fd_sc_hd__fill_8_1793 r0 *1 0,0
Xsky130_fd_sc_hd__fill_8_1793
+ vss
+ vdd
+ vdd
+ sky130_fd_sc_hd__fill_8
* cell instance sky130_fd_sc_hd__fill_8_1794 r0 *1 0,0
Xsky130_fd_sc_hd__fill_8_1794
+ vss
+ vdd
+ vdd
+ sky130_fd_sc_hd__fill_8
* cell instance sky130_fd_sc_hd__fill_8_1795 r0 *1 0,0
Xsky130_fd_sc_hd__fill_8_1795
+ vss
+ vdd
+ vdd
+ sky130_fd_sc_hd__fill_8
* cell instance sky130_fd_sc_hd__fill_8_1796 r0 *1 0,0
Xsky130_fd_sc_hd__fill_8_1796
+ vss
+ vdd
+ vdd
+ sky130_fd_sc_hd__fill_8
* cell instance sky130_fd_sc_hd__fill_8_1797 r0 *1 0,0
Xsky130_fd_sc_hd__fill_8_1797
+ vss
+ vdd
+ vdd
+ sky130_fd_sc_hd__fill_8
* cell instance sky130_fd_sc_hd__fill_8_1798 r0 *1 0,0
Xsky130_fd_sc_hd__fill_8_1798
+ vss
+ vdd
+ vdd
+ sky130_fd_sc_hd__fill_8
* cell instance sky130_fd_sc_hd__fill_8_1799 r0 *1 0,0
Xsky130_fd_sc_hd__fill_8_1799
+ vss
+ vdd
+ vdd
+ sky130_fd_sc_hd__fill_8
* cell instance sky130_fd_sc_hd__fill_8_1800 r0 *1 0,0
Xsky130_fd_sc_hd__fill_8_1800
+ vss
+ vdd
+ vdd
+ sky130_fd_sc_hd__fill_8
* cell instance sky130_fd_sc_hd__fill_8_1801 r0 *1 0,0
Xsky130_fd_sc_hd__fill_8_1801
+ vss
+ vdd
+ vdd
+ sky130_fd_sc_hd__fill_8
* cell instance sky130_fd_sc_hd__fill_8_1802 r0 *1 0,0
Xsky130_fd_sc_hd__fill_8_1802
+ vss
+ vdd
+ vdd
+ sky130_fd_sc_hd__fill_8
* cell instance sky130_fd_sc_hd__fill_8_1803 r0 *1 0,0
Xsky130_fd_sc_hd__fill_8_1803
+ vss
+ vdd
+ vdd
+ sky130_fd_sc_hd__fill_8
* cell instance sky130_fd_sc_hd__fill_8_1804 r0 *1 0,0
Xsky130_fd_sc_hd__fill_8_1804
+ vss
+ vdd
+ vdd
+ sky130_fd_sc_hd__fill_8
* cell instance sky130_fd_sc_hd__fill_8_1805 r0 *1 0,0
Xsky130_fd_sc_hd__fill_8_1805
+ vss
+ vdd
+ vdd
+ sky130_fd_sc_hd__fill_8
* cell instance sky130_fd_sc_hd__fill_8_1806 r0 *1 0,0
Xsky130_fd_sc_hd__fill_8_1806
+ vss
+ vdd
+ vdd
+ sky130_fd_sc_hd__fill_8
* cell instance sky130_fd_sc_hd__fill_8_1807 r0 *1 0,0
Xsky130_fd_sc_hd__fill_8_1807
+ vss
+ vdd
+ vdd
+ sky130_fd_sc_hd__fill_8
* cell instance sky130_fd_sc_hd__fill_8_1808 r0 *1 0,0
Xsky130_fd_sc_hd__fill_8_1808
+ vss
+ vdd
+ vdd
+ sky130_fd_sc_hd__fill_8
* cell instance sky130_fd_sc_hd__fill_8_1809 r0 *1 0,0
Xsky130_fd_sc_hd__fill_8_1809
+ vss
+ vdd
+ vdd
+ sky130_fd_sc_hd__fill_8
* cell instance sky130_fd_sc_hd__fill_8_1810 r0 *1 0,0
Xsky130_fd_sc_hd__fill_8_1810
+ vss
+ vdd
+ vdd
+ sky130_fd_sc_hd__fill_8
* cell instance sky130_fd_sc_hd__fill_8_1811 r0 *1 0,0
Xsky130_fd_sc_hd__fill_8_1811
+ vss
+ vdd
+ vdd
+ sky130_fd_sc_hd__fill_8
* cell instance sky130_fd_sc_hd__fill_8_1812 r0 *1 0,0
Xsky130_fd_sc_hd__fill_8_1812
+ vss
+ vdd
+ vdd
+ sky130_fd_sc_hd__fill_8
* cell instance sky130_fd_sc_hd__fill_8_1813 r0 *1 0,0
Xsky130_fd_sc_hd__fill_8_1813
+ vss
+ vdd
+ vdd
+ sky130_fd_sc_hd__fill_8
* cell instance sky130_fd_sc_hd__fill_8_1814 r0 *1 0,0
Xsky130_fd_sc_hd__fill_8_1814
+ vss
+ vdd
+ vdd
+ sky130_fd_sc_hd__fill_8
* cell instance sky130_fd_sc_hd__fill_8_1815 r0 *1 0,0
Xsky130_fd_sc_hd__fill_8_1815
+ vss
+ vdd
+ vdd
+ sky130_fd_sc_hd__fill_8
* cell instance sky130_fd_sc_hd__fill_8_1816 r0 *1 0,0
Xsky130_fd_sc_hd__fill_8_1816
+ vss
+ vdd
+ vdd
+ sky130_fd_sc_hd__fill_8
* cell instance sky130_fd_sc_hd__fill_8_1817 r0 *1 0,0
Xsky130_fd_sc_hd__fill_8_1817
+ vss
+ vdd
+ vdd
+ sky130_fd_sc_hd__fill_8
* cell instance sky130_fd_sc_hd__fill_8_1818 r0 *1 0,0
Xsky130_fd_sc_hd__fill_8_1818
+ vss
+ vdd
+ vdd
+ sky130_fd_sc_hd__fill_8
* cell instance sky130_fd_sc_hd__fill_8_1819 r0 *1 0,0
Xsky130_fd_sc_hd__fill_8_1819
+ vss
+ vdd
+ vdd
+ sky130_fd_sc_hd__fill_8
* cell instance sky130_fd_sc_hd__fill_8_1820 r0 *1 0,0
Xsky130_fd_sc_hd__fill_8_1820
+ vss
+ vdd
+ vdd
+ sky130_fd_sc_hd__fill_8
* cell instance sky130_fd_sc_hd__fill_8_1821 r0 *1 0,0
Xsky130_fd_sc_hd__fill_8_1821
+ vss
+ vdd
+ vdd
+ sky130_fd_sc_hd__fill_8
* cell instance sky130_fd_sc_hd__fill_8_1822 r0 *1 0,0
Xsky130_fd_sc_hd__fill_8_1822
+ vss
+ vdd
+ vdd
+ sky130_fd_sc_hd__fill_8
* cell instance sky130_fd_sc_hd__fill_8_1823 r0 *1 0,0
Xsky130_fd_sc_hd__fill_8_1823
+ vss
+ vdd
+ vdd
+ sky130_fd_sc_hd__fill_8
* cell instance sky130_fd_sc_hd__fill_8_1824 r0 *1 0,0
Xsky130_fd_sc_hd__fill_8_1824
+ vss
+ vdd
+ vdd
+ sky130_fd_sc_hd__fill_8
* cell instance sky130_fd_sc_hd__fill_8_1825 r0 *1 0,0
Xsky130_fd_sc_hd__fill_8_1825
+ vss
+ vdd
+ vdd
+ sky130_fd_sc_hd__fill_8
* cell instance sky130_fd_sc_hd__fill_8_1826 r0 *1 0,0
Xsky130_fd_sc_hd__fill_8_1826
+ vss
+ vdd
+ vdd
+ sky130_fd_sc_hd__fill_8
* cell instance sky130_fd_sc_hd__fill_8_1827 r0 *1 0,0
Xsky130_fd_sc_hd__fill_8_1827
+ vss
+ vdd
+ vdd
+ sky130_fd_sc_hd__fill_8
* cell instance sky130_fd_sc_hd__fill_8_1828 r0 *1 0,0
Xsky130_fd_sc_hd__fill_8_1828
+ vss
+ vdd
+ vdd
+ sky130_fd_sc_hd__fill_8
* cell instance sky130_fd_sc_hd__fill_8_1829 r0 *1 0,0
Xsky130_fd_sc_hd__fill_8_1829
+ vss
+ vdd
+ vdd
+ sky130_fd_sc_hd__fill_8
* cell instance sky130_fd_sc_hd__fill_8_1830 r0 *1 0,0
Xsky130_fd_sc_hd__fill_8_1830
+ vss
+ vdd
+ vdd
+ sky130_fd_sc_hd__fill_8
* cell instance sky130_fd_sc_hd__fill_8_1831 r0 *1 0,0
Xsky130_fd_sc_hd__fill_8_1831
+ vss
+ vdd
+ vdd
+ sky130_fd_sc_hd__fill_8
* cell instance sky130_fd_sc_hd__fill_8_1832 r0 *1 0,0
Xsky130_fd_sc_hd__fill_8_1832
+ vss
+ vdd
+ vdd
+ sky130_fd_sc_hd__fill_8
* cell instance sky130_fd_sc_hd__fill_8_1833 r0 *1 0,0
Xsky130_fd_sc_hd__fill_8_1833
+ vss
+ vdd
+ vdd
+ sky130_fd_sc_hd__fill_8
* cell instance sky130_fd_sc_hd__fill_8_1834 r0 *1 0,0
Xsky130_fd_sc_hd__fill_8_1834
+ vss
+ vdd
+ vdd
+ sky130_fd_sc_hd__fill_8
* cell instance sky130_fd_sc_hd__fill_8_1835 r0 *1 0,0
Xsky130_fd_sc_hd__fill_8_1835
+ vss
+ vdd
+ vdd
+ sky130_fd_sc_hd__fill_8
* cell instance sky130_fd_sc_hd__fill_8_1836 r0 *1 0,0
Xsky130_fd_sc_hd__fill_8_1836
+ vss
+ vdd
+ vdd
+ sky130_fd_sc_hd__fill_8
* cell instance sky130_fd_sc_hd__fill_8_1837 r0 *1 0,0
Xsky130_fd_sc_hd__fill_8_1837
+ vss
+ vdd
+ vdd
+ sky130_fd_sc_hd__fill_8
* cell instance sky130_fd_sc_hd__fill_8_1838 r0 *1 0,0
Xsky130_fd_sc_hd__fill_8_1838
+ vss
+ vdd
+ vdd
+ sky130_fd_sc_hd__fill_8
* cell instance sky130_fd_sc_hd__fill_8_1839 r0 *1 0,0
Xsky130_fd_sc_hd__fill_8_1839
+ vss
+ vdd
+ vdd
+ sky130_fd_sc_hd__fill_8
* cell instance sky130_fd_sc_hd__fill_8_1840 r0 *1 0,0
Xsky130_fd_sc_hd__fill_8_1840
+ vss
+ vdd
+ vdd
+ sky130_fd_sc_hd__fill_8
* cell instance sky130_fd_sc_hd__fill_8_1841 r0 *1 0,0
Xsky130_fd_sc_hd__fill_8_1841
+ vss
+ vdd
+ vdd
+ sky130_fd_sc_hd__fill_8
* cell instance sky130_fd_sc_hd__fill_8_1842 r0 *1 0,0
Xsky130_fd_sc_hd__fill_8_1842
+ vss
+ vdd
+ vdd
+ sky130_fd_sc_hd__fill_8
* cell instance sky130_fd_sc_hd__fill_8_1843 r0 *1 0,0
Xsky130_fd_sc_hd__fill_8_1843
+ vss
+ vdd
+ vdd
+ sky130_fd_sc_hd__fill_8
* cell instance sky130_fd_sc_hd__fill_8_1844 r0 *1 0,0
Xsky130_fd_sc_hd__fill_8_1844
+ vss
+ vdd
+ vdd
+ sky130_fd_sc_hd__fill_8
* cell instance sky130_fd_sc_hd__fill_8_1845 r0 *1 0,0
Xsky130_fd_sc_hd__fill_8_1845
+ vss
+ vdd
+ vdd
+ sky130_fd_sc_hd__fill_8
* cell instance sky130_fd_sc_hd__fill_8_1846 r0 *1 0,0
Xsky130_fd_sc_hd__fill_8_1846
+ vss
+ vdd
+ vdd
+ sky130_fd_sc_hd__fill_8
* cell instance sky130_fd_sc_hd__fill_8_1847 r0 *1 0,0
Xsky130_fd_sc_hd__fill_8_1847
+ vss
+ vdd
+ vdd
+ sky130_fd_sc_hd__fill_8
* cell instance sky130_fd_sc_hd__fill_8_1848 r0 *1 0,0
Xsky130_fd_sc_hd__fill_8_1848
+ vss
+ vdd
+ vdd
+ sky130_fd_sc_hd__fill_8
* cell instance sky130_fd_sc_hd__fill_8_1849 r0 *1 0,0
Xsky130_fd_sc_hd__fill_8_1849
+ vss
+ vdd
+ vdd
+ sky130_fd_sc_hd__fill_8
* cell instance sky130_fd_sc_hd__fill_8_1850 r0 *1 0,0
Xsky130_fd_sc_hd__fill_8_1850
+ vss
+ vdd
+ vdd
+ sky130_fd_sc_hd__fill_8
* cell instance sky130_fd_sc_hd__fill_8_1851 r0 *1 0,0
Xsky130_fd_sc_hd__fill_8_1851
+ vss
+ vdd
+ vdd
+ sky130_fd_sc_hd__fill_8
* cell instance sky130_fd_sc_hd__fill_8_1852 r0 *1 0,0
Xsky130_fd_sc_hd__fill_8_1852
+ vss
+ vdd
+ vdd
+ sky130_fd_sc_hd__fill_8
* cell instance sky130_fd_sc_hd__fill_8_1853 r0 *1 0,0
Xsky130_fd_sc_hd__fill_8_1853
+ vss
+ vdd
+ vdd
+ sky130_fd_sc_hd__fill_8
* cell instance sky130_fd_sc_hd__fill_8_1854 r0 *1 0,0
Xsky130_fd_sc_hd__fill_8_1854
+ vss
+ vdd
+ vdd
+ sky130_fd_sc_hd__fill_8
* cell instance sky130_fd_sc_hd__fill_8_1855 r0 *1 0,0
Xsky130_fd_sc_hd__fill_8_1855
+ vss
+ vdd
+ vdd
+ sky130_fd_sc_hd__fill_8
* cell instance sky130_fd_sc_hd__fill_8_1856 r0 *1 0,0
Xsky130_fd_sc_hd__fill_8_1856
+ vss
+ vdd
+ vdd
+ sky130_fd_sc_hd__fill_8
* cell instance sky130_fd_sc_hd__fill_8_1857 r0 *1 0,0
Xsky130_fd_sc_hd__fill_8_1857
+ vss
+ vdd
+ vdd
+ sky130_fd_sc_hd__fill_8
* cell instance sky130_fd_sc_hd__fill_8_1858 r0 *1 0,0
Xsky130_fd_sc_hd__fill_8_1858
+ vss
+ vdd
+ vdd
+ sky130_fd_sc_hd__fill_8
* cell instance sky130_fd_sc_hd__fill_8_1859 r0 *1 0,0
Xsky130_fd_sc_hd__fill_8_1859
+ vss
+ vdd
+ vdd
+ sky130_fd_sc_hd__fill_8
* cell instance sky130_fd_sc_hd__fill_8_1860 r0 *1 0,0
Xsky130_fd_sc_hd__fill_8_1860
+ vss
+ vdd
+ vdd
+ sky130_fd_sc_hd__fill_8
* cell instance sky130_fd_sc_hd__fill_8_1861 r0 *1 0,0
Xsky130_fd_sc_hd__fill_8_1861
+ vss
+ vdd
+ vdd
+ sky130_fd_sc_hd__fill_8
* cell instance sky130_fd_sc_hd__fill_8_1862 r0 *1 0,0
Xsky130_fd_sc_hd__fill_8_1862
+ vss
+ vdd
+ vdd
+ sky130_fd_sc_hd__fill_8
* cell instance sky130_fd_sc_hd__fill_8_1863 r0 *1 0,0
Xsky130_fd_sc_hd__fill_8_1863
+ vss
+ vdd
+ vdd
+ sky130_fd_sc_hd__fill_8
* cell instance sky130_fd_sc_hd__fill_8_1864 r0 *1 0,0
Xsky130_fd_sc_hd__fill_8_1864
+ vss
+ vdd
+ vdd
+ sky130_fd_sc_hd__fill_8
* cell instance sky130_fd_sc_hd__fill_8_1865 r0 *1 0,0
Xsky130_fd_sc_hd__fill_8_1865
+ vss
+ vdd
+ vdd
+ sky130_fd_sc_hd__fill_8
* cell instance sky130_fd_sc_hd__fill_8_1866 r0 *1 0,0
Xsky130_fd_sc_hd__fill_8_1866
+ vss
+ vdd
+ vdd
+ sky130_fd_sc_hd__fill_8
* cell instance sky130_fd_sc_hd__fill_8_1867 r0 *1 0,0
Xsky130_fd_sc_hd__fill_8_1867
+ vss
+ vdd
+ vdd
+ sky130_fd_sc_hd__fill_8
* cell instance sky130_fd_sc_hd__fill_8_1868 r0 *1 0,0
Xsky130_fd_sc_hd__fill_8_1868
+ vss
+ vdd
+ vdd
+ sky130_fd_sc_hd__fill_8
* cell instance sky130_fd_sc_hd__fill_8_1869 r0 *1 0,0
Xsky130_fd_sc_hd__fill_8_1869
+ vss
+ vdd
+ vdd
+ sky130_fd_sc_hd__fill_8
* cell instance sky130_fd_sc_hd__fill_8_1870 r0 *1 0,0
Xsky130_fd_sc_hd__fill_8_1870
+ vss
+ vdd
+ vdd
+ sky130_fd_sc_hd__fill_8
* cell instance sky130_fd_sc_hd__fill_8_1871 r0 *1 0,0
Xsky130_fd_sc_hd__fill_8_1871
+ vss
+ vdd
+ vdd
+ sky130_fd_sc_hd__fill_8
* cell instance sky130_fd_sc_hd__fill_8_1872 r0 *1 0,0
Xsky130_fd_sc_hd__fill_8_1872
+ vss
+ vdd
+ vdd
+ sky130_fd_sc_hd__fill_8
* cell instance sky130_fd_sc_hd__fill_8_1873 r0 *1 0,0
Xsky130_fd_sc_hd__fill_8_1873
+ vss
+ vdd
+ vdd
+ sky130_fd_sc_hd__fill_8
* cell instance sky130_fd_sc_hd__fill_8_1874 r0 *1 0,0
Xsky130_fd_sc_hd__fill_8_1874
+ vss
+ vdd
+ vdd
+ sky130_fd_sc_hd__fill_8
* cell instance sky130_fd_sc_hd__fill_8_1875 r0 *1 0,0
Xsky130_fd_sc_hd__fill_8_1875
+ vss
+ vdd
+ vdd
+ sky130_fd_sc_hd__fill_8
* cell instance sky130_fd_sc_hd__fill_8_1876 r0 *1 0,0
Xsky130_fd_sc_hd__fill_8_1876
+ vss
+ vdd
+ vdd
+ sky130_fd_sc_hd__fill_8
* cell instance sky130_fd_sc_hd__fill_8_1877 r0 *1 0,0
Xsky130_fd_sc_hd__fill_8_1877
+ vss
+ vdd
+ vdd
+ sky130_fd_sc_hd__fill_8
* cell instance sky130_fd_sc_hd__fill_8_1878 r0 *1 0,0
Xsky130_fd_sc_hd__fill_8_1878
+ vss
+ vdd
+ vdd
+ sky130_fd_sc_hd__fill_8
* cell instance sky130_fd_sc_hd__fill_8_1879 r0 *1 0,0
Xsky130_fd_sc_hd__fill_8_1879
+ vss
+ vdd
+ vdd
+ sky130_fd_sc_hd__fill_8
* cell instance sky130_fd_sc_hd__fill_8_1880 r0 *1 0,0
Xsky130_fd_sc_hd__fill_8_1880
+ vss
+ vdd
+ vdd
+ sky130_fd_sc_hd__fill_8
* cell instance sky130_fd_sc_hd__fill_8_1881 r0 *1 0,0
Xsky130_fd_sc_hd__fill_8_1881
+ vss
+ vdd
+ vdd
+ sky130_fd_sc_hd__fill_8
* cell instance sky130_fd_sc_hd__fill_8_1882 r0 *1 0,0
Xsky130_fd_sc_hd__fill_8_1882
+ vss
+ vdd
+ vdd
+ sky130_fd_sc_hd__fill_8
* cell instance sky130_fd_sc_hd__fill_8_1883 r0 *1 0,0
Xsky130_fd_sc_hd__fill_8_1883
+ vss
+ vdd
+ vdd
+ sky130_fd_sc_hd__fill_8
* cell instance sky130_fd_sc_hd__fill_8_1884 r0 *1 0,0
Xsky130_fd_sc_hd__fill_8_1884
+ vss
+ vdd
+ vdd
+ sky130_fd_sc_hd__fill_8
* cell instance sky130_fd_sc_hd__fill_8_1885 r0 *1 0,0
Xsky130_fd_sc_hd__fill_8_1885
+ vss
+ vdd
+ vdd
+ sky130_fd_sc_hd__fill_8
* cell instance sky130_fd_sc_hd__fill_8_1886 r0 *1 0,0
Xsky130_fd_sc_hd__fill_8_1886
+ vss
+ vdd
+ vdd
+ sky130_fd_sc_hd__fill_8
* cell instance sky130_fd_sc_hd__fill_8_1887 r0 *1 0,0
Xsky130_fd_sc_hd__fill_8_1887
+ vss
+ vdd
+ vdd
+ sky130_fd_sc_hd__fill_8
* cell instance sky130_fd_sc_hd__fill_8_1888 r0 *1 0,0
Xsky130_fd_sc_hd__fill_8_1888
+ vss
+ vdd
+ vdd
+ sky130_fd_sc_hd__fill_8
* cell instance sky130_fd_sc_hd__fill_8_1889 r0 *1 0,0
Xsky130_fd_sc_hd__fill_8_1889
+ vss
+ vdd
+ vdd
+ sky130_fd_sc_hd__fill_8
* cell instance sky130_fd_sc_hd__fill_8_1890 r0 *1 0,0
Xsky130_fd_sc_hd__fill_8_1890
+ vss
+ vdd
+ vdd
+ sky130_fd_sc_hd__fill_8
* cell instance sky130_fd_sc_hd__fill_8_1891 r0 *1 0,0
Xsky130_fd_sc_hd__fill_8_1891
+ vss
+ vdd
+ vdd
+ sky130_fd_sc_hd__fill_8
* cell instance sky130_fd_sc_hd__fill_8_1892 r0 *1 0,0
Xsky130_fd_sc_hd__fill_8_1892
+ vss
+ vdd
+ vdd
+ sky130_fd_sc_hd__fill_8
* cell instance sky130_fd_sc_hd__fill_8_1893 r0 *1 0,0
Xsky130_fd_sc_hd__fill_8_1893
+ vss
+ vdd
+ vdd
+ sky130_fd_sc_hd__fill_8
* cell instance sky130_fd_sc_hd__fill_8_1894 r0 *1 0,0
Xsky130_fd_sc_hd__fill_8_1894
+ vss
+ vdd
+ vdd
+ sky130_fd_sc_hd__fill_8
* cell instance sky130_fd_sc_hd__fill_8_1895 r0 *1 0,0
Xsky130_fd_sc_hd__fill_8_1895
+ vss
+ vdd
+ vdd
+ sky130_fd_sc_hd__fill_8
* cell instance sky130_fd_sc_hd__fill_8_1896 r0 *1 0,0
Xsky130_fd_sc_hd__fill_8_1896
+ vss
+ vdd
+ vdd
+ sky130_fd_sc_hd__fill_8
* cell instance sky130_fd_sc_hd__fill_8_1897 r0 *1 0,0
Xsky130_fd_sc_hd__fill_8_1897
+ vss
+ vdd
+ vdd
+ sky130_fd_sc_hd__fill_8
* cell instance sky130_fd_sc_hd__fill_8_1898 r0 *1 0,0
Xsky130_fd_sc_hd__fill_8_1898
+ vss
+ vdd
+ vdd
+ sky130_fd_sc_hd__fill_8
* cell instance sky130_fd_sc_hd__fill_8_1899 r0 *1 0,0
Xsky130_fd_sc_hd__fill_8_1899
+ vss
+ vdd
+ vdd
+ sky130_fd_sc_hd__fill_8
* cell instance sky130_fd_sc_hd__fill_8_1900 r0 *1 0,0
Xsky130_fd_sc_hd__fill_8_1900
+ vss
+ vdd
+ vdd
+ sky130_fd_sc_hd__fill_8
* cell instance sky130_fd_sc_hd__fill_8_1901 r0 *1 0,0
Xsky130_fd_sc_hd__fill_8_1901
+ vss
+ vdd
+ vdd
+ sky130_fd_sc_hd__fill_8
* cell instance sky130_fd_sc_hd__fill_8_1902 r0 *1 0,0
Xsky130_fd_sc_hd__fill_8_1902
+ vss
+ vdd
+ vdd
+ sky130_fd_sc_hd__fill_8
* cell instance sky130_fd_sc_hd__fill_8_1903 r0 *1 0,0
Xsky130_fd_sc_hd__fill_8_1903
+ vss
+ vdd
+ vdd
+ sky130_fd_sc_hd__fill_8
* cell instance sky130_fd_sc_hd__fill_8_1904 r0 *1 0,0
Xsky130_fd_sc_hd__fill_8_1904
+ vss
+ vdd
+ vdd
+ sky130_fd_sc_hd__fill_8
* cell instance sky130_fd_sc_hd__fill_8_1905 r0 *1 0,0
Xsky130_fd_sc_hd__fill_8_1905
+ vss
+ vdd
+ vdd
+ sky130_fd_sc_hd__fill_8
* cell instance sky130_fd_sc_hd__fill_8_1906 r0 *1 0,0
Xsky130_fd_sc_hd__fill_8_1906
+ vss
+ vdd
+ vdd
+ sky130_fd_sc_hd__fill_8
* cell instance sky130_fd_sc_hd__fill_8_1907 r0 *1 0,0
Xsky130_fd_sc_hd__fill_8_1907
+ vss
+ vdd
+ vdd
+ sky130_fd_sc_hd__fill_8
* cell instance sky130_fd_sc_hd__fill_8_1908 r0 *1 0,0
Xsky130_fd_sc_hd__fill_8_1908
+ vss
+ vdd
+ vdd
+ sky130_fd_sc_hd__fill_8
* cell instance sky130_fd_sc_hd__fill_8_1909 r0 *1 0,0
Xsky130_fd_sc_hd__fill_8_1909
+ vss
+ vdd
+ vdd
+ sky130_fd_sc_hd__fill_8
* cell instance sky130_fd_sc_hd__fill_8_1910 r0 *1 0,0
Xsky130_fd_sc_hd__fill_8_1910
+ vss
+ vdd
+ vdd
+ sky130_fd_sc_hd__fill_8
* cell instance sky130_fd_sc_hd__fill_8_1911 r0 *1 0,0
Xsky130_fd_sc_hd__fill_8_1911
+ vss
+ vdd
+ vdd
+ sky130_fd_sc_hd__fill_8
* cell instance sky130_fd_sc_hd__fill_8_1912 r0 *1 0,0
Xsky130_fd_sc_hd__fill_8_1912
+ vss
+ vdd
+ vdd
+ sky130_fd_sc_hd__fill_8
* cell instance sky130_fd_sc_hd__fill_8_1913 r0 *1 0,0
Xsky130_fd_sc_hd__fill_8_1913
+ vss
+ vdd
+ vdd
+ sky130_fd_sc_hd__fill_8
* cell instance sky130_fd_sc_hd__fill_8_1914 r0 *1 0,0
Xsky130_fd_sc_hd__fill_8_1914
+ vss
+ vdd
+ vdd
+ sky130_fd_sc_hd__fill_8
* cell instance sky130_fd_sc_hd__fill_8_1915 r0 *1 0,0
Xsky130_fd_sc_hd__fill_8_1915
+ vss
+ vdd
+ vdd
+ sky130_fd_sc_hd__fill_8
* cell instance sky130_fd_sc_hd__fill_8_1916 r0 *1 0,0
Xsky130_fd_sc_hd__fill_8_1916
+ vss
+ vdd
+ vdd
+ sky130_fd_sc_hd__fill_8
* cell instance sky130_fd_sc_hd__fill_8_1917 r0 *1 0,0
Xsky130_fd_sc_hd__fill_8_1917
+ vss
+ vdd
+ vdd
+ sky130_fd_sc_hd__fill_8
* cell instance sky130_fd_sc_hd__fill_8_1918 r0 *1 0,0
Xsky130_fd_sc_hd__fill_8_1918
+ vss
+ vdd
+ vdd
+ sky130_fd_sc_hd__fill_8
* cell instance sky130_fd_sc_hd__fill_8_1919 r0 *1 0,0
Xsky130_fd_sc_hd__fill_8_1919
+ vss
+ vdd
+ vdd
+ sky130_fd_sc_hd__fill_8
* cell instance sky130_fd_sc_hd__fill_8_1920 r0 *1 0,0
Xsky130_fd_sc_hd__fill_8_1920
+ vss
+ vdd
+ vdd
+ sky130_fd_sc_hd__fill_8
* cell instance sky130_fd_sc_hd__fill_8_1921 r0 *1 0,0
Xsky130_fd_sc_hd__fill_8_1921
+ vss
+ vdd
+ vdd
+ sky130_fd_sc_hd__fill_8
* cell instance sky130_fd_sc_hd__fill_8_1922 r0 *1 0,0
Xsky130_fd_sc_hd__fill_8_1922
+ vss
+ vdd
+ vdd
+ sky130_fd_sc_hd__fill_8
* cell instance sky130_fd_sc_hd__fill_8_1923 r0 *1 0,0
Xsky130_fd_sc_hd__fill_8_1923
+ vss
+ vdd
+ vdd
+ sky130_fd_sc_hd__fill_8
* cell instance sky130_fd_sc_hd__fill_8_1924 r0 *1 0,0
Xsky130_fd_sc_hd__fill_8_1924
+ vss
+ vdd
+ vdd
+ sky130_fd_sc_hd__fill_8
* cell instance sky130_fd_sc_hd__fill_8_1925 r0 *1 0,0
Xsky130_fd_sc_hd__fill_8_1925
+ vss
+ vdd
+ vdd
+ sky130_fd_sc_hd__fill_8
* cell instance sky130_fd_sc_hd__fill_8_1926 r0 *1 0,0
Xsky130_fd_sc_hd__fill_8_1926
+ vss
+ vdd
+ vdd
+ sky130_fd_sc_hd__fill_8
* cell instance sky130_fd_sc_hd__fill_8_1927 r0 *1 0,0
Xsky130_fd_sc_hd__fill_8_1927
+ vss
+ vdd
+ vdd
+ sky130_fd_sc_hd__fill_8
* cell instance sky130_fd_sc_hd__fill_8_1928 r0 *1 0,0
Xsky130_fd_sc_hd__fill_8_1928
+ vss
+ vdd
+ vdd
+ sky130_fd_sc_hd__fill_8
* cell instance sky130_fd_sc_hd__fill_8_1929 r0 *1 0,0
Xsky130_fd_sc_hd__fill_8_1929
+ vss
+ vdd
+ vdd
+ sky130_fd_sc_hd__fill_8
* cell instance sky130_fd_sc_hd__fill_8_1930 r0 *1 0,0
Xsky130_fd_sc_hd__fill_8_1930
+ vss
+ vdd
+ vdd
+ sky130_fd_sc_hd__fill_8
* cell instance sky130_fd_sc_hd__fill_8_1931 r0 *1 0,0
Xsky130_fd_sc_hd__fill_8_1931
+ vss
+ vdd
+ vdd
+ sky130_fd_sc_hd__fill_8
* cell instance sky130_fd_sc_hd__fill_8_1932 r0 *1 0,0
Xsky130_fd_sc_hd__fill_8_1932
+ vss
+ vdd
+ vdd
+ sky130_fd_sc_hd__fill_8
* cell instance sky130_fd_sc_hd__fill_8_1933 r0 *1 0,0
Xsky130_fd_sc_hd__fill_8_1933
+ vss
+ vdd
+ vdd
+ sky130_fd_sc_hd__fill_8
* cell instance sky130_fd_sc_hd__fill_8_1934 r0 *1 0,0
Xsky130_fd_sc_hd__fill_8_1934
+ vss
+ vdd
+ vdd
+ sky130_fd_sc_hd__fill_8
* cell instance sky130_fd_sc_hd__fill_8_1935 r0 *1 0,0
Xsky130_fd_sc_hd__fill_8_1935
+ vss
+ vdd
+ vdd
+ sky130_fd_sc_hd__fill_8
* cell instance sky130_fd_sc_hd__fill_8_1936 r0 *1 0,0
Xsky130_fd_sc_hd__fill_8_1936
+ vss
+ vdd
+ vdd
+ sky130_fd_sc_hd__fill_8
* cell instance sky130_fd_sc_hd__fill_8_1937 r0 *1 0,0
Xsky130_fd_sc_hd__fill_8_1937
+ vss
+ vdd
+ vdd
+ sky130_fd_sc_hd__fill_8
* cell instance sky130_fd_sc_hd__fill_8_1938 r0 *1 0,0
Xsky130_fd_sc_hd__fill_8_1938
+ vss
+ vdd
+ vdd
+ sky130_fd_sc_hd__fill_8
* cell instance sky130_fd_sc_hd__fill_8_1939 r0 *1 0,0
Xsky130_fd_sc_hd__fill_8_1939
+ vss
+ vdd
+ vdd
+ sky130_fd_sc_hd__fill_8
* cell instance sky130_fd_sc_hd__fill_8_1940 r0 *1 0,0
Xsky130_fd_sc_hd__fill_8_1940
+ vss
+ vdd
+ vdd
+ sky130_fd_sc_hd__fill_8
* cell instance sky130_fd_sc_hd__fill_8_1941 r0 *1 0,0
Xsky130_fd_sc_hd__fill_8_1941
+ vss
+ vdd
+ vdd
+ sky130_fd_sc_hd__fill_8
* cell instance sky130_fd_sc_hd__fill_8_1942 r0 *1 0,0
Xsky130_fd_sc_hd__fill_8_1942
+ vss
+ vdd
+ vdd
+ sky130_fd_sc_hd__fill_8
* cell instance sky130_fd_sc_hd__fill_8_1943 r0 *1 0,0
Xsky130_fd_sc_hd__fill_8_1943
+ vss
+ vdd
+ vdd
+ sky130_fd_sc_hd__fill_8
* cell instance sky130_fd_sc_hd__fill_8_1944 r0 *1 0,0
Xsky130_fd_sc_hd__fill_8_1944
+ vss
+ vdd
+ vdd
+ sky130_fd_sc_hd__fill_8
* cell instance sky130_fd_sc_hd__fill_8_1945 r0 *1 0,0
Xsky130_fd_sc_hd__fill_8_1945
+ vss
+ vdd
+ vdd
+ sky130_fd_sc_hd__fill_8
* cell instance sky130_fd_sc_hd__fill_8_1946 r0 *1 0,0
Xsky130_fd_sc_hd__fill_8_1946
+ vss
+ vdd
+ vdd
+ sky130_fd_sc_hd__fill_8
* cell instance sky130_fd_sc_hd__fill_8_1947 r0 *1 0,0
Xsky130_fd_sc_hd__fill_8_1947
+ vss
+ vdd
+ vdd
+ sky130_fd_sc_hd__fill_8
* cell instance sky130_fd_sc_hd__fill_8_1948 r0 *1 0,0
Xsky130_fd_sc_hd__fill_8_1948
+ vss
+ vdd
+ vdd
+ sky130_fd_sc_hd__fill_8
* cell instance sky130_fd_sc_hd__fill_8_1949 r0 *1 0,0
Xsky130_fd_sc_hd__fill_8_1949
+ vss
+ vdd
+ vdd
+ sky130_fd_sc_hd__fill_8
* cell instance sky130_fd_sc_hd__fill_8_1950 r0 *1 0,0
Xsky130_fd_sc_hd__fill_8_1950
+ vss
+ vdd
+ vdd
+ sky130_fd_sc_hd__fill_8
* cell instance sky130_fd_sc_hd__fill_8_1951 r0 *1 0,0
Xsky130_fd_sc_hd__fill_8_1951
+ vss
+ vdd
+ vdd
+ sky130_fd_sc_hd__fill_8
* cell instance sky130_fd_sc_hd__fill_8_1952 r0 *1 0,0
Xsky130_fd_sc_hd__fill_8_1952
+ vss
+ vdd
+ vdd
+ sky130_fd_sc_hd__fill_8
* cell instance sky130_fd_sc_hd__fill_8_1953 r0 *1 0,0
Xsky130_fd_sc_hd__fill_8_1953
+ vss
+ vdd
+ vdd
+ sky130_fd_sc_hd__fill_8
* cell instance sky130_fd_sc_hd__fill_8_1954 r0 *1 0,0
Xsky130_fd_sc_hd__fill_8_1954
+ vss
+ vdd
+ vdd
+ sky130_fd_sc_hd__fill_8
* cell instance sky130_fd_sc_hd__fill_8_1955 r0 *1 0,0
Xsky130_fd_sc_hd__fill_8_1955
+ vss
+ vdd
+ vdd
+ sky130_fd_sc_hd__fill_8
* cell instance sky130_fd_sc_hd__fill_8_1956 r0 *1 0,0
Xsky130_fd_sc_hd__fill_8_1956
+ vss
+ vdd
+ vdd
+ sky130_fd_sc_hd__fill_8
* cell instance sky130_fd_sc_hd__fill_8_1957 r0 *1 0,0
Xsky130_fd_sc_hd__fill_8_1957
+ vss
+ vdd
+ vdd
+ sky130_fd_sc_hd__fill_8
* cell instance sky130_fd_sc_hd__fill_8_1958 r0 *1 0,0
Xsky130_fd_sc_hd__fill_8_1958
+ vss
+ vdd
+ vdd
+ sky130_fd_sc_hd__fill_8
* cell instance sky130_fd_sc_hd__fill_8_1959 r0 *1 0,0
Xsky130_fd_sc_hd__fill_8_1959
+ vss
+ vdd
+ vdd
+ sky130_fd_sc_hd__fill_8
* cell instance sky130_fd_sc_hd__fill_8_1960 r0 *1 0,0
Xsky130_fd_sc_hd__fill_8_1960
+ vss
+ vdd
+ vdd
+ sky130_fd_sc_hd__fill_8
* cell instance sky130_fd_sc_hd__fill_8_1961 r0 *1 0,0
Xsky130_fd_sc_hd__fill_8_1961
+ vss
+ vdd
+ vdd
+ sky130_fd_sc_hd__fill_8
* cell instance sky130_fd_sc_hd__fill_8_1962 r0 *1 0,0
Xsky130_fd_sc_hd__fill_8_1962
+ vss
+ vdd
+ vdd
+ sky130_fd_sc_hd__fill_8
* cell instance sky130_fd_sc_hd__fill_8_1963 r0 *1 0,0
Xsky130_fd_sc_hd__fill_8_1963
+ vss
+ vdd
+ vdd
+ sky130_fd_sc_hd__fill_8
* cell instance sky130_fd_sc_hd__fill_8_1964 r0 *1 0,0
Xsky130_fd_sc_hd__fill_8_1964
+ vss
+ vdd
+ vdd
+ sky130_fd_sc_hd__fill_8
* cell instance sky130_fd_sc_hd__fill_8_1965 r0 *1 0,0
Xsky130_fd_sc_hd__fill_8_1965
+ vss
+ vdd
+ vdd
+ sky130_fd_sc_hd__fill_8
* cell instance sky130_fd_sc_hd__fill_8_1966 r0 *1 0,0
Xsky130_fd_sc_hd__fill_8_1966
+ vss
+ vdd
+ vdd
+ sky130_fd_sc_hd__fill_8
* cell instance sky130_fd_sc_hd__fill_8_1967 r0 *1 0,0
Xsky130_fd_sc_hd__fill_8_1967
+ vss
+ vdd
+ vdd
+ sky130_fd_sc_hd__fill_8
* cell instance sky130_fd_sc_hd__fill_8_1968 r0 *1 0,0
Xsky130_fd_sc_hd__fill_8_1968
+ vss
+ vdd
+ vdd
+ sky130_fd_sc_hd__fill_8
* cell instance sky130_fd_sc_hd__fill_8_1969 r0 *1 0,0
Xsky130_fd_sc_hd__fill_8_1969
+ vss
+ vdd
+ vdd
+ sky130_fd_sc_hd__fill_8
* cell instance sky130_fd_sc_hd__fill_8_1970 r0 *1 0,0
Xsky130_fd_sc_hd__fill_8_1970
+ vss
+ vdd
+ vdd
+ sky130_fd_sc_hd__fill_8
* cell instance sky130_fd_sc_hd__fill_8_1971 r0 *1 0,0
Xsky130_fd_sc_hd__fill_8_1971
+ vss
+ vdd
+ vdd
+ sky130_fd_sc_hd__fill_8
* cell instance sky130_fd_sc_hd__fill_8_1972 r0 *1 0,0
Xsky130_fd_sc_hd__fill_8_1972
+ vss
+ vdd
+ vdd
+ sky130_fd_sc_hd__fill_8
* cell instance sky130_fd_sc_hd__fill_8_1973 r0 *1 0,0
Xsky130_fd_sc_hd__fill_8_1973
+ vss
+ vdd
+ vdd
+ sky130_fd_sc_hd__fill_8
* cell instance sky130_fd_sc_hd__fill_8_1974 r0 *1 0,0
Xsky130_fd_sc_hd__fill_8_1974
+ vss
+ vdd
+ vdd
+ sky130_fd_sc_hd__fill_8
* cell instance sky130_fd_sc_hd__fill_8_1975 r0 *1 0,0
Xsky130_fd_sc_hd__fill_8_1975
+ vss
+ vdd
+ vdd
+ sky130_fd_sc_hd__fill_8
* cell instance sky130_fd_sc_hd__fill_8_1976 r0 *1 0,0
Xsky130_fd_sc_hd__fill_8_1976
+ vss
+ vdd
+ vdd
+ sky130_fd_sc_hd__fill_8
* cell instance sky130_fd_sc_hd__fill_8_1977 r0 *1 0,0
Xsky130_fd_sc_hd__fill_8_1977
+ vss
+ vdd
+ vdd
+ sky130_fd_sc_hd__fill_8
* cell instance sky130_fd_sc_hd__fill_8_1978 r0 *1 0,0
Xsky130_fd_sc_hd__fill_8_1978
+ vss
+ vdd
+ vdd
+ sky130_fd_sc_hd__fill_8
* cell instance sky130_fd_sc_hd__fill_8_1979 r0 *1 0,0
Xsky130_fd_sc_hd__fill_8_1979
+ vss
+ vdd
+ vdd
+ sky130_fd_sc_hd__fill_8
* cell instance sky130_fd_sc_hd__fill_8_1980 r0 *1 0,0
Xsky130_fd_sc_hd__fill_8_1980
+ vss
+ vdd
+ vdd
+ sky130_fd_sc_hd__fill_8
* cell instance sky130_fd_sc_hd__fill_8_1981 r0 *1 0,0
Xsky130_fd_sc_hd__fill_8_1981
+ vss
+ vdd
+ vdd
+ sky130_fd_sc_hd__fill_8
* cell instance sky130_fd_sc_hd__fill_8_1982 r0 *1 0,0
Xsky130_fd_sc_hd__fill_8_1982
+ vss
+ vdd
+ vdd
+ sky130_fd_sc_hd__fill_8
* cell instance sky130_fd_sc_hd__fill_8_1983 r0 *1 0,0
Xsky130_fd_sc_hd__fill_8_1983
+ vss
+ vdd
+ vdd
+ sky130_fd_sc_hd__fill_8
* cell instance sky130_fd_sc_hd__fill_8_1984 r0 *1 0,0
Xsky130_fd_sc_hd__fill_8_1984
+ vss
+ vdd
+ vdd
+ sky130_fd_sc_hd__fill_8
* cell instance sky130_fd_sc_hd__fill_8_1985 r0 *1 0,0
Xsky130_fd_sc_hd__fill_8_1985
+ vss
+ vdd
+ vdd
+ sky130_fd_sc_hd__fill_8
* cell instance sky130_fd_sc_hd__fill_8_1986 r0 *1 0,0
Xsky130_fd_sc_hd__fill_8_1986
+ vss
+ vdd
+ vdd
+ sky130_fd_sc_hd__fill_8
* cell instance sky130_fd_sc_hd__fill_8_1987 r0 *1 0,0
Xsky130_fd_sc_hd__fill_8_1987
+ vss
+ vdd
+ vdd
+ sky130_fd_sc_hd__fill_8
* cell instance sky130_fd_sc_hd__fill_8_1988 r0 *1 0,0
Xsky130_fd_sc_hd__fill_8_1988
+ vss
+ vdd
+ vdd
+ sky130_fd_sc_hd__fill_8
* cell instance sky130_fd_sc_hd__fill_8_1989 r0 *1 0,0
Xsky130_fd_sc_hd__fill_8_1989
+ vss
+ vdd
+ vdd
+ sky130_fd_sc_hd__fill_8
* cell instance sky130_fd_sc_hd__fill_8_1990 r0 *1 0,0
Xsky130_fd_sc_hd__fill_8_1990
+ vss
+ vdd
+ vdd
+ sky130_fd_sc_hd__fill_8
* cell instance sky130_fd_sc_hd__fill_8_1991 r0 *1 0,0
Xsky130_fd_sc_hd__fill_8_1991
+ vss
+ vdd
+ vdd
+ sky130_fd_sc_hd__fill_8
* cell instance sky130_fd_sc_hd__fill_8_1992 r0 *1 0,0
Xsky130_fd_sc_hd__fill_8_1992
+ vss
+ vdd
+ vdd
+ sky130_fd_sc_hd__fill_8
* cell instance sky130_fd_sc_hd__fill_8_1993 r0 *1 0,0
Xsky130_fd_sc_hd__fill_8_1993
+ vss
+ vdd
+ vdd
+ sky130_fd_sc_hd__fill_8
* cell instance sky130_fd_sc_hd__fill_8_1994 r0 *1 0,0
Xsky130_fd_sc_hd__fill_8_1994
+ vss
+ vdd
+ vdd
+ sky130_fd_sc_hd__fill_8
* cell instance sky130_fd_sc_hd__fill_8_1995 r0 *1 0,0
Xsky130_fd_sc_hd__fill_8_1995
+ vss
+ vdd
+ vdd
+ sky130_fd_sc_hd__fill_8
* cell instance sky130_fd_sc_hd__fill_8_1996 r0 *1 0,0
Xsky130_fd_sc_hd__fill_8_1996
+ vss
+ vdd
+ vdd
+ sky130_fd_sc_hd__fill_8
* cell instance sky130_fd_sc_hd__fill_8_1997 r0 *1 0,0
Xsky130_fd_sc_hd__fill_8_1997
+ vss
+ vdd
+ vdd
+ sky130_fd_sc_hd__fill_8
* cell instance sky130_fd_sc_hd__fill_8_1998 r0 *1 0,0
Xsky130_fd_sc_hd__fill_8_1998
+ vss
+ vdd
+ vdd
+ sky130_fd_sc_hd__fill_8
* cell instance sky130_fd_sc_hd__fill_8_1999 r0 *1 0,0
Xsky130_fd_sc_hd__fill_8_1999
+ vss
+ vdd
+ vdd
+ sky130_fd_sc_hd__fill_8
* cell instance sky130_fd_sc_hd__fill_8_2000 r0 *1 0,0
Xsky130_fd_sc_hd__fill_8_2000
+ vss
+ vdd
+ vdd
+ sky130_fd_sc_hd__fill_8
* cell instance sky130_fd_sc_hd__fill_8_2001 r0 *1 0,0
Xsky130_fd_sc_hd__fill_8_2001
+ vss
+ vdd
+ vdd
+ sky130_fd_sc_hd__fill_8
* cell instance sky130_fd_sc_hd__fill_8_2002 r0 *1 0,0
Xsky130_fd_sc_hd__fill_8_2002
+ vss
+ vdd
+ vdd
+ sky130_fd_sc_hd__fill_8
* cell instance sky130_fd_sc_hd__fill_8_2003 r0 *1 0,0
Xsky130_fd_sc_hd__fill_8_2003
+ vss
+ vdd
+ vdd
+ sky130_fd_sc_hd__fill_8
* cell instance sky130_fd_sc_hd__fill_8_2004 r0 *1 0,0
Xsky130_fd_sc_hd__fill_8_2004
+ vss
+ vdd
+ vdd
+ sky130_fd_sc_hd__fill_8
* cell instance sky130_fd_sc_hd__fill_8_2005 r0 *1 0,0
Xsky130_fd_sc_hd__fill_8_2005
+ vss
+ vdd
+ vdd
+ sky130_fd_sc_hd__fill_8
* cell instance sky130_fd_sc_hd__fill_8_2006 r0 *1 0,0
Xsky130_fd_sc_hd__fill_8_2006
+ vss
+ vdd
+ vdd
+ sky130_fd_sc_hd__fill_8
* cell instance sky130_fd_sc_hd__fill_8_2007 r0 *1 0,0
Xsky130_fd_sc_hd__fill_8_2007
+ vss
+ vdd
+ vdd
+ sky130_fd_sc_hd__fill_8
* cell instance sky130_fd_sc_hd__fill_8_2008 r0 *1 0,0
Xsky130_fd_sc_hd__fill_8_2008
+ vss
+ vdd
+ vdd
+ sky130_fd_sc_hd__fill_8
* cell instance sky130_fd_sc_hd__fill_8_2009 r0 *1 0,0
Xsky130_fd_sc_hd__fill_8_2009
+ vss
+ vdd
+ vdd
+ sky130_fd_sc_hd__fill_8
* cell instance sky130_fd_sc_hd__fill_8_2010 r0 *1 0,0
Xsky130_fd_sc_hd__fill_8_2010
+ vss
+ vdd
+ vdd
+ sky130_fd_sc_hd__fill_8
* cell instance sky130_fd_sc_hd__fill_8_2011 r0 *1 0,0
Xsky130_fd_sc_hd__fill_8_2011
+ vss
+ vdd
+ vdd
+ sky130_fd_sc_hd__fill_8
* cell instance sky130_fd_sc_hd__fill_8_2012 r0 *1 0,0
Xsky130_fd_sc_hd__fill_8_2012
+ vss
+ vdd
+ vdd
+ sky130_fd_sc_hd__fill_8
* cell instance sky130_fd_sc_hd__fill_8_2013 r0 *1 0,0
Xsky130_fd_sc_hd__fill_8_2013
+ vss
+ vdd
+ vdd
+ sky130_fd_sc_hd__fill_8
* cell instance sky130_fd_sc_hd__fill_8_2014 r0 *1 0,0
Xsky130_fd_sc_hd__fill_8_2014
+ vss
+ vdd
+ vdd
+ sky130_fd_sc_hd__fill_8
* cell instance sky130_fd_sc_hd__fill_8_2015 r0 *1 0,0
Xsky130_fd_sc_hd__fill_8_2015
+ vss
+ vdd
+ vdd
+ sky130_fd_sc_hd__fill_8
* cell instance sky130_fd_sc_hd__fill_8_2016 r0 *1 0,0
Xsky130_fd_sc_hd__fill_8_2016
+ vss
+ vdd
+ vdd
+ sky130_fd_sc_hd__fill_8
* cell instance sky130_fd_sc_hd__fill_8_2017 r0 *1 0,0
Xsky130_fd_sc_hd__fill_8_2017
+ vss
+ vdd
+ vdd
+ sky130_fd_sc_hd__fill_8
* cell instance sky130_fd_sc_hd__fill_8_2018 r0 *1 0,0
Xsky130_fd_sc_hd__fill_8_2018
+ vss
+ vdd
+ vdd
+ sky130_fd_sc_hd__fill_8
* cell instance sky130_fd_sc_hd__fill_8_2019 r0 *1 0,0
Xsky130_fd_sc_hd__fill_8_2019
+ vss
+ vdd
+ vdd
+ sky130_fd_sc_hd__fill_8
* cell instance sky130_fd_sc_hd__fill_8_2020 r0 *1 0,0
Xsky130_fd_sc_hd__fill_8_2020
+ vss
+ vdd
+ vdd
+ sky130_fd_sc_hd__fill_8
* cell instance sky130_fd_sc_hd__fill_8_2021 r0 *1 0,0
Xsky130_fd_sc_hd__fill_8_2021
+ vss
+ vdd
+ vdd
+ sky130_fd_sc_hd__fill_8
* cell instance sky130_fd_sc_hd__fill_8_2022 r0 *1 0,0
Xsky130_fd_sc_hd__fill_8_2022
+ vss
+ vdd
+ vdd
+ sky130_fd_sc_hd__fill_8
* cell instance sky130_fd_sc_hd__fill_8_2023 r0 *1 0,0
Xsky130_fd_sc_hd__fill_8_2023
+ vss
+ vdd
+ vdd
+ sky130_fd_sc_hd__fill_8
* cell instance sky130_fd_sc_hd__fill_8_2024 r0 *1 0,0
Xsky130_fd_sc_hd__fill_8_2024
+ vss
+ vdd
+ vdd
+ sky130_fd_sc_hd__fill_8
* cell instance sky130_fd_sc_hd__fill_8_2025 r0 *1 0,0
Xsky130_fd_sc_hd__fill_8_2025
+ vss
+ vdd
+ vdd
+ sky130_fd_sc_hd__fill_8
* cell instance sky130_fd_sc_hd__fill_8_2026 r0 *1 0,0
Xsky130_fd_sc_hd__fill_8_2026
+ vss
+ vdd
+ vdd
+ sky130_fd_sc_hd__fill_8
* cell instance sky130_fd_sc_hd__fill_8_2027 r0 *1 0,0
Xsky130_fd_sc_hd__fill_8_2027
+ vss
+ vdd
+ vdd
+ sky130_fd_sc_hd__fill_8
* cell instance sky130_fd_sc_hd__fill_8_2028 r0 *1 0,0
Xsky130_fd_sc_hd__fill_8_2028
+ vss
+ vdd
+ vdd
+ sky130_fd_sc_hd__fill_8
* cell instance sky130_fd_sc_hd__fill_8_2029 r0 *1 0,0
Xsky130_fd_sc_hd__fill_8_2029
+ vss
+ vdd
+ vdd
+ sky130_fd_sc_hd__fill_8
* cell instance sky130_fd_sc_hd__fill_8_2030 r0 *1 0,0
Xsky130_fd_sc_hd__fill_8_2030
+ vss
+ vdd
+ vdd
+ sky130_fd_sc_hd__fill_8
* cell instance sky130_fd_sc_hd__fill_8_2031 r0 *1 0,0
Xsky130_fd_sc_hd__fill_8_2031
+ vss
+ vdd
+ vdd
+ sky130_fd_sc_hd__fill_8
* cell instance sky130_fd_sc_hd__fill_8_2032 r0 *1 0,0
Xsky130_fd_sc_hd__fill_8_2032
+ vss
+ vdd
+ vdd
+ sky130_fd_sc_hd__fill_8
* cell instance sky130_fd_sc_hd__fill_8_2033 r0 *1 0,0
Xsky130_fd_sc_hd__fill_8_2033
+ vss
+ vdd
+ vdd
+ sky130_fd_sc_hd__fill_8
* cell instance sky130_fd_sc_hd__fill_8_2034 r0 *1 0,0
Xsky130_fd_sc_hd__fill_8_2034
+ vss
+ vdd
+ vdd
+ sky130_fd_sc_hd__fill_8
* cell instance sky130_fd_sc_hd__fill_8_2035 r0 *1 0,0
Xsky130_fd_sc_hd__fill_8_2035
+ vss
+ vdd
+ vdd
+ sky130_fd_sc_hd__fill_8
* cell instance sky130_fd_sc_hd__fill_8_2036 r0 *1 0,0
Xsky130_fd_sc_hd__fill_8_2036
+ vss
+ vdd
+ vdd
+ sky130_fd_sc_hd__fill_8
* cell instance sky130_fd_sc_hd__fill_8_2037 r0 *1 0,0
Xsky130_fd_sc_hd__fill_8_2037
+ vss
+ vdd
+ vdd
+ sky130_fd_sc_hd__fill_8
* cell instance sky130_fd_sc_hd__fill_8_2038 r0 *1 0,0
Xsky130_fd_sc_hd__fill_8_2038
+ vss
+ vdd
+ vdd
+ sky130_fd_sc_hd__fill_8
* cell instance sky130_fd_sc_hd__fill_8_2039 r0 *1 0,0
Xsky130_fd_sc_hd__fill_8_2039
+ vss
+ vdd
+ vdd
+ sky130_fd_sc_hd__fill_8
* cell instance sky130_fd_sc_hd__fill_8_2040 r0 *1 0,0
Xsky130_fd_sc_hd__fill_8_2040
+ vss
+ vdd
+ vdd
+ sky130_fd_sc_hd__fill_8
* cell instance sky130_fd_sc_hd__fill_8_2041 r0 *1 0,0
Xsky130_fd_sc_hd__fill_8_2041
+ vss
+ vdd
+ vdd
+ sky130_fd_sc_hd__fill_8
* cell instance sky130_fd_sc_hd__fill_8_2042 r0 *1 0,0
Xsky130_fd_sc_hd__fill_8_2042
+ vss
+ vdd
+ vdd
+ sky130_fd_sc_hd__fill_8
* cell instance sky130_fd_sc_hd__fill_8_2043 r0 *1 0,0
Xsky130_fd_sc_hd__fill_8_2043
+ vss
+ vdd
+ vdd
+ sky130_fd_sc_hd__fill_8
* cell instance sky130_fd_sc_hd__fill_8_2044 r0 *1 0,0
Xsky130_fd_sc_hd__fill_8_2044
+ vss
+ vdd
+ vdd
+ sky130_fd_sc_hd__fill_8
* cell instance sky130_fd_sc_hd__fill_8_2045 r0 *1 0,0
Xsky130_fd_sc_hd__fill_8_2045
+ vss
+ vdd
+ vdd
+ sky130_fd_sc_hd__fill_8
* cell instance sky130_fd_sc_hd__fill_8_2046 r0 *1 0,0
Xsky130_fd_sc_hd__fill_8_2046
+ vss
+ vdd
+ vdd
+ sky130_fd_sc_hd__fill_8
* cell instance sky130_fd_sc_hd__fill_8_2047 r0 *1 0,0
Xsky130_fd_sc_hd__fill_8_2047
+ vss
+ vdd
+ vdd
+ sky130_fd_sc_hd__fill_8
* cell instance sky130_fd_sc_hd__fill_8_2048 r0 *1 0,0
Xsky130_fd_sc_hd__fill_8_2048
+ vss
+ vdd
+ vdd
+ sky130_fd_sc_hd__fill_8
* cell instance sky130_fd_sc_hd__fill_8_2049 r0 *1 0,0
Xsky130_fd_sc_hd__fill_8_2049
+ vss
+ vdd
+ vdd
+ sky130_fd_sc_hd__fill_8
* cell instance sky130_fd_sc_hd__fill_8_2050 r0 *1 0,0
Xsky130_fd_sc_hd__fill_8_2050
+ vss
+ vdd
+ vdd
+ sky130_fd_sc_hd__fill_8
* cell instance sky130_fd_sc_hd__fill_8_2051 r0 *1 0,0
Xsky130_fd_sc_hd__fill_8_2051
+ vss
+ vdd
+ vdd
+ sky130_fd_sc_hd__fill_8
* cell instance sky130_fd_sc_hd__fill_8_2052 r0 *1 0,0
Xsky130_fd_sc_hd__fill_8_2052
+ vss
+ vdd
+ vdd
+ sky130_fd_sc_hd__fill_8
* cell instance sky130_fd_sc_hd__fill_8_2053 r0 *1 0,0
Xsky130_fd_sc_hd__fill_8_2053
+ vss
+ vdd
+ vdd
+ sky130_fd_sc_hd__fill_8
* cell instance sky130_fd_sc_hd__fill_8_2054 r0 *1 0,0
Xsky130_fd_sc_hd__fill_8_2054
+ vss
+ vdd
+ vdd
+ sky130_fd_sc_hd__fill_8
* cell instance sky130_fd_sc_hd__fill_8_2055 r0 *1 0,0
Xsky130_fd_sc_hd__fill_8_2055
+ vss
+ vdd
+ vdd
+ sky130_fd_sc_hd__fill_8
* cell instance sky130_fd_sc_hd__fill_8_2056 r0 *1 0,0
Xsky130_fd_sc_hd__fill_8_2056
+ vss
+ vdd
+ vdd
+ sky130_fd_sc_hd__fill_8
* cell instance sky130_fd_sc_hd__fill_8_2057 r0 *1 0,0
Xsky130_fd_sc_hd__fill_8_2057
+ vss
+ vdd
+ vdd
+ sky130_fd_sc_hd__fill_8
* cell instance sky130_fd_sc_hd__fill_8_2058 r0 *1 0,0
Xsky130_fd_sc_hd__fill_8_2058
+ vss
+ vdd
+ vdd
+ sky130_fd_sc_hd__fill_8
* cell instance sky130_fd_sc_hd__fill_8_2059 r0 *1 0,0
Xsky130_fd_sc_hd__fill_8_2059
+ vss
+ vdd
+ vdd
+ sky130_fd_sc_hd__fill_8
* cell instance sky130_fd_sc_hd__fill_8_2060 r0 *1 0,0
Xsky130_fd_sc_hd__fill_8_2060
+ vss
+ vdd
+ vdd
+ sky130_fd_sc_hd__fill_8
* cell instance sky130_fd_sc_hd__fill_8_2061 r0 *1 0,0
Xsky130_fd_sc_hd__fill_8_2061
+ vss
+ vdd
+ vdd
+ sky130_fd_sc_hd__fill_8
* cell instance sky130_fd_sc_hd__fill_8_2062 r0 *1 0,0
Xsky130_fd_sc_hd__fill_8_2062
+ vss
+ vdd
+ vdd
+ sky130_fd_sc_hd__fill_8
* cell instance sky130_fd_sc_hd__fill_8_2063 r0 *1 0,0
Xsky130_fd_sc_hd__fill_8_2063
+ vss
+ vdd
+ vdd
+ sky130_fd_sc_hd__fill_8
* cell instance sky130_fd_sc_hd__fill_8_2064 r0 *1 0,0
Xsky130_fd_sc_hd__fill_8_2064
+ vss
+ vdd
+ vdd
+ sky130_fd_sc_hd__fill_8
* cell instance sky130_fd_sc_hd__fill_8_2065 r0 *1 0,0
Xsky130_fd_sc_hd__fill_8_2065
+ vss
+ vdd
+ vdd
+ sky130_fd_sc_hd__fill_8
* cell instance sky130_fd_sc_hd__fill_8_2066 r0 *1 0,0
Xsky130_fd_sc_hd__fill_8_2066
+ vss
+ vdd
+ vdd
+ sky130_fd_sc_hd__fill_8
* cell instance sky130_fd_sc_hd__fill_8_2067 r0 *1 0,0
Xsky130_fd_sc_hd__fill_8_2067
+ vss
+ vdd
+ vdd
+ sky130_fd_sc_hd__fill_8
* cell instance sky130_fd_sc_hd__fill_8_2068 r0 *1 0,0
Xsky130_fd_sc_hd__fill_8_2068
+ vss
+ vdd
+ vdd
+ sky130_fd_sc_hd__fill_8
* cell instance sky130_fd_sc_hd__fill_8_2069 r0 *1 0,0
Xsky130_fd_sc_hd__fill_8_2069
+ vss
+ vdd
+ vdd
+ sky130_fd_sc_hd__fill_8
* cell instance sky130_fd_sc_hd__fill_8_2070 r0 *1 0,0
Xsky130_fd_sc_hd__fill_8_2070
+ vss
+ vdd
+ vdd
+ sky130_fd_sc_hd__fill_8
* cell instance sky130_fd_sc_hd__fill_8_2071 r0 *1 0,0
Xsky130_fd_sc_hd__fill_8_2071
+ vss
+ vdd
+ vdd
+ sky130_fd_sc_hd__fill_8
* cell instance sky130_fd_sc_hd__fill_8_2072 r0 *1 0,0
Xsky130_fd_sc_hd__fill_8_2072
+ vss
+ vdd
+ vdd
+ sky130_fd_sc_hd__fill_8
* cell instance sky130_fd_sc_hd__fill_8_2073 r0 *1 0,0
Xsky130_fd_sc_hd__fill_8_2073
+ vss
+ vdd
+ vdd
+ sky130_fd_sc_hd__fill_8
* cell instance sky130_fd_sc_hd__fill_8_2074 r0 *1 0,0
Xsky130_fd_sc_hd__fill_8_2074
+ vss
+ vdd
+ vdd
+ sky130_fd_sc_hd__fill_8
* cell instance sky130_fd_sc_hd__fill_8_2075 r0 *1 0,0
Xsky130_fd_sc_hd__fill_8_2075
+ vss
+ vdd
+ vdd
+ sky130_fd_sc_hd__fill_8
* cell instance sky130_fd_sc_hd__fill_8_2076 r0 *1 0,0
Xsky130_fd_sc_hd__fill_8_2076
+ vss
+ vdd
+ vdd
+ sky130_fd_sc_hd__fill_8
* cell instance sky130_fd_sc_hd__fill_8_2077 r0 *1 0,0
Xsky130_fd_sc_hd__fill_8_2077
+ vss
+ vdd
+ vdd
+ sky130_fd_sc_hd__fill_8
* cell instance sky130_fd_sc_hd__fill_8_2078 r0 *1 0,0
Xsky130_fd_sc_hd__fill_8_2078
+ vss
+ vdd
+ vdd
+ sky130_fd_sc_hd__fill_8
* cell instance sky130_fd_sc_hd__fill_8_2079 r0 *1 0,0
Xsky130_fd_sc_hd__fill_8_2079
+ vss
+ vdd
+ vdd
+ sky130_fd_sc_hd__fill_8
* cell instance sky130_fd_sc_hd__fill_8_2080 r0 *1 0,0
Xsky130_fd_sc_hd__fill_8_2080
+ vss
+ vdd
+ vdd
+ sky130_fd_sc_hd__fill_8
* cell instance sky130_fd_sc_hd__fill_8_2081 r0 *1 0,0
Xsky130_fd_sc_hd__fill_8_2081
+ vss
+ vdd
+ vdd
+ sky130_fd_sc_hd__fill_8
* cell instance sky130_fd_sc_hd__fill_8_2082 r0 *1 0,0
Xsky130_fd_sc_hd__fill_8_2082
+ vss
+ vdd
+ vdd
+ sky130_fd_sc_hd__fill_8
* cell instance sky130_fd_sc_hd__fill_8_2083 r0 *1 0,0
Xsky130_fd_sc_hd__fill_8_2083
+ vss
+ vdd
+ vdd
+ sky130_fd_sc_hd__fill_8
* cell instance sky130_fd_sc_hd__fill_8_2084 r0 *1 0,0
Xsky130_fd_sc_hd__fill_8_2084
+ vss
+ vdd
+ vdd
+ sky130_fd_sc_hd__fill_8
* cell instance sky130_fd_sc_hd__fill_8_2085 r0 *1 0,0
Xsky130_fd_sc_hd__fill_8_2085
+ vss
+ vdd
+ vdd
+ sky130_fd_sc_hd__fill_8
* cell instance sky130_fd_sc_hd__fill_8_2086 r0 *1 0,0
Xsky130_fd_sc_hd__fill_8_2086
+ vss
+ vdd
+ vdd
+ sky130_fd_sc_hd__fill_8
* cell instance sky130_fd_sc_hd__fill_8_2087 r0 *1 0,0
Xsky130_fd_sc_hd__fill_8_2087
+ vss
+ vdd
+ vdd
+ sky130_fd_sc_hd__fill_8
* cell instance sky130_fd_sc_hd__fill_8_2088 r0 *1 0,0
Xsky130_fd_sc_hd__fill_8_2088
+ vss
+ vdd
+ vdd
+ sky130_fd_sc_hd__fill_8
* cell instance sky130_fd_sc_hd__fill_8_2089 r0 *1 0,0
Xsky130_fd_sc_hd__fill_8_2089
+ vss
+ vdd
+ vdd
+ sky130_fd_sc_hd__fill_8
* cell instance sky130_fd_sc_hd__fill_8_2090 r0 *1 0,0
Xsky130_fd_sc_hd__fill_8_2090
+ vss
+ vdd
+ vdd
+ sky130_fd_sc_hd__fill_8
* cell instance sky130_fd_sc_hd__fill_8_2091 r0 *1 0,0
Xsky130_fd_sc_hd__fill_8_2091
+ vss
+ vdd
+ vdd
+ sky130_fd_sc_hd__fill_8
* cell instance sky130_fd_sc_hd__fill_8_2092 r0 *1 0,0
Xsky130_fd_sc_hd__fill_8_2092
+ vss
+ vdd
+ vdd
+ sky130_fd_sc_hd__fill_8
* cell instance sky130_fd_sc_hd__fill_8_2093 r0 *1 0,0
Xsky130_fd_sc_hd__fill_8_2093
+ vss
+ vdd
+ vdd
+ sky130_fd_sc_hd__fill_8
* cell instance sky130_fd_sc_hd__fill_8_2094 r0 *1 0,0
Xsky130_fd_sc_hd__fill_8_2094
+ vss
+ vdd
+ vdd
+ sky130_fd_sc_hd__fill_8
* cell instance sky130_fd_sc_hd__fill_8_2095 r0 *1 0,0
Xsky130_fd_sc_hd__fill_8_2095
+ vss
+ vdd
+ vdd
+ sky130_fd_sc_hd__fill_8
* cell instance sky130_fd_sc_hd__fill_8_2096 r0 *1 0,0
Xsky130_fd_sc_hd__fill_8_2096
+ vss
+ vdd
+ vdd
+ sky130_fd_sc_hd__fill_8
* cell instance sky130_fd_sc_hd__fill_8_2097 r0 *1 0,0
Xsky130_fd_sc_hd__fill_8_2097
+ vss
+ vdd
+ vdd
+ sky130_fd_sc_hd__fill_8
* cell instance sky130_fd_sc_hd__fill_8_2098 r0 *1 0,0
Xsky130_fd_sc_hd__fill_8_2098
+ vss
+ vdd
+ vdd
+ sky130_fd_sc_hd__fill_8
* cell instance sky130_fd_sc_hd__fill_8_2099 r0 *1 0,0
Xsky130_fd_sc_hd__fill_8_2099
+ vss
+ vdd
+ vdd
+ sky130_fd_sc_hd__fill_8
* cell instance sky130_fd_sc_hd__fill_8_2100 r0 *1 0,0
Xsky130_fd_sc_hd__fill_8_2100
+ vss
+ vdd
+ vdd
+ sky130_fd_sc_hd__fill_8
* cell instance sky130_fd_sc_hd__fill_8_2101 r0 *1 0,0
Xsky130_fd_sc_hd__fill_8_2101
+ vss
+ vdd
+ vdd
+ sky130_fd_sc_hd__fill_8
* cell instance sky130_fd_sc_hd__fill_8_2102 r0 *1 0,0
Xsky130_fd_sc_hd__fill_8_2102
+ vss
+ vdd
+ vdd
+ sky130_fd_sc_hd__fill_8
* cell instance sky130_fd_sc_hd__fill_8_2103 r0 *1 0,0
Xsky130_fd_sc_hd__fill_8_2103
+ vss
+ vdd
+ vdd
+ sky130_fd_sc_hd__fill_8
* cell instance sky130_fd_sc_hd__fill_8_2104 r0 *1 0,0
Xsky130_fd_sc_hd__fill_8_2104
+ vss
+ vdd
+ vdd
+ sky130_fd_sc_hd__fill_8
* cell instance sky130_fd_sc_hd__fill_8_2105 r0 *1 0,0
Xsky130_fd_sc_hd__fill_8_2105
+ vss
+ vdd
+ vdd
+ sky130_fd_sc_hd__fill_8
* cell instance sky130_fd_sc_hd__fill_8_2106 r0 *1 0,0
Xsky130_fd_sc_hd__fill_8_2106
+ vss
+ vdd
+ vdd
+ sky130_fd_sc_hd__fill_8
* cell instance sky130_fd_sc_hd__fill_8_2107 r0 *1 0,0
Xsky130_fd_sc_hd__fill_8_2107
+ vss
+ vdd
+ vdd
+ sky130_fd_sc_hd__fill_8
* cell instance sky130_fd_sc_hd__fill_8_2108 r0 *1 0,0
Xsky130_fd_sc_hd__fill_8_2108
+ vss
+ vdd
+ vdd
+ sky130_fd_sc_hd__fill_8
* cell instance sky130_fd_sc_hd__fill_8_2109 r0 *1 0,0
Xsky130_fd_sc_hd__fill_8_2109
+ vss
+ vdd
+ vdd
+ sky130_fd_sc_hd__fill_8
* cell instance sky130_fd_sc_hd__fill_8_2110 r0 *1 0,0
Xsky130_fd_sc_hd__fill_8_2110
+ vss
+ vdd
+ vdd
+ sky130_fd_sc_hd__fill_8
* cell instance sky130_fd_sc_hd__fill_8_2111 r0 *1 0,0
Xsky130_fd_sc_hd__fill_8_2111
+ vss
+ vdd
+ vdd
+ sky130_fd_sc_hd__fill_8
* cell instance sky130_fd_sc_hd__fill_8_2112 r0 *1 0,0
Xsky130_fd_sc_hd__fill_8_2112
+ vss
+ vdd
+ vdd
+ sky130_fd_sc_hd__fill_8
* cell instance sky130_fd_sc_hd__fill_8_2113 r0 *1 0,0
Xsky130_fd_sc_hd__fill_8_2113
+ vss
+ vdd
+ vdd
+ sky130_fd_sc_hd__fill_8
* cell instance sky130_fd_sc_hd__fill_8_2114 r0 *1 0,0
Xsky130_fd_sc_hd__fill_8_2114
+ vss
+ vdd
+ vdd
+ sky130_fd_sc_hd__fill_8
* cell instance sky130_fd_sc_hd__fill_8_2115 r0 *1 0,0
Xsky130_fd_sc_hd__fill_8_2115
+ vss
+ vdd
+ vdd
+ sky130_fd_sc_hd__fill_8
* cell instance sky130_fd_sc_hd__fill_8_2116 r0 *1 0,0
Xsky130_fd_sc_hd__fill_8_2116
+ vss
+ vdd
+ vdd
+ sky130_fd_sc_hd__fill_8
* cell instance sky130_fd_sc_hd__fill_8_2117 r0 *1 0,0
Xsky130_fd_sc_hd__fill_8_2117
+ vss
+ vdd
+ vdd
+ sky130_fd_sc_hd__fill_8
* cell instance sky130_fd_sc_hd__fill_8_2118 r0 *1 0,0
Xsky130_fd_sc_hd__fill_8_2118
+ vss
+ vdd
+ vdd
+ sky130_fd_sc_hd__fill_8
* cell instance sky130_fd_sc_hd__fill_8_2119 r0 *1 0,0
Xsky130_fd_sc_hd__fill_8_2119
+ vss
+ vdd
+ vdd
+ sky130_fd_sc_hd__fill_8
* cell instance sky130_fd_sc_hd__fill_8_2120 r0 *1 0,0
Xsky130_fd_sc_hd__fill_8_2120
+ vss
+ vdd
+ vdd
+ sky130_fd_sc_hd__fill_8
* cell instance sky130_fd_sc_hd__fill_8_2121 r0 *1 0,0
Xsky130_fd_sc_hd__fill_8_2121
+ vss
+ vdd
+ vdd
+ sky130_fd_sc_hd__fill_8
* cell instance sky130_fd_sc_hd__fill_8_2122 r0 *1 0,0
Xsky130_fd_sc_hd__fill_8_2122
+ vss
+ vdd
+ vdd
+ sky130_fd_sc_hd__fill_8
* cell instance sky130_fd_sc_hd__fill_8_2123 r0 *1 0,0
Xsky130_fd_sc_hd__fill_8_2123
+ vss
+ vdd
+ vdd
+ sky130_fd_sc_hd__fill_8
* cell instance sky130_fd_sc_hd__fill_8_2124 r0 *1 0,0
Xsky130_fd_sc_hd__fill_8_2124
+ vss
+ vdd
+ vdd
+ sky130_fd_sc_hd__fill_8
* cell instance sky130_fd_sc_hd__fill_8_2125 r0 *1 0,0
Xsky130_fd_sc_hd__fill_8_2125
+ vss
+ vdd
+ vdd
+ sky130_fd_sc_hd__fill_8
* cell instance sky130_fd_sc_hd__fill_8_2126 r0 *1 0,0
Xsky130_fd_sc_hd__fill_8_2126
+ vss
+ vdd
+ vdd
+ sky130_fd_sc_hd__fill_8
* cell instance sky130_fd_sc_hd__fill_8_2127 r0 *1 0,0
Xsky130_fd_sc_hd__fill_8_2127
+ vss
+ vdd
+ vdd
+ sky130_fd_sc_hd__fill_8
* cell instance sky130_fd_sc_hd__fill_8_2128 r0 *1 0,0
Xsky130_fd_sc_hd__fill_8_2128
+ vss
+ vdd
+ vdd
+ sky130_fd_sc_hd__fill_8
* cell instance sky130_fd_sc_hd__fill_8_2129 r0 *1 0,0
Xsky130_fd_sc_hd__fill_8_2129
+ vss
+ vdd
+ vdd
+ sky130_fd_sc_hd__fill_8
* cell instance sky130_fd_sc_hd__fill_8_2130 r0 *1 0,0
Xsky130_fd_sc_hd__fill_8_2130
+ vss
+ vdd
+ vdd
+ sky130_fd_sc_hd__fill_8
* cell instance sky130_fd_sc_hd__fill_8_2131 r0 *1 0,0
Xsky130_fd_sc_hd__fill_8_2131
+ vss
+ vdd
+ vdd
+ sky130_fd_sc_hd__fill_8
* cell instance sky130_fd_sc_hd__fill_8_2132 r0 *1 0,0
Xsky130_fd_sc_hd__fill_8_2132
+ vss
+ vdd
+ vdd
+ sky130_fd_sc_hd__fill_8
* cell instance sky130_fd_sc_hd__fill_8_2133 r0 *1 0,0
Xsky130_fd_sc_hd__fill_8_2133
+ vss
+ vdd
+ vdd
+ sky130_fd_sc_hd__fill_8
* cell instance sky130_fd_sc_hd__fill_8_2134 r0 *1 0,0
Xsky130_fd_sc_hd__fill_8_2134
+ vss
+ vdd
+ vdd
+ sky130_fd_sc_hd__fill_8
* cell instance sky130_fd_sc_hd__fill_8_2135 r0 *1 0,0
Xsky130_fd_sc_hd__fill_8_2135
+ vss
+ vdd
+ vdd
+ sky130_fd_sc_hd__fill_8
* cell instance sky130_fd_sc_hd__fill_8_2136 r0 *1 0,0
Xsky130_fd_sc_hd__fill_8_2136
+ vss
+ vdd
+ vdd
+ sky130_fd_sc_hd__fill_8
* cell instance sky130_fd_sc_hd__fill_8_2137 r0 *1 0,0
Xsky130_fd_sc_hd__fill_8_2137
+ vss
+ vdd
+ vdd
+ sky130_fd_sc_hd__fill_8
* cell instance sky130_fd_sc_hd__fill_8_2138 r0 *1 0,0
Xsky130_fd_sc_hd__fill_8_2138
+ vss
+ vdd
+ vdd
+ sky130_fd_sc_hd__fill_8
* cell instance sky130_fd_sc_hd__fill_8_2139 r0 *1 0,0
Xsky130_fd_sc_hd__fill_8_2139
+ vss
+ vdd
+ vdd
+ sky130_fd_sc_hd__fill_8
* cell instance sky130_fd_sc_hd__fill_8_2140 r0 *1 0,0
Xsky130_fd_sc_hd__fill_8_2140
+ vss
+ vdd
+ vdd
+ sky130_fd_sc_hd__fill_8
* cell instance sky130_fd_sc_hd__fill_8_2141 r0 *1 0,0
Xsky130_fd_sc_hd__fill_8_2141
+ vss
+ vdd
+ vdd
+ sky130_fd_sc_hd__fill_8
* cell instance sky130_fd_sc_hd__fill_8_2142 r0 *1 0,0
Xsky130_fd_sc_hd__fill_8_2142
+ vss
+ vdd
+ vdd
+ sky130_fd_sc_hd__fill_8
* cell instance sky130_fd_sc_hd__fill_8_2143 r0 *1 0,0
Xsky130_fd_sc_hd__fill_8_2143
+ vss
+ vdd
+ vdd
+ sky130_fd_sc_hd__fill_8
* cell instance sky130_fd_sc_hd__fill_8_2144 r0 *1 0,0
Xsky130_fd_sc_hd__fill_8_2144
+ vss
+ vdd
+ vdd
+ sky130_fd_sc_hd__fill_8
* cell instance sky130_fd_sc_hd__fill_8_2145 r0 *1 0,0
Xsky130_fd_sc_hd__fill_8_2145
+ vss
+ vdd
+ vdd
+ sky130_fd_sc_hd__fill_8
* cell instance sky130_fd_sc_hd__fill_8_2146 r0 *1 0,0
Xsky130_fd_sc_hd__fill_8_2146
+ vss
+ vdd
+ vdd
+ sky130_fd_sc_hd__fill_8
* cell instance sky130_fd_sc_hd__fill_8_2147 r0 *1 0,0
Xsky130_fd_sc_hd__fill_8_2147
+ vss
+ vdd
+ vdd
+ sky130_fd_sc_hd__fill_8
* cell instance sky130_fd_sc_hd__fill_8_2148 r0 *1 0,0
Xsky130_fd_sc_hd__fill_8_2148
+ vss
+ vdd
+ vdd
+ sky130_fd_sc_hd__fill_8
* cell instance sky130_fd_sc_hd__fill_8_2149 r0 *1 0,0
Xsky130_fd_sc_hd__fill_8_2149
+ vss
+ vdd
+ vdd
+ sky130_fd_sc_hd__fill_8
* cell instance sky130_fd_sc_hd__fill_8_2150 r0 *1 0,0
Xsky130_fd_sc_hd__fill_8_2150
+ vss
+ vdd
+ vdd
+ sky130_fd_sc_hd__fill_8
* cell instance sky130_fd_sc_hd__fill_8_2151 r0 *1 0,0
Xsky130_fd_sc_hd__fill_8_2151
+ vss
+ vdd
+ vdd
+ sky130_fd_sc_hd__fill_8
* cell instance sky130_fd_sc_hd__fill_8_2152 r0 *1 0,0
Xsky130_fd_sc_hd__fill_8_2152
+ vss
+ vdd
+ vdd
+ sky130_fd_sc_hd__fill_8
* cell instance sky130_fd_sc_hd__fill_8_2153 r0 *1 0,0
Xsky130_fd_sc_hd__fill_8_2153
+ vss
+ vdd
+ vdd
+ sky130_fd_sc_hd__fill_8
* cell instance sky130_fd_sc_hd__fill_8_2154 r0 *1 0,0
Xsky130_fd_sc_hd__fill_8_2154
+ vss
+ vdd
+ vdd
+ sky130_fd_sc_hd__fill_8
* cell instance sky130_fd_sc_hd__fill_8_2155 r0 *1 0,0
Xsky130_fd_sc_hd__fill_8_2155
+ vss
+ vdd
+ vdd
+ sky130_fd_sc_hd__fill_8
* cell instance sky130_fd_sc_hd__fill_8_2156 r0 *1 0,0
Xsky130_fd_sc_hd__fill_8_2156
+ vss
+ vdd
+ vdd
+ sky130_fd_sc_hd__fill_8
* cell instance sky130_fd_sc_hd__fill_8_2157 r0 *1 0,0
Xsky130_fd_sc_hd__fill_8_2157
+ vss
+ vdd
+ vdd
+ sky130_fd_sc_hd__fill_8
* cell instance sky130_fd_sc_hd__fill_8_2158 r0 *1 0,0
Xsky130_fd_sc_hd__fill_8_2158
+ vss
+ vdd
+ vdd
+ sky130_fd_sc_hd__fill_8
* cell instance sky130_fd_sc_hd__fill_8_2159 r0 *1 0,0
Xsky130_fd_sc_hd__fill_8_2159
+ vss
+ vdd
+ vdd
+ sky130_fd_sc_hd__fill_8
* cell instance sky130_fd_sc_hd__fill_8_2160 r0 *1 0,0
Xsky130_fd_sc_hd__fill_8_2160
+ vss
+ vdd
+ vdd
+ sky130_fd_sc_hd__fill_8
* cell instance sky130_fd_sc_hd__fill_8_2161 r0 *1 0,0
Xsky130_fd_sc_hd__fill_8_2161
+ vss
+ vdd
+ vdd
+ sky130_fd_sc_hd__fill_8
* cell instance sky130_fd_sc_hd__fill_8_2162 r0 *1 0,0
Xsky130_fd_sc_hd__fill_8_2162
+ vss
+ vdd
+ vdd
+ sky130_fd_sc_hd__fill_8
* cell instance sky130_fd_sc_hd__fill_8_2163 r0 *1 0,0
Xsky130_fd_sc_hd__fill_8_2163
+ vss
+ vdd
+ vdd
+ sky130_fd_sc_hd__fill_8
* cell instance sky130_fd_sc_hd__fill_8_2164 r0 *1 0,0
Xsky130_fd_sc_hd__fill_8_2164
+ vss
+ vdd
+ vdd
+ sky130_fd_sc_hd__fill_8
* cell instance sky130_fd_sc_hd__fill_8_2165 r0 *1 0,0
Xsky130_fd_sc_hd__fill_8_2165
+ vss
+ vdd
+ vdd
+ sky130_fd_sc_hd__fill_8
* cell instance sky130_fd_sc_hd__fill_8_2166 r0 *1 0,0
Xsky130_fd_sc_hd__fill_8_2166
+ vss
+ vdd
+ vdd
+ sky130_fd_sc_hd__fill_8
* cell instance sky130_fd_sc_hd__fill_8_2167 r0 *1 0,0
Xsky130_fd_sc_hd__fill_8_2167
+ vss
+ vdd
+ vdd
+ sky130_fd_sc_hd__fill_8
* cell instance sky130_fd_sc_hd__fill_8_2168 r0 *1 0,0
Xsky130_fd_sc_hd__fill_8_2168
+ vss
+ vdd
+ vdd
+ sky130_fd_sc_hd__fill_8
* cell instance sky130_fd_sc_hd__fill_8_2169 r0 *1 0,0
Xsky130_fd_sc_hd__fill_8_2169
+ vss
+ vdd
+ vdd
+ sky130_fd_sc_hd__fill_8
* cell instance sky130_fd_sc_hd__fill_8_2170 r0 *1 0,0
Xsky130_fd_sc_hd__fill_8_2170
+ vss
+ vdd
+ vdd
+ sky130_fd_sc_hd__fill_8
* cell instance sky130_fd_sc_hd__fill_8_2171 r0 *1 0,0
Xsky130_fd_sc_hd__fill_8_2171
+ vss
+ vdd
+ vdd
+ sky130_fd_sc_hd__fill_8
* cell instance sky130_fd_sc_hd__fill_8_2172 r0 *1 0,0
Xsky130_fd_sc_hd__fill_8_2172
+ vss
+ vdd
+ vdd
+ sky130_fd_sc_hd__fill_8
* cell instance sky130_fd_sc_hd__fill_8_2173 r0 *1 0,0
Xsky130_fd_sc_hd__fill_8_2173
+ vss
+ vdd
+ vdd
+ sky130_fd_sc_hd__fill_8
* cell instance sky130_fd_sc_hd__fill_8_2174 r0 *1 0,0
Xsky130_fd_sc_hd__fill_8_2174
+ vss
+ vdd
+ vdd
+ sky130_fd_sc_hd__fill_8
* cell instance sky130_fd_sc_hd__fill_8_2175 r0 *1 0,0
Xsky130_fd_sc_hd__fill_8_2175
+ vss
+ vdd
+ vdd
+ sky130_fd_sc_hd__fill_8
* cell instance sky130_fd_sc_hd__fill_8_2176 r0 *1 0,0
Xsky130_fd_sc_hd__fill_8_2176
+ vss
+ vdd
+ vdd
+ sky130_fd_sc_hd__fill_8
* cell instance sky130_fd_sc_hd__fill_8_2177 r0 *1 0,0
Xsky130_fd_sc_hd__fill_8_2177
+ vss
+ vdd
+ vdd
+ sky130_fd_sc_hd__fill_8
* cell instance sky130_fd_sc_hd__fill_8_2178 r0 *1 0,0
Xsky130_fd_sc_hd__fill_8_2178
+ vss
+ vdd
+ vdd
+ sky130_fd_sc_hd__fill_8
* cell instance sky130_fd_sc_hd__fill_8_2179 r0 *1 0,0
Xsky130_fd_sc_hd__fill_8_2179
+ vss
+ vdd
+ vdd
+ sky130_fd_sc_hd__fill_8
* cell instance sky130_fd_sc_hd__fill_8_2180 r0 *1 0,0
Xsky130_fd_sc_hd__fill_8_2180
+ vss
+ vdd
+ vdd
+ sky130_fd_sc_hd__fill_8
* cell instance sky130_fd_sc_hd__fill_8_2181 r0 *1 0,0
Xsky130_fd_sc_hd__fill_8_2181
+ vss
+ vdd
+ vdd
+ sky130_fd_sc_hd__fill_8
* cell instance sky130_fd_sc_hd__fill_8_2182 r0 *1 0,0
Xsky130_fd_sc_hd__fill_8_2182
+ vss
+ vdd
+ vdd
+ sky130_fd_sc_hd__fill_8
* cell instance sky130_fd_sc_hd__fill_8_2183 r0 *1 0,0
Xsky130_fd_sc_hd__fill_8_2183
+ vss
+ vdd
+ vdd
+ sky130_fd_sc_hd__fill_8
* cell instance sky130_fd_sc_hd__fill_8_2184 r0 *1 0,0
Xsky130_fd_sc_hd__fill_8_2184
+ vss
+ vdd
+ vdd
+ sky130_fd_sc_hd__fill_8
* cell instance sky130_fd_sc_hd__fill_8_2185 r0 *1 0,0
Xsky130_fd_sc_hd__fill_8_2185
+ vss
+ vdd
+ vdd
+ sky130_fd_sc_hd__fill_8
* cell instance sky130_fd_sc_hd__fill_8_2186 r0 *1 0,0
Xsky130_fd_sc_hd__fill_8_2186
+ vss
+ vdd
+ vdd
+ sky130_fd_sc_hd__fill_8
* cell instance sky130_fd_sc_hd__fill_8_2187 r0 *1 0,0
Xsky130_fd_sc_hd__fill_8_2187
+ vss
+ vdd
+ vdd
+ sky130_fd_sc_hd__fill_8
* cell instance sky130_fd_sc_hd__fill_8_2188 r0 *1 0,0
Xsky130_fd_sc_hd__fill_8_2188
+ vss
+ vdd
+ vdd
+ sky130_fd_sc_hd__fill_8
* cell instance sky130_fd_sc_hd__fill_8_2189 r0 *1 0,0
Xsky130_fd_sc_hd__fill_8_2189
+ vss
+ vdd
+ vdd
+ sky130_fd_sc_hd__fill_8
* cell instance sky130_fd_sc_hd__fill_8_2190 r0 *1 0,0
Xsky130_fd_sc_hd__fill_8_2190
+ vss
+ vdd
+ vdd
+ sky130_fd_sc_hd__fill_8
* cell instance sky130_fd_sc_hd__fill_8_2191 r0 *1 0,0
Xsky130_fd_sc_hd__fill_8_2191
+ vss
+ vdd
+ vdd
+ sky130_fd_sc_hd__fill_8
* cell instance sky130_fd_sc_hd__fill_8_2192 r0 *1 0,0
Xsky130_fd_sc_hd__fill_8_2192
+ vss
+ vdd
+ vdd
+ sky130_fd_sc_hd__fill_8
* cell instance sky130_fd_sc_hd__fill_8_2193 r0 *1 0,0
Xsky130_fd_sc_hd__fill_8_2193
+ vss
+ vdd
+ vdd
+ sky130_fd_sc_hd__fill_8
* cell instance sky130_fd_sc_hd__fill_8_2194 r0 *1 0,0
Xsky130_fd_sc_hd__fill_8_2194
+ vss
+ vdd
+ vdd
+ sky130_fd_sc_hd__fill_8
* cell instance sky130_fd_sc_hd__fill_8_2195 r0 *1 0,0
Xsky130_fd_sc_hd__fill_8_2195
+ vss
+ vdd
+ vdd
+ sky130_fd_sc_hd__fill_8
* cell instance sky130_fd_sc_hd__fill_8_2196 r0 *1 0,0
Xsky130_fd_sc_hd__fill_8_2196
+ vss
+ vdd
+ vdd
+ sky130_fd_sc_hd__fill_8
* cell instance sky130_fd_sc_hd__fill_8_2197 r0 *1 0,0
Xsky130_fd_sc_hd__fill_8_2197
+ vss
+ vdd
+ vdd
+ sky130_fd_sc_hd__fill_8
* cell instance sky130_fd_sc_hd__fill_8_2198 r0 *1 0,0
Xsky130_fd_sc_hd__fill_8_2198
+ vss
+ vdd
+ vdd
+ sky130_fd_sc_hd__fill_8
* cell instance sky130_fd_sc_hd__fill_8_2199 r0 *1 0,0
Xsky130_fd_sc_hd__fill_8_2199
+ vss
+ vdd
+ vdd
+ sky130_fd_sc_hd__fill_8
* cell instance sky130_fd_sc_hd__fill_8_2200 r0 *1 0,0
Xsky130_fd_sc_hd__fill_8_2200
+ vss
+ vdd
+ vdd
+ sky130_fd_sc_hd__fill_8
* cell instance sky130_fd_sc_hd__fill_8_2201 r0 *1 0,0
Xsky130_fd_sc_hd__fill_8_2201
+ vss
+ vdd
+ vdd
+ sky130_fd_sc_hd__fill_8
* cell instance sky130_fd_sc_hd__fill_8_2202 r0 *1 0,0
Xsky130_fd_sc_hd__fill_8_2202
+ vss
+ vdd
+ vdd
+ sky130_fd_sc_hd__fill_8
* cell instance sky130_fd_sc_hd__fill_8_2203 r0 *1 0,0
Xsky130_fd_sc_hd__fill_8_2203
+ vss
+ vdd
+ vdd
+ sky130_fd_sc_hd__fill_8
* cell instance sky130_fd_sc_hd__fill_8_2204 r0 *1 0,0
Xsky130_fd_sc_hd__fill_8_2204
+ vss
+ vdd
+ vdd
+ sky130_fd_sc_hd__fill_8
* cell instance sky130_fd_sc_hd__fill_8_2205 r0 *1 0,0
Xsky130_fd_sc_hd__fill_8_2205
+ vss
+ vdd
+ vdd
+ sky130_fd_sc_hd__fill_8
* cell instance sky130_fd_sc_hd__fill_8_2206 r0 *1 0,0
Xsky130_fd_sc_hd__fill_8_2206
+ vss
+ vdd
+ vdd
+ sky130_fd_sc_hd__fill_8
* cell instance sky130_fd_sc_hd__fill_8_2207 r0 *1 0,0
Xsky130_fd_sc_hd__fill_8_2207
+ vss
+ vdd
+ vdd
+ sky130_fd_sc_hd__fill_8
* cell instance sky130_fd_sc_hd__fill_8_2208 r0 *1 0,0
Xsky130_fd_sc_hd__fill_8_2208
+ vss
+ vdd
+ vdd
+ sky130_fd_sc_hd__fill_8
* cell instance sky130_fd_sc_hd__fill_8_2209 r0 *1 0,0
Xsky130_fd_sc_hd__fill_8_2209
+ vss
+ vdd
+ vdd
+ sky130_fd_sc_hd__fill_8
* cell instance sky130_fd_sc_hd__fill_8_2210 r0 *1 0,0
Xsky130_fd_sc_hd__fill_8_2210
+ vss
+ vdd
+ vdd
+ sky130_fd_sc_hd__fill_8
* cell instance sky130_fd_sc_hd__fill_8_2211 r0 *1 0,0
Xsky130_fd_sc_hd__fill_8_2211
+ vss
+ vdd
+ vdd
+ sky130_fd_sc_hd__fill_8
* cell instance sky130_fd_sc_hd__fill_8_2212 r0 *1 0,0
Xsky130_fd_sc_hd__fill_8_2212
+ vss
+ vdd
+ vdd
+ sky130_fd_sc_hd__fill_8
* cell instance sky130_fd_sc_hd__fill_8_2213 r0 *1 0,0
Xsky130_fd_sc_hd__fill_8_2213
+ vss
+ vdd
+ vdd
+ sky130_fd_sc_hd__fill_8
* cell instance sky130_fd_sc_hd__fill_8_2214 r0 *1 0,0
Xsky130_fd_sc_hd__fill_8_2214
+ vss
+ vdd
+ vdd
+ sky130_fd_sc_hd__fill_8
* cell instance sky130_fd_sc_hd__fill_8_2215 r0 *1 0,0
Xsky130_fd_sc_hd__fill_8_2215
+ vss
+ vdd
+ vdd
+ sky130_fd_sc_hd__fill_8
* cell instance sky130_fd_sc_hd__fill_8_2216 r0 *1 0,0
Xsky130_fd_sc_hd__fill_8_2216
+ vss
+ vdd
+ vdd
+ sky130_fd_sc_hd__fill_8
* cell instance sky130_fd_sc_hd__fill_8_2217 r0 *1 0,0
Xsky130_fd_sc_hd__fill_8_2217
+ vss
+ vdd
+ vdd
+ sky130_fd_sc_hd__fill_8
* cell instance sky130_fd_sc_hd__fill_8_2218 r0 *1 0,0
Xsky130_fd_sc_hd__fill_8_2218
+ vss
+ vdd
+ vdd
+ sky130_fd_sc_hd__fill_8
* cell instance sky130_fd_sc_hd__fill_8_2219 r0 *1 0,0
Xsky130_fd_sc_hd__fill_8_2219
+ vss
+ vdd
+ vdd
+ sky130_fd_sc_hd__fill_8
* cell instance sky130_fd_sc_hd__fill_8_2220 r0 *1 0,0
Xsky130_fd_sc_hd__fill_8_2220
+ vss
+ vdd
+ vdd
+ sky130_fd_sc_hd__fill_8
* cell instance sky130_fd_sc_hd__fill_8_2221 r0 *1 0,0
Xsky130_fd_sc_hd__fill_8_2221
+ vss
+ vdd
+ vdd
+ sky130_fd_sc_hd__fill_8
* cell instance sky130_fd_sc_hd__fill_8_2222 r0 *1 0,0
Xsky130_fd_sc_hd__fill_8_2222
+ vss
+ vdd
+ vdd
+ sky130_fd_sc_hd__fill_8
* cell instance sky130_fd_sc_hd__fill_8_2223 r0 *1 0,0
Xsky130_fd_sc_hd__fill_8_2223
+ vss
+ vdd
+ vdd
+ sky130_fd_sc_hd__fill_8
* cell instance sky130_fd_sc_hd__fill_8_2224 r0 *1 0,0
Xsky130_fd_sc_hd__fill_8_2224
+ vss
+ vdd
+ vdd
+ sky130_fd_sc_hd__fill_8
* cell instance sky130_fd_sc_hd__fill_8_2225 r0 *1 0,0
Xsky130_fd_sc_hd__fill_8_2225
+ vss
+ vdd
+ vdd
+ sky130_fd_sc_hd__fill_8
* cell instance sky130_fd_sc_hd__fill_8_2226 r0 *1 0,0
Xsky130_fd_sc_hd__fill_8_2226
+ vss
+ vdd
+ vdd
+ sky130_fd_sc_hd__fill_8
* cell instance sky130_fd_sc_hd__fill_8_2227 r0 *1 0,0
Xsky130_fd_sc_hd__fill_8_2227
+ vss
+ vdd
+ vdd
+ sky130_fd_sc_hd__fill_8
* cell instance sky130_fd_sc_hd__fill_8_2228 r0 *1 0,0
Xsky130_fd_sc_hd__fill_8_2228
+ vss
+ vdd
+ vdd
+ sky130_fd_sc_hd__fill_8
* cell instance sky130_fd_sc_hd__fill_8_2229 r0 *1 0,0
Xsky130_fd_sc_hd__fill_8_2229
+ vss
+ vdd
+ vdd
+ sky130_fd_sc_hd__fill_8
* cell instance sky130_fd_sc_hd__fill_8_2230 r0 *1 0,0
Xsky130_fd_sc_hd__fill_8_2230
+ vss
+ vdd
+ vdd
+ sky130_fd_sc_hd__fill_8
* cell instance sky130_fd_sc_hd__fill_8_2231 r0 *1 0,0
Xsky130_fd_sc_hd__fill_8_2231
+ vss
+ vdd
+ vdd
+ sky130_fd_sc_hd__fill_8
* cell instance sky130_fd_sc_hd__fill_8_2232 r0 *1 0,0
Xsky130_fd_sc_hd__fill_8_2232
+ vss
+ vdd
+ vdd
+ sky130_fd_sc_hd__fill_8
* cell instance sky130_fd_sc_hd__fill_8_2233 r0 *1 0,0
Xsky130_fd_sc_hd__fill_8_2233
+ vss
+ vdd
+ vdd
+ sky130_fd_sc_hd__fill_8
* cell instance sky130_fd_sc_hd__fill_8_2234 r0 *1 0,0
Xsky130_fd_sc_hd__fill_8_2234
+ vss
+ vdd
+ vdd
+ sky130_fd_sc_hd__fill_8
* cell instance sky130_fd_sc_hd__fill_8_2235 r0 *1 0,0
Xsky130_fd_sc_hd__fill_8_2235
+ vss
+ vdd
+ vdd
+ sky130_fd_sc_hd__fill_8
* cell instance sky130_fd_sc_hd__fill_8_2236 r0 *1 0,0
Xsky130_fd_sc_hd__fill_8_2236
+ vss
+ vdd
+ vdd
+ sky130_fd_sc_hd__fill_8
* cell instance sky130_fd_sc_hd__fill_8_2237 r0 *1 0,0
Xsky130_fd_sc_hd__fill_8_2237
+ vss
+ vdd
+ vdd
+ sky130_fd_sc_hd__fill_8
* cell instance sky130_fd_sc_hd__fill_8_2238 r0 *1 0,0
Xsky130_fd_sc_hd__fill_8_2238
+ vss
+ vdd
+ vdd
+ sky130_fd_sc_hd__fill_8
* cell instance sky130_fd_sc_hd__fill_8_2239 r0 *1 0,0
Xsky130_fd_sc_hd__fill_8_2239
+ vss
+ vdd
+ vdd
+ sky130_fd_sc_hd__fill_8
* cell instance sky130_fd_sc_hd__fill_8_2240 r0 *1 0,0
Xsky130_fd_sc_hd__fill_8_2240
+ vss
+ vdd
+ vdd
+ sky130_fd_sc_hd__fill_8
* cell instance sky130_fd_sc_hd__fill_8_2241 r0 *1 0,0
Xsky130_fd_sc_hd__fill_8_2241
+ vss
+ vdd
+ vdd
+ sky130_fd_sc_hd__fill_8
* cell instance sky130_fd_sc_hd__fill_8_2242 r0 *1 0,0
Xsky130_fd_sc_hd__fill_8_2242
+ vss
+ vdd
+ vdd
+ sky130_fd_sc_hd__fill_8
* cell instance sky130_fd_sc_hd__fill_8_2243 r0 *1 0,0
Xsky130_fd_sc_hd__fill_8_2243
+ vss
+ vdd
+ vdd
+ sky130_fd_sc_hd__fill_8
* cell instance sky130_fd_sc_hd__fill_8_2244 r0 *1 0,0
Xsky130_fd_sc_hd__fill_8_2244
+ vss
+ vdd
+ vdd
+ sky130_fd_sc_hd__fill_8
* cell instance sky130_fd_sc_hd__fill_8_2245 r0 *1 0,0
Xsky130_fd_sc_hd__fill_8_2245
+ vss
+ vdd
+ vdd
+ sky130_fd_sc_hd__fill_8
* cell instance sky130_fd_sc_hd__fill_8_2246 r0 *1 0,0
Xsky130_fd_sc_hd__fill_8_2246
+ vss
+ vdd
+ vdd
+ sky130_fd_sc_hd__fill_8
* cell instance sky130_fd_sc_hd__fill_8_2247 r0 *1 0,0
Xsky130_fd_sc_hd__fill_8_2247
+ vss
+ vdd
+ vdd
+ sky130_fd_sc_hd__fill_8
* cell instance sky130_fd_sc_hd__fill_8_2248 r0 *1 0,0
Xsky130_fd_sc_hd__fill_8_2248
+ vss
+ vdd
+ vdd
+ sky130_fd_sc_hd__fill_8
* cell instance sky130_fd_sc_hd__fill_8_2249 r0 *1 0,0
Xsky130_fd_sc_hd__fill_8_2249
+ vss
+ vdd
+ vdd
+ sky130_fd_sc_hd__fill_8
* cell instance sky130_fd_sc_hd__fill_8_2250 r0 *1 0,0
Xsky130_fd_sc_hd__fill_8_2250
+ vss
+ vdd
+ vdd
+ sky130_fd_sc_hd__fill_8
* cell instance sky130_fd_sc_hd__fill_8_2251 r0 *1 0,0
Xsky130_fd_sc_hd__fill_8_2251
+ vss
+ vdd
+ vdd
+ sky130_fd_sc_hd__fill_8
* cell instance sky130_fd_sc_hd__fill_8_2252 r0 *1 0,0
Xsky130_fd_sc_hd__fill_8_2252
+ vss
+ vdd
+ vdd
+ sky130_fd_sc_hd__fill_8
* cell instance sky130_fd_sc_hd__fill_8_2253 r0 *1 0,0
Xsky130_fd_sc_hd__fill_8_2253
+ vss
+ vdd
+ vdd
+ sky130_fd_sc_hd__fill_8
* cell instance sky130_fd_sc_hd__fill_8_2254 r0 *1 0,0
Xsky130_fd_sc_hd__fill_8_2254
+ vss
+ vdd
+ vdd
+ sky130_fd_sc_hd__fill_8
* cell instance sky130_fd_sc_hd__fill_8_2255 r0 *1 0,0
Xsky130_fd_sc_hd__fill_8_2255
+ vss
+ vdd
+ vdd
+ sky130_fd_sc_hd__fill_8
* cell instance sky130_fd_sc_hd__fill_8_2256 r0 *1 0,0
Xsky130_fd_sc_hd__fill_8_2256
+ vss
+ vdd
+ vdd
+ sky130_fd_sc_hd__fill_8
* cell instance sky130_fd_sc_hd__fill_8_2257 r0 *1 0,0
Xsky130_fd_sc_hd__fill_8_2257
+ vss
+ vdd
+ vdd
+ sky130_fd_sc_hd__fill_8
* cell instance sky130_fd_sc_hd__fill_8_2258 r0 *1 0,0
Xsky130_fd_sc_hd__fill_8_2258
+ vss
+ vdd
+ vdd
+ sky130_fd_sc_hd__fill_8
* cell instance sky130_fd_sc_hd__fill_8_2259 r0 *1 0,0
Xsky130_fd_sc_hd__fill_8_2259
+ vss
+ vdd
+ vdd
+ sky130_fd_sc_hd__fill_8
* cell instance sky130_fd_sc_hd__fill_8_2260 r0 *1 0,0
Xsky130_fd_sc_hd__fill_8_2260
+ vss
+ vdd
+ vdd
+ sky130_fd_sc_hd__fill_8
* cell instance sky130_fd_sc_hd__fill_8_2261 r0 *1 0,0
Xsky130_fd_sc_hd__fill_8_2261
+ vss
+ vdd
+ vdd
+ sky130_fd_sc_hd__fill_8
* cell instance sky130_fd_sc_hd__fill_8_2262 r0 *1 0,0
Xsky130_fd_sc_hd__fill_8_2262
+ vss
+ vdd
+ vdd
+ sky130_fd_sc_hd__fill_8
* cell instance sky130_fd_sc_hd__fill_8_2263 r0 *1 0,0
Xsky130_fd_sc_hd__fill_8_2263
+ vss
+ vdd
+ vdd
+ sky130_fd_sc_hd__fill_8
* cell instance sky130_fd_sc_hd__fill_8_2264 r0 *1 0,0
Xsky130_fd_sc_hd__fill_8_2264
+ vss
+ vdd
+ vdd
+ sky130_fd_sc_hd__fill_8
* cell instance sky130_fd_sc_hd__fill_8_2265 r0 *1 0,0
Xsky130_fd_sc_hd__fill_8_2265
+ vss
+ vdd
+ vdd
+ sky130_fd_sc_hd__fill_8
* cell instance sky130_fd_sc_hd__fill_8_2266 r0 *1 0,0
Xsky130_fd_sc_hd__fill_8_2266
+ vss
+ vdd
+ vdd
+ sky130_fd_sc_hd__fill_8
* cell instance sky130_fd_sc_hd__fill_8_2267 r0 *1 0,0
Xsky130_fd_sc_hd__fill_8_2267
+ vss
+ vdd
+ vdd
+ sky130_fd_sc_hd__fill_8
* cell instance sky130_fd_sc_hd__inv_1_0 r0 *1 0,0
Xsky130_fd_sc_hd__inv_1_0 \$2409
+ vss
+ vdd
+ vdd
+ \$3270 sky130_fd_sc_hd__inv_1
* cell instance sky130_fd_sc_hd__inv_1_1 r0 *1 0,0
Xsky130_fd_sc_hd__inv_1_1 \$4479
+ vss
+ vdd
+ vdd
+ \$4480 sky130_fd_sc_hd__inv_1
* cell instance sky130_fd_sc_hd__inv_1_2 r0 *1 0,0
Xsky130_fd_sc_hd__inv_1_2 \$4478
+ vss
+ vdd
+ vdd
+ \$5411 sky130_fd_sc_hd__inv_1
* cell instance sky130_fd_sc_hd__inv_1_3 r0 *1 0,0
Xsky130_fd_sc_hd__inv_1_3 \$2739
+ vss
+ vdd
+ vdd
+ \$3277 sky130_fd_sc_hd__inv_1
* cell instance sky130_fd_sc_hd__inv_1_4 r0 *1 0,0
Xsky130_fd_sc_hd__inv_1_4 \$5634
+ vss
+ vdd
+ vdd
+ \$5971 sky130_fd_sc_hd__inv_1
* cell instance sky130_fd_sc_hd__inv_1_5 r0 *1 0,0
Xsky130_fd_sc_hd__inv_1_5 \$4254
+ vss
+ vdd
+ vdd
+ \$4253 sky130_fd_sc_hd__inv_1
* cell instance sky130_fd_sc_hd__inv_1_6 r0 *1 0,0
Xsky130_fd_sc_hd__inv_1_6 \$3279
+ vss
+ vdd
+ vdd
+ \$3167 sky130_fd_sc_hd__inv_1
* cell instance sky130_fd_sc_hd__inv_1_7 r0 *1 0,0
Xsky130_fd_sc_hd__inv_1_7 \$3680
+ vss
+ vdd
+ vdd
+ \$3463 sky130_fd_sc_hd__inv_1
* cell instance sky130_fd_sc_hd__inv_1_8 r0 *1 0,0
Xsky130_fd_sc_hd__inv_1_8 \$2869
+ vss
+ vdd
+ vdd
+ \$2744 sky130_fd_sc_hd__inv_1
* cell instance sky130_fd_sc_hd__inv_1_9 r0 *1 0,0
Xsky130_fd_sc_hd__inv_1_9 \$2747
+ vss
+ vdd
+ vdd
+ \$2423 sky130_fd_sc_hd__inv_1
* cell instance sky130_fd_sc_hd__inv_1_10 r0 *1 0,0
Xsky130_fd_sc_hd__inv_1_10 \$3584
+ vss
+ vdd
+ vdd
+ \$3685 sky130_fd_sc_hd__inv_1
* cell instance sky130_fd_sc_hd__inv_1_11 r0 *1 0,0
Xsky130_fd_sc_hd__inv_1_11 \$4734
+ vss
+ vdd
+ vdd
+ \$5316 sky130_fd_sc_hd__inv_1
* cell instance sky130_fd_sc_hd__inv_1_12 r0 *1 0,0
Xsky130_fd_sc_hd__inv_1_12 \$5986
+ vss
+ vdd
+ vdd
+ \$5762 sky130_fd_sc_hd__inv_1
* cell instance sky130_fd_sc_hd__inv_1_13 r0 *1 0,0
Xsky130_fd_sc_hd__inv_1_13 \$1735
+ vss
+ vdd
+ vdd
+ \$2528 sky130_fd_sc_hd__inv_1
* cell instance sky130_fd_sc_hd__inv_1_14 r0 *1 0,0
Xsky130_fd_sc_hd__inv_1_14 \$5165
+ vss
+ vdd
+ vdd
+ \$5417 sky130_fd_sc_hd__inv_1
* cell instance sky130_fd_sc_hd__inv_1_15 r0 *1 0,0
Xsky130_fd_sc_hd__inv_1_15 \$1400
+ vss
+ vdd
+ vdd
+ \$1845 sky130_fd_sc_hd__inv_1
* cell instance sky130_fd_sc_hd__inv_1_16 r0 *1 0,0
Xsky130_fd_sc_hd__inv_1_16 \$3811
+ vss
+ vdd
+ vdd
+ \$4375 sky130_fd_sc_hd__inv_1
* cell instance sky130_fd_sc_hd__inv_1_17 r0 *1 0,0
Xsky130_fd_sc_hd__inv_1_17 \$7508
+ vss
+ vdd
+ vdd
+ \$7424 sky130_fd_sc_hd__inv_1
* cell instance sky130_fd_sc_hd__inv_1_18 r0 *1 0,0
Xsky130_fd_sc_hd__inv_1_18 \$6408
+ vss
+ vdd
+ vdd
+ \$6407 sky130_fd_sc_hd__inv_1
* cell instance sky130_fd_sc_hd__inv_1_19 r0 *1 0,0
Xsky130_fd_sc_hd__inv_1_19 \$6760
+ vss
+ vdd
+ vdd
+ \$6926 sky130_fd_sc_hd__inv_1
* cell instance sky130_fd_sc_hd__inv_1_20 r0 *1 0,0
Xsky130_fd_sc_hd__inv_1_20 \$4521
+ vss
+ vdd
+ vdd
+ \$4741 sky130_fd_sc_hd__inv_1
* cell instance sky130_fd_sc_hd__inv_1_21 r0 *1 0,0
Xsky130_fd_sc_hd__inv_1_21 \$5550
+ vss
+ vdd
+ vdd
+ \$5427 sky130_fd_sc_hd__inv_1
* cell instance sky130_fd_sc_hd__inv_1_22 r0 *1 0,0
Xsky130_fd_sc_hd__inv_1_22 \$7191
+ vss
+ vdd
+ vdd
+ \$7110 sky130_fd_sc_hd__inv_1
* cell instance sky130_fd_sc_hd__inv_1_23 r0 *1 0,0
Xsky130_fd_sc_hd__inv_1_23 \$1005
+ vss
+ vdd
+ vdd
+ \$1217 sky130_fd_sc_hd__inv_1
* cell instance sky130_fd_sc_hd__inv_1_24 r0 *1 0,0
Xsky130_fd_sc_hd__inv_1_24 \$6922
+ vss
+ vdd
+ vdd
+ \$7425 sky130_fd_sc_hd__inv_1
* cell instance sky130_fd_sc_hd__inv_1_25 r0 *1 0,0
Xsky130_fd_sc_hd__inv_1_25 \$5082
+ vss
+ vdd
+ vdd
+ \$5083 sky130_fd_sc_hd__inv_1
* cell instance sky130_fd_sc_hd__inv_1_26 r0 *1 0,0
Xsky130_fd_sc_hd__inv_1_26 \$5428
+ vss
+ vdd
+ vdd
+ \$5552 sky130_fd_sc_hd__inv_1
* cell instance sky130_fd_sc_hd__inv_1_27 r0 *1 0,0
Xsky130_fd_sc_hd__inv_1_27 \$2981
+ vss
+ vdd
+ vdd
+ \$3829 sky130_fd_sc_hd__inv_1
* cell instance sky130_fd_sc_hd__inv_1_28 r0 *1 0,0
Xsky130_fd_sc_hd__inv_1_28 \$5434
+ vss
+ vdd
+ vdd
+ \$5167 sky130_fd_sc_hd__inv_1
* cell instance sky130_fd_sc_hd__inv_1_29 r0 *1 0,0
Xsky130_fd_sc_hd__inv_1_29 \$6207
+ vss
+ vdd
+ vdd
+ \$6416 sky130_fd_sc_hd__inv_1
* cell instance sky130_fd_sc_hd__inv_1_30 r0 *1 0,0
Xsky130_fd_sc_hd__inv_1_30 \$6123
+ vss
+ vdd
+ vdd
+ \$6217 sky130_fd_sc_hd__inv_1
* cell instance sky130_fd_sc_hd__inv_1_31 r0 *1 0,0
Xsky130_fd_sc_hd__inv_1_31 \$7602
+ vss
+ vdd
+ vdd
+ \$7521 sky130_fd_sc_hd__inv_1
* cell instance sky130_fd_sc_hd__inv_1_32 r0 *1 0,0
Xsky130_fd_sc_hd__inv_1_32 \$6850
+ vss
+ vdd
+ vdd
+ \$7431 sky130_fd_sc_hd__inv_1
* cell instance sky130_fd_sc_hd__inv_1_33 r0 *1 0,0
Xsky130_fd_sc_hd__inv_1_33 \$2545
+ vss
+ vdd
+ vdd
+ \$3070 sky130_fd_sc_hd__inv_1
* cell instance sky130_fd_sc_hd__inv_1_34 r0 *1 0,0
Xsky130_fd_sc_hd__inv_1_34 \$5566
+ vss
+ vdd
+ vdd
+ \$5567 sky130_fd_sc_hd__inv_1
* cell instance sky130_fd_sc_hd__inv_1_35 r0 *1 0,0
Xsky130_fd_sc_hd__inv_1_35 \$6944
+ vss
+ vdd
+ vdd
+ \$6945 sky130_fd_sc_hd__inv_1
* cell instance sky130_fd_sc_hd__inv_1_36 r0 *1 0,0
Xsky130_fd_sc_hd__inv_1_36 \$5099
+ vss
+ vdd
+ vdd
+ \$5784 sky130_fd_sc_hd__inv_1
* cell instance sky130_fd_sc_hd__inv_1_37 r0 *1 0,0
Xsky130_fd_sc_hd__inv_1_37 \$7917
+ vss
+ vdd
+ vdd
+ \$7828 sky130_fd_sc_hd__inv_1
* cell instance sky130_fd_sc_hd__inv_1_38 r0 *1 0,0
Xsky130_fd_sc_hd__inv_1_38 \$6863
+ vss
+ vdd
+ vdd
+ \$7220 sky130_fd_sc_hd__inv_1
* cell instance sky130_fd_sc_hd__inv_1_39 r0 *1 0,0
Xsky130_fd_sc_hd__inv_1_39 \$5785
+ vss
+ vdd
+ vdd
+ \$5837 sky130_fd_sc_hd__inv_1
* cell instance sky130_fd_sc_hd__inv_1_40 r0 *1 0,0
Xsky130_fd_sc_hd__inv_1_40 \$233
+ vss
+ vdd
+ vdd
+ \$299 sky130_fd_sc_hd__inv_1
* cell instance sky130_fd_sc_hd__inv_1_41 r0 *1 0,0
Xsky130_fd_sc_hd__inv_1_41 \$7441
+ vss
+ vdd
+ vdd
+ \$7760 sky130_fd_sc_hd__inv_1
* cell instance sky130_fd_sc_hd__inv_1_42 r0 *1 0,0
Xsky130_fd_sc_hd__inv_1_42 \$5896
+ vss
+ vdd
+ vdd
+ \$6229 sky130_fd_sc_hd__inv_1
* cell instance sky130_fd_sc_hd__inv_1_43 r0 *1 0,0
Xsky130_fd_sc_hd__inv_1_43 \$7033
+ vss
+ vdd
+ vdd
+ \$7034 sky130_fd_sc_hd__inv_1
* cell instance sky130_fd_sc_hd__inv_1_44 r0 *1 0,0
Xsky130_fd_sc_hd__inv_1_44 \$6431
+ vss
+ vdd
+ vdd
+ \$6786 sky130_fd_sc_hd__inv_1
* cell instance sky130_fd_sc_hd__inv_1_45 r0 *1 0,0
Xsky130_fd_sc_hd__inv_1_45 \$6700
+ vss
+ vdd
+ vdd
+ \$6787 sky130_fd_sc_hd__inv_1
* cell instance sky130_fd_sc_hd__inv_1_46 r0 *1 0,0
Xsky130_fd_sc_hd__inv_1_46 \$4301
+ vss
+ vdd
+ vdd
+ \$4806 sky130_fd_sc_hd__inv_1
* cell instance sky130_fd_sc_hd__inv_1_47 r0 *1 0,0
Xsky130_fd_sc_hd__inv_1_47 \$5357
+ vss
+ vdd
+ vdd
+ \$5358 sky130_fd_sc_hd__inv_1
* cell instance sky130_fd_sc_hd__inv_1_48 r0 *1 0,0
Xsky130_fd_sc_hd__inv_1_48 \$2567
+ vss
+ vdd
+ vdd
+ \$3317 sky130_fd_sc_hd__inv_1
* cell instance sky130_fd_sc_hd__inv_1_49 r0 *1 0,0
Xsky130_fd_sc_hd__inv_1_49 \$1173
+ vss
+ vdd
+ vdd
+ \$1670 sky130_fd_sc_hd__inv_1
* cell instance sky130_fd_sc_hd__inv_1_50 r0 *1 0,0
Xsky130_fd_sc_hd__inv_1_50 \$6451
+ vss
+ vdd
+ vdd
+ \$6331 sky130_fd_sc_hd__inv_1
* cell instance sky130_fd_sc_hd__inv_1_51 r0 *1 0,0
Xsky130_fd_sc_hd__inv_1_51 \$7849
+ vss
+ vdd
+ vdd
+ \$7932 sky130_fd_sc_hd__inv_1
* cell instance sky130_fd_sc_hd__inv_1_52 r0 *1 0,0
Xsky130_fd_sc_hd__inv_1_52 \$40
+ vss
+ vdd
+ vdd
+ \$599 sky130_fd_sc_hd__inv_1
* cell instance sky130_fd_sc_hd__inv_1_53 r0 *1 0,0
Xsky130_fd_sc_hd__inv_1_53 \$3259
+ vss
+ vdd
+ vdd
+ \$3513 sky130_fd_sc_hd__inv_1
* cell instance sky130_fd_sc_hd__inv_1_54 r0 *1 0,0
Xsky130_fd_sc_hd__inv_1_54 \$7626
+ vss
+ vdd
+ vdd
+ \$7697 sky130_fd_sc_hd__inv_1
* cell instance sky130_fd_sc_hd__inv_1_55 r0 *1 0,0
Xsky130_fd_sc_hd__inv_1_55 \$5246
+ vss
+ vdd
+ vdd
+ \$5247 sky130_fd_sc_hd__inv_1
* cell instance sky130_fd_sc_hd__inv_1_56 r0 *1 0,0
Xsky130_fd_sc_hd__inv_1_56 \$6714
+ vss
+ vdd
+ vdd
+ \$6799 sky130_fd_sc_hd__inv_1
* cell instance sky130_fd_sc_hd__inv_1_57 r0 *1 0,0
Xsky130_fd_sc_hd__inv_1_57 \$5248
+ vss
+ vdd
+ vdd
+ \$5702 sky130_fd_sc_hd__inv_1
* cell instance sky130_fd_sc_hd__inv_1_58 r0 *1 0,0
Xsky130_fd_sc_hd__inv_1_58 \$6717
+ vss
+ vdd
+ vdd
+ \$6800 sky130_fd_sc_hd__inv_1
* cell instance sky130_fd_sc_hd__inv_1_59 r0 *1 0,0
Xsky130_fd_sc_hd__inv_1_59 \$7463
+ vss
+ vdd
+ vdd
+ \$7464 sky130_fd_sc_hd__inv_1
* cell instance sky130_fd_sc_hd__inv_1_60 r0 *1 0,0
Xsky130_fd_sc_hd__inv_1_60 \$7305
+ vss
+ vdd
+ vdd
+ \$7702 sky130_fd_sc_hd__inv_1
* cell instance sky130_fd_sc_hd__inv_1_61 r0 *1 0,0
Xsky130_fd_sc_hd__inv_1_61 \$7936
+ vss
+ vdd
+ vdd
+ \$7937 sky130_fd_sc_hd__inv_1
* cell instance sky130_fd_sc_hd__inv_1_62 r0 *1 0,0
Xsky130_fd_sc_hd__inv_1_62 \$4995
+ vss
+ vdd
+ vdd
+ \$4998 sky130_fd_sc_hd__inv_1
* cell instance sky130_fd_sc_hd__inv_1_63 r0 *1 0,0
Xsky130_fd_sc_hd__inv_1_63 \$3351
+ vss
+ vdd
+ vdd
+ \$3736 sky130_fd_sc_hd__inv_1
* cell instance sky130_fd_sc_hd__inv_1_64 r0 *1 0,0
Xsky130_fd_sc_hd__inv_1_64 \$6633
+ vss
+ vdd
+ vdd
+ \$7067 sky130_fd_sc_hd__inv_1
* cell instance sky130_fd_sc_hd__inv_1_65 r0 *1 0,0
Xsky130_fd_sc_hd__inv_1_65 \$59
+ vss
+ vdd
+ vdd
+ \$125 sky130_fd_sc_hd__inv_1
* cell instance sky130_fd_sc_hd__inv_1_66 r0 *1 0,0
Xsky130_fd_sc_hd__inv_1_66 \$3010
+ vss
+ vdd
+ vdd
+ \$3657 sky130_fd_sc_hd__inv_1
* cell instance sky130_fd_sc_hd__inv_1_67 r0 *1 0,0
Xsky130_fd_sc_hd__inv_1_67 \$673
+ vss
+ vdd
+ vdd
+ \$1029 sky130_fd_sc_hd__inv_1
* cell instance sky130_fd_sc_hd__inv_1_68 r0 *1 0,0
Xsky130_fd_sc_hd__inv_1_68 \$4421
+ vss
+ vdd
+ vdd
+ \$4887 sky130_fd_sc_hd__inv_1
* cell instance sky130_fd_sc_hd__inv_1_69 r0 *1 0,0
Xsky130_fd_sc_hd__inv_1_69 \$3240
+ vss
+ vdd
+ vdd
+ \$3737 sky130_fd_sc_hd__inv_1
* cell instance sky130_fd_sc_hd__inv_1_70 r0 *1 0,0
Xsky130_fd_sc_hd__inv_1_70 \$6321
+ vss
+ vdd
+ vdd
+ \$6725 sky130_fd_sc_hd__inv_1
* cell instance sky130_fd_sc_hd__inv_1_71 r0 *1 0,0
Xsky130_fd_sc_hd__inv_1_71 \$7872
+ vss
+ vdd
+ vdd
+ \$7873 sky130_fd_sc_hd__inv_1
* cell instance sky130_fd_sc_hd__inv_1_72 r0 *1 0,0
Xsky130_fd_sc_hd__inv_1_72 \$6724
+ vss
+ vdd
+ vdd
+ \$6890 sky130_fd_sc_hd__inv_1
* cell instance sky130_fd_sc_hd__inv_1_73 r0 *1 0,0
Xsky130_fd_sc_hd__inv_1_73 \$5139
+ vss
+ vdd
+ vdd
+ \$5140 sky130_fd_sc_hd__inv_1
* cell instance sky130_fd_sc_hd__inv_1_74 r0 *1 0,0
Xsky130_fd_sc_hd__inv_1_74 \$7333
+ vss
+ vdd
+ vdd
+ \$7403 sky130_fd_sc_hd__inv_1
* cell instance sky130_fd_sc_hd__inv_1_75 r0 *1 0,0
Xsky130_fd_sc_hd__inv_1_75 \$6060
+ vss
+ vdd
+ vdd
+ \$6154 sky130_fd_sc_hd__inv_1
* cell instance sky130_fd_sc_hd__inv_1_76 r0 *1 0,0
Xsky130_fd_sc_hd__inv_1_76 \$3862
+ vss
+ vdd
+ vdd
+ \$4427 sky130_fd_sc_hd__inv_1
* cell instance sky130_fd_sc_hd__inv_1_77 r0 *1 0,0
Xsky130_fd_sc_hd__inv_1_77 \$6068
+ vss
+ vdd
+ vdd
+ \$6155 sky130_fd_sc_hd__inv_1
* cell instance sky130_fd_sc_hd__inv_1_78 r0 *1 0,0
Xsky130_fd_sc_hd__inv_1_78 \$6454
+ vss
+ vdd
+ vdd
+ \$6732 sky130_fd_sc_hd__inv_1
* cell instance sky130_fd_sc_hd__inv_1_79 r0 *1 0,0
Xsky130_fd_sc_hd__inv_1_79 \$7078
+ vss
+ vdd
+ vdd
+ \$7339 sky130_fd_sc_hd__inv_1
* cell instance sky130_fd_sc_hd__inv_1_80 r0 *1 0,0
Xsky130_fd_sc_hd__inv_1_80 \$5390
+ vss
+ vdd
+ vdd
+ \$5391 sky130_fd_sc_hd__inv_1
* cell instance sky130_fd_sc_hd__inv_1_81 r0 *1 0,0
Xsky130_fd_sc_hd__inv_1_81 \$7725
+ vss
+ vdd
+ vdd
+ \$7887 sky130_fd_sc_hd__inv_1
* cell instance sky130_fd_sc_hd__inv_1_82 r0 *1 0,0
Xsky130_fd_sc_hd__inv_1_82 \$6088
+ vss
+ vdd
+ vdd
+ \$6158 sky130_fd_sc_hd__inv_1
* cell instance sky130_fd_sc_hd__inv_1_83 r0 *1 0,0
Xsky130_fd_sc_hd__inv_1_83 \$7574
+ vss
+ vdd
+ vdd
+ \$7575 sky130_fd_sc_hd__inv_1
* cell instance sky130_fd_sc_hd__inv_1_84 r0 *1 0,0
Xsky130_fd_sc_hd__inv_1_84 \$79
+ vss
+ vdd
+ vdd
+ \$482 sky130_fd_sc_hd__inv_1
* cell instance sky130_fd_sc_hd__inv_1_85 r0 *1 0,0
Xsky130_fd_sc_hd__inv_1_85 \$6469
+ vss
+ vdd
+ vdd
+ \$6735 sky130_fd_sc_hd__inv_1
* cell instance sky130_fd_sc_hd__inv_1_86 r0 *1 0,0
Xsky130_fd_sc_hd__inv_1_86 \$1698
+ vss
+ vdd
+ vdd
+ \$1909 sky130_fd_sc_hd__inv_1
* cell instance sky130_fd_sc_hd__inv_1_87 r0 *1 0,0
Xsky130_fd_sc_hd__inv_1_87 \$4685
+ vss
+ vdd
+ vdd
+ \$5012 sky130_fd_sc_hd__inv_1
* cell instance sky130_fd_sc_hd__inv_1_88 r0 *1 0,0
Xsky130_fd_sc_hd__inv_1_88 \$5616
+ vss
+ vdd
+ vdd
+ \$5729 sky130_fd_sc_hd__inv_1
* cell instance sky130_fd_sc_hd__inv_1_89 r0 *1 0,0
Xsky130_fd_sc_hd__inv_1_89 \$851
+ vss
+ vdd
+ vdd
+ \$1124 sky130_fd_sc_hd__inv_1
* cell instance sky130_fd_sc_hd__inv_1_90 r0 *1 0,0
Xsky130_fd_sc_hd__inv_1_90 \$2491
+ vss
+ vdd
+ vdd
+ \$3250 sky130_fd_sc_hd__inv_1
* cell instance sky130_fd_sc_hd__inv_1_91 r0 *1 0,0
Xsky130_fd_sc_hd__inv_1_91 \$3721
+ vss
+ vdd
+ vdd
+ alarm sky130_fd_sc_hd__inv_1
* cell instance sky130_fd_sc_hd__inv_1_92 r0 *1 0,0
Xsky130_fd_sc_hd__inv_1_92 \$1992
+ vss
+ vdd
+ vdd
+ out_valid sky130_fd_sc_hd__inv_1
* cell instance sky130_fd_sc_hd__inv_1_93 r0 *1 0,0
Xsky130_fd_sc_hd__inv_1_93 \$6662
+ vss
+ vdd
+ vdd
+ \$6668 sky130_fd_sc_hd__inv_1
* cell instance sky130_fd_sc_hd__inv_1_94 r0 *1 0,0
Xsky130_fd_sc_hd__inv_1_94 \$7273
+ vss
+ vdd
+ vdd
+ \$7421 sky130_fd_sc_hd__inv_1
* cell instance sky130_fd_sc_hd__inv_1_95 r0 *1 0,0
Xsky130_fd_sc_hd__inv_1_95 \$7897
+ vss
+ vdd
+ vdd
+ \$7903 sky130_fd_sc_hd__inv_1
* cell instance sky130_fd_sc_hd__inv_4_0 r0 *1 0,0
Xsky130_fd_sc_hd__inv_4_0 \$1208
+ vss
+ vdd
+ vdd
+ \$1562 sky130_fd_sc_hd__inv_4
* cell instance sky130_fd_sc_hd__mux2_2_0 r0 *1 0,0
Xsky130_fd_sc_hd__mux2_2_0 \$3958 \$3845 \$4206
+ vss
+ vdd
+ vdd
+ \$3840 sky130_fd_sc_hd__mux2_2
* cell instance sky130_fd_sc_hd__mux2_2_1 r0 *1 0,0
Xsky130_fd_sc_hd__mux2_2_1 \$4087 \$4085 \$4206
+ vss
+ vdd
+ vdd
+ \$4082 sky130_fd_sc_hd__mux2_2
* cell instance sky130_fd_sc_hd__mux2_2_2 r0 *1 0,0
Xsky130_fd_sc_hd__mux2_2_2 \$2351 \$3728 \$3619
+ vss
+ vdd
+ vdd
+ \$1992 sky130_fd_sc_hd__mux2_2
* cell instance sky130_fd_sc_hd__mux2_2_3 r0 *1 0,0
Xsky130_fd_sc_hd__mux2_2_3 \$2353 \$2618 \$2569
+ vss
+ vdd
+ vdd
+ \$2273 sky130_fd_sc_hd__mux2_2
* cell instance sky130_fd_sc_hd__mux2_2_4 r0 *1 0,0
Xsky130_fd_sc_hd__mux2_2_4 bus_wdata[0] \$3093 \$3318
+ vss
+ vdd
+ vdd
+ \$3327 sky130_fd_sc_hd__mux2_2
* cell instance sky130_fd_sc_hd__mux2_2_5 r0 *1 0,0
Xsky130_fd_sc_hd__mux2_2_5 \$658 \$528 \$182
+ vss
+ vdd
+ vdd
+ \$662 sky130_fd_sc_hd__mux2_2
* cell instance sky130_fd_sc_hd__mux2_2_6 r0 *1 0,0
Xsky130_fd_sc_hd__mux2_2_6 \$257 \$254 \$182
+ vss
+ vdd
+ vdd
+ \$259 sky130_fd_sc_hd__mux2_2
* cell instance sky130_fd_sc_hd__mux2_2_7 r0 *1 0,0
Xsky130_fd_sc_hd__mux2_2_7 \$261 \$192 \$182
+ vss
+ vdd
+ vdd
+ \$263 sky130_fd_sc_hd__mux2_2
* cell instance sky130_fd_sc_hd__mux2_2_8 r0 *1 0,0
Xsky130_fd_sc_hd__mux2_2_8 \$1185 \$830 \$182
+ vss
+ vdd
+ vdd
+ \$1114 sky130_fd_sc_hd__mux2_2
* cell instance sky130_fd_sc_hd__mux2_2_9 r0 *1 0,0
Xsky130_fd_sc_hd__mux2_2_9 \$266 \$68 \$182
+ vss
+ vdd
+ vdd
+ \$128 sky130_fd_sc_hd__mux2_2
* cell instance sky130_fd_sc_hd__mux2_2_10 r0 *1 0,0
Xsky130_fd_sc_hd__mux2_2_10 \$1193 \$1190 \$182
+ vss
+ vdd
+ vdd
+ \$909 sky130_fd_sc_hd__mux2_2
* cell instance sky130_fd_sc_hd__mux2_2_11 r0 *1 0,0
Xsky130_fd_sc_hd__mux2_2_11 \$270 \$198 \$182
+ vss
+ vdd
+ vdd
+ \$202 sky130_fd_sc_hd__mux2_2
* cell instance sky130_fd_sc_hd__mux2_2_12 r0 *1 0,0
Xsky130_fd_sc_hd__mux2_2_12 \$483 \$273 \$182
+ vss
+ vdd
+ vdd
+ \$138 sky130_fd_sc_hd__mux2_2
* cell instance sky130_fd_sc_hd__mux2_2_13 r0 *1 0,0
Xsky130_fd_sc_hd__mux2_2_13 \$276 \$204 \$182
+ vss
+ vdd
+ vdd
+ \$209 sky130_fd_sc_hd__mux2_2
* cell instance sky130_fd_sc_hd__mux2i_1_0 r0 *1 0,0
Xsky130_fd_sc_hd__mux2i_1_0 \$3694 \$3587 \$1561
+ vss
+ vdd
+ vdd
+ \$3695 sky130_fd_sc_hd__mux2i_1
* cell instance sky130_fd_sc_hd__mux2i_1_1 r0 *1 0,0
Xsky130_fd_sc_hd__mux2i_1_1 \$2016 \$1642 \$1561
+ vss
+ vdd
+ vdd
+ \$1937 sky130_fd_sc_hd__mux2i_1
* cell instance sky130_fd_sc_hd__mux2i_1_2 r0 *1 0,0
Xsky130_fd_sc_hd__mux2i_1_2 \$3186 \$2969 \$1561
+ vss
+ vdd
+ vdd
+ \$2880 sky130_fd_sc_hd__mux2i_1
* cell instance sky130_fd_sc_hd__mux2i_1_3 r0 *1 0,0
Xsky130_fd_sc_hd__mux2i_1_3 \$2533 \$2531 \$1561
+ vss
+ vdd
+ vdd
+ \$2437 sky130_fd_sc_hd__mux2i_1
* cell instance sky130_fd_sc_hd__mux2i_1_4 r0 *1 0,0
Xsky130_fd_sc_hd__mux2i_1_4 \$3816 \$3590 \$1561
+ vss
+ vdd
+ vdd
+ \$3815 sky130_fd_sc_hd__mux2i_1
* cell instance sky130_fd_sc_hd__mux2i_1_5 r0 *1 0,0
Xsky130_fd_sc_hd__mux2i_1_5 \$2133 \$2021 \$1561
+ vss
+ vdd
+ vdd
+ \$2323 sky130_fd_sc_hd__mux2i_1
* cell instance sky130_fd_sc_hd__mux2i_1_6 r0 *1 0,0
Xsky130_fd_sc_hd__mux2i_1_6 \$423 \$509 \$711
+ vss
+ vdd
+ vdd
+ \$786 sky130_fd_sc_hd__mux2i_1
* cell instance sky130_fd_sc_hd__mux2i_1_7 r0 *1 0,0
Xsky130_fd_sc_hd__mux2i_1_7 \$2656 \$2533 \$1561
+ vss
+ vdd
+ vdd
+ \$2655 sky130_fd_sc_hd__mux2i_1
* cell instance sky130_fd_sc_hd__mux2i_1_8 r0 *1 0,0
Xsky130_fd_sc_hd__mux2i_1_8 \$1940 \$2016 \$1561
+ vss
+ vdd
+ vdd
+ \$1745 sky130_fd_sc_hd__mux2i_1
* cell instance sky130_fd_sc_hd__mux2i_1_9 r0 *1 0,0
Xsky130_fd_sc_hd__mux2i_1_9 \$4180 \$3816 \$1561
+ vss
+ vdd
+ vdd
+ \$4281 sky130_fd_sc_hd__mux2i_1
* cell instance sky130_fd_sc_hd__mux2i_1_10 r0 *1 0,0
Xsky130_fd_sc_hd__mux2i_1_10 \$4053 \$3694 \$1561
+ vss
+ vdd
+ vdd
+ \$3707 sky130_fd_sc_hd__mux2i_1
* cell instance sky130_fd_sc_hd__mux2i_1_11 r0 *1 0,0
Xsky130_fd_sc_hd__mux2i_1_11 \$4614 \$4741 \$4802
+ vss
+ vdd
+ vdd
+ \$4284 sky130_fd_sc_hd__mux2i_1
* cell instance sky130_fd_sc_hd__mux2i_1_12 r0 *1 0,0
Xsky130_fd_sc_hd__mux2i_1_12 \$3060 \$3186 \$1561
+ vss
+ vdd
+ vdd
+ \$2979 sky130_fd_sc_hd__mux2i_1
* cell instance sky130_fd_sc_hd__mux2i_1_13 r0 *1 0,0
Xsky130_fd_sc_hd__mux2i_1_13 \$6304 \$6407 \$4802
+ vss
+ vdd
+ vdd
+ \$6303 sky130_fd_sc_hd__mux2i_1
* cell instance sky130_fd_sc_hd__mux2i_1_14 r0 *1 0,0
Xsky130_fd_sc_hd__mux2i_1_14 \$7284 \$7508 \$4299
+ vss
+ vdd
+ vdd
+ \$7514 sky130_fd_sc_hd__mux2i_1
* cell instance sky130_fd_sc_hd__mux2i_1_15 r0 *1 0,0
Xsky130_fd_sc_hd__mux2i_1_15 \$6303 \$6507 \$4299
+ vss
+ vdd
+ vdd
+ \$6511 sky130_fd_sc_hd__mux2i_1
* cell instance sky130_fd_sc_hd__mux2i_1_16 r0 *1 0,0
Xsky130_fd_sc_hd__mux2i_1_16 \$6507 \$6760 \$4299
+ vss
+ vdd
+ vdd
+ \$6687 sky130_fd_sc_hd__mux2i_1
* cell instance sky130_fd_sc_hd__mux2i_1_17 r0 *1 0,0
Xsky130_fd_sc_hd__mux2i_1_17 \$7194 \$7110 \$4802
+ vss
+ vdd
+ vdd
+ \$7114 sky130_fd_sc_hd__mux2i_1
* cell instance sky130_fd_sc_hd__mux2i_1_18 r0 *1 0,0
Xsky130_fd_sc_hd__mux2i_1_18 \$2035 \$2133 \$1561
+ vss
+ vdd
+ vdd
+ \$2034 sky130_fd_sc_hd__mux2i_1
* cell instance sky130_fd_sc_hd__mux2i_1_19 r0 *1 0,0
Xsky130_fd_sc_hd__mux2i_1_19 \$4744 \$5082 \$4299
+ vss
+ vdd
+ vdd
+ \$4846 sky130_fd_sc_hd__mux2i_1
* cell instance sky130_fd_sc_hd__mux2i_1_20 r0 *1 0,0
Xsky130_fd_sc_hd__mux2i_1_20 \$3709 \$3479 \$1561
+ vss
+ vdd
+ vdd
+ \$3650 sky130_fd_sc_hd__mux2i_1
* cell instance sky130_fd_sc_hd__mux2i_1_21 r0 *1 0,0
Xsky130_fd_sc_hd__mux2i_1_21 \$4284 \$4744 \$4299
+ vss
+ vdd
+ vdd
+ \$4619 sky130_fd_sc_hd__mux2i_1
* cell instance sky130_fd_sc_hd__mux2i_1_22 r0 *1 0,0
Xsky130_fd_sc_hd__mux2i_1_22 \$5329 \$5550 \$4299
+ vss
+ vdd
+ vdd
+ \$5433 sky130_fd_sc_hd__mux2i_1
* cell instance sky130_fd_sc_hd__mux2i_1_23 r0 *1 0,0
Xsky130_fd_sc_hd__mux2i_1_23 \$2971 \$6000 \$2057
+ vss
+ vdd
+ vdd
+ \$5774 sky130_fd_sc_hd__mux2i_1
* cell instance sky130_fd_sc_hd__mux2i_1_24 r0 *1 0,0
Xsky130_fd_sc_hd__mux2i_1_24 \$7114 \$7284 \$4299
+ vss
+ vdd
+ vdd
+ \$7202 sky130_fd_sc_hd__mux2i_1
* cell instance sky130_fd_sc_hd__mux2i_1_25 r0 *1 0,0
Xsky130_fd_sc_hd__mux2i_1_25 \$3613 \$6303 \$4299
+ vss
+ vdd
+ vdd
+ \$6008 sky130_fd_sc_hd__mux2i_1
* cell instance sky130_fd_sc_hd__mux2i_1_26 r0 *1 0,0
Xsky130_fd_sc_hd__mux2i_1_26 \$4050 \$6929 \$2057
+ vss
+ vdd
+ vdd
+ \$3063 sky130_fd_sc_hd__mux2i_1
* cell instance sky130_fd_sc_hd__mux2i_1_27 r0 *1 0,0
Xsky130_fd_sc_hd__mux2i_1_27 \$2982 \$2658 \$1561
+ vss
+ vdd
+ vdd
+ \$2986 sky130_fd_sc_hd__mux2i_1
* cell instance sky130_fd_sc_hd__mux2i_1_28 r0 *1 0,0
Xsky130_fd_sc_hd__mux2i_1_28 \$4242 \$4284 \$4299
+ vss
+ vdd
+ vdd
+ \$4285 sky130_fd_sc_hd__mux2i_1
* cell instance sky130_fd_sc_hd__mux2i_1_29 r0 *1 0,0
Xsky130_fd_sc_hd__mux2i_1_29 \$3828 \$3709 \$1561
+ vss
+ vdd
+ vdd
+ \$3936 sky130_fd_sc_hd__mux2i_1
* cell instance sky130_fd_sc_hd__mux2i_1_30 r0 *1 0,0
Xsky130_fd_sc_hd__mux2i_1_30 \$5087 \$5167 \$4802
+ vss
+ vdd
+ vdd
+ \$5089 sky130_fd_sc_hd__mux2i_1
* cell instance sky130_fd_sc_hd__mux2i_1_31 r0 *1 0,0
Xsky130_fd_sc_hd__mux2i_1_31 \$4577 \$7114 \$4299
+ vss
+ vdd
+ vdd
+ \$7120 sky130_fd_sc_hd__mux2i_1
* cell instance sky130_fd_sc_hd__mux2i_1_32 r0 *1 0,0
Xsky130_fd_sc_hd__mux2i_1_32 \$5089 \$5329 \$4299
+ vss
+ vdd
+ vdd
+ \$5224 sky130_fd_sc_hd__mux2i_1
* cell instance sky130_fd_sc_hd__mux2i_1_33 r0 *1 0,0
Xsky130_fd_sc_hd__mux2i_1_33 \$4178 \$5621 \$2057
+ vss
+ vdd
+ vdd
+ \$5708 sky130_fd_sc_hd__mux2i_1
* cell instance sky130_fd_sc_hd__mux2i_1_34 r0 *1 0,0
Xsky130_fd_sc_hd__mux2i_1_34 \$2989 \$2982 \$1561
+ vss
+ vdd
+ vdd
+ \$2889 sky130_fd_sc_hd__mux2i_1
* cell instance sky130_fd_sc_hd__mux2i_1_35 r0 *1 0,0
Xsky130_fd_sc_hd__mux2i_1_35 \$5882 \$6209 \$5547
+ vss
+ vdd
+ vdd
+ \$6123 sky130_fd_sc_hd__mux2i_1
* cell instance sky130_fd_sc_hd__mux2i_1_36 r0 *1 0,0
Xsky130_fd_sc_hd__mux2i_1_36 \$5882 \$6594 \$5325
+ vss
+ vdd
+ vdd
+ \$6309 sky130_fd_sc_hd__mux2i_1
* cell instance sky130_fd_sc_hd__mux2i_1_37 r0 *1 0,0
Xsky130_fd_sc_hd__mux2i_1_37 \$5882 \$5621 \$4302
+ vss
+ vdd
+ vdd
+ \$5881 sky130_fd_sc_hd__mux2i_1
* cell instance sky130_fd_sc_hd__mux2i_1_38 r0 *1 0,0
Xsky130_fd_sc_hd__mux2i_1_38 \$7367 \$7904 \$5325
+ vss
+ vdd
+ vdd
+ \$7290 sky130_fd_sc_hd__mux2i_1
* cell instance sky130_fd_sc_hd__mux2i_1_39 r0 *1 0,0
Xsky130_fd_sc_hd__mux2i_1_39 \$7367 \$7601 \$5547
+ vss
+ vdd
+ vdd
+ \$7602 sky130_fd_sc_hd__mux2i_1
* cell instance sky130_fd_sc_hd__mux2i_1_40 r0 *1 0,0
Xsky130_fd_sc_hd__mux2i_1_40 \$6013 \$5882 \$4802
+ vss
+ vdd
+ vdd
+ \$5883 sky130_fd_sc_hd__mux2i_1
* cell instance sky130_fd_sc_hd__mux2i_1_41 r0 *1 0,0
Xsky130_fd_sc_hd__mux2i_1_41 \$7746 \$7367 \$4802
+ vss
+ vdd
+ vdd
+ \$7292 sky130_fd_sc_hd__mux2i_1
* cell instance sky130_fd_sc_hd__mux2i_1_42 r0 *1 0,0
Xsky130_fd_sc_hd__mux2i_1_42 \$6309 \$6123 \$4299
+ vss
+ vdd
+ vdd
+ \$6421 sky130_fd_sc_hd__mux2i_1
* cell instance sky130_fd_sc_hd__mux2i_1_43 r0 *1 0,0
Xsky130_fd_sc_hd__mux2i_1_43 \$7292 \$7290 \$4299
+ vss
+ vdd
+ vdd
+ \$7296 sky130_fd_sc_hd__mux2i_1
* cell instance sky130_fd_sc_hd__mux2i_1_44 r0 *1 0,0
Xsky130_fd_sc_hd__mux2i_1_44 \$5881 \$5883 \$4299
+ vss
+ vdd
+ vdd
+ \$5560 sky130_fd_sc_hd__mux2i_1
* cell instance sky130_fd_sc_hd__mux2i_1_45 r0 *1 0,0
Xsky130_fd_sc_hd__mux2i_1_45 \$5883 \$6309 \$4299
+ vss
+ vdd
+ vdd
+ \$6128 sky130_fd_sc_hd__mux2i_1
* cell instance sky130_fd_sc_hd__mux2i_1_46 r0 *1 0,0
Xsky130_fd_sc_hd__mux2i_1_46 \$7290 \$7602 \$4299
+ vss
+ vdd
+ vdd
+ \$7607 sky130_fd_sc_hd__mux2i_1
* cell instance sky130_fd_sc_hd__mux2i_1_47 r0 *1 0,0
Xsky130_fd_sc_hd__mux2i_1_47 \$3601 \$3488 \$1561
+ vss
+ vdd
+ vdd
+ \$3602 sky130_fd_sc_hd__mux2i_1
* cell instance sky130_fd_sc_hd__mux2i_1_48 r0 *1 0,0
Xsky130_fd_sc_hd__mux2i_1_48 \$3724 \$7292 \$4299
+ vss
+ vdd
+ vdd
+ \$7208 sky130_fd_sc_hd__mux2i_1
* cell instance sky130_fd_sc_hd__mux2i_1_49 r0 *1 0,0
Xsky130_fd_sc_hd__mux2i_1_49 \$5406 \$5562 \$5547
+ vss
+ vdd
+ vdd
+ \$5566 sky130_fd_sc_hd__mux2i_1
* cell instance sky130_fd_sc_hd__mux2i_1_50 r0 *1 0,0
Xsky130_fd_sc_hd__mux2i_1_50 \$5406 \$5168 \$5325
+ vss
+ vdd
+ vdd
+ \$5438 sky130_fd_sc_hd__mux2i_1
* cell instance sky130_fd_sc_hd__mux2i_1_51 r0 *1 0,0
Xsky130_fd_sc_hd__mux2i_1_51 \$7367 \$4193 \$4302
+ vss
+ vdd
+ vdd
+ \$3724 sky130_fd_sc_hd__mux2i_1
* cell instance sky130_fd_sc_hd__mux2i_1_52 r0 *1 0,0
Xsky130_fd_sc_hd__mux2i_1_52 \$3992 \$3601 \$1561
+ vss
+ vdd
+ vdd
+ \$4072 sky130_fd_sc_hd__mux2i_1
* cell instance sky130_fd_sc_hd__mux2i_1_53 r0 *1 0,0
Xsky130_fd_sc_hd__mux2i_1_53 \$2548 \$2444 \$1561
+ vss
+ vdd
+ vdd
+ \$2159 sky130_fd_sc_hd__mux2i_1
* cell instance sky130_fd_sc_hd__mux2i_1_54 r0 *1 0,0
Xsky130_fd_sc_hd__mux2i_1_54 \$6604 \$7018 \$5325
+ vss
+ vdd
+ vdd
+ \$6695 sky130_fd_sc_hd__mux2i_1
* cell instance sky130_fd_sc_hd__mux2i_1_55 r0 *1 0,0
Xsky130_fd_sc_hd__mux2i_1_55 \$3603 \$4193 \$2057
+ vss
+ vdd
+ vdd
+ \$4197 sky130_fd_sc_hd__mux2i_1
* cell instance sky130_fd_sc_hd__mux2i_1_56 r0 *1 0,0
Xsky130_fd_sc_hd__mux2i_1_56 \$5226 \$5406 \$4802
+ vss
+ vdd
+ vdd
+ \$5341 sky130_fd_sc_hd__mux2i_1
* cell instance sky130_fd_sc_hd__mux2i_1_57 r0 *1 0,0
Xsky130_fd_sc_hd__mux2i_1_57 \$2764 \$6422 \$2057
+ vss
+ vdd
+ vdd
+ \$5783 sky130_fd_sc_hd__mux2i_1
* cell instance sky130_fd_sc_hd__mux2i_1_58 r0 *1 0,0
Xsky130_fd_sc_hd__mux2i_1_58 \$6604 \$6939 \$5547
+ vss
+ vdd
+ vdd
+ \$6944 sky130_fd_sc_hd__mux2i_1
* cell instance sky130_fd_sc_hd__mux2i_1_59 r0 *1 0,0
Xsky130_fd_sc_hd__mux2i_1_59 \$5438 \$5566 \$4299
+ vss
+ vdd
+ vdd
+ \$5098 sky130_fd_sc_hd__mux2i_1
* cell instance sky130_fd_sc_hd__mux2i_1_60 r0 *1 0,0
Xsky130_fd_sc_hd__mux2i_1_60 \$6693 \$6604 \$4802
+ vss
+ vdd
+ vdd
+ \$6517 sky130_fd_sc_hd__mux2i_1
* cell instance sky130_fd_sc_hd__mux2i_1_61 r0 *1 0,0
Xsky130_fd_sc_hd__mux2i_1_61 \$6604 \$6422 \$4302
+ vss
+ vdd
+ vdd
+ \$2804 sky130_fd_sc_hd__mux2i_1
* cell instance sky130_fd_sc_hd__mux2i_1_62 r0 *1 0,0
Xsky130_fd_sc_hd__mux2i_1_62 \$6695 \$6944 \$4299
+ vss
+ vdd
+ vdd
+ \$6776 sky130_fd_sc_hd__mux2i_1
* cell instance sky130_fd_sc_hd__mux2i_1_63 r0 *1 0,0
Xsky130_fd_sc_hd__mux2i_1_63 \$3078 \$3072 \$1561
+ vss
+ vdd
+ vdd
+ \$3077 sky130_fd_sc_hd__mux2i_1
* cell instance sky130_fd_sc_hd__mux2i_1_64 r0 *1 0,0
Xsky130_fd_sc_hd__mux2i_1_64 \$3494 \$3078 \$1561
+ vss
+ vdd
+ vdd
+ \$3493 sky130_fd_sc_hd__mux2i_1
* cell instance sky130_fd_sc_hd__mux2i_1_65 r0 *1 0,0
Xsky130_fd_sc_hd__mux2i_1_65 \$5341 \$5438 \$4299
+ vss
+ vdd
+ vdd
+ \$5276 sky130_fd_sc_hd__mux2i_1
* cell instance sky130_fd_sc_hd__mux2i_1_66 r0 *1 0,0
Xsky130_fd_sc_hd__mux2i_1_66 \$7525 \$7209 \$5547
+ vss
+ vdd
+ vdd
+ \$7917 sky130_fd_sc_hd__mux2i_1
* cell instance sky130_fd_sc_hd__mux2i_1_67 r0 *1 0,0
Xsky130_fd_sc_hd__mux2i_1_67 \$2804 \$6517 \$4299
+ vss
+ vdd
+ vdd
+ \$6430 sky130_fd_sc_hd__mux2i_1
* cell instance sky130_fd_sc_hd__mux2i_1_68 r0 *1 0,0
Xsky130_fd_sc_hd__mux2i_1_68 \$6517 \$6695 \$4299
+ vss
+ vdd
+ vdd
+ \$6699 sky130_fd_sc_hd__mux2i_1
* cell instance sky130_fd_sc_hd__mux2i_1_69 r0 *1 0,0
Xsky130_fd_sc_hd__mux2i_1_69 \$2613 \$2548 \$1561
+ vss
+ vdd
+ vdd
+ \$2552 sky130_fd_sc_hd__mux2i_1
* cell instance sky130_fd_sc_hd__mux2i_1_70 r0 *1 0,0
Xsky130_fd_sc_hd__mux2i_1_70 \$7525 \$7680 \$5325
+ vss
+ vdd
+ vdd
+ \$7827 sky130_fd_sc_hd__mux2i_1
* cell instance sky130_fd_sc_hd__mux2i_1_71 r0 *1 0,0
Xsky130_fd_sc_hd__mux2i_1_71 \$294 \$509 \$510
+ vss
+ vdd
+ vdd
+ \$297 sky130_fd_sc_hd__mux2i_1
* cell instance sky130_fd_sc_hd__mux2i_1_72 r0 *1 0,0
Xsky130_fd_sc_hd__mux2i_1_72 \$3827 \$5444 \$2057
+ vss
+ vdd
+ vdd
+ \$5446 sky130_fd_sc_hd__mux2i_1
* cell instance sky130_fd_sc_hd__mux2i_1_73 r0 *1 0,0
Xsky130_fd_sc_hd__mux2i_1_73 \$7827 \$7917 \$4299
+ vss
+ vdd
+ vdd
+ \$7922 sky130_fd_sc_hd__mux2i_1
* cell instance sky130_fd_sc_hd__mux2i_1_74 r0 *1 0,0
Xsky130_fd_sc_hd__mux2i_1_74 \$5406 \$5170 \$4302
+ vss
+ vdd
+ vdd
+ \$2994 sky130_fd_sc_hd__mux2i_1
* cell instance sky130_fd_sc_hd__mux2i_1_75 r0 *1 0,0
Xsky130_fd_sc_hd__mux2i_1_75 \$2994 \$5341 \$4299
+ vss
+ vdd
+ vdd
+ \$5107 sky130_fd_sc_hd__mux2i_1
* cell instance sky130_fd_sc_hd__mux2i_1_76 r0 *1 0,0
Xsky130_fd_sc_hd__mux2i_1_76 \$7962 \$7525 \$4802
+ vss
+ vdd
+ vdd
+ \$7759 sky130_fd_sc_hd__mux2i_1
* cell instance sky130_fd_sc_hd__mux2i_1_77 r0 *1 0,0
Xsky130_fd_sc_hd__mux2i_1_77 \$7525 \$5444 \$4302
+ vss
+ vdd
+ vdd
+ \$4199 sky130_fd_sc_hd__mux2i_1
* cell instance sky130_fd_sc_hd__mux2i_1_78 r0 *1 0,0
Xsky130_fd_sc_hd__mux2i_1_78 \$7759 \$7827 \$4299
+ vss
+ vdd
+ vdd
+ \$7833 sky130_fd_sc_hd__mux2i_1
* cell instance sky130_fd_sc_hd__mux2i_1_79 r0 *1 0,0
Xsky130_fd_sc_hd__mux2i_1_79 \$6022 \$5837 \$4802
+ vss
+ vdd
+ vdd
+ \$6027 sky130_fd_sc_hd__mux2i_1
* cell instance sky130_fd_sc_hd__mux2i_1_80 r0 *1 0,0
Xsky130_fd_sc_hd__mux2i_1_80 \$4199 \$7759 \$4299
+ vss
+ vdd
+ vdd
+ \$7447 sky130_fd_sc_hd__mux2i_1
* cell instance sky130_fd_sc_hd__mux2i_1_81 r0 *1 0,0
Xsky130_fd_sc_hd__mux2i_1_81 \$5897 \$5896 \$4299
+ vss
+ vdd
+ vdd
+ \$5899 sky130_fd_sc_hd__mux2i_1
* cell instance sky130_fd_sc_hd__mux2i_1_82 r0 *1 0,0
Xsky130_fd_sc_hd__mux2i_1_82 \$509 \$170 \$640
+ vss
+ vdd
+ vdd
+ \$206 sky130_fd_sc_hd__mux2i_1
* cell instance sky130_fd_sc_hd__mux2i_1_83 r0 *1 0,0
Xsky130_fd_sc_hd__mux2i_1_83 \$2452 \$2257 \$1561
+ vss
+ vdd
+ vdd
+ \$2348 sky130_fd_sc_hd__mux2i_1
* cell instance sky130_fd_sc_hd__mux2i_1_84 r0 *1 0,0
Xsky130_fd_sc_hd__mux2i_1_84 \$2685 \$5089 \$4299
+ vss
+ vdd
+ vdd
+ \$5354 sky130_fd_sc_hd__mux2i_1
* cell instance sky130_fd_sc_hd__mux2i_1_85 r0 *1 0,0
Xsky130_fd_sc_hd__mux2i_1_85 \$6027 \$5897 \$4299
+ vss
+ vdd
+ vdd
+ \$6032 sky130_fd_sc_hd__mux2i_1
* cell instance sky130_fd_sc_hd__mux2i_1_86 r0 *1 0,0
Xsky130_fd_sc_hd__mux2i_1_86 \$2502 \$2452 \$1561
+ vss
+ vdd
+ vdd
+ \$2556 sky130_fd_sc_hd__mux2i_1
* cell instance sky130_fd_sc_hd__mux2i_1_87 r0 *1 0,0
Xsky130_fd_sc_hd__mux2i_1_87 \$3308 \$3304 \$1561
+ vss
+ vdd
+ vdd
+ \$3407 sky130_fd_sc_hd__mux2i_1
* cell instance sky130_fd_sc_hd__mux2i_1_88 r0 *1 0,0
Xsky130_fd_sc_hd__mux2i_1_88 \$3502 \$4751 \$2057
+ vss
+ vdd
+ vdd
+ \$4752 sky130_fd_sc_hd__mux2i_1
* cell instance sky130_fd_sc_hd__mux2i_1_89 r0 *1 0,0
Xsky130_fd_sc_hd__mux2i_1_89 \$2715 \$4979 \$2057
+ vss
+ vdd
+ vdd
+ \$4981 sky130_fd_sc_hd__mux2i_1
* cell instance sky130_fd_sc_hd__mux2i_1_90 r0 *1 0,0
Xsky130_fd_sc_hd__mux2i_1_90 \$3031 \$5683 \$2057
+ vss
+ vdd
+ vdd
+ \$5684 sky130_fd_sc_hd__mux2i_1
* cell instance sky130_fd_sc_hd__mux2i_1_91 r0 *1 0,0
Xsky130_fd_sc_hd__mux2i_1_91 \$3730 \$6027 \$4299
+ vss
+ vdd
+ vdd
+ \$5576 sky130_fd_sc_hd__mux2i_1
* cell instance sky130_fd_sc_hd__mux2i_1_92 r0 *1 0,0
Xsky130_fd_sc_hd__mux2i_1_92 \$4460 \$4806 \$4802
+ vss
+ vdd
+ vdd
+ \$4863 sky130_fd_sc_hd__mux2i_1
* cell instance sky130_fd_sc_hd__mux2i_1_93 r0 *1 0,0
Xsky130_fd_sc_hd__mux2i_1_93 \$3617 \$3308 \$1561
+ vss
+ vdd
+ vdd
+ \$3510 sky130_fd_sc_hd__mux2i_1
* cell instance sky130_fd_sc_hd__mux2i_1_94 r0 *1 0,0
Xsky130_fd_sc_hd__mux2i_1_94 \$6955 \$7033 \$4299
+ vss
+ vdd
+ vdd
+ \$7039 sky130_fd_sc_hd__mux2i_1
* cell instance sky130_fd_sc_hd__mux2i_1_95 r0 *1 0,0
Xsky130_fd_sc_hd__mux2i_1_95 \$7538 \$5683 \$4302
+ vss
+ vdd
+ vdd
+ \$3087 sky130_fd_sc_hd__mux2i_1
* cell instance sky130_fd_sc_hd__mux2i_1_96 r0 *1 0,0
Xsky130_fd_sc_hd__mux2i_1_96 \$7923 \$7538 \$4802
+ vss
+ vdd
+ vdd
+ \$7838 sky130_fd_sc_hd__mux2i_1
* cell instance sky130_fd_sc_hd__mux2i_1_97 r0 *1 0,0
Xsky130_fd_sc_hd__mux2i_1_97 \$6869 \$6787 \$4802
+ vss
+ vdd
+ vdd
+ \$6868 sky130_fd_sc_hd__mux2i_1
* cell instance sky130_fd_sc_hd__mux2i_1_98 r0 *1 0,0
Xsky130_fd_sc_hd__mux2i_1_98 \$3087 \$7838 \$4299
+ vss
+ vdd
+ vdd
+ \$7383 sky130_fd_sc_hd__mux2i_1
* cell instance sky130_fd_sc_hd__mux2i_1_99 r0 *1 0,0
Xsky130_fd_sc_hd__mux2i_1_99 \$4863 \$4917 \$4299
+ vss
+ vdd
+ vdd
+ \$4462 sky130_fd_sc_hd__mux2i_1
* cell instance sky130_fd_sc_hd__mux2i_1_100 r0 *1 0,0
Xsky130_fd_sc_hd__mux2i_1_100 \$6868 \$6955 \$4299
+ vss
+ vdd
+ vdd
+ \$6871 sky130_fd_sc_hd__mux2i_1
* cell instance sky130_fd_sc_hd__mux2i_1_101 r0 *1 0,0
Xsky130_fd_sc_hd__mux2i_1_101 \$7538 \$7764 \$5325
+ vss
+ vdd
+ vdd
+ \$7766 sky130_fd_sc_hd__mux2i_1
* cell instance sky130_fd_sc_hd__mux2i_1_102 r0 *1 0,0
Xsky130_fd_sc_hd__mux2i_1_102 \$1736 \$2062 \$2057
+ vss
+ vdd
+ vdd
+ \$2063 sky130_fd_sc_hd__mux2i_1
* cell instance sky130_fd_sc_hd__mux2i_1_103 r0 *1 0,0
Xsky130_fd_sc_hd__mux2i_1_103 \$2807 \$6868 \$4299
+ vss
+ vdd
+ vdd
+ \$6446 sky130_fd_sc_hd__mux2i_1
* cell instance sky130_fd_sc_hd__mux2i_1_104 r0 *1 0,0
Xsky130_fd_sc_hd__mux2i_1_104 \$4647 \$4863 \$4299
+ vss
+ vdd
+ vdd
+ \$4646 sky130_fd_sc_hd__mux2i_1
* cell instance sky130_fd_sc_hd__mux2i_1_105 r0 *1 0,0
Xsky130_fd_sc_hd__mux2i_1_105 \$4917 \$5357 \$4299
+ vss
+ vdd
+ vdd
+ \$4984 sky130_fd_sc_hd__mux2i_1
* cell instance sky130_fd_sc_hd__mux2i_1_106 r0 *1 0,0
Xsky130_fd_sc_hd__mux2i_1_106 \$1956 \$3994 \$2057
+ vss
+ vdd
+ vdd
+ \$3892 sky130_fd_sc_hd__mux2i_1
* cell instance sky130_fd_sc_hd__mux2i_1_107 r0 *1 0,0
Xsky130_fd_sc_hd__mux2i_1_107 \$7838 \$7766 \$4299
+ vss
+ vdd
+ vdd
+ \$7843 sky130_fd_sc_hd__mux2i_1
* cell instance sky130_fd_sc_hd__mux2i_1_108 r0 *1 0,0
Xsky130_fd_sc_hd__mux2i_1_108 \$1086 \$1083 \$1156
+ vss
+ vdd
+ vdd
+ \$1091 sky130_fd_sc_hd__mux2i_1
* cell instance sky130_fd_sc_hd__mux2i_1_109 r0 *1 0,0
Xsky130_fd_sc_hd__mux2i_1_109 \$1083 \$1226 \$1225
+ vss
+ vdd
+ vdd
+ \$1428 sky130_fd_sc_hd__mux2i_1
* cell instance sky130_fd_sc_hd__mux2i_1_110 r0 *1 0,0
Xsky130_fd_sc_hd__mux2i_1_110 \$5582 \$2062 \$4302
+ vss
+ vdd
+ vdd
+ \$2678 sky130_fd_sc_hd__mux2i_1
* cell instance sky130_fd_sc_hd__mux2i_1_111 r0 *1 0,0
Xsky130_fd_sc_hd__mux2i_1_111 \$5901 \$5582 \$4802
+ vss
+ vdd
+ vdd
+ \$6038 sky130_fd_sc_hd__mux2i_1
* cell instance sky130_fd_sc_hd__mux2i_1_112 r0 *1 0,0
Xsky130_fd_sc_hd__mux2i_1_112 \$809 \$5170 \$2057
+ vss
+ vdd
+ vdd
+ \$5174 sky130_fd_sc_hd__mux2i_1
* cell instance sky130_fd_sc_hd__mux2i_1_113 r0 *1 0,0
Xsky130_fd_sc_hd__mux2i_1_113 \$645 \$4453 \$2057
+ vss
+ vdd
+ vdd
+ \$2068 sky130_fd_sc_hd__mux2i_1
* cell instance sky130_fd_sc_hd__mux2i_1_114 r0 *1 0,0
Xsky130_fd_sc_hd__mux2i_1_114 \$2140 \$2258 \$2057
+ vss
+ vdd
+ vdd
+ \$2279 sky130_fd_sc_hd__mux2i_1
* cell instance sky130_fd_sc_hd__mux2i_1_115 r0 *1 0,0
Xsky130_fd_sc_hd__mux2i_1_115 \$2678 \$6038 \$4299
+ vss
+ vdd
+ vdd
+ \$5693 sky130_fd_sc_hd__mux2i_1
* cell instance sky130_fd_sc_hd__mux2i_1_116 r0 *1 0,0
Xsky130_fd_sc_hd__mux2i_1_116 \$5582 \$6139 \$5325
+ vss
+ vdd
+ vdd
+ \$6234 sky130_fd_sc_hd__mux2i_1
* cell instance sky130_fd_sc_hd__mux2i_1_117 r0 *1 0,0
Xsky130_fd_sc_hd__mux2i_1_117 \$5582 \$6322 \$5547
+ vss
+ vdd
+ vdd
+ \$6451 sky130_fd_sc_hd__mux2i_1
* cell instance sky130_fd_sc_hd__mux2i_1_118 r0 *1 0,0
Xsky130_fd_sc_hd__mux2i_1_118 \$7766 \$7849 \$4299
+ vss
+ vdd
+ vdd
+ \$7695 sky130_fd_sc_hd__mux2i_1
* cell instance sky130_fd_sc_hd__mux2i_1_119 r0 *1 0,0
Xsky130_fd_sc_hd__mux2i_1_119 \$5464 \$4541 \$4802
+ vss
+ vdd
+ vdd
+ \$4872 sky130_fd_sc_hd__mux2i_1
* cell instance sky130_fd_sc_hd__mux2i_1_120 r0 *1 0,0
Xsky130_fd_sc_hd__mux2i_1_120 \$6038 \$6234 \$4299
+ vss
+ vdd
+ vdd
+ \$5909 sky130_fd_sc_hd__mux2i_1
* cell instance sky130_fd_sc_hd__mux2i_1_121 r0 *1 0,0
Xsky130_fd_sc_hd__mux2i_1_121 \$7538 \$7848 \$5547
+ vss
+ vdd
+ vdd
+ \$7849 sky130_fd_sc_hd__mux2i_1
* cell instance sky130_fd_sc_hd__mux2i_1_122 r0 *1 0,0
Xsky130_fd_sc_hd__mux2i_1_122 \$6234 \$6451 \$4299
+ vss
+ vdd
+ vdd
+ \$6147 sky130_fd_sc_hd__mux2i_1
* cell instance sky130_fd_sc_hd__mux2i_1_123 r0 *1 0,0
Xsky130_fd_sc_hd__mux2i_1_123 \$4541 \$2258 \$4302
+ vss
+ vdd
+ vdd
+ \$3847 sky130_fd_sc_hd__mux2i_1
* cell instance sky130_fd_sc_hd__mux2i_1_124 r0 *1 0,0
Xsky130_fd_sc_hd__mux2i_1_124 \$4541 \$4987 \$5325
+ vss
+ vdd
+ vdd
+ \$4988 sky130_fd_sc_hd__mux2i_1
* cell instance sky130_fd_sc_hd__mux2i_1_125 r0 *1 0,0
Xsky130_fd_sc_hd__mux2i_1_125 \$3847 \$4872 \$4299
+ vss
+ vdd
+ vdd
+ \$4652 sky130_fd_sc_hd__mux2i_1
* cell instance sky130_fd_sc_hd__mux2i_1_126 r0 *1 0,0
Xsky130_fd_sc_hd__mux2i_1_126 \$4541 \$5245 \$5547
+ vss
+ vdd
+ vdd
+ \$5246 sky130_fd_sc_hd__mux2i_1
* cell instance sky130_fd_sc_hd__mux2i_1_127 r0 *1 0,0
Xsky130_fd_sc_hd__mux2i_1_127 \$4872 \$4988 \$4428
+ vss
+ vdd
+ vdd
+ \$4877 sky130_fd_sc_hd__mux2i_1
* cell instance sky130_fd_sc_hd__mux2i_1_128 r0 *1 0,0
Xsky130_fd_sc_hd__mux2i_1_128 \$4063 \$5588 \$2057
+ vss
+ vdd
+ vdd
+ \$5589 sky130_fd_sc_hd__mux2i_1
* cell instance sky130_fd_sc_hd__mux2i_1_129 r0 *1 0,0
Xsky130_fd_sc_hd__mux2i_1_129 bus_wdata[1] \$2057 \$3318
+ vss
+ vdd
+ vdd
+ \$3259 sky130_fd_sc_hd__mux2i_1
* cell instance sky130_fd_sc_hd__mux2i_1_130 r0 *1 0,0
Xsky130_fd_sc_hd__mux2i_1_130 \$4988 \$5246 \$4428
+ vss
+ vdd
+ vdd
+ \$4991 sky130_fd_sc_hd__mux2i_1
* cell instance sky130_fd_sc_hd__mux2i_1_131 r0 *1 0,0
Xsky130_fd_sc_hd__mux2i_1_131 \$7222 \$5588 \$4302
+ vss
+ vdd
+ vdd
+ \$4411 sky130_fd_sc_hd__mux2i_1
* cell instance sky130_fd_sc_hd__mux2i_1_132 r0 *1 0,0
Xsky130_fd_sc_hd__mux2i_1_132 \$7318 \$7222 \$4802
+ vss
+ vdd
+ vdd
+ \$7235 sky130_fd_sc_hd__mux2i_1
* cell instance sky130_fd_sc_hd__mux2i_1_133 r0 *1 0,0
Xsky130_fd_sc_hd__mux2i_1_133 \$7222 \$7153 \$5325
+ vss
+ vdd
+ vdd
+ \$7392 sky130_fd_sc_hd__mux2i_1
* cell instance sky130_fd_sc_hd__mux2i_1_134 r0 *1 0,0
Xsky130_fd_sc_hd__mux2i_1_134 \$7222 \$7458 \$5547
+ vss
+ vdd
+ vdd
+ \$7463 sky130_fd_sc_hd__mux2i_1
* cell instance sky130_fd_sc_hd__mux2i_1_135 r0 *1 0,0
Xsky130_fd_sc_hd__mux2i_1_135 \$4411 \$7235 \$4428
+ vss
+ vdd
+ vdd
+ \$7152 sky130_fd_sc_hd__mux2i_1
* cell instance sky130_fd_sc_hd__mux2i_1_136 r0 *1 0,0
Xsky130_fd_sc_hd__mux2i_1_136 \$7235 \$7392 \$4428
+ vss
+ vdd
+ vdd
+ \$7240 sky130_fd_sc_hd__mux2i_1
* cell instance sky130_fd_sc_hd__mux2i_1_137 r0 *1 0,0
Xsky130_fd_sc_hd__mux2i_1_137 \$7392 \$7463 \$4428
+ vss
+ vdd
+ vdd
+ \$7156 sky130_fd_sc_hd__mux2i_1
* cell instance sky130_fd_sc_hd__mux2i_1_138 r0 *1 0,0
Xsky130_fd_sc_hd__mux2i_1_138 \$1095 \$2813 \$2057
+ vss
+ vdd
+ vdd
+ \$2712 sky130_fd_sc_hd__mux2i_1
* cell instance sky130_fd_sc_hd__mux2i_1_139 r0 *1 0,0
Xsky130_fd_sc_hd__mux2i_1_139 \$4213 \$4994 \$5547
+ vss
+ vdd
+ vdd
+ \$4995 sky130_fd_sc_hd__mux2i_1
* cell instance sky130_fd_sc_hd__mux2i_1_140 r0 *1 0,0
Xsky130_fd_sc_hd__mux2i_1_140 \$7704 \$7702 \$4802
+ vss
+ vdd
+ vdd
+ \$7703 sky130_fd_sc_hd__mux2i_1
* cell instance sky130_fd_sc_hd__mux2i_1_141 r0 *1 0,0
Xsky130_fd_sc_hd__mux2i_1_141 \$4213 \$2813 \$4302
+ vss
+ vdd
+ vdd
+ \$4094 sky130_fd_sc_hd__mux2i_1
* cell instance sky130_fd_sc_hd__mux2i_1_142 r0 *1 0,0
Xsky130_fd_sc_hd__mux2i_1_142 \$6719 \$6717 \$4428
+ vss
+ vdd
+ vdd
+ \$6974 sky130_fd_sc_hd__mux2i_1
* cell instance sky130_fd_sc_hd__mux2i_1_143 r0 *1 0,0
Xsky130_fd_sc_hd__mux2i_1_143 \$4657 \$4213 \$4802
+ vss
+ vdd
+ vdd
+ \$4553 sky130_fd_sc_hd__mux2i_1
* cell instance sky130_fd_sc_hd__mux2i_1_144 r0 *1 0,0
Xsky130_fd_sc_hd__mux2i_1_144 \$4213 \$4918 \$5325
+ vss
+ vdd
+ vdd
+ \$4764 sky130_fd_sc_hd__mux2i_1
* cell instance sky130_fd_sc_hd__mux2i_1_145 r0 *1 0,0
Xsky130_fd_sc_hd__mux2i_1_145 \$4094 \$4553 \$4428
+ vss
+ vdd
+ vdd
+ \$4464 sky130_fd_sc_hd__mux2i_1
* cell instance sky130_fd_sc_hd__mux2i_1_146 r0 *1 0,0
Xsky130_fd_sc_hd__mux2i_1_146 \$7861 \$7936 \$4428
+ vss
+ vdd
+ vdd
+ \$7866 sky130_fd_sc_hd__mux2i_1
* cell instance sky130_fd_sc_hd__mux2i_1_147 r0 *1 0,0
Xsky130_fd_sc_hd__mux2i_1_147 \$4553 \$4764 \$4428
+ vss
+ vdd
+ vdd
+ \$4660 sky130_fd_sc_hd__mux2i_1
* cell instance sky130_fd_sc_hd__mux2i_1_148 r0 *1 0,0
Xsky130_fd_sc_hd__mux2i_1_148 \$4764 \$4995 \$4428
+ vss
+ vdd
+ vdd
+ \$4885 sky130_fd_sc_hd__mux2i_1
* cell instance sky130_fd_sc_hd__mux2i_1_149 r0 *1 0,0
Xsky130_fd_sc_hd__mux2i_1_149 \$962 \$5238 \$2057
+ vss
+ vdd
+ vdd
+ \$5252 sky130_fd_sc_hd__mux2i_1
* cell instance sky130_fd_sc_hd__mux2i_1_150 r0 *1 0,0
Xsky130_fd_sc_hd__mux2i_1_150 \$7703 \$7861 \$4428
+ vss
+ vdd
+ vdd
+ \$7707 sky130_fd_sc_hd__mux2i_1
* cell instance sky130_fd_sc_hd__mux2i_1_151 r0 *1 0,0
Xsky130_fd_sc_hd__mux2i_1_151 \$1777 \$7465 \$2057
+ vss
+ vdd
+ vdd
+ \$2278 sky130_fd_sc_hd__mux2i_1
* cell instance sky130_fd_sc_hd__mux2i_1_152 r0 *1 0,0
Xsky130_fd_sc_hd__mux2i_1_152 \$2469 \$7703 \$4428
+ vss
+ vdd
+ vdd
+ \$7556 sky130_fd_sc_hd__mux2i_1
* cell instance sky130_fd_sc_hd__mux2i_1_153 r0 *1 0,0
Xsky130_fd_sc_hd__mux2i_1_153 \$1891 \$1601 \$182
+ vss
+ vdd
+ vdd
+ \$1893 sky130_fd_sc_hd__mux2i_1
* cell instance sky130_fd_sc_hd__mux2i_1_154 r0 *1 0,0
Xsky130_fd_sc_hd__mux2i_1_154 \$2182 \$1891 \$182
+ vss
+ vdd
+ vdd
+ \$1786 sky130_fd_sc_hd__mux2i_1
* cell instance sky130_fd_sc_hd__mux2i_1_155 r0 *1 0,0
Xsky130_fd_sc_hd__mux2i_1_155 \$4221 \$5035 \$5325
+ vss
+ vdd
+ vdd
+ \$5134 sky130_fd_sc_hd__mux2i_1
* cell instance sky130_fd_sc_hd__mux2i_1_156 r0 *1 0,0
Xsky130_fd_sc_hd__mux2i_1_156 \$5408 \$5809 \$4802
+ vss
+ vdd
+ vdd
+ \$5601 sky130_fd_sc_hd__mux2i_1
* cell instance sky130_fd_sc_hd__mux2i_1_157 r0 *1 0,0
Xsky130_fd_sc_hd__mux2i_1_157 \$7532 \$7871 \$5547
+ vss
+ vdd
+ vdd
+ \$7872 sky130_fd_sc_hd__mux2i_1
* cell instance sky130_fd_sc_hd__mux2i_1_158 r0 *1 0,0
Xsky130_fd_sc_hd__mux2i_1_158 \$4221 \$5255 \$5547
+ vss
+ vdd
+ vdd
+ \$5139 sky130_fd_sc_hd__mux2i_1
* cell instance sky130_fd_sc_hd__mux2i_1_159 r0 *1 0,0
Xsky130_fd_sc_hd__mux2i_1_159 \$4666 \$4221 \$4802
+ vss
+ vdd
+ vdd
+ \$4557 sky130_fd_sc_hd__mux2i_1
* cell instance sky130_fd_sc_hd__mux2i_1_160 r0 *1 0,0
Xsky130_fd_sc_hd__mux2i_1_160 \$7532 \$7714 \$5325
+ vss
+ vdd
+ vdd
+ \$7561 sky130_fd_sc_hd__mux2i_1
* cell instance sky130_fd_sc_hd__mux2i_1_161 r0 *1 0,0
Xsky130_fd_sc_hd__mux2i_1_161 \$1603 \$2074 \$2057
+ vss
+ vdd
+ vdd
+ \$2075 sky130_fd_sc_hd__mux2i_1
* cell instance sky130_fd_sc_hd__mux2i_1_162 r0 *1 0,0
Xsky130_fd_sc_hd__mux2i_1_162 \$6809 \$6725 \$4802
+ vss
+ vdd
+ vdd
+ \$6641 sky130_fd_sc_hd__mux2i_1
* cell instance sky130_fd_sc_hd__mux2i_1_163 r0 *1 0,0
Xsky130_fd_sc_hd__mux2i_1_163 \$7785 \$7532 \$4802
+ vss
+ vdd
+ vdd
+ \$7784 sky130_fd_sc_hd__mux2i_1
* cell instance sky130_fd_sc_hd__mux2i_1_164 r0 *1 0,0
Xsky130_fd_sc_hd__mux2i_1_164 \$7561 \$7872 \$4428
+ vss
+ vdd
+ vdd
+ \$7723 sky130_fd_sc_hd__mux2i_1
* cell instance sky130_fd_sc_hd__mux2i_1_165 r0 *1 0,0
Xsky130_fd_sc_hd__mux2i_1_165 \$4221 \$2191 \$4302
+ vss
+ vdd
+ vdd
+ \$2588 sky130_fd_sc_hd__mux2i_1
* cell instance sky130_fd_sc_hd__mux2i_1_166 r0 *1 0,0
Xsky130_fd_sc_hd__mux2i_1_166 \$5134 \$5139 \$4428
+ vss
+ vdd
+ vdd
+ \$5006 sky130_fd_sc_hd__mux2i_1
* cell instance sky130_fd_sc_hd__mux2i_1_167 r0 *1 0,0
Xsky130_fd_sc_hd__mux2i_1_167 \$4557 \$5134 \$4428
+ vss
+ vdd
+ vdd
+ \$4673 sky130_fd_sc_hd__mux2i_1
* cell instance sky130_fd_sc_hd__mux2i_1_168 r0 *1 0,0
Xsky130_fd_sc_hd__mux2i_1_168 \$3860 \$5601 \$4428
+ vss
+ vdd
+ vdd
+ \$5487 sky130_fd_sc_hd__mux2i_1
* cell instance sky130_fd_sc_hd__mux2i_1_169 r0 *1 0,0
Xsky130_fd_sc_hd__mux2i_1_169 \$7068 \$6890 \$4802
+ vss
+ vdd
+ vdd
+ \$6983 sky130_fd_sc_hd__mux2i_1
* cell instance sky130_fd_sc_hd__mux2i_1_170 r0 *1 0,0
Xsky130_fd_sc_hd__mux2i_1_170 \$7532 \$4466 \$4302
+ vss
+ vdd
+ vdd
+ \$4109 sky130_fd_sc_hd__mux2i_1
* cell instance sky130_fd_sc_hd__mux2i_1_171 r0 *1 0,0
Xsky130_fd_sc_hd__mux2i_1_171 \$834 \$4466 \$2057
+ vss
+ vdd
+ vdd
+ \$4338 sky130_fd_sc_hd__mux2i_1
* cell instance sky130_fd_sc_hd__mux2i_1_172 r0 *1 0,0
Xsky130_fd_sc_hd__mux2i_1_172 \$2588 \$4557 \$4428
+ vss
+ vdd
+ vdd
+ \$4323 sky130_fd_sc_hd__mux2i_1
* cell instance sky130_fd_sc_hd__mux2i_1_173 r0 *1 0,0
Xsky130_fd_sc_hd__mux2i_1_173 \$5601 \$5816 \$4428
+ vss
+ vdd
+ vdd
+ \$5385 sky130_fd_sc_hd__mux2i_1
* cell instance sky130_fd_sc_hd__mux2i_1_174 r0 *1 0,0
Xsky130_fd_sc_hd__mux2i_1_174 \$757 \$5924 \$2057
+ vss
+ vdd
+ vdd
+ \$5925 sky130_fd_sc_hd__mux2i_1
* cell instance sky130_fd_sc_hd__mux2i_1_175 r0 *1 0,0
Xsky130_fd_sc_hd__mux2i_1_175 \$6641 \$6719 \$4428
+ vss
+ vdd
+ vdd
+ \$6730 sky130_fd_sc_hd__mux2i_1
* cell instance sky130_fd_sc_hd__mux2i_1_176 r0 *1 0,0
Xsky130_fd_sc_hd__mux2i_1_176 \$1373 \$2191 \$2057
+ vss
+ vdd
+ vdd
+ \$2192 sky130_fd_sc_hd__mux2i_1
* cell instance sky130_fd_sc_hd__mux2i_1_177 r0 *1 0,0
Xsky130_fd_sc_hd__mux2i_1_177 \$7167 \$7333 \$4428
+ vss
+ vdd
+ vdd
+ \$7338 sky130_fd_sc_hd__mux2i_1
* cell instance sky130_fd_sc_hd__mux2i_1_178 r0 *1 0,0
Xsky130_fd_sc_hd__mux2i_1_178 \$7784 \$7561 \$4428
+ vss
+ vdd
+ vdd
+ \$7790 sky130_fd_sc_hd__mux2i_1
* cell instance sky130_fd_sc_hd__mux2i_1_179 r0 *1 0,0
Xsky130_fd_sc_hd__mux2i_1_179 \$5816 \$6068 \$4428
+ vss
+ vdd
+ vdd
+ \$6069 sky130_fd_sc_hd__mux2i_1
* cell instance sky130_fd_sc_hd__mux2i_1_180 r0 *1 0,0
Xsky130_fd_sc_hd__mux2i_1_180 \$6983 \$7167 \$4428
+ vss
+ vdd
+ vdd
+ \$7076 sky130_fd_sc_hd__mux2i_1
* cell instance sky130_fd_sc_hd__mux2i_1_181 r0 *1 0,0
Xsky130_fd_sc_hd__mux2i_1_181 \$6546 \$6641 \$4428
+ vss
+ vdd
+ vdd
+ \$6550 sky130_fd_sc_hd__mux2i_1
* cell instance sky130_fd_sc_hd__mux2i_1_182 r0 *1 0,0
Xsky130_fd_sc_hd__mux2i_1_182 \$4109 \$7784 \$4428
+ vss
+ vdd
+ vdd
+ \$7570 sky130_fd_sc_hd__mux2i_1
* cell instance sky130_fd_sc_hd__mux2i_1_183 r0 *1 0,0
Xsky130_fd_sc_hd__mux2i_1_183 \$6893 \$6983 \$4428
+ vss
+ vdd
+ vdd
+ \$6466 sky130_fd_sc_hd__mux2i_1
* cell instance sky130_fd_sc_hd__mux2i_1_184 r0 *1 0,0
Xsky130_fd_sc_hd__mux2i_1_184 \$760 \$6458 \$2057
+ vss
+ vdd
+ vdd
+ \$2702 sky130_fd_sc_hd__mux2i_1
* cell instance sky130_fd_sc_hd__mux2i_1_185 r0 *1 0,0
Xsky130_fd_sc_hd__mux2i_1_185 \$4777 \$5817 \$5547
+ vss
+ vdd
+ vdd
+ \$5390 sky130_fd_sc_hd__mux2i_1
* cell instance sky130_fd_sc_hd__mux2i_1_186 r0 *1 0,0
Xsky130_fd_sc_hd__mux2i_1_186 \$2283 \$2080 \$182
+ vss
+ vdd
+ vdd
+ \$2485 sky130_fd_sc_hd__mux2i_1
* cell instance sky130_fd_sc_hd__mux2i_1_187 r0 *1 0,0
Xsky130_fd_sc_hd__mux2i_1_187 \$4777 \$4920 \$5325
+ vss
+ vdd
+ vdd
+ \$4897 sky130_fd_sc_hd__mux2i_1
* cell instance sky130_fd_sc_hd__mux2i_1_188 r0 *1 0,0
Xsky130_fd_sc_hd__mux2i_1_188 \$2080 \$2078 \$182
+ vss
+ vdd
+ vdd
+ \$1697 sky130_fd_sc_hd__mux2i_1
* cell instance sky130_fd_sc_hd__mux2i_1_189 r0 *1 0,0
Xsky130_fd_sc_hd__mux2i_1_189 \$2376 \$4324 \$2057
+ vss
+ vdd
+ vdd
+ \$3866 sky130_fd_sc_hd__mux2i_1
* cell instance sky130_fd_sc_hd__mux2i_1_190 r0 *1 0,0
Xsky130_fd_sc_hd__mux2i_1_190 \$7510 \$7882 \$5547
+ vss
+ vdd
+ vdd
+ \$7725 sky130_fd_sc_hd__mux2i_1
* cell instance sky130_fd_sc_hd__mux2i_1_191 r0 *1 0,0
Xsky130_fd_sc_hd__mux2i_1_191 \$3531 \$5603 \$4428
+ vss
+ vdd
+ vdd
+ \$4347 sky130_fd_sc_hd__mux2i_1
* cell instance sky130_fd_sc_hd__mux2i_1_192 r0 *1 0,0
Xsky130_fd_sc_hd__mux2i_1_192 \$6553 \$6732 \$4802
+ vss
+ vdd
+ vdd
+ \$6556 sky130_fd_sc_hd__mux2i_1
* cell instance sky130_fd_sc_hd__mux2i_1_193 r0 *1 0,0
Xsky130_fd_sc_hd__mux2i_1_193 \$4676 \$4777 \$4802
+ vss
+ vdd
+ vdd
+ \$4782 sky130_fd_sc_hd__mux2i_1
* cell instance sky130_fd_sc_hd__mux2i_1_194 r0 *1 0,0
Xsky130_fd_sc_hd__mux2i_1_194 \$7404 \$7339 \$4802
+ vss
+ vdd
+ vdd
+ \$7176 sky130_fd_sc_hd__mux2i_1
* cell instance sky130_fd_sc_hd__mux2i_1_195 r0 *1 0,0
Xsky130_fd_sc_hd__mux2i_1_195 \$5603 \$5719 \$4428
+ vss
+ vdd
+ vdd
+ \$5494 sky130_fd_sc_hd__mux2i_1
* cell instance sky130_fd_sc_hd__mux2i_1_196 r0 *1 0,0
Xsky130_fd_sc_hd__mux2i_1_196 \$7510 \$7992 \$5325
+ vss
+ vdd
+ vdd
+ \$7795 sky130_fd_sc_hd__mux2i_1
* cell instance sky130_fd_sc_hd__mux2i_1_197 r0 *1 0,0
Xsky130_fd_sc_hd__mux2i_1_197 \$4777 \$2917 \$4302
+ vss
+ vdd
+ vdd
+ \$4563 sky130_fd_sc_hd__mux2i_1
* cell instance sky130_fd_sc_hd__mux2i_1_198 r0 *1 0,0
Xsky130_fd_sc_hd__mux2i_1_198 \$4897 \$5390 \$4428
+ vss
+ vdd
+ vdd
+ \$5148 sky130_fd_sc_hd__mux2i_1
* cell instance sky130_fd_sc_hd__mux2i_1_199 r0 *1 0,0
Xsky130_fd_sc_hd__mux2i_1_199 \$2668 \$2917 \$2057
+ vss
+ vdd
+ vdd
+ \$2919 sky130_fd_sc_hd__mux2i_1
* cell instance sky130_fd_sc_hd__mux2i_1_200 r0 *1 0,0
Xsky130_fd_sc_hd__mux2i_1_200 \$5719 \$6088 \$4428
+ vss
+ vdd
+ vdd
+ \$5935 sky130_fd_sc_hd__mux2i_1
* cell instance sky130_fd_sc_hd__mux2i_1_201 r0 *1 0,0
Xsky130_fd_sc_hd__mux2i_1_201 \$840 \$7081 \$2057
+ vss
+ vdd
+ vdd
+ \$3247 sky130_fd_sc_hd__mux2i_1
* cell instance sky130_fd_sc_hd__mux2i_1_202 r0 *1 0,0
Xsky130_fd_sc_hd__mux2i_1_202 \$7795 \$7725 \$4428
+ vss
+ vdd
+ vdd
+ \$7729 sky130_fd_sc_hd__mux2i_1
* cell instance sky130_fd_sc_hd__mux2i_1_203 r0 *1 0,0
Xsky130_fd_sc_hd__mux2i_1_203 \$6556 \$6561 \$4428
+ vss
+ vdd
+ vdd
+ \$6562 sky130_fd_sc_hd__mux2i_1
* cell instance sky130_fd_sc_hd__mux2i_1_204 r0 *1 0,0
Xsky130_fd_sc_hd__mux2i_1_204 \$6561 \$6469 \$4428
+ vss
+ vdd
+ vdd
+ \$6823 sky130_fd_sc_hd__mux2i_1
* cell instance sky130_fd_sc_hd__mux2i_1_205 r0 *1 0,0
Xsky130_fd_sc_hd__mux2i_1_205 \$7176 \$7487 \$4428
+ vss
+ vdd
+ vdd
+ \$7344 sky130_fd_sc_hd__mux2i_1
* cell instance sky130_fd_sc_hd__mux2i_1_206 r0 *1 0,0
Xsky130_fd_sc_hd__mux2i_1_206 \$4782 \$4897 \$4428
+ vss
+ vdd
+ vdd
+ \$4684 sky130_fd_sc_hd__mux2i_1
* cell instance sky130_fd_sc_hd__mux2i_1_207 r0 *1 0,0
Xsky130_fd_sc_hd__mux2i_1_207 \$7487 \$7574 \$4428
+ vss
+ vdd
+ vdd
+ \$7492 sky130_fd_sc_hd__mux2i_1
* cell instance sky130_fd_sc_hd__mux2i_1_208 r0 *1 0,0
Xsky130_fd_sc_hd__mux2i_1_208 \$4563 \$4782 \$4428
+ vss
+ vdd
+ vdd
+ \$4783 sky130_fd_sc_hd__mux2i_1
* cell instance sky130_fd_sc_hd__mux2i_1_209 r0 *1 0,0
Xsky130_fd_sc_hd__mux2i_1_209 \$4229 \$7176 \$4428
+ vss
+ vdd
+ vdd
+ \$7089 sky130_fd_sc_hd__mux2i_1
* cell instance sky130_fd_sc_hd__mux2i_1_210 r0 *1 0,0
Xsky130_fd_sc_hd__mux2i_1_210 \$1700 \$1776 \$182
+ vss
+ vdd
+ vdd
+ \$1619 sky130_fd_sc_hd__mux2i_1
* cell instance sky130_fd_sc_hd__mux2i_1_211 r0 *1 0,0
Xsky130_fd_sc_hd__mux2i_1_211 \$3537 \$6556 \$4428
+ vss
+ vdd
+ vdd
+ \$6355 sky130_fd_sc_hd__mux2i_1
* cell instance sky130_fd_sc_hd__mux2i_1_212 r0 *1 0,0
Xsky130_fd_sc_hd__mux2i_1_212 \$7730 \$7510 \$4802
+ vss
+ vdd
+ vdd
+ \$7800 sky130_fd_sc_hd__mux2i_1
* cell instance sky130_fd_sc_hd__mux2i_1_213 r0 *1 0,0
Xsky130_fd_sc_hd__mux2i_1_213 \$7800 \$7795 \$4428
+ vss
+ vdd
+ vdd
+ \$7738 sky130_fd_sc_hd__mux2i_1
* cell instance sky130_fd_sc_hd__mux2i_1_214 r0 *1 0,0
Xsky130_fd_sc_hd__mux2i_1_214 \$5149 \$5610 \$5547
+ vss
+ vdd
+ vdd
+ \$5616 sky130_fd_sc_hd__mux2i_1
* cell instance sky130_fd_sc_hd__mux2i_1_215 r0 *1 0,0
Xsky130_fd_sc_hd__mux2i_1_215 \$1197 \$1117 \$182
+ vss
+ vdd
+ vdd
+ \$1269 sky130_fd_sc_hd__mux2i_1
* cell instance sky130_fd_sc_hd__mux2i_1_216 r0 *1 0,0
Xsky130_fd_sc_hd__mux2i_1_216 \$5149 \$5519 \$5325
+ vss
+ vdd
+ vdd
+ \$5615 sky130_fd_sc_hd__mux2i_1
* cell instance sky130_fd_sc_hd__mux2i_1_217 r0 *1 0,0
Xsky130_fd_sc_hd__mux2i_1_217 \$2095 \$1700 \$182
+ vss
+ vdd
+ vdd
+ \$2198 sky130_fd_sc_hd__mux2i_1
* cell instance sky130_fd_sc_hd__mux2i_1_218 r0 *1 0,0
Xsky130_fd_sc_hd__mux2i_1_218 \$7510 \$3639 \$4302
+ vss
+ vdd
+ vdd
+ \$4335 sky130_fd_sc_hd__mux2i_1
* cell instance sky130_fd_sc_hd__mux2i_1_219 r0 *1 0,0
Xsky130_fd_sc_hd__mux2i_1_219 \$3018 \$2707 \$182
+ vss
+ vdd
+ vdd
+ \$2622 sky130_fd_sc_hd__mux2i_1
* cell instance sky130_fd_sc_hd__mux2i_1_220 r0 *1 0,0
Xsky130_fd_sc_hd__mux2i_1_220 \$5268 \$5149 \$4802
+ vss
+ vdd
+ vdd
+ \$5016 sky130_fd_sc_hd__mux2i_1
* cell instance sky130_fd_sc_hd__mux2i_1_221 r0 *1 0,0
Xsky130_fd_sc_hd__mux2i_1_221 \$5615 \$5616 \$4428
+ vss
+ vdd
+ vdd
+ \$5506 sky130_fd_sc_hd__mux2i_1
* cell instance sky130_fd_sc_hd__mux2i_1_222 r0 *1 0,0
Xsky130_fd_sc_hd__mux2i_1_222 \$4335 \$7800 \$4428
+ vss
+ vdd
+ vdd
+ \$7497 sky130_fd_sc_hd__mux2i_1
* cell instance sky130_fd_sc_hd__mux2i_1_223 r0 *1 0,0
Xsky130_fd_sc_hd__mux2i_1_223 \$5149 \$4784 \$4302
+ vss
+ vdd
+ vdd
+ \$5154 sky130_fd_sc_hd__mux2i_1
* cell instance sky130_fd_sc_hd__mux2i_1_224 r0 *1 0,0
Xsky130_fd_sc_hd__mux2i_1_224 \$549 \$6089 \$2057
+ vss
+ vdd
+ vdd
+ \$6079 sky130_fd_sc_hd__mux2i_1
* cell instance sky130_fd_sc_hd__mux2i_1_225 r0 *1 0,0
Xsky130_fd_sc_hd__mux2i_1_225 \$1983 \$6159 \$2057
+ vss
+ vdd
+ vdd
+ \$5940 sky130_fd_sc_hd__mux2i_1
* cell instance sky130_fd_sc_hd__mux2i_1_226 r0 *1 0,0
Xsky130_fd_sc_hd__mux2i_1_226 \$6335 \$6159 \$4302
+ vss
+ vdd
+ vdd
+ \$4234 sky130_fd_sc_hd__mux2i_1
* cell instance sky130_fd_sc_hd__mux2i_1_227 r0 *1 0,0
Xsky130_fd_sc_hd__mux2i_1_227 \$6335 \$6569 \$5547
+ vss
+ vdd
+ vdd
+ \$6662 sky130_fd_sc_hd__mux2i_1
* cell instance sky130_fd_sc_hd__mux2i_1_228 r0 *1 0,0
Xsky130_fd_sc_hd__mux2i_1_228 \$6335 \$6736 \$5325
+ vss
+ vdd
+ vdd
+ \$6483 sky130_fd_sc_hd__mux2i_1
* cell instance sky130_fd_sc_hd__mux2i_1_229 r0 *1 0,0
Xsky130_fd_sc_hd__mux2i_1_229 \$6721 \$7272 \$5547
+ vss
+ vdd
+ vdd
+ \$7273 sky130_fd_sc_hd__mux2i_1
* cell instance sky130_fd_sc_hd__mux2i_1_230 r0 *1 0,0
Xsky130_fd_sc_hd__mux2i_1_230 \$7308 \$7805 \$5325
+ vss
+ vdd
+ vdd
+ \$7806 sky130_fd_sc_hd__mux2i_1
* cell instance sky130_fd_sc_hd__mux2i_1_231 r0 *1 0,0
Xsky130_fd_sc_hd__mux2i_1_231 \$1272 \$3639 \$2057
+ vss
+ vdd
+ vdd
+ \$3641 sky130_fd_sc_hd__mux2i_1
* cell instance sky130_fd_sc_hd__mux2i_1_232 r0 *1 0,0
Xsky130_fd_sc_hd__mux2i_1_232 \$6357 \$6335 \$4802
+ vss
+ vdd
+ vdd
+ \$6265 sky130_fd_sc_hd__mux2i_1
* cell instance sky130_fd_sc_hd__mux2i_1_233 r0 *1 0,0
Xsky130_fd_sc_hd__mux2i_1_233 \$6998 \$6721 \$4802
+ vss
+ vdd
+ vdd
+ \$7002 sky130_fd_sc_hd__mux2i_1
* cell instance sky130_fd_sc_hd__mux2i_1_234 r0 *1 0,0
Xsky130_fd_sc_hd__mux2i_1_234 \$6721 \$5829 \$4302
+ vss
+ vdd
+ vdd
+ \$6907 sky130_fd_sc_hd__mux2i_1
* cell instance sky130_fd_sc_hd__mux2i_1_235 r0 *1 0,0
Xsky130_fd_sc_hd__mux2i_1_235 \$6721 \$7345 \$5325
+ vss
+ vdd
+ vdd
+ \$7185 sky130_fd_sc_hd__mux2i_1
* cell instance sky130_fd_sc_hd__mux2i_1_236 r0 *1 0,0
Xsky130_fd_sc_hd__mux2i_1_236 \$7308 \$7896 \$5547
+ vss
+ vdd
+ vdd
+ \$7897 sky130_fd_sc_hd__mux2i_1
* cell instance sky130_fd_sc_hd__mux2i_1_237 r0 *1 0,0
Xsky130_fd_sc_hd__mux2i_1_237 \$3266 \$4784 \$2057
+ vss
+ vdd
+ vdd
+ \$4909 sky130_fd_sc_hd__mux2i_1
* cell instance sky130_fd_sc_hd__mux2i_1_238 r0 *1 0,0
Xsky130_fd_sc_hd__mux2i_1_238 \$1273 \$1197 \$182
+ vss
+ vdd
+ vdd
+ \$1123 sky130_fd_sc_hd__mux2i_1
* cell instance sky130_fd_sc_hd__mux2i_1_239 r0 *1 0,0
Xsky130_fd_sc_hd__mux2i_1_239 \$1703 \$3880 \$2057
+ vss
+ vdd
+ vdd
+ \$3881 sky130_fd_sc_hd__mux2i_1
* cell instance sky130_fd_sc_hd__mux2i_1_240 r0 *1 0,0
Xsky130_fd_sc_hd__mux2i_1_240 \$7580 \$7308 \$4802
+ vss
+ vdd
+ vdd
+ \$7581 sky130_fd_sc_hd__mux2i_1
* cell instance sky130_fd_sc_hd__mux2i_1_241 r0 *1 0,0
Xsky130_fd_sc_hd__mux2i_1_241 \$5016 \$5615 \$4428
+ vss
+ vdd
+ vdd
+ \$5015 sky130_fd_sc_hd__mux2i_1
* cell instance sky130_fd_sc_hd__mux2i_1_242 r0 *1 0,0
Xsky130_fd_sc_hd__mux2i_1_242 \$7308 \$3880 \$4302
+ vss
+ vdd
+ vdd
+ \$2710 sky130_fd_sc_hd__mux2i_1
* cell instance sky130_fd_sc_hd__mux2i_1_243 r0 *1 0,0
Xsky130_fd_sc_hd__mux2i_1_243 \$3022 \$3018 \$182
+ vss
+ vdd
+ vdd
+ \$3024 sky130_fd_sc_hd__mux2i_1
* cell instance sky130_fd_sc_hd__mux2i_1_244 r0 *1 0,0
Xsky130_fd_sc_hd__mux2i_1_244 \$992 \$5829 \$2057
+ vss
+ vdd
+ vdd
+ \$5830 sky130_fd_sc_hd__mux2i_1
* cell instance sky130_fd_sc_hd__mux2i_1_245 r0 *1 0,0
Xsky130_fd_sc_hd__mux2i_1_245 \$5154 \$5016 \$4428
+ vss
+ vdd
+ vdd
+ \$4793 sky130_fd_sc_hd__mux2i_1
* cell instance sky130_fd_sc_hd__mux2i_1_246 r0 *1 0,0
Xsky130_fd_sc_hd__mux2i_1_246 \$4234 \$6265 \$4428
+ vss
+ vdd
+ vdd
+ \$6270 sky130_fd_sc_hd__mux2i_1
* cell instance sky130_fd_sc_hd__mux2i_1_247 r0 *1 0,0
Xsky130_fd_sc_hd__mux2i_1_247 \$6483 \$6662 \$4428
+ vss
+ vdd
+ vdd
+ \$6667 sky130_fd_sc_hd__mux2i_1
* cell instance sky130_fd_sc_hd__mux2i_1_248 r0 *1 0,0
Xsky130_fd_sc_hd__mux2i_1_248 \$6265 \$6483 \$4428
+ vss
+ vdd
+ vdd
+ \$6366 sky130_fd_sc_hd__mux2i_1
* cell instance sky130_fd_sc_hd__mux2i_1_249 r0 *1 0,0
Xsky130_fd_sc_hd__mux2i_1_249 \$7002 \$7185 \$4428
+ vss
+ vdd
+ vdd
+ \$7007 sky130_fd_sc_hd__mux2i_1
* cell instance sky130_fd_sc_hd__mux2i_1_250 r0 *1 0,0
Xsky130_fd_sc_hd__mux2i_1_250 \$6907 \$7002 \$4428
+ vss
+ vdd
+ vdd
+ \$6912 sky130_fd_sc_hd__mux2i_1
* cell instance sky130_fd_sc_hd__mux2i_1_251 r0 *1 0,0
Xsky130_fd_sc_hd__mux2i_1_251 \$7185 \$7273 \$4428
+ vss
+ vdd
+ vdd
+ \$7190 sky130_fd_sc_hd__mux2i_1
* cell instance sky130_fd_sc_hd__mux2i_1_252 r0 *1 0,0
Xsky130_fd_sc_hd__mux2i_1_252 \$7806 \$7897 \$4428
+ vss
+ vdd
+ vdd
+ \$7902 sky130_fd_sc_hd__mux2i_1
* cell instance sky130_fd_sc_hd__mux2i_1_253 r0 *1 0,0
Xsky130_fd_sc_hd__mux2i_1_253 \$623 \$355 \$182
+ vss
+ vdd
+ vdd
+ \$491 sky130_fd_sc_hd__mux2i_1
* cell instance sky130_fd_sc_hd__mux2i_1_254 r0 *1 0,0
Xsky130_fd_sc_hd__mux2i_1_254 \$1625 \$1622 \$182
+ vss
+ vdd
+ vdd
+ \$1629 sky130_fd_sc_hd__mux2i_1
* cell instance sky130_fd_sc_hd__mux2i_1_255 r0 *1 0,0
Xsky130_fd_sc_hd__mux2i_1_255 \$2710 \$7581 \$4428
+ vss
+ vdd
+ vdd
+ \$7586 sky130_fd_sc_hd__mux2i_1
* cell instance sky130_fd_sc_hd__mux2i_1_256 r0 *1 0,0
Xsky130_fd_sc_hd__mux2i_1_256 \$7581 \$7806 \$4428
+ vss
+ vdd
+ vdd
+ \$7745 sky130_fd_sc_hd__mux2i_1
* cell instance sky130_fd_sc_hd__mux2i_1_257 r0 *1 0,0
Xsky130_fd_sc_hd__mux2i_1_257 \$920 \$775 \$182
+ vss
+ vdd
+ vdd
+ \$925 sky130_fd_sc_hd__mux2i_1
* cell instance sky130_fd_sc_hd__mux2i_1_258 r0 *1 0,0
Xsky130_fd_sc_hd__mux2i_1_258 \$1816 \$1625 \$182
+ vss
+ vdd
+ vdd
+ \$1711 sky130_fd_sc_hd__mux2i_1
* cell instance sky130_fd_sc_hd__mux2i_1_259 r0 *1 0,0
Xsky130_fd_sc_hd__mux2i_1_259 \$994 \$920 \$182
+ vss
+ vdd
+ vdd
+ \$1129 sky130_fd_sc_hd__mux2i_1
* cell instance sky130_fd_sc_hd__nand2_1_0 r0 *1 0,0
Xsky130_fd_sc_hd__nand2_1_0 \$3269 \$3138
+ vss
+ vdd
+ vdd
+ \$3271 sky130_fd_sc_hd__nand2_1
* cell instance sky130_fd_sc_hd__nand2_1_1 r0 *1 0,0
Xsky130_fd_sc_hd__nand2_1_1 \$4574 \$4481
+ vss
+ vdd
+ vdd
+ \$4704 sky130_fd_sc_hd__nand2_1
* cell instance sky130_fd_sc_hd__nand2_1_2 r0 *1 0,0
Xsky130_fd_sc_hd__nand2_1_2 \$1998 \$290
+ vss
+ vdd
+ vdd
+ \$1997 sky130_fd_sc_hd__nand2_1
* cell instance sky130_fd_sc_hd__nand2_1_3 r0 *1 0,0
Xsky130_fd_sc_hd__nand2_1_3 \$2097 \$2207
+ vss
+ vdd
+ vdd
+ \$2506 sky130_fd_sc_hd__nand2_1
* cell instance sky130_fd_sc_hd__nand2_1_4 r0 *1 0,0
Xsky130_fd_sc_hd__nand2_1_4 \$3767 \$4353
+ vss
+ vdd
+ vdd
+ \$4352 sky130_fd_sc_hd__nand2_1
* cell instance sky130_fd_sc_hd__nand2_1_5 r0 *1 0,0
Xsky130_fd_sc_hd__nand2_1_5 \$2625 \$2506
+ vss
+ vdd
+ vdd
+ \$2627 sky130_fd_sc_hd__nand2_1
* cell instance sky130_fd_sc_hd__nand2_1_6 r0 *1 0,0
Xsky130_fd_sc_hd__nand2_1_6 \$4353 \$1146
+ vss
+ vdd
+ vdd
+ \$4705 sky130_fd_sc_hd__nand2_1
* cell instance sky130_fd_sc_hd__nand2_1_7 r0 *1 0,0
Xsky130_fd_sc_hd__nand2_1_7 \$3153 \$3149
+ vss
+ vdd
+ vdd
+ \$3154 sky130_fd_sc_hd__nand2_1
* cell instance sky130_fd_sc_hd__nand2_1_8 r0 *1 0,0
Xsky130_fd_sc_hd__nand2_1_8 \$4147 \$4017
+ vss
+ vdd
+ vdd
+ \$4247 sky130_fd_sc_hd__nand2_1
* cell instance sky130_fd_sc_hd__nand2_1_9 r0 *1 0,0
Xsky130_fd_sc_hd__nand2_1_9 \$5852 \$290
+ vss
+ vdd
+ vdd
+ \$5969 sky130_fd_sc_hd__nand2_1
* cell instance sky130_fd_sc_hd__nand2_1_10 r0 *1 0,0
Xsky130_fd_sc_hd__nand2_1_10 \$2729 \$2628
+ vss
+ vdd
+ vdd
+ \$2209 sky130_fd_sc_hd__nand2_1
* cell instance sky130_fd_sc_hd__nand2_1_11 r0 *1 0,0
Xsky130_fd_sc_hd__nand2_1_11 \$2109 \$2213
+ vss
+ vdd
+ vdd
+ \$2411 sky130_fd_sc_hd__nand2_1
* cell instance sky130_fd_sc_hd__nand2_1_12 r0 *1 0,0
Xsky130_fd_sc_hd__nand2_1_12 \$4484 \$4937
+ vss
+ vdd
+ vdd
+ \$5301 sky130_fd_sc_hd__nand2_1
* cell instance sky130_fd_sc_hd__nand2_1_13 r0 *1 0,0
Xsky130_fd_sc_hd__nand2_1_13 \$4933 \$290
+ vss
+ vdd
+ vdd
+ \$5524 sky130_fd_sc_hd__nand2_1
* cell instance sky130_fd_sc_hd__nand2_1_14 r0 *1 0,0
Xsky130_fd_sc_hd__nand2_1_14 \$2499 \$290
+ vss
+ vdd
+ vdd
+ \$2631 sky130_fd_sc_hd__nand2_1
* cell instance sky130_fd_sc_hd__nand2_1_15 r0 *1 0,0
Xsky130_fd_sc_hd__nand2_1_15 \$1083 \$1146
+ vss
+ vdd
+ vdd
+ \$2632 sky130_fd_sc_hd__nand2_1
* cell instance sky130_fd_sc_hd__nand2_1_16 r0 *1 0,0
Xsky130_fd_sc_hd__nand2_1_16 \$4151 \$4341
+ vss
+ vdd
+ vdd
+ \$4357 sky130_fd_sc_hd__nand2_1
* cell instance sky130_fd_sc_hd__nand2_1_17 r0 *1 0,0
Xsky130_fd_sc_hd__nand2_1_17 \$1146 \$4821
+ vss
+ vdd
+ vdd
+ \$4796 sky130_fd_sc_hd__nand2_1
* cell instance sky130_fd_sc_hd__nand2_1_18 r0 *1 0,0
Xsky130_fd_sc_hd__nand2_1_18 startup_done \$2634
+ vss
+ vdd
+ vdd
+ \$2956 sky130_fd_sc_hd__nand2_1
* cell instance sky130_fd_sc_hd__nand2_1_19 r0 *1 0,0
Xsky130_fd_sc_hd__nand2_1_19 startup_done \$3279
+ vss
+ vdd
+ vdd
+ \$3460 sky130_fd_sc_hd__nand2_1
* cell instance sky130_fd_sc_hd__nand2_1_20 r0 *1 0,0
Xsky130_fd_sc_hd__nand2_1_20 \$4254 \$290
+ vss
+ vdd
+ vdd
+ \$4257 sky130_fd_sc_hd__nand2_1
* cell instance sky130_fd_sc_hd__nand2_1_21 r0 *1 0,0
Xsky130_fd_sc_hd__nand2_1_21 \$3168 \$2837
+ vss
+ vdd
+ vdd
+ \$3280 sky130_fd_sc_hd__nand2_1
* cell instance sky130_fd_sc_hd__nand2_1_22 r0 *1 0,0
Xsky130_fd_sc_hd__nand2_1_22 \$2634 \$2305
+ vss
+ vdd
+ vdd
+ \$3130 sky130_fd_sc_hd__nand2_1
* cell instance sky130_fd_sc_hd__nand2_1_23 r0 *1 0,0
Xsky130_fd_sc_hd__nand2_1_23 \$2121 \$2012
+ vss
+ vdd
+ vdd
+ \$2119 sky130_fd_sc_hd__nand2_1
* cell instance sky130_fd_sc_hd__nand2_1_24 r0 *1 0,0
Xsky130_fd_sc_hd__nand2_1_24 startup_done \$2423
+ vss
+ vdd
+ vdd
+ \$2518 sky130_fd_sc_hd__nand2_1
* cell instance sky130_fd_sc_hd__nand2_1_25 r0 *1 0,0
Xsky130_fd_sc_hd__nand2_1_25 \$1146 \$4150
+ vss
+ vdd
+ vdd
+ \$4255 sky130_fd_sc_hd__nand2_1
* cell instance sky130_fd_sc_hd__nand2_1_26 r0 *1 0,0
Xsky130_fd_sc_hd__nand2_1_26 \$1726 \$1479
+ vss
+ vdd
+ vdd
+ \$1836 sky130_fd_sc_hd__nand2_1
* cell instance sky130_fd_sc_hd__nand2_1_27 r0 *1 0,0
Xsky130_fd_sc_hd__nand2_1_27 startup_done \$2746
+ vss
+ vdd
+ vdd
+ \$3172 sky130_fd_sc_hd__nand2_1
* cell instance sky130_fd_sc_hd__nand2_1_28 r0 *1 0,0
Xsky130_fd_sc_hd__nand2_1_28 \$4604 gated
+ vss
+ vdd
+ vdd
+ \$4952 sky130_fd_sc_hd__nand2_1
* cell instance sky130_fd_sc_hd__nand2_1_29 r0 *1 0,0
Xsky130_fd_sc_hd__nand2_1_29 \$3175 \$191
+ vss
+ vdd
+ vdd
+ \$3384 sky130_fd_sc_hd__nand2_1
* cell instance sky130_fd_sc_hd__nand2_1_30 r0 *1 0,0
Xsky130_fd_sc_hd__nand2_1_30 \$4261 gated
+ vss
+ vdd
+ vdd
+ \$4364 sky130_fd_sc_hd__nand2_1
* cell instance sky130_fd_sc_hd__nand2_1_31 r0 *1 0,0
Xsky130_fd_sc_hd__nand2_1_31 \$1488 \$191
+ vss
+ vdd
+ vdd
+ \$1558 sky130_fd_sc_hd__nand2_1
* cell instance sky130_fd_sc_hd__nand2_1_32 r0 *1 0,0
Xsky130_fd_sc_hd__nand2_1_32 \$2527 \$191
+ vss
+ vdd
+ vdd
+ \$2424 sky130_fd_sc_hd__nand2_1
* cell instance sky130_fd_sc_hd__nand2_1_33 r0 *1 0,0
Xsky130_fd_sc_hd__nand2_1_33 \$2872 \$191
+ vss
+ vdd
+ vdd
+ \$2873 sky130_fd_sc_hd__nand2_1
* cell instance sky130_fd_sc_hd__nand2_1_34 r0 *1 0,0
Xsky130_fd_sc_hd__nand2_1_34 \$3184 \$1561
+ vss
+ vdd
+ vdd
+ \$3466 sky130_fd_sc_hd__nand2_1
* cell instance sky130_fd_sc_hd__nand2_1_35 r0 *1 0,0
Xsky130_fd_sc_hd__nand2_1_35 \$4605 \$4368
+ vss
+ vdd
+ vdd
+ \$4735 sky130_fd_sc_hd__nand2_1
* cell instance sky130_fd_sc_hd__nand2_1_36 r0 *1 0,0
Xsky130_fd_sc_hd__nand2_1_36 \$2127 \$191
+ vss
+ vdd
+ vdd
+ \$2128 sky130_fd_sc_hd__nand2_1
* cell instance sky130_fd_sc_hd__nand2_1_37 r0 *1 0,0
Xsky130_fd_sc_hd__nand2_1_37 \$5417 \$5073
+ vss
+ vdd
+ vdd
+ \$5199 sky130_fd_sc_hd__nand2_1
* cell instance sky130_fd_sc_hd__nand2_1_38 r0 *1 0,0
Xsky130_fd_sc_hd__nand2_1_38 \$1497 \$1561
+ vss
+ vdd
+ vdd
+ \$1560 sky130_fd_sc_hd__nand2_1
* cell instance sky130_fd_sc_hd__nand2_1_39 r0 *1 0,0
Xsky130_fd_sc_hd__nand2_1_39 \$2427 \$1561
+ vss
+ vdd
+ vdd
+ \$2530 sky130_fd_sc_hd__nand2_1
* cell instance sky130_fd_sc_hd__nand2_1_40 r0 *1 0,0
Xsky130_fd_sc_hd__nand2_1_40 \$2931 \$1561
+ vss
+ vdd
+ vdd
+ \$2968 sky130_fd_sc_hd__nand2_1
* cell instance sky130_fd_sc_hd__nand2_1_41 r0 *1 0,0
Xsky130_fd_sc_hd__nand2_1_41 \$3386 \$191
+ vss
+ vdd
+ vdd
+ \$3387 sky130_fd_sc_hd__nand2_1
* cell instance sky130_fd_sc_hd__nand2_1_42 r0 *1 0,0
Xsky130_fd_sc_hd__nand2_1_42 \$2017 \$1561
+ vss
+ vdd
+ vdd
+ \$2129 sky130_fd_sc_hd__nand2_1
* cell instance sky130_fd_sc_hd__nand2_1_43 r0 *1 0,0
Xsky130_fd_sc_hd__nand2_1_43 \$4372 \$5474
+ vss
+ vdd
+ vdd
+ \$5203 sky130_fd_sc_hd__nand2_1
* cell instance sky130_fd_sc_hd__nand2_1_44 r0 *1 0,0
Xsky130_fd_sc_hd__nand2_1_44 \$3388 \$1561
+ vss
+ vdd
+ vdd
+ \$3436 sky130_fd_sc_hd__nand2_1
* cell instance sky130_fd_sc_hd__nand2_1_45 r0 *1 0,0
Xsky130_fd_sc_hd__nand2_1_45 \$5076 gated
+ vss
+ vdd
+ vdd
+ \$5077 sky130_fd_sc_hd__nand2_1
* cell instance sky130_fd_sc_hd__nand2_1_46 r0 *1 0,0
Xsky130_fd_sc_hd__nand2_1_46 \$1146 \$4372
+ vss
+ vdd
+ vdd
+ \$5324 sky130_fd_sc_hd__nand2_1
* cell instance sky130_fd_sc_hd__nand2_1_47 r0 *1 0,0
Xsky130_fd_sc_hd__nand2_1_47 \$7422 \$5547
+ vss
+ vdd
+ vdd
+ \$7423 sky130_fd_sc_hd__nand2_1
* cell instance sky130_fd_sc_hd__nand2_1_48 r0 *1 0,0
Xsky130_fd_sc_hd__nand2_1_48 \$5418 \$5547
+ vss
+ vdd
+ vdd
+ \$5546 sky130_fd_sc_hd__nand2_1
* cell instance sky130_fd_sc_hd__nand2_1_49 r0 *1 0,0
Xsky130_fd_sc_hd__nand2_1_49 \$6832 \$5547
+ vss
+ vdd
+ vdd
+ \$6757 sky130_fd_sc_hd__nand2_1
* cell instance sky130_fd_sc_hd__nand2_1_50 r0 *1 0,0
Xsky130_fd_sc_hd__nand2_1_50 \$6188 \$6924
+ vss
+ vdd
+ vdd
+ \$7009 sky130_fd_sc_hd__nand2_1
* cell instance sky130_fd_sc_hd__nand2_1_51 r0 *1 0,0
Xsky130_fd_sc_hd__nand2_1_51 \$5475 \$6408
+ vss
+ vdd
+ vdd
+ \$6925 sky130_fd_sc_hd__nand2_1
* cell instance sky130_fd_sc_hd__nand2_1_52 r0 *1 0,0
Xsky130_fd_sc_hd__nand2_1_52 \$3187 \$191
+ vss
+ vdd
+ vdd
+ \$3291 sky130_fd_sc_hd__nand2_1
* cell instance sky130_fd_sc_hd__nand2_1_53 r0 *1 0,0
Xsky130_fd_sc_hd__nand2_1_53 \$5475 \$4521
+ vss
+ vdd
+ vdd
+ \$5663 sky130_fd_sc_hd__nand2_1
* cell instance sky130_fd_sc_hd__nand2_1_54 r0 *1 0,0
Xsky130_fd_sc_hd__nand2_1_54 \$5592 \$5662
+ vss
+ vdd
+ vdd
+ \$5876 sky130_fd_sc_hd__nand2_1
* cell instance sky130_fd_sc_hd__nand2_1_55 r0 *1 0,0
Xsky130_fd_sc_hd__nand2_1_55 \$2324 \$191
+ vss
+ vdd
+ vdd
+ \$2439 sky130_fd_sc_hd__nand2_1
* cell instance sky130_fd_sc_hd__nand2_1_56 r0 *1 0,0
Xsky130_fd_sc_hd__nand2_1_56 \$5022 \$5547
+ vss
+ vdd
+ vdd
+ \$5079 sky130_fd_sc_hd__nand2_1
* cell instance sky130_fd_sc_hd__nand2_1_57 r0 *1 0,0
Xsky130_fd_sc_hd__nand2_1_57 \$631 \$1308
+ vss
+ vdd
+ vdd
+ \$1405 sky130_fd_sc_hd__nand2_1
* cell instance sky130_fd_sc_hd__nand2_1_58 r0 *1 0,0
Xsky130_fd_sc_hd__nand2_1_58 \$3257 \$1561
+ vss
+ vdd
+ vdd
+ \$3391 sky130_fd_sc_hd__nand2_1
* cell instance sky130_fd_sc_hd__nand2_1_59 r0 *1 0,0
Xsky130_fd_sc_hd__nand2_1_59 \$2440 \$1561
+ vss
+ vdd
+ vdd
+ \$2442 sky130_fd_sc_hd__nand2_1
* cell instance sky130_fd_sc_hd__nand2_1_60 r0 *1 0,0
Xsky130_fd_sc_hd__nand2_1_60 \$5475 \$7191
+ vss
+ vdd
+ vdd
+ \$7426 sky130_fd_sc_hd__nand2_1
* cell instance sky130_fd_sc_hd__nand2_1_61 r0 *1 0,0
Xsky130_fd_sc_hd__nand2_1_61 \$6188 \$7516
+ vss
+ vdd
+ vdd
+ \$7596 sky130_fd_sc_hd__nand2_1
* cell instance sky130_fd_sc_hd__nand2_1_62 r0 *1 0,0
Xsky130_fd_sc_hd__nand2_1_62 \$574 \$576
+ vss
+ vdd
+ vdd
+ \$575 sky130_fd_sc_hd__nand2_1
* cell instance sky130_fd_sc_hd__nand2_1_63 r0 *1 0,0
Xsky130_fd_sc_hd__nand2_1_63 \$2659 \$191
+ vss
+ vdd
+ vdd
+ \$2333 sky130_fd_sc_hd__nand2_1
* cell instance sky130_fd_sc_hd__nand2_1_64 r0 *1 0,0
Xsky130_fd_sc_hd__nand2_1_64 \$3712 \$191
+ vss
+ vdd
+ vdd
+ \$3196 sky130_fd_sc_hd__nand2_1
* cell instance sky130_fd_sc_hd__nand2_1_65 r0 *1 0,0
Xsky130_fd_sc_hd__nand2_1_65 \$717 \$720
+ vss
+ vdd
+ vdd
+ \$712 sky130_fd_sc_hd__nand2_1
* cell instance sky130_fd_sc_hd__nand2_1_66 r0 *1 0,0
Xsky130_fd_sc_hd__nand2_1_66 \$4062 \$290
+ vss
+ vdd
+ vdd
+ \$4132 sky130_fd_sc_hd__nand2_1
* cell instance sky130_fd_sc_hd__nand2_1_67 r0 *1 0,0
Xsky130_fd_sc_hd__nand2_1_67 \$716 \$718
+ vss
+ vdd
+ vdd
+ \$872 sky130_fd_sc_hd__nand2_1
* cell instance sky130_fd_sc_hd__nand2_1_68 r0 *1 0,0
Xsky130_fd_sc_hd__nand2_1_68 \$4457 \$290
+ vss
+ vdd
+ vdd
+ \$4388 sky130_fd_sc_hd__nand2_1
* cell instance sky130_fd_sc_hd__nand2_1_69 r0 *1 0,0
Xsky130_fd_sc_hd__nand2_1_69 \$3197 \$1561
+ vss
+ vdd
+ vdd
+ \$3392 sky130_fd_sc_hd__nand2_1
* cell instance sky130_fd_sc_hd__nand2_1_70 r0 *1 0,0
Xsky130_fd_sc_hd__nand2_1_70 \$2334 \$1561
+ vss
+ vdd
+ vdd
+ \$2335 sky130_fd_sc_hd__nand2_1
* cell instance sky130_fd_sc_hd__nand2_1_71 r0 *1 0,0
Xsky130_fd_sc_hd__nand2_1_71 \$2890 \$191
+ vss
+ vdd
+ vdd
+ \$2891 sky130_fd_sc_hd__nand2_1
* cell instance sky130_fd_sc_hd__nand2_1_72 r0 *1 0,0
Xsky130_fd_sc_hd__nand2_1_72 \$2892 \$1561
+ vss
+ vdd
+ vdd
+ \$2991 sky130_fd_sc_hd__nand2_1
* cell instance sky130_fd_sc_hd__nand2_1_73 r0 *1 0,0
Xsky130_fd_sc_hd__nand2_1_73 \$2250 \$191
+ vss
+ vdd
+ vdd
+ \$2251 sky130_fd_sc_hd__nand2_1
* cell instance sky130_fd_sc_hd__nand2_1_74 r0 *1 0,0
Xsky130_fd_sc_hd__nand2_1_74 \$5592 \$5571
+ vss
+ vdd
+ vdd
+ \$5570 sky130_fd_sc_hd__nand2_1
* cell instance sky130_fd_sc_hd__nand2_1_75 r0 *1 0,0
Xsky130_fd_sc_hd__nand2_1_75 \$2992 \$191
+ vss
+ vdd
+ vdd
+ \$2993 sky130_fd_sc_hd__nand2_1
* cell instance sky130_fd_sc_hd__nand2_1_76 r0 *1 0,0
Xsky130_fd_sc_hd__nand2_1_76 bus_rdata[15] \$2575
+ vss
+ vdd
+ vdd
+ \$3726 sky130_fd_sc_hd__nand2_1
* cell instance sky130_fd_sc_hd__nand2_1_77 r0 *1 0,0
Xsky130_fd_sc_hd__nand2_1_77 bus_rdata[23] \$2575
+ vss
+ vdd
+ vdd
+ \$4634 sky130_fd_sc_hd__nand2_1
* cell instance sky130_fd_sc_hd__nand2_1_78 r0 *1 0,0
Xsky130_fd_sc_hd__nand2_1_78 bus_rdata[21] \$2575
+ vss
+ vdd
+ vdd
+ \$4530 sky130_fd_sc_hd__nand2_1
* cell instance sky130_fd_sc_hd__nand2_1_79 r0 *1 0,0
Xsky130_fd_sc_hd__nand2_1_79 \$5475 \$5434
+ vss
+ vdd
+ vdd
+ \$5680 sky130_fd_sc_hd__nand2_1
* cell instance sky130_fd_sc_hd__nand2_1_80 r0 *1 0,0
Xsky130_fd_sc_hd__nand2_1_80 \$6220 \$5547
+ vss
+ vdd
+ vdd
+ \$6519 sky130_fd_sc_hd__nand2_1
* cell instance sky130_fd_sc_hd__nand2_1_81 r0 *1 0,0
Xsky130_fd_sc_hd__nand2_1_81 \$2252 \$1561
+ vss
+ vdd
+ vdd
+ \$2255 sky130_fd_sc_hd__nand2_1
* cell instance sky130_fd_sc_hd__nand2_1_82 r0 *1 0,0
Xsky130_fd_sc_hd__nand2_1_82 \$6777 \$5547
+ vss
+ vdd
+ vdd
+ \$7030 sky130_fd_sc_hd__nand2_1
* cell instance sky130_fd_sc_hd__nand2_1_83 r0 *1 0,0
Xsky130_fd_sc_hd__nand2_1_83 \$2995 \$1561
+ vss
+ vdd
+ vdd
+ \$3080 sky130_fd_sc_hd__nand2_1
* cell instance sky130_fd_sc_hd__nand2_1_84 r0 *1 0,0
Xsky130_fd_sc_hd__nand2_1_84 \$5475 \$5785
+ vss
+ vdd
+ vdd
+ \$6521 sky130_fd_sc_hd__nand2_1
* cell instance sky130_fd_sc_hd__nand2_1_85 r0 *1 0,0
Xsky130_fd_sc_hd__nand2_1_85 \$5592 \$6610
+ vss
+ vdd
+ vdd
+ \$6703 sky130_fd_sc_hd__nand2_1
* cell instance sky130_fd_sc_hd__nand2_1_86 r0 *1 0,0
Xsky130_fd_sc_hd__nand2_1_86 \$1146 \$1316
+ vss
+ vdd
+ vdd
+ \$281 sky130_fd_sc_hd__nand2_1
* cell instance sky130_fd_sc_hd__nand2_1_87 r0 *1 0,0
Xsky130_fd_sc_hd__nand2_1_87 \$30 \$191
+ vss
+ vdd
+ vdd
+ \$105 sky130_fd_sc_hd__nand2_1
* cell instance sky130_fd_sc_hd__nand2_1_88 r0 *1 0,0
Xsky130_fd_sc_hd__nand2_1_88 bus_rdata[17] \$2575
+ vss
+ vdd
+ vdd
+ \$2998 sky130_fd_sc_hd__nand2_1
* cell instance sky130_fd_sc_hd__nand2_1_89 r0 *1 0,0
Xsky130_fd_sc_hd__nand2_1_89 \$1014 \$1010
+ vss
+ vdd
+ vdd
+ \$1225 sky130_fd_sc_hd__nand2_1
* cell instance sky130_fd_sc_hd__nand2_1_90 r0 *1 0,0
Xsky130_fd_sc_hd__nand2_1_90 \$5455 \$5547
+ vss
+ vdd
+ vdd
+ \$5577 sky130_fd_sc_hd__nand2_1
* cell instance sky130_fd_sc_hd__nand2_1_91 r0 *1 0,0
Xsky130_fd_sc_hd__nand2_1_91 \$1586 \$1752
+ vss
+ vdd
+ vdd
+ \$1771 sky130_fd_sc_hd__nand2_1
* cell instance sky130_fd_sc_hd__nand2_1_92 r0 *1 0,0
Xsky130_fd_sc_hd__nand2_1_92 \$1752 \$3842
+ vss
+ vdd
+ vdd
+ \$4085 sky130_fd_sc_hd__nand2_1
* cell instance sky130_fd_sc_hd__nand2_1_93 r0 *1 0,0
Xsky130_fd_sc_hd__nand2_1_93 \$5475 \$6700
+ vss
+ vdd
+ vdd
+ \$6961 sky130_fd_sc_hd__nand2_1
* cell instance sky130_fd_sc_hd__nand2_1_94 r0 *1 0,0
Xsky130_fd_sc_hd__nand2_1_94 \$6188 \$7540
+ vss
+ vdd
+ vdd
+ \$7624 sky130_fd_sc_hd__nand2_1
* cell instance sky130_fd_sc_hd__nand2_1_95 r0 *1 0,0
Xsky130_fd_sc_hd__nand2_1_95 \$35 \$182
+ vss
+ vdd
+ vdd
+ \$181 sky130_fd_sc_hd__nand2_1
* cell instance sky130_fd_sc_hd__nand2_1_96 r0 *1 0,0
Xsky130_fd_sc_hd__nand2_1_96 bus_rdata[7] \$2575
+ vss
+ vdd
+ vdd
+ \$3000 sky130_fd_sc_hd__nand2_1
* cell instance sky130_fd_sc_hd__nand2_1_97 r0 *1 0,0
Xsky130_fd_sc_hd__nand2_1_97 \$5475 \$7078
+ vss
+ vdd
+ vdd
+ \$7541 sky130_fd_sc_hd__nand2_1
* cell instance sky130_fd_sc_hd__nand2_1_98 r0 *1 0,0
Xsky130_fd_sc_hd__nand2_1_98 \$221 \$598
+ vss
+ vdd
+ vdd
+ \$456 sky130_fd_sc_hd__nand2_1
* cell instance sky130_fd_sc_hd__nand2_1_99 r0 *1 0,0
Xsky130_fd_sc_hd__nand2_1_99 \$1669 \$2351
+ vss
+ vdd
+ vdd
+ \$683 sky130_fd_sc_hd__nand2_1
* cell instance sky130_fd_sc_hd__nand2_1_100 r0 *1 0,0
Xsky130_fd_sc_hd__nand2_1_100 \$6188 \$6963
+ vss
+ vdd
+ vdd
+ \$6964 sky130_fd_sc_hd__nand2_1
* cell instance sky130_fd_sc_hd__nand2_1_101 r0 *1 0,0
Xsky130_fd_sc_hd__nand2_1_101 \$3093
+ a|inv_q_y|inv_q_y_via|inv_q_y_via2|nand_s2_a|nand_s2_a_stub|nand_s2_a_via|nand_s2_a_via2|q|raw_valid|y
+ vss
+ vdd
+ vdd
+ \$3134 sky130_fd_sc_hd__nand2_1
* cell instance sky130_fd_sc_hd__nand2_1_102 r0 *1 0,0
Xsky130_fd_sc_hd__nand2_1_102 \$4286 \$4202
+ vss
+ vdd
+ vdd
+ \$3735 sky130_fd_sc_hd__nand2_1
* cell instance sky130_fd_sc_hd__nand2_1_103 r0 *1 0,0
Xsky130_fd_sc_hd__nand2_1_103 \$573 \$598
+ vss
+ vdd
+ vdd
+ \$525 sky130_fd_sc_hd__nand2_1
* cell instance sky130_fd_sc_hd__nand2_1_104 r0 *1 0,0
Xsky130_fd_sc_hd__nand2_1_104 \$1508 \$598
+ vss
+ vdd
+ vdd
+ \$1517 sky130_fd_sc_hd__nand2_1
* cell instance sky130_fd_sc_hd__nand2_1_105 r0 *1 0,0
Xsky130_fd_sc_hd__nand2_1_105 \$1516 \$1669
+ vss
+ vdd
+ vdd
+ \$1773 sky130_fd_sc_hd__nand2_1
* cell instance sky130_fd_sc_hd__nand2_1_106 r0 *1 0,0
Xsky130_fd_sc_hd__nand2_1_106 \$3513 \$4286
+ vss
+ vdd
+ vdd
+ \$3961 sky130_fd_sc_hd__nand2_1
* cell instance sky130_fd_sc_hd__nand2_1_107 r0 *1 0,0
Xsky130_fd_sc_hd__nand2_1_107 \$106 \$191
+ vss
+ vdd
+ vdd
+ \$185 sky130_fd_sc_hd__nand2_1
* cell instance sky130_fd_sc_hd__nand2_1_108 r0 *1 0,0
Xsky130_fd_sc_hd__nand2_1_108 \$6188 \$7628
+ vss
+ vdd
+ vdd
+ \$7696 sky130_fd_sc_hd__nand2_1
* cell instance sky130_fd_sc_hd__nand2_1_109 r0 *1 0,0
Xsky130_fd_sc_hd__nand2_1_109 \$3088 \$2569
+ vss
+ vdd
+ vdd
+ \$3228 sky130_fd_sc_hd__nand2_1
* cell instance sky130_fd_sc_hd__nand2_1_110 r0 *1 0,0
Xsky130_fd_sc_hd__nand2_1_110 \$5475 \$7305
+ vss
+ vdd
+ vdd
+ \$7629 sky130_fd_sc_hd__nand2_1
* cell instance sky130_fd_sc_hd__nand2_1_111 r0 *1 0,0
Xsky130_fd_sc_hd__nand2_1_111 \$1235 \$191
+ vss
+ vdd
+ vdd
+ \$1326 sky130_fd_sc_hd__nand2_1
* cell instance sky130_fd_sc_hd__nand2_1_112 r0 *1 0,0
Xsky130_fd_sc_hd__nand2_1_112 \$5592 \$6622
+ vss
+ vdd
+ vdd
+ \$6797 sky130_fd_sc_hd__nand2_1
* cell instance sky130_fd_sc_hd__nand2_1_113 r0 *1 0,0
Xsky130_fd_sc_hd__nand2_1_113 \$114 \$182
+ vss
+ vdd
+ vdd
+ \$253 sky130_fd_sc_hd__nand2_1
* cell instance sky130_fd_sc_hd__nand2_1_114 r0 *1 0,0
Xsky130_fd_sc_hd__nand2_1_114 \$3735 \$3848
+ vss
+ vdd
+ vdd
+ \$2803 sky130_fd_sc_hd__nand2_1
* cell instance sky130_fd_sc_hd__nand2_1_115 r0 *1 0,0
Xsky130_fd_sc_hd__nand2_1_115 \$6796 \$5547
+ vss
+ vdd
+ vdd
+ \$6798 sky130_fd_sc_hd__nand2_1
* cell instance sky130_fd_sc_hd__nand2_1_116 r0 *1 0,0
Xsky130_fd_sc_hd__nand2_1_116 \$5475 \$4301
+ vss
+ vdd
+ vdd
+ \$6235 sky130_fd_sc_hd__nand2_1
* cell instance sky130_fd_sc_hd__nand2_1_117 r0 *1 0,0
Xsky130_fd_sc_hd__nand2_1_117 \$5475 \$6454
+ vss
+ vdd
+ vdd
+ \$6623 sky130_fd_sc_hd__nand2_1
* cell instance sky130_fd_sc_hd__nand2_1_118 r0 *1 0,0
Xsky130_fd_sc_hd__nand2_1_118 \$526 \$191
+ vss
+ vdd
+ vdd
+ \$527 sky130_fd_sc_hd__nand2_1
* cell instance sky130_fd_sc_hd__nand2_1_119 r0 *1 0,0
Xsky130_fd_sc_hd__nand2_1_119 \$1095 \$683
+ vss
+ vdd
+ vdd
+ \$889 sky130_fd_sc_hd__nand2_1
* cell instance sky130_fd_sc_hd__nand2_1_120 r0 *1 0,0
Xsky130_fd_sc_hd__nand2_1_120 \$2353 \$2847
+ vss
+ vdd
+ vdd
+ \$2684 sky130_fd_sc_hd__nand2_1
* cell instance sky130_fd_sc_hd__nand2_1_121 r0 *1 0,0
Xsky130_fd_sc_hd__nand2_1_121 \$746 \$180
+ vss
+ vdd
+ vdd
+ \$657 sky130_fd_sc_hd__nand2_1
* cell instance sky130_fd_sc_hd__nand2_1_122 r0 *1 0,0
Xsky130_fd_sc_hd__nand2_1_122 bus_we \$3260
+ vss
+ vdd
+ vdd
+ \$3318 sky130_fd_sc_hd__nand2_1
* cell instance sky130_fd_sc_hd__nand2_1_123 r0 *1 0,0
Xsky130_fd_sc_hd__nand2_1_123 \$1243 \$182
+ vss
+ vdd
+ vdd
+ \$1329 sky130_fd_sc_hd__nand2_1
* cell instance sky130_fd_sc_hd__nand2_1_124 r0 *1 0,0
Xsky130_fd_sc_hd__nand2_1_124 \$2682 \$3232
+ vss
+ vdd
+ vdd
+ \$3412 sky130_fd_sc_hd__nand2_1
* cell instance sky130_fd_sc_hd__nand2_1_125 r0 *1 0,0
Xsky130_fd_sc_hd__nand2_1_125 \$5592 \$6333
+ vss
+ vdd
+ vdd
+ \$6334 sky130_fd_sc_hd__nand2_1
* cell instance sky130_fd_sc_hd__nand2_1_126 r0 *1 0,0
Xsky130_fd_sc_hd__nand2_1_126 \$7630 \$5547
+ vss
+ vdd
+ vdd
+ \$7858 sky130_fd_sc_hd__nand2_1
* cell instance sky130_fd_sc_hd__nand2_1_127 r0 *1 0,0
Xsky130_fd_sc_hd__nand2_1_127 \$182 \$658
+ vss
+ vdd
+ vdd
+ \$819 sky130_fd_sc_hd__nand2_1
* cell instance sky130_fd_sc_hd__nand2_1_128 r0 *1 0,0
Xsky130_fd_sc_hd__nand2_1_128 bus_rdata[18] \$2486
+ vss
+ vdd
+ vdd
+ \$4413 sky130_fd_sc_hd__nand2_1
* cell instance sky130_fd_sc_hd__nand2_1_129 r0 *1 0,0
Xsky130_fd_sc_hd__nand2_1_129 \$3735 \$3232
+ vss
+ vdd
+ vdd
+ \$3631 sky130_fd_sc_hd__nand2_1
* cell instance sky130_fd_sc_hd__nand2_1_130 r0 *1 0,0
Xsky130_fd_sc_hd__nand2_1_130 \$321 \$191
+ vss
+ vdd
+ vdd
+ \$386 sky130_fd_sc_hd__nand2_1
* cell instance sky130_fd_sc_hd__nand2_1_131 r0 *1 0,0
Xsky130_fd_sc_hd__nand2_1_131 \$1561 \$1814
+ vss
+ vdd
+ vdd
+ \$1775 sky130_fd_sc_hd__nand2_1
* cell instance sky130_fd_sc_hd__nand2_1_132 r0 *1 0,0
Xsky130_fd_sc_hd__nand2_1_132 \$1879 \$191
+ vss
+ vdd
+ vdd
+ \$1965 sky130_fd_sc_hd__nand2_1
* cell instance sky130_fd_sc_hd__nand2_1_133 r0 *1 0,0
Xsky130_fd_sc_hd__nand2_1_133 \$460 \$180
+ vss
+ vdd
+ vdd
+ \$387 sky130_fd_sc_hd__nand2_1
* cell instance sky130_fd_sc_hd__nand2_1_134 r0 *1 0,0
Xsky130_fd_sc_hd__nand2_1_134 \$1330 \$191
+ vss
+ vdd
+ vdd
+ \$1522 sky130_fd_sc_hd__nand2_1
* cell instance sky130_fd_sc_hd__nand2_1_135 r0 *1 0,0
Xsky130_fd_sc_hd__nand2_1_135 \$116 \$191
+ vss
+ vdd
+ vdd
+ \$190 sky130_fd_sc_hd__nand2_1
* cell instance sky130_fd_sc_hd__nand2_1_136 r0 *1 0,0
Xsky130_fd_sc_hd__nand2_1_136 \$962 \$683
+ vss
+ vdd
+ vdd
+ \$1026 sky130_fd_sc_hd__nand2_1
* cell instance sky130_fd_sc_hd__nand2_1_137 r0 *1 0,0
Xsky130_fd_sc_hd__nand2_1_137 \$2579 \$2814
+ vss
+ vdd
+ vdd
+ \$2686 sky130_fd_sc_hd__nand2_1
* cell instance sky130_fd_sc_hd__nand2_1_138 r0 *1 0,0
Xsky130_fd_sc_hd__nand2_1_138 \$2579 \$3232
+ vss
+ vdd
+ vdd
+ \$2908 sky130_fd_sc_hd__nand2_1
* cell instance sky130_fd_sc_hd__nand2_1_139 r0 *1 0,0
Xsky130_fd_sc_hd__nand2_1_139 \$182 \$257
+ vss
+ vdd
+ vdd
+ \$530 sky130_fd_sc_hd__nand2_1
* cell instance sky130_fd_sc_hd__nand2_1_140 r0 *1 0,0
Xsky130_fd_sc_hd__nand2_1_140 \$50 \$180
+ vss
+ vdd
+ vdd
+ \$330 sky130_fd_sc_hd__nand2_1
* cell instance sky130_fd_sc_hd__nand2_1_141 r0 *1 0,0
Xsky130_fd_sc_hd__nand2_1_141 \$5592 \$5477
+ vss
+ vdd
+ vdd
+ \$5594 sky130_fd_sc_hd__nand2_1
* cell instance sky130_fd_sc_hd__nand2_1_142 r0 *1 0,0
Xsky130_fd_sc_hd__nand2_1_142 \$1523 \$182
+ vss
+ vdd
+ vdd
+ \$1602 sky130_fd_sc_hd__nand2_1
* cell instance sky130_fd_sc_hd__nand2_1_143 r0 *1 0,0
Xsky130_fd_sc_hd__nand2_1_143 \$2814 \$2687
+ vss
+ vdd
+ vdd
+ \$2801 sky130_fd_sc_hd__nand2_1
* cell instance sky130_fd_sc_hd__nand2_1_144 r0 *1 0,0
Xsky130_fd_sc_hd__nand2_1_144 \$5475 \$4560
+ vss
+ vdd
+ vdd
+ \$5478 sky130_fd_sc_hd__nand2_1
* cell instance sky130_fd_sc_hd__nand2_1_145 r0 *1 0,0
Xsky130_fd_sc_hd__nand2_1_145 \$5475 \$6321
+ vss
+ vdd
+ vdd
+ \$6887 sky130_fd_sc_hd__nand2_1
* cell instance sky130_fd_sc_hd__nand2_1_146 r0 *1 0,0
Xsky130_fd_sc_hd__nand2_1_146 \$822 \$191
+ vss
+ vdd
+ vdd
+ \$1104 sky130_fd_sc_hd__nand2_1
* cell instance sky130_fd_sc_hd__nand2_1_147 r0 *1 0,0
Xsky130_fd_sc_hd__nand2_1_147 \$5592 \$6977
+ vss
+ vdd
+ vdd
+ \$7164 sky130_fd_sc_hd__nand2_1
* cell instance sky130_fd_sc_hd__nand2_1_148 r0 *1 0,0
Xsky130_fd_sc_hd__nand2_1_148 \$5475 \$6724
+ vss
+ vdd
+ vdd
+ \$6723 sky130_fd_sc_hd__nand2_1
* cell instance sky130_fd_sc_hd__nand2_1_149 r0 *1 0,0
Xsky130_fd_sc_hd__nand2_1_149 \$5592 \$6889
+ vss
+ vdd
+ vdd
+ \$6888 sky130_fd_sc_hd__nand2_1
* cell instance sky130_fd_sc_hd__nand2_1_150 r0 *1 0,0
Xsky130_fd_sc_hd__nand2_1_150 \$182 \$261
+ vss
+ vdd
+ vdd
+ \$469 sky130_fd_sc_hd__nand2_1
* cell instance sky130_fd_sc_hd__nand2_1_151 r0 *1 0,0
Xsky130_fd_sc_hd__nand2_1_151 \$1105 \$180
+ vss
+ vdd
+ vdd
+ \$1184 sky130_fd_sc_hd__nand2_1
* cell instance sky130_fd_sc_hd__nand2_1_152 r0 *1 0,0
Xsky130_fd_sc_hd__nand2_1_152 bus_wdata[2] \$3261
+ vss
+ vdd
+ vdd
+ \$3331 sky130_fd_sc_hd__nand2_1
* cell instance sky130_fd_sc_hd__nand2_1_153 r0 *1 0,0
Xsky130_fd_sc_hd__nand2_1_153 \$3240 \$3351
+ vss
+ vdd
+ vdd
+ \$3630 sky130_fd_sc_hd__nand2_1
* cell instance sky130_fd_sc_hd__nand2_1_154 r0 *1 0,0
Xsky130_fd_sc_hd__nand2_1_154 \$182 \$1185
+ vss
+ vdd
+ vdd
+ \$1255 sky130_fd_sc_hd__nand2_1
* cell instance sky130_fd_sc_hd__nand2_1_155 r0 *1 0,0
Xsky130_fd_sc_hd__nand2_1_155 \$182 \$1340
+ vss
+ vdd
+ vdd
+ \$1450 sky130_fd_sc_hd__nand2_1
* cell instance sky130_fd_sc_hd__nand2_1_156 r0 *1 0,0
Xsky130_fd_sc_hd__nand2_1_156 \$1603 \$683
+ vss
+ vdd
+ vdd
+ \$1526 sky130_fd_sc_hd__nand2_1
* cell instance sky130_fd_sc_hd__nand2_1_157 r0 *1 0,0
Xsky130_fd_sc_hd__nand2_1_157 \$7249 \$5547
+ vss
+ vdd
+ vdd
+ \$7401 sky130_fd_sc_hd__nand2_1
* cell instance sky130_fd_sc_hd__nand2_1_158 r0 *1 0,0
Xsky130_fd_sc_hd__nand2_1_158 \$60 \$191
+ vss
+ vdd
+ vdd
+ \$194 sky130_fd_sc_hd__nand2_1
* cell instance sky130_fd_sc_hd__nand2_1_159 r0 *1 0,0
Xsky130_fd_sc_hd__nand2_1_159 \$332 \$180
+ vss
+ vdd
+ vdd
+ \$265 sky130_fd_sc_hd__nand2_1
* cell instance sky130_fd_sc_hd__nand2_1_160 r0 *1 0,0
Xsky130_fd_sc_hd__nand2_1_160 \$757 \$683
+ vss
+ vdd
+ vdd
+ \$758 sky130_fd_sc_hd__nand2_1
* cell instance sky130_fd_sc_hd__nand2_1_161 r0 *1 0,0
Xsky130_fd_sc_hd__nand2_1_161 \$1788 \$191
+ vss
+ vdd
+ vdd
+ \$1976 sky130_fd_sc_hd__nand2_1
* cell instance sky130_fd_sc_hd__nand2_1_162 r0 *1 0,0
Xsky130_fd_sc_hd__nand2_1_162 \$5707 \$5547
+ vss
+ vdd
+ vdd
+ \$6153 sky130_fd_sc_hd__nand2_1
* cell instance sky130_fd_sc_hd__nand2_1_163 r0 *1 0,0
Xsky130_fd_sc_hd__nand2_1_163 \$182 \$266
+ vss
+ vdd
+ vdd
+ \$400 sky130_fd_sc_hd__nand2_1
* cell instance sky130_fd_sc_hd__nand2_1_164 r0 *1 0,0
Xsky130_fd_sc_hd__nand2_1_164 \$834 \$683
+ vss
+ vdd
+ vdd
+ \$835 sky130_fd_sc_hd__nand2_1
* cell instance sky130_fd_sc_hd__nand2_1_165 r0 *1 0,0
Xsky130_fd_sc_hd__nand2_1_165 \$2579 \$2815
+ vss
+ vdd
+ vdd
+ \$3088 sky130_fd_sc_hd__nand2_1
* cell instance sky130_fd_sc_hd__nand2_1_166 r0 *1 0,0
Xsky130_fd_sc_hd__nand2_1_166 bus_addr[0] bus_addr[1]
+ vss
+ vdd
+ vdd
+ \$3333 sky130_fd_sc_hd__nand2_1
* cell instance sky130_fd_sc_hd__nand2_1_167 r0 *1 0,0
Xsky130_fd_sc_hd__nand2_1_167 \$1373 \$683
+ vss
+ vdd
+ vdd
+ \$1607 sky130_fd_sc_hd__nand2_1
* cell instance sky130_fd_sc_hd__nand2_1_168 r0 *1 0,0
Xsky130_fd_sc_hd__nand2_1_168 \$972 \$191
+ vss
+ vdd
+ vdd
+ \$1189 sky130_fd_sc_hd__nand2_1
* cell instance sky130_fd_sc_hd__nand2_1_169 r0 *1 0,0
Xsky130_fd_sc_hd__nand2_1_169 \$899 \$180
+ vss
+ vdd
+ vdd
+ \$1115 sky130_fd_sc_hd__nand2_1
* cell instance sky130_fd_sc_hd__nand2_1_170 r0 *1 0,0
Xsky130_fd_sc_hd__nand2_1_170 \$2815 \$837
+ vss
+ vdd
+ vdd
+ \$2848 sky130_fd_sc_hd__nand2_1
* cell instance sky130_fd_sc_hd__nand2_1_171 r0 *1 0,0
Xsky130_fd_sc_hd__nand2_1_171 \$3631 \$3013
+ vss
+ vdd
+ vdd
+ \$3633 sky130_fd_sc_hd__nand2_1
* cell instance sky130_fd_sc_hd__nand2_1_172 r0 *1 0,0
Xsky130_fd_sc_hd__nand2_1_172 \$196 \$191
+ vss
+ vdd
+ vdd
+ \$197 sky130_fd_sc_hd__nand2_1
* cell instance sky130_fd_sc_hd__nand2_1_173 r0 *1 0,0
Xsky130_fd_sc_hd__nand2_1_173 \$1977 \$182
+ vss
+ vdd
+ vdd
+ \$1980 sky130_fd_sc_hd__nand2_1
* cell instance sky130_fd_sc_hd__nand2_1_174 r0 *1 0,0
Xsky130_fd_sc_hd__nand2_1_174 \$760 \$683
+ vss
+ vdd
+ vdd
+ \$682 sky130_fd_sc_hd__nand2_1
* cell instance sky130_fd_sc_hd__nand2_1_175 r0 *1 0,0
Xsky130_fd_sc_hd__nand2_1_175 \$268 \$180
+ vss
+ vdd
+ vdd
+ \$269 sky130_fd_sc_hd__nand2_1
* cell instance sky130_fd_sc_hd__nand2_1_176 r0 *1 0,0
Xsky130_fd_sc_hd__nand2_1_176 \$182 \$1193
+ vss
+ vdd
+ vdd
+ \$1257 sky130_fd_sc_hd__nand2_1
* cell instance sky130_fd_sc_hd__nand2_1_177 r0 *1 0,0
Xsky130_fd_sc_hd__nand2_1_177 \$182 \$270
+ vss
+ vdd
+ vdd
+ \$402 sky130_fd_sc_hd__nand2_1
* cell instance sky130_fd_sc_hd__nand2_1_178 r0 *1 0,0
Xsky130_fd_sc_hd__nand2_1_178 \$4560 \$4802
+ vss
+ vdd
+ vdd
+ \$5602 sky130_fd_sc_hd__nand2_1
* cell instance sky130_fd_sc_hd__nand2_1_179 r0 *1 0,0
Xsky130_fd_sc_hd__nand2_1_179 \$1038 \$191
+ vss
+ vdd
+ vdd
+ \$1039 sky130_fd_sc_hd__nand2_1
* cell instance sky130_fd_sc_hd__nand2_1_180 r0 *1 0,0
Xsky130_fd_sc_hd__nand2_1_180 \$7258 \$5547
+ vss
+ vdd
+ vdd
+ \$7571 sky130_fd_sc_hd__nand2_1
* cell instance sky130_fd_sc_hd__nand2_1_181 r0 *1 0,0
Xsky130_fd_sc_hd__nand2_1_181 \$6251 \$5547
+ vss
+ vdd
+ vdd
+ \$6157 sky130_fd_sc_hd__nand2_1
* cell instance sky130_fd_sc_hd__nand2_1_182 r0 *1 0,0
Xsky130_fd_sc_hd__nand2_1_182 \$6894 \$5547
+ vss
+ vdd
+ vdd
+ \$6818 sky130_fd_sc_hd__nand2_1
* cell instance sky130_fd_sc_hd__nand2_1_183 r0 *1 0,0
Xsky130_fd_sc_hd__nand2_1_183 \$840 \$683
+ vss
+ vdd
+ vdd
+ \$841 sky130_fd_sc_hd__nand2_1
* cell instance sky130_fd_sc_hd__nand2_1_184 r0 *1 0,0
Xsky130_fd_sc_hd__nand2_1_184 \$70 \$191
+ vss
+ vdd
+ vdd
+ \$272 sky130_fd_sc_hd__nand2_1
* cell instance sky130_fd_sc_hd__nand2_1_185 r0 *1 0,0
Xsky130_fd_sc_hd__nand2_1_185 \$129 \$180
+ vss
+ vdd
+ vdd
+ \$349 sky130_fd_sc_hd__nand2_1
* cell instance sky130_fd_sc_hd__nand2_1_186 r0 *1 0,0
Xsky130_fd_sc_hd__nand2_1_186 \$1040 \$182
+ vss
+ vdd
+ vdd
+ \$1042 sky130_fd_sc_hd__nand2_1
* cell instance sky130_fd_sc_hd__nand2_1_187 r0 *1 0,0
Xsky130_fd_sc_hd__nand2_1_187 \$1349 \$191
+ vss
+ vdd
+ vdd
+ \$1454 sky130_fd_sc_hd__nand2_1
* cell instance sky130_fd_sc_hd__nand2_1_188 r0 *1 0,0
Xsky130_fd_sc_hd__nand2_1_188 \$2579 \$3337
+ vss
+ vdd
+ vdd
+ \$3116 sky130_fd_sc_hd__nand2_1
* cell instance sky130_fd_sc_hd__nand2_1_189 r0 *1 0,0
Xsky130_fd_sc_hd__nand2_1_189 bus_rdata[27] \$2486
+ vss
+ vdd
+ vdd
+ \$4564 sky130_fd_sc_hd__nand2_1
* cell instance sky130_fd_sc_hd__nand2_1_190 r0 *1 0,0
Xsky130_fd_sc_hd__nand2_1_190 \$182 \$483
+ vss
+ vdd
+ vdd
+ \$485 sky130_fd_sc_hd__nand2_1
* cell instance sky130_fd_sc_hd__nand2_1_191 r0 *1 0,0
Xsky130_fd_sc_hd__nand2_1_191 \$1799 \$191
+ vss
+ vdd
+ vdd
+ \$2284 sky130_fd_sc_hd__nand2_1
* cell instance sky130_fd_sc_hd__nand2_1_192 r0 *1 0,0
Xsky130_fd_sc_hd__nand2_1_192 \$691 \$191
+ vss
+ vdd
+ vdd
+ \$771 sky130_fd_sc_hd__nand2_1
* cell instance sky130_fd_sc_hd__nand2_1_193 r0 *1 0,0
Xsky130_fd_sc_hd__nand2_1_193 \$2385 \$182
+ vss
+ vdd
+ vdd
+ \$2490 sky130_fd_sc_hd__nand2_1
* cell instance sky130_fd_sc_hd__nand2_1_194 r0 *1 0,0
Xsky130_fd_sc_hd__nand2_1_194 \$139 \$191
+ vss
+ vdd
+ vdd
+ \$203 sky130_fd_sc_hd__nand2_1
* cell instance sky130_fd_sc_hd__nand2_1_195 r0 *1 0,0
Xsky130_fd_sc_hd__nand2_1_195 \$1455 \$182
+ vss
+ vdd
+ vdd
+ \$1456 sky130_fd_sc_hd__nand2_1
* cell instance sky130_fd_sc_hd__nand2_1_196 r0 *1 0,0
Xsky130_fd_sc_hd__nand2_1_196 \$80 \$180
+ vss
+ vdd
+ vdd
+ \$275 sky130_fd_sc_hd__nand2_1
* cell instance sky130_fd_sc_hd__nand2_1_197 r0 *1 0,0
Xsky130_fd_sc_hd__nand2_1_197 bus_rdata[31] \$2486
+ vss
+ vdd
+ vdd
+ \$4910 sky130_fd_sc_hd__nand2_1
* cell instance sky130_fd_sc_hd__nand2_1_198 r0 *1 0,0
Xsky130_fd_sc_hd__nand2_1_198 \$182 \$276
+ vss
+ vdd
+ vdd
+ \$278 sky130_fd_sc_hd__nand2_1
* cell instance sky130_fd_sc_hd__nand2_1_199 r0 *1 0,0
Xsky130_fd_sc_hd__nand2_1_199 \$700 \$182
+ vss
+ vdd
+ vdd
+ \$776 sky130_fd_sc_hd__nand2_1
* cell instance sky130_fd_sc_hd__nand2_1_200 r0 *1 0,0
Xsky130_fd_sc_hd__nand2_1_200 bus_rdata[29] \$2486
+ vss
+ vdd
+ vdd
+ \$4337 sky130_fd_sc_hd__nand2_1
* cell instance sky130_fd_sc_hd__nand2_1_201 r0 *1 0,0
Xsky130_fd_sc_hd__nand2_1_201 bus_rdata[19] \$2486
+ vss
+ vdd
+ vdd
+ \$2495 sky130_fd_sc_hd__nand2_1
* cell instance sky130_fd_sc_hd__nand2_1_202 r0 *1 0,0
Xsky130_fd_sc_hd__nand2_1_202 bus_rdata[25] \$2486
+ vss
+ vdd
+ vdd
+ \$2496 sky130_fd_sc_hd__nand2_1
* cell instance sky130_fd_sc_hd__nand2_1_203 r0 *1 0,0
Xsky130_fd_sc_hd__nand2_1_203 bus_rdata[24] \$2486
+ vss
+ vdd
+ vdd
+ \$4336 sky130_fd_sc_hd__nand2_1
* cell instance sky130_fd_sc_hd__nand2b_1_0 r0 *1 0,0
Xsky130_fd_sc_hd__nand2b_1_0 \$1150 \$1220
+ vss
+ vdd
+ vdd
+ \$563 sky130_fd_sc_hd__nand2b_1
* cell instance sky130_fd_sc_hd__nand2b_1_1 r0 *1 0,0
Xsky130_fd_sc_hd__nand2b_1_1 \$1080 \$1075
+ vss
+ vdd
+ vdd
+ \$580 sky130_fd_sc_hd__nand2b_1
* cell instance sky130_fd_sc_hd__nand2b_1_2 r0 *1 0,0
Xsky130_fd_sc_hd__nand2b_1_2 \$1156 \$1079
+ vss
+ vdd
+ vdd
+ \$1150 sky130_fd_sc_hd__nand2b_1
* cell instance sky130_fd_sc_hd__nand2b_1_3 r0 *1 0,0
Xsky130_fd_sc_hd__nand2b_1_3 \$565 \$877
+ vss
+ vdd
+ vdd
+ \$1011 sky130_fd_sc_hd__nand2b_1
* cell instance sky130_fd_sc_hd__nand2b_1_4 r0 *1 0,0
Xsky130_fd_sc_hd__nand2b_1_4 \$1156 \$1083
+ vss
+ vdd
+ vdd
+ \$574 sky130_fd_sc_hd__nand2b_1
* cell instance sky130_fd_sc_hd__nand2b_1_5 r0 *1 0,0
Xsky130_fd_sc_hd__nand2b_1_5 \$242 \$399
+ vss
+ vdd
+ vdd
+ \$453 sky130_fd_sc_hd__nand2b_1
* cell instance sky130_fd_sc_hd__nand2b_1_6 r0 *1 0,0
Xsky130_fd_sc_hd__nand2b_1_6 \$312 \$399
+ vss
+ vdd
+ vdd
+ \$381 sky130_fd_sc_hd__nand2b_1
* cell instance sky130_fd_sc_hd__nand2b_1_7 r0 *1 0,0
Xsky130_fd_sc_hd__nand2b_1_7 \$1432 \$399
+ vss
+ vdd
+ vdd
+ \$1597 sky130_fd_sc_hd__nand2b_1
* cell instance sky130_fd_sc_hd__nand2b_1_8 r0 *1 0,0
Xsky130_fd_sc_hd__nand2b_1_8 bus_addr[0] bus_addr[1]
+ vss
+ vdd
+ vdd
+ \$2913 sky130_fd_sc_hd__nand2b_1
* cell instance sky130_fd_sc_hd__nand2b_1_9 r0 *1 0,0
Xsky130_fd_sc_hd__nand2b_1_9 bus_addr[3] bus_addr[2]
+ vss
+ vdd
+ vdd
+ \$3111 sky130_fd_sc_hd__nand2b_1
* cell instance sky130_fd_sc_hd__nand2b_1_10 r0 *1 0,0
Xsky130_fd_sc_hd__nand2b_1_10 bus_addr[1] bus_addr[0]
+ vss
+ vdd
+ vdd
+ \$2909 sky130_fd_sc_hd__nand2b_1
* cell instance sky130_fd_sc_hd__nand2b_1_11 r0 *1 0,0
Xsky130_fd_sc_hd__nand2b_1_11 bus_addr[2] bus_addr[3]
+ vss
+ vdd
+ vdd
+ \$3335 sky130_fd_sc_hd__nand2b_1
* cell instance sky130_fd_sc_hd__nand3_1_0 r0 *1 0,0
Xsky130_fd_sc_hd__nand3_1_0 \$3904 \$3767 \$4016
+ vss
+ vdd
+ vdd
+ \$4015 sky130_fd_sc_hd__nand3_1
* cell instance sky130_fd_sc_hd__nand3_1_1 r0 *1 0,0
Xsky130_fd_sc_hd__nand3_1_1 \$4574 \$4818 \$4481
+ vss
+ vdd
+ vdd
+ \$4018 sky130_fd_sc_hd__nand3_1
* cell instance sky130_fd_sc_hd__nand3_1_2 r0 *1 0,0
Xsky130_fd_sc_hd__nand3_1_2 \$3908 \$3885 \$3909
+ vss
+ vdd
+ vdd
+ \$3679 sky130_fd_sc_hd__nand3_1
* cell instance sky130_fd_sc_hd__nand3_1_3 r0 *1 0,0
Xsky130_fd_sc_hd__nand3_1_3 \$1146 \$4150 \$4358
+ vss
+ vdd
+ vdd
+ \$4248 sky130_fd_sc_hd__nand3_1
* cell instance sky130_fd_sc_hd__nand3_1_4 r0 *1 0,0
Xsky130_fd_sc_hd__nand3_1_4 \$5974 \$5978 \$5975
+ vss
+ vdd
+ vdd
+ \$5864 sky130_fd_sc_hd__nand3_1
* cell instance sky130_fd_sc_hd__nand3_1_5 r0 *1 0,0
Xsky130_fd_sc_hd__nand3_1_5 \$3165 \$3280 \$2633
+ vss
+ vdd
+ vdd
+ \$3169 sky130_fd_sc_hd__nand3_1
* cell instance sky130_fd_sc_hd__nand3_1_6 r0 *1 0,0
Xsky130_fd_sc_hd__nand3_1_6 \$2121 \$2012 \$1929
+ vss
+ vdd
+ vdd
+ \$2122 sky130_fd_sc_hd__nand3_1
* cell instance sky130_fd_sc_hd__nand3_1_7 r0 *1 0,0
Xsky130_fd_sc_hd__nand3_1_7 \$6286 \$6396 \$6398
+ vss
+ vdd
+ vdd
+ \$6397 sky130_fd_sc_hd__nand3_1
* cell instance sky130_fd_sc_hd__nand3_1_8 r0 *1 0,0
Xsky130_fd_sc_hd__nand3_1_8 \$6286 \$6396 \$6497
+ vss
+ vdd
+ vdd
+ \$5763 sky130_fd_sc_hd__nand3_1
* cell instance sky130_fd_sc_hd__nand3_1_9 r0 *1 0,0
Xsky130_fd_sc_hd__nand3_1_9 \$4604 \$4367 \$4365
+ vss
+ vdd
+ vdd
+ \$4605 sky130_fd_sc_hd__nand3_1
* cell instance sky130_fd_sc_hd__nand3_1_10 r0 *1 0,0
Xsky130_fd_sc_hd__nand3_1_10 \$565 \$930 \$788
+ vss
+ vdd
+ vdd
+ \$929 sky130_fd_sc_hd__nand3_1
* cell instance sky130_fd_sc_hd__nand3_1_11 r0 *1 0,0
Xsky130_fd_sc_hd__nand3_1_11 \$930 \$509 \$631
+ vss
+ vdd
+ vdd
+ \$1062 sky130_fd_sc_hd__nand3_1
* cell instance sky130_fd_sc_hd__nand3_1_12 r0 *1 0,0
Xsky130_fd_sc_hd__nand3_1_12 \$565 \$930 \$585
+ vss
+ vdd
+ vdd
+ \$791 sky130_fd_sc_hd__nand3_1
* cell instance sky130_fd_sc_hd__nand3_1_13 r0 *1 0,0
Xsky130_fd_sc_hd__nand3_1_13 \$509 \$631 \$632
+ vss
+ vdd
+ vdd
+ \$569 sky130_fd_sc_hd__nand3_1
* cell instance sky130_fd_sc_hd__nand3_1_14 r0 *1 0,0
Xsky130_fd_sc_hd__nand3_1_14 \$716 \$718 \$717
+ vss
+ vdd
+ vdd
+ \$1406 sky130_fd_sc_hd__nand3_1
* cell instance sky130_fd_sc_hd__nand3_1_15 r0 *1 0,0
Xsky130_fd_sc_hd__nand3_1_15 \$565 \$788 \$722
+ vss
+ vdd
+ vdd
+ \$1661 sky130_fd_sc_hd__nand3_1
* cell instance sky130_fd_sc_hd__nand3_1_16 r0 *1 0,0
Xsky130_fd_sc_hd__nand3_1_16 \$509 \$631 \$722
+ vss
+ vdd
+ vdd
+ \$721 sky130_fd_sc_hd__nand3_1
* cell instance sky130_fd_sc_hd__nand3_1_17 r0 *1 0,0
Xsky130_fd_sc_hd__nand3_1_17 \$565 \$722 \$585
+ vss
+ vdd
+ vdd
+ \$1662 sky130_fd_sc_hd__nand3_1
* cell instance sky130_fd_sc_hd__nand3_1_18 r0 *1 0,0
Xsky130_fd_sc_hd__nand3_1_18 \$717 \$565 \$720
+ vss
+ vdd
+ vdd
+ \$935 sky130_fd_sc_hd__nand3_1
* cell instance sky130_fd_sc_hd__nand3_1_19 r0 *1 0,0
Xsky130_fd_sc_hd__nand3_1_19 \$509 \$631 \$635
+ vss
+ vdd
+ vdd
+ \$564 sky130_fd_sc_hd__nand3_1
* cell instance sky130_fd_sc_hd__nand3_1_20 r0 *1 0,0
Xsky130_fd_sc_hd__nand3_1_20 \$4747 \$5475 \$3728
+ vss
+ vdd
+ vdd
+ \$4748 sky130_fd_sc_hd__nand3_1
* cell instance sky130_fd_sc_hd__nand3_1_21 r0 *1 0,0
Xsky130_fd_sc_hd__nand3_1_21 \$509 \$631 \$1152
+ vss
+ vdd
+ vdd
+ \$936 sky130_fd_sc_hd__nand3_1
* cell instance sky130_fd_sc_hd__nand3_1_22 r0 *1 0,0
Xsky130_fd_sc_hd__nand3_1_22 \$565 \$635 \$585
+ vss
+ vdd
+ vdd
+ \$584 sky130_fd_sc_hd__nand3_1
* cell instance sky130_fd_sc_hd__nand3_1_23 r0 *1 0,0
Xsky130_fd_sc_hd__nand3_1_23 \$565 \$788 \$635
+ vss
+ vdd
+ vdd
+ \$730 sky130_fd_sc_hd__nand3_1
* cell instance sky130_fd_sc_hd__nand3_1_24 r0 *1 0,0
Xsky130_fd_sc_hd__nand3_1_24 \$565 \$788 \$1152
+ vss
+ vdd
+ vdd
+ \$1763 sky130_fd_sc_hd__nand3_1
* cell instance sky130_fd_sc_hd__nand3_1_25 r0 *1 0,0
Xsky130_fd_sc_hd__nand3_1_25 \$565 \$1152 \$585
+ vss
+ vdd
+ vdd
+ \$1665 sky130_fd_sc_hd__nand3_1
* cell instance sky130_fd_sc_hd__nand3_1_26 r0 *1 0,0
Xsky130_fd_sc_hd__nand3_1_26 \$565 \$877 \$585
+ vss
+ vdd
+ vdd
+ \$640 sky130_fd_sc_hd__nand3_1
* cell instance sky130_fd_sc_hd__nand3_1_27 r0 *1 0,0
Xsky130_fd_sc_hd__nand3_1_27 \$565 \$788 \$632
+ vss
+ vdd
+ vdd
+ \$731 sky130_fd_sc_hd__nand3_1
* cell instance sky130_fd_sc_hd__nand3_1_28 r0 *1 0,0
Xsky130_fd_sc_hd__nand3_1_28 \$565 \$632 \$585
+ vss
+ vdd
+ vdd
+ \$807 sky130_fd_sc_hd__nand3_1
* cell instance sky130_fd_sc_hd__nand3_1_29 r0 *1 0,0
Xsky130_fd_sc_hd__nand3_1_29 \$565 \$1014 \$877
+ vss
+ vdd
+ vdd
+ \$1013 sky130_fd_sc_hd__nand3_1
* cell instance sky130_fd_sc_hd__nand3_1_30 r0 *1 0,0
Xsky130_fd_sc_hd__nand3_1_30 \$1516 \$1515 \$1669
+ vss
+ vdd
+ vdd
+ \$2170 sky130_fd_sc_hd__nand3_1
* cell instance sky130_fd_sc_hd__nand3_1_31 r0 *1 0,0
Xsky130_fd_sc_hd__nand3_1_31 \$182 \$456 \$453
+ vss
+ vdd
+ vdd
+ \$523 sky130_fd_sc_hd__nand3_1
* cell instance sky130_fd_sc_hd__nand3_1_32 r0 *1 0,0
Xsky130_fd_sc_hd__nand3_1_32 \$182 \$1517 \$1597
+ vss
+ vdd
+ vdd
+ \$1596 sky130_fd_sc_hd__nand3_1
* cell instance sky130_fd_sc_hd__nand3_1_33 r0 *1 0,0
Xsky130_fd_sc_hd__nand3_1_33 \$182 \$525 \$381
+ vss
+ vdd
+ vdd
+ \$524 sky130_fd_sc_hd__nand3_1
* cell instance sky130_fd_sc_hd__nand3_1_34 r0 *1 0,0
Xsky130_fd_sc_hd__nand3_1_34 out_ready \$3259 \$2844
+ vss
+ vdd
+ vdd
+ \$2569 sky130_fd_sc_hd__nand3_1
* cell instance sky130_fd_sc_hd__nand3_1_35 r0 *1 0,0
Xsky130_fd_sc_hd__nand3_1_35 \$2579 \$3735 \$3848
+ vss
+ vdd
+ vdd
+ \$3079 sky130_fd_sc_hd__nand3_1
* cell instance sky130_fd_sc_hd__nand3_1_36 r0 *1 0,0
Xsky130_fd_sc_hd__nand3_1_36 bus_we bus_wdata[2] \$3260
+ vss
+ vdd
+ vdd
+ \$3268 sky130_fd_sc_hd__nand3_1
* cell instance sky130_fd_sc_hd__nand3_1_37 r0 *1 0,0
Xsky130_fd_sc_hd__nand3_1_37 \$2805 \$3412 \$3113
+ vss
+ vdd
+ vdd
+ \$3628 sky130_fd_sc_hd__nand3_1
* cell instance sky130_fd_sc_hd__nand3_1_38 r0 *1 0,0
Xsky130_fd_sc_hd__nand3_1_38 \$3113 \$3658 \$2848
+ vss
+ vdd
+ vdd
+ \$3632 sky130_fd_sc_hd__nand3_1
* cell instance sky130_fd_sc_hd__nand3b_1_0 r0 *1 0,0
Xsky130_fd_sc_hd__nand3b_1_0 \$718 \$717 \$716
+ vss
+ vdd
+ vdd
+ \$1061 sky130_fd_sc_hd__nand3b_1
* cell instance sky130_fd_sc_hd__nand3b_1_1 r0 *1 0,0
Xsky130_fd_sc_hd__nand3b_1_1 \$716 \$718 \$717
+ vss
+ vdd
+ vdd
+ \$570 sky130_fd_sc_hd__nand3b_1
* cell instance sky130_fd_sc_hd__nand3b_1_2 r0 *1 0,0
Xsky130_fd_sc_hd__nand3b_1_2 \$565 \$788 \$722
+ vss
+ vdd
+ vdd
+ \$724 sky130_fd_sc_hd__nand3b_1
* cell instance sky130_fd_sc_hd__nand3b_1_3 r0 *1 0,0
Xsky130_fd_sc_hd__nand3b_1_3 \$2683 \$2458 \$2569
+ vss
+ vdd
+ vdd
+ \$2562 sky130_fd_sc_hd__nand3b_1
* cell instance sky130_fd_sc_hd__nand4_1_0 r0 *1 0,0
Xsky130_fd_sc_hd__nand4_1_0 \$3904 \$3667 \$3668 \$4016
+ vss
+ vdd
+ vdd
+ \$4246 sky130_fd_sc_hd__nand4_1
* cell instance sky130_fd_sc_hd__nand4_1_1 r0 *1 0,0
Xsky130_fd_sc_hd__nand4_1_1 \$3667 \$3668 \$4353 \$4479
+ vss
+ vdd
+ vdd
+ \$4128 sky130_fd_sc_hd__nand4_1
* cell instance sky130_fd_sc_hd__nand4_1_2 r0 *1 0,0
Xsky130_fd_sc_hd__nand4_1_2 \$3036 \$2946 \$3274 \$2942
+ vss
+ vdd
+ vdd
+ \$3152 sky130_fd_sc_hd__nand4_1
* cell instance sky130_fd_sc_hd__nand4_1_3 r0 *1 0,0
Xsky130_fd_sc_hd__nand4_1_3 \$3363 \$3155 \$3156 \$3344
+ vss
+ vdd
+ vdd
+ \$3151 sky130_fd_sc_hd__nand4_1
* cell instance sky130_fd_sc_hd__nand4_1_4 r0 *1 0,0
Xsky130_fd_sc_hd__nand4_1_4 \$4237 \$4351 \$4147 \$4482
+ vss
+ vdd
+ vdd
+ \$4354 sky130_fd_sc_hd__nand4_1
* cell instance sky130_fd_sc_hd__nand4_1_5 r0 *1 0,0
Xsky130_fd_sc_hd__nand4_1_5 \$3570 \$3908 \$3885 \$4020
+ vss
+ vdd
+ vdd
+ \$4149 sky130_fd_sc_hd__nand4_1
* cell instance sky130_fd_sc_hd__nand4_1_6 r0 *1 0,0
Xsky130_fd_sc_hd__nand4_1_6 \$5974 \$5978 \$5976 \$5975
+ vss
+ vdd
+ vdd
+ \$5859 sky130_fd_sc_hd__nand4_1
* cell instance sky130_fd_sc_hd__nand4_1_7 r0 *1 0,0
Xsky130_fd_sc_hd__nand4_1_7 \$2634 \$2869 \$2746 \$2305
+ vss
+ vdd
+ vdd
+ \$3168 sky130_fd_sc_hd__nand4_1
* cell instance sky130_fd_sc_hd__nand4_1_8 r0 *1 0,0
Xsky130_fd_sc_hd__nand4_1_8 \$1385 \$2012 \$1377 \$2013
+ vss
+ vdd
+ vdd
+ \$2100 sky130_fd_sc_hd__nand4_1
* cell instance sky130_fd_sc_hd__nand4_1_9 r0 *1 0,0
Xsky130_fd_sc_hd__nand4_1_9 \$5415 \$5308 \$5163 \$5062
+ vss
+ vdd
+ vdd
+ \$5416 sky130_fd_sc_hd__nand4_1
* cell instance sky130_fd_sc_hd__nand4_1_10 r0 *1 0,0
Xsky130_fd_sc_hd__nand4_1_10 \$1385 \$2288 \$1377 \$2120
+ vss
+ vdd
+ vdd
+ \$2422 sky130_fd_sc_hd__nand4_1
* cell instance sky130_fd_sc_hd__nand4_1_11 r0 *1 0,0
Xsky130_fd_sc_hd__nand4_1_11 \$4604 \$4367 \$4609 \$4365
+ vss
+ vdd
+ vdd
+ \$4164 sky130_fd_sc_hd__nand4_1
* cell instance sky130_fd_sc_hd__nand4_1_12 r0 *1 0,0
Xsky130_fd_sc_hd__nand4_1_12 \$5073 \$5070 \$4955 \$5074
+ vss
+ vdd
+ vdd
+ \$4833 sky130_fd_sc_hd__nand4_1
* cell instance sky130_fd_sc_hd__nand4_1_13 r0 *1 0,0
Xsky130_fd_sc_hd__nand4_1_13 \$6190 \$6402 \$6403 \$5989
+ vss
+ vdd
+ vdd
+ \$5764 sky130_fd_sc_hd__nand4_1
* cell instance sky130_fd_sc_hd__nand4_1_14 r0 *1 0,0
Xsky130_fd_sc_hd__nand4_1_14 \$4457 \$4372 \$4955 \$4953
+ vss
+ vdd
+ vdd
+ \$4745 sky130_fd_sc_hd__nand4_1
* cell instance sky130_fd_sc_hd__nand4_1_15 r0 *1 0,0
Xsky130_fd_sc_hd__nand4_1_15 \$4062 \$4457 \$4747 \$5475
+ vss
+ vdd
+ vdd
+ \$4527 sky130_fd_sc_hd__nand4_1
* cell instance sky130_fd_sc_hd__nand4_1_16 r0 *1 0,0
Xsky130_fd_sc_hd__nand4_1_16 \$716 \$718 \$717 \$565
+ vss
+ vdd
+ vdd
+ \$1311 sky130_fd_sc_hd__nand4_1
* cell instance sky130_fd_sc_hd__nand4b_1_0 r0 *1 0,0
Xsky130_fd_sc_hd__nand4b_1_0 \$4247 \$4030 \$4129 \$4496
+ vss
+ vdd
+ vdd
+ \$4358 sky130_fd_sc_hd__nand4b_1
* cell instance sky130_fd_sc_hd__nand4b_1_1 r0 *1 0,0
Xsky130_fd_sc_hd__nand4b_1_1 \$4457 \$4747 \$5475 \$4062
+ vss
+ vdd
+ vdd
+ \$4848 sky130_fd_sc_hd__nand4b_1
* cell instance sky130_fd_sc_hd__nand4b_1_2 r0 *1 0,0
Xsky130_fd_sc_hd__nand4b_1_2 \$1516 \$1515 \$1014 \$1313
+ vss
+ vdd
+ vdd
+ \$1424 sky130_fd_sc_hd__nand4b_1
* cell instance sky130_fd_sc_hd__nor2_1_0 r0 *1 0,0
Xsky130_fd_sc_hd__nor2_1_0 \$3767 \$4139
+ vss
+ vdd
+ vdd
+ \$3901 sky130_fd_sc_hd__nor2_1
* cell instance sky130_fd_sc_hd__nor2_1_1 r0 *1 0,0
Xsky130_fd_sc_hd__nor2_1_1 \$1548 \$4588
+ vss
+ vdd
+ vdd
+ \$4589 sky130_fd_sc_hd__nor2_1
* cell instance sky130_fd_sc_hd__nor2_1_2 r0 *1 0,0
Xsky130_fd_sc_hd__nor2_1_2 \$1548 \$3663
+ vss
+ vdd
+ vdd
+ \$3902 sky130_fd_sc_hd__nor2_1
* cell instance sky130_fd_sc_hd__nor2_1_3 r0 *1 0,0
Xsky130_fd_sc_hd__nor2_1_3 \$1548 \$4702
+ vss
+ vdd
+ vdd
+ \$4703 sky130_fd_sc_hd__nor2_1
* cell instance sky130_fd_sc_hd__nor2_1_4 r0 *1 0,0
Xsky130_fd_sc_hd__nor2_1_4 \$4818 \$4795
+ vss
+ vdd
+ vdd
+ \$4817 sky130_fd_sc_hd__nor2_1
* cell instance sky130_fd_sc_hd__nor2_1_5 r0 *1 0,0
Xsky130_fd_sc_hd__nor2_1_5 \$4018 \$4705
+ vss
+ vdd
+ vdd
+ \$4244 sky130_fd_sc_hd__nor2_1
* cell instance sky130_fd_sc_hd__nor2_1_6 r0 *1 0,0
Xsky130_fd_sc_hd__nor2_1_6 \$2202 \$5964
+ vss
+ vdd
+ vdd
+ \$5849 sky130_fd_sc_hd__nor2_1
* cell instance sky130_fd_sc_hd__nor2_1_7 r0 *1 0,0
Xsky130_fd_sc_hd__nor2_1_7 \$2202 \$5739
+ vss
+ vdd
+ vdd
+ \$5633 sky130_fd_sc_hd__nor2_1
* cell instance sky130_fd_sc_hd__nor2_1_8 r0 *1 0,0
Xsky130_fd_sc_hd__nor2_1_8 \$2202 \$2204
+ vss
+ vdd
+ vdd
+ \$2203 sky130_fd_sc_hd__nor2_1
* cell instance sky130_fd_sc_hd__nor2_1_9 r0 *1 0,0
Xsky130_fd_sc_hd__nor2_1_9 \$2202 \$2722
+ vss
+ vdd
+ vdd
+ \$2723 sky130_fd_sc_hd__nor2_1
* cell instance sky130_fd_sc_hd__nor2_1_10 r0 *1 0,0
Xsky130_fd_sc_hd__nor2_1_10 \$4704 \$4705
+ vss
+ vdd
+ vdd
+ \$4795 sky130_fd_sc_hd__nor2_1
* cell instance sky130_fd_sc_hd__nor2_1_11 r0 *1 0,0
Xsky130_fd_sc_hd__nor2_1_11 \$5740 \$5741
+ vss
+ vdd
+ vdd
+ \$5833 sky130_fd_sc_hd__nor2_1
* cell instance sky130_fd_sc_hd__nor2_1_12 r0 *1 0,0
Xsky130_fd_sc_hd__nor2_1_12 \$2209 \$2625
+ vss
+ vdd
+ vdd
+ \$2626 sky130_fd_sc_hd__nor2_1
* cell instance sky130_fd_sc_hd__nor2_1_13 r0 *1 0,0
Xsky130_fd_sc_hd__nor2_1_13 \$3668 \$3906
+ vss
+ vdd
+ vdd
+ \$3907 sky130_fd_sc_hd__nor2_1
* cell instance sky130_fd_sc_hd__nor2_1_14 r0 *1 0,0
Xsky130_fd_sc_hd__nor2_1_14 \$2202 \$5187
+ vss
+ vdd
+ vdd
+ \$5188 sky130_fd_sc_hd__nor2_1
* cell instance sky130_fd_sc_hd__nor2_1_15 r0 *1 0,0
Xsky130_fd_sc_hd__nor2_1_15 \$5522 \$5850
+ vss
+ vdd
+ vdd
+ \$5965 sky130_fd_sc_hd__nor2_1
* cell instance sky130_fd_sc_hd__nor2_1_16 r0 *1 0,0
Xsky130_fd_sc_hd__nor2_1_16 \$5624 \$5508
+ vss
+ vdd
+ vdd
+ \$5850 sky130_fd_sc_hd__nor2_1
* cell instance sky130_fd_sc_hd__nor2_1_17 r0 *1 0,0
Xsky130_fd_sc_hd__nor2_1_17 \$2202 \$6170
+ vss
+ vdd
+ vdd
+ \$6272 sky130_fd_sc_hd__nor2_1
* cell instance sky130_fd_sc_hd__nor2_1_18 r0 *1 0,0
Xsky130_fd_sc_hd__nor2_1_18 \$5966 \$5968
+ vss
+ vdd
+ vdd
+ \$6172 sky130_fd_sc_hd__nor2_1
* cell instance sky130_fd_sc_hd__nor2_1_19 r0 *1 0,0
Xsky130_fd_sc_hd__nor2_1_19 \$2202 \$2726
+ vss
+ vdd
+ vdd
+ \$2728 sky130_fd_sc_hd__nor2_1
* cell instance sky130_fd_sc_hd__nor2_1_20 r0 *1 0,0
Xsky130_fd_sc_hd__nor2_1_20 \$2202 \$2106
+ vss
+ vdd
+ vdd
+ \$2007 sky130_fd_sc_hd__nor2_1
* cell instance sky130_fd_sc_hd__nor2_1_21 r0 *1 0,0
Xsky130_fd_sc_hd__nor2_1_21 \$4248 \$4249
+ vss
+ vdd
+ vdd
+ \$4250 sky130_fd_sc_hd__nor2_1
* cell instance sky130_fd_sc_hd__nor2_1_22 r0 *1 0,0
Xsky130_fd_sc_hd__nor2_1_22 \$4248 \$5057
+ vss
+ vdd
+ vdd
+ \$5056 sky130_fd_sc_hd__nor2_1
* cell instance sky130_fd_sc_hd__nor2_1_23 r0 *1 0,0
Xsky130_fd_sc_hd__nor2_1_23 \$5975 \$6387
+ vss
+ vdd
+ vdd
+ \$6388 sky130_fd_sc_hd__nor2_1
* cell instance sky130_fd_sc_hd__nor2_1_24 r0 *1 0,0
Xsky130_fd_sc_hd__nor2_1_24 \$2729 \$1146
+ vss
+ vdd
+ vdd
+ \$2860 sky130_fd_sc_hd__nor2_1
* cell instance sky130_fd_sc_hd__nor2_1_25 r0 *1 0,0
Xsky130_fd_sc_hd__nor2_1_25 \$1548 \$3677
+ vss
+ vdd
+ vdd
+ \$3643 sky130_fd_sc_hd__nor2_1
* cell instance sky130_fd_sc_hd__nor2_1_26 r0 *1 0,0
Xsky130_fd_sc_hd__nor2_1_26 \$2202 \$5854
+ vss
+ vdd
+ vdd
+ \$5970 sky130_fd_sc_hd__nor2_1
* cell instance sky130_fd_sc_hd__nor2_1_27 r0 *1 0,0
Xsky130_fd_sc_hd__nor2_1_27 \$2202 \$6493
+ vss
+ vdd
+ vdd
+ \$6281 sky130_fd_sc_hd__nor2_1
* cell instance sky130_fd_sc_hd__nor2_1_28 r0 *1 0,0
Xsky130_fd_sc_hd__nor2_1_28 \$2202 \$2215
+ vss
+ vdd
+ vdd
+ \$2216 sky130_fd_sc_hd__nor2_1
* cell instance sky130_fd_sc_hd__nor2_1_29 r0 *1 0,0
Xsky130_fd_sc_hd__nor2_1_29 \$2202 \$4252
+ vss
+ vdd
+ vdd
+ \$3793 sky130_fd_sc_hd__nor2_1
* cell instance sky130_fd_sc_hd__nor2_1_30 r0 *1 0,0
Xsky130_fd_sc_hd__nor2_1_30 \$2202 \$4913
+ vss
+ vdd
+ vdd
+ \$4492 sky130_fd_sc_hd__nor2_1
* cell instance sky130_fd_sc_hd__nor2_1_31 r0 *1 0,0
Xsky130_fd_sc_hd__nor2_1_31 \$1548 \$2860
+ vss
+ vdd
+ vdd
+ \$2737 sky130_fd_sc_hd__nor2_1
* cell instance sky130_fd_sc_hd__nor2_1_32 r0 *1 0,0
Xsky130_fd_sc_hd__nor2_1_32 \$2202 \$5525
+ vss
+ vdd
+ vdd
+ \$5526 sky130_fd_sc_hd__nor2_1
* cell instance sky130_fd_sc_hd__nor2_1_33 r0 *1 0,0
Xsky130_fd_sc_hd__nor2_1_33 \$2202 \$2302
+ vss
+ vdd
+ vdd
+ \$2118 sky130_fd_sc_hd__nor2_1
* cell instance sky130_fd_sc_hd__nor2_1_34 r0 *1 0,0
Xsky130_fd_sc_hd__nor2_1_34 \$2202 \$5302
+ vss
+ vdd
+ vdd
+ \$5527 sky130_fd_sc_hd__nor2_1
* cell instance sky130_fd_sc_hd__nor2_1_35 r0 *1 0,0
Xsky130_fd_sc_hd__nor2_1_35 \$1379 \$1633
+ vss
+ vdd
+ vdd
+ \$1721 sky130_fd_sc_hd__nor2_1
* cell instance sky130_fd_sc_hd__nor2_1_36 r0 *1 0,0
Xsky130_fd_sc_hd__nor2_1_36 \$2202 \$4495
+ vss
+ vdd
+ vdd
+ \$4576 sky130_fd_sc_hd__nor2_1
* cell instance sky130_fd_sc_hd__nor2_1_37 r0 *1 0,0
Xsky130_fd_sc_hd__nor2_1_37 \$4826 \$4824
+ vss
+ vdd
+ vdd
+ \$4827 sky130_fd_sc_hd__nor2_1
* cell instance sky130_fd_sc_hd__nor2_1_38 r0 *1 0,0
Xsky130_fd_sc_hd__nor2_1_38 \$4151 \$4254
+ vss
+ vdd
+ vdd
+ \$4237 sky130_fd_sc_hd__nor2_1
* cell instance sky130_fd_sc_hd__nor2_1_39 r0 *1 0,0
Xsky130_fd_sc_hd__nor2_1_39 \$1380 \$1384
+ vss
+ vdd
+ vdd
+ \$1637 sky130_fd_sc_hd__nor2_1
* cell instance sky130_fd_sc_hd__nor2_1_40 r0 *1 0,0
Xsky130_fd_sc_hd__nor2_1_40 \$4253 \$4149
+ vss
+ vdd
+ vdd
+ \$4341 sky130_fd_sc_hd__nor2_1
* cell instance sky130_fd_sc_hd__nor2_1_41 r0 *1 0,0
Xsky130_fd_sc_hd__nor2_1_41 \$4255 \$4496
+ vss
+ vdd
+ vdd
+ \$4593 sky130_fd_sc_hd__nor2_1
* cell instance sky130_fd_sc_hd__nor2_1_42 r0 *1 0,0
Xsky130_fd_sc_hd__nor2_1_42 \$1548 \$1545
+ vss
+ vdd
+ vdd
+ \$1549 sky130_fd_sc_hd__nor2_1
* cell instance sky130_fd_sc_hd__nor2_1_43 r0 *1 0,0
Xsky130_fd_sc_hd__nor2_1_43 \$2202 \$3579
+ vss
+ vdd
+ vdd
+ \$3580 sky130_fd_sc_hd__nor2_1
* cell instance sky130_fd_sc_hd__nor2_1_44 r0 *1 0,0
Xsky130_fd_sc_hd__nor2_1_44 \$4821 \$4248
+ vss
+ vdd
+ vdd
+ \$5303 sky130_fd_sc_hd__nor2_1
* cell instance sky130_fd_sc_hd__nor2_1_45 r0 *1 0,0
Xsky130_fd_sc_hd__nor2_1_45 \$2202 \$2741
+ vss
+ vdd
+ vdd
+ \$2867 sky130_fd_sc_hd__nor2_1
* cell instance sky130_fd_sc_hd__nor2_1_46 r0 *1 0,0
Xsky130_fd_sc_hd__nor2_1_46 \$3167 \$3168
+ vss
+ vdd
+ vdd
+ \$3374 sky130_fd_sc_hd__nor2_1
* cell instance sky130_fd_sc_hd__nor2_1_47 r0 *1 0,0
Xsky130_fd_sc_hd__nor2_1_47 \$4255 \$4129
+ vss
+ vdd
+ vdd
+ \$4256 sky130_fd_sc_hd__nor2_1
* cell instance sky130_fd_sc_hd__nor2_1_48 r0 *1 0,0
Xsky130_fd_sc_hd__nor2_1_48 \$2202 \$6284
+ vss
+ vdd
+ vdd
+ \$6285 sky130_fd_sc_hd__nor2_1
* cell instance sky130_fd_sc_hd__nor2_1_49 r0 *1 0,0
Xsky130_fd_sc_hd__nor2_1_49 \$2202 \$2010
+ vss
+ vdd
+ vdd
+ \$2224 sky130_fd_sc_hd__nor2_1
* cell instance sky130_fd_sc_hd__nor2_1_50 r0 *1 0,0
Xsky130_fd_sc_hd__nor2_1_50 startup_done \$290
+ vss
+ vdd
+ vdd
+ \$1384 sky130_fd_sc_hd__nor2_1
* cell instance sky130_fd_sc_hd__nor2_1_51 r0 *1 0,0
Xsky130_fd_sc_hd__nor2_1_51 \$2202 \$3922
+ vss
+ vdd
+ vdd
+ \$3921 sky130_fd_sc_hd__nor2_1
* cell instance sky130_fd_sc_hd__nor2_1_52 r0 *1 0,0
Xsky130_fd_sc_hd__nor2_1_52 \$5307 \$5529
+ vss
+ vdd
+ vdd
+ \$5510 sky130_fd_sc_hd__nor2_1
* cell instance sky130_fd_sc_hd__nor2_1_53 r0 *1 0,0
Xsky130_fd_sc_hd__nor2_1_53 \$2119 \$1836
+ vss
+ vdd
+ vdd
+ \$2120 sky130_fd_sc_hd__nor2_1
* cell instance sky130_fd_sc_hd__nor2_1_54 r0 *1 0,0
Xsky130_fd_sc_hd__nor2_1_54 \$2423 \$2422
+ vss
+ vdd
+ vdd
+ \$2305 sky130_fd_sc_hd__nor2_1
* cell instance sky130_fd_sc_hd__nor2_1_55 r0 *1 0,0
Xsky130_fd_sc_hd__nor2_1_55 \$2202 \$3683
+ vss
+ vdd
+ vdd
+ \$3682 sky130_fd_sc_hd__nor2_1
* cell instance sky130_fd_sc_hd__nor2_1_56 r0 *1 0,0
Xsky130_fd_sc_hd__nor2_1_56 \$2202 \$4830
+ vss
+ vdd
+ vdd
+ \$4831 sky130_fd_sc_hd__nor2_1
* cell instance sky130_fd_sc_hd__nor2_1_57 r0 *1 0,0
Xsky130_fd_sc_hd__nor2_1_57 startup_done \$1836
+ vss
+ vdd
+ vdd
+ \$2013 sky130_fd_sc_hd__nor2_1
* cell instance sky130_fd_sc_hd__nor2_1_58 r0 *1 0,0
Xsky130_fd_sc_hd__nor2_1_58 \$2202 \$5753
+ vss
+ vdd
+ vdd
+ \$6104 sky130_fd_sc_hd__nor2_1
* cell instance sky130_fd_sc_hd__nor2_1_59 r0 *1 0,0
Xsky130_fd_sc_hd__nor2_1_59 \$2202 \$5195
+ vss
+ vdd
+ vdd
+ \$5196 sky130_fd_sc_hd__nor2_1
* cell instance sky130_fd_sc_hd__nor2_1_60 r0 *1 0,0
Xsky130_fd_sc_hd__nor2_1_60 \$1548 \$1386
+ vss
+ vdd
+ vdd
+ \$1291 sky130_fd_sc_hd__nor2_1
* cell instance sky130_fd_sc_hd__nor2_1_61 r0 *1 0,0
Xsky130_fd_sc_hd__nor2_1_61 \$4255 \$4033
+ vss
+ vdd
+ vdd
+ \$2108 sky130_fd_sc_hd__nor2_1
* cell instance sky130_fd_sc_hd__nor2_1_62 r0 *1 0,0
Xsky130_fd_sc_hd__nor2_1_62 \$2202 \$5647
+ vss
+ vdd
+ vdd
+ \$5531 sky130_fd_sc_hd__nor2_1
* cell instance sky130_fd_sc_hd__nor2_1_63 r0 *1 0,0
Xsky130_fd_sc_hd__nor2_1_63 \$290 \$4150
+ vss
+ vdd
+ vdd
+ \$3923 sky130_fd_sc_hd__nor2_1
* cell instance sky130_fd_sc_hd__nor2_1_64 r0 *1 0,0
Xsky130_fd_sc_hd__nor2_1_64 \$2202 \$5650
+ vss
+ vdd
+ vdd
+ \$5651 sky130_fd_sc_hd__nor2_1
* cell instance sky130_fd_sc_hd__nor2_1_65 r0 *1 0,0
Xsky130_fd_sc_hd__nor2_1_65 \$2202 \$6103
+ vss
+ vdd
+ vdd
+ \$6105 sky130_fd_sc_hd__nor2_1
* cell instance sky130_fd_sc_hd__nor2_1_66 r0 *1 0,0
Xsky130_fd_sc_hd__nor2_1_66 \$1548 \$2308
+ vss
+ vdd
+ vdd
+ \$2311 sky130_fd_sc_hd__nor2_1
* cell instance sky130_fd_sc_hd__nor2_1_67 r0 *1 0,0
Xsky130_fd_sc_hd__nor2_1_67 \$2202 \$2639
+ vss
+ vdd
+ vdd
+ \$2638 sky130_fd_sc_hd__nor2_1
* cell instance sky130_fd_sc_hd__nor2_1_68 r0 *1 0,0
Xsky130_fd_sc_hd__nor2_1_68 startup_done \$1146
+ vss
+ vdd
+ vdd
+ \$3684 sky130_fd_sc_hd__nor2_1
* cell instance sky130_fd_sc_hd__nor2_1_69 r0 *1 0,0
Xsky130_fd_sc_hd__nor2_1_69 \$2202 \$3041
+ vss
+ vdd
+ vdd
+ \$2965 sky130_fd_sc_hd__nor2_1
* cell instance sky130_fd_sc_hd__nor2_1_70 r0 *1 0,0
Xsky130_fd_sc_hd__nor2_1_70 \$1548 \$2123
+ vss
+ vdd
+ vdd
+ \$2126 sky130_fd_sc_hd__nor2_1
* cell instance sky130_fd_sc_hd__nor2_1_71 r0 *1 0,0
Xsky130_fd_sc_hd__nor2_1_71 \$2202 \$3173
+ vss
+ vdd
+ vdd
+ \$3042 sky130_fd_sc_hd__nor2_1
* cell instance sky130_fd_sc_hd__nor2_1_72 r0 *1 0,0
Xsky130_fd_sc_hd__nor2_1_72 \$219 \$4362
+ vss
+ vdd
+ vdd
+ \$4161 sky130_fd_sc_hd__nor2_1
* cell instance sky130_fd_sc_hd__nor2_1_73 r0 *1 0,0
Xsky130_fd_sc_hd__nor2_1_73 \$219 \$4949
+ vss
+ vdd
+ vdd
+ \$4733 sky130_fd_sc_hd__nor2_1
* cell instance sky130_fd_sc_hd__nor2_1_74 r0 *1 0,0
Xsky130_fd_sc_hd__nor2_1_74 \$1500 \$180
+ vss
+ vdd
+ vdd
+ \$3588 sky130_fd_sc_hd__nor2_1
* cell instance sky130_fd_sc_hd__nor2_1_75 r0 *1 0,0
Xsky130_fd_sc_hd__nor2_1_75 \$1559 \$180
+ vss
+ vdd
+ vdd
+ \$1643 sky130_fd_sc_hd__nor2_1
* cell instance sky130_fd_sc_hd__nor2_1_76 r0 *1 0,0
Xsky130_fd_sc_hd__nor2_1_76 \$1500 \$399
+ vss
+ vdd
+ vdd
+ \$3812 sky130_fd_sc_hd__nor2_1
* cell instance sky130_fd_sc_hd__nor2_1_77 r0 *1 0,0
Xsky130_fd_sc_hd__nor2_1_77 \$786 \$180
+ vss
+ vdd
+ vdd
+ \$2429 sky130_fd_sc_hd__nor2_1
* cell instance sky130_fd_sc_hd__nor2_1_78 r0 *1 0,0
Xsky130_fd_sc_hd__nor2_1_78 \$219 \$4271
+ vss
+ vdd
+ vdd
+ \$4131 sky130_fd_sc_hd__nor2_1
* cell instance sky130_fd_sc_hd__nor2_1_79 r0 *1 0,0
Xsky130_fd_sc_hd__nor2_1_79 \$1559 \$399
+ vss
+ vdd
+ vdd
+ \$1644 sky130_fd_sc_hd__nor2_1
* cell instance sky130_fd_sc_hd__nor2_1_80 r0 *1 0,0
Xsky130_fd_sc_hd__nor2_1_80 \$1211 \$180
+ vss
+ vdd
+ vdd
+ \$2875 sky130_fd_sc_hd__nor2_1
* cell instance sky130_fd_sc_hd__nor2_1_81 r0 *1 0,0
Xsky130_fd_sc_hd__nor2_1_81 \$219 \$1057
+ vss
+ vdd
+ vdd
+ \$1209 sky130_fd_sc_hd__nor2_1
* cell instance sky130_fd_sc_hd__nor2_1_82 r0 *1 0,0
Xsky130_fd_sc_hd__nor2_1_82 \$219 \$1402
+ vss
+ vdd
+ vdd
+ \$1139 sky130_fd_sc_hd__nor2_1
* cell instance sky130_fd_sc_hd__nor2_1_83 r0 *1 0,0
Xsky130_fd_sc_hd__nor2_1_83 \$219 \$927
+ vss
+ vdd
+ vdd
+ \$995 sky130_fd_sc_hd__nor2_1
* cell instance sky130_fd_sc_hd__nor2_1_84 r0 *1 0,0
Xsky130_fd_sc_hd__nor2_1_84 \$4609 \$4372
+ vss
+ vdd
+ vdd
+ \$4374 sky130_fd_sc_hd__nor2_1
* cell instance sky130_fd_sc_hd__nor2_1_85 r0 *1 0,0
Xsky130_fd_sc_hd__nor2_1_85 \$1559 \$281
+ vss
+ vdd
+ vdd
+ \$928 sky130_fd_sc_hd__nor2_1
* cell instance sky130_fd_sc_hd__nor2_1_86 r0 *1 0,0
Xsky130_fd_sc_hd__nor2_1_86 \$1210 \$281
+ vss
+ vdd
+ vdd
+ \$1403 sky130_fd_sc_hd__nor2_1
* cell instance sky130_fd_sc_hd__nor2_1_87 r0 *1 0,0
Xsky130_fd_sc_hd__nor2_1_87 \$1210 \$180
+ vss
+ vdd
+ vdd
+ \$2130 sky130_fd_sc_hd__nor2_1
* cell instance sky130_fd_sc_hd__nor2_1_88 r0 *1 0,0
Xsky130_fd_sc_hd__nor2_1_88 \$1211 \$399
+ vss
+ vdd
+ vdd
+ \$3256 sky130_fd_sc_hd__nor2_1
* cell instance sky130_fd_sc_hd__nor2_1_89 r0 *1 0,0
Xsky130_fd_sc_hd__nor2_1_89 \$219 \$5321
+ vss
+ vdd
+ vdd
+ \$5322 sky130_fd_sc_hd__nor2_1
* cell instance sky130_fd_sc_hd__nor2_1_90 r0 *1 0,0
Xsky130_fd_sc_hd__nor2_1_90 \$786 \$281
+ vss
+ vdd
+ vdd
+ \$861 sky130_fd_sc_hd__nor2_1
* cell instance sky130_fd_sc_hd__nor2_1_91 r0 *1 0,0
Xsky130_fd_sc_hd__nor2_1_91 \$1211 \$281
+ vss
+ vdd
+ vdd
+ \$1058 sky130_fd_sc_hd__nor2_1
* cell instance sky130_fd_sc_hd__nor2_1_92 r0 *1 0,0
Xsky130_fd_sc_hd__nor2_1_92 \$625 \$180
+ vss
+ vdd
+ vdd
+ \$3290 sky130_fd_sc_hd__nor2_1
* cell instance sky130_fd_sc_hd__nor2_1_93 r0 *1 0,0
Xsky130_fd_sc_hd__nor2_1_93 \$219 \$780
+ vss
+ vdd
+ vdd
+ \$781 sky130_fd_sc_hd__nor2_1
* cell instance sky130_fd_sc_hd__nor2_1_94 r0 *1 0,0
Xsky130_fd_sc_hd__nor2_1_94 \$625 \$399
+ vss
+ vdd
+ vdd
+ \$3928 sky130_fd_sc_hd__nor2_1
* cell instance sky130_fd_sc_hd__nor2_1_95 r0 *1 0,0
Xsky130_fd_sc_hd__nor2_1_95 \$786 \$399
+ vss
+ vdd
+ vdd
+ \$2611 sky130_fd_sc_hd__nor2_1
* cell instance sky130_fd_sc_hd__nor2_1_96 r0 *1 0,0
Xsky130_fd_sc_hd__nor2_1_96 \$219 \$4610
+ vss
+ vdd
+ vdd
+ \$4612 sky130_fd_sc_hd__nor2_1
* cell instance sky130_fd_sc_hd__nor2_1_97 r0 *1 0,0
Xsky130_fd_sc_hd__nor2_1_97 \$625 \$281
+ vss
+ vdd
+ vdd
+ \$560 sky130_fd_sc_hd__nor2_1
* cell instance sky130_fd_sc_hd__nor2_1_98 r0 *1 0,0
Xsky130_fd_sc_hd__nor2_1_98 \$1500 \$281
+ vss
+ vdd
+ vdd
+ \$1502 sky130_fd_sc_hd__nor2_1
* cell instance sky130_fd_sc_hd__nor2_1_99 r0 *1 0,0
Xsky130_fd_sc_hd__nor2_1_99 \$219 \$4957
+ vss
+ vdd
+ vdd
+ \$5078 sky130_fd_sc_hd__nor2_1
* cell instance sky130_fd_sc_hd__nor2_1_100 r0 *1 0,0
Xsky130_fd_sc_hd__nor2_1_100 \$219 \$559
+ vss
+ vdd
+ vdd
+ \$561 sky130_fd_sc_hd__nor2_1
* cell instance sky130_fd_sc_hd__nor2_1_101 r0 *1 0,0
Xsky130_fd_sc_hd__nor2_1_101 \$219 \$1503
+ vss
+ vdd
+ vdd
+ \$1563 sky130_fd_sc_hd__nor2_1
* cell instance sky130_fd_sc_hd__nor2_1_102 r0 *1 0,0
Xsky130_fd_sc_hd__nor2_1_102 \$1210 \$399
+ vss
+ vdd
+ vdd
+ \$2134 sky130_fd_sc_hd__nor2_1
* cell instance sky130_fd_sc_hd__nor2_1_103 r0 *1 0,0
Xsky130_fd_sc_hd__nor2_1_103 \$4169 \$219
+ vss
+ vdd
+ vdd
+ \$6188 sky130_fd_sc_hd__nor2_1
* cell instance sky130_fd_sc_hd__nor2_1_104 r0 *1 0,0
Xsky130_fd_sc_hd__nor2_1_104 \$290 gated
+ vss
+ vdd
+ vdd
+ \$4613 sky130_fd_sc_hd__nor2_1
* cell instance sky130_fd_sc_hd__nor2_1_105 r0 *1 0,0
Xsky130_fd_sc_hd__nor2_1_105 \$786 \$742
+ vss
+ vdd
+ vdd
+ \$2534 sky130_fd_sc_hd__nor2_1
* cell instance sky130_fd_sc_hd__nor2_1_106 r0 *1 0,0
Xsky130_fd_sc_hd__nor2_1_106 \$1500 \$742
+ vss
+ vdd
+ vdd
+ \$3929 sky130_fd_sc_hd__nor2_1
* cell instance sky130_fd_sc_hd__nor2_1_107 r0 *1 0,0
Xsky130_fd_sc_hd__nor2_1_107 \$625 \$742
+ vss
+ vdd
+ vdd
+ \$4051 sky130_fd_sc_hd__nor2_1
* cell instance sky130_fd_sc_hd__nor2_1_108 r0 *1 0,0
Xsky130_fd_sc_hd__nor2_1_108 \$563 \$1062
+ vss
+ vdd
+ vdd
+ \$1140 sky130_fd_sc_hd__nor2_1
* cell instance sky130_fd_sc_hd__nor2_1_109 r0 *1 0,0
Xsky130_fd_sc_hd__nor2_1_109 \$1211 \$742
+ vss
+ vdd
+ vdd
+ \$3058 sky130_fd_sc_hd__nor2_1
* cell instance sky130_fd_sc_hd__nor2_1_110 r0 *1 0,0
Xsky130_fd_sc_hd__nor2_1_110 \$1559 \$742
+ vss
+ vdd
+ vdd
+ \$1846 sky130_fd_sc_hd__nor2_1
* cell instance sky130_fd_sc_hd__nor2_1_111 r0 *1 0,0
Xsky130_fd_sc_hd__nor2_1_111 \$563 \$1405
+ vss
+ vdd
+ vdd
+ \$1505 sky130_fd_sc_hd__nor2_1
* cell instance sky130_fd_sc_hd__nor2_1_112 r0 *1 0,0
Xsky130_fd_sc_hd__nor2_1_112 \$6116 \$5475
+ vss
+ vdd
+ vdd
+ \$6117 sky130_fd_sc_hd__nor2_1
* cell instance sky130_fd_sc_hd__nor2_1_113 r0 *1 0,0
Xsky130_fd_sc_hd__nor2_1_113 \$563 \$564
+ vss
+ vdd
+ vdd
+ \$562 sky130_fd_sc_hd__nor2_1
* cell instance sky130_fd_sc_hd__nor2_1_114 r0 *1 0,0
Xsky130_fd_sc_hd__nor2_1_114 \$574 \$1213
+ vss
+ vdd
+ vdd
+ \$1215 sky130_fd_sc_hd__nor2_1
* cell instance sky130_fd_sc_hd__nor2_1_115 r0 *1 0,0
Xsky130_fd_sc_hd__nor2_1_115 \$219 \$1565
+ vss
+ vdd
+ vdd
+ \$1652 sky130_fd_sc_hd__nor2_1
* cell instance sky130_fd_sc_hd__nor2_1_116 r0 *1 0,0
Xsky130_fd_sc_hd__nor2_1_116 \$1141 \$281
+ vss
+ vdd
+ vdd
+ \$1467 sky130_fd_sc_hd__nor2_1
* cell instance sky130_fd_sc_hd__nor2_1_117 r0 *1 0,0
Xsky130_fd_sc_hd__nor2_1_117 \$1210 \$742
+ vss
+ vdd
+ vdd
+ \$2139 sky130_fd_sc_hd__nor2_1
* cell instance sky130_fd_sc_hd__nor2_1_118 r0 *1 0,0
Xsky130_fd_sc_hd__nor2_1_118 \$789 \$281
+ vss
+ vdd
+ vdd
+ \$997 sky130_fd_sc_hd__nor2_1
* cell instance sky130_fd_sc_hd__nor2_1_119 r0 *1 0,0
Xsky130_fd_sc_hd__nor2_1_119 \$1062 \$580
+ vss
+ vdd
+ vdd
+ \$1144 sky130_fd_sc_hd__nor2_1
* cell instance sky130_fd_sc_hd__nor2_1_120 r0 *1 0,0
Xsky130_fd_sc_hd__nor2_1_120 \$219 \$503
+ vss
+ vdd
+ vdd
+ \$629 sky130_fd_sc_hd__nor2_1
* cell instance sky130_fd_sc_hd__nor2_1_121 r0 *1 0,0
Xsky130_fd_sc_hd__nor2_1_121 \$505 \$281
+ vss
+ vdd
+ vdd
+ \$504 sky130_fd_sc_hd__nor2_1
* cell instance sky130_fd_sc_hd__nor2_1_122 r0 *1 0,0
Xsky130_fd_sc_hd__nor2_1_122 \$219 \$932
+ vss
+ vdd
+ vdd
+ \$871 sky130_fd_sc_hd__nor2_1
* cell instance sky130_fd_sc_hd__nor2_1_123 r0 *1 0,0
Xsky130_fd_sc_hd__nor2_1_123 \$1406 \$574
+ vss
+ vdd
+ vdd
+ \$1308 sky130_fd_sc_hd__nor2_1
* cell instance sky130_fd_sc_hd__nor2_1_124 r0 *1 0,0
Xsky130_fd_sc_hd__nor2_1_124 \$789 \$180
+ vss
+ vdd
+ vdd
+ \$3480 sky130_fd_sc_hd__nor2_1
* cell instance sky130_fd_sc_hd__nor2_1_125 r0 *1 0,0
Xsky130_fd_sc_hd__nor2_1_125 \$7191 \$5325
+ vss
+ vdd
+ vdd
+ \$7285 sky130_fd_sc_hd__nor2_1
* cell instance sky130_fd_sc_hd__nor2_1_126 r0 *1 0,0
Xsky130_fd_sc_hd__nor2_1_126 \$4521 \$5325
+ vss
+ vdd
+ vdd
+ \$5429 sky130_fd_sc_hd__nor2_1
* cell instance sky130_fd_sc_hd__nor2_1_127 r0 *1 0,0
Xsky130_fd_sc_hd__nor2_1_127 \$6408 \$5325
+ vss
+ vdd
+ vdd
+ \$6593 sky130_fd_sc_hd__nor2_1
* cell instance sky130_fd_sc_hd__nor2_1_128 r0 *1 0,0
Xsky130_fd_sc_hd__nor2_1_128 \$563 \$569
+ vss
+ vdd
+ vdd
+ \$630 sky130_fd_sc_hd__nor2_1
* cell instance sky130_fd_sc_hd__nor2_1_129 r0 *1 0,0
Xsky130_fd_sc_hd__nor2_1_129 \$1405 \$580
+ vss
+ vdd
+ vdd
+ \$1407 sky130_fd_sc_hd__nor2_1
* cell instance sky130_fd_sc_hd__nor2_1_130 r0 *1 0,0
Xsky130_fd_sc_hd__nor2_1_130 \$505 \$180
+ vss
+ vdd
+ vdd
+ \$2882 sky130_fd_sc_hd__nor2_1
* cell instance sky130_fd_sc_hd__nor2_1_131 r0 *1 0,0
Xsky130_fd_sc_hd__nor2_1_131 \$789 \$399
+ vss
+ vdd
+ vdd
+ \$3710 sky130_fd_sc_hd__nor2_1
* cell instance sky130_fd_sc_hd__nor2_1_132 r0 *1 0,0
Xsky130_fd_sc_hd__nor2_1_132 \$5434 \$5325
+ vss
+ vdd
+ vdd
+ \$5551 sky130_fd_sc_hd__nor2_1
* cell instance sky130_fd_sc_hd__nor2_1_133 r0 *1 0,0
Xsky130_fd_sc_hd__nor2_1_133 \$6408 \$4302
+ vss
+ vdd
+ vdd
+ \$6208 sky130_fd_sc_hd__nor2_1
* cell instance sky130_fd_sc_hd__nor2_1_134 r0 *1 0,0
Xsky130_fd_sc_hd__nor2_1_134 \$4521 \$4302
+ vss
+ vdd
+ vdd
+ \$4522 sky130_fd_sc_hd__nor2_1
* cell instance sky130_fd_sc_hd__nor2_1_135 r0 *1 0,0
Xsky130_fd_sc_hd__nor2_1_135 \$505 \$399
+ vss
+ vdd
+ vdd
+ \$2883 sky130_fd_sc_hd__nor2_1
* cell instance sky130_fd_sc_hd__nor2_1_136 r0 *1 0,0
Xsky130_fd_sc_hd__nor2_1_136 \$789 \$742
+ vss
+ vdd
+ vdd
+ \$3825 sky130_fd_sc_hd__nor2_1
* cell instance sky130_fd_sc_hd__nor2_1_137 r0 *1 0,0
Xsky130_fd_sc_hd__nor2_1_137 \$7191 \$4302
+ vss
+ vdd
+ vdd
+ \$7115 sky130_fd_sc_hd__nor2_1
* cell instance sky130_fd_sc_hd__nor2_1_138 r0 *1 0,0
Xsky130_fd_sc_hd__nor2_1_138 \$219 \$282
+ vss
+ vdd
+ vdd
+ \$220 sky130_fd_sc_hd__nor2_1
* cell instance sky130_fd_sc_hd__nor2_1_139 r0 *1 0,0
Xsky130_fd_sc_hd__nor2_1_139 \$573 \$281
+ vss
+ vdd
+ vdd
+ \$283 sky130_fd_sc_hd__nor2_1
* cell instance sky130_fd_sc_hd__nor2_1_140 r0 *1 0,0
Xsky130_fd_sc_hd__nor2_1_140 \$1508 \$281
+ vss
+ vdd
+ vdd
+ \$1748 sky130_fd_sc_hd__nor2_1
* cell instance sky130_fd_sc_hd__nor2_1_141 r0 *1 0,0
Xsky130_fd_sc_hd__nor2_1_141 \$505 \$742
+ vss
+ vdd
+ vdd
+ \$2884 sky130_fd_sc_hd__nor2_1
* cell instance sky130_fd_sc_hd__nor2_1_142 r0 *1 0,0
Xsky130_fd_sc_hd__nor2_1_142 \$6841 \$5475
+ vss
+ vdd
+ vdd
+ \$6765 sky130_fd_sc_hd__nor2_1
* cell instance sky130_fd_sc_hd__nor2_1_143 r0 *1 0,0
Xsky130_fd_sc_hd__nor2_1_143 \$290 \$1406
+ vss
+ vdd
+ vdd
+ \$1145 sky130_fd_sc_hd__nor2_1
* cell instance sky130_fd_sc_hd__nor2_1_144 r0 *1 0,0
Xsky130_fd_sc_hd__nor2_1_144 \$565 \$1145
+ vss
+ vdd
+ vdd
+ \$1309 sky130_fd_sc_hd__nor2_1
* cell instance sky130_fd_sc_hd__nor2_1_145 r0 *1 0,0
Xsky130_fd_sc_hd__nor2_1_145 \$717 \$1073
+ vss
+ vdd
+ vdd
+ \$1218 sky130_fd_sc_hd__nor2_1
* cell instance sky130_fd_sc_hd__nor2_1_146 r0 *1 0,0
Xsky130_fd_sc_hd__nor2_1_146 \$284 \$281
+ vss
+ vdd
+ vdd
+ \$285 sky130_fd_sc_hd__nor2_1
* cell instance sky130_fd_sc_hd__nor2_1_147 r0 *1 0,0
Xsky130_fd_sc_hd__nor2_1_147 \$290 \$872
+ vss
+ vdd
+ vdd
+ \$1073 sky130_fd_sc_hd__nor2_1
* cell instance sky130_fd_sc_hd__nor2_1_148 r0 *1 0,0
Xsky130_fd_sc_hd__nor2_1_148 \$716 \$718
+ vss
+ vdd
+ vdd
+ \$720 sky130_fd_sc_hd__nor2_1
* cell instance sky130_fd_sc_hd__nor2_1_149 r0 *1 0,0
Xsky130_fd_sc_hd__nor2_1_149 \$1509 \$180
+ vss
+ vdd
+ vdd
+ \$3485 sky130_fd_sc_hd__nor2_1
* cell instance sky130_fd_sc_hd__nor2_1_150 r0 *1 0,0
Xsky130_fd_sc_hd__nor2_1_150 \$219 \$368
+ vss
+ vdd
+ vdd
+ \$369 sky130_fd_sc_hd__nor2_1
* cell instance sky130_fd_sc_hd__nor2_1_151 r0 *1 0,0
Xsky130_fd_sc_hd__nor2_1_151 \$1753 \$281
+ vss
+ vdd
+ vdd
+ \$1856 sky130_fd_sc_hd__nor2_1
* cell instance sky130_fd_sc_hd__nor2_1_152 r0 *1 0,0
Xsky130_fd_sc_hd__nor2_1_152 \$219 \$1855
+ vss
+ vdd
+ vdd
+ \$1944 sky130_fd_sc_hd__nor2_1
* cell instance sky130_fd_sc_hd__nor2_1_153 r0 *1 0,0
Xsky130_fd_sc_hd__nor2_1_153 \$5882 \$5475
+ vss
+ vdd
+ vdd
+ \$6768 sky130_fd_sc_hd__nor2_1
* cell instance sky130_fd_sc_hd__nor2_1_154 r0 *1 0,0
Xsky130_fd_sc_hd__nor2_1_154 \$717 \$872
+ vss
+ vdd
+ vdd
+ \$722 sky130_fd_sc_hd__nor2_1
* cell instance sky130_fd_sc_hd__nor2_1_155 r0 *1 0,0
Xsky130_fd_sc_hd__nor2_1_155 \$1753 \$180
+ vss
+ vdd
+ vdd
+ \$2546 sky130_fd_sc_hd__nor2_1
* cell instance sky130_fd_sc_hd__nor2_1_156 r0 *1 0,0
Xsky130_fd_sc_hd__nor2_1_156 \$564 \$580
+ vss
+ vdd
+ vdd
+ \$634 sky130_fd_sc_hd__nor2_1
* cell instance sky130_fd_sc_hd__nor2_1_157 r0 *1 0,0
Xsky130_fd_sc_hd__nor2_1_157 \$1509 \$399
+ vss
+ vdd
+ vdd
+ \$3831 sky130_fd_sc_hd__nor2_1
* cell instance sky130_fd_sc_hd__nor2_1_158 r0 *1 0,0
Xsky130_fd_sc_hd__nor2_1_158 \$1753 \$399
+ vss
+ vdd
+ vdd
+ \$2445 sky130_fd_sc_hd__nor2_1
* cell instance sky130_fd_sc_hd__nor2_1_159 r0 *1 0,0
Xsky130_fd_sc_hd__nor2_1_159 \$721 \$580
+ vss
+ vdd
+ vdd
+ \$581 sky130_fd_sc_hd__nor2_1
* cell instance sky130_fd_sc_hd__nor2_1_160 r0 *1 0,0
Xsky130_fd_sc_hd__nor2_1_160 \$1509 \$281
+ vss
+ vdd
+ vdd
+ \$1510 sky130_fd_sc_hd__nor2_1
* cell instance sky130_fd_sc_hd__nor2_1_161 r0 *1 0,0
Xsky130_fd_sc_hd__nor2_1_161 \$563 \$721
+ vss
+ vdd
+ vdd
+ \$723 sky130_fd_sc_hd__nor2_1
* cell instance sky130_fd_sc_hd__nor2_1_162 r0 *1 0,0
Xsky130_fd_sc_hd__nor2_1_162 \$1509 \$742
+ vss
+ vdd
+ vdd
+ \$3944 sky130_fd_sc_hd__nor2_1
* cell instance sky130_fd_sc_hd__nor2_1_163 r0 *1 0,0
Xsky130_fd_sc_hd__nor2_1_163 \$370 \$281
+ vss
+ vdd
+ vdd
+ \$288 sky130_fd_sc_hd__nor2_1
* cell instance sky130_fd_sc_hd__nor2_1_164 r0 *1 0,0
Xsky130_fd_sc_hd__nor2_1_164 \$1756 \$281
+ vss
+ vdd
+ vdd
+ \$1759 sky130_fd_sc_hd__nor2_1
* cell instance sky130_fd_sc_hd__nor2_1_165 r0 *1 0,0
Xsky130_fd_sc_hd__nor2_1_165 \$219 \$287
+ vss
+ vdd
+ vdd
+ \$289 sky130_fd_sc_hd__nor2_1
* cell instance sky130_fd_sc_hd__nor2_1_166 r0 *1 0,0
Xsky130_fd_sc_hd__nor2_1_166 \$563 \$936
+ vss
+ vdd
+ vdd
+ \$1219 sky130_fd_sc_hd__nor2_1
* cell instance sky130_fd_sc_hd__nor2_1_167 r0 *1 0,0
Xsky130_fd_sc_hd__nor2_1_167 \$219 \$1575
+ vss
+ vdd
+ vdd
+ \$1511 sky130_fd_sc_hd__nor2_1
* cell instance sky130_fd_sc_hd__nor2_1_168 r0 *1 0,0
Xsky130_fd_sc_hd__nor2_1_168 \$221 \$281
+ vss
+ vdd
+ vdd
+ \$160 sky130_fd_sc_hd__nor2_1
* cell instance sky130_fd_sc_hd__nor2_1_169 r0 *1 0,0
Xsky130_fd_sc_hd__nor2_1_169 \$219 \$1946
+ vss
+ vdd
+ vdd
+ \$1947 sky130_fd_sc_hd__nor2_1
* cell instance sky130_fd_sc_hd__nor2_1_170 r0 *1 0,0
Xsky130_fd_sc_hd__nor2_1_170 \$1753 \$742
+ vss
+ vdd
+ vdd
+ \$2549 sky130_fd_sc_hd__nor2_1
* cell instance sky130_fd_sc_hd__nor2_1_171 r0 *1 0,0
Xsky130_fd_sc_hd__nor2_1_171 \$219 \$159
+ vss
+ vdd
+ vdd
+ \$161 sky130_fd_sc_hd__nor2_1
* cell instance sky130_fd_sc_hd__nor2_1_172 r0 *1 0,0
Xsky130_fd_sc_hd__nor2_1_172 \$1663 \$180
+ vss
+ vdd
+ vdd
+ \$2894 sky130_fd_sc_hd__nor2_1
* cell instance sky130_fd_sc_hd__nor2_1_173 r0 *1 0,0
Xsky130_fd_sc_hd__nor2_1_173 \$7367 \$5475
+ vss
+ vdd
+ vdd
+ \$7522 sky130_fd_sc_hd__nor2_1
* cell instance sky130_fd_sc_hd__nor2_1_174 r0 *1 0,0
Xsky130_fd_sc_hd__nor2_1_174 \$1663 \$399
+ vss
+ vdd
+ vdd
+ \$3301 sky130_fd_sc_hd__nor2_1
* cell instance sky130_fd_sc_hd__nor2_1_175 r0 *1 0,0
Xsky130_fd_sc_hd__nor2_1_175 \$935 \$580
+ vss
+ vdd
+ vdd
+ \$510 sky130_fd_sc_hd__nor2_1
* cell instance sky130_fd_sc_hd__nor2_1_176 r0 *1 0,0
Xsky130_fd_sc_hd__nor2_1_176 \$1663 \$281
+ vss
+ vdd
+ vdd
+ \$1760 sky130_fd_sc_hd__nor2_1
* cell instance sky130_fd_sc_hd__nor2_1_177 r0 *1 0,0
Xsky130_fd_sc_hd__nor2_1_177 \$5953 \$5475
+ vss
+ vdd
+ vdd
+ \$6130 sky130_fd_sc_hd__nor2_1
* cell instance sky130_fd_sc_hd__nor2_1_178 r0 *1 0,0
Xsky130_fd_sc_hd__nor2_1_178 \$1663 \$742
+ vss
+ vdd
+ vdd
+ \$3393 sky130_fd_sc_hd__nor2_1
* cell instance sky130_fd_sc_hd__nor2_1_179 r0 *1 0,0
Xsky130_fd_sc_hd__nor2_1_179 \$1150 \$1075
+ vss
+ vdd
+ vdd
+ \$788 sky130_fd_sc_hd__nor2_1
* cell instance sky130_fd_sc_hd__nor2_1_180 r0 *1 0,0
Xsky130_fd_sc_hd__nor2_1_180 \$727 \$281
+ vss
+ vdd
+ vdd
+ \$638 sky130_fd_sc_hd__nor2_1
* cell instance sky130_fd_sc_hd__nor2_1_181 r0 *1 0,0
Xsky130_fd_sc_hd__nor2_1_181 \$219 \$292
+ vss
+ vdd
+ vdd
+ \$231 sky130_fd_sc_hd__nor2_1
* cell instance sky130_fd_sc_hd__nor2_1_182 r0 *1 0,0
Xsky130_fd_sc_hd__nor2_1_182 \$1080 \$1220
+ vss
+ vdd
+ vdd
+ \$585 sky130_fd_sc_hd__nor2_1
* cell instance sky130_fd_sc_hd__nor2_1_183 r0 *1 0,0
Xsky130_fd_sc_hd__nor2_1_183 \$219 \$1762
+ vss
+ vdd
+ vdd
+ \$1584 sky130_fd_sc_hd__nor2_1
* cell instance sky130_fd_sc_hd__nor2_1_184 r0 *1 0,0
Xsky130_fd_sc_hd__nor2_1_184 \$230 \$281
+ vss
+ vdd
+ vdd
+ \$293 sky130_fd_sc_hd__nor2_1
* cell instance sky130_fd_sc_hd__nor2_1_185 r0 *1 0,0
Xsky130_fd_sc_hd__nor2_1_185 \$219 \$637
+ vss
+ vdd
+ vdd
+ \$583 sky130_fd_sc_hd__nor2_1
* cell instance sky130_fd_sc_hd__nor2_1_186 r0 *1 0,0
Xsky130_fd_sc_hd__nor2_1_186 \$7369 \$5475
+ vss
+ vdd
+ vdd
+ \$7370 sky130_fd_sc_hd__nor2_1
* cell instance sky130_fd_sc_hd__nor2_1_187 r0 *1 0,0
Xsky130_fd_sc_hd__nor2_1_187 \$6604 \$5475
+ vss
+ vdd
+ vdd
+ \$7027 sky130_fd_sc_hd__nor2_1
* cell instance sky130_fd_sc_hd__nor2_1_188 r0 *1 0,0
Xsky130_fd_sc_hd__nor2_1_188 \$290 \$1311
+ vss
+ vdd
+ vdd
+ \$1313 sky130_fd_sc_hd__nor2_1
* cell instance sky130_fd_sc_hd__nor2_1_189 r0 *1 0,0
Xsky130_fd_sc_hd__nor2_1_189 \$2202 \$3210
+ vss
+ vdd
+ vdd
+ \$4803 sky130_fd_sc_hd__nor2_1
* cell instance sky130_fd_sc_hd__nor2_1_190 r0 *1 0,0
Xsky130_fd_sc_hd__nor2_1_190 \$1756 \$180
+ vss
+ vdd
+ vdd
+ \$2254 sky130_fd_sc_hd__nor2_1
* cell instance sky130_fd_sc_hd__nor2_1_191 r0 *1 0,0
Xsky130_fd_sc_hd__nor2_1_191 \$102 \$281
+ vss
+ vdd
+ vdd
+ \$103 sky130_fd_sc_hd__nor2_1
* cell instance sky130_fd_sc_hd__nor2_1_192 r0 *1 0,0
Xsky130_fd_sc_hd__nor2_1_192 \$219 \$236
+ vss
+ vdd
+ vdd
+ \$104 sky130_fd_sc_hd__nor2_1
* cell instance sky130_fd_sc_hd__nor2_1_193 r0 *1 0,0
Xsky130_fd_sc_hd__nor2_1_193 \$297 \$281
+ vss
+ vdd
+ vdd
+ \$298 sky130_fd_sc_hd__nor2_1
* cell instance sky130_fd_sc_hd__nor2_1_194 r0 *1 0,0
Xsky130_fd_sc_hd__nor2_1_194 \$219 \$296
+ vss
+ vdd
+ vdd
+ \$237 sky130_fd_sc_hd__nor2_1
* cell instance sky130_fd_sc_hd__nor2_1_195 r0 *1 0,0
Xsky130_fd_sc_hd__nor2_1_195 \$1756 \$399
+ vss
+ vdd
+ vdd
+ \$2344 sky130_fd_sc_hd__nor2_1
* cell instance sky130_fd_sc_hd__nor2_1_196 r0 *1 0,0
Xsky130_fd_sc_hd__nor2_1_196 \$5434 \$4302
+ vss
+ vdd
+ vdd
+ \$5279 sky130_fd_sc_hd__nor2_1
* cell instance sky130_fd_sc_hd__nor2_1_197 r0 *1 0,0
Xsky130_fd_sc_hd__nor2_1_197 \$1764 \$180
+ vss
+ vdd
+ vdd
+ \$3305 sky130_fd_sc_hd__nor2_1
* cell instance sky130_fd_sc_hd__nor2_1_198 r0 *1 0,0
Xsky130_fd_sc_hd__nor2_1_198 \$5785 \$5325
+ vss
+ vdd
+ vdd
+ \$6320 sky130_fd_sc_hd__nor2_1
* cell instance sky130_fd_sc_hd__nor2_1_199 r0 *1 0,0
Xsky130_fd_sc_hd__nor2_1_199 \$7525 \$5475
+ vss
+ vdd
+ vdd
+ \$7531 sky130_fd_sc_hd__nor2_1
* cell instance sky130_fd_sc_hd__nor2_1_200 r0 *1 0,0
Xsky130_fd_sc_hd__nor2_1_200 \$1666 \$281
+ vss
+ vdd
+ vdd
+ \$1715 sky130_fd_sc_hd__nor2_1
* cell instance sky130_fd_sc_hd__nor2_1_201 r0 *1 0,0
Xsky130_fd_sc_hd__nor2_1_201 \$1756 \$742
+ vss
+ vdd
+ vdd
+ \$2453 sky130_fd_sc_hd__nor2_1
* cell instance sky130_fd_sc_hd__nor2_1_202 r0 *1 0,0
Xsky130_fd_sc_hd__nor2_1_202 \$1764 \$281
+ vss
+ vdd
+ vdd
+ \$1868 sky130_fd_sc_hd__nor2_1
* cell instance sky130_fd_sc_hd__nor2_1_203 r0 *1 0,0
Xsky130_fd_sc_hd__nor2_1_203 \$805 \$281
+ vss
+ vdd
+ vdd
+ \$880 sky130_fd_sc_hd__nor2_1
* cell instance sky130_fd_sc_hd__nor2_1_204 r0 *1 0,0
Xsky130_fd_sc_hd__nor2_1_204 \$1764 \$399
+ vss
+ vdd
+ vdd
+ \$3307 sky130_fd_sc_hd__nor2_1
* cell instance sky130_fd_sc_hd__nor2_1_205 r0 *1 0,0
Xsky130_fd_sc_hd__nor2_1_205 \$219 \$1769
+ vss
+ vdd
+ vdd
+ \$1770 sky130_fd_sc_hd__nor2_1
* cell instance sky130_fd_sc_hd__nor2_1_206 r0 *1 0,0
Xsky130_fd_sc_hd__nor2_1_206 \$219 \$1768
+ vss
+ vdd
+ vdd
+ \$1869 sky130_fd_sc_hd__nor2_1
* cell instance sky130_fd_sc_hd__nor2_1_207 r0 *1 0,0
Xsky130_fd_sc_hd__nor2_1_207 \$219 \$881
+ vss
+ vdd
+ vdd
+ \$882 sky130_fd_sc_hd__nor2_1
* cell instance sky130_fd_sc_hd__nor2_1_208 r0 *1 0,0
Xsky130_fd_sc_hd__nor2_1_208 \$574 \$1013
+ vss
+ vdd
+ vdd
+ \$940 sky130_fd_sc_hd__nor2_1
* cell instance sky130_fd_sc_hd__nor2_1_209 r0 *1 0,0
Xsky130_fd_sc_hd__nor2_1_209 \$1764 \$742
+ vss
+ vdd
+ vdd
+ \$3614 sky130_fd_sc_hd__nor2_1
* cell instance sky130_fd_sc_hd__nor2_1_210 r0 *1 0,0
Xsky130_fd_sc_hd__nor2_1_210 \$219 \$301
+ vss
+ vdd
+ vdd
+ \$303 sky130_fd_sc_hd__nor2_1
* cell instance sky130_fd_sc_hd__nor2_1_211 r0 *1 0,0
Xsky130_fd_sc_hd__nor2_1_211 \$206 \$281
+ vss
+ vdd
+ vdd
+ \$302 sky130_fd_sc_hd__nor2_1
* cell instance sky130_fd_sc_hd__nor2_1_212 r0 *1 0,0
Xsky130_fd_sc_hd__nor2_1_212 \$5785 \$4302
+ vss
+ vdd
+ vdd
+ \$5900 sky130_fd_sc_hd__nor2_1
* cell instance sky130_fd_sc_hd__nor2_1_213 r0 *1 0,0
Xsky130_fd_sc_hd__nor2_1_213 \$641 \$281
+ vss
+ vdd
+ vdd
+ \$521 sky130_fd_sc_hd__nor2_1
* cell instance sky130_fd_sc_hd__nor2_1_214 r0 *1 0,0
Xsky130_fd_sc_hd__nor2_1_214 \$6700 \$5325
+ vss
+ vdd
+ vdd
+ \$6956 sky130_fd_sc_hd__nor2_1
* cell instance sky130_fd_sc_hd__nor2_1_215 r0 *1 0,0
Xsky130_fd_sc_hd__nor2_1_215 \$219 \$520
+ vss
+ vdd
+ vdd
+ \$522 sky130_fd_sc_hd__nor2_1
* cell instance sky130_fd_sc_hd__nor2_1_216 r0 *1 0,0
Xsky130_fd_sc_hd__nor2_1_216 \$594 \$281
+ vss
+ vdd
+ vdd
+ \$596 sky130_fd_sc_hd__nor2_1
* cell instance sky130_fd_sc_hd__nor2_1_217 r0 *1 0,0
Xsky130_fd_sc_hd__nor2_1_217 \$6700 \$4302
+ vss
+ vdd
+ vdd
+ \$6523 sky130_fd_sc_hd__nor2_1
* cell instance sky130_fd_sc_hd__nor2_1_218 r0 *1 0,0
Xsky130_fd_sc_hd__nor2_1_218 \$219 \$644
+ vss
+ vdd
+ vdd
+ \$597 sky130_fd_sc_hd__nor2_1
* cell instance sky130_fd_sc_hd__nor2_1_219 r0 *1 0,0
Xsky130_fd_sc_hd__nor2_1_219 \$1016 \$281
+ vss
+ vdd
+ vdd
+ \$1017 sky130_fd_sc_hd__nor2_1
* cell instance sky130_fd_sc_hd__nor2_1_220 r0 *1 0,0
Xsky130_fd_sc_hd__nor2_1_220 \$290 \$1316
+ vss
+ vdd
+ vdd
+ \$1669 sky130_fd_sc_hd__nor2_1
* cell instance sky130_fd_sc_hd__nor2_1_221 r0 *1 0,0
Xsky130_fd_sc_hd__nor2_1_221 \$4301 \$5325
+ vss
+ vdd
+ vdd
+ \$5240 sky130_fd_sc_hd__nor2_1
* cell instance sky130_fd_sc_hd__nor2_1_222 r0 *1 0,0
Xsky130_fd_sc_hd__nor2_1_222 \$4301 \$4302
+ vss
+ vdd
+ vdd
+ \$4303 sky130_fd_sc_hd__nor2_1
* cell instance sky130_fd_sc_hd__nor2_1_223 r0 *1 0,0
Xsky130_fd_sc_hd__nor2_1_223 \$221 \$180
+ vss
+ vdd
+ vdd
+ \$179 sky130_fd_sc_hd__nor2_1
* cell instance sky130_fd_sc_hd__nor2_1_224 r0 *1 0,0
Xsky130_fd_sc_hd__nor2_1_224 \$219 \$884
+ vss
+ vdd
+ vdd
+ \$1018 sky130_fd_sc_hd__nor2_1
* cell instance sky130_fd_sc_hd__nor2_1_225 r0 *1 0,0
Xsky130_fd_sc_hd__nor2_1_225 \$7308 \$5475
+ vss
+ vdd
+ vdd
+ \$7221 sky130_fd_sc_hd__nor2_1
* cell instance sky130_fd_sc_hd__nor2_1_226 r0 *1 0,0
Xsky130_fd_sc_hd__nor2_1_226 \$1669 \$1771
+ vss
+ vdd
+ vdd
+ \$1594 sky130_fd_sc_hd__nor2_1
* cell instance sky130_fd_sc_hd__nor2_1_227 r0 *1 0,0
Xsky130_fd_sc_hd__nor2_1_227 \$6613 \$5475
+ vss
+ vdd
+ vdd
+ \$6617 sky130_fd_sc_hd__nor2_1
* cell instance sky130_fd_sc_hd__nor2_1_228 r0 *1 0,0
Xsky130_fd_sc_hd__nor2_1_228 \$1091 \$281
+ vss
+ vdd
+ vdd
+ \$1092 sky130_fd_sc_hd__nor2_1
* cell instance sky130_fd_sc_hd__nor2_1_229 r0 *1 0,0
Xsky130_fd_sc_hd__nor2_1_229 \$1428 \$281
+ vss
+ vdd
+ vdd
+ \$1324 sky130_fd_sc_hd__nor2_1
* cell instance sky130_fd_sc_hd__nor2_1_230 r0 *1 0,0
Xsky130_fd_sc_hd__nor2_1_230 \$1508 \$742
+ vss
+ vdd
+ vdd
+ \$1872 sky130_fd_sc_hd__nor2_1
* cell instance sky130_fd_sc_hd__nor2_1_231 r0 *1 0,0
Xsky130_fd_sc_hd__nor2_1_231 \$221 \$742
+ vss
+ vdd
+ vdd
+ \$741 sky130_fd_sc_hd__nor2_1
* cell instance sky130_fd_sc_hd__nor2_1_232 r0 *1 0,0
Xsky130_fd_sc_hd__nor2_1_232 \$219 \$1020
+ vss
+ vdd
+ vdd
+ \$1093 sky130_fd_sc_hd__nor2_1
* cell instance sky130_fd_sc_hd__nor2_1_233 r0 *1 0,0
Xsky130_fd_sc_hd__nor2_1_233 \$219 \$1323
+ vss
+ vdd
+ vdd
+ \$1325 sky130_fd_sc_hd__nor2_1
* cell instance sky130_fd_sc_hd__nor2_1_234 r0 *1 0,0
Xsky130_fd_sc_hd__nor2_1_234 \$1516 \$1515
+ vss
+ vdd
+ vdd
+ \$2263 sky130_fd_sc_hd__nor2_1
* cell instance sky130_fd_sc_hd__nor2_1_235 r0 *1 0,0
Xsky130_fd_sc_hd__nor2_1_235 \$573 \$742
+ vss
+ vdd
+ vdd
+ \$743 sky130_fd_sc_hd__nor2_1
* cell instance sky130_fd_sc_hd__nor2_1_236 r0 *1 0,0
Xsky130_fd_sc_hd__nor2_1_236 \$1515 \$1773
+ vss
+ vdd
+ vdd
+ \$598 sky130_fd_sc_hd__nor2_1
* cell instance sky130_fd_sc_hd__nor2_1_237 r0 *1 0,0
Xsky130_fd_sc_hd__nor2_1_237 \$219 \$2455
+ vss
+ vdd
+ vdd
+ \$2458 sky130_fd_sc_hd__nor2_1
* cell instance sky130_fd_sc_hd__nor2_1_238 r0 *1 0,0
Xsky130_fd_sc_hd__nor2_1_238 \$3318 \$3319
+ vss
+ vdd
+ vdd
+ \$2679 sky130_fd_sc_hd__nor2_1
* cell instance sky130_fd_sc_hd__nor2_1_239 r0 *1 0,0
Xsky130_fd_sc_hd__nor2_1_239 \$3259 \$4304
+ vss
+ vdd
+ vdd
+ \$4206 sky130_fd_sc_hd__nor2_1
* cell instance sky130_fd_sc_hd__nor2_1_240 r0 *1 0,0
Xsky130_fd_sc_hd__nor2_1_240 \$7222 \$5475
+ vss
+ vdd
+ vdd
+ \$7543 sky130_fd_sc_hd__nor2_1
* cell instance sky130_fd_sc_hd__nor2_1_241 r0 *1 0,0
Xsky130_fd_sc_hd__nor2_1_241 \$573 \$180
+ vss
+ vdd
+ vdd
+ \$252 sky130_fd_sc_hd__nor2_1
* cell instance sky130_fd_sc_hd__nor2_1_242 r0 *1 0,0
Xsky130_fd_sc_hd__nor2_1_242 \$2801 \$886
+ vss
+ vdd
+ vdd
+ \$3512 sky130_fd_sc_hd__nor2_1
* cell instance sky130_fd_sc_hd__nor2_1_243 r0 *1 0,0
Xsky130_fd_sc_hd__nor2_1_243 \$219 \$1875
+ vss
+ vdd
+ vdd
+ \$2682 sky130_fd_sc_hd__nor2_1
* cell instance sky130_fd_sc_hd__nor2_1_244 r0 *1 0,0
Xsky130_fd_sc_hd__nor2_1_244 bus_wdata[2] \$3094
+ vss
+ vdd
+ vdd
+ \$3319 sky130_fd_sc_hd__nor2_1
* cell instance sky130_fd_sc_hd__nor2_1_245 r0 *1 0,0
Xsky130_fd_sc_hd__nor2_1_245 \$2569 \$2459
+ vss
+ vdd
+ vdd
+ \$2356 sky130_fd_sc_hd__nor2_1
* cell instance sky130_fd_sc_hd__nor2_1_246 r0 *1 0,0
Xsky130_fd_sc_hd__nor2_1_246 \$1508 \$180
+ vss
+ vdd
+ vdd
+ \$1327 sky130_fd_sc_hd__nor2_1
* cell instance sky130_fd_sc_hd__nor2_1_247 r0 *1 0,0
Xsky130_fd_sc_hd__nor2_1_247 \$4541 \$5475
+ vss
+ vdd
+ vdd
+ \$5590 sky130_fd_sc_hd__nor2_1
* cell instance sky130_fd_sc_hd__nor2_1_248 r0 *1 0,0
Xsky130_fd_sc_hd__nor2_1_248 \$641 \$399
+ vss
+ vdd
+ vdd
+ \$888 sky130_fd_sc_hd__nor2_1
* cell instance sky130_fd_sc_hd__nor2_1_249 r0 *1 0,0
Xsky130_fd_sc_hd__nor2_1_249 \$180 \$1667
+ vss
+ vdd
+ vdd
+ \$1774 sky130_fd_sc_hd__nor2_1
* cell instance sky130_fd_sc_hd__nor2_1_250 r0 *1 0,0
Xsky130_fd_sc_hd__nor2_1_250 \$182 \$1022
+ vss
+ vdd
+ vdd
+ \$961 sky130_fd_sc_hd__nor2_1
* cell instance sky130_fd_sc_hd__nor2_1_251 r0 *1 0,0
Xsky130_fd_sc_hd__nor2_1_251 \$2579 \$2202
+ vss
+ vdd
+ vdd
+ \$2575 sky130_fd_sc_hd__nor2_1
* cell instance sky130_fd_sc_hd__nor2_1_252 r0 *1 0,0
Xsky130_fd_sc_hd__nor2_1_252 \$5582 \$5475
+ vss
+ vdd
+ vdd
+ \$5807 sky130_fd_sc_hd__nor2_1
* cell instance sky130_fd_sc_hd__nor2_1_253 r0 *1 0,0
Xsky130_fd_sc_hd__nor2_1_253 \$6087 \$5475
+ vss
+ vdd
+ vdd
+ \$6236 sky130_fd_sc_hd__nor2_1
* cell instance sky130_fd_sc_hd__nor2_1_254 r0 *1 0,0
Xsky130_fd_sc_hd__nor2_1_254 \$2686 \$2680
+ vss
+ vdd
+ vdd
+ \$2683 sky130_fd_sc_hd__nor2_1
* cell instance sky130_fd_sc_hd__nor2_1_255 r0 *1 0,0
Xsky130_fd_sc_hd__nor2_1_255 \$2202 \$2265
+ vss
+ vdd
+ vdd
+ \$2295 sky130_fd_sc_hd__nor2_1
* cell instance sky130_fd_sc_hd__nor2_1_256 r0 *1 0,0
Xsky130_fd_sc_hd__nor2_1_256 \$7305 \$5325
+ vss
+ vdd
+ vdd
+ \$7775 sky130_fd_sc_hd__nor2_1
* cell instance sky130_fd_sc_hd__nor2_1_257 r0 *1 0,0
Xsky130_fd_sc_hd__nor2_1_257 \$6321 \$5325
+ vss
+ vdd
+ vdd
+ \$6720 sky130_fd_sc_hd__nor2_1
* cell instance sky130_fd_sc_hd__nor2_1_258 r0 *1 0,0
Xsky130_fd_sc_hd__nor2_1_258 \$5149 \$5475
+ vss
+ vdd
+ vdd
+ \$5476 sky130_fd_sc_hd__nor2_1
* cell instance sky130_fd_sc_hd__nor2_1_259 r0 *1 0,0
Xsky130_fd_sc_hd__nor2_1_259 \$2458 \$2680
+ vss
+ vdd
+ vdd
+ \$2572 sky130_fd_sc_hd__nor2_1
* cell instance sky130_fd_sc_hd__nor2_1_260 r0 *1 0,0
Xsky130_fd_sc_hd__nor2_1_260 \$2686 \$2572
+ vss
+ vdd
+ vdd
+ \$2847 sky130_fd_sc_hd__nor2_1
* cell instance sky130_fd_sc_hd__nor2_1_261 r0 *1 0,0
Xsky130_fd_sc_hd__nor2_1_261 \$7305 \$4302
+ vss
+ vdd
+ vdd
+ \$7397 sky130_fd_sc_hd__nor2_1
* cell instance sky130_fd_sc_hd__nor2_1_262 r0 *1 0,0
Xsky130_fd_sc_hd__nor2_1_262 \$4085 \$2908
+ vss
+ vdd
+ vdd
+ \$4095 sky130_fd_sc_hd__nor2_1
* cell instance sky130_fd_sc_hd__nor2_1_263 r0 *1 0,0
Xsky130_fd_sc_hd__nor2_1_263 \$230 \$399
+ vss
+ vdd
+ vdd
+ \$755 sky130_fd_sc_hd__nor2_1
* cell instance sky130_fd_sc_hd__nor2_1_264 r0 *1 0,0
Xsky130_fd_sc_hd__nor2_1_264 \$1428 \$180
+ vss
+ vdd
+ vdd
+ \$1681 sky130_fd_sc_hd__nor2_1
* cell instance sky130_fd_sc_hd__nor2_1_265 r0 *1 0,0
Xsky130_fd_sc_hd__nor2_1_265 \$1428 \$399
+ vss
+ vdd
+ vdd
+ \$1887 sky130_fd_sc_hd__nor2_1
* cell instance sky130_fd_sc_hd__nor2_1_266 r0 *1 0,0
Xsky130_fd_sc_hd__nor2_1_266 \$1428 \$683
+ vss
+ vdd
+ vdd
+ \$2069 sky130_fd_sc_hd__nor2_1
* cell instance sky130_fd_sc_hd__nor2_1_267 r0 *1 0,0
Xsky130_fd_sc_hd__nor2_1_267 \$6536 \$5475
+ vss
+ vdd
+ vdd
+ \$6634 sky130_fd_sc_hd__nor2_1
* cell instance sky130_fd_sc_hd__nor2_1_268 r0 *1 0,0
Xsky130_fd_sc_hd__nor2_1_268 \$182 \$892
+ vss
+ vdd
+ vdd
+ \$1027 sky130_fd_sc_hd__nor2_1
* cell instance sky130_fd_sc_hd__nor2_1_269 r0 *1 0,0
Xsky130_fd_sc_hd__nor2_1_269 \$6721 \$5475
+ vss
+ vdd
+ vdd
+ \$7163 sky130_fd_sc_hd__nor2_1
* cell instance sky130_fd_sc_hd__nor2_1_270 r0 *1 0,0
Xsky130_fd_sc_hd__nor2_1_270 \$5703 \$5475
+ vss
+ vdd
+ vdd
+ \$5704 sky130_fd_sc_hd__nor2_1
* cell instance sky130_fd_sc_hd__nor2_1_271 r0 *1 0,0
Xsky130_fd_sc_hd__nor2_1_271 bus_wdata[1] \$3008
+ vss
+ vdd
+ vdd
+ \$3330 sky130_fd_sc_hd__nor2_1
* cell instance sky130_fd_sc_hd__nor2_1_272 r0 *1 0,0
Xsky130_fd_sc_hd__nor2_1_272 \$6335 \$5475
+ vss
+ vdd
+ vdd
+ \$6242 sky130_fd_sc_hd__nor2_1
* cell instance sky130_fd_sc_hd__nor2_1_273 r0 *1 0,0
Xsky130_fd_sc_hd__nor2_1_273 bus_wdata[0] \$3008
+ vss
+ vdd
+ vdd
+ \$3416 sky130_fd_sc_hd__nor2_1
* cell instance sky130_fd_sc_hd__nor2_1_274 r0 *1 0,0
Xsky130_fd_sc_hd__nor2_1_274 \$1091 \$399
+ vss
+ vdd
+ vdd
+ \$1338 sky130_fd_sc_hd__nor2_1
* cell instance sky130_fd_sc_hd__nor2_1_275 r0 *1 0,0
Xsky130_fd_sc_hd__nor2_1_275 bus_addr[2] \$3331
+ vss
+ vdd
+ vdd
+ \$3415 sky130_fd_sc_hd__nor2_1
* cell instance sky130_fd_sc_hd__nor2_1_276 r0 *1 0,0
Xsky130_fd_sc_hd__nor2_1_276 \$284 \$399
+ vss
+ vdd
+ vdd
+ \$533 sky130_fd_sc_hd__nor2_1
* cell instance sky130_fd_sc_hd__nor2_1_277 r0 *1 0,0
Xsky130_fd_sc_hd__nor2_1_277 \$5705 \$5325
+ vss
+ vdd
+ vdd
+ \$6061 sky130_fd_sc_hd__nor2_1
* cell instance sky130_fd_sc_hd__nor2_1_278 r0 *1 0,0
Xsky130_fd_sc_hd__nor2_1_278 \$5705 \$4302
+ vss
+ vdd
+ vdd
+ \$5596 sky130_fd_sc_hd__nor2_1
* cell instance sky130_fd_sc_hd__nor2_1_279 r0 *1 0,0
Xsky130_fd_sc_hd__nor2_1_279 \$102 \$399
+ vss
+ vdd
+ vdd
+ \$470 sky130_fd_sc_hd__nor2_1
* cell instance sky130_fd_sc_hd__nor2_1_280 r0 *1 0,0
Xsky130_fd_sc_hd__nor2_1_280 \$6724 \$5325
+ vss
+ vdd
+ vdd
+ \$7166 sky130_fd_sc_hd__nor2_1
* cell instance sky130_fd_sc_hd__nor2_1_281 r0 *1 0,0
Xsky130_fd_sc_hd__nor2_1_281 \$6321 \$4302
+ vss
+ vdd
+ vdd
+ \$6457 sky130_fd_sc_hd__nor2_1
* cell instance sky130_fd_sc_hd__nor2_1_282 r0 *1 0,0
Xsky130_fd_sc_hd__nor2_1_282 \$182 \$832
+ vss
+ vdd
+ vdd
+ \$759 sky130_fd_sc_hd__nor2_1
* cell instance sky130_fd_sc_hd__nor2_1_283 r0 *1 0,0
Xsky130_fd_sc_hd__nor2_1_283 \$6724 \$4302
+ vss
+ vdd
+ vdd
+ \$6891 sky130_fd_sc_hd__nor2_1
* cell instance sky130_fd_sc_hd__nor2_1_284 r0 *1 0,0
Xsky130_fd_sc_hd__nor2_1_284 \$182 \$897
+ vss
+ vdd
+ vdd
+ \$836 sky130_fd_sc_hd__nor2_1
* cell instance sky130_fd_sc_hd__nor2_1_285 r0 *1 0,0
Xsky130_fd_sc_hd__nor2_1_285 \$1666 \$180
+ vss
+ vdd
+ vdd
+ \$1979 sky130_fd_sc_hd__nor2_1
* cell instance sky130_fd_sc_hd__nor2_1_286 r0 *1 0,0
Xsky130_fd_sc_hd__nor2_1_286 \$182 \$1608
+ vss
+ vdd
+ vdd
+ \$1609 sky130_fd_sc_hd__nor2_1
* cell instance sky130_fd_sc_hd__nor2_1_287 r0 *1 0,0
Xsky130_fd_sc_hd__nor2_1_287 \$1141 \$399
+ vss
+ vdd
+ vdd
+ \$1451 sky130_fd_sc_hd__nor2_1
* cell instance sky130_fd_sc_hd__nor2_1_288 r0 *1 0,0
Xsky130_fd_sc_hd__nor2_1_288 \$1666 \$399
+ vss
+ vdd
+ vdd
+ \$2281 sky130_fd_sc_hd__nor2_1
* cell instance sky130_fd_sc_hd__nor2_1_289 r0 *1 0,0
Xsky130_fd_sc_hd__nor2_1_289 \$1666 \$683
+ vss
+ vdd
+ vdd
+ \$2194 sky130_fd_sc_hd__nor2_1
* cell instance sky130_fd_sc_hd__nor2_1_290 r0 *1 0,0
Xsky130_fd_sc_hd__nor2_1_290 \$370 \$399
+ vss
+ vdd
+ vdd
+ \$401 sky130_fd_sc_hd__nor2_1
* cell instance sky130_fd_sc_hd__nor2_1_291 r0 *1 0,0
Xsky130_fd_sc_hd__nor2_1_291 \$182 \$837
+ vss
+ vdd
+ vdd
+ \$839 sky130_fd_sc_hd__nor2_1
* cell instance sky130_fd_sc_hd__nor2_1_292 r0 *1 0,0
Xsky130_fd_sc_hd__nor2_1_292 \$1992 \$2702
+ vss
+ vdd
+ vdd
+ out_data[5] sky130_fd_sc_hd__nor2_1
* cell instance sky130_fd_sc_hd__nor2_1_293 r0 *1 0,0
Xsky130_fd_sc_hd__nor2_1_293 \$4560 \$4302
+ vss
+ vdd
+ vdd
+ \$4561 sky130_fd_sc_hd__nor2_1
* cell instance sky130_fd_sc_hd__nor2_1_294 r0 *1 0,0
Xsky130_fd_sc_hd__nor2_1_294 \$4560 \$5325
+ vss
+ vdd
+ vdd
+ \$6156 sky130_fd_sc_hd__nor2_1
* cell instance sky130_fd_sc_hd__nor2_1_295 r0 *1 0,0
Xsky130_fd_sc_hd__nor2_1_295 \$7078 \$5325
+ vss
+ vdd
+ vdd
+ \$7485 sky130_fd_sc_hd__nor2_1
* cell instance sky130_fd_sc_hd__nor2_1_296 r0 *1 0,0
Xsky130_fd_sc_hd__nor2_1_296 \$7078 \$4302
+ vss
+ vdd
+ vdd
+ \$7079 sky130_fd_sc_hd__nor2_1
* cell instance sky130_fd_sc_hd__nor2_1_297 r0 *1 0,0
Xsky130_fd_sc_hd__nor2_1_297 \$6454 \$5325
+ vss
+ vdd
+ vdd
+ \$6734 sky130_fd_sc_hd__nor2_1
* cell instance sky130_fd_sc_hd__nor2_1_298 r0 *1 0,0
Xsky130_fd_sc_hd__nor2_1_298 \$6454 \$4302
+ vss
+ vdd
+ vdd
+ \$6470 sky130_fd_sc_hd__nor2_1
* cell instance sky130_fd_sc_hd__nor2_1_299 r0 *1 0,0
Xsky130_fd_sc_hd__nor2_1_299 \$182 \$686
+ vss
+ vdd
+ vdd
+ \$688 sky130_fd_sc_hd__nor2_1
* cell instance sky130_fd_sc_hd__nor2_1_300 r0 *1 0,0
Xsky130_fd_sc_hd__nor2_1_300 \$1992 \$3866
+ vss
+ vdd
+ vdd
+ out_data[26] sky130_fd_sc_hd__nor2_1
* cell instance sky130_fd_sc_hd__nor2_1_301 r0 *1 0,0
Xsky130_fd_sc_hd__nor2_1_301 \$399 \$1667
+ vss
+ vdd
+ vdd
+ \$1798 sky130_fd_sc_hd__nor2_1
* cell instance sky130_fd_sc_hd__nor2_1_302 r0 *1 0,0
Xsky130_fd_sc_hd__nor2_1_302 \$297 \$399
+ vss
+ vdd
+ vdd
+ \$547 sky130_fd_sc_hd__nor2_1
* cell instance sky130_fd_sc_hd__nor2_1_303 r0 *1 0,0
Xsky130_fd_sc_hd__nor2_1_303 \$1016 \$180
+ vss
+ vdd
+ vdd
+ \$1043 sky130_fd_sc_hd__nor2_1
* cell instance sky130_fd_sc_hd__nor2_1_304 r0 *1 0,0
Xsky130_fd_sc_hd__nor2_1_304 \$683 \$1667
+ vss
+ vdd
+ vdd
+ \$1908 sky130_fd_sc_hd__nor2_1
* cell instance sky130_fd_sc_hd__nor2_1_305 r0 *1 0,0
Xsky130_fd_sc_hd__nor2_1_305 \$805 \$180
+ vss
+ vdd
+ vdd
+ \$2704 sky130_fd_sc_hd__nor2_1
* cell instance sky130_fd_sc_hd__nor2_1_306 r0 *1 0,0
Xsky130_fd_sc_hd__nor2_1_306 \$1016 \$399
+ vss
+ vdd
+ vdd
+ \$1118 sky130_fd_sc_hd__nor2_1
* cell instance sky130_fd_sc_hd__nor2_1_307 r0 *1 0,0
Xsky130_fd_sc_hd__nor2_1_307 \$805 \$399
+ vss
+ vdd
+ vdd
+ \$2921 sky130_fd_sc_hd__nor2_1
* cell instance sky130_fd_sc_hd__nor2_1_308 r0 *1 0,0
Xsky130_fd_sc_hd__nor2_1_308 \$1016 \$683
+ vss
+ vdd
+ vdd
+ \$1198 sky130_fd_sc_hd__nor2_1
* cell instance sky130_fd_sc_hd__nor2_1_309 r0 *1 0,0
Xsky130_fd_sc_hd__nor2_1_309 \$727 \$180
+ vss
+ vdd
+ vdd
+ \$1538 sky130_fd_sc_hd__nor2_1
* cell instance sky130_fd_sc_hd__nor2_1_310 r0 *1 0,0
Xsky130_fd_sc_hd__nor2_1_310 \$805 \$683
+ vss
+ vdd
+ vdd
+ \$3019 sky130_fd_sc_hd__nor2_1
* cell instance sky130_fd_sc_hd__nor2_1_311 r0 *1 0,0
Xsky130_fd_sc_hd__nor2_1_311 \$727 \$399
+ vss
+ vdd
+ vdd
+ \$1623 sky130_fd_sc_hd__nor2_1
* cell instance sky130_fd_sc_hd__nor2_1_312 r0 *1 0,0
Xsky130_fd_sc_hd__nor2_1_312 \$594 \$399
+ vss
+ vdd
+ vdd
+ \$918 sky130_fd_sc_hd__nor2_1
* cell instance sky130_fd_sc_hd__nor2_1_313 r0 *1 0,0
Xsky130_fd_sc_hd__nor2_1_313 \$594 \$180
+ vss
+ vdd
+ vdd
+ \$773 sky130_fd_sc_hd__nor2_1
* cell instance sky130_fd_sc_hd__nor2_1_314 r0 *1 0,0
Xsky130_fd_sc_hd__nor2_1_314 \$727 \$683
+ vss
+ vdd
+ vdd
+ \$1702 sky130_fd_sc_hd__nor2_1
* cell instance sky130_fd_sc_hd__nor2_1_315 r0 *1 0,0
Xsky130_fd_sc_hd__nor2_1_315 \$206 \$683
+ vss
+ vdd
+ vdd
+ \$486 sky130_fd_sc_hd__nor2_1
* cell instance sky130_fd_sc_hd__nor2_1_316 r0 *1 0,0
Xsky130_fd_sc_hd__nor2_1_316 \$206 \$399
+ vss
+ vdd
+ vdd
+ \$353 sky130_fd_sc_hd__nor2_1
* cell instance sky130_fd_sc_hd__nor2_1_317 r0 *1 0,0
Xsky130_fd_sc_hd__nor2_1_317 \$594 \$683
+ vss
+ vdd
+ vdd
+ \$991 sky130_fd_sc_hd__nor2_1
* cell instance sky130_fd_sc_hd__nor2_1_318 r0 *1 0,0
Xsky130_fd_sc_hd__nor2_1_318 \$1992 \$5925
+ vss
+ vdd
+ vdd
+ out_data[4] sky130_fd_sc_hd__nor2_1
* cell instance sky130_fd_sc_hd__nor2_1_319 r0 *1 0,0
Xsky130_fd_sc_hd__nor2_1_319 \$1992 \$2075
+ vss
+ vdd
+ vdd
+ out_data[0] sky130_fd_sc_hd__nor2_1
* cell instance sky130_fd_sc_hd__nor2_1_320 r0 *1 0,0
Xsky130_fd_sc_hd__nor2_1_320 \$1992 \$2068
+ vss
+ vdd
+ vdd
+ out_data[1] sky130_fd_sc_hd__nor2_1
* cell instance sky130_fd_sc_hd__nor2_1_321 r0 *1 0,0
Xsky130_fd_sc_hd__nor2_1_321 \$1992 \$2278
+ vss
+ vdd
+ vdd
+ out_data[16] sky130_fd_sc_hd__nor2_1
* cell instance sky130_fd_sc_hd__nor2_1_322 r0 *1 0,0
Xsky130_fd_sc_hd__nor2_1_322 \$1992 \$2192
+ vss
+ vdd
+ vdd
+ out_data[6] sky130_fd_sc_hd__nor2_1
* cell instance sky130_fd_sc_hd__nor2_1_323 r0 *1 0,0
Xsky130_fd_sc_hd__nor2_1_323 \$1992 \$2919
+ vss
+ vdd
+ vdd
+ out_data[27] sky130_fd_sc_hd__nor2_1
* cell instance sky130_fd_sc_hd__nor2_1_324 r0 *1 0,0
Xsky130_fd_sc_hd__nor2_1_324 \$1992 \$3247
+ vss
+ vdd
+ vdd
+ out_data[12] sky130_fd_sc_hd__nor2_1
* cell instance sky130_fd_sc_hd__nor2_1_325 r0 *1 0,0
Xsky130_fd_sc_hd__nor2_1_325 \$1992 \$3641
+ vss
+ vdd
+ vdd
+ out_data[24] sky130_fd_sc_hd__nor2_1
* cell instance sky130_fd_sc_hd__nor2_1_326 r0 *1 0,0
Xsky130_fd_sc_hd__nor2_1_326 \$1992 \$4197
+ vss
+ vdd
+ vdd
+ out_data[15] sky130_fd_sc_hd__nor2_1
* cell instance sky130_fd_sc_hd__nor2_1_327 r0 *1 0,0
Xsky130_fd_sc_hd__nor2_1_327 \$1992 \$4909
+ vss
+ vdd
+ vdd
+ out_data[29] sky130_fd_sc_hd__nor2_1
* cell instance sky130_fd_sc_hd__nor2_1_328 r0 *1 0,0
Xsky130_fd_sc_hd__nor2_1_328 \$1992 \$4752
+ vss
+ vdd
+ vdd
+ out_data[10] sky130_fd_sc_hd__nor2_1
* cell instance sky130_fd_sc_hd__nor2_1_329 r0 *1 0,0
Xsky130_fd_sc_hd__nor2_1_329 \$1992 \$5252
+ vss
+ vdd
+ vdd
+ out_data[2] sky130_fd_sc_hd__nor2_1
* cell instance sky130_fd_sc_hd__nor2_1_330 r0 *1 0,0
Xsky130_fd_sc_hd__nor2_1_330 \$1992 \$5589
+ vss
+ vdd
+ vdd
+ out_data[18] sky130_fd_sc_hd__nor2_1
* cell instance sky130_fd_sc_hd__nor2_1_331 r0 *1 0,0
Xsky130_fd_sc_hd__nor2_1_331 \$1992 \$5174
+ vss
+ vdd
+ vdd
+ out_data[3] sky130_fd_sc_hd__nor2_1
* cell instance sky130_fd_sc_hd__nor2_1_332 r0 *1 0,0
Xsky130_fd_sc_hd__nor2_1_332 \$1992 \$5708
+ vss
+ vdd
+ vdd
+ out_data[21] sky130_fd_sc_hd__nor2_1
* cell instance sky130_fd_sc_hd__nor2_1_333 r0 *1 0,0
Xsky130_fd_sc_hd__nor2_1_333 \$1992 \$5684
+ vss
+ vdd
+ vdd
+ out_data[17] sky130_fd_sc_hd__nor2_1
* cell instance sky130_fd_sc_hd__nor2_1_334 r0 *1 0,0
Xsky130_fd_sc_hd__nor2_1_334 \$1992 \$6079
+ vss
+ vdd
+ vdd
+ out_data[8] sky130_fd_sc_hd__nor2_1
* cell instance sky130_fd_sc_hd__nor2_1_335 r0 *1 0,0
Xsky130_fd_sc_hd__nor2_1_335 \$1992 \$5940
+ vss
+ vdd
+ vdd
+ out_data[31] sky130_fd_sc_hd__nor2_1
* cell instance sky130_fd_sc_hd__nor2_1_336 r0 *1 0,0
Xsky130_fd_sc_hd__nor2_1_336 \$1992 \$3892
+ vss
+ vdd
+ vdd
+ out_data[7] sky130_fd_sc_hd__nor2_1
* cell instance sky130_fd_sc_hd__nor2_1_337 r0 *1 0,0
Xsky130_fd_sc_hd__nor2_1_337 \$1992 \$3881
+ vss
+ vdd
+ vdd
+ out_data[19] sky130_fd_sc_hd__nor2_1
* cell instance sky130_fd_sc_hd__nor2_1_338 r0 *1 0,0
Xsky130_fd_sc_hd__nor2_1_338 \$1992 \$4338
+ vss
+ vdd
+ vdd
+ out_data[13] sky130_fd_sc_hd__nor2_1
* cell instance sky130_fd_sc_hd__nor2_1_339 r0 *1 0,0
Xsky130_fd_sc_hd__nor2_1_339 \$1992 \$2063
+ vss
+ vdd
+ vdd
+ out_data[30] sky130_fd_sc_hd__nor2_1
* cell instance sky130_fd_sc_hd__nor2_1_340 r0 *1 0,0
Xsky130_fd_sc_hd__nor2_1_340 \$1992 \$2279
+ vss
+ vdd
+ vdd
+ out_data[28] sky130_fd_sc_hd__nor2_1
* cell instance sky130_fd_sc_hd__nor2_1_341 r0 *1 0,0
Xsky130_fd_sc_hd__nor2_1_341 \$1992 \$2712
+ vss
+ vdd
+ vdd
+ out_data[9] sky130_fd_sc_hd__nor2_1
* cell instance sky130_fd_sc_hd__nor2_1_342 r0 *1 0,0
Xsky130_fd_sc_hd__nor2_1_342 \$1992 \$3063
+ vss
+ vdd
+ vdd
+ out_data[23] sky130_fd_sc_hd__nor2_1
* cell instance sky130_fd_sc_hd__nor2_1_343 r0 *1 0,0
Xsky130_fd_sc_hd__nor2_1_343 \$1992 \$4981
+ vss
+ vdd
+ vdd
+ out_data[11] sky130_fd_sc_hd__nor2_1
* cell instance sky130_fd_sc_hd__nor2_1_344 r0 *1 0,0
Xsky130_fd_sc_hd__nor2_1_344 \$1992 \$5446
+ vss
+ vdd
+ vdd
+ out_data[14] sky130_fd_sc_hd__nor2_1
* cell instance sky130_fd_sc_hd__nor2_1_345 r0 *1 0,0
Xsky130_fd_sc_hd__nor2_1_345 \$1992 \$5774
+ vss
+ vdd
+ vdd
+ out_data[22] sky130_fd_sc_hd__nor2_1
* cell instance sky130_fd_sc_hd__nor2_1_346 r0 *1 0,0
Xsky130_fd_sc_hd__nor2_1_346 \$1992 \$5783
+ vss
+ vdd
+ vdd
+ out_data[20] sky130_fd_sc_hd__nor2_1
* cell instance sky130_fd_sc_hd__nor2_1_347 r0 *1 0,0
Xsky130_fd_sc_hd__nor2_1_347 \$1992 \$5830
+ vss
+ vdd
+ vdd
+ out_data[25] sky130_fd_sc_hd__nor2_1
* cell instance sky130_fd_sc_hd__nor2b_1_0 r0 *1 0,0
Xsky130_fd_sc_hd__nor2b_1_0 \$1156 \$1083
+ vss
+ vdd
+ vdd
+ \$509 sky130_fd_sc_hd__nor2b_1
* cell instance sky130_fd_sc_hd__nor2b_1_1 r0 *1 0,0
Xsky130_fd_sc_hd__nor2b_1_1 \$1080 \$1078
+ vss
+ vdd
+ vdd
+ \$1014 sky130_fd_sc_hd__nor2b_1
* cell instance sky130_fd_sc_hd__nor3_1_0 r0 *1 0,0
Xsky130_fd_sc_hd__nor3_1_0 \$1548 \$3666 \$3901
+ vss
+ vdd
+ vdd
+ \$3776 sky130_fd_sc_hd__nor3_1
* cell instance sky130_fd_sc_hd__nor3_1_1 r0 *1 0,0
Xsky130_fd_sc_hd__nor3_1_1 \$1548 \$4139 \$4340
+ vss
+ vdd
+ vdd
+ \$4350 sky130_fd_sc_hd__nor3_1
* cell instance sky130_fd_sc_hd__nor3_1_2 r0 *1 0,0
Xsky130_fd_sc_hd__nor3_1_2 \$1548 \$4244 \$4817
+ vss
+ vdd
+ vdd
+ \$4912 sky130_fd_sc_hd__nor3_1
* cell instance sky130_fd_sc_hd__nor3_1_3 r0 *1 0,0
Xsky130_fd_sc_hd__nor3_1_3 \$1548 \$3906 \$3903
+ vss
+ vdd
+ vdd
+ \$3905 sky130_fd_sc_hd__nor3_1
* cell instance sky130_fd_sc_hd__nor3_1_4 r0 *1 0,0
Xsky130_fd_sc_hd__nor3_1_4 \$4128 \$4018 \$4015
+ vss
+ vdd
+ vdd
+ \$4017 sky130_fd_sc_hd__nor3_1
* cell instance sky130_fd_sc_hd__nor3_1_5 r0 *1 0,0
Xsky130_fd_sc_hd__nor3_1_5 \$1995 \$2209 \$2297
+ vss
+ vdd
+ vdd
+ \$2498 sky130_fd_sc_hd__nor3_1
* cell instance sky130_fd_sc_hd__nor3_1_6 r0 *1 0,0
Xsky130_fd_sc_hd__nor3_1_6 \$1548 \$4795 \$4706
+ vss
+ vdd
+ vdd
+ \$4819 sky130_fd_sc_hd__nor3_1
* cell instance sky130_fd_sc_hd__nor3_1_7 r0 *1 0,0
Xsky130_fd_sc_hd__nor3_1_7 \$2942 \$2508 \$2209
+ vss
+ vdd
+ vdd
+ \$2507 sky130_fd_sc_hd__nor3_1
* cell instance sky130_fd_sc_hd__nor3_1_8 r0 *1 0,0
Xsky130_fd_sc_hd__nor3_1_8 \$1548 \$3909 \$3907
+ vss
+ vdd
+ vdd
+ \$3676 sky130_fd_sc_hd__nor3_1
* cell instance sky130_fd_sc_hd__nor3_1_9 r0 *1 0,0
Xsky130_fd_sc_hd__nor3_1_9 \$1919 \$2209 \$2211
+ vss
+ vdd
+ vdd
+ \$2210 sky130_fd_sc_hd__nor3_1
* cell instance sky130_fd_sc_hd__nor3_1_10 r0 *1 0,0
Xsky130_fd_sc_hd__nor3_1_10 \$3570 \$3908 \$3885
+ vss
+ vdd
+ vdd
+ \$4147 sky130_fd_sc_hd__nor3_1
* cell instance sky130_fd_sc_hd__nor3_1_11 r0 *1 0,0
Xsky130_fd_sc_hd__nor3_1_11 \$1548 \$1633 \$1636
+ vss
+ vdd
+ vdd
+ \$1635 sky130_fd_sc_hd__nor3_1
* cell instance sky130_fd_sc_hd__nor3_1_12 r0 *1 0,0
Xsky130_fd_sc_hd__nor3_1_12 \$1548 \$1382 \$1637
+ vss
+ vdd
+ vdd
+ \$1724 sky130_fd_sc_hd__nor3_1
* cell instance sky130_fd_sc_hd__nor3_1_13 r0 *1 0,0
Xsky130_fd_sc_hd__nor3_1_13 \$5059 \$4821 \$4248
+ vss
+ vdd
+ vdd
+ \$5530 sky130_fd_sc_hd__nor3_1
* cell instance sky130_fd_sc_hd__nor3_1_14 r0 *1 0,0
Xsky130_fd_sc_hd__nor3_1_14 \$4797 \$4821 \$4248
+ vss
+ vdd
+ vdd
+ \$4828 sky130_fd_sc_hd__nor3_1
* cell instance sky130_fd_sc_hd__nor3_1_15 r0 *1 0,0
Xsky130_fd_sc_hd__nor3_1_15 \$4360 \$4821 \$4248
+ vss
+ vdd
+ vdd
+ \$5193 sky130_fd_sc_hd__nor3_1
* cell instance sky130_fd_sc_hd__nor3_1_16 r0 *1 0,0
Xsky130_fd_sc_hd__nor3_1_16 \$1548 \$1388 \$1639
+ vss
+ vdd
+ vdd
+ \$1640 sky130_fd_sc_hd__nor3_1
* cell instance sky130_fd_sc_hd__nor3_1_17 r0 *1 0,0
Xsky130_fd_sc_hd__nor3_1_17 \$1548 \$1929 \$1931
+ vss
+ vdd
+ vdd
+ \$1932 sky130_fd_sc_hd__nor3_1
* cell instance sky130_fd_sc_hd__nor3_1_18 r0 *1 0,0
Xsky130_fd_sc_hd__nor3_1_18 \$5762 \$5763 \$5764
+ vss
+ vdd
+ vdd
+ \$5073 sky130_fd_sc_hd__nor3_1
* cell instance sky130_fd_sc_hd__nor3_1_19 r0 *1 0,0
Xsky130_fd_sc_hd__nor3_1_19 \$4169 \$219 \$6296
+ vss
+ vdd
+ vdd
+ \$5987 sky130_fd_sc_hd__nor3_1
* cell instance sky130_fd_sc_hd__nor3_1_20 r0 *1 0,0
Xsky130_fd_sc_hd__nor3_1_20 \$5165 \$5200 \$5273
+ vss
+ vdd
+ vdd
+ \$5074 sky130_fd_sc_hd__nor3_1
* cell instance sky130_fd_sc_hd__nor3_1_21 r0 *1 0,0
Xsky130_fd_sc_hd__nor3_1_21 \$4169 \$219 \$5867
+ vss
+ vdd
+ vdd
+ \$5765 sky130_fd_sc_hd__nor3_1
* cell instance sky130_fd_sc_hd__nor3_1_22 r0 *1 0,0
Xsky130_fd_sc_hd__nor3_1_22 \$4169 \$219 \$6399
+ vss
+ vdd
+ vdd
+ \$6298 sky130_fd_sc_hd__nor3_1
* cell instance sky130_fd_sc_hd__nor3_1_23 r0 *1 0,0
Xsky130_fd_sc_hd__nor3_1_23 \$565 \$563 \$712
+ vss
+ vdd
+ vdd
+ \$711 sky130_fd_sc_hd__nor3_1
* cell instance sky130_fd_sc_hd__nor3_1_24 r0 *1 0,0
Xsky130_fd_sc_hd__nor3_1_24 \$5474 \$5324 \$5999
+ vss
+ vdd
+ vdd
+ \$6118 sky130_fd_sc_hd__nor3_1
* cell instance sky130_fd_sc_hd__nor3_1_25 r0 *1 0,0
Xsky130_fd_sc_hd__nor3_1_25 \$1061 \$574 \$631
+ vss
+ vdd
+ vdd
+ \$787 sky130_fd_sc_hd__nor3_1
* cell instance sky130_fd_sc_hd__nor3_1_26 r0 *1 0,0
Xsky130_fd_sc_hd__nor3_1_26 \$574 \$631 \$568
+ vss
+ vdd
+ vdd
+ \$633 sky130_fd_sc_hd__nor3_1
* cell instance sky130_fd_sc_hd__nor3_1_27 r0 *1 0,0
Xsky130_fd_sc_hd__nor3_1_27 \$565 \$712 \$580
+ vss
+ vdd
+ vdd
+ \$576 sky130_fd_sc_hd__nor3_1
* cell instance sky130_fd_sc_hd__nor3_1_28 r0 *1 0,0
Xsky130_fd_sc_hd__nor3_1_28 \$5882 \$5474 \$5324
+ vss
+ vdd
+ vdd
+ \$6688 sky130_fd_sc_hd__nor3_1
* cell instance sky130_fd_sc_hd__nor3_1_29 r0 *1 0,0
Xsky130_fd_sc_hd__nor3_1_29 \$1145 \$219 \$1218
+ vss
+ vdd
+ vdd
+ \$1072 sky130_fd_sc_hd__nor3_1
* cell instance sky130_fd_sc_hd__nor3_1_30 r0 *1 0,0
Xsky130_fd_sc_hd__nor3_1_30 \$1313 \$219 \$1309
+ vss
+ vdd
+ vdd
+ \$1410 sky130_fd_sc_hd__nor3_1
* cell instance sky130_fd_sc_hd__nor3_1_31 r0 *1 0,0
Xsky130_fd_sc_hd__nor3_1_31 \$1073 \$219 \$1148
+ vss
+ vdd
+ vdd
+ \$1007 sky130_fd_sc_hd__nor3_1
* cell instance sky130_fd_sc_hd__nor3_1_32 r0 *1 0,0
Xsky130_fd_sc_hd__nor3_1_32 \$1406 \$574 \$631
+ vss
+ vdd
+ vdd
+ \$1411 sky130_fd_sc_hd__nor3_1
* cell instance sky130_fd_sc_hd__nor3_1_33 r0 *1 0,0
Xsky130_fd_sc_hd__nor3_1_33 \$4062 \$290 \$4745
+ vss
+ vdd
+ vdd
+ \$4746 sky130_fd_sc_hd__nor3_1
* cell instance sky130_fd_sc_hd__nor3_1_34 r0 *1 0,0
Xsky130_fd_sc_hd__nor3_1_34 \$6604 \$5474 \$5324
+ vss
+ vdd
+ vdd
+ \$6771 sky130_fd_sc_hd__nor3_1
* cell instance sky130_fd_sc_hd__nor3_1_35 r0 *1 0,0
Xsky130_fd_sc_hd__nor3_1_35 \$4062 \$4457 \$4391
+ vss
+ vdd
+ vdd
+ \$3728 sky130_fd_sc_hd__nor3_1
* cell instance sky130_fd_sc_hd__nor3_1_36 r0 *1 0,0
Xsky130_fd_sc_hd__nor3_1_36 \$5406 \$4747 \$5324
+ vss
+ vdd
+ vdd
+ \$5568 sky130_fd_sc_hd__nor3_1
* cell instance sky130_fd_sc_hd__nor3_1_37 r0 *1 0,0
Xsky130_fd_sc_hd__nor3_1_37 \$7367 \$5474 \$5324
+ vss
+ vdd
+ vdd
+ \$7368 sky130_fd_sc_hd__nor3_1
* cell instance sky130_fd_sc_hd__nor3_1_38 r0 *1 0,0
Xsky130_fd_sc_hd__nor3_1_38 \$574 \$631 \$570
+ vss
+ vdd
+ vdd
+ \$582 sky130_fd_sc_hd__nor3_1
* cell instance sky130_fd_sc_hd__nor3_1_39 r0 *1 0,0
Xsky130_fd_sc_hd__nor3_1_39 \$7525 \$5474 \$5324
+ vss
+ vdd
+ vdd
+ \$7526 sky130_fd_sc_hd__nor3_1
* cell instance sky130_fd_sc_hd__nor3_1_40 r0 *1 0,0
Xsky130_fd_sc_hd__nor3_1_40 \$716 \$718 \$717
+ vss
+ vdd
+ vdd
+ \$877 sky130_fd_sc_hd__nor3_1
* cell instance sky130_fd_sc_hd__nor3_1_41 r0 *1 0,0
Xsky130_fd_sc_hd__nor3_1_41 \$574 \$631 \$874
+ vss
+ vdd
+ vdd
+ \$1414 sky130_fd_sc_hd__nor3_1
* cell instance sky130_fd_sc_hd__nor3_1_42 r0 *1 0,0
Xsky130_fd_sc_hd__nor3_1_42 \$1078 \$1080 \$1011
+ vss
+ vdd
+ vdd
+ \$1156 sky130_fd_sc_hd__nor3_1
* cell instance sky130_fd_sc_hd__nor3_1_43 r0 *1 0,0
Xsky130_fd_sc_hd__nor3_1_43 \$7308 \$5474 \$5324
+ vss
+ vdd
+ vdd
+ \$7309 sky130_fd_sc_hd__nor3_1
* cell instance sky130_fd_sc_hd__nor3_1_44 r0 *1 0,0
Xsky130_fd_sc_hd__nor3_1_44 \$2202 \$3210 \$3243
+ vss
+ vdd
+ vdd
+ \$3217 sky130_fd_sc_hd__nor3_1
* cell instance sky130_fd_sc_hd__nor3_1_45 r0 *1 0,0
Xsky130_fd_sc_hd__nor3_1_45 \$7532 \$5474 \$5324
+ vss
+ vdd
+ vdd
+ \$7533 sky130_fd_sc_hd__nor3_1
* cell instance sky130_fd_sc_hd__nor3_1_46 r0 *1 0,0
Xsky130_fd_sc_hd__nor3_1_46 \$7222 \$5474 \$5324
+ vss
+ vdd
+ vdd
+ \$7386 sky130_fd_sc_hd__nor3_1
* cell instance sky130_fd_sc_hd__nor3_1_47 r0 *1 0,0
Xsky130_fd_sc_hd__nor3_1_47 \$1516 \$1515 \$2350
+ vss
+ vdd
+ vdd
+ \$2351 sky130_fd_sc_hd__nor3_1
* cell instance sky130_fd_sc_hd__nor3_1_48 r0 *1 0,0
Xsky130_fd_sc_hd__nor3_1_48 \$7538 \$5474 \$5324
+ vss
+ vdd
+ vdd
+ \$7542 sky130_fd_sc_hd__nor3_1
* cell instance sky130_fd_sc_hd__nor3_1_49 r0 *1 0,0
Xsky130_fd_sc_hd__nor3_1_49 \$4213 \$5474 \$5324
+ vss
+ vdd
+ vdd
+ \$6620 sky130_fd_sc_hd__nor3_1
* cell instance sky130_fd_sc_hd__nor3_1_50 r0 *1 0,0
Xsky130_fd_sc_hd__nor3_1_50 \$4541 \$5474 \$5324
+ vss
+ vdd
+ vdd
+ \$5591 sky130_fd_sc_hd__nor3_1
* cell instance sky130_fd_sc_hd__nor3_1_51 r0 *1 0,0
Xsky130_fd_sc_hd__nor3_1_51 \$4777 \$5474 \$5324
+ vss
+ vdd
+ vdd
+ \$5473 sky130_fd_sc_hd__nor3_1
* cell instance sky130_fd_sc_hd__nor3_1_52 r0 *1 0,0
Xsky130_fd_sc_hd__nor3_1_52 \$5149 \$5474 \$5324
+ vss
+ vdd
+ vdd
+ \$5808 sky130_fd_sc_hd__nor3_1
* cell instance sky130_fd_sc_hd__nor3_1_53 r0 *1 0,0
Xsky130_fd_sc_hd__nor3_1_53 \$5582 \$5474 \$5324
+ vss
+ vdd
+ vdd
+ \$6239 sky130_fd_sc_hd__nor3_1
* cell instance sky130_fd_sc_hd__nor3_1_54 r0 *1 0,0
Xsky130_fd_sc_hd__nor3_1_54 \$4221 \$5474 \$5324
+ vss
+ vdd
+ vdd
+ \$6238 sky130_fd_sc_hd__nor3_1
* cell instance sky130_fd_sc_hd__nor3_1_55 r0 *1 0,0
Xsky130_fd_sc_hd__nor3_1_55 \$2202 \$2265 \$2908
+ vss
+ vdd
+ vdd
+ \$2573 sky130_fd_sc_hd__nor3_1
* cell instance sky130_fd_sc_hd__nor3_1_56 r0 *1 0,0
Xsky130_fd_sc_hd__nor3_1_56 \$7510 \$5474 \$5324
+ vss
+ vdd
+ vdd
+ \$7328 sky130_fd_sc_hd__nor3_1
* cell instance sky130_fd_sc_hd__nor3_1_57 r0 *1 0,0
Xsky130_fd_sc_hd__nor3_1_57 \$6335 \$5474 \$5324
+ vss
+ vdd
+ vdd
+ \$6151 sky130_fd_sc_hd__nor3_1
* cell instance sky130_fd_sc_hd__nor3_1_58 r0 *1 0,0
Xsky130_fd_sc_hd__nor3_1_58 \$6721 \$5474 \$5324
+ vss
+ vdd
+ vdd
+ \$6722 sky130_fd_sc_hd__nor3_1
* cell instance sky130_fd_sc_hd__nor3_1_59 r0 *1 0,0
Xsky130_fd_sc_hd__nor3_1_59 \$3328 \$3413 \$3519
+ vss
+ vdd
+ vdd
+ \$3721 sky130_fd_sc_hd__nor3_1
* cell instance sky130_fd_sc_hd__nor3_1_60 r0 *1 0,0
Xsky130_fd_sc_hd__nor3_1_60 \$3657 \$3584 \$3630
+ vss
+ vdd
+ vdd
+ \$3975 sky130_fd_sc_hd__nor3_1
* cell instance sky130_fd_sc_hd__nor3_1_61 r0 *1 0,0
Xsky130_fd_sc_hd__nor3_1_61 bus_addr[3] bus_addr[2] \$2913
+ vss
+ vdd
+ vdd
+ \$2814 sky130_fd_sc_hd__nor3_1
* cell instance sky130_fd_sc_hd__nor3_1_62 r0 *1 0,0
Xsky130_fd_sc_hd__nor3_1_62 bus_addr[3] bus_addr[2] \$3333
+ vss
+ vdd
+ vdd
+ \$3332 sky130_fd_sc_hd__nor3_1
* cell instance sky130_fd_sc_hd__nor3_1_63 r0 *1 0,0
Xsky130_fd_sc_hd__nor3_1_63 bus_addr[3] bus_addr[2] \$2909
+ vss
+ vdd
+ vdd
+ \$3232 sky130_fd_sc_hd__nor3_1
* cell instance sky130_fd_sc_hd__nor3b_1_0 r0 *1 0,0
Xsky130_fd_sc_hd__nor3b_1_0 \$3910 \$1548 \$3679
+ vss
+ vdd
+ vdd
+ \$3912 sky130_fd_sc_hd__nor3b_1
* cell instance sky130_fd_sc_hd__nor3b_1_1 r0 *1 0,0
Xsky130_fd_sc_hd__nor3b_1_1 \$5975 \$6387 \$5974
+ vss
+ vdd
+ vdd
+ \$5862 sky130_fd_sc_hd__nor3b_1
* cell instance sky130_fd_sc_hd__nor3b_1_2 r0 *1 0,0
Xsky130_fd_sc_hd__nor3b_1_2 \$716 \$717 \$718
+ vss
+ vdd
+ vdd
+ \$632 sky130_fd_sc_hd__nor3b_1
* cell instance sky130_fd_sc_hd__nor3b_1_3 r0 *1 0,0
Xsky130_fd_sc_hd__nor3b_1_3 \$4062 \$4457 \$4391
+ vss
+ vdd
+ vdd
+ \$4627 sky130_fd_sc_hd__nor3b_1
* cell instance sky130_fd_sc_hd__nor3b_1_4 r0 *1 0,0
Xsky130_fd_sc_hd__nor3b_1_4 \$718 \$717 \$716
+ vss
+ vdd
+ vdd
+ \$1152 sky130_fd_sc_hd__nor3b_1
* cell instance sky130_fd_sc_hd__nor4_1_0 r0 *1 0,0
Xsky130_fd_sc_hd__nor4_1_0 \$3269 \$3363 \$2942 \$3272
+ vss
+ vdd
+ vdd
+ \$3149 sky130_fd_sc_hd__nor4_1
* cell instance sky130_fd_sc_hd__nor4_1_1 r0 *1 0,0
Xsky130_fd_sc_hd__nor4_1_1 \$3904 \$3667 \$3668 \$3767
+ vss
+ vdd
+ vdd
+ \$4351 sky130_fd_sc_hd__nor4_1
* cell instance sky130_fd_sc_hd__nor4_1_2 r0 *1 0,0
Xsky130_fd_sc_hd__nor4_1_2 \$4480 \$4018 \$4352 \$4246
+ vss
+ vdd
+ vdd
+ \$4020 sky130_fd_sc_hd__nor4_1
* cell instance sky130_fd_sc_hd__nor4_1_3 r0 *1 0,0
Xsky130_fd_sc_hd__nor4_1_3 \$4574 \$4016 \$4479 \$4481
+ vss
+ vdd
+ vdd
+ \$4482 sky130_fd_sc_hd__nor4_1
* cell instance sky130_fd_sc_hd__nor4_1_4 r0 *1 0,0
Xsky130_fd_sc_hd__nor4_1_4 \$4353 \$4494 \$4818 \$4354
+ vss
+ vdd
+ vdd
+ \$4820 sky130_fd_sc_hd__nor4_1
* cell instance sky130_fd_sc_hd__nor4_1_5 r0 *1 0,0
Xsky130_fd_sc_hd__nor4_1_5 \$3155 \$3156 \$2946 \$3274
+ vss
+ vdd
+ vdd
+ \$3153 sky130_fd_sc_hd__nor4_1
* cell instance sky130_fd_sc_hd__nor4_1_6 r0 *1 0,0
Xsky130_fd_sc_hd__nor4_1_6 \$2957 \$2870 \$3346 \$3169
+ vss
+ vdd
+ vdd
+ \$3281 sky130_fd_sc_hd__nor4_1
* cell instance sky130_fd_sc_hd__nor4_1_7 r0 *1 0,0
Xsky130_fd_sc_hd__nor4_1_7 \$5200 \$5273 \$4604 \$5199
+ vss
+ vdd
+ vdd
+ \$5198 sky130_fd_sc_hd__nor4_1
* cell instance sky130_fd_sc_hd__nor4_1_8 r0 *1 0,0
Xsky130_fd_sc_hd__nor4_1_8 \$5762 \$5417 \$5763 \$5764
+ vss
+ vdd
+ vdd
+ \$5318 sky130_fd_sc_hd__nor4_1
* cell instance sky130_fd_sc_hd__nor4_1_9 r0 *1 0,0
Xsky130_fd_sc_hd__nor4_1_9 \$4169 \$219 \$6398 \$6503
+ vss
+ vdd
+ vdd
+ \$6582 sky130_fd_sc_hd__nor4_1
* cell instance sky130_fd_sc_hd__nor4_1_10 r0 *1 0,0
Xsky130_fd_sc_hd__nor4_1_10 \$4169 \$219 \$5836 \$5767
+ vss
+ vdd
+ vdd
+ \$5660 sky130_fd_sc_hd__nor4_1
* cell instance sky130_fd_sc_hd__nor4_1_11 r0 *1 0,0
Xsky130_fd_sc_hd__nor4_1_11 \$4169 \$219 \$6504 \$6405
+ vss
+ vdd
+ vdd
+ \$6506 sky130_fd_sc_hd__nor4_1
* cell instance sky130_fd_sc_hd__nor4_1_12 r0 *1 0,0
Xsky130_fd_sc_hd__nor4_1_12 \$717 \$872 \$574 \$631
+ vss
+ vdd
+ vdd
+ \$1074 sky130_fd_sc_hd__nor4_1
* cell instance sky130_fd_sc_hd__nor4_1_13 r0 *1 0,0
Xsky130_fd_sc_hd__nor4_1_13 \$716 \$718 \$717 \$565
+ vss
+ vdd
+ vdd
+ \$1010 sky130_fd_sc_hd__nor4_1
* cell instance sky130_fd_sc_hd__nor4_1_14 r0 *1 0,0
Xsky130_fd_sc_hd__nor4_1_14 bus_addr[0] bus_addr[1] bus_addr[3] bus_addr[2]
+ vss
+ vdd
+ vdd
+ \$3260 sky130_fd_sc_hd__nor4_1
* cell instance sky130_fd_sc_hd__nor4b_1_0 r0 *1 0,0
Xsky130_fd_sc_hd__nor4b_1_0 bus_addr[0] bus_addr[1] bus_addr[3] bus_we
+ vss
+ vdd
+ vdd
+ \$3261 sky130_fd_sc_hd__nor4b_1
* cell instance sky130_fd_sc_hd__nor4b_1_1 r0 *1 0,0
Xsky130_fd_sc_hd__nor4b_1_1 \$3657 \$3584 \$3630 \$3332
+ vss
+ vdd
+ vdd
+ \$3848 sky130_fd_sc_hd__nor4b_1
* cell instance sky130_fd_sc_hd__o211a_1_0 r0 *1 0,0
Xsky130_fd_sc_hd__o211a_1_0 \$5307 \$5529 \$5059 \$5863
+ vss
+ vdd
+ vdd
+ \$4361 sky130_fd_sc_hd__o211a_1
* cell instance sky130_fd_sc_hd__o211ai_1_0 r0 *1 0,0
Xsky130_fd_sc_hd__o211ai_1_0 \$1998 \$1919 \$2207 \$2108
+ vss
+ vdd
+ vdd
+ \$2205 sky130_fd_sc_hd__o211ai_1
* cell instance sky130_fd_sc_hd__o211ai_1_1 r0 *1 0,0
Xsky130_fd_sc_hd__o211ai_1_1 \$5966 \$5968 \$5944 \$5637
+ vss
+ vdd
+ vdd
+ \$5860 sky130_fd_sc_hd__o211ai_1
* cell instance sky130_fd_sc_hd__o211ai_1_2 r0 *1 0,0
Xsky130_fd_sc_hd__o211ai_1_2 \$3079 \$3087 \$3083 \$2998
+ vss
+ vdd
+ vdd
+ \$3085 sky130_fd_sc_hd__o211ai_1
* cell instance sky130_fd_sc_hd__o211ai_1_3 r0 *1 0,0
Xsky130_fd_sc_hd__o211ai_1_3 \$3008 \$3351 \$2805 \$3515
+ vss
+ vdd
+ vdd
+ \$3629 sky130_fd_sc_hd__o211ai_1
* cell instance sky130_fd_sc_hd__o211ai_1_4 r0 *1 0,0
Xsky130_fd_sc_hd__o211ai_1_4 \$3010 \$3008 \$2805 \$3007
+ vss
+ vdd
+ vdd
+ \$2580 sky130_fd_sc_hd__o211ai_1
* cell instance sky130_fd_sc_hd__o21a_1_0 r0 *1 0,0
Xsky130_fd_sc_hd__o21a_1_0 \$5547 \$7191 \$7423
+ vss
+ vdd
+ vdd
+ \$7508 sky130_fd_sc_hd__o21a_1
* cell instance sky130_fd_sc_hd__o21a_1_1 r0 *1 0,0
Xsky130_fd_sc_hd__o21a_1_1 \$5547 \$5434 \$5546
+ vss
+ vdd
+ vdd
+ \$5550 sky130_fd_sc_hd__o21a_1
* cell instance sky130_fd_sc_hd__o21a_1_2 r0 *1 0,0
Xsky130_fd_sc_hd__o21a_1_2 \$5547 \$6408 \$6757
+ vss
+ vdd
+ vdd
+ \$6760 sky130_fd_sc_hd__o21a_1
* cell instance sky130_fd_sc_hd__o21a_1_3 r0 *1 0,0
Xsky130_fd_sc_hd__o21a_1_3 \$5547 \$4521 \$5079
+ vss
+ vdd
+ vdd
+ \$5082 sky130_fd_sc_hd__o21a_1
* cell instance sky130_fd_sc_hd__o21a_1_4 r0 *1 0,0
Xsky130_fd_sc_hd__o21a_1_4 \$569 \$580 \$506
+ vss
+ vdd
+ vdd
+ \$573 sky130_fd_sc_hd__o21a_1
* cell instance sky130_fd_sc_hd__o21a_1_5 r0 *1 0,0
Xsky130_fd_sc_hd__o21a_1_5 \$1746 \$1748 \$1752
+ vss
+ vdd
+ vdd
+ \$1943 sky130_fd_sc_hd__o21a_1
* cell instance sky130_fd_sc_hd__o21a_1_6 r0 *1 0,0
Xsky130_fd_sc_hd__o21a_1_6 \$936 \$580 \$875
+ vss
+ vdd
+ vdd
+ \$230 sky130_fd_sc_hd__o21a_1
* cell instance sky130_fd_sc_hd__o21a_1_7 r0 *1 0,0
Xsky130_fd_sc_hd__o21a_1_7 \$5547 \$5785 \$6519
+ vss
+ vdd
+ vdd
+ \$5896 sky130_fd_sc_hd__o21a_1
* cell instance sky130_fd_sc_hd__o21a_1_8 r0 *1 0,0
Xsky130_fd_sc_hd__o21a_1_8 \$5547 \$6700 \$7030
+ vss
+ vdd
+ vdd
+ \$7033 sky130_fd_sc_hd__o21a_1
* cell instance sky130_fd_sc_hd__o21a_1_9 r0 *1 0,0
Xsky130_fd_sc_hd__o21a_1_9 \$1078 \$1313 \$1317
+ vss
+ vdd
+ vdd
+ \$1321 sky130_fd_sc_hd__o21a_1
* cell instance sky130_fd_sc_hd__o21a_1_10 r0 *1 0,0
Xsky130_fd_sc_hd__o21a_1_10 \$5547 \$4301 \$5577
+ vss
+ vdd
+ vdd
+ \$5357 sky130_fd_sc_hd__o21a_1
* cell instance sky130_fd_sc_hd__o21a_1_11 r0 *1 0,0
Xsky130_fd_sc_hd__o21a_1_11 \$5547 \$6321 \$6798
+ vss
+ vdd
+ vdd
+ \$6717 sky130_fd_sc_hd__o21a_1
* cell instance sky130_fd_sc_hd__o21a_1_12 r0 *1 0,0
Xsky130_fd_sc_hd__o21a_1_12 \$5547 \$7305 \$7858
+ vss
+ vdd
+ vdd
+ \$7936 sky130_fd_sc_hd__o21a_1
* cell instance sky130_fd_sc_hd__o21a_1_13 r0 *1 0,0
Xsky130_fd_sc_hd__o21a_1_13 \$5547 \$6724 \$7401
+ vss
+ vdd
+ vdd
+ \$7333 sky130_fd_sc_hd__o21a_1
* cell instance sky130_fd_sc_hd__o21a_1_14 r0 *1 0,0
Xsky130_fd_sc_hd__o21a_1_14 \$182 \$1527 \$1450
+ vss
+ vdd
+ vdd
+ \$1606 sky130_fd_sc_hd__o21a_1
* cell instance sky130_fd_sc_hd__o21a_1_15 r0 *1 0,0
Xsky130_fd_sc_hd__o21a_1_15 \$5547 \$5705 \$6153
+ vss
+ vdd
+ vdd
+ \$6068 sky130_fd_sc_hd__o21a_1
* cell instance sky130_fd_sc_hd__o21a_1_16 r0 *1 0,0
Xsky130_fd_sc_hd__o21a_1_16 \$5547 \$4560 \$6157
+ vss
+ vdd
+ vdd
+ \$6088 sky130_fd_sc_hd__o21a_1
* cell instance sky130_fd_sc_hd__o21a_1_17 r0 *1 0,0
Xsky130_fd_sc_hd__o21a_1_17 \$5547 \$6454 \$6818
+ vss
+ vdd
+ vdd
+ \$6469 sky130_fd_sc_hd__o21a_1
* cell instance sky130_fd_sc_hd__o21a_1_18 r0 *1 0,0
Xsky130_fd_sc_hd__o21a_1_18 \$5547 \$7078 \$7571
+ vss
+ vdd
+ vdd
+ \$7574 sky130_fd_sc_hd__o21a_1
* cell instance sky130_fd_sc_hd__o21ai_0_0 r0 *1 0,0
Xsky130_fd_sc_hd__o21ai_0_0 \$4353 \$2108 \$3268
+ vss
+ vdd
+ vdd
+ \$4483 sky130_fd_sc_hd__o21ai_0
* cell instance sky130_fd_sc_hd__o21ai_0_1 r0 *1 0,0
Xsky130_fd_sc_hd__o21ai_0_1 \$1083 \$4796 \$3268
+ vss
+ vdd
+ vdd
+ \$4824 sky130_fd_sc_hd__o21ai_0
* cell instance sky130_fd_sc_hd__o21ai_0_2 r0 *1 0,0
Xsky130_fd_sc_hd__o21ai_0_2 \$5974 \$5975 \$5303
+ vss
+ vdd
+ vdd
+ \$5972 sky130_fd_sc_hd__o21ai_0
* cell instance sky130_fd_sc_hd__o21ai_0_3 r0 *1 0,0
Xsky130_fd_sc_hd__o21ai_0_3 startup_done \$3165 \$3460
+ vss
+ vdd
+ vdd
+ \$3461 sky130_fd_sc_hd__o21ai_0
* cell instance sky130_fd_sc_hd__o21ai_0_4 r0 *1 0,0
Xsky130_fd_sc_hd__o21ai_0_4 startup_done \$2633 \$2956
+ vss
+ vdd
+ vdd
+ \$2743 sky130_fd_sc_hd__o21ai_0
* cell instance sky130_fd_sc_hd__o21ai_0_5 r0 *1 0,0
Xsky130_fd_sc_hd__o21ai_0_5 startup_done \$3346 \$2108
+ vss
+ vdd
+ vdd
+ \$3583 sky130_fd_sc_hd__o21ai_0
* cell instance sky130_fd_sc_hd__o21ai_0_6 r0 *1 0,0
Xsky130_fd_sc_hd__o21ai_0_6 startup_done \$2957 \$2108
+ vss
+ vdd
+ vdd
+ \$3027 sky130_fd_sc_hd__o21ai_0
* cell instance sky130_fd_sc_hd__o21ai_0_7 r0 *1 0,0
Xsky130_fd_sc_hd__o21ai_0_7 startup_done \$3280 \$3172
+ vss
+ vdd
+ vdd
+ \$3255 sky130_fd_sc_hd__o21ai_0
* cell instance sky130_fd_sc_hd__o21ai_0_8 r0 *1 0,0
Xsky130_fd_sc_hd__o21ai_0_8 \$6396 \$6398 \$6188
+ vss
+ vdd
+ vdd
+ \$6187 sky130_fd_sc_hd__o21ai_0
* cell instance sky130_fd_sc_hd__o21ai_0_9 r0 *1 0,0
Xsky130_fd_sc_hd__o21ai_0_9 gated \$4162 \$4364
+ vss
+ vdd
+ vdd
+ \$4363 sky130_fd_sc_hd__o21ai_0
* cell instance sky130_fd_sc_hd__o21ai_0_10 r0 *1 0,0
Xsky130_fd_sc_hd__o21ai_0_10 gated \$5070 \$4952
+ vss
+ vdd
+ vdd
+ \$4951 sky130_fd_sc_hd__o21ai_0
* cell instance sky130_fd_sc_hd__o21ai_0_11 r0 *1 0,0
Xsky130_fd_sc_hd__o21ai_0_11 \$191 \$1500 \$3384
+ vss
+ vdd
+ vdd
+ \$3184 sky130_fd_sc_hd__o21ai_0
* cell instance sky130_fd_sc_hd__o21ai_0_12 r0 *1 0,0
Xsky130_fd_sc_hd__o21ai_0_12 \$191 \$1559 \$1558
+ vss
+ vdd
+ vdd
+ \$1497 sky130_fd_sc_hd__o21ai_0
* cell instance sky130_fd_sc_hd__o21ai_0_13 r0 *1 0,0
Xsky130_fd_sc_hd__o21ai_0_13 \$191 \$786 \$2424
+ vss
+ vdd
+ vdd
+ \$2427 sky130_fd_sc_hd__o21ai_0
* cell instance sky130_fd_sc_hd__o21ai_0_14 r0 *1 0,0
Xsky130_fd_sc_hd__o21ai_0_14 \$1561 \$1642 \$1560
+ vss
+ vdd
+ vdd
+ \$1398 sky130_fd_sc_hd__o21ai_0
* cell instance sky130_fd_sc_hd__o21ai_0_15 r0 *1 0,0
Xsky130_fd_sc_hd__o21ai_0_15 \$191 \$1211 \$2873
+ vss
+ vdd
+ vdd
+ \$2931 sky130_fd_sc_hd__o21ai_0
* cell instance sky130_fd_sc_hd__o21ai_0_16 r0 *1 0,0
Xsky130_fd_sc_hd__o21ai_0_16 \$1561 \$3587 \$3466
+ vss
+ vdd
+ vdd
+ \$3646 sky130_fd_sc_hd__o21ai_0
* cell instance sky130_fd_sc_hd__o21ai_0_17 r0 *1 0,0
Xsky130_fd_sc_hd__o21ai_0_17 \$4367 \$4372 \$2108
+ vss
+ vdd
+ vdd
+ \$4370 sky130_fd_sc_hd__o21ai_0
* cell instance sky130_fd_sc_hd__o21ai_0_18 r0 *1 0,0
Xsky130_fd_sc_hd__o21ai_0_18 \$1561 \$2531 \$2530
+ vss
+ vdd
+ vdd
+ \$2609 sky130_fd_sc_hd__o21ai_0
* cell instance sky130_fd_sc_hd__o21ai_0_19 r0 *1 0,0
Xsky130_fd_sc_hd__o21ai_0_19 \$191 \$1210 \$2128
+ vss
+ vdd
+ vdd
+ \$2017 sky130_fd_sc_hd__o21ai_0
* cell instance sky130_fd_sc_hd__o21ai_0_20 r0 *1 0,0
Xsky130_fd_sc_hd__o21ai_0_20 \$6190 \$6504 \$6188
+ vss
+ vdd
+ vdd
+ \$6753 sky130_fd_sc_hd__o21ai_0
* cell instance sky130_fd_sc_hd__o21ai_0_21 r0 *1 0,0
Xsky130_fd_sc_hd__o21ai_0_21 \$1561 \$2969 \$2968
+ vss
+ vdd
+ vdd
+ \$2970 sky130_fd_sc_hd__o21ai_0
* cell instance sky130_fd_sc_hd__o21ai_0_22 r0 *1 0,0
Xsky130_fd_sc_hd__o21ai_0_22 \$6403 \$5475 \$6188
+ vss
+ vdd
+ vdd
+ \$6755 sky130_fd_sc_hd__o21ai_0
* cell instance sky130_fd_sc_hd__o21ai_0_23 r0 *1 0,0
Xsky130_fd_sc_hd__o21ai_0_23 \$191 \$625 \$3387
+ vss
+ vdd
+ vdd
+ \$3388 sky130_fd_sc_hd__o21ai_0
* cell instance sky130_fd_sc_hd__o21ai_0_24 r0 *1 0,0
Xsky130_fd_sc_hd__o21ai_0_24 \$1561 \$2021 \$2129
+ vss
+ vdd
+ vdd
+ \$2131 sky130_fd_sc_hd__o21ai_0
* cell instance sky130_fd_sc_hd__o21ai_0_25 r0 *1 0,0
Xsky130_fd_sc_hd__o21ai_0_25 \$1561 \$3590 \$3436
+ vss
+ vdd
+ vdd
+ \$3476 sky130_fd_sc_hd__o21ai_0
* cell instance sky130_fd_sc_hd__o21ai_0_26 r0 *1 0,0
Xsky130_fd_sc_hd__o21ai_0_26 gated \$4955 \$5077
+ vss
+ vdd
+ vdd
+ \$4959 sky130_fd_sc_hd__o21ai_0
* cell instance sky130_fd_sc_hd__o21ai_0_27 r0 *1 0,0
Xsky130_fd_sc_hd__o21ai_0_27 \$6117 \$6118 \$5592
+ vss
+ vdd
+ vdd
+ \$6300 sky130_fd_sc_hd__o21ai_0
* cell instance sky130_fd_sc_hd__o21ai_0_28 r0 *1 0,0
Xsky130_fd_sc_hd__o21ai_0_28 \$191 \$789 \$3291
+ vss
+ vdd
+ vdd
+ \$3257 sky130_fd_sc_hd__o21ai_0
* cell instance sky130_fd_sc_hd__o21ai_0_29 r0 *1 0,0
Xsky130_fd_sc_hd__o21ai_0_29 \$191 \$505 \$2439
+ vss
+ vdd
+ vdd
+ \$2440 sky130_fd_sc_hd__o21ai_0
* cell instance sky130_fd_sc_hd__o21ai_0_30 r0 *1 0,0
Xsky130_fd_sc_hd__o21ai_0_30 \$1561 \$3479 \$3391
+ vss
+ vdd
+ vdd
+ \$3481 sky130_fd_sc_hd__o21ai_0
* cell instance sky130_fd_sc_hd__o21ai_0_31 r0 *1 0,0
Xsky130_fd_sc_hd__o21ai_0_31 \$1561 \$2658 \$2442
+ vss
+ vdd
+ vdd
+ \$2544 sky130_fd_sc_hd__o21ai_0
* cell instance sky130_fd_sc_hd__o21ai_0_32 r0 *1 0,0
Xsky130_fd_sc_hd__o21ai_0_32 \$718 \$1146 \$1752
+ vss
+ vdd
+ vdd
+ \$1751 sky130_fd_sc_hd__o21ai_0
* cell instance sky130_fd_sc_hd__o21ai_0_33 r0 *1 0,0
Xsky130_fd_sc_hd__o21ai_0_33 \$6765 \$6688 \$6188
+ vss
+ vdd
+ vdd
+ \$6766 sky130_fd_sc_hd__o21ai_0
* cell instance sky130_fd_sc_hd__o21ai_0_34 r0 *1 0,0
Xsky130_fd_sc_hd__o21ai_0_34 \$149 \$576 \$575
+ vss
+ vdd
+ vdd
+ \$284 sky130_fd_sc_hd__o21ai_0
* cell instance sky130_fd_sc_hd__o21ai_0_35 r0 *1 0,0
Xsky130_fd_sc_hd__o21ai_0_35 \$191 \$1753 \$2333
+ vss
+ vdd
+ vdd
+ \$2334 sky130_fd_sc_hd__o21ai_0
* cell instance sky130_fd_sc_hd__o21ai_0_36 r0 *1 0,0
Xsky130_fd_sc_hd__o21ai_0_36 \$191 \$1509 \$3196
+ vss
+ vdd
+ vdd
+ \$3197 sky130_fd_sc_hd__o21ai_0
* cell instance sky130_fd_sc_hd__o21ai_0_37 r0 *1 0,0
Xsky130_fd_sc_hd__o21ai_0_37 \$1561 \$3488 \$3392
+ vss
+ vdd
+ vdd
+ \$3486 sky130_fd_sc_hd__o21ai_0
* cell instance sky130_fd_sc_hd__o21ai_0_38 r0 *1 0,0
Xsky130_fd_sc_hd__o21ai_0_38 \$6768 \$6771 \$6188
+ vss
+ vdd
+ vdd
+ \$6769 sky130_fd_sc_hd__o21ai_0
* cell instance sky130_fd_sc_hd__o21ai_0_39 r0 *1 0,0
Xsky130_fd_sc_hd__o21ai_0_39 \$1561 \$2444 \$2335
+ vss
+ vdd
+ vdd
+ \$2249 sky130_fd_sc_hd__o21ai_0
* cell instance sky130_fd_sc_hd__o21ai_0_40 r0 *1 0,0
Xsky130_fd_sc_hd__o21ai_0_40 \$191 \$1663 \$2891
+ vss
+ vdd
+ vdd
+ \$2892 sky130_fd_sc_hd__o21ai_0
* cell instance sky130_fd_sc_hd__o21ai_0_41 r0 *1 0,0
Xsky130_fd_sc_hd__o21ai_0_41 \$1561 \$3072 \$2991
+ vss
+ vdd
+ vdd
+ \$2839 sky130_fd_sc_hd__o21ai_0
* cell instance sky130_fd_sc_hd__o21ai_0_42 r0 *1 0,0
Xsky130_fd_sc_hd__o21ai_0_42 \$7522 \$7526 \$6188
+ vss
+ vdd
+ vdd
+ \$7523 sky130_fd_sc_hd__o21ai_0
* cell instance sky130_fd_sc_hd__o21ai_0_43 r0 *1 0,0
Xsky130_fd_sc_hd__o21ai_0_43 \$6130 \$5568 \$5592
+ vss
+ vdd
+ vdd
+ \$5891 sky130_fd_sc_hd__o21ai_0
* cell instance sky130_fd_sc_hd__o21ai_0_44 r0 *1 0,0
Xsky130_fd_sc_hd__o21ai_0_44 \$7370 \$7368 \$6188
+ vss
+ vdd
+ vdd
+ \$7439 sky130_fd_sc_hd__o21ai_0
* cell instance sky130_fd_sc_hd__o21ai_0_45 r0 *1 0,0
Xsky130_fd_sc_hd__o21ai_0_45 \$191 \$1756 \$2251
+ vss
+ vdd
+ vdd
+ \$2252 sky130_fd_sc_hd__o21ai_0
* cell instance sky130_fd_sc_hd__o21ai_0_46 r0 *1 0,0
Xsky130_fd_sc_hd__o21ai_0_46 \$7027 \$7309 \$6188
+ vss
+ vdd
+ vdd
+ \$7218 sky130_fd_sc_hd__o21ai_0
* cell instance sky130_fd_sc_hd__o21ai_0_47 r0 *1 0,0
Xsky130_fd_sc_hd__o21ai_0_47 \$191 \$1764 \$2993
+ vss
+ vdd
+ vdd
+ \$2995 sky130_fd_sc_hd__o21ai_0
* cell instance sky130_fd_sc_hd__o21ai_0_48 r0 *1 0,0
Xsky130_fd_sc_hd__o21ai_0_48 \$1078 \$1011 \$1080
+ vss
+ vdd
+ vdd
+ \$1079 sky130_fd_sc_hd__o21ai_0
* cell instance sky130_fd_sc_hd__o21ai_0_49 r0 *1 0,0
Xsky130_fd_sc_hd__o21ai_0_49 \$1561 \$2257 \$2255
+ vss
+ vdd
+ vdd
+ \$2168 sky130_fd_sc_hd__o21ai_0
* cell instance sky130_fd_sc_hd__o21ai_0_50 r0 *1 0,0
Xsky130_fd_sc_hd__o21ai_0_50 \$1561 \$3304 \$3080
+ vss
+ vdd
+ vdd
+ \$3081 sky130_fd_sc_hd__o21ai_0
* cell instance sky130_fd_sc_hd__o21ai_0_51 r0 *1 0,0
Xsky130_fd_sc_hd__o21ai_0_51 \$7531 \$7533 \$6188
+ vss
+ vdd
+ vdd
+ \$7615 sky130_fd_sc_hd__o21ai_0
* cell instance sky130_fd_sc_hd__o21ai_0_52 r0 *1 0,0
Xsky130_fd_sc_hd__o21ai_0_52 \$2801 \$2989 \$2805
+ vss
+ vdd
+ vdd
+ \$2997 sky130_fd_sc_hd__o21ai_0
* cell instance sky130_fd_sc_hd__o21ai_0_53 r0 *1 0,0
Xsky130_fd_sc_hd__o21ai_0_53 \$3079 \$4199 \$4083
+ vss
+ vdd
+ vdd
+ \$4200 sky130_fd_sc_hd__o21ai_0
* cell instance sky130_fd_sc_hd__o21ai_0_54 r0 *1 0,0
Xsky130_fd_sc_hd__o21ai_0_54 \$3217 \$2997 \$2579
+ vss
+ vdd
+ vdd
+ \$3083 sky130_fd_sc_hd__o21ai_0
* cell instance sky130_fd_sc_hd__o21ai_0_55 r0 *1 0,0
Xsky130_fd_sc_hd__o21ai_0_55 \$4198 \$3842 \$1752
+ vss
+ vdd
+ vdd
+ \$4202 sky130_fd_sc_hd__o21ai_0
* cell instance sky130_fd_sc_hd__o21ai_0_56 r0 *1 0,0
Xsky130_fd_sc_hd__o21ai_0_56 \$191 \$221 \$105
+ vss
+ vdd
+ vdd
+ \$35 sky130_fd_sc_hd__o21ai_0
* cell instance sky130_fd_sc_hd__o21ai_0_57 r0 *1 0,0
Xsky130_fd_sc_hd__o21ai_0_57 \$7221 \$7386 \$6188
+ vss
+ vdd
+ vdd
+ \$7384 sky130_fd_sc_hd__o21ai_0
* cell instance sky130_fd_sc_hd__o21ai_0_58 r0 *1 0,0
Xsky130_fd_sc_hd__o21ai_0_58 \$182 \$241 \$181
+ vss
+ vdd
+ vdd
+ \$183 sky130_fd_sc_hd__o21ai_0
* cell instance sky130_fd_sc_hd__o21ai_0_59 r0 *1 0,0
Xsky130_fd_sc_hd__o21ai_0_59 \$6617 \$6620 \$5592
+ vss
+ vdd
+ vdd
+ \$6618 sky130_fd_sc_hd__o21ai_0
* cell instance sky130_fd_sc_hd__o21ai_0_60 r0 *1 0,0
Xsky130_fd_sc_hd__o21ai_0_60 \$1561 \$1871 \$1596
+ vss
+ vdd
+ vdd
+ \$1873 sky130_fd_sc_hd__o21ai_0
* cell instance sky130_fd_sc_hd__o21ai_0_61 r0 *1 0,0
Xsky130_fd_sc_hd__o21ai_0_61 \$1516 \$1669 \$2352
+ vss
+ vdd
+ vdd
+ \$2353 sky130_fd_sc_hd__o21ai_0
* cell instance sky130_fd_sc_hd__o21ai_0_62 r0 *1 0,0
Xsky130_fd_sc_hd__o21ai_0_62 \$182 \$951 \$523
+ vss
+ vdd
+ vdd
+ \$744 sky130_fd_sc_hd__o21ai_0
* cell instance sky130_fd_sc_hd__o21ai_0_63 r0 *1 0,0
Xsky130_fd_sc_hd__o21ai_0_63 \$7543 \$7542 \$6188
+ vss
+ vdd
+ vdd
+ \$7456 sky130_fd_sc_hd__o21ai_0
* cell instance sky130_fd_sc_hd__o21ai_0_64 r0 *1 0,0
Xsky130_fd_sc_hd__o21ai_0_64 \$3259 \$4304 \$3079
+ vss
+ vdd
+ vdd
+ \$4089 sky130_fd_sc_hd__o21ai_0
* cell instance sky130_fd_sc_hd__o21ai_0_65 r0 *1 0,0
Xsky130_fd_sc_hd__o21ai_0_65 \$182 \$886 \$524
+ vss
+ vdd
+ vdd
+ \$654 sky130_fd_sc_hd__o21ai_0
* cell instance sky130_fd_sc_hd__o21ai_0_66 r0 *1 0,0
Xsky130_fd_sc_hd__o21ai_0_66 \$219 \$1875 \$2353
+ vss
+ vdd
+ vdd
+ \$2680 sky130_fd_sc_hd__o21ai_0
* cell instance sky130_fd_sc_hd__o21ai_0_67 r0 *1 0,0
Xsky130_fd_sc_hd__o21ai_0_67 \$191 \$573 \$185
+ vss
+ vdd
+ vdd
+ \$114 sky130_fd_sc_hd__o21ai_0
* cell instance sky130_fd_sc_hd__o21ai_0_68 r0 *1 0,0
Xsky130_fd_sc_hd__o21ai_0_68 \$1875 \$2353 \$2680
+ vss
+ vdd
+ vdd
+ \$2459 sky130_fd_sc_hd__o21ai_0
* cell instance sky130_fd_sc_hd__o21ai_0_69 r0 *1 0,0
Xsky130_fd_sc_hd__o21ai_0_69 \$2569 \$2568 \$2562
+ vss
+ vdd
+ vdd
+ \$2566 sky130_fd_sc_hd__o21ai_0
* cell instance sky130_fd_sc_hd__o21ai_0_70 r0 *1 0,0
Xsky130_fd_sc_hd__o21ai_0_70 \$182 \$187 \$253
+ vss
+ vdd
+ vdd
+ \$188 sky130_fd_sc_hd__o21ai_0
* cell instance sky130_fd_sc_hd__o21ai_0_71 r0 *1 0,0
Xsky130_fd_sc_hd__o21ai_0_71 \$5590 \$5473 \$5592
+ vss
+ vdd
+ vdd
+ \$5515 sky130_fd_sc_hd__o21ai_0
* cell instance sky130_fd_sc_hd__o21ai_0_72 r0 *1 0,0
Xsky130_fd_sc_hd__o21ai_0_72 \$191 \$1508 \$1326
+ vss
+ vdd
+ vdd
+ \$1243 sky130_fd_sc_hd__o21ai_0
* cell instance sky130_fd_sc_hd__o21ai_0_73 r0 *1 0,0
Xsky130_fd_sc_hd__o21ai_0_73 \$641 \$683 \$889
+ vss
+ vdd
+ vdd
+ \$1022 sky130_fd_sc_hd__o21ai_0
* cell instance sky130_fd_sc_hd__o21ai_0_74 r0 *1 0,0
Xsky130_fd_sc_hd__o21ai_0_74 \$191 \$641 \$527
+ vss
+ vdd
+ vdd
+ \$528 sky130_fd_sc_hd__o21ai_0
* cell instance sky130_fd_sc_hd__o21ai_0_75 r0 *1 0,0
Xsky130_fd_sc_hd__o21ai_0_75 \$182 \$887 \$819
+ vss
+ vdd
+ vdd
+ \$890 sky130_fd_sc_hd__o21ai_0
* cell instance sky130_fd_sc_hd__o21ai_0_76 r0 *1 0,0
Xsky130_fd_sc_hd__o21ai_0_76 \$182 \$1520 \$1329
+ vss
+ vdd
+ vdd
+ \$1182 sky130_fd_sc_hd__o21ai_0
* cell instance sky130_fd_sc_hd__o21ai_0_77 r0 *1 0,0
Xsky130_fd_sc_hd__o21ai_0_77 \$5807 \$5808 \$5592
+ vss
+ vdd
+ vdd
+ \$5805 sky130_fd_sc_hd__o21ai_0
* cell instance sky130_fd_sc_hd__o21ai_0_78 r0 *1 0,0
Xsky130_fd_sc_hd__o21ai_0_78 \$641 \$180 \$657
+ vss
+ vdd
+ vdd
+ \$658 sky130_fd_sc_hd__o21ai_0
* cell instance sky130_fd_sc_hd__o21ai_0_79 r0 *1 0,0
Xsky130_fd_sc_hd__o21ai_0_79 \$1561 \$1776 \$1775
+ vss
+ vdd
+ vdd
+ \$1679 sky130_fd_sc_hd__o21ai_0
* cell instance sky130_fd_sc_hd__o21ai_0_80 r0 *1 0,0
Xsky130_fd_sc_hd__o21ai_0_80 \$191 \$1667 \$1965
+ vss
+ vdd
+ vdd
+ \$1814 sky130_fd_sc_hd__o21ai_0
* cell instance sky130_fd_sc_hd__o21ai_0_81 r0 *1 0,0
Xsky130_fd_sc_hd__o21ai_0_81 \$5476 \$5591 \$5592
+ vss
+ vdd
+ vdd
+ \$5623 sky130_fd_sc_hd__o21ai_0
* cell instance sky130_fd_sc_hd__o21ai_0_82 r0 *1 0,0
Xsky130_fd_sc_hd__o21ai_0_82 \$191 \$230 \$386
+ vss
+ vdd
+ vdd
+ \$254 sky130_fd_sc_hd__o21ai_0
* cell instance sky130_fd_sc_hd__o21ai_0_83 r0 *1 0,0
Xsky130_fd_sc_hd__o21ai_0_83 \$3079 \$4094 \$4093
+ vss
+ vdd
+ vdd
+ \$3970 sky130_fd_sc_hd__o21ai_0
* cell instance sky130_fd_sc_hd__o21ai_0_84 r0 *1 0,0
Xsky130_fd_sc_hd__o21ai_0_84 \$6236 \$6238 \$5592
+ vss
+ vdd
+ vdd
+ \$6050 sky130_fd_sc_hd__o21ai_0
* cell instance sky130_fd_sc_hd__o21ai_0_85 r0 *1 0,0
Xsky130_fd_sc_hd__o21ai_0_85 \$230 \$180 \$387
+ vss
+ vdd
+ vdd
+ \$257 sky130_fd_sc_hd__o21ai_0
* cell instance sky130_fd_sc_hd__o21ai_0_86 r0 *1 0,0
Xsky130_fd_sc_hd__o21ai_0_86 \$2572 \$2908 \$2905
+ vss
+ vdd
+ vdd
+ \$2366 sky130_fd_sc_hd__o21ai_0
* cell instance sky130_fd_sc_hd__o21ai_0_87 r0 *1 0,0
Xsky130_fd_sc_hd__o21ai_0_87 \$191 \$1428 \$1522
+ vss
+ vdd
+ vdd
+ \$1523 sky130_fd_sc_hd__o21ai_0
* cell instance sky130_fd_sc_hd__o21ai_0_88 r0 *1 0,0
Xsky130_fd_sc_hd__o21ai_0_88 \$191 \$284 \$190
+ vss
+ vdd
+ vdd
+ \$192 sky130_fd_sc_hd__o21ai_0
* cell instance sky130_fd_sc_hd__o21ai_0_89 r0 *1 0,0
Xsky130_fd_sc_hd__o21ai_0_89 \$230 \$683 \$1026
+ vss
+ vdd
+ vdd
+ \$892 sky130_fd_sc_hd__o21ai_0
* cell instance sky130_fd_sc_hd__o21ai_0_90 r0 *1 0,0
Xsky130_fd_sc_hd__o21ai_0_90 \$284 \$180 \$330
+ vss
+ vdd
+ vdd
+ \$261 sky130_fd_sc_hd__o21ai_0
* cell instance sky130_fd_sc_hd__o21ai_0_91 r0 *1 0,0
Xsky130_fd_sc_hd__o21ai_0_91 \$182 \$821 \$530
+ vss
+ vdd
+ vdd
+ \$672 sky130_fd_sc_hd__o21ai_0
* cell instance sky130_fd_sc_hd__o21ai_0_92 r0 *1 0,0
Xsky130_fd_sc_hd__o21ai_0_92 \$7163 \$7328 \$5592
+ vss
+ vdd
+ vdd
+ \$7329 sky130_fd_sc_hd__o21ai_0
* cell instance sky130_fd_sc_hd__o21ai_0_93 r0 *1 0,0
Xsky130_fd_sc_hd__o21ai_0_93 \$6242 \$6239 \$5592
+ vss
+ vdd
+ vdd
+ \$6240 sky130_fd_sc_hd__o21ai_0
* cell instance sky130_fd_sc_hd__o21ai_0_94 r0 *1 0,0
Xsky130_fd_sc_hd__o21ai_0_94 \$6634 \$6722 \$5592
+ vss
+ vdd
+ vdd
+ \$6635 sky130_fd_sc_hd__o21ai_0
* cell instance sky130_fd_sc_hd__o21ai_0_95 r0 *1 0,0
Xsky130_fd_sc_hd__o21ai_0_95 \$182 \$1601 \$1602
+ vss
+ vdd
+ vdd
+ \$1254 sky130_fd_sc_hd__o21ai_0
* cell instance sky130_fd_sc_hd__o21ai_0_96 r0 *1 0,0
Xsky130_fd_sc_hd__o21ai_0_96 \$5704 \$6151 \$5592
+ vss
+ vdd
+ vdd
+ \$6152 sky130_fd_sc_hd__o21ai_0
* cell instance sky130_fd_sc_hd__o21ai_0_97 r0 *1 0,0
Xsky130_fd_sc_hd__o21ai_0_97 \$3519 \$3521 \$3331
+ vss
+ vdd
+ vdd
+ \$3010 sky130_fd_sc_hd__o21ai_0
* cell instance sky130_fd_sc_hd__o21ai_0_98 r0 *1 0,0
Xsky130_fd_sc_hd__o21ai_0_98 \$191 \$1091 \$1104
+ vss
+ vdd
+ vdd
+ \$830 sky130_fd_sc_hd__o21ai_0
* cell instance sky130_fd_sc_hd__o21ai_0_99 r0 *1 0,0
Xsky130_fd_sc_hd__o21ai_0_99 \$1091 \$180 \$1184
+ vss
+ vdd
+ vdd
+ \$1185 sky130_fd_sc_hd__o21ai_0
* cell instance sky130_fd_sc_hd__o21ai_0_100 r0 *1 0,0
Xsky130_fd_sc_hd__o21ai_0_100 bus_addr[2] bus_wdata[2] \$3261
+ vss
+ vdd
+ vdd
+ \$3352 sky130_fd_sc_hd__o21ai_0
* cell instance sky130_fd_sc_hd__o21ai_0_101 r0 *1 0,0
Xsky130_fd_sc_hd__o21ai_0_101 \$3008 \$3240 \$3239
+ vss
+ vdd
+ vdd
+ \$3107 sky130_fd_sc_hd__o21ai_0
* cell instance sky130_fd_sc_hd__o21ai_0_102 r0 *1 0,0
Xsky130_fd_sc_hd__o21ai_0_102 \$182 \$532 \$469
+ vss
+ vdd
+ vdd
+ \$398 sky130_fd_sc_hd__o21ai_0
* cell instance sky130_fd_sc_hd__o21ai_0_103 r0 *1 0,0
Xsky130_fd_sc_hd__o21ai_0_103 \$182 \$1340 \$1255
+ vss
+ vdd
+ vdd
+ \$1372 sky130_fd_sc_hd__o21ai_0
* cell instance sky130_fd_sc_hd__o21ai_0_104 r0 *1 0,0
Xsky130_fd_sc_hd__o21ai_0_104 \$1091 \$683 \$1526
+ vss
+ vdd
+ vdd
+ \$1527 sky130_fd_sc_hd__o21ai_0
* cell instance sky130_fd_sc_hd__o21ai_0_105 r0 *1 0,0
Xsky130_fd_sc_hd__o21ai_0_105 \$3079 \$2685 \$2581
+ vss
+ vdd
+ vdd
+ \$2374 sky130_fd_sc_hd__o21ai_0
* cell instance sky130_fd_sc_hd__o21ai_0_106 r0 *1 0,0
Xsky130_fd_sc_hd__o21ai_0_106 \$284 \$683 \$758
+ vss
+ vdd
+ vdd
+ \$832 sky130_fd_sc_hd__o21ai_0
* cell instance sky130_fd_sc_hd__o21ai_0_107 r0 *1 0,0
Xsky130_fd_sc_hd__o21ai_0_107 \$191 \$102 \$194
+ vss
+ vdd
+ vdd
+ \$68 sky130_fd_sc_hd__o21ai_0
* cell instance sky130_fd_sc_hd__o21ai_0_108 r0 *1 0,0
Xsky130_fd_sc_hd__o21ai_0_108 \$102 \$180 \$265
+ vss
+ vdd
+ vdd
+ \$266 sky130_fd_sc_hd__o21ai_0
* cell instance sky130_fd_sc_hd__o21ai_0_109 r0 *1 0,0
Xsky130_fd_sc_hd__o21ai_0_109 \$102 \$683 \$835
+ vss
+ vdd
+ vdd
+ \$897 sky130_fd_sc_hd__o21ai_0
* cell instance sky130_fd_sc_hd__o21ai_0_110 r0 *1 0,0
Xsky130_fd_sc_hd__o21ai_0_110 \$182 \$609 \$400
+ vss
+ vdd
+ vdd
+ \$471 sky130_fd_sc_hd__o21ai_0
* cell instance sky130_fd_sc_hd__o21ai_0_111 r0 *1 0,0
Xsky130_fd_sc_hd__o21ai_0_111 \$3657 \$3630 \$3232
+ vss
+ vdd
+ vdd
+ \$3658 sky130_fd_sc_hd__o21ai_0
* cell instance sky130_fd_sc_hd__o21ai_0_112 r0 *1 0,0
Xsky130_fd_sc_hd__o21ai_0_112 \$191 \$1666 \$1976
+ vss
+ vdd
+ vdd
+ \$1977 sky130_fd_sc_hd__o21ai_0
* cell instance sky130_fd_sc_hd__o21ai_0_113 r0 *1 0,0
Xsky130_fd_sc_hd__o21ai_0_113 \$3111 \$2909 \$2805
+ vss
+ vdd
+ vdd
+ \$2586 sky130_fd_sc_hd__o21ai_0
* cell instance sky130_fd_sc_hd__o21ai_0_114 r0 *1 0,0
Xsky130_fd_sc_hd__o21ai_0_114 \$3079 \$2588 \$2587
+ vss
+ vdd
+ vdd
+ \$2480 sky130_fd_sc_hd__o21ai_0
* cell instance sky130_fd_sc_hd__o21ai_0_115 r0 *1 0,0
Xsky130_fd_sc_hd__o21ai_0_115 \$1141 \$683 \$1607
+ vss
+ vdd
+ vdd
+ \$1608 sky130_fd_sc_hd__o21ai_0
* cell instance sky130_fd_sc_hd__o21ai_0_116 r0 *1 0,0
Xsky130_fd_sc_hd__o21ai_0_116 \$3079 \$6893 \$4558
+ vss
+ vdd
+ vdd
+ \$4776 sky130_fd_sc_hd__o21ai_0
* cell instance sky130_fd_sc_hd__o21ai_0_117 r0 *1 0,0
Xsky130_fd_sc_hd__o21ai_0_117 \$191 \$1141 \$1189
+ vss
+ vdd
+ vdd
+ \$1190 sky130_fd_sc_hd__o21ai_0
* cell instance sky130_fd_sc_hd__o21ai_0_118 r0 *1 0,0
Xsky130_fd_sc_hd__o21ai_0_118 \$1141 \$180 \$1115
+ vss
+ vdd
+ vdd
+ \$1193 sky130_fd_sc_hd__o21ai_0
* cell instance sky130_fd_sc_hd__o21ai_0_119 r0 *1 0,0
Xsky130_fd_sc_hd__o21ai_0_119 \$3079 \$4109 \$4107
+ vss
+ vdd
+ vdd
+ \$4108 sky130_fd_sc_hd__o21ai_0
* cell instance sky130_fd_sc_hd__o21ai_0_120 r0 *1 0,0
Xsky130_fd_sc_hd__o21ai_0_120 \$370 \$683 \$682
+ vss
+ vdd
+ vdd
+ \$837 sky130_fd_sc_hd__o21ai_0
* cell instance sky130_fd_sc_hd__o21ai_0_121 r0 *1 0,0
Xsky130_fd_sc_hd__o21ai_0_121 \$191 \$370 \$197
+ vss
+ vdd
+ vdd
+ \$198 sky130_fd_sc_hd__o21ai_0
* cell instance sky130_fd_sc_hd__o21ai_0_122 r0 *1 0,0
Xsky130_fd_sc_hd__o21ai_0_122 \$370 \$180 \$269
+ vss
+ vdd
+ vdd
+ \$270 sky130_fd_sc_hd__o21ai_0
* cell instance sky130_fd_sc_hd__o21ai_0_123 r0 *1 0,0
Xsky130_fd_sc_hd__o21ai_0_123 \$182 \$1452 \$1257
+ vss
+ vdd
+ vdd
+ \$1453 sky130_fd_sc_hd__o21ai_0
* cell instance sky130_fd_sc_hd__o21ai_0_124 r0 *1 0,0
Xsky130_fd_sc_hd__o21ai_0_124 \$182 \$2078 \$1980
+ vss
+ vdd
+ vdd
+ \$1981 sky130_fd_sc_hd__o21ai_0
* cell instance sky130_fd_sc_hd__o21ai_0_125 r0 *1 0,0
Xsky130_fd_sc_hd__o21ai_0_125 \$5518 \$4802 \$5602
+ vss
+ vdd
+ vdd
+ \$5603 sky130_fd_sc_hd__o21ai_0
* cell instance sky130_fd_sc_hd__o21ai_0_126 r0 *1 0,0
Xsky130_fd_sc_hd__o21ai_0_126 \$182 \$545 \$402
+ vss
+ vdd
+ vdd
+ \$403 sky130_fd_sc_hd__o21ai_0
* cell instance sky130_fd_sc_hd__o21ai_0_127 r0 *1 0,0
Xsky130_fd_sc_hd__o21ai_0_127 \$3079 \$6546 \$3978
+ vss
+ vdd
+ vdd
+ \$3634 sky130_fd_sc_hd__o21ai_0
* cell instance sky130_fd_sc_hd__o21ai_0_128 r0 *1 0,0
Xsky130_fd_sc_hd__o21ai_0_128 \$191 \$1016 \$1039
+ vss
+ vdd
+ vdd
+ \$1040 sky130_fd_sc_hd__o21ai_0
* cell instance sky130_fd_sc_hd__o21ai_0_129 r0 *1 0,0
Xsky130_fd_sc_hd__o21ai_0_129 \$297 \$683 \$841
+ vss
+ vdd
+ vdd
+ \$686 sky130_fd_sc_hd__o21ai_0
* cell instance sky130_fd_sc_hd__o21ai_0_130 r0 *1 0,0
Xsky130_fd_sc_hd__o21ai_0_130 \$3079 \$4229 \$3979
+ vss
+ vdd
+ vdd
+ \$4119 sky130_fd_sc_hd__o21ai_0
* cell instance sky130_fd_sc_hd__o21ai_0_131 r0 *1 0,0
Xsky130_fd_sc_hd__o21ai_0_131 \$297 \$180 \$349
+ vss
+ vdd
+ vdd
+ \$483 sky130_fd_sc_hd__o21ai_0
* cell instance sky130_fd_sc_hd__o21ai_0_132 r0 *1 0,0
Xsky130_fd_sc_hd__o21ai_0_132 \$191 \$297 \$272
+ vss
+ vdd
+ vdd
+ \$273 sky130_fd_sc_hd__o21ai_0
* cell instance sky130_fd_sc_hd__o21ai_0_133 r0 *1 0,0
Xsky130_fd_sc_hd__o21ai_0_133 \$182 \$1117 \$1042
+ vss
+ vdd
+ vdd
+ \$990 sky130_fd_sc_hd__o21ai_0
* cell instance sky130_fd_sc_hd__o21ai_0_134 r0 *1 0,0
Xsky130_fd_sc_hd__o21ai_0_134 \$182 \$621 \$485
+ vss
+ vdd
+ vdd
+ \$413 sky130_fd_sc_hd__o21ai_0
* cell instance sky130_fd_sc_hd__o21ai_0_135 r0 *1 0,0
Xsky130_fd_sc_hd__o21ai_0_135 \$191 \$727 \$1454
+ vss
+ vdd
+ vdd
+ \$1455 sky130_fd_sc_hd__o21ai_0
* cell instance sky130_fd_sc_hd__o21ai_0_136 r0 *1 0,0
Xsky130_fd_sc_hd__o21ai_0_136 \$191 \$805 \$2284
+ vss
+ vdd
+ vdd
+ \$2385 sky130_fd_sc_hd__o21ai_0
* cell instance sky130_fd_sc_hd__o21ai_0_137 r0 *1 0,0
Xsky130_fd_sc_hd__o21ai_0_137 \$3088 \$623 \$3116
+ vss
+ vdd
+ vdd
+ \$3248 sky130_fd_sc_hd__o21ai_0
* cell instance sky130_fd_sc_hd__o21ai_0_138 r0 *1 0,0
Xsky130_fd_sc_hd__o21ai_0_138 \$3079 \$3537 \$3342
+ vss
+ vdd
+ vdd
+ \$3427 sky130_fd_sc_hd__o21ai_0
* cell instance sky130_fd_sc_hd__o21ai_0_139 r0 *1 0,0
Xsky130_fd_sc_hd__o21ai_0_139 \$182 \$2707 \$2490
+ vss
+ vdd
+ vdd
+ \$2705 sky130_fd_sc_hd__o21ai_0
* cell instance sky130_fd_sc_hd__o21ai_0_140 r0 *1 0,0
Xsky130_fd_sc_hd__o21ai_0_140 \$191 \$594 \$771
+ vss
+ vdd
+ vdd
+ \$700 sky130_fd_sc_hd__o21ai_0
* cell instance sky130_fd_sc_hd__o21ai_0_141 r0 *1 0,0
Xsky130_fd_sc_hd__o21ai_0_141 \$191 \$206 \$203
+ vss
+ vdd
+ vdd
+ \$204 sky130_fd_sc_hd__o21ai_0
* cell instance sky130_fd_sc_hd__o21ai_0_142 r0 *1 0,0
Xsky130_fd_sc_hd__o21ai_0_142 \$206 \$180 \$275
+ vss
+ vdd
+ vdd
+ \$276 sky130_fd_sc_hd__o21ai_0
* cell instance sky130_fd_sc_hd__o21ai_0_143 r0 *1 0,0
Xsky130_fd_sc_hd__o21ai_0_143 \$182 \$1622 \$1456
+ vss
+ vdd
+ vdd
+ \$1539 sky130_fd_sc_hd__o21ai_0
* cell instance sky130_fd_sc_hd__o21ai_0_144 r0 *1 0,0
Xsky130_fd_sc_hd__o21ai_0_144 \$182 \$355 \$278
+ vss
+ vdd
+ vdd
+ \$356 sky130_fd_sc_hd__o21ai_0
* cell instance sky130_fd_sc_hd__o21ai_0_145 r0 *1 0,0
Xsky130_fd_sc_hd__o21ai_0_145 \$182 \$775 \$776
+ vss
+ vdd
+ vdd
+ \$777 sky130_fd_sc_hd__o21ai_0
* cell instance sky130_fd_sc_hd__o21ba_2_0 r0 *1 0,0
Xsky130_fd_sc_hd__o21ba_2_0 \$3923 \$3972 startup_done
+ vss
+ vdd
+ vdd
+ \$3521 sky130_fd_sc_hd__o21ba_2
* cell instance sky130_fd_sc_hd__o21bai_1_0 r0 *1 0,0
Xsky130_fd_sc_hd__o21bai_1_0 \$2744 \$3130 \$2746
+ vss
+ vdd
+ vdd
+ \$2837 sky130_fd_sc_hd__o21bai_1
* cell instance sky130_fd_sc_hd__o21bai_1_1 r0 *1 0,0
Xsky130_fd_sc_hd__o21bai_1_1 \$2305 \$2306 startup_done
+ vss
+ vdd
+ vdd
+ \$2870 sky130_fd_sc_hd__o21bai_1
* cell instance sky130_fd_sc_hd__o221ai_1_0 r0 *1 0,0
Xsky130_fd_sc_hd__o221ai_1_0 \$3088 \$3494 \$3724 \$3079 \$3726
+ vss
+ vdd
+ vdd
+ \$3402 sky130_fd_sc_hd__o221ai_1
* cell instance sky130_fd_sc_hd__o221ai_1_1 r0 *1 0,0
Xsky130_fd_sc_hd__o221ai_1_1 \$3088 \$4053 \$4577 \$3079 \$4634
+ vss
+ vdd
+ vdd
+ \$4631 sky130_fd_sc_hd__o221ai_1
* cell instance sky130_fd_sc_hd__o221ai_1_2 r0 *1 0,0
Xsky130_fd_sc_hd__o221ai_1_2 \$3088 \$4180 \$5881 \$3079 \$4530
+ vss
+ vdd
+ vdd
+ \$4529 sky130_fd_sc_hd__o221ai_1
* cell instance sky130_fd_sc_hd__o221ai_1_3 r0 *1 0,0
Xsky130_fd_sc_hd__o221ai_1_3 \$2801 \$2656 \$2804 \$2803 \$2805
+ vss
+ vdd
+ vdd
+ \$2802 sky130_fd_sc_hd__o221ai_1
* cell instance sky130_fd_sc_hd__o221ai_1_4 r0 *1 0,0
Xsky130_fd_sc_hd__o221ai_1_4 \$2801 \$3060 \$3613 \$2803 \$2805
+ vss
+ vdd
+ vdd
+ \$3612 sky130_fd_sc_hd__o221ai_1
* cell instance sky130_fd_sc_hd__o221ai_1_5 r0 *1 0,0
Xsky130_fd_sc_hd__o221ai_1_5 \$2801 \$3828 \$3243 \$4286 \$2805
+ vss
+ vdd
+ vdd
+ \$3841 sky130_fd_sc_hd__o221ai_1
* cell instance sky130_fd_sc_hd__o221ai_1_6 r0 *1 0,0
Xsky130_fd_sc_hd__o221ai_1_6 \$2801 \$2502 \$2807 \$2803 \$2805
+ vss
+ vdd
+ vdd
+ \$2806 sky130_fd_sc_hd__o221ai_1
* cell instance sky130_fd_sc_hd__o221ai_1_7 r0 *1 0,0
Xsky130_fd_sc_hd__o221ai_1_7 \$2801 \$3617 \$3730 \$2803 \$3225
+ vss
+ vdd
+ vdd
+ \$3731 sky130_fd_sc_hd__o221ai_1
* cell instance sky130_fd_sc_hd__o221ai_1_8 r0 *1 0,0
Xsky130_fd_sc_hd__o221ai_1_8 \$2801 \$1940 \$2678 \$2803 \$2805
+ vss
+ vdd
+ vdd
+ \$2489 sky130_fd_sc_hd__o221ai_1
* cell instance sky130_fd_sc_hd__o221ai_1_9 r0 *1 0,0
Xsky130_fd_sc_hd__o221ai_1_9 \$3088 \$1871 \$4647 \$3079 \$3000
+ vss
+ vdd
+ vdd
+ \$3090 sky130_fd_sc_hd__o221ai_1
* cell instance sky130_fd_sc_hd__o221ai_1_10 r0 *1 0,0
Xsky130_fd_sc_hd__o221ai_1_10 \$2801 \$2035 \$3847 \$2803 \$2805
+ vss
+ vdd
+ vdd
+ \$3846 sky130_fd_sc_hd__o221ai_1
* cell instance sky130_fd_sc_hd__o221ai_1_11 r0 *1 0,0
Xsky130_fd_sc_hd__o221ai_1_11 \$2801 \$951 \$2994 \$2803 \$3113
+ vss
+ vdd
+ vdd
+ \$3003 sky130_fd_sc_hd__o221ai_1
* cell instance sky130_fd_sc_hd__o221ai_1_12 r0 *1 0,0
Xsky130_fd_sc_hd__o221ai_1_12 \$3088 \$3992 \$4411 \$3079 \$4413
+ vss
+ vdd
+ vdd
+ \$4412 sky130_fd_sc_hd__o221ai_1
* cell instance sky130_fd_sc_hd__o221ai_1_13 r0 *1 0,0
Xsky130_fd_sc_hd__o221ai_1_13 \$3079 \$4242 \$2908 \$3975 \$4422
+ vss
+ vdd
+ vdd
+ \$4215 sky130_fd_sc_hd__o221ai_1
* cell instance sky130_fd_sc_hd__o221ai_1_14 r0 *1 0,0
Xsky130_fd_sc_hd__o221ai_1_14 \$2803 \$3860 \$3243 \$3584 \$3109
+ vss
+ vdd
+ vdd
+ \$3863 sky130_fd_sc_hd__o221ai_1
* cell instance sky130_fd_sc_hd__o221ai_1_15 r0 *1 0,0
Xsky130_fd_sc_hd__o221ai_1_15 \$3335 \$2909 \$3243 \$2353 \$3113
+ vss
+ vdd
+ vdd
+ \$3337 sky130_fd_sc_hd__o221ai_1
* cell instance sky130_fd_sc_hd__o221ai_1_16 r0 *1 0,0
Xsky130_fd_sc_hd__o221ai_1_16 \$2801 \$2283 \$3531 \$2803 \$2805
+ vss
+ vdd
+ vdd
+ \$3428 sky130_fd_sc_hd__o221ai_1
* cell instance sky130_fd_sc_hd__o221ai_1_17 r0 *1 0,0
Xsky130_fd_sc_hd__o221ai_1_17 \$3088 \$2613 \$4563 \$3079 \$4564
+ vss
+ vdd
+ vdd
+ \$4562 sky130_fd_sc_hd__o221ai_1
* cell instance sky130_fd_sc_hd__o221ai_1_18 r0 *1 0,0
Xsky130_fd_sc_hd__o221ai_1_18 \$3088 \$2095 \$4234 \$3079 \$4910
+ vss
+ vdd
+ vdd
+ \$4232 sky130_fd_sc_hd__o221ai_1
* cell instance sky130_fd_sc_hd__o221ai_1_19 r0 *1 0,0
Xsky130_fd_sc_hd__o221ai_1_19 \$3088 \$1273 \$4335 \$3079 \$4336
+ vss
+ vdd
+ vdd
+ \$4334 sky130_fd_sc_hd__o221ai_1
* cell instance sky130_fd_sc_hd__o221ai_1_20 r0 *1 0,0
Xsky130_fd_sc_hd__o221ai_1_20 \$3088 \$3022 \$5154 \$3079 \$4337
+ vss
+ vdd
+ vdd
+ \$5269 sky130_fd_sc_hd__o221ai_1
* cell instance sky130_fd_sc_hd__o221ai_1_21 r0 *1 0,0
Xsky130_fd_sc_hd__o221ai_1_21 \$3088 \$1816 \$2710 \$3079 \$2495
+ vss
+ vdd
+ vdd
+ \$2393 sky130_fd_sc_hd__o221ai_1
* cell instance sky130_fd_sc_hd__o221ai_1_22 r0 *1 0,0
Xsky130_fd_sc_hd__o221ai_1_22 \$3088 \$994 \$6907 \$3079 \$2496
+ vss
+ vdd
+ vdd
+ \$2607 sky130_fd_sc_hd__o221ai_1
* cell instance sky130_fd_sc_hd__o22ai_1_0 r0 *1 0,0
Xsky130_fd_sc_hd__o22ai_1_0 \$7100 \$5475 \$6925 \$5474
+ vss
+ vdd
+ vdd
+ \$6924 sky130_fd_sc_hd__o22ai_1
* cell instance sky130_fd_sc_hd__o22ai_1_1 r0 *1 0,0
Xsky130_fd_sc_hd__o22ai_1_1 \$5661 \$5475 \$5663 \$5474
+ vss
+ vdd
+ vdd
+ \$5662 sky130_fd_sc_hd__o22ai_1
* cell instance sky130_fd_sc_hd__o22ai_1_2 r0 *1 0,0
Xsky130_fd_sc_hd__o22ai_1_2 \$7510 \$5475 \$7426 \$5474
+ vss
+ vdd
+ vdd
+ \$7516 sky130_fd_sc_hd__o22ai_1
* cell instance sky130_fd_sc_hd__o22ai_1_3 r0 *1 0,0
Xsky130_fd_sc_hd__o22ai_1_3 \$5406 \$5475 \$5680 \$5474
+ vss
+ vdd
+ vdd
+ \$5571 sky130_fd_sc_hd__o22ai_1
* cell instance sky130_fd_sc_hd__o22ai_1_4 r0 *1 0,0
Xsky130_fd_sc_hd__o22ai_1_4 \$6608 \$5475 \$6521 \$5474
+ vss
+ vdd
+ vdd
+ \$6610 sky130_fd_sc_hd__o22ai_1
* cell instance sky130_fd_sc_hd__o22ai_1_5 r0 *1 0,0
Xsky130_fd_sc_hd__o22ai_1_5 \$7532 \$5475 \$7541 \$5474
+ vss
+ vdd
+ vdd
+ \$7540 sky130_fd_sc_hd__o22ai_1
* cell instance sky130_fd_sc_hd__o22ai_1_6 r0 *1 0,0
Xsky130_fd_sc_hd__o22ai_1_6 \$7040 \$5475 \$6961 \$5474
+ vss
+ vdd
+ vdd
+ \$6963 sky130_fd_sc_hd__o22ai_1
* cell instance sky130_fd_sc_hd__o22ai_1_7 r0 *1 0,0
Xsky130_fd_sc_hd__o22ai_1_7 \$7538 \$5475 \$7629 \$5474
+ vss
+ vdd
+ vdd
+ \$7628 sky130_fd_sc_hd__o22ai_1
* cell instance sky130_fd_sc_hd__o22ai_1_8 r0 *1 0,0
Xsky130_fd_sc_hd__o22ai_1_8 \$4213 \$5475 \$6623 \$5474
+ vss
+ vdd
+ vdd
+ \$6622 sky130_fd_sc_hd__o22ai_1
* cell instance sky130_fd_sc_hd__o22ai_1_9 r0 *1 0,0
Xsky130_fd_sc_hd__o22ai_1_9 \$6332 \$5475 \$6235 \$5474
+ vss
+ vdd
+ vdd
+ \$6333 sky130_fd_sc_hd__o22ai_1
* cell instance sky130_fd_sc_hd__o22ai_1_10 r0 *1 0,0
Xsky130_fd_sc_hd__o22ai_1_10 \$4777 \$5475 \$5478 \$5474
+ vss
+ vdd
+ vdd
+ \$5477 sky130_fd_sc_hd__o22ai_1
* cell instance sky130_fd_sc_hd__o22ai_1_11 r0 *1 0,0
Xsky130_fd_sc_hd__o22ai_1_11 \$6975 \$5475 \$6887 \$5474
+ vss
+ vdd
+ vdd
+ \$6977 sky130_fd_sc_hd__o22ai_1
* cell instance sky130_fd_sc_hd__o22ai_1_12 r0 *1 0,0
Xsky130_fd_sc_hd__o22ai_1_12 \$2801 \$2182 \$2469 \$2803
+ vss
+ vdd
+ vdd
+ \$2471 sky130_fd_sc_hd__o22ai_1
* cell instance sky130_fd_sc_hd__o22ai_1_13 r0 *1 0,0
Xsky130_fd_sc_hd__o22ai_1_13 \$3328 \$3972 \$3352 \$3330
+ vss
+ vdd
+ vdd
+ \$3351 sky130_fd_sc_hd__o22ai_1
* cell instance sky130_fd_sc_hd__o22ai_1_14 r0 *1 0,0
Xsky130_fd_sc_hd__o22ai_1_14 \$3413 \$3923 \$3416 \$3352
+ vss
+ vdd
+ vdd
+ \$3240 sky130_fd_sc_hd__o22ai_1
* cell instance sky130_fd_sc_hd__o22ai_1_15 r0 *1 0,0
Xsky130_fd_sc_hd__o22ai_1_15 \$4221 \$5475 \$6723 \$5474
+ vss
+ vdd
+ vdd
+ \$6889 sky130_fd_sc_hd__o22ai_1
* cell instance sky130_fd_sc_hd__o22ai_1_16 r0 *1 0,0
Xsky130_fd_sc_hd__o22ai_1_16 \$3111 \$3333 \$3335 bus_addr[0]
+ vss
+ vdd
+ vdd
+ \$3234 sky130_fd_sc_hd__o22ai_1
* cell instance sky130_fd_sc_hd__o31a_1_0 r0 *1 0,0
Xsky130_fd_sc_hd__o31a_1_0 \$5944 \$4821 \$4248 \$5969
+ vss
+ vdd
+ vdd
+ \$5854 sky130_fd_sc_hd__o31a_1
* cell instance sky130_fd_sc_hd__o31ai_1_0 r0 *1 0,0
Xsky130_fd_sc_hd__o31ai_1_0 \$565 \$568 \$580 \$358
+ vss
+ vdd
+ vdd
+ \$506 sky130_fd_sc_hd__o31ai_1
* cell instance sky130_fd_sc_hd__o31ai_1_1 r0 *1 0,0
Xsky130_fd_sc_hd__o31ai_1_1 \$4255 \$4033 \$4455 \$4132
+ vss
+ vdd
+ vdd
+ \$4198 sky130_fd_sc_hd__o31ai_1
* cell instance sky130_fd_sc_hd__o31ai_1_2 r0 *1 0,0
Xsky130_fd_sc_hd__o31ai_1_2 \$4255 \$4033 \$4456 \$4388
+ vss
+ vdd
+ vdd
+ \$3842 sky130_fd_sc_hd__o31ai_1
* cell instance sky130_fd_sc_hd__o31ai_1_3 r0 *1 0,0
Xsky130_fd_sc_hd__o31ai_1_3 \$565 \$874 \$580 \$222
+ vss
+ vdd
+ vdd
+ \$875 sky130_fd_sc_hd__o31ai_1
* cell instance sky130_fd_sc_hd__o41a_1_0 r0 *1 0,0
Xsky130_fd_sc_hd__o41a_1_0 \$5508 \$4821 \$4248 \$4934 \$5524
+ vss
+ vdd
+ vdd
+ \$5525 sky130_fd_sc_hd__o41a_1
* cell instance sky130_fd_sc_hd__o41ai_1_0 r0 *1 0,0
Xsky130_fd_sc_hd__o41ai_1_0 \$4353 \$4494 \$4818 \$4354 \$5400
+ vss
+ vdd
+ vdd
+ \$4932 sky130_fd_sc_hd__o41ai_1
* cell instance sky130_fd_sc_hd__o41ai_1_1 r0 *1 0,0
Xsky130_fd_sc_hd__o41ai_1_1 \$3891 \$3960 \$4091 \$3961 out_ready
+ vss
+ vdd
+ vdd
+ \$4304 sky130_fd_sc_hd__o41ai_1
* cell instance sky130_fd_sc_hd__or2_2_0 r0 *1 0,0
Xsky130_fd_sc_hd__or2_2_0 \$4484 \$4937
+ vss
+ vdd
+ vdd
+ \$5189 sky130_fd_sc_hd__or2_2
* cell instance sky130_fd_sc_hd__or2_2_1 r0 *1 0,0
Xsky130_fd_sc_hd__or2_2_1 \$4365 \$5201
+ vss
+ vdd
+ vdd
+ \$4955 sky130_fd_sc_hd__or2_2
* cell instance sky130_fd_sc_hd__or2_2_2 r0 *1 0,0
Xsky130_fd_sc_hd__or2_2_2 \$3923 \$3972
+ vss
+ vdd
+ vdd
+ \$4169 sky130_fd_sc_hd__or2_2
* cell instance sky130_fd_sc_hd__or2_2_3 r0 *1 0,0
Xsky130_fd_sc_hd__or2_2_3 \$1515 \$1773
+ vss
+ vdd
+ vdd
+ \$399 sky130_fd_sc_hd__or2_2
* cell instance sky130_fd_sc_hd__or2_2_4 r0 *1 0,0
Xsky130_fd_sc_hd__or2_2_4 \$3318 \$3319
+ vss
+ vdd
+ vdd
+ \$1752 sky130_fd_sc_hd__or2_2
* cell instance sky130_fd_sc_hd__or2_2_5 r0 *1 0,0
Xsky130_fd_sc_hd__or2_2_5 \$3960 \$4091
+ vss
+ vdd
+ vdd
+ \$4087 sky130_fd_sc_hd__or2_2
* cell instance sky130_fd_sc_hd__or2_2_6 r0 *1 0,0
Xsky130_fd_sc_hd__or2_2_6 \$2458 \$2680
+ vss
+ vdd
+ vdd
+ \$2687 sky130_fd_sc_hd__or2_2
* cell instance sky130_fd_sc_hd__or2_2_7 r0 *1 0,0
Xsky130_fd_sc_hd__or2_2_7 \$3111 \$2913
+ vss
+ vdd
+ vdd
+ \$3113 sky130_fd_sc_hd__or2_2
* cell instance sky130_fd_sc_hd__or2_2_8 r0 *1 0,0
Xsky130_fd_sc_hd__or2_2_8 \$2913 \$3335
+ vss
+ vdd
+ vdd
+ \$2805 sky130_fd_sc_hd__or2_2
* cell instance sky130_fd_sc_hd__or3_1_0 r0 *1 0,0
Xsky130_fd_sc_hd__or3_1_0 \$3138 \$3344 \$3036
+ vss
+ vdd
+ vdd
+ \$3272 sky130_fd_sc_hd__or3_1
* cell instance sky130_fd_sc_hd__or3_1_1 r0 *1 0,0
Xsky130_fd_sc_hd__or3_1_1 \$3271 \$3151 \$3152
+ vss
+ vdd
+ vdd
+ \$2944 sky130_fd_sc_hd__or3_1
* cell instance sky130_fd_sc_hd__or3_1_2 r0 *1 0,0
Xsky130_fd_sc_hd__or3_1_2 \$4255 \$4030 \$4033
+ vss
+ vdd
+ vdd
+ \$4031 sky130_fd_sc_hd__or3_1
* cell instance sky130_fd_sc_hd__or3_1_3 r0 *1 0,0
Xsky130_fd_sc_hd__or3_1_3 \$1548 \$3281 \$3684
+ vss
+ vdd
+ vdd
+ \$3584 sky130_fd_sc_hd__or3_1
* cell instance sky130_fd_sc_hd__or3_1_4 r0 *1 0,0
Xsky130_fd_sc_hd__or3_1_4 \$2202 \$3923 \$3972
+ vss
+ vdd
+ vdd
+ \$1548 sky130_fd_sc_hd__or3_1
* cell instance sky130_fd_sc_hd__or3_1_5 r0 *1 0,0
Xsky130_fd_sc_hd__or3_1_5 \$5763 \$5764 \$5324
+ vss
+ vdd
+ vdd
+ \$6084 sky130_fd_sc_hd__or3_1
* cell instance sky130_fd_sc_hd__or3_1_6 r0 *1 0,0
Xsky130_fd_sc_hd__or3_1_6 \$565 \$1061 \$563
+ vss
+ vdd
+ vdd
+ \$1059 sky130_fd_sc_hd__or3_1
* cell instance sky130_fd_sc_hd__or3_1_7 r0 *1 0,0
Xsky130_fd_sc_hd__or3_1_7 \$565 \$1406 \$563
+ vss
+ vdd
+ vdd
+ \$1466 sky130_fd_sc_hd__or3_1
* cell instance sky130_fd_sc_hd__or3_1_8 r0 *1 0,0
Xsky130_fd_sc_hd__or3_1_8 \$565 \$563 \$570
+ vss
+ vdd
+ vdd
+ \$626 sky130_fd_sc_hd__or3_1
* cell instance sky130_fd_sc_hd__or3_1_9 r0 *1 0,0
Xsky130_fd_sc_hd__or3_1_9 \$565 \$1061 \$580
+ vss
+ vdd
+ vdd
+ \$1142 sky130_fd_sc_hd__or3_1
* cell instance sky130_fd_sc_hd__or3_1_10 r0 *1 0,0
Xsky130_fd_sc_hd__or3_1_10 \$565 \$563 \$568
+ vss
+ vdd
+ vdd
+ \$566 sky130_fd_sc_hd__or3_1
* cell instance sky130_fd_sc_hd__or3_1_11 r0 *1 0,0
Xsky130_fd_sc_hd__or3_1_11 \$565 \$1406 \$580
+ vss
+ vdd
+ vdd
+ \$1408 sky130_fd_sc_hd__or3_1
* cell instance sky130_fd_sc_hd__or3_1_12 r0 *1 0,0
Xsky130_fd_sc_hd__or3_1_12 \$4169 \$219 \$4524
+ vss
+ vdd
+ vdd
+ \$4286 sky130_fd_sc_hd__or3_1
* cell instance sky130_fd_sc_hd__or3_1_13 r0 *1 0,0
Xsky130_fd_sc_hd__or3_1_13 \$565 \$570 \$580
+ vss
+ vdd
+ vdd
+ \$578 sky130_fd_sc_hd__or3_1
* cell instance sky130_fd_sc_hd__or3_1_14 r0 *1 0,0
Xsky130_fd_sc_hd__or3_1_14 \$565 \$563 \$874
+ vss
+ vdd
+ vdd
+ \$1369 sky130_fd_sc_hd__or3_1
* cell instance sky130_fd_sc_hd__or3_1_15 r0 *1 0,0
Xsky130_fd_sc_hd__or3_1_15 \$1150 \$1075 \$935
+ vss
+ vdd
+ vdd
+ \$1213 sky130_fd_sc_hd__or3_1
* cell instance sky130_fd_sc_hd__or3_1_16 r0 *1 0,0
Xsky130_fd_sc_hd__or3_1_16 \$1078 \$1311 \$1150
+ vss
+ vdd
+ vdd
+ \$1370 sky130_fd_sc_hd__or3_1
* cell instance sky130_fd_sc_hd__or3_1_17 r0 *1 0,0
Xsky130_fd_sc_hd__or3_1_17 \$2458 \$2682 \$2618
+ vss
+ vdd
+ vdd
+ \$2844 sky130_fd_sc_hd__or3_1
* cell instance sky130_fd_sc_hd__or3_1_18 r0 *1 0,0
Xsky130_fd_sc_hd__or3_1_18 bus_addr[0] bus_addr[1] \$3111
+ vss
+ vdd
+ vdd
+ \$3008 sky130_fd_sc_hd__or3_1
* cell instance sky130_fd_sc_hd__or3_1_19 r0 *1 0,0
Xsky130_fd_sc_hd__or3_1_19 bus_addr[3] bus_addr[2] \$2909
+ vss
+ vdd
+ vdd
+ \$3243 sky130_fd_sc_hd__or3_1
* cell instance sky130_fd_sc_hd__or3b_2_0 r0 *1 0,0
Xsky130_fd_sc_hd__or3b_2_0 \$716 \$717 \$718
+ vss
+ vdd
+ vdd
+ \$568 sky130_fd_sc_hd__or3b_2
* cell instance sky130_fd_sc_hd__or3b_2_1 r0 *1 0,0
Xsky130_fd_sc_hd__or3b_2_1 \$718 \$717 \$716
+ vss
+ vdd
+ vdd
+ \$874 sky130_fd_sc_hd__or3b_2
* cell instance sky130_fd_sc_hd__or3b_2_2 r0 *1 0,0
Xsky130_fd_sc_hd__or3b_2_2 \$1080 \$1311 \$1078
+ vss
+ vdd
+ vdd
+ \$1316 sky130_fd_sc_hd__or3b_2
* cell instance sky130_fd_sc_hd__or4_1_0 r0 *1 0,0
Xsky130_fd_sc_hd__or4_1_0 \$717 \$565 \$872 \$580
+ vss
+ vdd
+ vdd
+ \$793 sky130_fd_sc_hd__or4_1
* cell instance sky130_fd_sc_hd__or4b_2_0 r0 *1 0,0
Xsky130_fd_sc_hd__or4b_2_0 \$5522 \$5850 \$4932 \$5638
+ vss
+ vdd
+ vdd
+ \$5637 sky130_fd_sc_hd__or4b_2
* cell instance sky130_fd_sc_hd__tapvpwrvgnd_1_0 r0 *1 0,0
Xsky130_fd_sc_hd__tapvpwrvgnd_1_0
+ vss
+ vdd
+ sky130_fd_sc_hd__tapvpwrvgnd_1
* cell instance sky130_fd_sc_hd__tapvpwrvgnd_1_1 r0 *1 0,0
Xsky130_fd_sc_hd__tapvpwrvgnd_1_1
+ vss
+ vdd
+ sky130_fd_sc_hd__tapvpwrvgnd_1
* cell instance sky130_fd_sc_hd__tapvpwrvgnd_1_2 r0 *1 0,0
Xsky130_fd_sc_hd__tapvpwrvgnd_1_2
+ vss
+ vdd
+ sky130_fd_sc_hd__tapvpwrvgnd_1
* cell instance sky130_fd_sc_hd__tapvpwrvgnd_1_3 r0 *1 0,0
Xsky130_fd_sc_hd__tapvpwrvgnd_1_3
+ vss
+ vdd
+ sky130_fd_sc_hd__tapvpwrvgnd_1
* cell instance sky130_fd_sc_hd__tapvpwrvgnd_1_4 r0 *1 0,0
Xsky130_fd_sc_hd__tapvpwrvgnd_1_4
+ vss
+ vdd
+ sky130_fd_sc_hd__tapvpwrvgnd_1
* cell instance sky130_fd_sc_hd__tapvpwrvgnd_1_5 r0 *1 0,0
Xsky130_fd_sc_hd__tapvpwrvgnd_1_5
+ vss
+ vdd
+ sky130_fd_sc_hd__tapvpwrvgnd_1
* cell instance sky130_fd_sc_hd__tapvpwrvgnd_1_6 r0 *1 0,0
Xsky130_fd_sc_hd__tapvpwrvgnd_1_6
+ vss
+ vdd
+ sky130_fd_sc_hd__tapvpwrvgnd_1
* cell instance sky130_fd_sc_hd__tapvpwrvgnd_1_7 r0 *1 0,0
Xsky130_fd_sc_hd__tapvpwrvgnd_1_7
+ vss
+ vdd
+ sky130_fd_sc_hd__tapvpwrvgnd_1
* cell instance sky130_fd_sc_hd__tapvpwrvgnd_1_8 r0 *1 0,0
Xsky130_fd_sc_hd__tapvpwrvgnd_1_8
+ vss
+ vdd
+ sky130_fd_sc_hd__tapvpwrvgnd_1
* cell instance sky130_fd_sc_hd__tapvpwrvgnd_1_9 r0 *1 0,0
Xsky130_fd_sc_hd__tapvpwrvgnd_1_9
+ vss
+ vdd
+ sky130_fd_sc_hd__tapvpwrvgnd_1
* cell instance sky130_fd_sc_hd__tapvpwrvgnd_1_10 r0 *1 0,0
Xsky130_fd_sc_hd__tapvpwrvgnd_1_10
+ vss
+ vdd
+ sky130_fd_sc_hd__tapvpwrvgnd_1
* cell instance sky130_fd_sc_hd__tapvpwrvgnd_1_11 r0 *1 0,0
Xsky130_fd_sc_hd__tapvpwrvgnd_1_11
+ vss
+ vdd
+ sky130_fd_sc_hd__tapvpwrvgnd_1
* cell instance sky130_fd_sc_hd__tapvpwrvgnd_1_12 r0 *1 0,0
Xsky130_fd_sc_hd__tapvpwrvgnd_1_12
+ vss
+ vdd
+ sky130_fd_sc_hd__tapvpwrvgnd_1
* cell instance sky130_fd_sc_hd__tapvpwrvgnd_1_13 r0 *1 0,0
Xsky130_fd_sc_hd__tapvpwrvgnd_1_13
+ vss
+ vdd
+ sky130_fd_sc_hd__tapvpwrvgnd_1
* cell instance sky130_fd_sc_hd__tapvpwrvgnd_1_14 r0 *1 0,0
Xsky130_fd_sc_hd__tapvpwrvgnd_1_14
+ vss
+ vdd
+ sky130_fd_sc_hd__tapvpwrvgnd_1
* cell instance sky130_fd_sc_hd__tapvpwrvgnd_1_15 r0 *1 0,0
Xsky130_fd_sc_hd__tapvpwrvgnd_1_15
+ vss
+ vdd
+ sky130_fd_sc_hd__tapvpwrvgnd_1
* cell instance sky130_fd_sc_hd__tapvpwrvgnd_1_16 r0 *1 0,0
Xsky130_fd_sc_hd__tapvpwrvgnd_1_16
+ vss
+ vdd
+ sky130_fd_sc_hd__tapvpwrvgnd_1
* cell instance sky130_fd_sc_hd__tapvpwrvgnd_1_17 r0 *1 0,0
Xsky130_fd_sc_hd__tapvpwrvgnd_1_17
+ vss
+ vdd
+ sky130_fd_sc_hd__tapvpwrvgnd_1
* cell instance sky130_fd_sc_hd__tapvpwrvgnd_1_18 r0 *1 0,0
Xsky130_fd_sc_hd__tapvpwrvgnd_1_18
+ vss
+ vdd
+ sky130_fd_sc_hd__tapvpwrvgnd_1
* cell instance sky130_fd_sc_hd__tapvpwrvgnd_1_19 r0 *1 0,0
Xsky130_fd_sc_hd__tapvpwrvgnd_1_19
+ vss
+ vdd
+ sky130_fd_sc_hd__tapvpwrvgnd_1
* cell instance sky130_fd_sc_hd__tapvpwrvgnd_1_20 r0 *1 0,0
Xsky130_fd_sc_hd__tapvpwrvgnd_1_20
+ vss
+ vdd
+ sky130_fd_sc_hd__tapvpwrvgnd_1
* cell instance sky130_fd_sc_hd__tapvpwrvgnd_1_21 r0 *1 0,0
Xsky130_fd_sc_hd__tapvpwrvgnd_1_21
+ vss
+ vdd
+ sky130_fd_sc_hd__tapvpwrvgnd_1
* cell instance sky130_fd_sc_hd__tapvpwrvgnd_1_22 r0 *1 0,0
Xsky130_fd_sc_hd__tapvpwrvgnd_1_22
+ vss
+ vdd
+ sky130_fd_sc_hd__tapvpwrvgnd_1
* cell instance sky130_fd_sc_hd__tapvpwrvgnd_1_23 r0 *1 0,0
Xsky130_fd_sc_hd__tapvpwrvgnd_1_23
+ vss
+ vdd
+ sky130_fd_sc_hd__tapvpwrvgnd_1
* cell instance sky130_fd_sc_hd__tapvpwrvgnd_1_24 r0 *1 0,0
Xsky130_fd_sc_hd__tapvpwrvgnd_1_24
+ vss
+ vdd
+ sky130_fd_sc_hd__tapvpwrvgnd_1
* cell instance sky130_fd_sc_hd__tapvpwrvgnd_1_25 r0 *1 0,0
Xsky130_fd_sc_hd__tapvpwrvgnd_1_25
+ vss
+ vdd
+ sky130_fd_sc_hd__tapvpwrvgnd_1
* cell instance sky130_fd_sc_hd__tapvpwrvgnd_1_26 r0 *1 0,0
Xsky130_fd_sc_hd__tapvpwrvgnd_1_26
+ vss
+ vdd
+ sky130_fd_sc_hd__tapvpwrvgnd_1
* cell instance sky130_fd_sc_hd__tapvpwrvgnd_1_27 r0 *1 0,0
Xsky130_fd_sc_hd__tapvpwrvgnd_1_27
+ vss
+ vdd
+ sky130_fd_sc_hd__tapvpwrvgnd_1
* cell instance sky130_fd_sc_hd__tapvpwrvgnd_1_28 r0 *1 0,0
Xsky130_fd_sc_hd__tapvpwrvgnd_1_28
+ vss
+ vdd
+ sky130_fd_sc_hd__tapvpwrvgnd_1
* cell instance sky130_fd_sc_hd__tapvpwrvgnd_1_29 r0 *1 0,0
Xsky130_fd_sc_hd__tapvpwrvgnd_1_29
+ vss
+ vdd
+ sky130_fd_sc_hd__tapvpwrvgnd_1
* cell instance sky130_fd_sc_hd__tapvpwrvgnd_1_30 r0 *1 0,0
Xsky130_fd_sc_hd__tapvpwrvgnd_1_30
+ vss
+ vdd
+ sky130_fd_sc_hd__tapvpwrvgnd_1
* cell instance sky130_fd_sc_hd__tapvpwrvgnd_1_31 r0 *1 0,0
Xsky130_fd_sc_hd__tapvpwrvgnd_1_31
+ vss
+ vdd
+ sky130_fd_sc_hd__tapvpwrvgnd_1
* cell instance sky130_fd_sc_hd__tapvpwrvgnd_1_32 r0 *1 0,0
Xsky130_fd_sc_hd__tapvpwrvgnd_1_32
+ vss
+ vdd
+ sky130_fd_sc_hd__tapvpwrvgnd_1
* cell instance sky130_fd_sc_hd__tapvpwrvgnd_1_33 r0 *1 0,0
Xsky130_fd_sc_hd__tapvpwrvgnd_1_33
+ vss
+ vdd
+ sky130_fd_sc_hd__tapvpwrvgnd_1
* cell instance sky130_fd_sc_hd__tapvpwrvgnd_1_34 r0 *1 0,0
Xsky130_fd_sc_hd__tapvpwrvgnd_1_34
+ vss
+ vdd
+ sky130_fd_sc_hd__tapvpwrvgnd_1
* cell instance sky130_fd_sc_hd__tapvpwrvgnd_1_35 r0 *1 0,0
Xsky130_fd_sc_hd__tapvpwrvgnd_1_35
+ vss
+ vdd
+ sky130_fd_sc_hd__tapvpwrvgnd_1
* cell instance sky130_fd_sc_hd__tapvpwrvgnd_1_36 r0 *1 0,0
Xsky130_fd_sc_hd__tapvpwrvgnd_1_36
+ vss
+ vdd
+ sky130_fd_sc_hd__tapvpwrvgnd_1
* cell instance sky130_fd_sc_hd__tapvpwrvgnd_1_37 r0 *1 0,0
Xsky130_fd_sc_hd__tapvpwrvgnd_1_37
+ vss
+ vdd
+ sky130_fd_sc_hd__tapvpwrvgnd_1
* cell instance sky130_fd_sc_hd__tapvpwrvgnd_1_38 r0 *1 0,0
Xsky130_fd_sc_hd__tapvpwrvgnd_1_38
+ vss
+ vdd
+ sky130_fd_sc_hd__tapvpwrvgnd_1
* cell instance sky130_fd_sc_hd__tapvpwrvgnd_1_39 r0 *1 0,0
Xsky130_fd_sc_hd__tapvpwrvgnd_1_39
+ vss
+ vdd
+ sky130_fd_sc_hd__tapvpwrvgnd_1
* cell instance sky130_fd_sc_hd__tapvpwrvgnd_1_40 r0 *1 0,0
Xsky130_fd_sc_hd__tapvpwrvgnd_1_40
+ vss
+ vdd
+ sky130_fd_sc_hd__tapvpwrvgnd_1
* cell instance sky130_fd_sc_hd__tapvpwrvgnd_1_41 r0 *1 0,0
Xsky130_fd_sc_hd__tapvpwrvgnd_1_41
+ vss
+ vdd
+ sky130_fd_sc_hd__tapvpwrvgnd_1
* cell instance sky130_fd_sc_hd__tapvpwrvgnd_1_42 r0 *1 0,0
Xsky130_fd_sc_hd__tapvpwrvgnd_1_42
+ vss
+ vdd
+ sky130_fd_sc_hd__tapvpwrvgnd_1
* cell instance sky130_fd_sc_hd__tapvpwrvgnd_1_43 r0 *1 0,0
Xsky130_fd_sc_hd__tapvpwrvgnd_1_43
+ vss
+ vdd
+ sky130_fd_sc_hd__tapvpwrvgnd_1
* cell instance sky130_fd_sc_hd__tapvpwrvgnd_1_44 r0 *1 0,0
Xsky130_fd_sc_hd__tapvpwrvgnd_1_44
+ vss
+ vdd
+ sky130_fd_sc_hd__tapvpwrvgnd_1
* cell instance sky130_fd_sc_hd__tapvpwrvgnd_1_45 r0 *1 0,0
Xsky130_fd_sc_hd__tapvpwrvgnd_1_45
+ vss
+ vdd
+ sky130_fd_sc_hd__tapvpwrvgnd_1
* cell instance sky130_fd_sc_hd__tapvpwrvgnd_1_46 r0 *1 0,0
Xsky130_fd_sc_hd__tapvpwrvgnd_1_46
+ vss
+ vdd
+ sky130_fd_sc_hd__tapvpwrvgnd_1
* cell instance sky130_fd_sc_hd__tapvpwrvgnd_1_47 r0 *1 0,0
Xsky130_fd_sc_hd__tapvpwrvgnd_1_47
+ vss
+ vdd
+ sky130_fd_sc_hd__tapvpwrvgnd_1
* cell instance sky130_fd_sc_hd__tapvpwrvgnd_1_48 r0 *1 0,0
Xsky130_fd_sc_hd__tapvpwrvgnd_1_48
+ vss
+ vdd
+ sky130_fd_sc_hd__tapvpwrvgnd_1
* cell instance sky130_fd_sc_hd__tapvpwrvgnd_1_49 r0 *1 0,0
Xsky130_fd_sc_hd__tapvpwrvgnd_1_49
+ vss
+ vdd
+ sky130_fd_sc_hd__tapvpwrvgnd_1
* cell instance sky130_fd_sc_hd__tapvpwrvgnd_1_50 r0 *1 0,0
Xsky130_fd_sc_hd__tapvpwrvgnd_1_50
+ vss
+ vdd
+ sky130_fd_sc_hd__tapvpwrvgnd_1
* cell instance sky130_fd_sc_hd__tapvpwrvgnd_1_51 r0 *1 0,0
Xsky130_fd_sc_hd__tapvpwrvgnd_1_51
+ vss
+ vdd
+ sky130_fd_sc_hd__tapvpwrvgnd_1
* cell instance sky130_fd_sc_hd__tapvpwrvgnd_1_52 r0 *1 0,0
Xsky130_fd_sc_hd__tapvpwrvgnd_1_52
+ vss
+ vdd
+ sky130_fd_sc_hd__tapvpwrvgnd_1
* cell instance sky130_fd_sc_hd__tapvpwrvgnd_1_53 r0 *1 0,0
Xsky130_fd_sc_hd__tapvpwrvgnd_1_53
+ vss
+ vdd
+ sky130_fd_sc_hd__tapvpwrvgnd_1
* cell instance sky130_fd_sc_hd__tapvpwrvgnd_1_54 r0 *1 0,0
Xsky130_fd_sc_hd__tapvpwrvgnd_1_54
+ vss
+ vdd
+ sky130_fd_sc_hd__tapvpwrvgnd_1
* cell instance sky130_fd_sc_hd__tapvpwrvgnd_1_55 r0 *1 0,0
Xsky130_fd_sc_hd__tapvpwrvgnd_1_55
+ vss
+ vdd
+ sky130_fd_sc_hd__tapvpwrvgnd_1
* cell instance sky130_fd_sc_hd__tapvpwrvgnd_1_56 r0 *1 0,0
Xsky130_fd_sc_hd__tapvpwrvgnd_1_56
+ vss
+ vdd
+ sky130_fd_sc_hd__tapvpwrvgnd_1
* cell instance sky130_fd_sc_hd__tapvpwrvgnd_1_57 r0 *1 0,0
Xsky130_fd_sc_hd__tapvpwrvgnd_1_57
+ vss
+ vdd
+ sky130_fd_sc_hd__tapvpwrvgnd_1
* cell instance sky130_fd_sc_hd__tapvpwrvgnd_1_58 r0 *1 0,0
Xsky130_fd_sc_hd__tapvpwrvgnd_1_58
+ vss
+ vdd
+ sky130_fd_sc_hd__tapvpwrvgnd_1
* cell instance sky130_fd_sc_hd__tapvpwrvgnd_1_59 r0 *1 0,0
Xsky130_fd_sc_hd__tapvpwrvgnd_1_59
+ vss
+ vdd
+ sky130_fd_sc_hd__tapvpwrvgnd_1
* cell instance sky130_fd_sc_hd__tapvpwrvgnd_1_60 r0 *1 0,0
Xsky130_fd_sc_hd__tapvpwrvgnd_1_60
+ vss
+ vdd
+ sky130_fd_sc_hd__tapvpwrvgnd_1
* cell instance sky130_fd_sc_hd__tapvpwrvgnd_1_61 r0 *1 0,0
Xsky130_fd_sc_hd__tapvpwrvgnd_1_61
+ vss
+ vdd
+ sky130_fd_sc_hd__tapvpwrvgnd_1
* cell instance sky130_fd_sc_hd__tapvpwrvgnd_1_62 r0 *1 0,0
Xsky130_fd_sc_hd__tapvpwrvgnd_1_62
+ vss
+ vdd
+ sky130_fd_sc_hd__tapvpwrvgnd_1
* cell instance sky130_fd_sc_hd__tapvpwrvgnd_1_63 r0 *1 0,0
Xsky130_fd_sc_hd__tapvpwrvgnd_1_63
+ vss
+ vdd
+ sky130_fd_sc_hd__tapvpwrvgnd_1
* cell instance sky130_fd_sc_hd__tapvpwrvgnd_1_64 r0 *1 0,0
Xsky130_fd_sc_hd__tapvpwrvgnd_1_64
+ vss
+ vdd
+ sky130_fd_sc_hd__tapvpwrvgnd_1
* cell instance sky130_fd_sc_hd__tapvpwrvgnd_1_65 r0 *1 0,0
Xsky130_fd_sc_hd__tapvpwrvgnd_1_65
+ vss
+ vdd
+ sky130_fd_sc_hd__tapvpwrvgnd_1
* cell instance sky130_fd_sc_hd__tapvpwrvgnd_1_66 r0 *1 0,0
Xsky130_fd_sc_hd__tapvpwrvgnd_1_66
+ vss
+ vdd
+ sky130_fd_sc_hd__tapvpwrvgnd_1
* cell instance sky130_fd_sc_hd__tapvpwrvgnd_1_67 r0 *1 0,0
Xsky130_fd_sc_hd__tapvpwrvgnd_1_67
+ vss
+ vdd
+ sky130_fd_sc_hd__tapvpwrvgnd_1
* cell instance sky130_fd_sc_hd__tapvpwrvgnd_1_68 r0 *1 0,0
Xsky130_fd_sc_hd__tapvpwrvgnd_1_68
+ vss
+ vdd
+ sky130_fd_sc_hd__tapvpwrvgnd_1
* cell instance sky130_fd_sc_hd__tapvpwrvgnd_1_69 r0 *1 0,0
Xsky130_fd_sc_hd__tapvpwrvgnd_1_69
+ vss
+ vdd
+ sky130_fd_sc_hd__tapvpwrvgnd_1
* cell instance sky130_fd_sc_hd__tapvpwrvgnd_1_70 r0 *1 0,0
Xsky130_fd_sc_hd__tapvpwrvgnd_1_70
+ vss
+ vdd
+ sky130_fd_sc_hd__tapvpwrvgnd_1
* cell instance sky130_fd_sc_hd__tapvpwrvgnd_1_71 r0 *1 0,0
Xsky130_fd_sc_hd__tapvpwrvgnd_1_71
+ vss
+ vdd
+ sky130_fd_sc_hd__tapvpwrvgnd_1
* cell instance sky130_fd_sc_hd__tapvpwrvgnd_1_72 r0 *1 0,0
Xsky130_fd_sc_hd__tapvpwrvgnd_1_72
+ vss
+ vdd
+ sky130_fd_sc_hd__tapvpwrvgnd_1
* cell instance sky130_fd_sc_hd__tapvpwrvgnd_1_73 r0 *1 0,0
Xsky130_fd_sc_hd__tapvpwrvgnd_1_73
+ vss
+ vdd
+ sky130_fd_sc_hd__tapvpwrvgnd_1
* cell instance sky130_fd_sc_hd__tapvpwrvgnd_1_74 r0 *1 0,0
Xsky130_fd_sc_hd__tapvpwrvgnd_1_74
+ vss
+ vdd
+ sky130_fd_sc_hd__tapvpwrvgnd_1
* cell instance sky130_fd_sc_hd__tapvpwrvgnd_1_75 r0 *1 0,0
Xsky130_fd_sc_hd__tapvpwrvgnd_1_75
+ vss
+ vdd
+ sky130_fd_sc_hd__tapvpwrvgnd_1
* cell instance sky130_fd_sc_hd__tapvpwrvgnd_1_76 r0 *1 0,0
Xsky130_fd_sc_hd__tapvpwrvgnd_1_76
+ vss
+ vdd
+ sky130_fd_sc_hd__tapvpwrvgnd_1
* cell instance sky130_fd_sc_hd__tapvpwrvgnd_1_77 r0 *1 0,0
Xsky130_fd_sc_hd__tapvpwrvgnd_1_77
+ vss
+ vdd
+ sky130_fd_sc_hd__tapvpwrvgnd_1
* cell instance sky130_fd_sc_hd__tapvpwrvgnd_1_78 r0 *1 0,0
Xsky130_fd_sc_hd__tapvpwrvgnd_1_78
+ vss
+ vdd
+ sky130_fd_sc_hd__tapvpwrvgnd_1
* cell instance sky130_fd_sc_hd__tapvpwrvgnd_1_79 r0 *1 0,0
Xsky130_fd_sc_hd__tapvpwrvgnd_1_79
+ vss
+ vdd
+ sky130_fd_sc_hd__tapvpwrvgnd_1
* cell instance sky130_fd_sc_hd__tapvpwrvgnd_1_80 r0 *1 0,0
Xsky130_fd_sc_hd__tapvpwrvgnd_1_80
+ vss
+ vdd
+ sky130_fd_sc_hd__tapvpwrvgnd_1
* cell instance sky130_fd_sc_hd__tapvpwrvgnd_1_81 r0 *1 0,0
Xsky130_fd_sc_hd__tapvpwrvgnd_1_81
+ vss
+ vdd
+ sky130_fd_sc_hd__tapvpwrvgnd_1
* cell instance sky130_fd_sc_hd__tapvpwrvgnd_1_82 r0 *1 0,0
Xsky130_fd_sc_hd__tapvpwrvgnd_1_82
+ vss
+ vdd
+ sky130_fd_sc_hd__tapvpwrvgnd_1
* cell instance sky130_fd_sc_hd__tapvpwrvgnd_1_83 r0 *1 0,0
Xsky130_fd_sc_hd__tapvpwrvgnd_1_83
+ vss
+ vdd
+ sky130_fd_sc_hd__tapvpwrvgnd_1
* cell instance sky130_fd_sc_hd__tapvpwrvgnd_1_84 r0 *1 0,0
Xsky130_fd_sc_hd__tapvpwrvgnd_1_84
+ vss
+ vdd
+ sky130_fd_sc_hd__tapvpwrvgnd_1
* cell instance sky130_fd_sc_hd__tapvpwrvgnd_1_85 r0 *1 0,0
Xsky130_fd_sc_hd__tapvpwrvgnd_1_85
+ vss
+ vdd
+ sky130_fd_sc_hd__tapvpwrvgnd_1
* cell instance sky130_fd_sc_hd__tapvpwrvgnd_1_86 r0 *1 0,0
Xsky130_fd_sc_hd__tapvpwrvgnd_1_86
+ vss
+ vdd
+ sky130_fd_sc_hd__tapvpwrvgnd_1
* cell instance sky130_fd_sc_hd__tapvpwrvgnd_1_87 r0 *1 0,0
Xsky130_fd_sc_hd__tapvpwrvgnd_1_87
+ vss
+ vdd
+ sky130_fd_sc_hd__tapvpwrvgnd_1
* cell instance sky130_fd_sc_hd__tapvpwrvgnd_1_88 r0 *1 0,0
Xsky130_fd_sc_hd__tapvpwrvgnd_1_88
+ vss
+ vdd
+ sky130_fd_sc_hd__tapvpwrvgnd_1
* cell instance sky130_fd_sc_hd__tapvpwrvgnd_1_89 r0 *1 0,0
Xsky130_fd_sc_hd__tapvpwrvgnd_1_89
+ vss
+ vdd
+ sky130_fd_sc_hd__tapvpwrvgnd_1
* cell instance sky130_fd_sc_hd__tapvpwrvgnd_1_90 r0 *1 0,0
Xsky130_fd_sc_hd__tapvpwrvgnd_1_90
+ vss
+ vdd
+ sky130_fd_sc_hd__tapvpwrvgnd_1
* cell instance sky130_fd_sc_hd__tapvpwrvgnd_1_91 r0 *1 0,0
Xsky130_fd_sc_hd__tapvpwrvgnd_1_91
+ vss
+ vdd
+ sky130_fd_sc_hd__tapvpwrvgnd_1
* cell instance sky130_fd_sc_hd__tapvpwrvgnd_1_92 r0 *1 0,0
Xsky130_fd_sc_hd__tapvpwrvgnd_1_92
+ vss
+ vdd
+ sky130_fd_sc_hd__tapvpwrvgnd_1
* cell instance sky130_fd_sc_hd__tapvpwrvgnd_1_93 r0 *1 0,0
Xsky130_fd_sc_hd__tapvpwrvgnd_1_93
+ vss
+ vdd
+ sky130_fd_sc_hd__tapvpwrvgnd_1
* cell instance sky130_fd_sc_hd__tapvpwrvgnd_1_94 r0 *1 0,0
Xsky130_fd_sc_hd__tapvpwrvgnd_1_94
+ vss
+ vdd
+ sky130_fd_sc_hd__tapvpwrvgnd_1
* cell instance sky130_fd_sc_hd__tapvpwrvgnd_1_95 r0 *1 0,0
Xsky130_fd_sc_hd__tapvpwrvgnd_1_95
+ vss
+ vdd
+ sky130_fd_sc_hd__tapvpwrvgnd_1
* cell instance sky130_fd_sc_hd__tapvpwrvgnd_1_96 r0 *1 0,0
Xsky130_fd_sc_hd__tapvpwrvgnd_1_96
+ vss
+ vdd
+ sky130_fd_sc_hd__tapvpwrvgnd_1
* cell instance sky130_fd_sc_hd__tapvpwrvgnd_1_97 r0 *1 0,0
Xsky130_fd_sc_hd__tapvpwrvgnd_1_97
+ vss
+ vdd
+ sky130_fd_sc_hd__tapvpwrvgnd_1
* cell instance sky130_fd_sc_hd__tapvpwrvgnd_1_98 r0 *1 0,0
Xsky130_fd_sc_hd__tapvpwrvgnd_1_98
+ vss
+ vdd
+ sky130_fd_sc_hd__tapvpwrvgnd_1
* cell instance sky130_fd_sc_hd__tapvpwrvgnd_1_99 r0 *1 0,0
Xsky130_fd_sc_hd__tapvpwrvgnd_1_99
+ vss
+ vdd
+ sky130_fd_sc_hd__tapvpwrvgnd_1
* cell instance sky130_fd_sc_hd__tapvpwrvgnd_1_100 r0 *1 0,0
Xsky130_fd_sc_hd__tapvpwrvgnd_1_100
+ vss
+ vdd
+ sky130_fd_sc_hd__tapvpwrvgnd_1
* cell instance sky130_fd_sc_hd__tapvpwrvgnd_1_101 r0 *1 0,0
Xsky130_fd_sc_hd__tapvpwrvgnd_1_101
+ vss
+ vdd
+ sky130_fd_sc_hd__tapvpwrvgnd_1
* cell instance sky130_fd_sc_hd__tapvpwrvgnd_1_102 r0 *1 0,0
Xsky130_fd_sc_hd__tapvpwrvgnd_1_102
+ vss
+ vdd
+ sky130_fd_sc_hd__tapvpwrvgnd_1
* cell instance sky130_fd_sc_hd__tapvpwrvgnd_1_103 r0 *1 0,0
Xsky130_fd_sc_hd__tapvpwrvgnd_1_103
+ vss
+ vdd
+ sky130_fd_sc_hd__tapvpwrvgnd_1
* cell instance sky130_fd_sc_hd__tapvpwrvgnd_1_104 r0 *1 0,0
Xsky130_fd_sc_hd__tapvpwrvgnd_1_104
+ vss
+ vdd
+ sky130_fd_sc_hd__tapvpwrvgnd_1
* cell instance sky130_fd_sc_hd__tapvpwrvgnd_1_105 r0 *1 0,0
Xsky130_fd_sc_hd__tapvpwrvgnd_1_105
+ vss
+ vdd
+ sky130_fd_sc_hd__tapvpwrvgnd_1
* cell instance sky130_fd_sc_hd__tapvpwrvgnd_1_106 r0 *1 0,0
Xsky130_fd_sc_hd__tapvpwrvgnd_1_106
+ vss
+ vdd
+ sky130_fd_sc_hd__tapvpwrvgnd_1
* cell instance sky130_fd_sc_hd__tapvpwrvgnd_1_107 r0 *1 0,0
Xsky130_fd_sc_hd__tapvpwrvgnd_1_107
+ vss
+ vdd
+ sky130_fd_sc_hd__tapvpwrvgnd_1
* cell instance sky130_fd_sc_hd__tapvpwrvgnd_1_108 r0 *1 0,0
Xsky130_fd_sc_hd__tapvpwrvgnd_1_108
+ vss
+ vdd
+ sky130_fd_sc_hd__tapvpwrvgnd_1
* cell instance sky130_fd_sc_hd__tapvpwrvgnd_1_109 r0 *1 0,0
Xsky130_fd_sc_hd__tapvpwrvgnd_1_109
+ vss
+ vdd
+ sky130_fd_sc_hd__tapvpwrvgnd_1
* cell instance sky130_fd_sc_hd__tapvpwrvgnd_1_110 r0 *1 0,0
Xsky130_fd_sc_hd__tapvpwrvgnd_1_110
+ vss
+ vdd
+ sky130_fd_sc_hd__tapvpwrvgnd_1
* cell instance sky130_fd_sc_hd__tapvpwrvgnd_1_111 r0 *1 0,0
Xsky130_fd_sc_hd__tapvpwrvgnd_1_111
+ vss
+ vdd
+ sky130_fd_sc_hd__tapvpwrvgnd_1
* cell instance sky130_fd_sc_hd__tapvpwrvgnd_1_112 r0 *1 0,0
Xsky130_fd_sc_hd__tapvpwrvgnd_1_112
+ vss
+ vdd
+ sky130_fd_sc_hd__tapvpwrvgnd_1
* cell instance sky130_fd_sc_hd__tapvpwrvgnd_1_113 r0 *1 0,0
Xsky130_fd_sc_hd__tapvpwrvgnd_1_113
+ vss
+ vdd
+ sky130_fd_sc_hd__tapvpwrvgnd_1
* cell instance sky130_fd_sc_hd__tapvpwrvgnd_1_114 r0 *1 0,0
Xsky130_fd_sc_hd__tapvpwrvgnd_1_114
+ vss
+ vdd
+ sky130_fd_sc_hd__tapvpwrvgnd_1
* cell instance sky130_fd_sc_hd__tapvpwrvgnd_1_115 r0 *1 0,0
Xsky130_fd_sc_hd__tapvpwrvgnd_1_115
+ vss
+ vdd
+ sky130_fd_sc_hd__tapvpwrvgnd_1
* cell instance sky130_fd_sc_hd__tapvpwrvgnd_1_116 r0 *1 0,0
Xsky130_fd_sc_hd__tapvpwrvgnd_1_116
+ vss
+ vdd
+ sky130_fd_sc_hd__tapvpwrvgnd_1
* cell instance sky130_fd_sc_hd__tapvpwrvgnd_1_117 r0 *1 0,0
Xsky130_fd_sc_hd__tapvpwrvgnd_1_117
+ vss
+ vdd
+ sky130_fd_sc_hd__tapvpwrvgnd_1
* cell instance sky130_fd_sc_hd__tapvpwrvgnd_1_118 r0 *1 0,0
Xsky130_fd_sc_hd__tapvpwrvgnd_1_118
+ vss
+ vdd
+ sky130_fd_sc_hd__tapvpwrvgnd_1
* cell instance sky130_fd_sc_hd__tapvpwrvgnd_1_119 r0 *1 0,0
Xsky130_fd_sc_hd__tapvpwrvgnd_1_119
+ vss
+ vdd
+ sky130_fd_sc_hd__tapvpwrvgnd_1
* cell instance sky130_fd_sc_hd__tapvpwrvgnd_1_120 r0 *1 0,0
Xsky130_fd_sc_hd__tapvpwrvgnd_1_120
+ vss
+ vdd
+ sky130_fd_sc_hd__tapvpwrvgnd_1
* cell instance sky130_fd_sc_hd__tapvpwrvgnd_1_121 r0 *1 0,0
Xsky130_fd_sc_hd__tapvpwrvgnd_1_121
+ vss
+ vdd
+ sky130_fd_sc_hd__tapvpwrvgnd_1
* cell instance sky130_fd_sc_hd__tapvpwrvgnd_1_122 r0 *1 0,0
Xsky130_fd_sc_hd__tapvpwrvgnd_1_122
+ vss
+ vdd
+ sky130_fd_sc_hd__tapvpwrvgnd_1
* cell instance sky130_fd_sc_hd__tapvpwrvgnd_1_123 r0 *1 0,0
Xsky130_fd_sc_hd__tapvpwrvgnd_1_123
+ vss
+ vdd
+ sky130_fd_sc_hd__tapvpwrvgnd_1
* cell instance sky130_fd_sc_hd__tapvpwrvgnd_1_124 r0 *1 0,0
Xsky130_fd_sc_hd__tapvpwrvgnd_1_124
+ vss
+ vdd
+ sky130_fd_sc_hd__tapvpwrvgnd_1
* cell instance sky130_fd_sc_hd__tapvpwrvgnd_1_125 r0 *1 0,0
Xsky130_fd_sc_hd__tapvpwrvgnd_1_125
+ vss
+ vdd
+ sky130_fd_sc_hd__tapvpwrvgnd_1
* cell instance sky130_fd_sc_hd__tapvpwrvgnd_1_126 r0 *1 0,0
Xsky130_fd_sc_hd__tapvpwrvgnd_1_126
+ vss
+ vdd
+ sky130_fd_sc_hd__tapvpwrvgnd_1
* cell instance sky130_fd_sc_hd__tapvpwrvgnd_1_127 r0 *1 0,0
Xsky130_fd_sc_hd__tapvpwrvgnd_1_127
+ vss
+ vdd
+ sky130_fd_sc_hd__tapvpwrvgnd_1
* cell instance sky130_fd_sc_hd__tapvpwrvgnd_1_128 r0 *1 0,0
Xsky130_fd_sc_hd__tapvpwrvgnd_1_128
+ vss
+ vdd
+ sky130_fd_sc_hd__tapvpwrvgnd_1
* cell instance sky130_fd_sc_hd__tapvpwrvgnd_1_129 r0 *1 0,0
Xsky130_fd_sc_hd__tapvpwrvgnd_1_129
+ vss
+ vdd
+ sky130_fd_sc_hd__tapvpwrvgnd_1
* cell instance sky130_fd_sc_hd__tapvpwrvgnd_1_130 r0 *1 0,0
Xsky130_fd_sc_hd__tapvpwrvgnd_1_130
+ vss
+ vdd
+ sky130_fd_sc_hd__tapvpwrvgnd_1
* cell instance sky130_fd_sc_hd__tapvpwrvgnd_1_131 r0 *1 0,0
Xsky130_fd_sc_hd__tapvpwrvgnd_1_131
+ vss
+ vdd
+ sky130_fd_sc_hd__tapvpwrvgnd_1
* cell instance sky130_fd_sc_hd__tapvpwrvgnd_1_132 r0 *1 0,0
Xsky130_fd_sc_hd__tapvpwrvgnd_1_132
+ vss
+ vdd
+ sky130_fd_sc_hd__tapvpwrvgnd_1
* cell instance sky130_fd_sc_hd__tapvpwrvgnd_1_133 r0 *1 0,0
Xsky130_fd_sc_hd__tapvpwrvgnd_1_133
+ vss
+ vdd
+ sky130_fd_sc_hd__tapvpwrvgnd_1
* cell instance sky130_fd_sc_hd__tapvpwrvgnd_1_134 r0 *1 0,0
Xsky130_fd_sc_hd__tapvpwrvgnd_1_134
+ vss
+ vdd
+ sky130_fd_sc_hd__tapvpwrvgnd_1
* cell instance sky130_fd_sc_hd__tapvpwrvgnd_1_135 r0 *1 0,0
Xsky130_fd_sc_hd__tapvpwrvgnd_1_135
+ vss
+ vdd
+ sky130_fd_sc_hd__tapvpwrvgnd_1
* cell instance sky130_fd_sc_hd__tapvpwrvgnd_1_136 r0 *1 0,0
Xsky130_fd_sc_hd__tapvpwrvgnd_1_136
+ vss
+ vdd
+ sky130_fd_sc_hd__tapvpwrvgnd_1
* cell instance sky130_fd_sc_hd__tapvpwrvgnd_1_137 r0 *1 0,0
Xsky130_fd_sc_hd__tapvpwrvgnd_1_137
+ vss
+ vdd
+ sky130_fd_sc_hd__tapvpwrvgnd_1
* cell instance sky130_fd_sc_hd__tapvpwrvgnd_1_138 r0 *1 0,0
Xsky130_fd_sc_hd__tapvpwrvgnd_1_138
+ vss
+ vdd
+ sky130_fd_sc_hd__tapvpwrvgnd_1
* cell instance sky130_fd_sc_hd__tapvpwrvgnd_1_139 r0 *1 0,0
Xsky130_fd_sc_hd__tapvpwrvgnd_1_139
+ vss
+ vdd
+ sky130_fd_sc_hd__tapvpwrvgnd_1
* cell instance sky130_fd_sc_hd__tapvpwrvgnd_1_140 r0 *1 0,0
Xsky130_fd_sc_hd__tapvpwrvgnd_1_140
+ vss
+ vdd
+ sky130_fd_sc_hd__tapvpwrvgnd_1
* cell instance sky130_fd_sc_hd__tapvpwrvgnd_1_141 r0 *1 0,0
Xsky130_fd_sc_hd__tapvpwrvgnd_1_141
+ vss
+ vdd
+ sky130_fd_sc_hd__tapvpwrvgnd_1
* cell instance sky130_fd_sc_hd__tapvpwrvgnd_1_142 r0 *1 0,0
Xsky130_fd_sc_hd__tapvpwrvgnd_1_142
+ vss
+ vdd
+ sky130_fd_sc_hd__tapvpwrvgnd_1
* cell instance sky130_fd_sc_hd__tapvpwrvgnd_1_143 r0 *1 0,0
Xsky130_fd_sc_hd__tapvpwrvgnd_1_143
+ vss
+ vdd
+ sky130_fd_sc_hd__tapvpwrvgnd_1
* cell instance sky130_fd_sc_hd__tapvpwrvgnd_1_144 r0 *1 0,0
Xsky130_fd_sc_hd__tapvpwrvgnd_1_144
+ vss
+ vdd
+ sky130_fd_sc_hd__tapvpwrvgnd_1
* cell instance sky130_fd_sc_hd__tapvpwrvgnd_1_145 r0 *1 0,0
Xsky130_fd_sc_hd__tapvpwrvgnd_1_145
+ vss
+ vdd
+ sky130_fd_sc_hd__tapvpwrvgnd_1
* cell instance sky130_fd_sc_hd__tapvpwrvgnd_1_146 r0 *1 0,0
Xsky130_fd_sc_hd__tapvpwrvgnd_1_146
+ vss
+ vdd
+ sky130_fd_sc_hd__tapvpwrvgnd_1
* cell instance sky130_fd_sc_hd__tapvpwrvgnd_1_147 r0 *1 0,0
Xsky130_fd_sc_hd__tapvpwrvgnd_1_147
+ vss
+ vdd
+ sky130_fd_sc_hd__tapvpwrvgnd_1
* cell instance sky130_fd_sc_hd__tapvpwrvgnd_1_148 r0 *1 0,0
Xsky130_fd_sc_hd__tapvpwrvgnd_1_148
+ vss
+ vdd
+ sky130_fd_sc_hd__tapvpwrvgnd_1
* cell instance sky130_fd_sc_hd__tapvpwrvgnd_1_149 r0 *1 0,0
Xsky130_fd_sc_hd__tapvpwrvgnd_1_149
+ vss
+ vdd
+ sky130_fd_sc_hd__tapvpwrvgnd_1
* cell instance sky130_fd_sc_hd__tapvpwrvgnd_1_150 r0 *1 0,0
Xsky130_fd_sc_hd__tapvpwrvgnd_1_150
+ vss
+ vdd
+ sky130_fd_sc_hd__tapvpwrvgnd_1
* cell instance sky130_fd_sc_hd__tapvpwrvgnd_1_151 r0 *1 0,0
Xsky130_fd_sc_hd__tapvpwrvgnd_1_151
+ vss
+ vdd
+ sky130_fd_sc_hd__tapvpwrvgnd_1
* cell instance sky130_fd_sc_hd__tapvpwrvgnd_1_152 r0 *1 0,0
Xsky130_fd_sc_hd__tapvpwrvgnd_1_152
+ vss
+ vdd
+ sky130_fd_sc_hd__tapvpwrvgnd_1
* cell instance sky130_fd_sc_hd__tapvpwrvgnd_1_153 r0 *1 0,0
Xsky130_fd_sc_hd__tapvpwrvgnd_1_153
+ vss
+ vdd
+ sky130_fd_sc_hd__tapvpwrvgnd_1
* cell instance sky130_fd_sc_hd__tapvpwrvgnd_1_154 r0 *1 0,0
Xsky130_fd_sc_hd__tapvpwrvgnd_1_154
+ vss
+ vdd
+ sky130_fd_sc_hd__tapvpwrvgnd_1
* cell instance sky130_fd_sc_hd__tapvpwrvgnd_1_155 r0 *1 0,0
Xsky130_fd_sc_hd__tapvpwrvgnd_1_155
+ vss
+ vdd
+ sky130_fd_sc_hd__tapvpwrvgnd_1
* cell instance sky130_fd_sc_hd__tapvpwrvgnd_1_156 r0 *1 0,0
Xsky130_fd_sc_hd__tapvpwrvgnd_1_156
+ vss
+ vdd
+ sky130_fd_sc_hd__tapvpwrvgnd_1
* cell instance sky130_fd_sc_hd__tapvpwrvgnd_1_157 r0 *1 0,0
Xsky130_fd_sc_hd__tapvpwrvgnd_1_157
+ vss
+ vdd
+ sky130_fd_sc_hd__tapvpwrvgnd_1
* cell instance sky130_fd_sc_hd__tapvpwrvgnd_1_158 r0 *1 0,0
Xsky130_fd_sc_hd__tapvpwrvgnd_1_158
+ vss
+ vdd
+ sky130_fd_sc_hd__tapvpwrvgnd_1
* cell instance sky130_fd_sc_hd__tapvpwrvgnd_1_159 r0 *1 0,0
Xsky130_fd_sc_hd__tapvpwrvgnd_1_159
+ vss
+ vdd
+ sky130_fd_sc_hd__tapvpwrvgnd_1
* cell instance sky130_fd_sc_hd__tapvpwrvgnd_1_160 r0 *1 0,0
Xsky130_fd_sc_hd__tapvpwrvgnd_1_160
+ vss
+ vdd
+ sky130_fd_sc_hd__tapvpwrvgnd_1
* cell instance sky130_fd_sc_hd__tapvpwrvgnd_1_161 r0 *1 0,0
Xsky130_fd_sc_hd__tapvpwrvgnd_1_161
+ vss
+ vdd
+ sky130_fd_sc_hd__tapvpwrvgnd_1
* cell instance sky130_fd_sc_hd__tapvpwrvgnd_1_162 r0 *1 0,0
Xsky130_fd_sc_hd__tapvpwrvgnd_1_162
+ vss
+ vdd
+ sky130_fd_sc_hd__tapvpwrvgnd_1
* cell instance sky130_fd_sc_hd__tapvpwrvgnd_1_163 r0 *1 0,0
Xsky130_fd_sc_hd__tapvpwrvgnd_1_163
+ vss
+ vdd
+ sky130_fd_sc_hd__tapvpwrvgnd_1
* cell instance sky130_fd_sc_hd__tapvpwrvgnd_1_164 r0 *1 0,0
Xsky130_fd_sc_hd__tapvpwrvgnd_1_164
+ vss
+ vdd
+ sky130_fd_sc_hd__tapvpwrvgnd_1
* cell instance sky130_fd_sc_hd__tapvpwrvgnd_1_165 r0 *1 0,0
Xsky130_fd_sc_hd__tapvpwrvgnd_1_165
+ vss
+ vdd
+ sky130_fd_sc_hd__tapvpwrvgnd_1
* cell instance sky130_fd_sc_hd__tapvpwrvgnd_1_166 r0 *1 0,0
Xsky130_fd_sc_hd__tapvpwrvgnd_1_166
+ vss
+ vdd
+ sky130_fd_sc_hd__tapvpwrvgnd_1
* cell instance sky130_fd_sc_hd__tapvpwrvgnd_1_167 r0 *1 0,0
Xsky130_fd_sc_hd__tapvpwrvgnd_1_167
+ vss
+ vdd
+ sky130_fd_sc_hd__tapvpwrvgnd_1
* cell instance sky130_fd_sc_hd__tapvpwrvgnd_1_168 r0 *1 0,0
Xsky130_fd_sc_hd__tapvpwrvgnd_1_168
+ vss
+ vdd
+ sky130_fd_sc_hd__tapvpwrvgnd_1
* cell instance sky130_fd_sc_hd__tapvpwrvgnd_1_169 r0 *1 0,0
Xsky130_fd_sc_hd__tapvpwrvgnd_1_169
+ vss
+ vdd
+ sky130_fd_sc_hd__tapvpwrvgnd_1
* cell instance sky130_fd_sc_hd__tapvpwrvgnd_1_170 r0 *1 0,0
Xsky130_fd_sc_hd__tapvpwrvgnd_1_170
+ vss
+ vdd
+ sky130_fd_sc_hd__tapvpwrvgnd_1
* cell instance sky130_fd_sc_hd__tapvpwrvgnd_1_171 r0 *1 0,0
Xsky130_fd_sc_hd__tapvpwrvgnd_1_171
+ vss
+ vdd
+ sky130_fd_sc_hd__tapvpwrvgnd_1
* cell instance sky130_fd_sc_hd__tapvpwrvgnd_1_172 r0 *1 0,0
Xsky130_fd_sc_hd__tapvpwrvgnd_1_172
+ vss
+ vdd
+ sky130_fd_sc_hd__tapvpwrvgnd_1
* cell instance sky130_fd_sc_hd__tapvpwrvgnd_1_173 r0 *1 0,0
Xsky130_fd_sc_hd__tapvpwrvgnd_1_173
+ vss
+ vdd
+ sky130_fd_sc_hd__tapvpwrvgnd_1
* cell instance sky130_fd_sc_hd__tapvpwrvgnd_1_174 r0 *1 0,0
Xsky130_fd_sc_hd__tapvpwrvgnd_1_174
+ vss
+ vdd
+ sky130_fd_sc_hd__tapvpwrvgnd_1
* cell instance sky130_fd_sc_hd__tapvpwrvgnd_1_175 r0 *1 0,0
Xsky130_fd_sc_hd__tapvpwrvgnd_1_175
+ vss
+ vdd
+ sky130_fd_sc_hd__tapvpwrvgnd_1
* cell instance sky130_fd_sc_hd__tapvpwrvgnd_1_176 r0 *1 0,0
Xsky130_fd_sc_hd__tapvpwrvgnd_1_176
+ vss
+ vdd
+ sky130_fd_sc_hd__tapvpwrvgnd_1
* cell instance sky130_fd_sc_hd__tapvpwrvgnd_1_177 r0 *1 0,0
Xsky130_fd_sc_hd__tapvpwrvgnd_1_177
+ vss
+ vdd
+ sky130_fd_sc_hd__tapvpwrvgnd_1
* cell instance sky130_fd_sc_hd__tapvpwrvgnd_1_178 r0 *1 0,0
Xsky130_fd_sc_hd__tapvpwrvgnd_1_178
+ vss
+ vdd
+ sky130_fd_sc_hd__tapvpwrvgnd_1
* cell instance sky130_fd_sc_hd__tapvpwrvgnd_1_179 r0 *1 0,0
Xsky130_fd_sc_hd__tapvpwrvgnd_1_179
+ vss
+ vdd
+ sky130_fd_sc_hd__tapvpwrvgnd_1
* cell instance sky130_fd_sc_hd__tapvpwrvgnd_1_180 r0 *1 0,0
Xsky130_fd_sc_hd__tapvpwrvgnd_1_180
+ vss
+ vdd
+ sky130_fd_sc_hd__tapvpwrvgnd_1
* cell instance sky130_fd_sc_hd__tapvpwrvgnd_1_181 r0 *1 0,0
Xsky130_fd_sc_hd__tapvpwrvgnd_1_181
+ vss
+ vdd
+ sky130_fd_sc_hd__tapvpwrvgnd_1
* cell instance sky130_fd_sc_hd__tapvpwrvgnd_1_182 r0 *1 0,0
Xsky130_fd_sc_hd__tapvpwrvgnd_1_182
+ vss
+ vdd
+ sky130_fd_sc_hd__tapvpwrvgnd_1
* cell instance sky130_fd_sc_hd__tapvpwrvgnd_1_183 r0 *1 0,0
Xsky130_fd_sc_hd__tapvpwrvgnd_1_183
+ vss
+ vdd
+ sky130_fd_sc_hd__tapvpwrvgnd_1
* cell instance sky130_fd_sc_hd__tapvpwrvgnd_1_184 r0 *1 0,0
Xsky130_fd_sc_hd__tapvpwrvgnd_1_184
+ vss
+ vdd
+ sky130_fd_sc_hd__tapvpwrvgnd_1
* cell instance sky130_fd_sc_hd__tapvpwrvgnd_1_185 r0 *1 0,0
Xsky130_fd_sc_hd__tapvpwrvgnd_1_185
+ vss
+ vdd
+ sky130_fd_sc_hd__tapvpwrvgnd_1
* cell instance sky130_fd_sc_hd__tapvpwrvgnd_1_186 r0 *1 0,0
Xsky130_fd_sc_hd__tapvpwrvgnd_1_186
+ vss
+ vdd
+ sky130_fd_sc_hd__tapvpwrvgnd_1
* cell instance sky130_fd_sc_hd__tapvpwrvgnd_1_187 r0 *1 0,0
Xsky130_fd_sc_hd__tapvpwrvgnd_1_187
+ vss
+ vdd
+ sky130_fd_sc_hd__tapvpwrvgnd_1
* cell instance sky130_fd_sc_hd__tapvpwrvgnd_1_188 r0 *1 0,0
Xsky130_fd_sc_hd__tapvpwrvgnd_1_188
+ vss
+ vdd
+ sky130_fd_sc_hd__tapvpwrvgnd_1
* cell instance sky130_fd_sc_hd__tapvpwrvgnd_1_189 r0 *1 0,0
Xsky130_fd_sc_hd__tapvpwrvgnd_1_189
+ vss
+ vdd
+ sky130_fd_sc_hd__tapvpwrvgnd_1
* cell instance sky130_fd_sc_hd__tapvpwrvgnd_1_190 r0 *1 0,0
Xsky130_fd_sc_hd__tapvpwrvgnd_1_190
+ vss
+ vdd
+ sky130_fd_sc_hd__tapvpwrvgnd_1
* cell instance sky130_fd_sc_hd__tapvpwrvgnd_1_191 r0 *1 0,0
Xsky130_fd_sc_hd__tapvpwrvgnd_1_191
+ vss
+ vdd
+ sky130_fd_sc_hd__tapvpwrvgnd_1
* cell instance sky130_fd_sc_hd__tapvpwrvgnd_1_192 r0 *1 0,0
Xsky130_fd_sc_hd__tapvpwrvgnd_1_192
+ vss
+ vdd
+ sky130_fd_sc_hd__tapvpwrvgnd_1
* cell instance sky130_fd_sc_hd__tapvpwrvgnd_1_193 r0 *1 0,0
Xsky130_fd_sc_hd__tapvpwrvgnd_1_193
+ vss
+ vdd
+ sky130_fd_sc_hd__tapvpwrvgnd_1
* cell instance sky130_fd_sc_hd__tapvpwrvgnd_1_194 r0 *1 0,0
Xsky130_fd_sc_hd__tapvpwrvgnd_1_194
+ vss
+ vdd
+ sky130_fd_sc_hd__tapvpwrvgnd_1
* cell instance sky130_fd_sc_hd__tapvpwrvgnd_1_195 r0 *1 0,0
Xsky130_fd_sc_hd__tapvpwrvgnd_1_195
+ vss
+ vdd
+ sky130_fd_sc_hd__tapvpwrvgnd_1
* cell instance sky130_fd_sc_hd__tapvpwrvgnd_1_196 r0 *1 0,0
Xsky130_fd_sc_hd__tapvpwrvgnd_1_196
+ vss
+ vdd
+ sky130_fd_sc_hd__tapvpwrvgnd_1
* cell instance sky130_fd_sc_hd__tapvpwrvgnd_1_197 r0 *1 0,0
Xsky130_fd_sc_hd__tapvpwrvgnd_1_197
+ vss
+ vdd
+ sky130_fd_sc_hd__tapvpwrvgnd_1
* cell instance sky130_fd_sc_hd__tapvpwrvgnd_1_198 r0 *1 0,0
Xsky130_fd_sc_hd__tapvpwrvgnd_1_198
+ vss
+ vdd
+ sky130_fd_sc_hd__tapvpwrvgnd_1
* cell instance sky130_fd_sc_hd__tapvpwrvgnd_1_199 r0 *1 0,0
Xsky130_fd_sc_hd__tapvpwrvgnd_1_199
+ vss
+ vdd
+ sky130_fd_sc_hd__tapvpwrvgnd_1
* cell instance sky130_fd_sc_hd__tapvpwrvgnd_1_200 r0 *1 0,0
Xsky130_fd_sc_hd__tapvpwrvgnd_1_200
+ vss
+ vdd
+ sky130_fd_sc_hd__tapvpwrvgnd_1
* cell instance sky130_fd_sc_hd__tapvpwrvgnd_1_201 r0 *1 0,0
Xsky130_fd_sc_hd__tapvpwrvgnd_1_201
+ vss
+ vdd
+ sky130_fd_sc_hd__tapvpwrvgnd_1
* cell instance sky130_fd_sc_hd__tapvpwrvgnd_1_202 r0 *1 0,0
Xsky130_fd_sc_hd__tapvpwrvgnd_1_202
+ vss
+ vdd
+ sky130_fd_sc_hd__tapvpwrvgnd_1
* cell instance sky130_fd_sc_hd__tapvpwrvgnd_1_203 r0 *1 0,0
Xsky130_fd_sc_hd__tapvpwrvgnd_1_203
+ vss
+ vdd
+ sky130_fd_sc_hd__tapvpwrvgnd_1
* cell instance sky130_fd_sc_hd__tapvpwrvgnd_1_204 r0 *1 0,0
Xsky130_fd_sc_hd__tapvpwrvgnd_1_204
+ vss
+ vdd
+ sky130_fd_sc_hd__tapvpwrvgnd_1
* cell instance sky130_fd_sc_hd__tapvpwrvgnd_1_205 r0 *1 0,0
Xsky130_fd_sc_hd__tapvpwrvgnd_1_205
+ vss
+ vdd
+ sky130_fd_sc_hd__tapvpwrvgnd_1
* cell instance sky130_fd_sc_hd__tapvpwrvgnd_1_206 r0 *1 0,0
Xsky130_fd_sc_hd__tapvpwrvgnd_1_206
+ vss
+ vdd
+ sky130_fd_sc_hd__tapvpwrvgnd_1
* cell instance sky130_fd_sc_hd__tapvpwrvgnd_1_207 r0 *1 0,0
Xsky130_fd_sc_hd__tapvpwrvgnd_1_207
+ vss
+ vdd
+ sky130_fd_sc_hd__tapvpwrvgnd_1
* cell instance sky130_fd_sc_hd__tapvpwrvgnd_1_208 r0 *1 0,0
Xsky130_fd_sc_hd__tapvpwrvgnd_1_208
+ vss
+ vdd
+ sky130_fd_sc_hd__tapvpwrvgnd_1
* cell instance sky130_fd_sc_hd__tapvpwrvgnd_1_209 r0 *1 0,0
Xsky130_fd_sc_hd__tapvpwrvgnd_1_209
+ vss
+ vdd
+ sky130_fd_sc_hd__tapvpwrvgnd_1
* cell instance sky130_fd_sc_hd__tapvpwrvgnd_1_210 r0 *1 0,0
Xsky130_fd_sc_hd__tapvpwrvgnd_1_210
+ vss
+ vdd
+ sky130_fd_sc_hd__tapvpwrvgnd_1
* cell instance sky130_fd_sc_hd__tapvpwrvgnd_1_211 r0 *1 0,0
Xsky130_fd_sc_hd__tapvpwrvgnd_1_211
+ vss
+ vdd
+ sky130_fd_sc_hd__tapvpwrvgnd_1
* cell instance sky130_fd_sc_hd__tapvpwrvgnd_1_212 r0 *1 0,0
Xsky130_fd_sc_hd__tapvpwrvgnd_1_212
+ vss
+ vdd
+ sky130_fd_sc_hd__tapvpwrvgnd_1
* cell instance sky130_fd_sc_hd__tapvpwrvgnd_1_213 r0 *1 0,0
Xsky130_fd_sc_hd__tapvpwrvgnd_1_213
+ vss
+ vdd
+ sky130_fd_sc_hd__tapvpwrvgnd_1
* cell instance sky130_fd_sc_hd__tapvpwrvgnd_1_214 r0 *1 0,0
Xsky130_fd_sc_hd__tapvpwrvgnd_1_214
+ vss
+ vdd
+ sky130_fd_sc_hd__tapvpwrvgnd_1
* cell instance sky130_fd_sc_hd__tapvpwrvgnd_1_215 r0 *1 0,0
Xsky130_fd_sc_hd__tapvpwrvgnd_1_215
+ vss
+ vdd
+ sky130_fd_sc_hd__tapvpwrvgnd_1
* cell instance sky130_fd_sc_hd__tapvpwrvgnd_1_216 r0 *1 0,0
Xsky130_fd_sc_hd__tapvpwrvgnd_1_216
+ vss
+ vdd
+ sky130_fd_sc_hd__tapvpwrvgnd_1
* cell instance sky130_fd_sc_hd__tapvpwrvgnd_1_217 r0 *1 0,0
Xsky130_fd_sc_hd__tapvpwrvgnd_1_217
+ vss
+ vdd
+ sky130_fd_sc_hd__tapvpwrvgnd_1
* cell instance sky130_fd_sc_hd__tapvpwrvgnd_1_218 r0 *1 0,0
Xsky130_fd_sc_hd__tapvpwrvgnd_1_218
+ vss
+ vdd
+ sky130_fd_sc_hd__tapvpwrvgnd_1
* cell instance sky130_fd_sc_hd__tapvpwrvgnd_1_219 r0 *1 0,0
Xsky130_fd_sc_hd__tapvpwrvgnd_1_219
+ vss
+ vdd
+ sky130_fd_sc_hd__tapvpwrvgnd_1
* cell instance sky130_fd_sc_hd__tapvpwrvgnd_1_220 r0 *1 0,0
Xsky130_fd_sc_hd__tapvpwrvgnd_1_220
+ vss
+ vdd
+ sky130_fd_sc_hd__tapvpwrvgnd_1
* cell instance sky130_fd_sc_hd__tapvpwrvgnd_1_221 r0 *1 0,0
Xsky130_fd_sc_hd__tapvpwrvgnd_1_221
+ vss
+ vdd
+ sky130_fd_sc_hd__tapvpwrvgnd_1
* cell instance sky130_fd_sc_hd__tapvpwrvgnd_1_222 r0 *1 0,0
Xsky130_fd_sc_hd__tapvpwrvgnd_1_222
+ vss
+ vdd
+ sky130_fd_sc_hd__tapvpwrvgnd_1
* cell instance sky130_fd_sc_hd__tapvpwrvgnd_1_223 r0 *1 0,0
Xsky130_fd_sc_hd__tapvpwrvgnd_1_223
+ vss
+ vdd
+ sky130_fd_sc_hd__tapvpwrvgnd_1
* cell instance sky130_fd_sc_hd__tapvpwrvgnd_1_224 r0 *1 0,0
Xsky130_fd_sc_hd__tapvpwrvgnd_1_224
+ vss
+ vdd
+ sky130_fd_sc_hd__tapvpwrvgnd_1
* cell instance sky130_fd_sc_hd__tapvpwrvgnd_1_225 r0 *1 0,0
Xsky130_fd_sc_hd__tapvpwrvgnd_1_225
+ vss
+ vdd
+ sky130_fd_sc_hd__tapvpwrvgnd_1
* cell instance sky130_fd_sc_hd__tapvpwrvgnd_1_226 r0 *1 0,0
Xsky130_fd_sc_hd__tapvpwrvgnd_1_226
+ vss
+ vdd
+ sky130_fd_sc_hd__tapvpwrvgnd_1
* cell instance sky130_fd_sc_hd__tapvpwrvgnd_1_227 r0 *1 0,0
Xsky130_fd_sc_hd__tapvpwrvgnd_1_227
+ vss
+ vdd
+ sky130_fd_sc_hd__tapvpwrvgnd_1
* cell instance sky130_fd_sc_hd__tapvpwrvgnd_1_228 r0 *1 0,0
Xsky130_fd_sc_hd__tapvpwrvgnd_1_228
+ vss
+ vdd
+ sky130_fd_sc_hd__tapvpwrvgnd_1
* cell instance sky130_fd_sc_hd__tapvpwrvgnd_1_229 r0 *1 0,0
Xsky130_fd_sc_hd__tapvpwrvgnd_1_229
+ vss
+ vdd
+ sky130_fd_sc_hd__tapvpwrvgnd_1
* cell instance sky130_fd_sc_hd__tapvpwrvgnd_1_230 r0 *1 0,0
Xsky130_fd_sc_hd__tapvpwrvgnd_1_230
+ vss
+ vdd
+ sky130_fd_sc_hd__tapvpwrvgnd_1
* cell instance sky130_fd_sc_hd__tapvpwrvgnd_1_231 r0 *1 0,0
Xsky130_fd_sc_hd__tapvpwrvgnd_1_231
+ vss
+ vdd
+ sky130_fd_sc_hd__tapvpwrvgnd_1
* cell instance sky130_fd_sc_hd__tapvpwrvgnd_1_232 r0 *1 0,0
Xsky130_fd_sc_hd__tapvpwrvgnd_1_232
+ vss
+ vdd
+ sky130_fd_sc_hd__tapvpwrvgnd_1
* cell instance sky130_fd_sc_hd__tapvpwrvgnd_1_233 r0 *1 0,0
Xsky130_fd_sc_hd__tapvpwrvgnd_1_233
+ vss
+ vdd
+ sky130_fd_sc_hd__tapvpwrvgnd_1
* cell instance sky130_fd_sc_hd__tapvpwrvgnd_1_234 r0 *1 0,0
Xsky130_fd_sc_hd__tapvpwrvgnd_1_234
+ vss
+ vdd
+ sky130_fd_sc_hd__tapvpwrvgnd_1
* cell instance sky130_fd_sc_hd__tapvpwrvgnd_1_235 r0 *1 0,0
Xsky130_fd_sc_hd__tapvpwrvgnd_1_235
+ vss
+ vdd
+ sky130_fd_sc_hd__tapvpwrvgnd_1
* cell instance sky130_fd_sc_hd__tapvpwrvgnd_1_236 r0 *1 0,0
Xsky130_fd_sc_hd__tapvpwrvgnd_1_236
+ vss
+ vdd
+ sky130_fd_sc_hd__tapvpwrvgnd_1
* cell instance sky130_fd_sc_hd__tapvpwrvgnd_1_237 r0 *1 0,0
Xsky130_fd_sc_hd__tapvpwrvgnd_1_237
+ vss
+ vdd
+ sky130_fd_sc_hd__tapvpwrvgnd_1
* cell instance sky130_fd_sc_hd__tapvpwrvgnd_1_238 r0 *1 0,0
Xsky130_fd_sc_hd__tapvpwrvgnd_1_238
+ vss
+ vdd
+ sky130_fd_sc_hd__tapvpwrvgnd_1
* cell instance sky130_fd_sc_hd__tapvpwrvgnd_1_239 r0 *1 0,0
Xsky130_fd_sc_hd__tapvpwrvgnd_1_239
+ vss
+ vdd
+ sky130_fd_sc_hd__tapvpwrvgnd_1
* cell instance sky130_fd_sc_hd__tapvpwrvgnd_1_240 r0 *1 0,0
Xsky130_fd_sc_hd__tapvpwrvgnd_1_240
+ vss
+ vdd
+ sky130_fd_sc_hd__tapvpwrvgnd_1
* cell instance sky130_fd_sc_hd__tapvpwrvgnd_1_241 r0 *1 0,0
Xsky130_fd_sc_hd__tapvpwrvgnd_1_241
+ vss
+ vdd
+ sky130_fd_sc_hd__tapvpwrvgnd_1
* cell instance sky130_fd_sc_hd__tapvpwrvgnd_1_242 r0 *1 0,0
Xsky130_fd_sc_hd__tapvpwrvgnd_1_242
+ vss
+ vdd
+ sky130_fd_sc_hd__tapvpwrvgnd_1
* cell instance sky130_fd_sc_hd__tapvpwrvgnd_1_243 r0 *1 0,0
Xsky130_fd_sc_hd__tapvpwrvgnd_1_243
+ vss
+ vdd
+ sky130_fd_sc_hd__tapvpwrvgnd_1
* cell instance sky130_fd_sc_hd__tapvpwrvgnd_1_244 r0 *1 0,0
Xsky130_fd_sc_hd__tapvpwrvgnd_1_244
+ vss
+ vdd
+ sky130_fd_sc_hd__tapvpwrvgnd_1
* cell instance sky130_fd_sc_hd__tapvpwrvgnd_1_245 r0 *1 0,0
Xsky130_fd_sc_hd__tapvpwrvgnd_1_245
+ vss
+ vdd
+ sky130_fd_sc_hd__tapvpwrvgnd_1
* cell instance sky130_fd_sc_hd__tapvpwrvgnd_1_246 r0 *1 0,0
Xsky130_fd_sc_hd__tapvpwrvgnd_1_246
+ vss
+ vdd
+ sky130_fd_sc_hd__tapvpwrvgnd_1
* cell instance sky130_fd_sc_hd__tapvpwrvgnd_1_247 r0 *1 0,0
Xsky130_fd_sc_hd__tapvpwrvgnd_1_247
+ vss
+ vdd
+ sky130_fd_sc_hd__tapvpwrvgnd_1
* cell instance sky130_fd_sc_hd__tapvpwrvgnd_1_248 r0 *1 0,0
Xsky130_fd_sc_hd__tapvpwrvgnd_1_248
+ vss
+ vdd
+ sky130_fd_sc_hd__tapvpwrvgnd_1
* cell instance sky130_fd_sc_hd__tapvpwrvgnd_1_249 r0 *1 0,0
Xsky130_fd_sc_hd__tapvpwrvgnd_1_249
+ vss
+ vdd
+ sky130_fd_sc_hd__tapvpwrvgnd_1
* cell instance sky130_fd_sc_hd__tapvpwrvgnd_1_250 r0 *1 0,0
Xsky130_fd_sc_hd__tapvpwrvgnd_1_250
+ vss
+ vdd
+ sky130_fd_sc_hd__tapvpwrvgnd_1
* cell instance sky130_fd_sc_hd__tapvpwrvgnd_1_251 r0 *1 0,0
Xsky130_fd_sc_hd__tapvpwrvgnd_1_251
+ vss
+ vdd
+ sky130_fd_sc_hd__tapvpwrvgnd_1
* cell instance sky130_fd_sc_hd__tapvpwrvgnd_1_252 r0 *1 0,0
Xsky130_fd_sc_hd__tapvpwrvgnd_1_252
+ vss
+ vdd
+ sky130_fd_sc_hd__tapvpwrvgnd_1
* cell instance sky130_fd_sc_hd__tapvpwrvgnd_1_253 r0 *1 0,0
Xsky130_fd_sc_hd__tapvpwrvgnd_1_253
+ vss
+ vdd
+ sky130_fd_sc_hd__tapvpwrvgnd_1
* cell instance sky130_fd_sc_hd__tapvpwrvgnd_1_254 r0 *1 0,0
Xsky130_fd_sc_hd__tapvpwrvgnd_1_254
+ vss
+ vdd
+ sky130_fd_sc_hd__tapvpwrvgnd_1
* cell instance sky130_fd_sc_hd__tapvpwrvgnd_1_255 r0 *1 0,0
Xsky130_fd_sc_hd__tapvpwrvgnd_1_255
+ vss
+ vdd
+ sky130_fd_sc_hd__tapvpwrvgnd_1
* cell instance sky130_fd_sc_hd__tapvpwrvgnd_1_256 r0 *1 0,0
Xsky130_fd_sc_hd__tapvpwrvgnd_1_256
+ vss
+ vdd
+ sky130_fd_sc_hd__tapvpwrvgnd_1
* cell instance sky130_fd_sc_hd__tapvpwrvgnd_1_257 r0 *1 0,0
Xsky130_fd_sc_hd__tapvpwrvgnd_1_257
+ vss
+ vdd
+ sky130_fd_sc_hd__tapvpwrvgnd_1
* cell instance sky130_fd_sc_hd__tapvpwrvgnd_1_258 r0 *1 0,0
Xsky130_fd_sc_hd__tapvpwrvgnd_1_258
+ vss
+ vdd
+ sky130_fd_sc_hd__tapvpwrvgnd_1
* cell instance sky130_fd_sc_hd__tapvpwrvgnd_1_259 r0 *1 0,0
Xsky130_fd_sc_hd__tapvpwrvgnd_1_259
+ vss
+ vdd
+ sky130_fd_sc_hd__tapvpwrvgnd_1
* cell instance sky130_fd_sc_hd__tapvpwrvgnd_1_260 r0 *1 0,0
Xsky130_fd_sc_hd__tapvpwrvgnd_1_260
+ vss
+ vdd
+ sky130_fd_sc_hd__tapvpwrvgnd_1
* cell instance sky130_fd_sc_hd__tapvpwrvgnd_1_261 r0 *1 0,0
Xsky130_fd_sc_hd__tapvpwrvgnd_1_261
+ vss
+ vdd
+ sky130_fd_sc_hd__tapvpwrvgnd_1
* cell instance sky130_fd_sc_hd__tapvpwrvgnd_1_262 r0 *1 0,0
Xsky130_fd_sc_hd__tapvpwrvgnd_1_262
+ vss
+ vdd
+ sky130_fd_sc_hd__tapvpwrvgnd_1
* cell instance sky130_fd_sc_hd__tapvpwrvgnd_1_263 r0 *1 0,0
Xsky130_fd_sc_hd__tapvpwrvgnd_1_263
+ vss
+ vdd
+ sky130_fd_sc_hd__tapvpwrvgnd_1
* cell instance sky130_fd_sc_hd__tapvpwrvgnd_1_264 r0 *1 0,0
Xsky130_fd_sc_hd__tapvpwrvgnd_1_264
+ vss
+ vdd
+ sky130_fd_sc_hd__tapvpwrvgnd_1
* cell instance sky130_fd_sc_hd__tapvpwrvgnd_1_265 r0 *1 0,0
Xsky130_fd_sc_hd__tapvpwrvgnd_1_265
+ vss
+ vdd
+ sky130_fd_sc_hd__tapvpwrvgnd_1
* cell instance sky130_fd_sc_hd__tapvpwrvgnd_1_266 r0 *1 0,0
Xsky130_fd_sc_hd__tapvpwrvgnd_1_266
+ vss
+ vdd
+ sky130_fd_sc_hd__tapvpwrvgnd_1
* cell instance sky130_fd_sc_hd__tapvpwrvgnd_1_267 r0 *1 0,0
Xsky130_fd_sc_hd__tapvpwrvgnd_1_267
+ vss
+ vdd
+ sky130_fd_sc_hd__tapvpwrvgnd_1
* cell instance sky130_fd_sc_hd__tapvpwrvgnd_1_268 r0 *1 0,0
Xsky130_fd_sc_hd__tapvpwrvgnd_1_268
+ vss
+ vdd
+ sky130_fd_sc_hd__tapvpwrvgnd_1
* cell instance sky130_fd_sc_hd__tapvpwrvgnd_1_269 r0 *1 0,0
Xsky130_fd_sc_hd__tapvpwrvgnd_1_269
+ vss
+ vdd
+ sky130_fd_sc_hd__tapvpwrvgnd_1
* cell instance sky130_fd_sc_hd__tapvpwrvgnd_1_270 r0 *1 0,0
Xsky130_fd_sc_hd__tapvpwrvgnd_1_270
+ vss
+ vdd
+ sky130_fd_sc_hd__tapvpwrvgnd_1
* cell instance sky130_fd_sc_hd__tapvpwrvgnd_1_271 r0 *1 0,0
Xsky130_fd_sc_hd__tapvpwrvgnd_1_271
+ vss
+ vdd
+ sky130_fd_sc_hd__tapvpwrvgnd_1
* cell instance sky130_fd_sc_hd__tapvpwrvgnd_1_272 r0 *1 0,0
Xsky130_fd_sc_hd__tapvpwrvgnd_1_272
+ vss
+ vdd
+ sky130_fd_sc_hd__tapvpwrvgnd_1
* cell instance sky130_fd_sc_hd__tapvpwrvgnd_1_273 r0 *1 0,0
Xsky130_fd_sc_hd__tapvpwrvgnd_1_273
+ vss
+ vdd
+ sky130_fd_sc_hd__tapvpwrvgnd_1
* cell instance sky130_fd_sc_hd__tapvpwrvgnd_1_274 r0 *1 0,0
Xsky130_fd_sc_hd__tapvpwrvgnd_1_274
+ vss
+ vdd
+ sky130_fd_sc_hd__tapvpwrvgnd_1
* cell instance sky130_fd_sc_hd__tapvpwrvgnd_1_275 r0 *1 0,0
Xsky130_fd_sc_hd__tapvpwrvgnd_1_275
+ vss
+ vdd
+ sky130_fd_sc_hd__tapvpwrvgnd_1
* cell instance sky130_fd_sc_hd__tapvpwrvgnd_1_276 r0 *1 0,0
Xsky130_fd_sc_hd__tapvpwrvgnd_1_276
+ vss
+ vdd
+ sky130_fd_sc_hd__tapvpwrvgnd_1
* cell instance sky130_fd_sc_hd__tapvpwrvgnd_1_277 r0 *1 0,0
Xsky130_fd_sc_hd__tapvpwrvgnd_1_277
+ vss
+ vdd
+ sky130_fd_sc_hd__tapvpwrvgnd_1
* cell instance sky130_fd_sc_hd__tapvpwrvgnd_1_278 r0 *1 0,0
Xsky130_fd_sc_hd__tapvpwrvgnd_1_278
+ vss
+ vdd
+ sky130_fd_sc_hd__tapvpwrvgnd_1
* cell instance sky130_fd_sc_hd__tapvpwrvgnd_1_279 r0 *1 0,0
Xsky130_fd_sc_hd__tapvpwrvgnd_1_279
+ vss
+ vdd
+ sky130_fd_sc_hd__tapvpwrvgnd_1
* cell instance sky130_fd_sc_hd__tapvpwrvgnd_1_280 r0 *1 0,0
Xsky130_fd_sc_hd__tapvpwrvgnd_1_280
+ vss
+ vdd
+ sky130_fd_sc_hd__tapvpwrvgnd_1
* cell instance sky130_fd_sc_hd__tapvpwrvgnd_1_281 r0 *1 0,0
Xsky130_fd_sc_hd__tapvpwrvgnd_1_281
+ vss
+ vdd
+ sky130_fd_sc_hd__tapvpwrvgnd_1
* cell instance sky130_fd_sc_hd__tapvpwrvgnd_1_282 r0 *1 0,0
Xsky130_fd_sc_hd__tapvpwrvgnd_1_282
+ vss
+ vdd
+ sky130_fd_sc_hd__tapvpwrvgnd_1
* cell instance sky130_fd_sc_hd__tapvpwrvgnd_1_283 r0 *1 0,0
Xsky130_fd_sc_hd__tapvpwrvgnd_1_283
+ vss
+ vdd
+ sky130_fd_sc_hd__tapvpwrvgnd_1
* cell instance sky130_fd_sc_hd__tapvpwrvgnd_1_284 r0 *1 0,0
Xsky130_fd_sc_hd__tapvpwrvgnd_1_284
+ vss
+ vdd
+ sky130_fd_sc_hd__tapvpwrvgnd_1
* cell instance sky130_fd_sc_hd__tapvpwrvgnd_1_285 r0 *1 0,0
Xsky130_fd_sc_hd__tapvpwrvgnd_1_285
+ vss
+ vdd
+ sky130_fd_sc_hd__tapvpwrvgnd_1
* cell instance sky130_fd_sc_hd__tapvpwrvgnd_1_286 r0 *1 0,0
Xsky130_fd_sc_hd__tapvpwrvgnd_1_286
+ vss
+ vdd
+ sky130_fd_sc_hd__tapvpwrvgnd_1
* cell instance sky130_fd_sc_hd__tapvpwrvgnd_1_287 r0 *1 0,0
Xsky130_fd_sc_hd__tapvpwrvgnd_1_287
+ vss
+ vdd
+ sky130_fd_sc_hd__tapvpwrvgnd_1
* cell instance sky130_fd_sc_hd__tapvpwrvgnd_1_288 r0 *1 0,0
Xsky130_fd_sc_hd__tapvpwrvgnd_1_288
+ vss
+ vdd
+ sky130_fd_sc_hd__tapvpwrvgnd_1
* cell instance sky130_fd_sc_hd__tapvpwrvgnd_1_289 r0 *1 0,0
Xsky130_fd_sc_hd__tapvpwrvgnd_1_289
+ vss
+ vdd
+ sky130_fd_sc_hd__tapvpwrvgnd_1
* cell instance sky130_fd_sc_hd__tapvpwrvgnd_1_290 r0 *1 0,0
Xsky130_fd_sc_hd__tapvpwrvgnd_1_290
+ vss
+ vdd
+ sky130_fd_sc_hd__tapvpwrvgnd_1
* cell instance sky130_fd_sc_hd__tapvpwrvgnd_1_291 r0 *1 0,0
Xsky130_fd_sc_hd__tapvpwrvgnd_1_291
+ vss
+ vdd
+ sky130_fd_sc_hd__tapvpwrvgnd_1
* cell instance sky130_fd_sc_hd__tapvpwrvgnd_1_292 r0 *1 0,0
Xsky130_fd_sc_hd__tapvpwrvgnd_1_292
+ vss
+ vdd
+ sky130_fd_sc_hd__tapvpwrvgnd_1
* cell instance sky130_fd_sc_hd__tapvpwrvgnd_1_293 r0 *1 0,0
Xsky130_fd_sc_hd__tapvpwrvgnd_1_293
+ vss
+ vdd
+ sky130_fd_sc_hd__tapvpwrvgnd_1
* cell instance sky130_fd_sc_hd__tapvpwrvgnd_1_294 r0 *1 0,0
Xsky130_fd_sc_hd__tapvpwrvgnd_1_294
+ vss
+ vdd
+ sky130_fd_sc_hd__tapvpwrvgnd_1
* cell instance sky130_fd_sc_hd__tapvpwrvgnd_1_295 r0 *1 0,0
Xsky130_fd_sc_hd__tapvpwrvgnd_1_295
+ vss
+ vdd
+ sky130_fd_sc_hd__tapvpwrvgnd_1
* cell instance sky130_fd_sc_hd__tapvpwrvgnd_1_296 r0 *1 0,0
Xsky130_fd_sc_hd__tapvpwrvgnd_1_296
+ vss
+ vdd
+ sky130_fd_sc_hd__tapvpwrvgnd_1
* cell instance sky130_fd_sc_hd__tapvpwrvgnd_1_297 r0 *1 0,0
Xsky130_fd_sc_hd__tapvpwrvgnd_1_297
+ vss
+ vdd
+ sky130_fd_sc_hd__tapvpwrvgnd_1
* cell instance sky130_fd_sc_hd__tapvpwrvgnd_1_298 r0 *1 0,0
Xsky130_fd_sc_hd__tapvpwrvgnd_1_298
+ vss
+ vdd
+ sky130_fd_sc_hd__tapvpwrvgnd_1
* cell instance sky130_fd_sc_hd__tapvpwrvgnd_1_299 r0 *1 0,0
Xsky130_fd_sc_hd__tapvpwrvgnd_1_299
+ vss
+ vdd
+ sky130_fd_sc_hd__tapvpwrvgnd_1
* cell instance sky130_fd_sc_hd__tapvpwrvgnd_1_300 r0 *1 0,0
Xsky130_fd_sc_hd__tapvpwrvgnd_1_300
+ vss
+ vdd
+ sky130_fd_sc_hd__tapvpwrvgnd_1
* cell instance sky130_fd_sc_hd__tapvpwrvgnd_1_301 r0 *1 0,0
Xsky130_fd_sc_hd__tapvpwrvgnd_1_301
+ vss
+ vdd
+ sky130_fd_sc_hd__tapvpwrvgnd_1
* cell instance sky130_fd_sc_hd__tapvpwrvgnd_1_302 r0 *1 0,0
Xsky130_fd_sc_hd__tapvpwrvgnd_1_302
+ vss
+ vdd
+ sky130_fd_sc_hd__tapvpwrvgnd_1
* cell instance sky130_fd_sc_hd__tapvpwrvgnd_1_303 r0 *1 0,0
Xsky130_fd_sc_hd__tapvpwrvgnd_1_303
+ vss
+ vdd
+ sky130_fd_sc_hd__tapvpwrvgnd_1
* cell instance sky130_fd_sc_hd__tapvpwrvgnd_1_304 r0 *1 0,0
Xsky130_fd_sc_hd__tapvpwrvgnd_1_304
+ vss
+ vdd
+ sky130_fd_sc_hd__tapvpwrvgnd_1
* cell instance sky130_fd_sc_hd__tapvpwrvgnd_1_305 r0 *1 0,0
Xsky130_fd_sc_hd__tapvpwrvgnd_1_305
+ vss
+ vdd
+ sky130_fd_sc_hd__tapvpwrvgnd_1
* cell instance sky130_fd_sc_hd__tapvpwrvgnd_1_306 r0 *1 0,0
Xsky130_fd_sc_hd__tapvpwrvgnd_1_306
+ vss
+ vdd
+ sky130_fd_sc_hd__tapvpwrvgnd_1
* cell instance sky130_fd_sc_hd__tapvpwrvgnd_1_307 r0 *1 0,0
Xsky130_fd_sc_hd__tapvpwrvgnd_1_307
+ vss
+ vdd
+ sky130_fd_sc_hd__tapvpwrvgnd_1
* cell instance sky130_fd_sc_hd__tapvpwrvgnd_1_308 r0 *1 0,0
Xsky130_fd_sc_hd__tapvpwrvgnd_1_308
+ vss
+ vdd
+ sky130_fd_sc_hd__tapvpwrvgnd_1
* cell instance sky130_fd_sc_hd__tapvpwrvgnd_1_309 r0 *1 0,0
Xsky130_fd_sc_hd__tapvpwrvgnd_1_309
+ vss
+ vdd
+ sky130_fd_sc_hd__tapvpwrvgnd_1
* cell instance sky130_fd_sc_hd__tapvpwrvgnd_1_310 r0 *1 0,0
Xsky130_fd_sc_hd__tapvpwrvgnd_1_310
+ vss
+ vdd
+ sky130_fd_sc_hd__tapvpwrvgnd_1
* cell instance sky130_fd_sc_hd__tapvpwrvgnd_1_311 r0 *1 0,0
Xsky130_fd_sc_hd__tapvpwrvgnd_1_311
+ vss
+ vdd
+ sky130_fd_sc_hd__tapvpwrvgnd_1
* cell instance sky130_fd_sc_hd__tapvpwrvgnd_1_312 r0 *1 0,0
Xsky130_fd_sc_hd__tapvpwrvgnd_1_312
+ vss
+ vdd
+ sky130_fd_sc_hd__tapvpwrvgnd_1
* cell instance sky130_fd_sc_hd__tapvpwrvgnd_1_313 r0 *1 0,0
Xsky130_fd_sc_hd__tapvpwrvgnd_1_313
+ vss
+ vdd
+ sky130_fd_sc_hd__tapvpwrvgnd_1
* cell instance sky130_fd_sc_hd__tapvpwrvgnd_1_314 r0 *1 0,0
Xsky130_fd_sc_hd__tapvpwrvgnd_1_314
+ vss
+ vdd
+ sky130_fd_sc_hd__tapvpwrvgnd_1
* cell instance sky130_fd_sc_hd__tapvpwrvgnd_1_315 r0 *1 0,0
Xsky130_fd_sc_hd__tapvpwrvgnd_1_315
+ vss
+ vdd
+ sky130_fd_sc_hd__tapvpwrvgnd_1
* cell instance sky130_fd_sc_hd__tapvpwrvgnd_1_316 r0 *1 0,0
Xsky130_fd_sc_hd__tapvpwrvgnd_1_316
+ vss
+ vdd
+ sky130_fd_sc_hd__tapvpwrvgnd_1
* cell instance sky130_fd_sc_hd__tapvpwrvgnd_1_317 r0 *1 0,0
Xsky130_fd_sc_hd__tapvpwrvgnd_1_317
+ vss
+ vdd
+ sky130_fd_sc_hd__tapvpwrvgnd_1
* cell instance sky130_fd_sc_hd__tapvpwrvgnd_1_318 r0 *1 0,0
Xsky130_fd_sc_hd__tapvpwrvgnd_1_318
+ vss
+ vdd
+ sky130_fd_sc_hd__tapvpwrvgnd_1
* cell instance sky130_fd_sc_hd__tapvpwrvgnd_1_319 r0 *1 0,0
Xsky130_fd_sc_hd__tapvpwrvgnd_1_319
+ vss
+ vdd
+ sky130_fd_sc_hd__tapvpwrvgnd_1
* cell instance sky130_fd_sc_hd__tapvpwrvgnd_1_320 r0 *1 0,0
Xsky130_fd_sc_hd__tapvpwrvgnd_1_320
+ vss
+ vdd
+ sky130_fd_sc_hd__tapvpwrvgnd_1
* cell instance sky130_fd_sc_hd__tapvpwrvgnd_1_321 r0 *1 0,0
Xsky130_fd_sc_hd__tapvpwrvgnd_1_321
+ vss
+ vdd
+ sky130_fd_sc_hd__tapvpwrvgnd_1
* cell instance sky130_fd_sc_hd__tapvpwrvgnd_1_322 r0 *1 0,0
Xsky130_fd_sc_hd__tapvpwrvgnd_1_322
+ vss
+ vdd
+ sky130_fd_sc_hd__tapvpwrvgnd_1
* cell instance sky130_fd_sc_hd__tapvpwrvgnd_1_323 r0 *1 0,0
Xsky130_fd_sc_hd__tapvpwrvgnd_1_323
+ vss
+ vdd
+ sky130_fd_sc_hd__tapvpwrvgnd_1
* cell instance sky130_fd_sc_hd__tapvpwrvgnd_1_324 r0 *1 0,0
Xsky130_fd_sc_hd__tapvpwrvgnd_1_324
+ vss
+ vdd
+ sky130_fd_sc_hd__tapvpwrvgnd_1
* cell instance sky130_fd_sc_hd__tapvpwrvgnd_1_325 r0 *1 0,0
Xsky130_fd_sc_hd__tapvpwrvgnd_1_325
+ vss
+ vdd
+ sky130_fd_sc_hd__tapvpwrvgnd_1
* cell instance sky130_fd_sc_hd__tapvpwrvgnd_1_326 r0 *1 0,0
Xsky130_fd_sc_hd__tapvpwrvgnd_1_326
+ vss
+ vdd
+ sky130_fd_sc_hd__tapvpwrvgnd_1
* cell instance sky130_fd_sc_hd__tapvpwrvgnd_1_327 r0 *1 0,0
Xsky130_fd_sc_hd__tapvpwrvgnd_1_327
+ vss
+ vdd
+ sky130_fd_sc_hd__tapvpwrvgnd_1
* cell instance sky130_fd_sc_hd__tapvpwrvgnd_1_328 r0 *1 0,0
Xsky130_fd_sc_hd__tapvpwrvgnd_1_328
+ vss
+ vdd
+ sky130_fd_sc_hd__tapvpwrvgnd_1
* cell instance sky130_fd_sc_hd__tapvpwrvgnd_1_329 r0 *1 0,0
Xsky130_fd_sc_hd__tapvpwrvgnd_1_329
+ vss
+ vdd
+ sky130_fd_sc_hd__tapvpwrvgnd_1
* cell instance sky130_fd_sc_hd__tapvpwrvgnd_1_330 r0 *1 0,0
Xsky130_fd_sc_hd__tapvpwrvgnd_1_330
+ vss
+ vdd
+ sky130_fd_sc_hd__tapvpwrvgnd_1
* cell instance sky130_fd_sc_hd__tapvpwrvgnd_1_331 r0 *1 0,0
Xsky130_fd_sc_hd__tapvpwrvgnd_1_331
+ vss
+ vdd
+ sky130_fd_sc_hd__tapvpwrvgnd_1
* cell instance sky130_fd_sc_hd__tapvpwrvgnd_1_332 r0 *1 0,0
Xsky130_fd_sc_hd__tapvpwrvgnd_1_332
+ vss
+ vdd
+ sky130_fd_sc_hd__tapvpwrvgnd_1
* cell instance sky130_fd_sc_hd__tapvpwrvgnd_1_333 r0 *1 0,0
Xsky130_fd_sc_hd__tapvpwrvgnd_1_333
+ vss
+ vdd
+ sky130_fd_sc_hd__tapvpwrvgnd_1
* cell instance sky130_fd_sc_hd__tapvpwrvgnd_1_334 r0 *1 0,0
Xsky130_fd_sc_hd__tapvpwrvgnd_1_334
+ vss
+ vdd
+ sky130_fd_sc_hd__tapvpwrvgnd_1
* cell instance sky130_fd_sc_hd__tapvpwrvgnd_1_335 r0 *1 0,0
Xsky130_fd_sc_hd__tapvpwrvgnd_1_335
+ vss
+ vdd
+ sky130_fd_sc_hd__tapvpwrvgnd_1
* cell instance sky130_fd_sc_hd__tapvpwrvgnd_1_336 r0 *1 0,0
Xsky130_fd_sc_hd__tapvpwrvgnd_1_336
+ vss
+ vdd
+ sky130_fd_sc_hd__tapvpwrvgnd_1
* cell instance sky130_fd_sc_hd__tapvpwrvgnd_1_337 r0 *1 0,0
Xsky130_fd_sc_hd__tapvpwrvgnd_1_337
+ vss
+ vdd
+ sky130_fd_sc_hd__tapvpwrvgnd_1
* cell instance sky130_fd_sc_hd__tapvpwrvgnd_1_338 r0 *1 0,0
Xsky130_fd_sc_hd__tapvpwrvgnd_1_338
+ vss
+ vdd
+ sky130_fd_sc_hd__tapvpwrvgnd_1
* cell instance sky130_fd_sc_hd__tapvpwrvgnd_1_339 r0 *1 0,0
Xsky130_fd_sc_hd__tapvpwrvgnd_1_339
+ vss
+ vdd
+ sky130_fd_sc_hd__tapvpwrvgnd_1
* cell instance sky130_fd_sc_hd__tapvpwrvgnd_1_340 r0 *1 0,0
Xsky130_fd_sc_hd__tapvpwrvgnd_1_340
+ vss
+ vdd
+ sky130_fd_sc_hd__tapvpwrvgnd_1
* cell instance sky130_fd_sc_hd__tapvpwrvgnd_1_341 r0 *1 0,0
Xsky130_fd_sc_hd__tapvpwrvgnd_1_341
+ vss
+ vdd
+ sky130_fd_sc_hd__tapvpwrvgnd_1
* cell instance sky130_fd_sc_hd__tapvpwrvgnd_1_342 r0 *1 0,0
Xsky130_fd_sc_hd__tapvpwrvgnd_1_342
+ vss
+ vdd
+ sky130_fd_sc_hd__tapvpwrvgnd_1
* cell instance sky130_fd_sc_hd__tapvpwrvgnd_1_343 r0 *1 0,0
Xsky130_fd_sc_hd__tapvpwrvgnd_1_343
+ vss
+ vdd
+ sky130_fd_sc_hd__tapvpwrvgnd_1
* cell instance sky130_fd_sc_hd__tapvpwrvgnd_1_344 r0 *1 0,0
Xsky130_fd_sc_hd__tapvpwrvgnd_1_344
+ vss
+ vdd
+ sky130_fd_sc_hd__tapvpwrvgnd_1
* cell instance sky130_fd_sc_hd__tapvpwrvgnd_1_345 r0 *1 0,0
Xsky130_fd_sc_hd__tapvpwrvgnd_1_345
+ vss
+ vdd
+ sky130_fd_sc_hd__tapvpwrvgnd_1
* cell instance sky130_fd_sc_hd__tapvpwrvgnd_1_346 r0 *1 0,0
Xsky130_fd_sc_hd__tapvpwrvgnd_1_346
+ vss
+ vdd
+ sky130_fd_sc_hd__tapvpwrvgnd_1
* cell instance sky130_fd_sc_hd__tapvpwrvgnd_1_347 r0 *1 0,0
Xsky130_fd_sc_hd__tapvpwrvgnd_1_347
+ vss
+ vdd
+ sky130_fd_sc_hd__tapvpwrvgnd_1
* cell instance sky130_fd_sc_hd__tapvpwrvgnd_1_348 r0 *1 0,0
Xsky130_fd_sc_hd__tapvpwrvgnd_1_348
+ vss
+ vdd
+ sky130_fd_sc_hd__tapvpwrvgnd_1
* cell instance sky130_fd_sc_hd__tapvpwrvgnd_1_349 r0 *1 0,0
Xsky130_fd_sc_hd__tapvpwrvgnd_1_349
+ vss
+ vdd
+ sky130_fd_sc_hd__tapvpwrvgnd_1
* cell instance sky130_fd_sc_hd__tapvpwrvgnd_1_350 r0 *1 0,0
Xsky130_fd_sc_hd__tapvpwrvgnd_1_350
+ vss
+ vdd
+ sky130_fd_sc_hd__tapvpwrvgnd_1
* cell instance sky130_fd_sc_hd__tapvpwrvgnd_1_351 r0 *1 0,0
Xsky130_fd_sc_hd__tapvpwrvgnd_1_351
+ vss
+ vdd
+ sky130_fd_sc_hd__tapvpwrvgnd_1
* cell instance sky130_fd_sc_hd__tapvpwrvgnd_1_352 r0 *1 0,0
Xsky130_fd_sc_hd__tapvpwrvgnd_1_352
+ vss
+ vdd
+ sky130_fd_sc_hd__tapvpwrvgnd_1
* cell instance sky130_fd_sc_hd__tapvpwrvgnd_1_353 r0 *1 0,0
Xsky130_fd_sc_hd__tapvpwrvgnd_1_353
+ vss
+ vdd
+ sky130_fd_sc_hd__tapvpwrvgnd_1
* cell instance sky130_fd_sc_hd__tapvpwrvgnd_1_354 r0 *1 0,0
Xsky130_fd_sc_hd__tapvpwrvgnd_1_354
+ vss
+ vdd
+ sky130_fd_sc_hd__tapvpwrvgnd_1
* cell instance sky130_fd_sc_hd__tapvpwrvgnd_1_355 r0 *1 0,0
Xsky130_fd_sc_hd__tapvpwrvgnd_1_355
+ vss
+ vdd
+ sky130_fd_sc_hd__tapvpwrvgnd_1
* cell instance sky130_fd_sc_hd__tapvpwrvgnd_1_356 r0 *1 0,0
Xsky130_fd_sc_hd__tapvpwrvgnd_1_356
+ vss
+ vdd
+ sky130_fd_sc_hd__tapvpwrvgnd_1
* cell instance sky130_fd_sc_hd__tapvpwrvgnd_1_357 r0 *1 0,0
Xsky130_fd_sc_hd__tapvpwrvgnd_1_357
+ vss
+ vdd
+ sky130_fd_sc_hd__tapvpwrvgnd_1
* cell instance sky130_fd_sc_hd__tapvpwrvgnd_1_358 r0 *1 0,0
Xsky130_fd_sc_hd__tapvpwrvgnd_1_358
+ vss
+ vdd
+ sky130_fd_sc_hd__tapvpwrvgnd_1
* cell instance sky130_fd_sc_hd__tapvpwrvgnd_1_359 r0 *1 0,0
Xsky130_fd_sc_hd__tapvpwrvgnd_1_359
+ vss
+ vdd
+ sky130_fd_sc_hd__tapvpwrvgnd_1
* cell instance sky130_fd_sc_hd__tapvpwrvgnd_1_360 r0 *1 0,0
Xsky130_fd_sc_hd__tapvpwrvgnd_1_360
+ vss
+ vdd
+ sky130_fd_sc_hd__tapvpwrvgnd_1
* cell instance sky130_fd_sc_hd__tapvpwrvgnd_1_361 r0 *1 0,0
Xsky130_fd_sc_hd__tapvpwrvgnd_1_361
+ vss
+ vdd
+ sky130_fd_sc_hd__tapvpwrvgnd_1
* cell instance sky130_fd_sc_hd__tapvpwrvgnd_1_362 r0 *1 0,0
Xsky130_fd_sc_hd__tapvpwrvgnd_1_362
+ vss
+ vdd
+ sky130_fd_sc_hd__tapvpwrvgnd_1
* cell instance sky130_fd_sc_hd__tapvpwrvgnd_1_363 r0 *1 0,0
Xsky130_fd_sc_hd__tapvpwrvgnd_1_363
+ vss
+ vdd
+ sky130_fd_sc_hd__tapvpwrvgnd_1
* cell instance sky130_fd_sc_hd__tapvpwrvgnd_1_364 r0 *1 0,0
Xsky130_fd_sc_hd__tapvpwrvgnd_1_364
+ vss
+ vdd
+ sky130_fd_sc_hd__tapvpwrvgnd_1
* cell instance sky130_fd_sc_hd__tapvpwrvgnd_1_365 r0 *1 0,0
Xsky130_fd_sc_hd__tapvpwrvgnd_1_365
+ vss
+ vdd
+ sky130_fd_sc_hd__tapvpwrvgnd_1
* cell instance sky130_fd_sc_hd__tapvpwrvgnd_1_366 r0 *1 0,0
Xsky130_fd_sc_hd__tapvpwrvgnd_1_366
+ vss
+ vdd
+ sky130_fd_sc_hd__tapvpwrvgnd_1
* cell instance sky130_fd_sc_hd__tapvpwrvgnd_1_367 r0 *1 0,0
Xsky130_fd_sc_hd__tapvpwrvgnd_1_367
+ vss
+ vdd
+ sky130_fd_sc_hd__tapvpwrvgnd_1
* cell instance sky130_fd_sc_hd__tapvpwrvgnd_1_368 r0 *1 0,0
Xsky130_fd_sc_hd__tapvpwrvgnd_1_368
+ vss
+ vdd
+ sky130_fd_sc_hd__tapvpwrvgnd_1
* cell instance sky130_fd_sc_hd__tapvpwrvgnd_1_369 r0 *1 0,0
Xsky130_fd_sc_hd__tapvpwrvgnd_1_369
+ vss
+ vdd
+ sky130_fd_sc_hd__tapvpwrvgnd_1
* cell instance sky130_fd_sc_hd__tapvpwrvgnd_1_370 r0 *1 0,0
Xsky130_fd_sc_hd__tapvpwrvgnd_1_370
+ vss
+ vdd
+ sky130_fd_sc_hd__tapvpwrvgnd_1
* cell instance sky130_fd_sc_hd__tapvpwrvgnd_1_371 r0 *1 0,0
Xsky130_fd_sc_hd__tapvpwrvgnd_1_371
+ vss
+ vdd
+ sky130_fd_sc_hd__tapvpwrvgnd_1
* cell instance sky130_fd_sc_hd__tapvpwrvgnd_1_372 r0 *1 0,0
Xsky130_fd_sc_hd__tapvpwrvgnd_1_372
+ vss
+ vdd
+ sky130_fd_sc_hd__tapvpwrvgnd_1
* cell instance sky130_fd_sc_hd__tapvpwrvgnd_1_373 r0 *1 0,0
Xsky130_fd_sc_hd__tapvpwrvgnd_1_373
+ vss
+ vdd
+ sky130_fd_sc_hd__tapvpwrvgnd_1
* cell instance sky130_fd_sc_hd__tapvpwrvgnd_1_374 r0 *1 0,0
Xsky130_fd_sc_hd__tapvpwrvgnd_1_374
+ vss
+ vdd
+ sky130_fd_sc_hd__tapvpwrvgnd_1
* cell instance sky130_fd_sc_hd__tapvpwrvgnd_1_375 r0 *1 0,0
Xsky130_fd_sc_hd__tapvpwrvgnd_1_375
+ vss
+ vdd
+ sky130_fd_sc_hd__tapvpwrvgnd_1
* cell instance sky130_fd_sc_hd__tapvpwrvgnd_1_376 r0 *1 0,0
Xsky130_fd_sc_hd__tapvpwrvgnd_1_376
+ vss
+ vdd
+ sky130_fd_sc_hd__tapvpwrvgnd_1
* cell instance sky130_fd_sc_hd__tapvpwrvgnd_1_377 r0 *1 0,0
Xsky130_fd_sc_hd__tapvpwrvgnd_1_377
+ vss
+ vdd
+ sky130_fd_sc_hd__tapvpwrvgnd_1
* cell instance sky130_fd_sc_hd__tapvpwrvgnd_1_378 r0 *1 0,0
Xsky130_fd_sc_hd__tapvpwrvgnd_1_378
+ vss
+ vdd
+ sky130_fd_sc_hd__tapvpwrvgnd_1
* cell instance sky130_fd_sc_hd__tapvpwrvgnd_1_379 r0 *1 0,0
Xsky130_fd_sc_hd__tapvpwrvgnd_1_379
+ vss
+ vdd
+ sky130_fd_sc_hd__tapvpwrvgnd_1
* cell instance sky130_fd_sc_hd__tapvpwrvgnd_1_380 r0 *1 0,0
Xsky130_fd_sc_hd__tapvpwrvgnd_1_380
+ vss
+ vdd
+ sky130_fd_sc_hd__tapvpwrvgnd_1
* cell instance sky130_fd_sc_hd__tapvpwrvgnd_1_381 r0 *1 0,0
Xsky130_fd_sc_hd__tapvpwrvgnd_1_381
+ vss
+ vdd
+ sky130_fd_sc_hd__tapvpwrvgnd_1
* cell instance sky130_fd_sc_hd__tapvpwrvgnd_1_382 r0 *1 0,0
Xsky130_fd_sc_hd__tapvpwrvgnd_1_382
+ vss
+ vdd
+ sky130_fd_sc_hd__tapvpwrvgnd_1
* cell instance sky130_fd_sc_hd__tapvpwrvgnd_1_383 r0 *1 0,0
Xsky130_fd_sc_hd__tapvpwrvgnd_1_383
+ vss
+ vdd
+ sky130_fd_sc_hd__tapvpwrvgnd_1
* cell instance sky130_fd_sc_hd__tapvpwrvgnd_1_384 r0 *1 0,0
Xsky130_fd_sc_hd__tapvpwrvgnd_1_384
+ vss
+ vdd
+ sky130_fd_sc_hd__tapvpwrvgnd_1
* cell instance sky130_fd_sc_hd__tapvpwrvgnd_1_385 r0 *1 0,0
Xsky130_fd_sc_hd__tapvpwrvgnd_1_385
+ vss
+ vdd
+ sky130_fd_sc_hd__tapvpwrvgnd_1
* cell instance sky130_fd_sc_hd__tapvpwrvgnd_1_386 r0 *1 0,0
Xsky130_fd_sc_hd__tapvpwrvgnd_1_386
+ vss
+ vdd
+ sky130_fd_sc_hd__tapvpwrvgnd_1
* cell instance sky130_fd_sc_hd__tapvpwrvgnd_1_387 r0 *1 0,0
Xsky130_fd_sc_hd__tapvpwrvgnd_1_387
+ vss
+ vdd
+ sky130_fd_sc_hd__tapvpwrvgnd_1
* cell instance sky130_fd_sc_hd__tapvpwrvgnd_1_388 r0 *1 0,0
Xsky130_fd_sc_hd__tapvpwrvgnd_1_388
+ vss
+ vdd
+ sky130_fd_sc_hd__tapvpwrvgnd_1
* cell instance sky130_fd_sc_hd__tapvpwrvgnd_1_389 r0 *1 0,0
Xsky130_fd_sc_hd__tapvpwrvgnd_1_389
+ vss
+ vdd
+ sky130_fd_sc_hd__tapvpwrvgnd_1
* cell instance sky130_fd_sc_hd__tapvpwrvgnd_1_390 r0 *1 0,0
Xsky130_fd_sc_hd__tapvpwrvgnd_1_390
+ vss
+ vdd
+ sky130_fd_sc_hd__tapvpwrvgnd_1
* cell instance sky130_fd_sc_hd__tapvpwrvgnd_1_391 r0 *1 0,0
Xsky130_fd_sc_hd__tapvpwrvgnd_1_391
+ vss
+ vdd
+ sky130_fd_sc_hd__tapvpwrvgnd_1
* cell instance sky130_fd_sc_hd__tapvpwrvgnd_1_392 r0 *1 0,0
Xsky130_fd_sc_hd__tapvpwrvgnd_1_392
+ vss
+ vdd
+ sky130_fd_sc_hd__tapvpwrvgnd_1
* cell instance sky130_fd_sc_hd__tapvpwrvgnd_1_393 r0 *1 0,0
Xsky130_fd_sc_hd__tapvpwrvgnd_1_393
+ vss
+ vdd
+ sky130_fd_sc_hd__tapvpwrvgnd_1
* cell instance sky130_fd_sc_hd__tapvpwrvgnd_1_394 r0 *1 0,0
Xsky130_fd_sc_hd__tapvpwrvgnd_1_394
+ vss
+ vdd
+ sky130_fd_sc_hd__tapvpwrvgnd_1
* cell instance sky130_fd_sc_hd__tapvpwrvgnd_1_395 r0 *1 0,0
Xsky130_fd_sc_hd__tapvpwrvgnd_1_395
+ vss
+ vdd
+ sky130_fd_sc_hd__tapvpwrvgnd_1
* cell instance sky130_fd_sc_hd__tapvpwrvgnd_1_396 r0 *1 0,0
Xsky130_fd_sc_hd__tapvpwrvgnd_1_396
+ vss
+ vdd
+ sky130_fd_sc_hd__tapvpwrvgnd_1
* cell instance sky130_fd_sc_hd__tapvpwrvgnd_1_397 r0 *1 0,0
Xsky130_fd_sc_hd__tapvpwrvgnd_1_397
+ vss
+ vdd
+ sky130_fd_sc_hd__tapvpwrvgnd_1
* cell instance sky130_fd_sc_hd__tapvpwrvgnd_1_398 r0 *1 0,0
Xsky130_fd_sc_hd__tapvpwrvgnd_1_398
+ vss
+ vdd
+ sky130_fd_sc_hd__tapvpwrvgnd_1
* cell instance sky130_fd_sc_hd__tapvpwrvgnd_1_399 r0 *1 0,0
Xsky130_fd_sc_hd__tapvpwrvgnd_1_399
+ vss
+ vdd
+ sky130_fd_sc_hd__tapvpwrvgnd_1
* cell instance sky130_fd_sc_hd__tapvpwrvgnd_1_400 r0 *1 0,0
Xsky130_fd_sc_hd__tapvpwrvgnd_1_400
+ vss
+ vdd
+ sky130_fd_sc_hd__tapvpwrvgnd_1
* cell instance sky130_fd_sc_hd__tapvpwrvgnd_1_401 r0 *1 0,0
Xsky130_fd_sc_hd__tapvpwrvgnd_1_401
+ vss
+ vdd
+ sky130_fd_sc_hd__tapvpwrvgnd_1
* cell instance sky130_fd_sc_hd__tapvpwrvgnd_1_402 r0 *1 0,0
Xsky130_fd_sc_hd__tapvpwrvgnd_1_402
+ vss
+ vdd
+ sky130_fd_sc_hd__tapvpwrvgnd_1
* cell instance sky130_fd_sc_hd__tapvpwrvgnd_1_403 r0 *1 0,0
Xsky130_fd_sc_hd__tapvpwrvgnd_1_403
+ vss
+ vdd
+ sky130_fd_sc_hd__tapvpwrvgnd_1
* cell instance sky130_fd_sc_hd__tapvpwrvgnd_1_404 r0 *1 0,0
Xsky130_fd_sc_hd__tapvpwrvgnd_1_404
+ vss
+ vdd
+ sky130_fd_sc_hd__tapvpwrvgnd_1
* cell instance sky130_fd_sc_hd__tapvpwrvgnd_1_405 r0 *1 0,0
Xsky130_fd_sc_hd__tapvpwrvgnd_1_405
+ vss
+ vdd
+ sky130_fd_sc_hd__tapvpwrvgnd_1
* cell instance sky130_fd_sc_hd__tapvpwrvgnd_1_406 r0 *1 0,0
Xsky130_fd_sc_hd__tapvpwrvgnd_1_406
+ vss
+ vdd
+ sky130_fd_sc_hd__tapvpwrvgnd_1
* cell instance sky130_fd_sc_hd__tapvpwrvgnd_1_407 r0 *1 0,0
Xsky130_fd_sc_hd__tapvpwrvgnd_1_407
+ vss
+ vdd
+ sky130_fd_sc_hd__tapvpwrvgnd_1
* cell instance sky130_fd_sc_hd__tapvpwrvgnd_1_408 r0 *1 0,0
Xsky130_fd_sc_hd__tapvpwrvgnd_1_408
+ vss
+ vdd
+ sky130_fd_sc_hd__tapvpwrvgnd_1
* cell instance sky130_fd_sc_hd__tapvpwrvgnd_1_409 r0 *1 0,0
Xsky130_fd_sc_hd__tapvpwrvgnd_1_409
+ vss
+ vdd
+ sky130_fd_sc_hd__tapvpwrvgnd_1
* cell instance sky130_fd_sc_hd__tapvpwrvgnd_1_410 r0 *1 0,0
Xsky130_fd_sc_hd__tapvpwrvgnd_1_410
+ vss
+ vdd
+ sky130_fd_sc_hd__tapvpwrvgnd_1
* cell instance sky130_fd_sc_hd__tapvpwrvgnd_1_411 r0 *1 0,0
Xsky130_fd_sc_hd__tapvpwrvgnd_1_411
+ vss
+ vdd
+ sky130_fd_sc_hd__tapvpwrvgnd_1
* cell instance sky130_fd_sc_hd__tapvpwrvgnd_1_412 r0 *1 0,0
Xsky130_fd_sc_hd__tapvpwrvgnd_1_412
+ vss
+ vdd
+ sky130_fd_sc_hd__tapvpwrvgnd_1
* cell instance sky130_fd_sc_hd__tapvpwrvgnd_1_413 r0 *1 0,0
Xsky130_fd_sc_hd__tapvpwrvgnd_1_413
+ vss
+ vdd
+ sky130_fd_sc_hd__tapvpwrvgnd_1
* cell instance sky130_fd_sc_hd__tapvpwrvgnd_1_414 r0 *1 0,0
Xsky130_fd_sc_hd__tapvpwrvgnd_1_414
+ vss
+ vdd
+ sky130_fd_sc_hd__tapvpwrvgnd_1
* cell instance sky130_fd_sc_hd__tapvpwrvgnd_1_415 r0 *1 0,0
Xsky130_fd_sc_hd__tapvpwrvgnd_1_415
+ vss
+ vdd
+ sky130_fd_sc_hd__tapvpwrvgnd_1
* cell instance sky130_fd_sc_hd__tapvpwrvgnd_1_416 r0 *1 0,0
Xsky130_fd_sc_hd__tapvpwrvgnd_1_416
+ vss
+ vdd
+ sky130_fd_sc_hd__tapvpwrvgnd_1
* cell instance sky130_fd_sc_hd__tapvpwrvgnd_1_417 r0 *1 0,0
Xsky130_fd_sc_hd__tapvpwrvgnd_1_417
+ vss
+ vdd
+ sky130_fd_sc_hd__tapvpwrvgnd_1
* cell instance sky130_fd_sc_hd__tapvpwrvgnd_1_418 r0 *1 0,0
Xsky130_fd_sc_hd__tapvpwrvgnd_1_418
+ vss
+ vdd
+ sky130_fd_sc_hd__tapvpwrvgnd_1
* cell instance sky130_fd_sc_hd__tapvpwrvgnd_1_419 r0 *1 0,0
Xsky130_fd_sc_hd__tapvpwrvgnd_1_419
+ vss
+ vdd
+ sky130_fd_sc_hd__tapvpwrvgnd_1
* cell instance sky130_fd_sc_hd__tapvpwrvgnd_1_420 r0 *1 0,0
Xsky130_fd_sc_hd__tapvpwrvgnd_1_420
+ vss
+ vdd
+ sky130_fd_sc_hd__tapvpwrvgnd_1
* cell instance sky130_fd_sc_hd__tapvpwrvgnd_1_421 r0 *1 0,0
Xsky130_fd_sc_hd__tapvpwrvgnd_1_421
+ vss
+ vdd
+ sky130_fd_sc_hd__tapvpwrvgnd_1
* cell instance sky130_fd_sc_hd__tapvpwrvgnd_1_422 r0 *1 0,0
Xsky130_fd_sc_hd__tapvpwrvgnd_1_422
+ vss
+ vdd
+ sky130_fd_sc_hd__tapvpwrvgnd_1
* cell instance sky130_fd_sc_hd__tapvpwrvgnd_1_423 r0 *1 0,0
Xsky130_fd_sc_hd__tapvpwrvgnd_1_423
+ vss
+ vdd
+ sky130_fd_sc_hd__tapvpwrvgnd_1
* cell instance sky130_fd_sc_hd__tapvpwrvgnd_1_424 r0 *1 0,0
Xsky130_fd_sc_hd__tapvpwrvgnd_1_424
+ vss
+ vdd
+ sky130_fd_sc_hd__tapvpwrvgnd_1
* cell instance sky130_fd_sc_hd__tapvpwrvgnd_1_425 r0 *1 0,0
Xsky130_fd_sc_hd__tapvpwrvgnd_1_425
+ vss
+ vdd
+ sky130_fd_sc_hd__tapvpwrvgnd_1
* cell instance sky130_fd_sc_hd__tapvpwrvgnd_1_426 r0 *1 0,0
Xsky130_fd_sc_hd__tapvpwrvgnd_1_426
+ vss
+ vdd
+ sky130_fd_sc_hd__tapvpwrvgnd_1
* cell instance sky130_fd_sc_hd__tapvpwrvgnd_1_427 r0 *1 0,0
Xsky130_fd_sc_hd__tapvpwrvgnd_1_427
+ vss
+ vdd
+ sky130_fd_sc_hd__tapvpwrvgnd_1
* cell instance sky130_fd_sc_hd__tapvpwrvgnd_1_428 r0 *1 0,0
Xsky130_fd_sc_hd__tapvpwrvgnd_1_428
+ vss
+ vdd
+ sky130_fd_sc_hd__tapvpwrvgnd_1
* cell instance sky130_fd_sc_hd__tapvpwrvgnd_1_429 r0 *1 0,0
Xsky130_fd_sc_hd__tapvpwrvgnd_1_429
+ vss
+ vdd
+ sky130_fd_sc_hd__tapvpwrvgnd_1
* cell instance sky130_fd_sc_hd__tapvpwrvgnd_1_430 r0 *1 0,0
Xsky130_fd_sc_hd__tapvpwrvgnd_1_430
+ vss
+ vdd
+ sky130_fd_sc_hd__tapvpwrvgnd_1
* cell instance sky130_fd_sc_hd__tapvpwrvgnd_1_431 r0 *1 0,0
Xsky130_fd_sc_hd__tapvpwrvgnd_1_431
+ vss
+ vdd
+ sky130_fd_sc_hd__tapvpwrvgnd_1
* cell instance sky130_fd_sc_hd__tapvpwrvgnd_1_432 r0 *1 0,0
Xsky130_fd_sc_hd__tapvpwrvgnd_1_432
+ vss
+ vdd
+ sky130_fd_sc_hd__tapvpwrvgnd_1
* cell instance sky130_fd_sc_hd__tapvpwrvgnd_1_433 r0 *1 0,0
Xsky130_fd_sc_hd__tapvpwrvgnd_1_433
+ vss
+ vdd
+ sky130_fd_sc_hd__tapvpwrvgnd_1
* cell instance sky130_fd_sc_hd__tapvpwrvgnd_1_434 r0 *1 0,0
Xsky130_fd_sc_hd__tapvpwrvgnd_1_434
+ vss
+ vdd
+ sky130_fd_sc_hd__tapvpwrvgnd_1
* cell instance sky130_fd_sc_hd__tapvpwrvgnd_1_435 r0 *1 0,0
Xsky130_fd_sc_hd__tapvpwrvgnd_1_435
+ vss
+ vdd
+ sky130_fd_sc_hd__tapvpwrvgnd_1
* cell instance sky130_fd_sc_hd__tapvpwrvgnd_1_436 r0 *1 0,0
Xsky130_fd_sc_hd__tapvpwrvgnd_1_436
+ vss
+ vdd
+ sky130_fd_sc_hd__tapvpwrvgnd_1
* cell instance sky130_fd_sc_hd__tapvpwrvgnd_1_437 r0 *1 0,0
Xsky130_fd_sc_hd__tapvpwrvgnd_1_437
+ vss
+ vdd
+ sky130_fd_sc_hd__tapvpwrvgnd_1
* cell instance sky130_fd_sc_hd__tapvpwrvgnd_1_438 r0 *1 0,0
Xsky130_fd_sc_hd__tapvpwrvgnd_1_438
+ vss
+ vdd
+ sky130_fd_sc_hd__tapvpwrvgnd_1
* cell instance sky130_fd_sc_hd__tapvpwrvgnd_1_439 r0 *1 0,0
Xsky130_fd_sc_hd__tapvpwrvgnd_1_439
+ vss
+ vdd
+ sky130_fd_sc_hd__tapvpwrvgnd_1
* cell instance sky130_fd_sc_hd__tapvpwrvgnd_1_440 r0 *1 0,0
Xsky130_fd_sc_hd__tapvpwrvgnd_1_440
+ vss
+ vdd
+ sky130_fd_sc_hd__tapvpwrvgnd_1
* cell instance sky130_fd_sc_hd__tapvpwrvgnd_1_441 r0 *1 0,0
Xsky130_fd_sc_hd__tapvpwrvgnd_1_441
+ vss
+ vdd
+ sky130_fd_sc_hd__tapvpwrvgnd_1
* cell instance sky130_fd_sc_hd__tapvpwrvgnd_1_442 r0 *1 0,0
Xsky130_fd_sc_hd__tapvpwrvgnd_1_442
+ vss
+ vdd
+ sky130_fd_sc_hd__tapvpwrvgnd_1
* cell instance sky130_fd_sc_hd__tapvpwrvgnd_1_443 r0 *1 0,0
Xsky130_fd_sc_hd__tapvpwrvgnd_1_443
+ vss
+ vdd
+ sky130_fd_sc_hd__tapvpwrvgnd_1
* cell instance sky130_fd_sc_hd__tapvpwrvgnd_1_444 r0 *1 0,0
Xsky130_fd_sc_hd__tapvpwrvgnd_1_444
+ vss
+ vdd
+ sky130_fd_sc_hd__tapvpwrvgnd_1
* cell instance sky130_fd_sc_hd__tapvpwrvgnd_1_445 r0 *1 0,0
Xsky130_fd_sc_hd__tapvpwrvgnd_1_445
+ vss
+ vdd
+ sky130_fd_sc_hd__tapvpwrvgnd_1
* cell instance sky130_fd_sc_hd__tapvpwrvgnd_1_446 r0 *1 0,0
Xsky130_fd_sc_hd__tapvpwrvgnd_1_446
+ vss
+ vdd
+ sky130_fd_sc_hd__tapvpwrvgnd_1
* cell instance sky130_fd_sc_hd__tapvpwrvgnd_1_447 r0 *1 0,0
Xsky130_fd_sc_hd__tapvpwrvgnd_1_447
+ vss
+ vdd
+ sky130_fd_sc_hd__tapvpwrvgnd_1
* cell instance sky130_fd_sc_hd__tapvpwrvgnd_1_448 r0 *1 0,0
Xsky130_fd_sc_hd__tapvpwrvgnd_1_448
+ vss
+ vdd
+ sky130_fd_sc_hd__tapvpwrvgnd_1
* cell instance sky130_fd_sc_hd__tapvpwrvgnd_1_449 r0 *1 0,0
Xsky130_fd_sc_hd__tapvpwrvgnd_1_449
+ vss
+ vdd
+ sky130_fd_sc_hd__tapvpwrvgnd_1
* cell instance sky130_fd_sc_hd__tapvpwrvgnd_1_450 r0 *1 0,0
Xsky130_fd_sc_hd__tapvpwrvgnd_1_450
+ vss
+ vdd
+ sky130_fd_sc_hd__tapvpwrvgnd_1
* cell instance sky130_fd_sc_hd__tapvpwrvgnd_1_451 r0 *1 0,0
Xsky130_fd_sc_hd__tapvpwrvgnd_1_451
+ vss
+ vdd
+ sky130_fd_sc_hd__tapvpwrvgnd_1
* cell instance sky130_fd_sc_hd__tapvpwrvgnd_1_452 r0 *1 0,0
Xsky130_fd_sc_hd__tapvpwrvgnd_1_452
+ vss
+ vdd
+ sky130_fd_sc_hd__tapvpwrvgnd_1
* cell instance sky130_fd_sc_hd__tapvpwrvgnd_1_453 r0 *1 0,0
Xsky130_fd_sc_hd__tapvpwrvgnd_1_453
+ vss
+ vdd
+ sky130_fd_sc_hd__tapvpwrvgnd_1
* cell instance sky130_fd_sc_hd__tapvpwrvgnd_1_454 r0 *1 0,0
Xsky130_fd_sc_hd__tapvpwrvgnd_1_454
+ vss
+ vdd
+ sky130_fd_sc_hd__tapvpwrvgnd_1
* cell instance sky130_fd_sc_hd__tapvpwrvgnd_1_455 r0 *1 0,0
Xsky130_fd_sc_hd__tapvpwrvgnd_1_455
+ vss
+ vdd
+ sky130_fd_sc_hd__tapvpwrvgnd_1
* cell instance sky130_fd_sc_hd__tapvpwrvgnd_1_456 r0 *1 0,0
Xsky130_fd_sc_hd__tapvpwrvgnd_1_456
+ vss
+ vdd
+ sky130_fd_sc_hd__tapvpwrvgnd_1
* cell instance sky130_fd_sc_hd__tapvpwrvgnd_1_457 r0 *1 0,0
Xsky130_fd_sc_hd__tapvpwrvgnd_1_457
+ vss
+ vdd
+ sky130_fd_sc_hd__tapvpwrvgnd_1
* cell instance sky130_fd_sc_hd__tapvpwrvgnd_1_458 r0 *1 0,0
Xsky130_fd_sc_hd__tapvpwrvgnd_1_458
+ vss
+ vdd
+ sky130_fd_sc_hd__tapvpwrvgnd_1
* cell instance sky130_fd_sc_hd__tapvpwrvgnd_1_459 r0 *1 0,0
Xsky130_fd_sc_hd__tapvpwrvgnd_1_459
+ vss
+ vdd
+ sky130_fd_sc_hd__tapvpwrvgnd_1
* cell instance sky130_fd_sc_hd__tapvpwrvgnd_1_460 r0 *1 0,0
Xsky130_fd_sc_hd__tapvpwrvgnd_1_460
+ vss
+ vdd
+ sky130_fd_sc_hd__tapvpwrvgnd_1
* cell instance sky130_fd_sc_hd__tapvpwrvgnd_1_461 r0 *1 0,0
Xsky130_fd_sc_hd__tapvpwrvgnd_1_461
+ vss
+ vdd
+ sky130_fd_sc_hd__tapvpwrvgnd_1
* cell instance sky130_fd_sc_hd__tapvpwrvgnd_1_462 r0 *1 0,0
Xsky130_fd_sc_hd__tapvpwrvgnd_1_462
+ vss
+ vdd
+ sky130_fd_sc_hd__tapvpwrvgnd_1
* cell instance sky130_fd_sc_hd__tapvpwrvgnd_1_463 r0 *1 0,0
Xsky130_fd_sc_hd__tapvpwrvgnd_1_463
+ vss
+ vdd
+ sky130_fd_sc_hd__tapvpwrvgnd_1
* cell instance sky130_fd_sc_hd__tapvpwrvgnd_1_464 r0 *1 0,0
Xsky130_fd_sc_hd__tapvpwrvgnd_1_464
+ vss
+ vdd
+ sky130_fd_sc_hd__tapvpwrvgnd_1
* cell instance sky130_fd_sc_hd__tapvpwrvgnd_1_465 r0 *1 0,0
Xsky130_fd_sc_hd__tapvpwrvgnd_1_465
+ vss
+ vdd
+ sky130_fd_sc_hd__tapvpwrvgnd_1
* cell instance sky130_fd_sc_hd__tapvpwrvgnd_1_466 r0 *1 0,0
Xsky130_fd_sc_hd__tapvpwrvgnd_1_466
+ vss
+ vdd
+ sky130_fd_sc_hd__tapvpwrvgnd_1
* cell instance sky130_fd_sc_hd__tapvpwrvgnd_1_467 r0 *1 0,0
Xsky130_fd_sc_hd__tapvpwrvgnd_1_467
+ vss
+ vdd
+ sky130_fd_sc_hd__tapvpwrvgnd_1
* cell instance sky130_fd_sc_hd__tapvpwrvgnd_1_468 r0 *1 0,0
Xsky130_fd_sc_hd__tapvpwrvgnd_1_468
+ vss
+ vdd
+ sky130_fd_sc_hd__tapvpwrvgnd_1
* cell instance sky130_fd_sc_hd__tapvpwrvgnd_1_469 r0 *1 0,0
Xsky130_fd_sc_hd__tapvpwrvgnd_1_469
+ vss
+ vdd
+ sky130_fd_sc_hd__tapvpwrvgnd_1
* cell instance sky130_fd_sc_hd__tapvpwrvgnd_1_470 r0 *1 0,0
Xsky130_fd_sc_hd__tapvpwrvgnd_1_470
+ vss
+ vdd
+ sky130_fd_sc_hd__tapvpwrvgnd_1
* cell instance sky130_fd_sc_hd__tapvpwrvgnd_1_471 r0 *1 0,0
Xsky130_fd_sc_hd__tapvpwrvgnd_1_471
+ vss
+ vdd
+ sky130_fd_sc_hd__tapvpwrvgnd_1
* cell instance sky130_fd_sc_hd__tapvpwrvgnd_1_472 r0 *1 0,0
Xsky130_fd_sc_hd__tapvpwrvgnd_1_472
+ vss
+ vdd
+ sky130_fd_sc_hd__tapvpwrvgnd_1
* cell instance sky130_fd_sc_hd__tapvpwrvgnd_1_473 r0 *1 0,0
Xsky130_fd_sc_hd__tapvpwrvgnd_1_473
+ vss
+ vdd
+ sky130_fd_sc_hd__tapvpwrvgnd_1
* cell instance sky130_fd_sc_hd__tapvpwrvgnd_1_474 r0 *1 0,0
Xsky130_fd_sc_hd__tapvpwrvgnd_1_474
+ vss
+ vdd
+ sky130_fd_sc_hd__tapvpwrvgnd_1
* cell instance sky130_fd_sc_hd__tapvpwrvgnd_1_475 r0 *1 0,0
Xsky130_fd_sc_hd__tapvpwrvgnd_1_475
+ vss
+ vdd
+ sky130_fd_sc_hd__tapvpwrvgnd_1
* cell instance sky130_fd_sc_hd__tapvpwrvgnd_1_476 r0 *1 0,0
Xsky130_fd_sc_hd__tapvpwrvgnd_1_476
+ vss
+ vdd
+ sky130_fd_sc_hd__tapvpwrvgnd_1
* cell instance sky130_fd_sc_hd__tapvpwrvgnd_1_477 r0 *1 0,0
Xsky130_fd_sc_hd__tapvpwrvgnd_1_477
+ vss
+ vdd
+ sky130_fd_sc_hd__tapvpwrvgnd_1
* cell instance sky130_fd_sc_hd__tapvpwrvgnd_1_478 r0 *1 0,0
Xsky130_fd_sc_hd__tapvpwrvgnd_1_478
+ vss
+ vdd
+ sky130_fd_sc_hd__tapvpwrvgnd_1
* cell instance sky130_fd_sc_hd__tapvpwrvgnd_1_479 r0 *1 0,0
Xsky130_fd_sc_hd__tapvpwrvgnd_1_479
+ vss
+ vdd
+ sky130_fd_sc_hd__tapvpwrvgnd_1
* cell instance sky130_fd_sc_hd__tapvpwrvgnd_1_480 r0 *1 0,0
Xsky130_fd_sc_hd__tapvpwrvgnd_1_480
+ vss
+ vdd
+ sky130_fd_sc_hd__tapvpwrvgnd_1
* cell instance sky130_fd_sc_hd__tapvpwrvgnd_1_481 r0 *1 0,0
Xsky130_fd_sc_hd__tapvpwrvgnd_1_481
+ vss
+ vdd
+ sky130_fd_sc_hd__tapvpwrvgnd_1
* cell instance sky130_fd_sc_hd__tapvpwrvgnd_1_482 r0 *1 0,0
Xsky130_fd_sc_hd__tapvpwrvgnd_1_482
+ vss
+ vdd
+ sky130_fd_sc_hd__tapvpwrvgnd_1
* cell instance sky130_fd_sc_hd__tapvpwrvgnd_1_483 r0 *1 0,0
Xsky130_fd_sc_hd__tapvpwrvgnd_1_483
+ vss
+ vdd
+ sky130_fd_sc_hd__tapvpwrvgnd_1
* cell instance sky130_fd_sc_hd__tapvpwrvgnd_1_484 r0 *1 0,0
Xsky130_fd_sc_hd__tapvpwrvgnd_1_484
+ vss
+ vdd
+ sky130_fd_sc_hd__tapvpwrvgnd_1
* cell instance sky130_fd_sc_hd__tapvpwrvgnd_1_485 r0 *1 0,0
Xsky130_fd_sc_hd__tapvpwrvgnd_1_485
+ vss
+ vdd
+ sky130_fd_sc_hd__tapvpwrvgnd_1
* cell instance sky130_fd_sc_hd__tapvpwrvgnd_1_486 r0 *1 0,0
Xsky130_fd_sc_hd__tapvpwrvgnd_1_486
+ vss
+ vdd
+ sky130_fd_sc_hd__tapvpwrvgnd_1
* cell instance sky130_fd_sc_hd__tapvpwrvgnd_1_487 r0 *1 0,0
Xsky130_fd_sc_hd__tapvpwrvgnd_1_487
+ vss
+ vdd
+ sky130_fd_sc_hd__tapvpwrvgnd_1
* cell instance sky130_fd_sc_hd__tapvpwrvgnd_1_488 r0 *1 0,0
Xsky130_fd_sc_hd__tapvpwrvgnd_1_488
+ vss
+ vdd
+ sky130_fd_sc_hd__tapvpwrvgnd_1
* cell instance sky130_fd_sc_hd__tapvpwrvgnd_1_489 r0 *1 0,0
Xsky130_fd_sc_hd__tapvpwrvgnd_1_489
+ vss
+ vdd
+ sky130_fd_sc_hd__tapvpwrvgnd_1
* cell instance sky130_fd_sc_hd__tapvpwrvgnd_1_490 r0 *1 0,0
Xsky130_fd_sc_hd__tapvpwrvgnd_1_490
+ vss
+ vdd
+ sky130_fd_sc_hd__tapvpwrvgnd_1
* cell instance sky130_fd_sc_hd__tapvpwrvgnd_1_491 r0 *1 0,0
Xsky130_fd_sc_hd__tapvpwrvgnd_1_491
+ vss
+ vdd
+ sky130_fd_sc_hd__tapvpwrvgnd_1
* cell instance sky130_fd_sc_hd__tapvpwrvgnd_1_492 r0 *1 0,0
Xsky130_fd_sc_hd__tapvpwrvgnd_1_492
+ vss
+ vdd
+ sky130_fd_sc_hd__tapvpwrvgnd_1
* cell instance sky130_fd_sc_hd__tapvpwrvgnd_1_493 r0 *1 0,0
Xsky130_fd_sc_hd__tapvpwrvgnd_1_493
+ vss
+ vdd
+ sky130_fd_sc_hd__tapvpwrvgnd_1
* cell instance sky130_fd_sc_hd__tapvpwrvgnd_1_494 r0 *1 0,0
Xsky130_fd_sc_hd__tapvpwrvgnd_1_494
+ vss
+ vdd
+ sky130_fd_sc_hd__tapvpwrvgnd_1
* cell instance sky130_fd_sc_hd__tapvpwrvgnd_1_495 r0 *1 0,0
Xsky130_fd_sc_hd__tapvpwrvgnd_1_495
+ vss
+ vdd
+ sky130_fd_sc_hd__tapvpwrvgnd_1
* cell instance sky130_fd_sc_hd__tapvpwrvgnd_1_496 r0 *1 0,0
Xsky130_fd_sc_hd__tapvpwrvgnd_1_496
+ vss
+ vdd
+ sky130_fd_sc_hd__tapvpwrvgnd_1
* cell instance sky130_fd_sc_hd__tapvpwrvgnd_1_497 r0 *1 0,0
Xsky130_fd_sc_hd__tapvpwrvgnd_1_497
+ vss
+ vdd
+ sky130_fd_sc_hd__tapvpwrvgnd_1
* cell instance sky130_fd_sc_hd__tapvpwrvgnd_1_498 r0 *1 0,0
Xsky130_fd_sc_hd__tapvpwrvgnd_1_498
+ vss
+ vdd
+ sky130_fd_sc_hd__tapvpwrvgnd_1
* cell instance sky130_fd_sc_hd__tapvpwrvgnd_1_499 r0 *1 0,0
Xsky130_fd_sc_hd__tapvpwrvgnd_1_499
+ vss
+ vdd
+ sky130_fd_sc_hd__tapvpwrvgnd_1
* cell instance sky130_fd_sc_hd__tapvpwrvgnd_1_500 r0 *1 0,0
Xsky130_fd_sc_hd__tapvpwrvgnd_1_500
+ vss
+ vdd
+ sky130_fd_sc_hd__tapvpwrvgnd_1
* cell instance sky130_fd_sc_hd__tapvpwrvgnd_1_501 r0 *1 0,0
Xsky130_fd_sc_hd__tapvpwrvgnd_1_501
+ vss
+ vdd
+ sky130_fd_sc_hd__tapvpwrvgnd_1
* cell instance sky130_fd_sc_hd__tapvpwrvgnd_1_502 r0 *1 0,0
Xsky130_fd_sc_hd__tapvpwrvgnd_1_502
+ vss
+ vdd
+ sky130_fd_sc_hd__tapvpwrvgnd_1
* cell instance sky130_fd_sc_hd__tapvpwrvgnd_1_503 r0 *1 0,0
Xsky130_fd_sc_hd__tapvpwrvgnd_1_503
+ vss
+ vdd
+ sky130_fd_sc_hd__tapvpwrvgnd_1
* cell instance sky130_fd_sc_hd__tapvpwrvgnd_1_504 r0 *1 0,0
Xsky130_fd_sc_hd__tapvpwrvgnd_1_504
+ vss
+ vdd
+ sky130_fd_sc_hd__tapvpwrvgnd_1
* cell instance sky130_fd_sc_hd__tapvpwrvgnd_1_505 r0 *1 0,0
Xsky130_fd_sc_hd__tapvpwrvgnd_1_505
+ vss
+ vdd
+ sky130_fd_sc_hd__tapvpwrvgnd_1
* cell instance sky130_fd_sc_hd__tapvpwrvgnd_1_506 r0 *1 0,0
Xsky130_fd_sc_hd__tapvpwrvgnd_1_506
+ vss
+ vdd
+ sky130_fd_sc_hd__tapvpwrvgnd_1
* cell instance sky130_fd_sc_hd__tapvpwrvgnd_1_507 r0 *1 0,0
Xsky130_fd_sc_hd__tapvpwrvgnd_1_507
+ vss
+ vdd
+ sky130_fd_sc_hd__tapvpwrvgnd_1
* cell instance sky130_fd_sc_hd__tapvpwrvgnd_1_508 r0 *1 0,0
Xsky130_fd_sc_hd__tapvpwrvgnd_1_508
+ vss
+ vdd
+ sky130_fd_sc_hd__tapvpwrvgnd_1
* cell instance sky130_fd_sc_hd__tapvpwrvgnd_1_509 r0 *1 0,0
Xsky130_fd_sc_hd__tapvpwrvgnd_1_509
+ vss
+ vdd
+ sky130_fd_sc_hd__tapvpwrvgnd_1
* cell instance sky130_fd_sc_hd__tapvpwrvgnd_1_510 r0 *1 0,0
Xsky130_fd_sc_hd__tapvpwrvgnd_1_510
+ vss
+ vdd
+ sky130_fd_sc_hd__tapvpwrvgnd_1
* cell instance sky130_fd_sc_hd__tapvpwrvgnd_1_511 r0 *1 0,0
Xsky130_fd_sc_hd__tapvpwrvgnd_1_511
+ vss
+ vdd
+ sky130_fd_sc_hd__tapvpwrvgnd_1
* cell instance sky130_fd_sc_hd__tapvpwrvgnd_1_512 r0 *1 0,0
Xsky130_fd_sc_hd__tapvpwrvgnd_1_512
+ vss
+ vdd
+ sky130_fd_sc_hd__tapvpwrvgnd_1
* cell instance sky130_fd_sc_hd__tapvpwrvgnd_1_513 r0 *1 0,0
Xsky130_fd_sc_hd__tapvpwrvgnd_1_513
+ vss
+ vdd
+ sky130_fd_sc_hd__tapvpwrvgnd_1
* cell instance sky130_fd_sc_hd__tapvpwrvgnd_1_514 r0 *1 0,0
Xsky130_fd_sc_hd__tapvpwrvgnd_1_514
+ vss
+ vdd
+ sky130_fd_sc_hd__tapvpwrvgnd_1
* cell instance sky130_fd_sc_hd__tapvpwrvgnd_1_515 r0 *1 0,0
Xsky130_fd_sc_hd__tapvpwrvgnd_1_515
+ vss
+ vdd
+ sky130_fd_sc_hd__tapvpwrvgnd_1
* cell instance sky130_fd_sc_hd__tapvpwrvgnd_1_516 r0 *1 0,0
Xsky130_fd_sc_hd__tapvpwrvgnd_1_516
+ vss
+ vdd
+ sky130_fd_sc_hd__tapvpwrvgnd_1
* cell instance sky130_fd_sc_hd__tapvpwrvgnd_1_517 r0 *1 0,0
Xsky130_fd_sc_hd__tapvpwrvgnd_1_517
+ vss
+ vdd
+ sky130_fd_sc_hd__tapvpwrvgnd_1
* cell instance sky130_fd_sc_hd__tapvpwrvgnd_1_518 r0 *1 0,0
Xsky130_fd_sc_hd__tapvpwrvgnd_1_518
+ vss
+ vdd
+ sky130_fd_sc_hd__tapvpwrvgnd_1
* cell instance sky130_fd_sc_hd__tapvpwrvgnd_1_519 r0 *1 0,0
Xsky130_fd_sc_hd__tapvpwrvgnd_1_519
+ vss
+ vdd
+ sky130_fd_sc_hd__tapvpwrvgnd_1
* cell instance sky130_fd_sc_hd__tapvpwrvgnd_1_520 r0 *1 0,0
Xsky130_fd_sc_hd__tapvpwrvgnd_1_520
+ vss
+ vdd
+ sky130_fd_sc_hd__tapvpwrvgnd_1
* cell instance sky130_fd_sc_hd__tapvpwrvgnd_1_521 r0 *1 0,0
Xsky130_fd_sc_hd__tapvpwrvgnd_1_521
+ vss
+ vdd
+ sky130_fd_sc_hd__tapvpwrvgnd_1
* cell instance sky130_fd_sc_hd__tapvpwrvgnd_1_522 r0 *1 0,0
Xsky130_fd_sc_hd__tapvpwrvgnd_1_522
+ vss
+ vdd
+ sky130_fd_sc_hd__tapvpwrvgnd_1
* cell instance sky130_fd_sc_hd__tapvpwrvgnd_1_523 r0 *1 0,0
Xsky130_fd_sc_hd__tapvpwrvgnd_1_523
+ vss
+ vdd
+ sky130_fd_sc_hd__tapvpwrvgnd_1
* cell instance sky130_fd_sc_hd__tapvpwrvgnd_1_524 r0 *1 0,0
Xsky130_fd_sc_hd__tapvpwrvgnd_1_524
+ vss
+ vdd
+ sky130_fd_sc_hd__tapvpwrvgnd_1
* cell instance sky130_fd_sc_hd__tapvpwrvgnd_1_525 r0 *1 0,0
Xsky130_fd_sc_hd__tapvpwrvgnd_1_525
+ vss
+ vdd
+ sky130_fd_sc_hd__tapvpwrvgnd_1
* cell instance sky130_fd_sc_hd__tapvpwrvgnd_1_526 r0 *1 0,0
Xsky130_fd_sc_hd__tapvpwrvgnd_1_526
+ vss
+ vdd
+ sky130_fd_sc_hd__tapvpwrvgnd_1
* cell instance sky130_fd_sc_hd__tapvpwrvgnd_1_527 r0 *1 0,0
Xsky130_fd_sc_hd__tapvpwrvgnd_1_527
+ vss
+ vdd
+ sky130_fd_sc_hd__tapvpwrvgnd_1
* cell instance sky130_fd_sc_hd__tapvpwrvgnd_1_528 r0 *1 0,0
Xsky130_fd_sc_hd__tapvpwrvgnd_1_528
+ vss
+ vdd
+ sky130_fd_sc_hd__tapvpwrvgnd_1
* cell instance sky130_fd_sc_hd__tapvpwrvgnd_1_529 r0 *1 0,0
Xsky130_fd_sc_hd__tapvpwrvgnd_1_529
+ vss
+ vdd
+ sky130_fd_sc_hd__tapvpwrvgnd_1
* cell instance sky130_fd_sc_hd__tapvpwrvgnd_1_530 r0 *1 0,0
Xsky130_fd_sc_hd__tapvpwrvgnd_1_530
+ vss
+ vdd
+ sky130_fd_sc_hd__tapvpwrvgnd_1
* cell instance sky130_fd_sc_hd__tapvpwrvgnd_1_531 r0 *1 0,0
Xsky130_fd_sc_hd__tapvpwrvgnd_1_531
+ vss
+ vdd
+ sky130_fd_sc_hd__tapvpwrvgnd_1
* cell instance sky130_fd_sc_hd__tapvpwrvgnd_1_532 r0 *1 0,0
Xsky130_fd_sc_hd__tapvpwrvgnd_1_532
+ vss
+ vdd
+ sky130_fd_sc_hd__tapvpwrvgnd_1
* cell instance sky130_fd_sc_hd__tapvpwrvgnd_1_533 r0 *1 0,0
Xsky130_fd_sc_hd__tapvpwrvgnd_1_533
+ vss
+ vdd
+ sky130_fd_sc_hd__tapvpwrvgnd_1
* cell instance sky130_fd_sc_hd__tapvpwrvgnd_1_534 r0 *1 0,0
Xsky130_fd_sc_hd__tapvpwrvgnd_1_534
+ vss
+ vdd
+ sky130_fd_sc_hd__tapvpwrvgnd_1
* cell instance sky130_fd_sc_hd__tapvpwrvgnd_1_535 r0 *1 0,0
Xsky130_fd_sc_hd__tapvpwrvgnd_1_535
+ vss
+ vdd
+ sky130_fd_sc_hd__tapvpwrvgnd_1
* cell instance sky130_fd_sc_hd__tapvpwrvgnd_1_536 r0 *1 0,0
Xsky130_fd_sc_hd__tapvpwrvgnd_1_536
+ vss
+ vdd
+ sky130_fd_sc_hd__tapvpwrvgnd_1
* cell instance sky130_fd_sc_hd__tapvpwrvgnd_1_537 r0 *1 0,0
Xsky130_fd_sc_hd__tapvpwrvgnd_1_537
+ vss
+ vdd
+ sky130_fd_sc_hd__tapvpwrvgnd_1
* cell instance sky130_fd_sc_hd__tapvpwrvgnd_1_538 r0 *1 0,0
Xsky130_fd_sc_hd__tapvpwrvgnd_1_538
+ vss
+ vdd
+ sky130_fd_sc_hd__tapvpwrvgnd_1
* cell instance sky130_fd_sc_hd__tapvpwrvgnd_1_539 r0 *1 0,0
Xsky130_fd_sc_hd__tapvpwrvgnd_1_539
+ vss
+ vdd
+ sky130_fd_sc_hd__tapvpwrvgnd_1
* cell instance sky130_fd_sc_hd__tapvpwrvgnd_1_540 r0 *1 0,0
Xsky130_fd_sc_hd__tapvpwrvgnd_1_540
+ vss
+ vdd
+ sky130_fd_sc_hd__tapvpwrvgnd_1
* cell instance sky130_fd_sc_hd__tapvpwrvgnd_1_541 r0 *1 0,0
Xsky130_fd_sc_hd__tapvpwrvgnd_1_541
+ vss
+ vdd
+ sky130_fd_sc_hd__tapvpwrvgnd_1
* cell instance sky130_fd_sc_hd__tapvpwrvgnd_1_542 r0 *1 0,0
Xsky130_fd_sc_hd__tapvpwrvgnd_1_542
+ vss
+ vdd
+ sky130_fd_sc_hd__tapvpwrvgnd_1
* cell instance sky130_fd_sc_hd__tapvpwrvgnd_1_543 r0 *1 0,0
Xsky130_fd_sc_hd__tapvpwrvgnd_1_543
+ vss
+ vdd
+ sky130_fd_sc_hd__tapvpwrvgnd_1
* cell instance sky130_fd_sc_hd__tapvpwrvgnd_1_544 r0 *1 0,0
Xsky130_fd_sc_hd__tapvpwrvgnd_1_544
+ vss
+ vdd
+ sky130_fd_sc_hd__tapvpwrvgnd_1
* cell instance sky130_fd_sc_hd__tapvpwrvgnd_1_545 r0 *1 0,0
Xsky130_fd_sc_hd__tapvpwrvgnd_1_545
+ vss
+ vdd
+ sky130_fd_sc_hd__tapvpwrvgnd_1
* cell instance sky130_fd_sc_hd__tapvpwrvgnd_1_546 r0 *1 0,0
Xsky130_fd_sc_hd__tapvpwrvgnd_1_546
+ vss
+ vdd
+ sky130_fd_sc_hd__tapvpwrvgnd_1
* cell instance sky130_fd_sc_hd__tapvpwrvgnd_1_547 r0 *1 0,0
Xsky130_fd_sc_hd__tapvpwrvgnd_1_547
+ vss
+ vdd
+ sky130_fd_sc_hd__tapvpwrvgnd_1
* cell instance sky130_fd_sc_hd__tapvpwrvgnd_1_548 r0 *1 0,0
Xsky130_fd_sc_hd__tapvpwrvgnd_1_548
+ vss
+ vdd
+ sky130_fd_sc_hd__tapvpwrvgnd_1
* cell instance sky130_fd_sc_hd__tapvpwrvgnd_1_549 r0 *1 0,0
Xsky130_fd_sc_hd__tapvpwrvgnd_1_549
+ vss
+ vdd
+ sky130_fd_sc_hd__tapvpwrvgnd_1
* cell instance sky130_fd_sc_hd__tapvpwrvgnd_1_550 r0 *1 0,0
Xsky130_fd_sc_hd__tapvpwrvgnd_1_550
+ vss
+ vdd
+ sky130_fd_sc_hd__tapvpwrvgnd_1
* cell instance sky130_fd_sc_hd__tapvpwrvgnd_1_551 r0 *1 0,0
Xsky130_fd_sc_hd__tapvpwrvgnd_1_551
+ vss
+ vdd
+ sky130_fd_sc_hd__tapvpwrvgnd_1
* cell instance sky130_fd_sc_hd__tapvpwrvgnd_1_552 r0 *1 0,0
Xsky130_fd_sc_hd__tapvpwrvgnd_1_552
+ vss
+ vdd
+ sky130_fd_sc_hd__tapvpwrvgnd_1
* cell instance sky130_fd_sc_hd__tapvpwrvgnd_1_553 r0 *1 0,0
Xsky130_fd_sc_hd__tapvpwrvgnd_1_553
+ vss
+ vdd
+ sky130_fd_sc_hd__tapvpwrvgnd_1
* cell instance sky130_fd_sc_hd__tapvpwrvgnd_1_554 r0 *1 0,0
Xsky130_fd_sc_hd__tapvpwrvgnd_1_554
+ vss
+ vdd
+ sky130_fd_sc_hd__tapvpwrvgnd_1
* cell instance sky130_fd_sc_hd__tapvpwrvgnd_1_555 r0 *1 0,0
Xsky130_fd_sc_hd__tapvpwrvgnd_1_555
+ vss
+ vdd
+ sky130_fd_sc_hd__tapvpwrvgnd_1
* cell instance sky130_fd_sc_hd__tapvpwrvgnd_1_556 r0 *1 0,0
Xsky130_fd_sc_hd__tapvpwrvgnd_1_556
+ vss
+ vdd
+ sky130_fd_sc_hd__tapvpwrvgnd_1
* cell instance sky130_fd_sc_hd__tapvpwrvgnd_1_557 r0 *1 0,0
Xsky130_fd_sc_hd__tapvpwrvgnd_1_557
+ vss
+ vdd
+ sky130_fd_sc_hd__tapvpwrvgnd_1
* cell instance sky130_fd_sc_hd__tapvpwrvgnd_1_558 r0 *1 0,0
Xsky130_fd_sc_hd__tapvpwrvgnd_1_558
+ vss
+ vdd
+ sky130_fd_sc_hd__tapvpwrvgnd_1
* cell instance sky130_fd_sc_hd__tapvpwrvgnd_1_559 r0 *1 0,0
Xsky130_fd_sc_hd__tapvpwrvgnd_1_559
+ vss
+ vdd
+ sky130_fd_sc_hd__tapvpwrvgnd_1
* cell instance sky130_fd_sc_hd__tapvpwrvgnd_1_560 r0 *1 0,0
Xsky130_fd_sc_hd__tapvpwrvgnd_1_560
+ vss
+ vdd
+ sky130_fd_sc_hd__tapvpwrvgnd_1
* cell instance sky130_fd_sc_hd__tapvpwrvgnd_1_561 r0 *1 0,0
Xsky130_fd_sc_hd__tapvpwrvgnd_1_561
+ vss
+ vdd
+ sky130_fd_sc_hd__tapvpwrvgnd_1
* cell instance sky130_fd_sc_hd__tapvpwrvgnd_1_562 r0 *1 0,0
Xsky130_fd_sc_hd__tapvpwrvgnd_1_562
+ vss
+ vdd
+ sky130_fd_sc_hd__tapvpwrvgnd_1
* cell instance sky130_fd_sc_hd__tapvpwrvgnd_1_563 r0 *1 0,0
Xsky130_fd_sc_hd__tapvpwrvgnd_1_563
+ vss
+ vdd
+ sky130_fd_sc_hd__tapvpwrvgnd_1
* cell instance sky130_fd_sc_hd__tapvpwrvgnd_1_564 r0 *1 0,0
Xsky130_fd_sc_hd__tapvpwrvgnd_1_564
+ vss
+ vdd
+ sky130_fd_sc_hd__tapvpwrvgnd_1
* cell instance sky130_fd_sc_hd__tapvpwrvgnd_1_565 r0 *1 0,0
Xsky130_fd_sc_hd__tapvpwrvgnd_1_565
+ vss
+ vdd
+ sky130_fd_sc_hd__tapvpwrvgnd_1
* cell instance sky130_fd_sc_hd__tapvpwrvgnd_1_566 r0 *1 0,0
Xsky130_fd_sc_hd__tapvpwrvgnd_1_566
+ vss
+ vdd
+ sky130_fd_sc_hd__tapvpwrvgnd_1
* cell instance sky130_fd_sc_hd__tapvpwrvgnd_1_567 r0 *1 0,0
Xsky130_fd_sc_hd__tapvpwrvgnd_1_567
+ vss
+ vdd
+ sky130_fd_sc_hd__tapvpwrvgnd_1
* cell instance sky130_fd_sc_hd__tapvpwrvgnd_1_568 r0 *1 0,0
Xsky130_fd_sc_hd__tapvpwrvgnd_1_568
+ vss
+ vdd
+ sky130_fd_sc_hd__tapvpwrvgnd_1
* cell instance sky130_fd_sc_hd__tapvpwrvgnd_1_569 r0 *1 0,0
Xsky130_fd_sc_hd__tapvpwrvgnd_1_569
+ vss
+ vdd
+ sky130_fd_sc_hd__tapvpwrvgnd_1
* cell instance sky130_fd_sc_hd__tapvpwrvgnd_1_570 r0 *1 0,0
Xsky130_fd_sc_hd__tapvpwrvgnd_1_570
+ vss
+ vdd
+ sky130_fd_sc_hd__tapvpwrvgnd_1
* cell instance sky130_fd_sc_hd__tapvpwrvgnd_1_571 r0 *1 0,0
Xsky130_fd_sc_hd__tapvpwrvgnd_1_571
+ vss
+ vdd
+ sky130_fd_sc_hd__tapvpwrvgnd_1
* cell instance sky130_fd_sc_hd__tapvpwrvgnd_1_572 r0 *1 0,0
Xsky130_fd_sc_hd__tapvpwrvgnd_1_572
+ vss
+ vdd
+ sky130_fd_sc_hd__tapvpwrvgnd_1
* cell instance sky130_fd_sc_hd__tapvpwrvgnd_1_573 r0 *1 0,0
Xsky130_fd_sc_hd__tapvpwrvgnd_1_573
+ vss
+ vdd
+ sky130_fd_sc_hd__tapvpwrvgnd_1
* cell instance sky130_fd_sc_hd__tapvpwrvgnd_1_574 r0 *1 0,0
Xsky130_fd_sc_hd__tapvpwrvgnd_1_574
+ vss
+ vdd
+ sky130_fd_sc_hd__tapvpwrvgnd_1
* cell instance sky130_fd_sc_hd__tapvpwrvgnd_1_575 r0 *1 0,0
Xsky130_fd_sc_hd__tapvpwrvgnd_1_575
+ vss
+ vdd
+ sky130_fd_sc_hd__tapvpwrvgnd_1
* cell instance sky130_fd_sc_hd__tapvpwrvgnd_1_576 r0 *1 0,0
Xsky130_fd_sc_hd__tapvpwrvgnd_1_576
+ vss
+ vdd
+ sky130_fd_sc_hd__tapvpwrvgnd_1
* cell instance sky130_fd_sc_hd__tapvpwrvgnd_1_577 r0 *1 0,0
Xsky130_fd_sc_hd__tapvpwrvgnd_1_577
+ vss
+ vdd
+ sky130_fd_sc_hd__tapvpwrvgnd_1
* cell instance sky130_fd_sc_hd__tapvpwrvgnd_1_578 r0 *1 0,0
Xsky130_fd_sc_hd__tapvpwrvgnd_1_578
+ vss
+ vdd
+ sky130_fd_sc_hd__tapvpwrvgnd_1
* cell instance sky130_fd_sc_hd__tapvpwrvgnd_1_579 r0 *1 0,0
Xsky130_fd_sc_hd__tapvpwrvgnd_1_579
+ vss
+ vdd
+ sky130_fd_sc_hd__tapvpwrvgnd_1
* cell instance sky130_fd_sc_hd__tapvpwrvgnd_1_580 r0 *1 0,0
Xsky130_fd_sc_hd__tapvpwrvgnd_1_580
+ vss
+ vdd
+ sky130_fd_sc_hd__tapvpwrvgnd_1
* cell instance sky130_fd_sc_hd__tapvpwrvgnd_1_581 r0 *1 0,0
Xsky130_fd_sc_hd__tapvpwrvgnd_1_581
+ vss
+ vdd
+ sky130_fd_sc_hd__tapvpwrvgnd_1
* cell instance sky130_fd_sc_hd__tapvpwrvgnd_1_582 r0 *1 0,0
Xsky130_fd_sc_hd__tapvpwrvgnd_1_582
+ vss
+ vdd
+ sky130_fd_sc_hd__tapvpwrvgnd_1
* cell instance sky130_fd_sc_hd__tapvpwrvgnd_1_583 r0 *1 0,0
Xsky130_fd_sc_hd__tapvpwrvgnd_1_583
+ vss
+ vdd
+ sky130_fd_sc_hd__tapvpwrvgnd_1
* cell instance sky130_fd_sc_hd__tapvpwrvgnd_1_584 r0 *1 0,0
Xsky130_fd_sc_hd__tapvpwrvgnd_1_584
+ vss
+ vdd
+ sky130_fd_sc_hd__tapvpwrvgnd_1
* cell instance sky130_fd_sc_hd__tapvpwrvgnd_1_585 r0 *1 0,0
Xsky130_fd_sc_hd__tapvpwrvgnd_1_585
+ vss
+ vdd
+ sky130_fd_sc_hd__tapvpwrvgnd_1
* cell instance sky130_fd_sc_hd__tapvpwrvgnd_1_586 r0 *1 0,0
Xsky130_fd_sc_hd__tapvpwrvgnd_1_586
+ vss
+ vdd
+ sky130_fd_sc_hd__tapvpwrvgnd_1
* cell instance sky130_fd_sc_hd__tapvpwrvgnd_1_587 r0 *1 0,0
Xsky130_fd_sc_hd__tapvpwrvgnd_1_587
+ vss
+ vdd
+ sky130_fd_sc_hd__tapvpwrvgnd_1
* cell instance sky130_fd_sc_hd__tapvpwrvgnd_1_588 r0 *1 0,0
Xsky130_fd_sc_hd__tapvpwrvgnd_1_588
+ vss
+ vdd
+ sky130_fd_sc_hd__tapvpwrvgnd_1
* cell instance sky130_fd_sc_hd__tapvpwrvgnd_1_589 r0 *1 0,0
Xsky130_fd_sc_hd__tapvpwrvgnd_1_589
+ vss
+ vdd
+ sky130_fd_sc_hd__tapvpwrvgnd_1
* cell instance sky130_fd_sc_hd__tapvpwrvgnd_1_590 r0 *1 0,0
Xsky130_fd_sc_hd__tapvpwrvgnd_1_590
+ vss
+ vdd
+ sky130_fd_sc_hd__tapvpwrvgnd_1
* cell instance sky130_fd_sc_hd__tapvpwrvgnd_1_591 r0 *1 0,0
Xsky130_fd_sc_hd__tapvpwrvgnd_1_591
+ vss
+ vdd
+ sky130_fd_sc_hd__tapvpwrvgnd_1
* cell instance sky130_fd_sc_hd__tapvpwrvgnd_1_592 r0 *1 0,0
Xsky130_fd_sc_hd__tapvpwrvgnd_1_592
+ vss
+ vdd
+ sky130_fd_sc_hd__tapvpwrvgnd_1
* cell instance sky130_fd_sc_hd__tapvpwrvgnd_1_593 r0 *1 0,0
Xsky130_fd_sc_hd__tapvpwrvgnd_1_593
+ vss
+ vdd
+ sky130_fd_sc_hd__tapvpwrvgnd_1
* cell instance sky130_fd_sc_hd__tapvpwrvgnd_1_594 r0 *1 0,0
Xsky130_fd_sc_hd__tapvpwrvgnd_1_594
+ vss
+ vdd
+ sky130_fd_sc_hd__tapvpwrvgnd_1
* cell instance sky130_fd_sc_hd__tapvpwrvgnd_1_595 r0 *1 0,0
Xsky130_fd_sc_hd__tapvpwrvgnd_1_595
+ vss
+ vdd
+ sky130_fd_sc_hd__tapvpwrvgnd_1
* cell instance sky130_fd_sc_hd__tapvpwrvgnd_1_596 r0 *1 0,0
Xsky130_fd_sc_hd__tapvpwrvgnd_1_596
+ vss
+ vdd
+ sky130_fd_sc_hd__tapvpwrvgnd_1
* cell instance sky130_fd_sc_hd__tapvpwrvgnd_1_597 r0 *1 0,0
Xsky130_fd_sc_hd__tapvpwrvgnd_1_597
+ vss
+ vdd
+ sky130_fd_sc_hd__tapvpwrvgnd_1
* cell instance sky130_fd_sc_hd__tapvpwrvgnd_1_598 r0 *1 0,0
Xsky130_fd_sc_hd__tapvpwrvgnd_1_598
+ vss
+ vdd
+ sky130_fd_sc_hd__tapvpwrvgnd_1
* cell instance sky130_fd_sc_hd__tapvpwrvgnd_1_599 r0 *1 0,0
Xsky130_fd_sc_hd__tapvpwrvgnd_1_599
+ vss
+ vdd
+ sky130_fd_sc_hd__tapvpwrvgnd_1
* cell instance sky130_fd_sc_hd__tapvpwrvgnd_1_600 r0 *1 0,0
Xsky130_fd_sc_hd__tapvpwrvgnd_1_600
+ vss
+ vdd
+ sky130_fd_sc_hd__tapvpwrvgnd_1
* cell instance sky130_fd_sc_hd__tapvpwrvgnd_1_601 r0 *1 0,0
Xsky130_fd_sc_hd__tapvpwrvgnd_1_601
+ vss
+ vdd
+ sky130_fd_sc_hd__tapvpwrvgnd_1
* cell instance sky130_fd_sc_hd__tapvpwrvgnd_1_602 r0 *1 0,0
Xsky130_fd_sc_hd__tapvpwrvgnd_1_602
+ vss
+ vdd
+ sky130_fd_sc_hd__tapvpwrvgnd_1
* cell instance sky130_fd_sc_hd__tapvpwrvgnd_1_603 r0 *1 0,0
Xsky130_fd_sc_hd__tapvpwrvgnd_1_603
+ vss
+ vdd
+ sky130_fd_sc_hd__tapvpwrvgnd_1
* cell instance sky130_fd_sc_hd__tapvpwrvgnd_1_604 r0 *1 0,0
Xsky130_fd_sc_hd__tapvpwrvgnd_1_604
+ vss
+ vdd
+ sky130_fd_sc_hd__tapvpwrvgnd_1
* cell instance sky130_fd_sc_hd__tapvpwrvgnd_1_605 r0 *1 0,0
Xsky130_fd_sc_hd__tapvpwrvgnd_1_605
+ vss
+ vdd
+ sky130_fd_sc_hd__tapvpwrvgnd_1
* cell instance sky130_fd_sc_hd__tapvpwrvgnd_1_606 r0 *1 0,0
Xsky130_fd_sc_hd__tapvpwrvgnd_1_606
+ vss
+ vdd
+ sky130_fd_sc_hd__tapvpwrvgnd_1
* cell instance sky130_fd_sc_hd__tapvpwrvgnd_1_607 r0 *1 0,0
Xsky130_fd_sc_hd__tapvpwrvgnd_1_607
+ vss
+ vdd
+ sky130_fd_sc_hd__tapvpwrvgnd_1
* cell instance sky130_fd_sc_hd__tapvpwrvgnd_1_608 r0 *1 0,0
Xsky130_fd_sc_hd__tapvpwrvgnd_1_608
+ vss
+ vdd
+ sky130_fd_sc_hd__tapvpwrvgnd_1
* cell instance sky130_fd_sc_hd__tapvpwrvgnd_1_609 r0 *1 0,0
Xsky130_fd_sc_hd__tapvpwrvgnd_1_609
+ vss
+ vdd
+ sky130_fd_sc_hd__tapvpwrvgnd_1
* cell instance sky130_fd_sc_hd__tapvpwrvgnd_1_610 r0 *1 0,0
Xsky130_fd_sc_hd__tapvpwrvgnd_1_610
+ vss
+ vdd
+ sky130_fd_sc_hd__tapvpwrvgnd_1
* cell instance sky130_fd_sc_hd__tapvpwrvgnd_1_611 r0 *1 0,0
Xsky130_fd_sc_hd__tapvpwrvgnd_1_611
+ vss
+ vdd
+ sky130_fd_sc_hd__tapvpwrvgnd_1
* cell instance sky130_fd_sc_hd__tapvpwrvgnd_1_612 r0 *1 0,0
Xsky130_fd_sc_hd__tapvpwrvgnd_1_612
+ vss
+ vdd
+ sky130_fd_sc_hd__tapvpwrvgnd_1
* cell instance sky130_fd_sc_hd__tapvpwrvgnd_1_613 r0 *1 0,0
Xsky130_fd_sc_hd__tapvpwrvgnd_1_613
+ vss
+ vdd
+ sky130_fd_sc_hd__tapvpwrvgnd_1
* cell instance sky130_fd_sc_hd__tapvpwrvgnd_1_614 r0 *1 0,0
Xsky130_fd_sc_hd__tapvpwrvgnd_1_614
+ vss
+ vdd
+ sky130_fd_sc_hd__tapvpwrvgnd_1
* cell instance sky130_fd_sc_hd__tapvpwrvgnd_1_615 r0 *1 0,0
Xsky130_fd_sc_hd__tapvpwrvgnd_1_615
+ vss
+ vdd
+ sky130_fd_sc_hd__tapvpwrvgnd_1
* cell instance sky130_fd_sc_hd__tapvpwrvgnd_1_616 r0 *1 0,0
Xsky130_fd_sc_hd__tapvpwrvgnd_1_616
+ vss
+ vdd
+ sky130_fd_sc_hd__tapvpwrvgnd_1
* cell instance sky130_fd_sc_hd__tapvpwrvgnd_1_617 r0 *1 0,0
Xsky130_fd_sc_hd__tapvpwrvgnd_1_617
+ vss
+ vdd
+ sky130_fd_sc_hd__tapvpwrvgnd_1
* cell instance sky130_fd_sc_hd__tapvpwrvgnd_1_618 r0 *1 0,0
Xsky130_fd_sc_hd__tapvpwrvgnd_1_618
+ vss
+ vdd
+ sky130_fd_sc_hd__tapvpwrvgnd_1
* cell instance sky130_fd_sc_hd__tapvpwrvgnd_1_619 r0 *1 0,0
Xsky130_fd_sc_hd__tapvpwrvgnd_1_619
+ vss
+ vdd
+ sky130_fd_sc_hd__tapvpwrvgnd_1
* cell instance sky130_fd_sc_hd__tapvpwrvgnd_1_620 r0 *1 0,0
Xsky130_fd_sc_hd__tapvpwrvgnd_1_620
+ vss
+ vdd
+ sky130_fd_sc_hd__tapvpwrvgnd_1
* cell instance sky130_fd_sc_hd__tapvpwrvgnd_1_621 r0 *1 0,0
Xsky130_fd_sc_hd__tapvpwrvgnd_1_621
+ vss
+ vdd
+ sky130_fd_sc_hd__tapvpwrvgnd_1
* cell instance sky130_fd_sc_hd__tapvpwrvgnd_1_622 r0 *1 0,0
Xsky130_fd_sc_hd__tapvpwrvgnd_1_622
+ vss
+ vdd
+ sky130_fd_sc_hd__tapvpwrvgnd_1
* cell instance sky130_fd_sc_hd__tapvpwrvgnd_1_623 r0 *1 0,0
Xsky130_fd_sc_hd__tapvpwrvgnd_1_623
+ vss
+ vdd
+ sky130_fd_sc_hd__tapvpwrvgnd_1
* cell instance sky130_fd_sc_hd__tapvpwrvgnd_1_624 r0 *1 0,0
Xsky130_fd_sc_hd__tapvpwrvgnd_1_624
+ vss
+ vdd
+ sky130_fd_sc_hd__tapvpwrvgnd_1
* cell instance sky130_fd_sc_hd__tapvpwrvgnd_1_625 r0 *1 0,0
Xsky130_fd_sc_hd__tapvpwrvgnd_1_625
+ vss
+ vdd
+ sky130_fd_sc_hd__tapvpwrvgnd_1
* cell instance sky130_fd_sc_hd__tapvpwrvgnd_1_626 r0 *1 0,0
Xsky130_fd_sc_hd__tapvpwrvgnd_1_626
+ vss
+ vdd
+ sky130_fd_sc_hd__tapvpwrvgnd_1
* cell instance sky130_fd_sc_hd__tapvpwrvgnd_1_627 r0 *1 0,0
Xsky130_fd_sc_hd__tapvpwrvgnd_1_627
+ vss
+ vdd
+ sky130_fd_sc_hd__tapvpwrvgnd_1
* cell instance sky130_fd_sc_hd__tapvpwrvgnd_1_628 r0 *1 0,0
Xsky130_fd_sc_hd__tapvpwrvgnd_1_628
+ vss
+ vdd
+ sky130_fd_sc_hd__tapvpwrvgnd_1
* cell instance sky130_fd_sc_hd__tapvpwrvgnd_1_629 r0 *1 0,0
Xsky130_fd_sc_hd__tapvpwrvgnd_1_629
+ vss
+ vdd
+ sky130_fd_sc_hd__tapvpwrvgnd_1
* cell instance sky130_fd_sc_hd__tapvpwrvgnd_1_630 r0 *1 0,0
Xsky130_fd_sc_hd__tapvpwrvgnd_1_630
+ vss
+ vdd
+ sky130_fd_sc_hd__tapvpwrvgnd_1
* cell instance sky130_fd_sc_hd__tapvpwrvgnd_1_631 r0 *1 0,0
Xsky130_fd_sc_hd__tapvpwrvgnd_1_631
+ vss
+ vdd
+ sky130_fd_sc_hd__tapvpwrvgnd_1
* cell instance sky130_fd_sc_hd__tapvpwrvgnd_1_632 r0 *1 0,0
Xsky130_fd_sc_hd__tapvpwrvgnd_1_632
+ vss
+ vdd
+ sky130_fd_sc_hd__tapvpwrvgnd_1
* cell instance sky130_fd_sc_hd__tapvpwrvgnd_1_633 r0 *1 0,0
Xsky130_fd_sc_hd__tapvpwrvgnd_1_633
+ vss
+ vdd
+ sky130_fd_sc_hd__tapvpwrvgnd_1
* cell instance sky130_fd_sc_hd__tapvpwrvgnd_1_634 r0 *1 0,0
Xsky130_fd_sc_hd__tapvpwrvgnd_1_634
+ vss
+ vdd
+ sky130_fd_sc_hd__tapvpwrvgnd_1
* cell instance sky130_fd_sc_hd__tapvpwrvgnd_1_635 r0 *1 0,0
Xsky130_fd_sc_hd__tapvpwrvgnd_1_635
+ vss
+ vdd
+ sky130_fd_sc_hd__tapvpwrvgnd_1
* cell instance sky130_fd_sc_hd__tapvpwrvgnd_1_636 r0 *1 0,0
Xsky130_fd_sc_hd__tapvpwrvgnd_1_636
+ vss
+ vdd
+ sky130_fd_sc_hd__tapvpwrvgnd_1
* cell instance sky130_fd_sc_hd__tapvpwrvgnd_1_637 r0 *1 0,0
Xsky130_fd_sc_hd__tapvpwrvgnd_1_637
+ vss
+ vdd
+ sky130_fd_sc_hd__tapvpwrvgnd_1
* cell instance sky130_fd_sc_hd__tapvpwrvgnd_1_638 r0 *1 0,0
Xsky130_fd_sc_hd__tapvpwrvgnd_1_638
+ vss
+ vdd
+ sky130_fd_sc_hd__tapvpwrvgnd_1
* cell instance sky130_fd_sc_hd__tapvpwrvgnd_1_639 r0 *1 0,0
Xsky130_fd_sc_hd__tapvpwrvgnd_1_639
+ vss
+ vdd
+ sky130_fd_sc_hd__tapvpwrvgnd_1
* cell instance sky130_fd_sc_hd__tapvpwrvgnd_1_640 r0 *1 0,0
Xsky130_fd_sc_hd__tapvpwrvgnd_1_640
+ vss
+ vdd
+ sky130_fd_sc_hd__tapvpwrvgnd_1
* cell instance sky130_fd_sc_hd__tapvpwrvgnd_1_641 r0 *1 0,0
Xsky130_fd_sc_hd__tapvpwrvgnd_1_641
+ vss
+ vdd
+ sky130_fd_sc_hd__tapvpwrvgnd_1
* cell instance sky130_fd_sc_hd__tapvpwrvgnd_1_642 r0 *1 0,0
Xsky130_fd_sc_hd__tapvpwrvgnd_1_642
+ vss
+ vdd
+ sky130_fd_sc_hd__tapvpwrvgnd_1
* cell instance sky130_fd_sc_hd__tapvpwrvgnd_1_643 r0 *1 0,0
Xsky130_fd_sc_hd__tapvpwrvgnd_1_643
+ vss
+ vdd
+ sky130_fd_sc_hd__tapvpwrvgnd_1
* cell instance sky130_fd_sc_hd__tapvpwrvgnd_1_644 r0 *1 0,0
Xsky130_fd_sc_hd__tapvpwrvgnd_1_644
+ vss
+ vdd
+ sky130_fd_sc_hd__tapvpwrvgnd_1
* cell instance sky130_fd_sc_hd__tapvpwrvgnd_1_645 r0 *1 0,0
Xsky130_fd_sc_hd__tapvpwrvgnd_1_645
+ vss
+ vdd
+ sky130_fd_sc_hd__tapvpwrvgnd_1
* cell instance sky130_fd_sc_hd__tapvpwrvgnd_1_646 r0 *1 0,0
Xsky130_fd_sc_hd__tapvpwrvgnd_1_646
+ vss
+ vdd
+ sky130_fd_sc_hd__tapvpwrvgnd_1
* cell instance sky130_fd_sc_hd__tapvpwrvgnd_1_647 r0 *1 0,0
Xsky130_fd_sc_hd__tapvpwrvgnd_1_647
+ vss
+ vdd
+ sky130_fd_sc_hd__tapvpwrvgnd_1
* cell instance sky130_fd_sc_hd__tapvpwrvgnd_1_648 r0 *1 0,0
Xsky130_fd_sc_hd__tapvpwrvgnd_1_648
+ vss
+ vdd
+ sky130_fd_sc_hd__tapvpwrvgnd_1
* cell instance sky130_fd_sc_hd__tapvpwrvgnd_1_649 r0 *1 0,0
Xsky130_fd_sc_hd__tapvpwrvgnd_1_649
+ vss
+ vdd
+ sky130_fd_sc_hd__tapvpwrvgnd_1
* cell instance sky130_fd_sc_hd__tapvpwrvgnd_1_650 r0 *1 0,0
Xsky130_fd_sc_hd__tapvpwrvgnd_1_650
+ vss
+ vdd
+ sky130_fd_sc_hd__tapvpwrvgnd_1
* cell instance sky130_fd_sc_hd__tapvpwrvgnd_1_651 r0 *1 0,0
Xsky130_fd_sc_hd__tapvpwrvgnd_1_651
+ vss
+ vdd
+ sky130_fd_sc_hd__tapvpwrvgnd_1
* cell instance sky130_fd_sc_hd__tapvpwrvgnd_1_652 r0 *1 0,0
Xsky130_fd_sc_hd__tapvpwrvgnd_1_652
+ vss
+ vdd
+ sky130_fd_sc_hd__tapvpwrvgnd_1
* cell instance sky130_fd_sc_hd__tapvpwrvgnd_1_653 r0 *1 0,0
Xsky130_fd_sc_hd__tapvpwrvgnd_1_653
+ vss
+ vdd
+ sky130_fd_sc_hd__tapvpwrvgnd_1
* cell instance sky130_fd_sc_hd__tapvpwrvgnd_1_654 r0 *1 0,0
Xsky130_fd_sc_hd__tapvpwrvgnd_1_654
+ vss
+ vdd
+ sky130_fd_sc_hd__tapvpwrvgnd_1
* cell instance sky130_fd_sc_hd__tapvpwrvgnd_1_655 r0 *1 0,0
Xsky130_fd_sc_hd__tapvpwrvgnd_1_655
+ vss
+ vdd
+ sky130_fd_sc_hd__tapvpwrvgnd_1
* cell instance sky130_fd_sc_hd__tapvpwrvgnd_1_656 r0 *1 0,0
Xsky130_fd_sc_hd__tapvpwrvgnd_1_656
+ vss
+ vdd
+ sky130_fd_sc_hd__tapvpwrvgnd_1
* cell instance sky130_fd_sc_hd__tapvpwrvgnd_1_657 r0 *1 0,0
Xsky130_fd_sc_hd__tapvpwrvgnd_1_657
+ vss
+ vdd
+ sky130_fd_sc_hd__tapvpwrvgnd_1
* cell instance sky130_fd_sc_hd__tapvpwrvgnd_1_658 r0 *1 0,0
Xsky130_fd_sc_hd__tapvpwrvgnd_1_658
+ vss
+ vdd
+ sky130_fd_sc_hd__tapvpwrvgnd_1
* cell instance sky130_fd_sc_hd__tapvpwrvgnd_1_659 r0 *1 0,0
Xsky130_fd_sc_hd__tapvpwrvgnd_1_659
+ vss
+ vdd
+ sky130_fd_sc_hd__tapvpwrvgnd_1
* cell instance sky130_fd_sc_hd__tapvpwrvgnd_1_660 r0 *1 0,0
Xsky130_fd_sc_hd__tapvpwrvgnd_1_660
+ vss
+ vdd
+ sky130_fd_sc_hd__tapvpwrvgnd_1
* cell instance sky130_fd_sc_hd__tapvpwrvgnd_1_661 r0 *1 0,0
Xsky130_fd_sc_hd__tapvpwrvgnd_1_661
+ vss
+ vdd
+ sky130_fd_sc_hd__tapvpwrvgnd_1
* cell instance sky130_fd_sc_hd__tapvpwrvgnd_1_662 r0 *1 0,0
Xsky130_fd_sc_hd__tapvpwrvgnd_1_662
+ vss
+ vdd
+ sky130_fd_sc_hd__tapvpwrvgnd_1
* cell instance sky130_fd_sc_hd__tapvpwrvgnd_1_663 r0 *1 0,0
Xsky130_fd_sc_hd__tapvpwrvgnd_1_663
+ vss
+ vdd
+ sky130_fd_sc_hd__tapvpwrvgnd_1
* cell instance sky130_fd_sc_hd__tapvpwrvgnd_1_664 r0 *1 0,0
Xsky130_fd_sc_hd__tapvpwrvgnd_1_664
+ vss
+ vdd
+ sky130_fd_sc_hd__tapvpwrvgnd_1
* cell instance sky130_fd_sc_hd__tapvpwrvgnd_1_665 r0 *1 0,0
Xsky130_fd_sc_hd__tapvpwrvgnd_1_665
+ vss
+ vdd
+ sky130_fd_sc_hd__tapvpwrvgnd_1
* cell instance sky130_fd_sc_hd__tapvpwrvgnd_1_666 r0 *1 0,0
Xsky130_fd_sc_hd__tapvpwrvgnd_1_666
+ vss
+ vdd
+ sky130_fd_sc_hd__tapvpwrvgnd_1
* cell instance sky130_fd_sc_hd__tapvpwrvgnd_1_667 r0 *1 0,0
Xsky130_fd_sc_hd__tapvpwrvgnd_1_667
+ vss
+ vdd
+ sky130_fd_sc_hd__tapvpwrvgnd_1
* cell instance sky130_fd_sc_hd__tapvpwrvgnd_1_668 r0 *1 0,0
Xsky130_fd_sc_hd__tapvpwrvgnd_1_668
+ vss
+ vdd
+ sky130_fd_sc_hd__tapvpwrvgnd_1
* cell instance sky130_fd_sc_hd__tapvpwrvgnd_1_669 r0 *1 0,0
Xsky130_fd_sc_hd__tapvpwrvgnd_1_669
+ vss
+ vdd
+ sky130_fd_sc_hd__tapvpwrvgnd_1
* cell instance sky130_fd_sc_hd__tapvpwrvgnd_1_670 r0 *1 0,0
Xsky130_fd_sc_hd__tapvpwrvgnd_1_670
+ vss
+ vdd
+ sky130_fd_sc_hd__tapvpwrvgnd_1
* cell instance sky130_fd_sc_hd__tapvpwrvgnd_1_671 r0 *1 0,0
Xsky130_fd_sc_hd__tapvpwrvgnd_1_671
+ vss
+ vdd
+ sky130_fd_sc_hd__tapvpwrvgnd_1
* cell instance sky130_fd_sc_hd__tapvpwrvgnd_1_672 r0 *1 0,0
Xsky130_fd_sc_hd__tapvpwrvgnd_1_672
+ vss
+ vdd
+ sky130_fd_sc_hd__tapvpwrvgnd_1
* cell instance sky130_fd_sc_hd__tapvpwrvgnd_1_673 r0 *1 0,0
Xsky130_fd_sc_hd__tapvpwrvgnd_1_673
+ vss
+ vdd
+ sky130_fd_sc_hd__tapvpwrvgnd_1
* cell instance sky130_fd_sc_hd__tapvpwrvgnd_1_674 r0 *1 0,0
Xsky130_fd_sc_hd__tapvpwrvgnd_1_674
+ vss
+ vdd
+ sky130_fd_sc_hd__tapvpwrvgnd_1
* cell instance sky130_fd_sc_hd__tapvpwrvgnd_1_675 r0 *1 0,0
Xsky130_fd_sc_hd__tapvpwrvgnd_1_675
+ vss
+ vdd
+ sky130_fd_sc_hd__tapvpwrvgnd_1
* cell instance sky130_fd_sc_hd__tapvpwrvgnd_1_676 r0 *1 0,0
Xsky130_fd_sc_hd__tapvpwrvgnd_1_676
+ vss
+ vdd
+ sky130_fd_sc_hd__tapvpwrvgnd_1
* cell instance sky130_fd_sc_hd__tapvpwrvgnd_1_677 r0 *1 0,0
Xsky130_fd_sc_hd__tapvpwrvgnd_1_677
+ vss
+ vdd
+ sky130_fd_sc_hd__tapvpwrvgnd_1
* cell instance sky130_fd_sc_hd__tapvpwrvgnd_1_678 r0 *1 0,0
Xsky130_fd_sc_hd__tapvpwrvgnd_1_678
+ vss
+ vdd
+ sky130_fd_sc_hd__tapvpwrvgnd_1
* cell instance sky130_fd_sc_hd__tapvpwrvgnd_1_679 r0 *1 0,0
Xsky130_fd_sc_hd__tapvpwrvgnd_1_679
+ vss
+ vdd
+ sky130_fd_sc_hd__tapvpwrvgnd_1
* cell instance sky130_fd_sc_hd__tapvpwrvgnd_1_680 r0 *1 0,0
Xsky130_fd_sc_hd__tapvpwrvgnd_1_680
+ vss
+ vdd
+ sky130_fd_sc_hd__tapvpwrvgnd_1
* cell instance sky130_fd_sc_hd__tapvpwrvgnd_1_681 r0 *1 0,0
Xsky130_fd_sc_hd__tapvpwrvgnd_1_681
+ vss
+ vdd
+ sky130_fd_sc_hd__tapvpwrvgnd_1
* cell instance sky130_fd_sc_hd__tapvpwrvgnd_1_682 r0 *1 0,0
Xsky130_fd_sc_hd__tapvpwrvgnd_1_682
+ vss
+ vdd
+ sky130_fd_sc_hd__tapvpwrvgnd_1
* cell instance sky130_fd_sc_hd__tapvpwrvgnd_1_683 r0 *1 0,0
Xsky130_fd_sc_hd__tapvpwrvgnd_1_683
+ vss
+ vdd
+ sky130_fd_sc_hd__tapvpwrvgnd_1
* cell instance sky130_fd_sc_hd__tapvpwrvgnd_1_684 r0 *1 0,0
Xsky130_fd_sc_hd__tapvpwrvgnd_1_684
+ vss
+ vdd
+ sky130_fd_sc_hd__tapvpwrvgnd_1
* cell instance sky130_fd_sc_hd__tapvpwrvgnd_1_685 r0 *1 0,0
Xsky130_fd_sc_hd__tapvpwrvgnd_1_685
+ vss
+ vdd
+ sky130_fd_sc_hd__tapvpwrvgnd_1
* cell instance sky130_fd_sc_hd__tapvpwrvgnd_1_686 r0 *1 0,0
Xsky130_fd_sc_hd__tapvpwrvgnd_1_686
+ vss
+ vdd
+ sky130_fd_sc_hd__tapvpwrvgnd_1
* cell instance sky130_fd_sc_hd__tapvpwrvgnd_1_687 r0 *1 0,0
Xsky130_fd_sc_hd__tapvpwrvgnd_1_687
+ vss
+ vdd
+ sky130_fd_sc_hd__tapvpwrvgnd_1
* cell instance sky130_fd_sc_hd__tapvpwrvgnd_1_688 r0 *1 0,0
Xsky130_fd_sc_hd__tapvpwrvgnd_1_688
+ vss
+ vdd
+ sky130_fd_sc_hd__tapvpwrvgnd_1
* cell instance sky130_fd_sc_hd__tapvpwrvgnd_1_689 r0 *1 0,0
Xsky130_fd_sc_hd__tapvpwrvgnd_1_689
+ vss
+ vdd
+ sky130_fd_sc_hd__tapvpwrvgnd_1
* cell instance sky130_fd_sc_hd__tapvpwrvgnd_1_690 r0 *1 0,0
Xsky130_fd_sc_hd__tapvpwrvgnd_1_690
+ vss
+ vdd
+ sky130_fd_sc_hd__tapvpwrvgnd_1
* cell instance sky130_fd_sc_hd__tapvpwrvgnd_1_691 r0 *1 0,0
Xsky130_fd_sc_hd__tapvpwrvgnd_1_691
+ vss
+ vdd
+ sky130_fd_sc_hd__tapvpwrvgnd_1
* cell instance sky130_fd_sc_hd__tapvpwrvgnd_1_692 r0 *1 0,0
Xsky130_fd_sc_hd__tapvpwrvgnd_1_692
+ vss
+ vdd
+ sky130_fd_sc_hd__tapvpwrvgnd_1
* cell instance sky130_fd_sc_hd__tapvpwrvgnd_1_693 r0 *1 0,0
Xsky130_fd_sc_hd__tapvpwrvgnd_1_693
+ vss
+ vdd
+ sky130_fd_sc_hd__tapvpwrvgnd_1
* cell instance sky130_fd_sc_hd__tapvpwrvgnd_1_694 r0 *1 0,0
Xsky130_fd_sc_hd__tapvpwrvgnd_1_694
+ vss
+ vdd
+ sky130_fd_sc_hd__tapvpwrvgnd_1
* cell instance sky130_fd_sc_hd__tapvpwrvgnd_1_695 r0 *1 0,0
Xsky130_fd_sc_hd__tapvpwrvgnd_1_695
+ vss
+ vdd
+ sky130_fd_sc_hd__tapvpwrvgnd_1
* cell instance sky130_fd_sc_hd__tapvpwrvgnd_1_696 r0 *1 0,0
Xsky130_fd_sc_hd__tapvpwrvgnd_1_696
+ vss
+ vdd
+ sky130_fd_sc_hd__tapvpwrvgnd_1
* cell instance sky130_fd_sc_hd__tapvpwrvgnd_1_697 r0 *1 0,0
Xsky130_fd_sc_hd__tapvpwrvgnd_1_697
+ vss
+ vdd
+ sky130_fd_sc_hd__tapvpwrvgnd_1
* cell instance sky130_fd_sc_hd__tapvpwrvgnd_1_698 r0 *1 0,0
Xsky130_fd_sc_hd__tapvpwrvgnd_1_698
+ vss
+ vdd
+ sky130_fd_sc_hd__tapvpwrvgnd_1
* cell instance sky130_fd_sc_hd__tapvpwrvgnd_1_699 r0 *1 0,0
Xsky130_fd_sc_hd__tapvpwrvgnd_1_699
+ vss
+ vdd
+ sky130_fd_sc_hd__tapvpwrvgnd_1
* cell instance sky130_fd_sc_hd__tapvpwrvgnd_1_700 r0 *1 0,0
Xsky130_fd_sc_hd__tapvpwrvgnd_1_700
+ vss
+ vdd
+ sky130_fd_sc_hd__tapvpwrvgnd_1
* cell instance sky130_fd_sc_hd__tapvpwrvgnd_1_701 r0 *1 0,0
Xsky130_fd_sc_hd__tapvpwrvgnd_1_701
+ vss
+ vdd
+ sky130_fd_sc_hd__tapvpwrvgnd_1
* cell instance sky130_fd_sc_hd__tapvpwrvgnd_1_702 r0 *1 0,0
Xsky130_fd_sc_hd__tapvpwrvgnd_1_702
+ vss
+ vdd
+ sky130_fd_sc_hd__tapvpwrvgnd_1
* cell instance sky130_fd_sc_hd__tapvpwrvgnd_1_703 r0 *1 0,0
Xsky130_fd_sc_hd__tapvpwrvgnd_1_703
+ vss
+ vdd
+ sky130_fd_sc_hd__tapvpwrvgnd_1
* cell instance sky130_fd_sc_hd__xnor2_1_0 r0 *1 0,0
Xsky130_fd_sc_hd__xnor2_1_0 \$4479 \$4244
+ vss
+ vdd
+ vdd
+ \$4588 sky130_fd_sc_hd__xnor2_1
* cell instance sky130_fd_sc_hd__xnor2_1_1 r0 *1 0,0
Xsky130_fd_sc_hd__xnor2_1_1 \$3667 \$3666
+ vss
+ vdd
+ vdd
+ \$3663 sky130_fd_sc_hd__xnor2_1
* cell instance sky130_fd_sc_hd__xnor2_1_2 r0 *1 0,0
Xsky130_fd_sc_hd__xnor2_1_2 \$2851 \$1995
+ vss
+ vdd
+ vdd
+ \$2625 sky130_fd_sc_hd__xnor2_1
* cell instance sky130_fd_sc_hd__xnor2_1_3 r0 *1 0,0
Xsky130_fd_sc_hd__xnor2_1_3 \$5852 \$5740
+ vss
+ vdd
+ vdd
+ \$5944 sky130_fd_sc_hd__xnor2_1
* cell instance sky130_fd_sc_hd__xnor2_1_4 r0 *1 0,0
Xsky130_fd_sc_hd__xnor2_1_4 \$3885 \$4020
+ vss
+ vdd
+ vdd
+ \$4249 sky130_fd_sc_hd__xnor2_1
* cell instance sky130_fd_sc_hd__xnor2_1_5 r0 *1 0,0
Xsky130_fd_sc_hd__xnor2_1_5 \$4936 \$5301
+ vss
+ vdd
+ vdd
+ \$5304 sky130_fd_sc_hd__xnor2_1
* cell instance sky130_fd_sc_hd__xnor2_1_6 r0 *1 0,0
Xsky130_fd_sc_hd__xnor2_1_6 \$1083 \$2499
+ vss
+ vdd
+ vdd
+ \$2628 sky130_fd_sc_hd__xnor2_1
* cell instance sky130_fd_sc_hd__xnor2_1_7 r0 *1 0,0
Xsky130_fd_sc_hd__xnor2_1_7 \$1083 \$4938
+ vss
+ vdd
+ vdd
+ \$4937 sky130_fd_sc_hd__xnor2_1
* cell instance sky130_fd_sc_hd__xnor2_1_8 r0 *1 0,0
Xsky130_fd_sc_hd__xnor2_1_8 \$1381 \$1382
+ vss
+ vdd
+ vdd
+ \$1545 sky130_fd_sc_hd__xnor2_1
* cell instance sky130_fd_sc_hd__xnor2_1_9 r0 *1 0,0
Xsky130_fd_sc_hd__xnor2_1_9 \$4253 \$4149
+ vss
+ vdd
+ vdd
+ \$4030 sky130_fd_sc_hd__xnor2_1
* cell instance sky130_fd_sc_hd__xnor2_1_10 r0 *1 0,0
Xsky130_fd_sc_hd__xnor2_1_10 \$4151 \$4341
+ vss
+ vdd
+ vdd
+ \$4129 sky130_fd_sc_hd__xnor2_1
* cell instance sky130_fd_sc_hd__xnor2_1_11 r0 *1 0,0
Xsky130_fd_sc_hd__xnor2_1_11 \$3167 \$3168
+ vss
+ vdd
+ vdd
+ \$3165 sky130_fd_sc_hd__xnor2_1
* cell instance sky130_fd_sc_hd__xnor2_1_12 r0 *1 0,0
Xsky130_fd_sc_hd__xnor2_1_12 \$2634 \$2305
+ vss
+ vdd
+ vdd
+ \$2633 sky130_fd_sc_hd__xnor2_1
* cell instance sky130_fd_sc_hd__xnor2_1_13 r0 *1 0,0
Xsky130_fd_sc_hd__xnor2_1_13 \$5415 \$5062
+ vss
+ vdd
+ vdd
+ \$5059 sky130_fd_sc_hd__xnor2_1
* cell instance sky130_fd_sc_hd__xnor2_1_14 r0 *1 0,0
Xsky130_fd_sc_hd__xnor2_1_14 \$5163 \$5307
+ vss
+ vdd
+ vdd
+ \$4360 sky130_fd_sc_hd__xnor2_1
* cell instance sky130_fd_sc_hd__xnor2_1_15 r0 *1 0,0
Xsky130_fd_sc_hd__xnor2_1_15 \$2121 \$2100
+ vss
+ vdd
+ vdd
+ \$2011 sky130_fd_sc_hd__xnor2_1
* cell instance sky130_fd_sc_hd__xnor2_1_16 r0 *1 0,0
Xsky130_fd_sc_hd__xnor2_1_16 \$3463 \$3374
+ vss
+ vdd
+ vdd
+ \$3346 sky130_fd_sc_hd__xnor2_1
* cell instance sky130_fd_sc_hd__xnor2_1_17 r0 *1 0,0
Xsky130_fd_sc_hd__xnor2_1_17 \$2869 \$3130
+ vss
+ vdd
+ vdd
+ \$2957 sky130_fd_sc_hd__xnor2_1
* cell instance sky130_fd_sc_hd__xnor2_1_18 r0 *1 0,0
Xsky130_fd_sc_hd__xnor2_1_18 \$1385 \$1388
+ vss
+ vdd
+ vdd
+ \$1386 sky130_fd_sc_hd__xnor2_1
* cell instance sky130_fd_sc_hd__xnor2_1_19 r0 *1 0,0
Xsky130_fd_sc_hd__xnor2_1_19 \$2012 \$1929
+ vss
+ vdd
+ vdd
+ \$2123 sky130_fd_sc_hd__xnor2_1
* cell instance sky130_fd_sc_hd__xnor2_1_20 r0 *1 0,0
Xsky130_fd_sc_hd__xnor2_1_20 \$4604 \$4365
+ vss
+ vdd
+ vdd
+ \$5070 sky130_fd_sc_hd__xnor2_1
* cell instance sky130_fd_sc_hd__xnor2_1_21 r0 *1 0,0
Xsky130_fd_sc_hd__xnor2_1_21 \$5762 \$6084
+ vss
+ vdd
+ vdd
+ \$6296 sky130_fd_sc_hd__xnor2_1
* cell instance sky130_fd_sc_hd__xnor2_1_22 r0 *1 0,0
Xsky130_fd_sc_hd__xnor2_1_22 \$5273 \$5836
+ vss
+ vdd
+ vdd
+ \$5867 sky130_fd_sc_hd__xnor2_1
* cell instance sky130_fd_sc_hd__xnor2_1_23 r0 *1 0,0
Xsky130_fd_sc_hd__xnor2_1_23 \$7100 \$5999
+ vss
+ vdd
+ vdd
+ \$7191 sky130_fd_sc_hd__xnor2_1
* cell instance sky130_fd_sc_hd__xnor2_1_24 r0 *1 0,0
Xsky130_fd_sc_hd__xnor2_1_24 \$5661 \$5999
+ vss
+ vdd
+ vdd
+ \$5434 sky130_fd_sc_hd__xnor2_1
* cell instance sky130_fd_sc_hd__xnor2_1_25 r0 *1 0,0
Xsky130_fd_sc_hd__xnor2_1_25 \$6116 \$5999
+ vss
+ vdd
+ vdd
+ \$4521 sky130_fd_sc_hd__xnor2_1
* cell instance sky130_fd_sc_hd__xnor2_1_26 r0 *1 0,0
Xsky130_fd_sc_hd__xnor2_1_26 \$6841 \$5999
+ vss
+ vdd
+ vdd
+ \$6408 sky130_fd_sc_hd__xnor2_1
* cell instance sky130_fd_sc_hd__xnor2_1_27 r0 *1 0,0
Xsky130_fd_sc_hd__xnor2_1_27 \$5953 \$5999
+ vss
+ vdd
+ vdd
+ \$6321 sky130_fd_sc_hd__xnor2_1
* cell instance sky130_fd_sc_hd__xnor2_1_28 r0 *1 0,0
Xsky130_fd_sc_hd__xnor2_1_28 \$1078 \$1010
+ vss
+ vdd
+ vdd
+ \$1075 sky130_fd_sc_hd__xnor2_1
* cell instance sky130_fd_sc_hd__xnor2_1_29 r0 *1 0,0
Xsky130_fd_sc_hd__xnor2_1_29 \$565 \$877
+ vss
+ vdd
+ vdd
+ \$631 sky130_fd_sc_hd__xnor2_1
* cell instance sky130_fd_sc_hd__xnor2_1_30 r0 *1 0,0
Xsky130_fd_sc_hd__xnor2_1_30 \$7369 \$5999
+ vss
+ vdd
+ vdd
+ \$7305 sky130_fd_sc_hd__xnor2_1
* cell instance sky130_fd_sc_hd__xnor2_1_31 r0 *1 0,0
Xsky130_fd_sc_hd__xnor2_1_31 \$6608 \$5999
+ vss
+ vdd
+ vdd
+ \$6700 sky130_fd_sc_hd__xnor2_1
* cell instance sky130_fd_sc_hd__xnor2_1_32 r0 *1 0,0
Xsky130_fd_sc_hd__xnor2_1_32 \$6613 \$5999
+ vss
+ vdd
+ vdd
+ \$5785 sky130_fd_sc_hd__xnor2_1
* cell instance sky130_fd_sc_hd__xnor2_1_33 r0 *1 0,0
Xsky130_fd_sc_hd__xnor2_1_33 \$7040 \$5999
+ vss
+ vdd
+ vdd
+ \$7078 sky130_fd_sc_hd__xnor2_1
* cell instance sky130_fd_sc_hd__xnor2_1_34 r0 *1 0,0
Xsky130_fd_sc_hd__xnor2_1_34 \$6332 \$5999
+ vss
+ vdd
+ vdd
+ \$6454 sky130_fd_sc_hd__xnor2_1
* cell instance sky130_fd_sc_hd__xnor2_1_35 r0 *1 0,0
Xsky130_fd_sc_hd__xnor2_1_35 \$6087 \$5999
+ vss
+ vdd
+ vdd
+ \$4301 sky130_fd_sc_hd__xnor2_1
* cell instance sky130_fd_sc_hd__xnor2_1_36 r0 *1 0,0
Xsky130_fd_sc_hd__xnor2_1_36 \$2353 \$2847
+ vss
+ vdd
+ vdd
+ \$2618 sky130_fd_sc_hd__xnor2_1
* cell instance sky130_fd_sc_hd__xnor2_1_37 r0 *1 0,0
Xsky130_fd_sc_hd__xnor2_1_37 \$6536 \$5999
+ vss
+ vdd
+ vdd
+ \$4560 sky130_fd_sc_hd__xnor2_1
* cell instance sky130_fd_sc_hd__xnor2_1_38 r0 *1 0,0
Xsky130_fd_sc_hd__xnor2_1_38 \$6975 \$5999
+ vss
+ vdd
+ vdd
+ \$6724 sky130_fd_sc_hd__xnor2_1
* cell instance sky130_fd_sc_hd__xnor2_1_39 r0 *1 0,0
Xsky130_fd_sc_hd__xnor2_1_39 \$1083 \$5703
+ vss
+ vdd
+ vdd
+ \$5705 sky130_fd_sc_hd__xnor2_1
* cell instance sky130_fd_sc_hd__xor2_1_0 r0 *1 0,0
Xsky130_fd_sc_hd__xor2_1_0 \$4574 \$4705
+ vss
+ vdd
+ vdd
+ \$4702 sky130_fd_sc_hd__xor2_1
* cell instance sky130_fd_sc_hd__xor2_1_1 r0 *1 0,0
Xsky130_fd_sc_hd__xor2_1_1 \$5400 \$5522
+ vss
+ vdd
+ vdd
+ \$5520 sky130_fd_sc_hd__xor2_1
* cell instance sky130_fd_sc_hd__xor2_1_2 r0 *1 0,0
Xsky130_fd_sc_hd__xor2_1_2 \$2214 \$2109
+ vss
+ vdd
+ vdd
+ \$2299 sky130_fd_sc_hd__xor2_1
* cell instance sky130_fd_sc_hd__xor2_1_3 r0 *1 0,0
Xsky130_fd_sc_hd__xor2_1_3 \$3570 \$3679
+ vss
+ vdd
+ vdd
+ \$3677 sky130_fd_sc_hd__xor2_1
* cell instance sky130_fd_sc_hd__xor2_1_4 r0 *1 0,0
Xsky130_fd_sc_hd__xor2_1_4 \$4494 \$4357
+ vss
+ vdd
+ vdd
+ \$4496 sky130_fd_sc_hd__xor2_1
* cell instance sky130_fd_sc_hd__xor2_1_5 r0 *1 0,0
Xsky130_fd_sc_hd__xor2_1_5 \$4500 \$5416
+ vss
+ vdd
+ vdd
+ \$4797 sky130_fd_sc_hd__xor2_1
* cell instance sky130_fd_sc_hd__xor2_1_6 r0 *1 0,0
Xsky130_fd_sc_hd__xor2_1_6 \$2288 \$2122
+ vss
+ vdd
+ vdd
+ \$2308 sky130_fd_sc_hd__xor2_1
* cell instance sky130_fd_sc_hd__xor2_1_7 r0 *1 0,0
Xsky130_fd_sc_hd__xor2_1_7 \$4261 \$4164
+ vss
+ vdd
+ vdd
+ \$4162 sky130_fd_sc_hd__xor2_1
* cell instance sky130_fd_sc_hd__xor2_1_8 r0 *1 0,0
Xsky130_fd_sc_hd__xor2_1_8 \$4609 \$4605
+ vss
+ vdd
+ vdd
+ \$4606 sky130_fd_sc_hd__xor2_1
* cell instance sky130_fd_sc_hd__xor2_1_9 r0 *1 0,0
Xsky130_fd_sc_hd__xor2_1_9 \$5989 \$6397
+ vss
+ vdd
+ vdd
+ \$6399 sky130_fd_sc_hd__xor2_1
* cell instance sky130_fd_sc_hd__xor2_1_10 r0 *1 0,0
Xsky130_fd_sc_hd__xor2_1_10 \$4062 \$4745
+ vss
+ vdd
+ vdd
+ \$4455 sky130_fd_sc_hd__xor2_1
* cell instance sky130_fd_sc_hd__xor2_1_11 r0 *1 0,0
Xsky130_fd_sc_hd__xor2_1_11 \$4391 \$4527
+ vss
+ vdd
+ vdd
+ \$4524 sky130_fd_sc_hd__xor2_1
* cell instance sky130_fd_sc_hd__xor2_1_12 r0 *1 0,0
Xsky130_fd_sc_hd__xor2_1_12 \$1078 \$1010
+ vss
+ vdd
+ vdd
+ \$1220 sky130_fd_sc_hd__xor2_1
* cell instance sky130_fd_sc_hd__xor2_1_13 r0 *1 0,0
Xsky130_fd_sc_hd__xor2_1_13 \$2350 \$2170
+ vss
+ vdd
+ vdd
+ \$2455 sky130_fd_sc_hd__xor2_1
* cell instance sky130_fd_sc_hd__xor2_1_14 r0 *1 0,0
Xsky130_fd_sc_hd__xor2_1_14 \$3891 \$3960
+ vss
+ vdd
+ vdd
+ \$3958 sky130_fd_sc_hd__xor2_1
* cell instance sky130_fd_sc_hd__xor2_1_15 r0 *1 0,0
Xsky130_fd_sc_hd__xor2_1_15 \$1515 \$1773
+ vss
+ vdd
+ vdd
+ \$1875 sky130_fd_sc_hd__xor2_1
* cell instance sky130_fd_sc_hd__xor2_1_16 r0 *1 0,0
Xsky130_fd_sc_hd__xor2_1_16 \$2458 \$2680
+ vss
+ vdd
+ vdd
+ \$2568 sky130_fd_sc_hd__xor2_1
* cell instance sky130_fd_sc_hd__xor2_1_17 r0 *1 0,0
Xsky130_fd_sc_hd__xor2_1_17 \$2057 bus_wdata[1]
+ vss
+ vdd
+ vdd
+ \$3094 sky130_fd_sc_hd__xor2_1
* cell instance sky130_fd_sc_hd__xor2_1_18 r0 *1 0,0
Xsky130_fd_sc_hd__xor2_1_18 \$1083 \$5703
+ vss
+ vdd
+ vdd
+ \$5809 sky130_fd_sc_hd__xor2_1
* device instance $1 r0 *1 6.625,268.85 nfet
M$1 \$8019
+ ring_bit4
+ a|mnab_y|mpa_y|mpb_y|nand_s2_y|qb|tg_fbs_a|y
+ vss
+ nfet L=0.15U W=0.84U AS=0.3948P AD=0.2184P PS=2.62U PD=1.36U
* device instance $2 r0 *1 7.295,268.85 nfet
M$2
+ vss
+ rst_n \$8019
+ vss
+ nfet L=0.15U W=0.84U AS=0.2184P AD=0.3948P PS=1.36U PD=2.62U
* device instance $3 r0 *1 37.485,268.85 nfet
M$3 \$8024
+ a|b|m_east|m_west|nand_m_a|nand_m_a_ext_via|nand_m_a_ext_via2|nand_m_a_stub|tg_d_b|tg_d_b_via|tg_d_b_via2|tg_fbm_b|tg_fbm_b_alt_via|tg_fbm_b_alt_via2
+ a|inv_mc_a|mb|mnab_y|mpa_y|mpb_y|nand_m_y|tg_s_a|y$1
+ vss
+ nfet L=0.15U W=0.84U AS=0.3948P AD=0.2184P PS=2.62U PD=1.36U
* device instance $4 r0 *1 38.155,268.85 nfet
M$4
+ vss
+ rst_n \$8024
+ vss
+ nfet L=0.15U W=0.84U AS=0.2184P AD=0.3948P PS=1.36U PD=2.62U
* device instance $5 r0 *1 62.285,268.85 nfet
M$5 \$8026
+ ring_bit3
+ a|mnab_y|mpa_y|mpb_y|nand_s2_y|qb|tg_fbs_a|y$1
+ vss
+ nfet L=0.15U W=0.84U AS=0.3948P AD=0.2184P PS=2.62U PD=1.36U
* device instance $6 r0 *1 62.955,268.85 nfet
M$6
+ vss
+ rst_n \$8026
+ vss
+ nfet L=0.15U W=0.84U AS=0.2184P AD=0.3948P PS=1.36U PD=2.62U
* device instance $7 r0 *1 93.145,268.85 nfet
M$7 \$8031
+ a|b|m_east|m_west|nand_m_a|nand_m_a_ext_via|nand_m_a_ext_via2|nand_m_a_stub|tg_d_b|tg_d_b_via|tg_d_b_via2|tg_fbm_b|tg_fbm_b_alt_via|tg_fbm_b_alt_via2$1
+ a|inv_mc_a|mb|mnab_y|mpa_y|mpb_y|nand_m_y|tg_s_a|y$2
+ vss
+ nfet L=0.15U W=0.84U AS=0.3948P AD=0.2184P PS=2.62U PD=1.36U
* device instance $8 r0 *1 93.815,268.85 nfet
M$8
+ vss
+ rst_n \$8031
+ vss
+ nfet L=0.15U W=0.84U AS=0.2184P AD=0.3948P PS=1.36U PD=2.62U
* device instance $9 r0 *1 117.945,268.85 nfet
M$9 \$8032
+ ring_bit2
+ a|mnab_y|mpa_y|mpb_y|nand_s2_y|qb|tg_fbs_a|y$2
+ vss
+ nfet L=0.15U W=0.84U AS=0.3948P AD=0.2184P PS=2.62U PD=1.36U
* device instance $10 r0 *1 118.615,268.85 nfet
M$10
+ vss
+ rst_n \$8032
+ vss
+ nfet L=0.15U W=0.84U AS=0.2184P AD=0.3948P PS=1.36U PD=2.62U
* device instance $11 r0 *1 148.805,268.85 nfet
M$11 \$8037
+ a|b|m_east|m_west|nand_m_a|nand_m_a_ext_via|nand_m_a_ext_via2|nand_m_a_stub|tg_d_b|tg_d_b_via|tg_d_b_via2|tg_fbm_b|tg_fbm_b_alt_via|tg_fbm_b_alt_via2$2
+ a|inv_mc_a|mb|mnab_y|mpa_y|mpb_y|nand_m_y|tg_s_a|y$3
+ vss
+ nfet L=0.15U W=0.84U AS=0.3948P AD=0.2184P PS=2.62U PD=1.36U
* device instance $12 r0 *1 149.475,268.85 nfet
M$12
+ vss
+ rst_n \$8037
+ vss
+ nfet L=0.15U W=0.84U AS=0.2184P AD=0.3948P PS=1.36U PD=2.62U
* device instance $13 r0 *1 173.605,268.85 nfet
M$13 \$8039
+ ring_bit1
+ a|mnab_y|mpa_y|mpb_y|nand_s2_y|qb|tg_fbs_a|y$3
+ vss
+ nfet L=0.15U W=0.84U AS=0.3948P AD=0.2184P PS=2.62U PD=1.36U
* device instance $14 r0 *1 174.275,268.85 nfet
M$14
+ vss
+ rst_n \$8039
+ vss
+ nfet L=0.15U W=0.84U AS=0.2184P AD=0.3948P PS=1.36U PD=2.62U
* device instance $15 r0 *1 204.465,268.85 nfet
M$15 \$8044
+ a|b|m_east|m_west|nand_m_a|nand_m_a_ext_via|nand_m_a_ext_via2|nand_m_a_stub|tg_d_b|tg_d_b_via|tg_d_b_via2|tg_fbm_b|tg_fbm_b_alt_via|tg_fbm_b_alt_via2$3
+ a|inv_mc_a|mb|mnab_y|mpa_y|mpb_y|nand_m_y|tg_s_a|y$4
+ vss
+ nfet L=0.15U W=0.84U AS=0.3948P AD=0.2184P PS=2.62U PD=1.36U
* device instance $16 r0 *1 205.135,268.85 nfet
M$16
+ vss
+ rst_n \$8044
+ vss
+ nfet L=0.15U W=0.84U AS=0.2184P AD=0.3948P PS=1.36U PD=2.62U
* device instance $17 r0 *1 229.265,268.85 nfet
M$17 \$8046
+ a|inv_q_y|inv_q_y_via|inv_q_y_via2|nand_s2_a|nand_s2_a_stub|nand_s2_a_via|nand_s2_a_via2|q|raw_valid|y
+ a|mnab_y|mpa_y|mpb_y|nand_s2_y|qb|tg_fbs_a|y$4
+ vss
+ nfet L=0.15U W=0.84U AS=0.3948P AD=0.2184P PS=2.62U PD=1.36U
* device instance $18 r0 *1 229.935,268.85 nfet
M$18
+ vss
+ rst_n \$8046
+ vss
+ nfet L=0.15U W=0.84U AS=0.2184P AD=0.3948P PS=1.36U PD=2.62U
* device instance $19 r0 *1 260.125,268.85 nfet
M$19 \$8050
+ a|b|m_east|m_west|nand_m_a|nand_m_a_ext_via|nand_m_a_ext_via2|nand_m_a_stub|tg_d_b|tg_d_b_via|tg_d_b_via2|tg_fbm_b|tg_fbm_b_alt_via|tg_fbm_b_alt_via2$4
+ a|inv_mc_a|mb|mnab_y|mpa_y|mpb_y|nand_m_y|tg_s_a|y$5
+ vss
+ nfet L=0.15U W=0.84U AS=0.3948P AD=0.2184P PS=2.62U PD=1.36U
* device instance $20 r0 *1 260.795,268.85 nfet
M$20
+ vss
+ rst_n \$8050
+ vss
+ nfet L=0.15U W=0.84U AS=0.2184P AD=0.3948P PS=1.36U PD=2.62U
* device instance $21 r0 *1 284.925,268.85 nfet
M$21 \$8051
+ a|inv_q_y|inv_q_y_via|inv_q_y_via2|nand_s2_a|nand_s2_a_stub|nand_s2_a_via|nand_s2_a_via2|q|raw_bit|y
+ a|mnab_y|mpa_y|mpb_y|nand_s2_y|qb|tg_fbs_a|y$5
+ vss
+ nfet L=0.15U W=0.84U AS=0.3948P AD=0.2184P PS=2.62U PD=1.36U
* device instance $22 r0 *1 285.595,268.85 nfet
M$22
+ vss
+ rst_n \$8051
+ vss
+ nfet L=0.15U W=0.84U AS=0.2184P AD=0.3948P PS=1.36U PD=2.62U
* device instance $23 r0 *1 315.785,268.85 nfet
M$23 \$8055
+ a|b|m_east|m_west|nand_m_a|nand_m_a_ext_via|nand_m_a_ext_via2|nand_m_a_stub|tg_d_b|tg_d_b_via|tg_d_b_via2|tg_fbm_b|tg_fbm_b_alt_via|tg_fbm_b_alt_via2$5
+ a|inv_mc_a|mb|mnab_y|mpa_y|mpb_y|nand_m_y|tg_s_a|y
+ vss
+ nfet L=0.15U W=0.84U AS=0.3948P AD=0.2184P PS=2.62U PD=1.36U
* device instance $24 r0 *1 316.455,268.85 nfet
M$24
+ vss
+ rst_n \$8055
+ vss
+ nfet L=0.15U W=0.84U AS=0.2184P AD=0.3948P PS=1.36U PD=2.62U
* device instance $25 r0 *1 1.44,268.85 nfet
M$25 a|b|inv_q_a|inv_q_a_via|s|tg_fbs_b|tg_fbs_b_via|tg_s_b|tg_s_b_via$2
+ clkb|clkb_bridge1|clkb_bridge2|clkb_mid|clkb_w|ctrl|ctrlb|inv_clk_y|tg_d_ctrlb|tg_fbm_ctrl|tg_fbs_ctrlb|tg_s_ctrl|y
+ a|mnab_y|mpa_y|mpb_y|nand_s2_y|qb|tg_fbs_a|y
+ vss
+ nfet L=0.15U W=0.42U AS=0.1974P AD=0.1974P PS=1.78U PD=1.78U
* device instance $26 r0 *1 13.925,268.85 nfet
M$26
+ vss
+ a|b|inv_q_a|inv_q_a_via|s|tg_fbs_b|tg_fbs_b_via|tg_s_b|tg_s_b_via$2
+ ring_bit4
+ vss
+ nfet L=0.15U W=0.42U AS=0.1974P AD=0.1974P PS=1.78U PD=1.78U
* device instance $27 r0 *1 20.73,268.85 nfet
M$27 a|b|inv_q_a|inv_q_a_via|s|tg_fbs_b|tg_fbs_b_via|tg_s_b|tg_s_b_via$2
+ clk
+ a|inv_mc_a|mb|mnab_y|mpa_y|mpb_y|nand_m_y|tg_s_a|y$1
+ vss
+ nfet L=0.15U W=0.42U AS=0.1974P AD=0.1974P PS=1.78U PD=1.78U
* device instance $28 r0 *1 25.87,268.85 nfet
M$28
+ a|b|m_east|m_west|nand_m_a|nand_m_a_ext_via|nand_m_a_ext_via2|nand_m_a_stub|tg_d_b|tg_d_b_via|tg_d_b_via2|tg_fbm_b|tg_fbm_b_alt_via|tg_fbm_b_alt_via2
+ clk
+ a|inv_mc_y|inv_mc_y_via|mc|tg_fbm_a|tg_fbm_a_via|y
+ vss
+ nfet L=0.15U W=0.42U AS=0.1974P AD=0.1974P PS=1.78U PD=1.78U
* device instance $29 r0 *1 30.635,268.85 nfet
M$29
+ vss
+ a|inv_mc_a|mb|mnab_y|mpa_y|mpb_y|nand_m_y|tg_s_a|y$1
+ a|inv_mc_y|inv_mc_y_via|mc|tg_fbm_a|tg_fbm_a_via|y
+ vss
+ nfet L=0.15U W=0.42U AS=0.1974P AD=0.1974P PS=1.78U PD=1.78U
* device instance $30 r0 *1 45.16,268.85 nfet
M$30
+ a|b|m_east|m_west|nand_m_a|nand_m_a_ext_via|nand_m_a_ext_via2|nand_m_a_stub|tg_d_b|tg_d_b_via|tg_d_b_via2|tg_fbm_b|tg_fbm_b_alt_via|tg_fbm_b_alt_via2
+ clkb|clkb_bridge1|clkb_bridge2|clkb_mid|clkb_w|ctrl|ctrlb|inv_clk_y|tg_d_ctrlb|tg_fbm_ctrl|tg_fbs_ctrlb|tg_s_ctrl|y
+ a|b|d|invb_a|mn12_g1|mp24_g0|ro4|ro4_esc|sr4_d_stub|tg_d_a|y
+ vss
+ nfet L=0.15U W=0.42U AS=0.1974P AD=0.1974P PS=1.78U PD=1.78U
* device instance $31 r0 *1 49.925,268.85 nfet
M$31
+ vss
+ clk
+ clkb|clkb_bridge1|clkb_bridge2|clkb_mid|clkb_w|ctrl|ctrlb|inv_clk_y|tg_d_ctrlb|tg_fbm_ctrl|tg_fbs_ctrlb|tg_s_ctrl|y
+ vss
+ nfet L=0.15U W=0.42U AS=0.1974P AD=0.1974P PS=1.78U PD=1.78U
* device instance $32 r0 *1 57.1,268.85 nfet
M$32 a|b|inv_q_a|inv_q_a_via|s|tg_fbs_b|tg_fbs_b_via|tg_s_b|tg_s_b_via$3
+ clkb|clkb_bridge1|clkb_bridge2|clkb_mid|clkb_w|ctrl|ctrlb|inv_clk_y|tg_d_ctrlb|tg_fbm_ctrl|tg_fbs_ctrlb|tg_s_ctrl|y$1
+ a|mnab_y|mpa_y|mpb_y|nand_s2_y|qb|tg_fbs_a|y$1
+ vss
+ nfet L=0.15U W=0.42U AS=0.1974P AD=0.1974P PS=1.78U PD=1.78U
* device instance $33 r0 *1 69.585,268.85 nfet
M$33
+ vss
+ a|b|inv_q_a|inv_q_a_via|s|tg_fbs_b|tg_fbs_b_via|tg_s_b|tg_s_b_via$3
+ ring_bit3
+ vss
+ nfet L=0.15U W=0.42U AS=0.1974P AD=0.1974P PS=1.78U PD=1.78U
* device instance $34 r0 *1 76.39,268.85 nfet
M$34 a|b|inv_q_a|inv_q_a_via|s|tg_fbs_b|tg_fbs_b_via|tg_s_b|tg_s_b_via$3
+ clk
+ a|inv_mc_a|mb|mnab_y|mpa_y|mpb_y|nand_m_y|tg_s_a|y$2
+ vss
+ nfet L=0.15U W=0.42U AS=0.1974P AD=0.1974P PS=1.78U PD=1.78U
* device instance $35 r0 *1 81.53,268.85 nfet
M$35
+ a|b|m_east|m_west|nand_m_a|nand_m_a_ext_via|nand_m_a_ext_via2|nand_m_a_stub|tg_d_b|tg_d_b_via|tg_d_b_via2|tg_fbm_b|tg_fbm_b_alt_via|tg_fbm_b_alt_via2$1
+ clk
+ a|inv_mc_y|inv_mc_y_via|mc|tg_fbm_a|tg_fbm_a_via|y$1
+ vss
+ nfet L=0.15U W=0.42U AS=0.1974P AD=0.1974P PS=1.78U PD=1.78U
* device instance $36 r0 *1 86.295,268.85 nfet
M$36
+ vss
+ a|inv_mc_a|mb|mnab_y|mpa_y|mpb_y|nand_m_y|tg_s_a|y$2
+ a|inv_mc_y|inv_mc_y_via|mc|tg_fbm_a|tg_fbm_a_via|y$1
+ vss
+ nfet L=0.15U W=0.42U AS=0.1974P AD=0.1974P PS=1.78U PD=1.78U
* device instance $37 r0 *1 100.82,268.85 nfet
M$37
+ a|b|m_east|m_west|nand_m_a|nand_m_a_ext_via|nand_m_a_ext_via2|nand_m_a_stub|tg_d_b|tg_d_b_via|tg_d_b_via2|tg_fbm_b|tg_fbm_b_alt_via|tg_fbm_b_alt_via2$1
+ clkb|clkb_bridge1|clkb_bridge2|clkb_mid|clkb_w|ctrl|ctrlb|inv_clk_y|tg_d_ctrlb|tg_fbm_ctrl|tg_fbs_ctrlb|tg_s_ctrl|y$1
+ a|d|inva_a|mn12_g0|mp13_g0|ro3|ro3_esc_e|ro3_esc_w|ro3_hop|sr3_d_stub|tg_d_a|y
+ vss
+ nfet L=0.15U W=0.42U AS=0.1974P AD=0.1974P PS=1.78U PD=1.78U
* device instance $38 r0 *1 105.585,268.85 nfet
M$38
+ vss
+ clk
+ clkb|clkb_bridge1|clkb_bridge2|clkb_mid|clkb_w|ctrl|ctrlb|inv_clk_y|tg_d_ctrlb|tg_fbm_ctrl|tg_fbs_ctrlb|tg_s_ctrl|y$1
+ vss
+ nfet L=0.15U W=0.42U AS=0.1974P AD=0.1974P PS=1.78U PD=1.78U
* device instance $39 r0 *1 112.76,268.85 nfet
M$39 a|b|inv_q_a|inv_q_a_via|s|tg_fbs_b|tg_fbs_b_via|tg_s_b|tg_s_b_via$4
+ clkb|clkb_bridge1|clkb_bridge2|clkb_mid|clkb_w|ctrl|ctrlb|inv_clk_y|tg_d_ctrlb|tg_fbm_ctrl|tg_fbs_ctrlb|tg_s_ctrl|y$2
+ a|mnab_y|mpa_y|mpb_y|nand_s2_y|qb|tg_fbs_a|y$2
+ vss
+ nfet L=0.15U W=0.42U AS=0.1974P AD=0.1974P PS=1.78U PD=1.78U
* device instance $40 r0 *1 125.245,268.85 nfet
M$40
+ vss
+ a|b|inv_q_a|inv_q_a_via|s|tg_fbs_b|tg_fbs_b_via|tg_s_b|tg_s_b_via$4
+ ring_bit2
+ vss
+ nfet L=0.15U W=0.42U AS=0.1974P AD=0.1974P PS=1.78U PD=1.78U
* device instance $41 r0 *1 132.05,268.85 nfet
M$41 a|b|inv_q_a|inv_q_a_via|s|tg_fbs_b|tg_fbs_b_via|tg_s_b|tg_s_b_via$4
+ clk
+ a|inv_mc_a|mb|mnab_y|mpa_y|mpb_y|nand_m_y|tg_s_a|y$3
+ vss
+ nfet L=0.15U W=0.42U AS=0.1974P AD=0.1974P PS=1.78U PD=1.78U
* device instance $42 r0 *1 137.19,268.85 nfet
M$42
+ a|b|m_east|m_west|nand_m_a|nand_m_a_ext_via|nand_m_a_ext_via2|nand_m_a_stub|tg_d_b|tg_d_b_via|tg_d_b_via2|tg_fbm_b|tg_fbm_b_alt_via|tg_fbm_b_alt_via2$2
+ clk
+ a|inv_mc_y|inv_mc_y_via|mc|tg_fbm_a|tg_fbm_a_via|y$2
+ vss
+ nfet L=0.15U W=0.42U AS=0.1974P AD=0.1974P PS=1.78U PD=1.78U
* device instance $43 r0 *1 141.955,268.85 nfet
M$43
+ vss
+ a|inv_mc_a|mb|mnab_y|mpa_y|mpb_y|nand_m_y|tg_s_a|y$3
+ a|inv_mc_y|inv_mc_y_via|mc|tg_fbm_a|tg_fbm_a_via|y$2
+ vss
+ nfet L=0.15U W=0.42U AS=0.1974P AD=0.1974P PS=1.78U PD=1.78U
* device instance $44 r0 *1 156.48,268.85 nfet
M$44
+ a|b|m_east|m_west|nand_m_a|nand_m_a_ext_via|nand_m_a_ext_via2|nand_m_a_stub|tg_d_b|tg_d_b_via|tg_d_b_via2|tg_fbm_b|tg_fbm_b_alt_via|tg_fbm_b_alt_via2$2
+ clkb|clkb_bridge1|clkb_bridge2|clkb_mid|clkb_w|ctrl|ctrlb|inv_clk_y|tg_d_ctrlb|tg_fbm_ctrl|tg_fbs_ctrlb|tg_s_ctrl|y$2
+ a|b|d|invb_a|mn12_g1|mp24_g0|ro2|ro2_esc|sr2_d_stub|tg_d_a|y
+ vss
+ nfet L=0.15U W=0.42U AS=0.1974P AD=0.1974P PS=1.78U PD=1.78U
* device instance $45 r0 *1 161.245,268.85 nfet
M$45
+ vss
+ clk
+ clkb|clkb_bridge1|clkb_bridge2|clkb_mid|clkb_w|ctrl|ctrlb|inv_clk_y|tg_d_ctrlb|tg_fbm_ctrl|tg_fbs_ctrlb|tg_s_ctrl|y$2
+ vss
+ nfet L=0.15U W=0.42U AS=0.1974P AD=0.1974P PS=1.78U PD=1.78U
* device instance $46 r0 *1 168.42,268.85 nfet
M$46 a|b|inv_q_a|inv_q_a_via|s|tg_fbs_b|tg_fbs_b_via|tg_s_b|tg_s_b_via
+ clkb|clkb_bridge1|clkb_bridge2|clkb_mid|clkb_w|ctrl|ctrlb|inv_clk_y|tg_d_ctrlb|tg_fbm_ctrl|tg_fbs_ctrlb|tg_s_ctrl|y$3
+ a|mnab_y|mpa_y|mpb_y|nand_s2_y|qb|tg_fbs_a|y$3
+ vss
+ nfet L=0.15U W=0.42U AS=0.1974P AD=0.1974P PS=1.78U PD=1.78U
* device instance $47 r0 *1 180.905,268.85 nfet
M$47
+ vss
+ a|b|inv_q_a|inv_q_a_via|s|tg_fbs_b|tg_fbs_b_via|tg_s_b|tg_s_b_via
+ ring_bit1
+ vss
+ nfet L=0.15U W=0.42U AS=0.1974P AD=0.1974P PS=1.78U PD=1.78U
* device instance $48 r0 *1 187.71,268.85 nfet
M$48 a|b|inv_q_a|inv_q_a_via|s|tg_fbs_b|tg_fbs_b_via|tg_s_b|tg_s_b_via
+ clk
+ a|inv_mc_a|mb|mnab_y|mpa_y|mpb_y|nand_m_y|tg_s_a|y$4
+ vss
+ nfet L=0.15U W=0.42U AS=0.1974P AD=0.1974P PS=1.78U PD=1.78U
* device instance $49 r0 *1 192.85,268.85 nfet
M$49
+ a|b|m_east|m_west|nand_m_a|nand_m_a_ext_via|nand_m_a_ext_via2|nand_m_a_stub|tg_d_b|tg_d_b_via|tg_d_b_via2|tg_fbm_b|tg_fbm_b_alt_via|tg_fbm_b_alt_via2$3
+ clk
+ a|inv_mc_y|inv_mc_y_via|mc|tg_fbm_a|tg_fbm_a_via|y$3
+ vss
+ nfet L=0.15U W=0.42U AS=0.1974P AD=0.1974P PS=1.78U PD=1.78U
* device instance $50 r0 *1 197.615,268.85 nfet
M$50
+ vss
+ a|inv_mc_a|mb|mnab_y|mpa_y|mpb_y|nand_m_y|tg_s_a|y$4
+ a|inv_mc_y|inv_mc_y_via|mc|tg_fbm_a|tg_fbm_a_via|y$3
+ vss
+ nfet L=0.15U W=0.42U AS=0.1974P AD=0.1974P PS=1.78U PD=1.78U
* device instance $51 r0 *1 212.14,268.85 nfet
M$51
+ a|b|m_east|m_west|nand_m_a|nand_m_a_ext_via|nand_m_a_ext_via2|nand_m_a_stub|tg_d_b|tg_d_b_via|tg_d_b_via2|tg_fbm_b|tg_fbm_b_alt_via|tg_fbm_b_alt_via2$3
+ clkb|clkb_bridge1|clkb_bridge2|clkb_mid|clkb_w|ctrl|ctrlb|inv_clk_y|tg_d_ctrlb|tg_fbm_ctrl|tg_fbs_ctrlb|tg_s_ctrl|y$3
+ a|d|inva_a|mn12_g0|mp13_g0|ro1|ro1_esc|sr1_d_stub|tg_d_a|y
+ vss
+ nfet L=0.15U W=0.42U AS=0.1974P AD=0.1974P PS=1.78U PD=1.78U
* device instance $52 r0 *1 216.905,268.85 nfet
M$52
+ vss
+ clk
+ clkb|clkb_bridge1|clkb_bridge2|clkb_mid|clkb_w|ctrl|ctrlb|inv_clk_y|tg_d_ctrlb|tg_fbm_ctrl|tg_fbs_ctrlb|tg_s_ctrl|y$3
+ vss
+ nfet L=0.15U W=0.42U AS=0.1974P AD=0.1974P PS=1.78U PD=1.78U
* device instance $53 r0 *1 224.08,268.85 nfet
M$53 a|b|inv_q_a|inv_q_a_via|s|tg_fbs_b|tg_fbs_b_via|tg_s_b|tg_s_b_via$1
+ clkb|clkb_bridge1|clkb_bridge2|clkb_mid|clkb_w|ctrl|ctrlb|inv_clk_y|tg_d_ctrlb|tg_fbm_ctrl|tg_fbs_ctrlb|tg_s_ctrl|y$4
+ a|mnab_y|mpa_y|mpb_y|nand_s2_y|qb|tg_fbs_a|y$4
+ vss
+ nfet L=0.15U W=0.42U AS=0.1974P AD=0.1974P PS=1.78U PD=1.78U
* device instance $54 r0 *1 236.565,268.85 nfet
M$54
+ vss
+ a|b|inv_q_a|inv_q_a_via|s|tg_fbs_b|tg_fbs_b_via|tg_s_b|tg_s_b_via$1
+ a|inv_q_y|inv_q_y_via|inv_q_y_via2|nand_s2_a|nand_s2_a_stub|nand_s2_a_via|nand_s2_a_via2|q|raw_valid|y
+ vss
+ nfet L=0.15U W=0.42U AS=0.1974P AD=0.1974P PS=1.78U PD=1.78U
* device instance $55 r0 *1 243.37,268.85 nfet
M$55 a|b|inv_q_a|inv_q_a_via|s|tg_fbs_b|tg_fbs_b_via|tg_s_b|tg_s_b_via$1
+ clk
+ a|inv_mc_a|mb|mnab_y|mpa_y|mpb_y|nand_m_y|tg_s_a|y$5
+ vss
+ nfet L=0.15U W=0.42U AS=0.1974P AD=0.1974P PS=1.78U PD=1.78U
* device instance $56 r0 *1 248.51,268.85 nfet
M$56
+ a|b|m_east|m_west|nand_m_a|nand_m_a_ext_via|nand_m_a_ext_via2|nand_m_a_stub|tg_d_b|tg_d_b_via|tg_d_b_via2|tg_fbm_b|tg_fbm_b_alt_via|tg_fbm_b_alt_via2$4
+ clk
+ a|inv_mc_y|inv_mc_y_via|mc|tg_fbm_a|tg_fbm_a_via|y$4
+ vss
+ nfet L=0.15U W=0.42U AS=0.1974P AD=0.1974P PS=1.78U PD=1.78U
* device instance $57 r0 *1 253.275,268.85 nfet
M$57
+ vss
+ a|inv_mc_a|mb|mnab_y|mpa_y|mpb_y|nand_m_y|tg_s_a|y$5
+ a|inv_mc_y|inv_mc_y_via|mc|tg_fbm_a|tg_fbm_a_via|y$4
+ vss
+ nfet L=0.15U W=0.42U AS=0.1974P AD=0.1974P PS=1.78U PD=1.78U
* device instance $58 r0 *1 267.8,268.85 nfet
M$58
+ a|b|m_east|m_west|nand_m_a|nand_m_a_ext_via|nand_m_a_ext_via2|nand_m_a_stub|tg_d_b|tg_d_b_via|tg_d_b_via2|tg_fbm_b|tg_fbm_b_alt_via|tg_fbm_b_alt_via2$4
+ clkb|clkb_bridge1|clkb_bridge2|clkb_mid|clkb_w|ctrl|ctrlb|inv_clk_y|tg_d_ctrlb|tg_fbm_ctrl|tg_fbs_ctrlb|tg_s_ctrl|y$4
+ vdd
+ vss
+ nfet L=0.15U W=0.42U AS=0.1974P AD=0.1974P PS=1.78U PD=1.78U
* device instance $59 r0 *1 272.565,268.85 nfet
M$59
+ vss
+ clk
+ clkb|clkb_bridge1|clkb_bridge2|clkb_mid|clkb_w|ctrl|ctrlb|inv_clk_y|tg_d_ctrlb|tg_fbm_ctrl|tg_fbs_ctrlb|tg_s_ctrl|y$4
+ vss
+ nfet L=0.15U W=0.42U AS=0.1974P AD=0.1974P PS=1.78U PD=1.78U
* device instance $60 r0 *1 279.74,268.85 nfet
M$60 a|b|inv_q_a|inv_q_a_via|s|tg_fbs_b|tg_fbs_b_via|tg_s_b|tg_s_b_via$5
+ clkb|clkb_bridge1|clkb_bridge2|clkb_mid|clkb_w|ctrl|ctrlb|inv_clk_y|tg_d_ctrlb|tg_fbm_ctrl|tg_fbs_ctrlb|tg_s_ctrl|y$5
+ a|mnab_y|mpa_y|mpb_y|nand_s2_y|qb|tg_fbs_a|y$5
+ vss
+ nfet L=0.15U W=0.42U AS=0.1974P AD=0.1974P PS=1.78U PD=1.78U
* device instance $61 r0 *1 292.225,268.85 nfet
M$61
+ vss
+ a|b|inv_q_a|inv_q_a_via|s|tg_fbs_b|tg_fbs_b_via|tg_s_b|tg_s_b_via$5
+ a|inv_q_y|inv_q_y_via|inv_q_y_via2|nand_s2_a|nand_s2_a_stub|nand_s2_a_via|nand_s2_a_via2|q|raw_bit|y
+ vss
+ nfet L=0.15U W=0.42U AS=0.1974P AD=0.1974P PS=1.78U PD=1.78U
* device instance $62 r0 *1 299.03,268.85 nfet
M$62 a|b|inv_q_a|inv_q_a_via|s|tg_fbs_b|tg_fbs_b_via|tg_s_b|tg_s_b_via$5
+ clk
+ a|inv_mc_a|mb|mnab_y|mpa_y|mpb_y|nand_m_y|tg_s_a|y
+ vss
+ nfet L=0.15U W=0.42U AS=0.1974P AD=0.1974P PS=1.78U PD=1.78U
* device instance $63 r0 *1 304.17,268.85 nfet
M$63
+ a|b|m_east|m_west|nand_m_a|nand_m_a_ext_via|nand_m_a_ext_via2|nand_m_a_stub|tg_d_b|tg_d_b_via|tg_d_b_via2|tg_fbm_b|tg_fbm_b_alt_via|tg_fbm_b_alt_via2$5
+ clk
+ a|inv_mc_y|inv_mc_y_via|mc|tg_fbm_a|tg_fbm_a_via|y$5
+ vss
+ nfet L=0.15U W=0.42U AS=0.1974P AD=0.1974P PS=1.78U PD=1.78U
* device instance $64 r0 *1 308.935,268.85 nfet
M$64
+ vss
+ a|inv_mc_a|mb|mnab_y|mpa_y|mpb_y|nand_m_y|tg_s_a|y
+ a|inv_mc_y|inv_mc_y_via|mc|tg_fbm_a|tg_fbm_a_via|y$5
+ vss
+ nfet L=0.15U W=0.42U AS=0.1974P AD=0.1974P PS=1.78U PD=1.78U
* device instance $65 r0 *1 323.46,268.85 nfet
M$65
+ a|b|m_east|m_west|nand_m_a|nand_m_a_ext_via|nand_m_a_ext_via2|nand_m_a_stub|tg_d_b|tg_d_b_via|tg_d_b_via2|tg_fbm_b|tg_fbm_b_alt_via|tg_fbm_b_alt_via2$5
+ clkb|clkb_bridge1|clkb_bridge2|clkb_mid|clkb_w|ctrl|ctrlb|inv_clk_y|tg_d_ctrlb|tg_fbm_ctrl|tg_fbs_ctrlb|tg_s_ctrl|y$5
+ a|d|sb_d_stub|tg_d_a|xo|xo_dip|xo_hop|xo_stub|y
+ vss
+ nfet L=0.15U W=0.42U AS=0.1974P AD=0.1974P PS=1.78U PD=1.78U
* device instance $66 r0 *1 328.225,268.85 nfet
M$66
+ vss
+ clk
+ clkb|clkb_bridge1|clkb_bridge2|clkb_mid|clkb_w|ctrl|ctrlb|inv_clk_y|tg_d_ctrlb|tg_fbm_ctrl|tg_fbs_ctrlb|tg_s_ctrl|y$5
+ vss
+ nfet L=0.15U W=0.42U AS=0.1974P AD=0.1974P PS=1.78U PD=1.78U
* device instance $67 r0 *1 114.01,292.485 nfet
M$67
+ vss
+ a|g_a|rn4|ro|s4_y|y
+ a|b|d|invb_a|mn12_g1|mp24_g0|ro4|ro4_esc|sr4_d_stub|tg_d_a|y
+ vss
+ nfet L=0.15U W=0.42U AS=0.1974P AD=0.1974P PS=1.78U PD=1.78U
* device instance $68 r0 *1 123.07,292.485 nfet
M$68 ny a|n4|s3_y|s4_a|y a|g_a|rn4|ro|s4_y|y
+ vss
+ nfet L=0.15U W=0.42U AS=0.1974P AD=0.1974P PS=1.78U PD=1.78U
* device instance $69 r0 *1 125.435,292.485 nfet
M$69
+ vss
+ vddr4 ny
+ vss
+ nfet L=2U W=0.48U AS=0.2016P AD=0.2016P PS=1.8U PD=1.8U
* device instance $70 r0 *1 131.245,292.485 nfet
M$70 ny$1 a|n3|s2_y|s3_a|y a|n4|s3_y|s4_a|y
+ vss
+ nfet L=0.15U W=0.42U AS=0.1974P AD=0.1974P PS=1.78U PD=1.78U
* device instance $71 r0 *1 133.61,292.485 nfet
M$71
+ vss
+ vddr4 ny$1
+ vss
+ nfet L=2U W=0.48U AS=0.2016P AD=0.2016P PS=1.8U PD=1.8U
* device instance $72 r0 *1 139.42,292.485 nfet
M$72 ny$2 a|n2|s1_y|s2_a|y a|n3|s2_y|s3_a|y
+ vss
+ nfet L=0.15U W=0.42U AS=0.1974P AD=0.1974P PS=1.78U PD=1.78U
* device instance $73 r0 *1 141.785,292.485 nfet
M$73
+ vss
+ vddr4 ny$2
+ vss
+ nfet L=2U W=0.48U AS=0.2016P AD=0.2016P PS=1.8U PD=1.8U
* device instance $74 r0 *1 147.595,292.485 nfet
M$74 ny$3 a|g_y|mnab_y|mpa_y|mpb_y|n1|s1_a|y a|n2|s1_y|s2_a|y
+ vss
+ nfet L=0.15U W=0.42U AS=0.1974P AD=0.1974P PS=1.78U PD=1.78U
* device instance $75 r0 *1 149.96,292.485 nfet
M$75
+ vss
+ vddr4 ny$3
+ vss
+ nfet L=2U W=0.48U AS=0.2016P AD=0.2016P PS=1.8U PD=1.8U
* device instance $76 r0 *1 156.225,292.485 nfet
M$76 \$8082 a|g_a|rn4|ro|s4_y|y a|g_y|mnab_y|mpa_y|mpb_y|n1|s1_a|y
+ vss
+ nfet L=0.15U W=0.84U AS=0.3948P AD=0.2184P PS=2.62U PD=1.36U
* device instance $77 r0 *1 156.895,292.485 nfet
M$77 ny$4 en4 \$8082
+ vss
+ nfet L=0.15U W=0.84U AS=0.2184P AD=0.3948P PS=1.36U PD=2.62U
* device instance $78 r0 *1 159.26,292.485 nfet
M$78
+ vss
+ vddr4 ny$4
+ vss
+ nfet L=2U W=0.48U AS=0.2016P AD=0.2016P PS=1.8U PD=1.8U
* device instance $79 r0 *1 169.31,292.485 nfet
M$79
+ vss
+ a|g_a|rn3|ro|s4_y|y
+ a|d|inva_a|mn12_g0|mp13_g0|ro3|ro3_esc_e|ro3_esc_w|ro3_hop|sr3_d_stub|tg_d_a|y
+ vss
+ nfet L=0.15U W=0.42U AS=0.1974P AD=0.1974P PS=1.78U PD=1.78U
* device instance $80 r0 *1 178.37,292.485 nfet
M$80 ny$5 a|n4|s3_y|s4_a|y$3 a|g_a|rn3|ro|s4_y|y
+ vss
+ nfet L=0.15U W=0.42U AS=0.1974P AD=0.1974P PS=1.78U PD=1.78U
* device instance $81 r0 *1 180.735,292.485 nfet
M$81
+ vss
+ vddr3 ny$5
+ vss
+ nfet L=2U W=0.46U AS=0.1932P AD=0.1932P PS=1.76U PD=1.76U
* device instance $82 r0 *1 186.545,292.485 nfet
M$82 ny$6 a|n3|s2_y|s3_a|y$1 a|n4|s3_y|s4_a|y$3
+ vss
+ nfet L=0.15U W=0.42U AS=0.1974P AD=0.1974P PS=1.78U PD=1.78U
* device instance $83 r0 *1 188.91,292.485 nfet
M$83
+ vss
+ vddr3 ny$6
+ vss
+ nfet L=2U W=0.46U AS=0.1932P AD=0.1932P PS=1.76U PD=1.76U
* device instance $84 r0 *1 194.72,292.485 nfet
M$84 ny$7 a|n2|s1_y|s2_a|y$1 a|n3|s2_y|s3_a|y$1
+ vss
+ nfet L=0.15U W=0.42U AS=0.1974P AD=0.1974P PS=1.78U PD=1.78U
* device instance $85 r0 *1 197.085,292.485 nfet
M$85
+ vss
+ vddr3 ny$7
+ vss
+ nfet L=2U W=0.46U AS=0.1932P AD=0.1932P PS=1.76U PD=1.76U
* device instance $86 r0 *1 202.895,292.485 nfet
M$86 ny$8 a|g_y|mnab_y|mpa_y|mpb_y|n1|s1_a|y$1 a|n2|s1_y|s2_a|y$1
+ vss
+ nfet L=0.15U W=0.42U AS=0.1974P AD=0.1974P PS=1.78U PD=1.78U
* device instance $87 r0 *1 205.26,292.485 nfet
M$87
+ vss
+ vddr3 ny$8
+ vss
+ nfet L=2U W=0.46U AS=0.1932P AD=0.1932P PS=1.76U PD=1.76U
* device instance $88 r0 *1 211.525,292.485 nfet
M$88 \$8089 a|g_a|rn3|ro|s4_y|y a|g_y|mnab_y|mpa_y|mpb_y|n1|s1_a|y$1
+ vss
+ nfet L=0.15U W=0.84U AS=0.3948P AD=0.2184P PS=2.62U PD=1.36U
* device instance $89 r0 *1 212.195,292.485 nfet
M$89 ny$9 en3 \$8089
+ vss
+ nfet L=0.15U W=0.84U AS=0.2184P AD=0.3948P PS=1.36U PD=2.62U
* device instance $90 r0 *1 214.56,292.485 nfet
M$90
+ vss
+ vddr3 ny$9
+ vss
+ nfet L=2U W=0.46U AS=0.1932P AD=0.1932P PS=1.76U PD=1.76U
* device instance $91 r0 *1 224.61,292.485 nfet
M$91
+ vss
+ a|g_a|rn2|ro|s4_y|y
+ a|b|d|invb_a|mn12_g1|mp24_g0|ro2|ro2_esc|sr2_d_stub|tg_d_a|y
+ vss
+ nfet L=0.15U W=0.42U AS=0.1974P AD=0.1974P PS=1.78U PD=1.78U
* device instance $92 r0 *1 233.67,292.485 nfet
M$92 ny$10 a|n4|s3_y|s4_a|y$1 a|g_a|rn2|ro|s4_y|y
+ vss
+ nfet L=0.15U W=0.42U AS=0.1974P AD=0.1974P PS=1.78U PD=1.78U
* device instance $93 r0 *1 236.035,292.485 nfet
M$93
+ vss
+ vddr2 ny$10
+ vss
+ nfet L=2U W=0.44U AS=0.1848P AD=0.1848P PS=1.72U PD=1.72U
* device instance $94 r0 *1 241.845,292.485 nfet
M$94 ny$11 a|n3|s2_y|s3_a|y$3 a|n4|s3_y|s4_a|y$1
+ vss
+ nfet L=0.15U W=0.42U AS=0.1974P AD=0.1974P PS=1.78U PD=1.78U
* device instance $95 r0 *1 244.21,292.485 nfet
M$95
+ vss
+ vddr2 ny$11
+ vss
+ nfet L=2U W=0.44U AS=0.1848P AD=0.1848P PS=1.72U PD=1.72U
* device instance $96 r0 *1 249.21,310.18 nfet
M$96
+ vss
+ a|b|b3|invb_a|mn12_g1|mp24_g0|t2|y bn|invb_y|mn34_g1|mp24_g1|y
+ vss
+ nfet L=0.15U W=0.42U AS=0.1974P AD=0.1974P PS=1.78U PD=1.78U
* device instance $97 r0 *1 250.02,292.485 nfet
M$97 ny$12 a|n2|s1_y|s2_a|y$2 a|n3|s2_y|s3_a|y$3
+ vss
+ nfet L=0.15U W=0.42U AS=0.1974P AD=0.1974P PS=1.78U PD=1.78U
* device instance $98 r0 *1 252.385,292.485 nfet
M$98
+ vss
+ vddr2 ny$12
+ vss
+ nfet L=2U W=0.44U AS=0.1848P AD=0.1848P PS=1.72U PD=1.72U
* device instance $99 r0 *1 255.38,307.86 nfet
M$99 \$8138 a|b|b3|invb_a|mn12_g1|mp24_g0|t2|y
+ vss
+ vss
+ nfet L=0.15U W=0.84U AS=0.3948P AD=0.2184P PS=2.62U PD=1.36U
* device instance $100 r0 *1 256.05,307.86 nfet
M$100 a|d|sb_d_stub|tg_d_a|xo|xo_dip|xo_hop|xo_stub|y
+ a|inva_a|mn12_g0|mp13_g0|t1|y \$8138
+ vss
+ nfet L=0.15U W=0.84U AS=0.2184P AD=0.3948P PS=1.36U PD=2.62U
* device instance $101 r0 *1 258.195,292.485 nfet
M$101 ny$13 a|g_y|mnab_y|mpa_y|mpb_y|n1|s1_a|y$2 a|n2|s1_y|s2_a|y$2
+ vss
+ nfet L=0.15U W=0.42U AS=0.1974P AD=0.1974P PS=1.78U PD=1.78U
* device instance $102 r0 *1 260.56,292.485 nfet
M$102
+ vss
+ vddr2 ny$13
+ vss
+ nfet L=2U W=0.44U AS=0.1848P AD=0.1848P PS=1.72U PD=1.72U
* device instance $103 r0 *1 262.38,307.86 nfet
M$103 \$8140 bn|invb_y|mn34_g1|mp24_g1|y
+ vss
+ vss
+ nfet L=0.15U W=0.84U AS=0.3948P AD=0.2184P PS=2.62U PD=1.36U
* device instance $104 r0 *1 263.05,307.86 nfet
M$104 a|d|sb_d_stub|tg_d_a|xo|xo_dip|xo_hop|xo_stub|y
+ an|inva_y|mn34_g0|mp13_g1|y \$8140
+ vss
+ nfet L=0.15U W=0.84U AS=0.2184P AD=0.3948P PS=1.36U PD=2.62U
* device instance $105 r0 *1 266.825,292.485 nfet
M$105 \$8095 a|g_a|rn2|ro|s4_y|y a|g_y|mnab_y|mpa_y|mpb_y|n1|s1_a|y$2
+ vss
+ nfet L=0.15U W=0.84U AS=0.3948P AD=0.2184P PS=2.62U PD=1.36U
* device instance $106 r0 *1 267.495,292.485 nfet
M$106 ny$14 en2 \$8095
+ vss
+ nfet L=0.15U W=0.84U AS=0.2184P AD=0.3948P PS=1.36U PD=2.62U
* device instance $107 r0 *1 267.385,310.18 nfet
M$107
+ vss
+ a|inva_a|mn12_g0|mp13_g0|t1|y an|inva_y|mn34_g0|mp13_g1|y
+ vss
+ nfet L=0.15U W=0.42U AS=0.1974P AD=0.1974P PS=1.78U PD=1.78U
* device instance $108 r0 *1 269.86,292.485 nfet
M$108
+ vss
+ vddr2 ny$14
+ vss
+ nfet L=2U W=0.44U AS=0.1848P AD=0.1848P PS=1.72U PD=1.72U
* device instance $109 r0 *1 278.18,310.18 nfet
M$109
+ vss
+ a|b|d|invb_a|mn12_g1|mp24_g0|ro4|ro4_esc|sr4_d_stub|tg_d_a|y
+ bn|invb_y|mn34_g1|mp24_g1|y$1
+ vss
+ nfet L=0.15U W=0.42U AS=0.1974P AD=0.1974P PS=1.78U PD=1.78U
* device instance $110 r0 *1 279.91,292.485 nfet
M$110
+ vss
+ a|g_a|rn1|ro|s4_y|y
+ a|d|inva_a|mn12_g0|mp13_g0|ro1|ro1_esc|sr1_d_stub|tg_d_a|y
+ vss
+ nfet L=0.15U W=0.42U AS=0.1974P AD=0.1974P PS=1.78U PD=1.78U
* device instance $111 r0 *1 284.35,307.86 nfet
M$111 \$8141 a|b|d|invb_a|mn12_g1|mp24_g0|ro4|ro4_esc|sr4_d_stub|tg_d_a|y
+ vss
+ vss
+ nfet L=0.15U W=0.84U AS=0.3948P AD=0.2184P PS=2.62U PD=1.36U
* device instance $112 r0 *1 285.02,307.86 nfet
M$112 a|b|b3|invb_a|mn12_g1|mp24_g0|t2|y
+ a|d|inva_a|mn12_g0|mp13_g0|ro3|ro3_esc_e|ro3_esc_w|ro3_hop|sr3_d_stub|tg_d_a|y
+ \$8141
+ vss
+ nfet L=0.15U W=0.84U AS=0.2184P AD=0.3948P PS=1.36U PD=2.62U
* device instance $113 r0 *1 288.97,292.485 nfet
M$113 ny$15 a|n4|s3_y|s4_a|y$2 a|g_a|rn1|ro|s4_y|y
+ vss
+ nfet L=0.15U W=0.42U AS=0.1974P AD=0.1974P PS=1.78U PD=1.78U
* device instance $114 r0 *1 291.335,292.485 nfet
M$114
+ vss
+ vddr1 ny$15
+ vss
+ nfet L=2U W=0.42U AS=0.1764P AD=0.1764P PS=1.68U PD=1.68U
* device instance $115 r0 *1 291.35,307.86 nfet
M$115 \$8142 bn|invb_y|mn34_g1|mp24_g1|y$1
+ vss
+ vss
+ nfet L=0.15U W=0.84U AS=0.3948P AD=0.2184P PS=2.62U PD=1.36U
* device instance $116 r0 *1 292.02,307.86 nfet
M$116 a|b|b3|invb_a|mn12_g1|mp24_g0|t2|y an|inva_y|mn34_g0|mp13_g1|y$1 \$8142
+ vss
+ nfet L=0.15U W=0.84U AS=0.2184P AD=0.3948P PS=1.36U PD=2.62U
* device instance $117 r0 *1 296.355,310.18 nfet
M$117
+ vss
+ a|d|inva_a|mn12_g0|mp13_g0|ro3|ro3_esc_e|ro3_esc_w|ro3_hop|sr3_d_stub|tg_d_a|y
+ an|inva_y|mn34_g0|mp13_g1|y$1
+ vss
+ nfet L=0.15U W=0.42U AS=0.1974P AD=0.1974P PS=1.78U PD=1.78U
* device instance $118 r0 *1 297.145,292.485 nfet
M$118 ny$16 a|n3|s2_y|s3_a|y$2 a|n4|s3_y|s4_a|y$2
+ vss
+ nfet L=0.15U W=0.42U AS=0.1974P AD=0.1974P PS=1.78U PD=1.78U
* device instance $119 r0 *1 299.51,292.485 nfet
M$119
+ vss
+ vddr1 ny$16
+ vss
+ nfet L=2U W=0.42U AS=0.1764P AD=0.1764P PS=1.68U PD=1.68U
* device instance $120 r0 *1 305.32,292.485 nfet
M$120 ny$17 a|n2|s1_y|s2_a|y$3 a|n3|s2_y|s3_a|y$2
+ vss
+ nfet L=0.15U W=0.42U AS=0.1974P AD=0.1974P PS=1.78U PD=1.78U
* device instance $121 r0 *1 307.685,292.485 nfet
M$121
+ vss
+ vddr1 ny$17
+ vss
+ nfet L=2U W=0.42U AS=0.1764P AD=0.1764P PS=1.68U PD=1.68U
* device instance $122 r0 *1 307.15,310.18 nfet
M$122
+ vss
+ a|b|d|invb_a|mn12_g1|mp24_g0|ro2|ro2_esc|sr2_d_stub|tg_d_a|y
+ bn|invb_y|mn34_g1|mp24_g1|y$2
+ vss
+ nfet L=0.15U W=0.42U AS=0.1974P AD=0.1974P PS=1.78U PD=1.78U
* device instance $123 r0 *1 313.32,307.86 nfet
M$123 \$8143 a|b|d|invb_a|mn12_g1|mp24_g0|ro2|ro2_esc|sr2_d_stub|tg_d_a|y
+ vss
+ vss
+ nfet L=0.15U W=0.84U AS=0.3948P AD=0.2184P PS=2.62U PD=1.36U
* device instance $124 r0 *1 313.99,307.86 nfet
M$124 a|inva_a|mn12_g0|mp13_g0|t1|y
+ a|d|inva_a|mn12_g0|mp13_g0|ro1|ro1_esc|sr1_d_stub|tg_d_a|y \$8143
+ vss
+ nfet L=0.15U W=0.84U AS=0.2184P AD=0.3948P PS=1.36U PD=2.62U
* device instance $125 r0 *1 313.495,292.485 nfet
M$125 ny$18 a|g_y|mnab_y|mpa_y|mpb_y|n1|s1_a|y$3 a|n2|s1_y|s2_a|y$3
+ vss
+ nfet L=0.15U W=0.42U AS=0.1974P AD=0.1974P PS=1.78U PD=1.78U
* device instance $126 r0 *1 315.86,292.485 nfet
M$126
+ vss
+ vddr1 ny$18
+ vss
+ nfet L=2U W=0.42U AS=0.1764P AD=0.1764P PS=1.68U PD=1.68U
* device instance $127 r0 *1 320.32,307.86 nfet
M$127 \$8144 bn|invb_y|mn34_g1|mp24_g1|y$2
+ vss
+ vss
+ nfet L=0.15U W=0.84U AS=0.3948P AD=0.2184P PS=2.62U PD=1.36U
* device instance $128 r0 *1 320.99,307.86 nfet
M$128 a|inva_a|mn12_g0|mp13_g0|t1|y an|inva_y|mn34_g0|mp13_g1|y$2 \$8144
+ vss
+ nfet L=0.15U W=0.84U AS=0.2184P AD=0.3948P PS=1.36U PD=2.62U
* device instance $129 r0 *1 322.125,292.485 nfet
M$129 \$8101 a|g_a|rn1|ro|s4_y|y a|g_y|mnab_y|mpa_y|mpb_y|n1|s1_a|y$3
+ vss
+ nfet L=0.15U W=0.84U AS=0.3948P AD=0.2184P PS=2.62U PD=1.36U
* device instance $130 r0 *1 322.795,292.485 nfet
M$130 ny$19 en1 \$8101
+ vss
+ nfet L=0.15U W=0.84U AS=0.2184P AD=0.3948P PS=1.36U PD=2.62U
* device instance $131 r0 *1 325.16,292.485 nfet
M$131
+ vss
+ vddr1 ny$19
+ vss
+ nfet L=2U W=0.42U AS=0.1764P AD=0.1764P PS=1.68U PD=1.68U
* device instance $132 r0 *1 325.325,310.18 nfet
M$132
+ vss
+ a|d|inva_a|mn12_g0|mp13_g0|ro1|ro1_esc|sr1_d_stub|tg_d_a|y
+ an|inva_y|mn34_g0|mp13_g1|y$2
+ vss
+ nfet L=0.15U W=0.42U AS=0.1974P AD=0.1974P PS=1.78U PD=1.78U
* device instance $133 r0 *1 1.44,272.17 pfet
M$133 a|b|inv_q_a|inv_q_a_via|s|tg_fbs_b|tg_fbs_b_via|tg_s_b|tg_s_b_via$2
+ clk
+ a|mnab_y|mpa_y|mpb_y|nand_s2_y|qb|tg_fbs_a|y
+ vdd
+ pfet L=0.15U W=0.84U AS=0.3948P AD=0.3948P PS=2.62U PD=2.62U
* device instance $134 r0 *1 13.925,272.17 pfet
M$134
+ vdd
+ a|b|inv_q_a|inv_q_a_via|s|tg_fbs_b|tg_fbs_b_via|tg_s_b|tg_s_b_via$2
+ ring_bit4
+ vdd
+ pfet L=0.15U W=0.84U AS=0.3948P AD=0.3948P PS=2.62U PD=2.62U
* device instance $135 r0 *1 20.73,272.17 pfet
M$135 a|b|inv_q_a|inv_q_a_via|s|tg_fbs_b|tg_fbs_b_via|tg_s_b|tg_s_b_via$2
+ clkb|clkb_bridge1|clkb_bridge2|clkb_mid|clkb_w|ctrl|ctrlb|inv_clk_y|tg_d_ctrlb|tg_fbm_ctrl|tg_fbs_ctrlb|tg_s_ctrl|y
+ a|inv_mc_a|mb|mnab_y|mpa_y|mpb_y|nand_m_y|tg_s_a|y$1
+ vdd
+ pfet L=0.15U W=0.84U AS=0.3948P AD=0.3948P PS=2.62U PD=2.62U
* device instance $136 r0 *1 25.87,272.17 pfet
M$136
+ a|b|m_east|m_west|nand_m_a|nand_m_a_ext_via|nand_m_a_ext_via2|nand_m_a_stub|tg_d_b|tg_d_b_via|tg_d_b_via2|tg_fbm_b|tg_fbm_b_alt_via|tg_fbm_b_alt_via2
+ clkb|clkb_bridge1|clkb_bridge2|clkb_mid|clkb_w|ctrl|ctrlb|inv_clk_y|tg_d_ctrlb|tg_fbm_ctrl|tg_fbs_ctrlb|tg_s_ctrl|y
+ a|inv_mc_y|inv_mc_y_via|mc|tg_fbm_a|tg_fbm_a_via|y
+ vdd
+ pfet L=0.15U W=0.84U AS=0.3948P AD=0.3948P PS=2.62U PD=2.62U
* device instance $137 r0 *1 30.635,272.17 pfet
M$137
+ vdd
+ a|inv_mc_a|mb|mnab_y|mpa_y|mpb_y|nand_m_y|tg_s_a|y$1
+ a|inv_mc_y|inv_mc_y_via|mc|tg_fbm_a|tg_fbm_a_via|y
+ vdd
+ pfet L=0.15U W=0.84U AS=0.3948P AD=0.3948P PS=2.62U PD=2.62U
* device instance $138 r0 *1 45.16,272.17 pfet
M$138
+ a|b|m_east|m_west|nand_m_a|nand_m_a_ext_via|nand_m_a_ext_via2|nand_m_a_stub|tg_d_b|tg_d_b_via|tg_d_b_via2|tg_fbm_b|tg_fbm_b_alt_via|tg_fbm_b_alt_via2
+ clk
+ a|b|d|invb_a|mn12_g1|mp24_g0|ro4|ro4_esc|sr4_d_stub|tg_d_a|y
+ vdd
+ pfet L=0.15U W=0.84U AS=0.3948P AD=0.3948P PS=2.62U PD=2.62U
* device instance $139 r0 *1 49.925,272.17 pfet
M$139
+ vdd
+ clk
+ clkb|clkb_bridge1|clkb_bridge2|clkb_mid|clkb_w|ctrl|ctrlb|inv_clk_y|tg_d_ctrlb|tg_fbm_ctrl|tg_fbs_ctrlb|tg_s_ctrl|y
+ vdd
+ pfet L=0.15U W=0.84U AS=0.3948P AD=0.3948P PS=2.62U PD=2.62U
* device instance $140 r0 *1 57.1,272.17 pfet
M$140 a|b|inv_q_a|inv_q_a_via|s|tg_fbs_b|tg_fbs_b_via|tg_s_b|tg_s_b_via$3
+ clk
+ a|mnab_y|mpa_y|mpb_y|nand_s2_y|qb|tg_fbs_a|y$1
+ vdd
+ pfet L=0.15U W=0.84U AS=0.3948P AD=0.3948P PS=2.62U PD=2.62U
* device instance $141 r0 *1 69.585,272.17 pfet
M$141
+ vdd
+ a|b|inv_q_a|inv_q_a_via|s|tg_fbs_b|tg_fbs_b_via|tg_s_b|tg_s_b_via$3
+ ring_bit3
+ vdd
+ pfet L=0.15U W=0.84U AS=0.3948P AD=0.3948P PS=2.62U PD=2.62U
* device instance $142 r0 *1 76.39,272.17 pfet
M$142 a|b|inv_q_a|inv_q_a_via|s|tg_fbs_b|tg_fbs_b_via|tg_s_b|tg_s_b_via$3
+ clkb|clkb_bridge1|clkb_bridge2|clkb_mid|clkb_w|ctrl|ctrlb|inv_clk_y|tg_d_ctrlb|tg_fbm_ctrl|tg_fbs_ctrlb|tg_s_ctrl|y$1
+ a|inv_mc_a|mb|mnab_y|mpa_y|mpb_y|nand_m_y|tg_s_a|y$2
+ vdd
+ pfet L=0.15U W=0.84U AS=0.3948P AD=0.3948P PS=2.62U PD=2.62U
* device instance $143 r0 *1 81.53,272.17 pfet
M$143
+ a|b|m_east|m_west|nand_m_a|nand_m_a_ext_via|nand_m_a_ext_via2|nand_m_a_stub|tg_d_b|tg_d_b_via|tg_d_b_via2|tg_fbm_b|tg_fbm_b_alt_via|tg_fbm_b_alt_via2$1
+ clkb|clkb_bridge1|clkb_bridge2|clkb_mid|clkb_w|ctrl|ctrlb|inv_clk_y|tg_d_ctrlb|tg_fbm_ctrl|tg_fbs_ctrlb|tg_s_ctrl|y$1
+ a|inv_mc_y|inv_mc_y_via|mc|tg_fbm_a|tg_fbm_a_via|y$1
+ vdd
+ pfet L=0.15U W=0.84U AS=0.3948P AD=0.3948P PS=2.62U PD=2.62U
* device instance $144 r0 *1 86.295,272.17 pfet
M$144
+ vdd
+ a|inv_mc_a|mb|mnab_y|mpa_y|mpb_y|nand_m_y|tg_s_a|y$2
+ a|inv_mc_y|inv_mc_y_via|mc|tg_fbm_a|tg_fbm_a_via|y$1
+ vdd
+ pfet L=0.15U W=0.84U AS=0.3948P AD=0.3948P PS=2.62U PD=2.62U
* device instance $145 r0 *1 100.82,272.17 pfet
M$145
+ a|b|m_east|m_west|nand_m_a|nand_m_a_ext_via|nand_m_a_ext_via2|nand_m_a_stub|tg_d_b|tg_d_b_via|tg_d_b_via2|tg_fbm_b|tg_fbm_b_alt_via|tg_fbm_b_alt_via2$1
+ clk
+ a|d|inva_a|mn12_g0|mp13_g0|ro3|ro3_esc_e|ro3_esc_w|ro3_hop|sr3_d_stub|tg_d_a|y
+ vdd
+ pfet L=0.15U W=0.84U AS=0.3948P AD=0.3948P PS=2.62U PD=2.62U
* device instance $146 r0 *1 105.585,272.17 pfet
M$146
+ vdd
+ clk
+ clkb|clkb_bridge1|clkb_bridge2|clkb_mid|clkb_w|ctrl|ctrlb|inv_clk_y|tg_d_ctrlb|tg_fbm_ctrl|tg_fbs_ctrlb|tg_s_ctrl|y$1
+ vdd
+ pfet L=0.15U W=0.84U AS=0.3948P AD=0.3948P PS=2.62U PD=2.62U
* device instance $147 r0 *1 112.76,272.17 pfet
M$147 a|b|inv_q_a|inv_q_a_via|s|tg_fbs_b|tg_fbs_b_via|tg_s_b|tg_s_b_via$4
+ clk
+ a|mnab_y|mpa_y|mpb_y|nand_s2_y|qb|tg_fbs_a|y$2
+ vdd
+ pfet L=0.15U W=0.84U AS=0.3948P AD=0.3948P PS=2.62U PD=2.62U
* device instance $148 r0 *1 125.245,272.17 pfet
M$148
+ vdd
+ a|b|inv_q_a|inv_q_a_via|s|tg_fbs_b|tg_fbs_b_via|tg_s_b|tg_s_b_via$4
+ ring_bit2
+ vdd
+ pfet L=0.15U W=0.84U AS=0.3948P AD=0.3948P PS=2.62U PD=2.62U
* device instance $149 r0 *1 132.05,272.17 pfet
M$149 a|b|inv_q_a|inv_q_a_via|s|tg_fbs_b|tg_fbs_b_via|tg_s_b|tg_s_b_via$4
+ clkb|clkb_bridge1|clkb_bridge2|clkb_mid|clkb_w|ctrl|ctrlb|inv_clk_y|tg_d_ctrlb|tg_fbm_ctrl|tg_fbs_ctrlb|tg_s_ctrl|y$2
+ a|inv_mc_a|mb|mnab_y|mpa_y|mpb_y|nand_m_y|tg_s_a|y$3
+ vdd
+ pfet L=0.15U W=0.84U AS=0.3948P AD=0.3948P PS=2.62U PD=2.62U
* device instance $150 r0 *1 137.19,272.17 pfet
M$150
+ a|b|m_east|m_west|nand_m_a|nand_m_a_ext_via|nand_m_a_ext_via2|nand_m_a_stub|tg_d_b|tg_d_b_via|tg_d_b_via2|tg_fbm_b|tg_fbm_b_alt_via|tg_fbm_b_alt_via2$2
+ clkb|clkb_bridge1|clkb_bridge2|clkb_mid|clkb_w|ctrl|ctrlb|inv_clk_y|tg_d_ctrlb|tg_fbm_ctrl|tg_fbs_ctrlb|tg_s_ctrl|y$2
+ a|inv_mc_y|inv_mc_y_via|mc|tg_fbm_a|tg_fbm_a_via|y$2
+ vdd
+ pfet L=0.15U W=0.84U AS=0.3948P AD=0.3948P PS=2.62U PD=2.62U
* device instance $151 r0 *1 141.955,272.17 pfet
M$151
+ vdd
+ a|inv_mc_a|mb|mnab_y|mpa_y|mpb_y|nand_m_y|tg_s_a|y$3
+ a|inv_mc_y|inv_mc_y_via|mc|tg_fbm_a|tg_fbm_a_via|y$2
+ vdd
+ pfet L=0.15U W=0.84U AS=0.3948P AD=0.3948P PS=2.62U PD=2.62U
* device instance $152 r0 *1 156.48,272.17 pfet
M$152
+ a|b|m_east|m_west|nand_m_a|nand_m_a_ext_via|nand_m_a_ext_via2|nand_m_a_stub|tg_d_b|tg_d_b_via|tg_d_b_via2|tg_fbm_b|tg_fbm_b_alt_via|tg_fbm_b_alt_via2$2
+ clk
+ a|b|d|invb_a|mn12_g1|mp24_g0|ro2|ro2_esc|sr2_d_stub|tg_d_a|y
+ vdd
+ pfet L=0.15U W=0.84U AS=0.3948P AD=0.3948P PS=2.62U PD=2.62U
* device instance $153 r0 *1 161.245,272.17 pfet
M$153
+ vdd
+ clk
+ clkb|clkb_bridge1|clkb_bridge2|clkb_mid|clkb_w|ctrl|ctrlb|inv_clk_y|tg_d_ctrlb|tg_fbm_ctrl|tg_fbs_ctrlb|tg_s_ctrl|y$2
+ vdd
+ pfet L=0.15U W=0.84U AS=0.3948P AD=0.3948P PS=2.62U PD=2.62U
* device instance $154 r0 *1 168.42,272.17 pfet
M$154 a|b|inv_q_a|inv_q_a_via|s|tg_fbs_b|tg_fbs_b_via|tg_s_b|tg_s_b_via
+ clk
+ a|mnab_y|mpa_y|mpb_y|nand_s2_y|qb|tg_fbs_a|y$3
+ vdd
+ pfet L=0.15U W=0.84U AS=0.3948P AD=0.3948P PS=2.62U PD=2.62U
* device instance $155 r0 *1 180.905,272.17 pfet
M$155
+ vdd
+ a|b|inv_q_a|inv_q_a_via|s|tg_fbs_b|tg_fbs_b_via|tg_s_b|tg_s_b_via
+ ring_bit1
+ vdd
+ pfet L=0.15U W=0.84U AS=0.3948P AD=0.3948P PS=2.62U PD=2.62U
* device instance $156 r0 *1 187.71,272.17 pfet
M$156 a|b|inv_q_a|inv_q_a_via|s|tg_fbs_b|tg_fbs_b_via|tg_s_b|tg_s_b_via
+ clkb|clkb_bridge1|clkb_bridge2|clkb_mid|clkb_w|ctrl|ctrlb|inv_clk_y|tg_d_ctrlb|tg_fbm_ctrl|tg_fbs_ctrlb|tg_s_ctrl|y$3
+ a|inv_mc_a|mb|mnab_y|mpa_y|mpb_y|nand_m_y|tg_s_a|y$4
+ vdd
+ pfet L=0.15U W=0.84U AS=0.3948P AD=0.3948P PS=2.62U PD=2.62U
* device instance $157 r0 *1 192.85,272.17 pfet
M$157
+ a|b|m_east|m_west|nand_m_a|nand_m_a_ext_via|nand_m_a_ext_via2|nand_m_a_stub|tg_d_b|tg_d_b_via|tg_d_b_via2|tg_fbm_b|tg_fbm_b_alt_via|tg_fbm_b_alt_via2$3
+ clkb|clkb_bridge1|clkb_bridge2|clkb_mid|clkb_w|ctrl|ctrlb|inv_clk_y|tg_d_ctrlb|tg_fbm_ctrl|tg_fbs_ctrlb|tg_s_ctrl|y$3
+ a|inv_mc_y|inv_mc_y_via|mc|tg_fbm_a|tg_fbm_a_via|y$3
+ vdd
+ pfet L=0.15U W=0.84U AS=0.3948P AD=0.3948P PS=2.62U PD=2.62U
* device instance $158 r0 *1 197.615,272.17 pfet
M$158
+ vdd
+ a|inv_mc_a|mb|mnab_y|mpa_y|mpb_y|nand_m_y|tg_s_a|y$4
+ a|inv_mc_y|inv_mc_y_via|mc|tg_fbm_a|tg_fbm_a_via|y$3
+ vdd
+ pfet L=0.15U W=0.84U AS=0.3948P AD=0.3948P PS=2.62U PD=2.62U
* device instance $159 r0 *1 212.14,272.17 pfet
M$159
+ a|b|m_east|m_west|nand_m_a|nand_m_a_ext_via|nand_m_a_ext_via2|nand_m_a_stub|tg_d_b|tg_d_b_via|tg_d_b_via2|tg_fbm_b|tg_fbm_b_alt_via|tg_fbm_b_alt_via2$3
+ clk
+ a|d|inva_a|mn12_g0|mp13_g0|ro1|ro1_esc|sr1_d_stub|tg_d_a|y
+ vdd
+ pfet L=0.15U W=0.84U AS=0.3948P AD=0.3948P PS=2.62U PD=2.62U
* device instance $160 r0 *1 216.905,272.17 pfet
M$160
+ vdd
+ clk
+ clkb|clkb_bridge1|clkb_bridge2|clkb_mid|clkb_w|ctrl|ctrlb|inv_clk_y|tg_d_ctrlb|tg_fbm_ctrl|tg_fbs_ctrlb|tg_s_ctrl|y$3
+ vdd
+ pfet L=0.15U W=0.84U AS=0.3948P AD=0.3948P PS=2.62U PD=2.62U
* device instance $161 r0 *1 224.08,272.17 pfet
M$161 a|b|inv_q_a|inv_q_a_via|s|tg_fbs_b|tg_fbs_b_via|tg_s_b|tg_s_b_via$1
+ clk
+ a|mnab_y|mpa_y|mpb_y|nand_s2_y|qb|tg_fbs_a|y$4
+ vdd
+ pfet L=0.15U W=0.84U AS=0.3948P AD=0.3948P PS=2.62U PD=2.62U
* device instance $162 r0 *1 236.565,272.17 pfet
M$162
+ vdd
+ a|b|inv_q_a|inv_q_a_via|s|tg_fbs_b|tg_fbs_b_via|tg_s_b|tg_s_b_via$1
+ a|inv_q_y|inv_q_y_via|inv_q_y_via2|nand_s2_a|nand_s2_a_stub|nand_s2_a_via|nand_s2_a_via2|q|raw_valid|y
+ vdd
+ pfet L=0.15U W=0.84U AS=0.3948P AD=0.3948P PS=2.62U PD=2.62U
* device instance $163 r0 *1 243.37,272.17 pfet
M$163 a|b|inv_q_a|inv_q_a_via|s|tg_fbs_b|tg_fbs_b_via|tg_s_b|tg_s_b_via$1
+ clkb|clkb_bridge1|clkb_bridge2|clkb_mid|clkb_w|ctrl|ctrlb|inv_clk_y|tg_d_ctrlb|tg_fbm_ctrl|tg_fbs_ctrlb|tg_s_ctrl|y$4
+ a|inv_mc_a|mb|mnab_y|mpa_y|mpb_y|nand_m_y|tg_s_a|y$5
+ vdd
+ pfet L=0.15U W=0.84U AS=0.3948P AD=0.3948P PS=2.62U PD=2.62U
* device instance $164 r0 *1 248.51,272.17 pfet
M$164
+ a|b|m_east|m_west|nand_m_a|nand_m_a_ext_via|nand_m_a_ext_via2|nand_m_a_stub|tg_d_b|tg_d_b_via|tg_d_b_via2|tg_fbm_b|tg_fbm_b_alt_via|tg_fbm_b_alt_via2$4
+ clkb|clkb_bridge1|clkb_bridge2|clkb_mid|clkb_w|ctrl|ctrlb|inv_clk_y|tg_d_ctrlb|tg_fbm_ctrl|tg_fbs_ctrlb|tg_s_ctrl|y$4
+ a|inv_mc_y|inv_mc_y_via|mc|tg_fbm_a|tg_fbm_a_via|y$4
+ vdd
+ pfet L=0.15U W=0.84U AS=0.3948P AD=0.3948P PS=2.62U PD=2.62U
* device instance $165 r0 *1 253.275,272.17 pfet
M$165
+ vdd
+ a|inv_mc_a|mb|mnab_y|mpa_y|mpb_y|nand_m_y|tg_s_a|y$5
+ a|inv_mc_y|inv_mc_y_via|mc|tg_fbm_a|tg_fbm_a_via|y$4
+ vdd
+ pfet L=0.15U W=0.84U AS=0.3948P AD=0.3948P PS=2.62U PD=2.62U
* device instance $166 r0 *1 267.8,272.17 pfet
M$166
+ a|b|m_east|m_west|nand_m_a|nand_m_a_ext_via|nand_m_a_ext_via2|nand_m_a_stub|tg_d_b|tg_d_b_via|tg_d_b_via2|tg_fbm_b|tg_fbm_b_alt_via|tg_fbm_b_alt_via2$4
+ clk
+ vdd
+ vdd
+ pfet L=0.15U W=0.84U AS=0.3948P AD=0.3948P PS=2.62U PD=2.62U
* device instance $167 r0 *1 272.565,272.17 pfet
M$167
+ vdd
+ clk
+ clkb|clkb_bridge1|clkb_bridge2|clkb_mid|clkb_w|ctrl|ctrlb|inv_clk_y|tg_d_ctrlb|tg_fbm_ctrl|tg_fbs_ctrlb|tg_s_ctrl|y$4
+ vdd
+ pfet L=0.15U W=0.84U AS=0.3948P AD=0.3948P PS=2.62U PD=2.62U
* device instance $168 r0 *1 279.74,272.17 pfet
M$168 a|b|inv_q_a|inv_q_a_via|s|tg_fbs_b|tg_fbs_b_via|tg_s_b|tg_s_b_via$5
+ clk
+ a|mnab_y|mpa_y|mpb_y|nand_s2_y|qb|tg_fbs_a|y$5
+ vdd
+ pfet L=0.15U W=0.84U AS=0.3948P AD=0.3948P PS=2.62U PD=2.62U
* device instance $169 r0 *1 292.225,272.17 pfet
M$169
+ vdd
+ a|b|inv_q_a|inv_q_a_via|s|tg_fbs_b|tg_fbs_b_via|tg_s_b|tg_s_b_via$5
+ a|inv_q_y|inv_q_y_via|inv_q_y_via2|nand_s2_a|nand_s2_a_stub|nand_s2_a_via|nand_s2_a_via2|q|raw_bit|y
+ vdd
+ pfet L=0.15U W=0.84U AS=0.3948P AD=0.3948P PS=2.62U PD=2.62U
* device instance $170 r0 *1 299.03,272.17 pfet
M$170 a|b|inv_q_a|inv_q_a_via|s|tg_fbs_b|tg_fbs_b_via|tg_s_b|tg_s_b_via$5
+ clkb|clkb_bridge1|clkb_bridge2|clkb_mid|clkb_w|ctrl|ctrlb|inv_clk_y|tg_d_ctrlb|tg_fbm_ctrl|tg_fbs_ctrlb|tg_s_ctrl|y$5
+ a|inv_mc_a|mb|mnab_y|mpa_y|mpb_y|nand_m_y|tg_s_a|y
+ vdd
+ pfet L=0.15U W=0.84U AS=0.3948P AD=0.3948P PS=2.62U PD=2.62U
* device instance $171 r0 *1 304.17,272.17 pfet
M$171
+ a|b|m_east|m_west|nand_m_a|nand_m_a_ext_via|nand_m_a_ext_via2|nand_m_a_stub|tg_d_b|tg_d_b_via|tg_d_b_via2|tg_fbm_b|tg_fbm_b_alt_via|tg_fbm_b_alt_via2$5
+ clkb|clkb_bridge1|clkb_bridge2|clkb_mid|clkb_w|ctrl|ctrlb|inv_clk_y|tg_d_ctrlb|tg_fbm_ctrl|tg_fbs_ctrlb|tg_s_ctrl|y$5
+ a|inv_mc_y|inv_mc_y_via|mc|tg_fbm_a|tg_fbm_a_via|y$5
+ vdd
+ pfet L=0.15U W=0.84U AS=0.3948P AD=0.3948P PS=2.62U PD=2.62U
* device instance $172 r0 *1 308.935,272.17 pfet
M$172
+ vdd
+ a|inv_mc_a|mb|mnab_y|mpa_y|mpb_y|nand_m_y|tg_s_a|y
+ a|inv_mc_y|inv_mc_y_via|mc|tg_fbm_a|tg_fbm_a_via|y$5
+ vdd
+ pfet L=0.15U W=0.84U AS=0.3948P AD=0.3948P PS=2.62U PD=2.62U
* device instance $173 r0 *1 323.46,272.17 pfet
M$173
+ a|b|m_east|m_west|nand_m_a|nand_m_a_ext_via|nand_m_a_ext_via2|nand_m_a_stub|tg_d_b|tg_d_b_via|tg_d_b_via2|tg_fbm_b|tg_fbm_b_alt_via|tg_fbm_b_alt_via2$5
+ clk
+ a|d|sb_d_stub|tg_d_a|xo|xo_dip|xo_hop|xo_stub|y
+ vdd
+ pfet L=0.15U W=0.84U AS=0.3948P AD=0.3948P PS=2.62U PD=2.62U
* device instance $174 r0 *1 328.225,272.17 pfet
M$174
+ vdd
+ clk
+ clkb|clkb_bridge1|clkb_bridge2|clkb_mid|clkb_w|ctrl|ctrlb|inv_clk_y|tg_d_ctrlb|tg_fbm_ctrl|tg_fbs_ctrlb|tg_s_ctrl|y$5
+ vdd
+ pfet L=0.15U W=0.84U AS=0.3948P AD=0.3948P PS=2.62U PD=2.62U
* device instance $175 r0 *1 6.205,272.38 pfet
M$175 a|mnab_y|mpa_y|mpb_y|nand_s2_y|qb|tg_fbs_a|y
+ ring_bit4
+ vdd
+ vdd
+ pfet L=0.15U W=0.84U AS=0.3948P AD=0.3948P PS=2.62U PD=2.62U
* device instance $176 r0 *1 7.495,272.38 pfet
M$176
+ vdd
+ rst_n
+ a|mnab_y|mpa_y|mpb_y|nand_s2_y|qb|tg_fbs_a|y
+ vdd
+ pfet L=0.15U W=0.84U AS=0.3948P AD=0.3948P PS=2.62U PD=2.62U
* device instance $177 r0 *1 37.065,272.38 pfet
M$177 a|inv_mc_a|mb|mnab_y|mpa_y|mpb_y|nand_m_y|tg_s_a|y$1
+ a|b|m_east|m_west|nand_m_a|nand_m_a_ext_via|nand_m_a_ext_via2|nand_m_a_stub|tg_d_b|tg_d_b_via|tg_d_b_via2|tg_fbm_b|tg_fbm_b_alt_via|tg_fbm_b_alt_via2
+ vdd
+ vdd
+ pfet L=0.15U W=0.84U AS=0.3948P AD=0.3948P PS=2.62U PD=2.62U
* device instance $178 r0 *1 38.355,272.38 pfet
M$178
+ vdd
+ rst_n
+ a|inv_mc_a|mb|mnab_y|mpa_y|mpb_y|nand_m_y|tg_s_a|y$1
+ vdd
+ pfet L=0.15U W=0.84U AS=0.3948P AD=0.3948P PS=2.62U PD=2.62U
* device instance $179 r0 *1 61.865,272.38 pfet
M$179 a|mnab_y|mpa_y|mpb_y|nand_s2_y|qb|tg_fbs_a|y$1
+ ring_bit3
+ vdd
+ vdd
+ pfet L=0.15U W=0.84U AS=0.3948P AD=0.3948P PS=2.62U PD=2.62U
* device instance $180 r0 *1 63.155,272.38 pfet
M$180
+ vdd
+ rst_n
+ a|mnab_y|mpa_y|mpb_y|nand_s2_y|qb|tg_fbs_a|y$1
+ vdd
+ pfet L=0.15U W=0.84U AS=0.3948P AD=0.3948P PS=2.62U PD=2.62U
* device instance $181 r0 *1 92.725,272.38 pfet
M$181 a|inv_mc_a|mb|mnab_y|mpa_y|mpb_y|nand_m_y|tg_s_a|y$2
+ a|b|m_east|m_west|nand_m_a|nand_m_a_ext_via|nand_m_a_ext_via2|nand_m_a_stub|tg_d_b|tg_d_b_via|tg_d_b_via2|tg_fbm_b|tg_fbm_b_alt_via|tg_fbm_b_alt_via2$1
+ vdd
+ vdd
+ pfet L=0.15U W=0.84U AS=0.3948P AD=0.3948P PS=2.62U PD=2.62U
* device instance $182 r0 *1 94.015,272.38 pfet
M$182
+ vdd
+ rst_n
+ a|inv_mc_a|mb|mnab_y|mpa_y|mpb_y|nand_m_y|tg_s_a|y$2
+ vdd
+ pfet L=0.15U W=0.84U AS=0.3948P AD=0.3948P PS=2.62U PD=2.62U
* device instance $183 r0 *1 114.01,295.805 pfet
M$183
+ vdd
+ a|g_a|rn4|ro|s4_y|y
+ a|b|d|invb_a|mn12_g1|mp24_g0|ro4|ro4_esc|sr4_d_stub|tg_d_a|y
+ vdd
+ pfet L=0.15U W=0.84U AS=0.3948P AD=0.3948P PS=2.62U PD=2.62U
* device instance $184 r0 *1 117.525,272.38 pfet
M$184 a|mnab_y|mpa_y|mpb_y|nand_s2_y|qb|tg_fbs_a|y$2
+ ring_bit2
+ vdd
+ vdd
+ pfet L=0.15U W=0.84U AS=0.3948P AD=0.3948P PS=2.62U PD=2.62U
* device instance $185 r0 *1 118.815,272.38 pfet
M$185
+ vdd
+ rst_n
+ a|mnab_y|mpa_y|mpb_y|nand_s2_y|qb|tg_fbs_a|y$2
+ vdd
+ pfet L=0.15U W=0.84U AS=0.3948P AD=0.3948P PS=2.62U PD=2.62U
* device instance $186 r0 *1 123.27,296.015 pfet
M$186 py a|n4|s3_y|s4_a|y a|g_a|rn4|ro|s4_y|y
+ vddr4 pfet
+ L=0.15U W=0.84U AS=0.3948P AD=0.3948P PS=2.62U PD=2.62U
* device instance $187 r0 *1 131.445,296.015 pfet
M$187 py$1 a|n3|s2_y|s3_a|y a|n4|s3_y|s4_a|y
+ vddr4 pfet
+ L=0.15U W=0.84U AS=0.3948P AD=0.3948P PS=2.62U PD=2.62U
* device instance $188 r0 *1 139.62,296.015 pfet
M$188 py$2 a|n2|s1_y|s2_a|y a|n3|s2_y|s3_a|y
+ vddr4 pfet
+ L=0.15U W=0.84U AS=0.3948P AD=0.3948P PS=2.62U PD=2.62U
* device instance $189 r0 *1 147.795,296.015 pfet
M$189 py$3 a|g_y|mnab_y|mpa_y|mpb_y|n1|s1_a|y a|n2|s1_y|s2_a|y
+ vddr4 pfet
+ L=0.15U W=0.84U AS=0.3948P AD=0.3948P PS=2.62U PD=2.62U
* device instance $190 r0 *1 148.385,272.38 pfet
M$190 a|inv_mc_a|mb|mnab_y|mpa_y|mpb_y|nand_m_y|tg_s_a|y$3
+ a|b|m_east|m_west|nand_m_a|nand_m_a_ext_via|nand_m_a_ext_via2|nand_m_a_stub|tg_d_b|tg_d_b_via|tg_d_b_via2|tg_fbm_b|tg_fbm_b_alt_via|tg_fbm_b_alt_via2$2
+ vdd
+ vdd
+ pfet L=0.15U W=0.84U AS=0.3948P AD=0.3948P PS=2.62U PD=2.62U
* device instance $191 r0 *1 149.675,272.38 pfet
M$191
+ vdd
+ rst_n
+ a|inv_mc_a|mb|mnab_y|mpa_y|mpb_y|nand_m_y|tg_s_a|y$3
+ vdd
+ pfet L=0.15U W=0.84U AS=0.3948P AD=0.3948P PS=2.62U PD=2.62U
* device instance $192 r0 *1 155.805,296.015 pfet
M$192 a|g_y|mnab_y|mpa_y|mpb_y|n1|s1_a|y a|g_a|rn4|ro|s4_y|y
+ mpa_py|mpb_py|mph_py|py
+ vddr4 pfet
+ L=0.15U W=0.84U AS=0.3948P AD=0.3948P PS=2.62U PD=2.62U
* device instance $193 r0 *1 157.095,296.015 pfet
M$193 mpa_py|mpb_py|mph_py|py en4 a|g_y|mnab_y|mpa_y|mpb_y|n1|s1_a|y
+ vddr4 pfet
+ L=0.15U W=0.84U AS=0.3948P AD=0.3948P PS=2.62U PD=2.62U
* device instance $194 r0 *1 169.31,295.805 pfet
M$194
+ vdd
+ a|g_a|rn3|ro|s4_y|y
+ a|d|inva_a|mn12_g0|mp13_g0|ro3|ro3_esc_e|ro3_esc_w|ro3_hop|sr3_d_stub|tg_d_a|y
+ vdd
+ pfet L=0.15U W=0.84U AS=0.3948P AD=0.3948P PS=2.62U PD=2.62U
* device instance $195 r0 *1 173.185,272.38 pfet
M$195 a|mnab_y|mpa_y|mpb_y|nand_s2_y|qb|tg_fbs_a|y$3
+ ring_bit1
+ vdd
+ vdd
+ pfet L=0.15U W=0.84U AS=0.3948P AD=0.3948P PS=2.62U PD=2.62U
* device instance $196 r0 *1 174.475,272.38 pfet
M$196
+ vdd
+ rst_n
+ a|mnab_y|mpa_y|mpb_y|nand_s2_y|qb|tg_fbs_a|y$3
+ vdd
+ pfet L=0.15U W=0.84U AS=0.3948P AD=0.3948P PS=2.62U PD=2.62U
* device instance $197 r0 *1 178.57,296.015 pfet
M$197 py$4 a|n4|s3_y|s4_a|y$3 a|g_a|rn3|ro|s4_y|y
+ vddr3 pfet
+ L=0.15U W=0.84U AS=0.3948P AD=0.3948P PS=2.62U PD=2.62U
* device instance $198 r0 *1 186.745,296.015 pfet
M$198 py$5 a|n3|s2_y|s3_a|y$1 a|n4|s3_y|s4_a|y$3
+ vddr3 pfet
+ L=0.15U W=0.84U AS=0.3948P AD=0.3948P PS=2.62U PD=2.62U
* device instance $199 r0 *1 194.92,296.015 pfet
M$199 py$6 a|n2|s1_y|s2_a|y$1 a|n3|s2_y|s3_a|y$1
+ vddr3 pfet
+ L=0.15U W=0.84U AS=0.3948P AD=0.3948P PS=2.62U PD=2.62U
* device instance $200 r0 *1 203.095,296.015 pfet
M$200 py$7 a|g_y|mnab_y|mpa_y|mpb_y|n1|s1_a|y$1 a|n2|s1_y|s2_a|y$1
+ vddr3 pfet
+ L=0.15U W=0.84U AS=0.3948P AD=0.3948P PS=2.62U PD=2.62U
* device instance $201 r0 *1 204.045,272.38 pfet
M$201 a|inv_mc_a|mb|mnab_y|mpa_y|mpb_y|nand_m_y|tg_s_a|y$4
+ a|b|m_east|m_west|nand_m_a|nand_m_a_ext_via|nand_m_a_ext_via2|nand_m_a_stub|tg_d_b|tg_d_b_via|tg_d_b_via2|tg_fbm_b|tg_fbm_b_alt_via|tg_fbm_b_alt_via2$3
+ vdd
+ vdd
+ pfet L=0.15U W=0.84U AS=0.3948P AD=0.3948P PS=2.62U PD=2.62U
* device instance $202 r0 *1 205.335,272.38 pfet
M$202
+ vdd
+ rst_n
+ a|inv_mc_a|mb|mnab_y|mpa_y|mpb_y|nand_m_y|tg_s_a|y$4
+ vdd
+ pfet L=0.15U W=0.84U AS=0.3948P AD=0.3948P PS=2.62U PD=2.62U
* device instance $203 r0 *1 211.105,296.015 pfet
M$203 a|g_y|mnab_y|mpa_y|mpb_y|n1|s1_a|y$1 a|g_a|rn3|ro|s4_y|y
+ mpa_py|mpb_py|mph_py|py$1
+ vddr3 pfet
+ L=0.15U W=0.84U AS=0.3948P AD=0.3948P PS=2.62U PD=2.62U
* device instance $204 r0 *1 212.395,296.015 pfet
M$204 mpa_py|mpb_py|mph_py|py$1 en3
+ a|g_y|mnab_y|mpa_y|mpb_y|n1|s1_a|y$1
+ vddr3 pfet
+ L=0.15U W=0.84U AS=0.3948P AD=0.3948P PS=2.62U PD=2.62U
* device instance $205 r0 *1 224.61,295.805 pfet
M$205
+ vdd
+ a|g_a|rn2|ro|s4_y|y
+ a|b|d|invb_a|mn12_g1|mp24_g0|ro2|ro2_esc|sr2_d_stub|tg_d_a|y
+ vdd
+ pfet L=0.15U W=0.84U AS=0.3948P AD=0.3948P PS=2.62U PD=2.62U
* device instance $206 r0 *1 228.845,272.38 pfet
M$206 a|mnab_y|mpa_y|mpb_y|nand_s2_y|qb|tg_fbs_a|y$4
+ a|inv_q_y|inv_q_y_via|inv_q_y_via2|nand_s2_a|nand_s2_a_stub|nand_s2_a_via|nand_s2_a_via2|q|raw_valid|y
+ vdd
+ vdd
+ pfet L=0.15U W=0.84U AS=0.3948P AD=0.3948P PS=2.62U PD=2.62U
* device instance $207 r0 *1 230.135,272.38 pfet
M$207
+ vdd
+ rst_n
+ a|mnab_y|mpa_y|mpb_y|nand_s2_y|qb|tg_fbs_a|y$4
+ vdd
+ pfet L=0.15U W=0.84U AS=0.3948P AD=0.3948P PS=2.62U PD=2.62U
* device instance $208 r0 *1 233.87,296.015 pfet
M$208 py$8 a|n4|s3_y|s4_a|y$1 a|g_a|rn2|ro|s4_y|y
+ vddr2 pfet
+ L=0.15U W=0.84U AS=0.3948P AD=0.3948P PS=2.62U PD=2.62U
* device instance $209 r0 *1 242.045,296.015 pfet
M$209 py$9 a|n3|s2_y|s3_a|y$3 a|n4|s3_y|s4_a|y$1
+ vddr2 pfet
+ L=0.15U W=0.84U AS=0.3948P AD=0.3948P PS=2.62U PD=2.62U
* device instance $210 r0 *1 250.22,296.015 pfet
M$210 py$10 a|n2|s1_y|s2_a|y$2 a|n3|s2_y|s3_a|y$3
+ vddr2 pfet
+ L=0.15U W=0.84U AS=0.3948P AD=0.3948P PS=2.62U PD=2.62U
* device instance $211 r0 *1 258.395,296.015 pfet
M$211 py$11 a|g_y|mnab_y|mpa_y|mpb_y|n1|s1_a|y$2 a|n2|s1_y|s2_a|y$2
+ vddr2 pfet
+ L=0.15U W=0.84U AS=0.3948P AD=0.3948P PS=2.62U PD=2.62U
* device instance $212 r0 *1 259.705,272.38 pfet
M$212 a|inv_mc_a|mb|mnab_y|mpa_y|mpb_y|nand_m_y|tg_s_a|y$5
+ a|b|m_east|m_west|nand_m_a|nand_m_a_ext_via|nand_m_a_ext_via2|nand_m_a_stub|tg_d_b|tg_d_b_via|tg_d_b_via2|tg_fbm_b|tg_fbm_b_alt_via|tg_fbm_b_alt_via2$4
+ vdd
+ vdd
+ pfet L=0.15U W=0.84U AS=0.3948P AD=0.3948P PS=2.62U PD=2.62U
* device instance $213 r0 *1 260.995,272.38 pfet
M$213
+ vdd
+ rst_n
+ a|inv_mc_a|mb|mnab_y|mpa_y|mpb_y|nand_m_y|tg_s_a|y$5
+ vdd
+ pfet L=0.15U W=0.84U AS=0.3948P AD=0.3948P PS=2.62U PD=2.62U
* device instance $214 r0 *1 266.405,296.015 pfet
M$214 a|g_y|mnab_y|mpa_y|mpb_y|n1|s1_a|y$2 a|g_a|rn2|ro|s4_y|y
+ mpa_py|mpb_py|mph_py|py$2
+ vddr2 pfet
+ L=0.15U W=0.84U AS=0.3948P AD=0.3948P PS=2.62U PD=2.62U
* device instance $215 r0 *1 267.695,296.015 pfet
M$215 mpa_py|mpb_py|mph_py|py$2 en2
+ a|g_y|mnab_y|mpa_y|mpb_y|n1|s1_a|y$2
+ vddr2 pfet
+ L=0.15U W=0.84U AS=0.3948P AD=0.3948P PS=2.62U PD=2.62U
* device instance $216 r0 *1 279.91,295.805 pfet
M$216
+ vdd
+ a|g_a|rn1|ro|s4_y|y
+ a|d|inva_a|mn12_g0|mp13_g0|ro1|ro1_esc|sr1_d_stub|tg_d_a|y
+ vdd
+ pfet L=0.15U W=0.84U AS=0.3948P AD=0.3948P PS=2.62U PD=2.62U
* device instance $217 r0 *1 284.505,272.38 pfet
M$217 a|mnab_y|mpa_y|mpb_y|nand_s2_y|qb|tg_fbs_a|y$5
+ a|inv_q_y|inv_q_y_via|inv_q_y_via2|nand_s2_a|nand_s2_a_stub|nand_s2_a_via|nand_s2_a_via2|q|raw_bit|y
+ vdd
+ vdd
+ pfet L=0.15U W=0.84U AS=0.3948P AD=0.3948P PS=2.62U PD=2.62U
* device instance $218 r0 *1 285.795,272.38 pfet
M$218
+ vdd
+ rst_n
+ a|mnab_y|mpa_y|mpb_y|nand_s2_y|qb|tg_fbs_a|y$5
+ vdd
+ pfet L=0.15U W=0.84U AS=0.3948P AD=0.3948P PS=2.62U PD=2.62U
* device instance $219 r0 *1 289.17,296.015 pfet
M$219 py$12 a|n4|s3_y|s4_a|y$2 a|g_a|rn1|ro|s4_y|y
+ vddr1 pfet
+ L=0.15U W=0.84U AS=0.3948P AD=0.3948P PS=2.62U PD=2.62U
* device instance $220 r0 *1 297.345,296.015 pfet
M$220 py$13 a|n3|s2_y|s3_a|y$2 a|n4|s3_y|s4_a|y$2
+ vddr1 pfet
+ L=0.15U W=0.84U AS=0.3948P AD=0.3948P PS=2.62U PD=2.62U
* device instance $221 r0 *1 305.52,296.015 pfet
M$221 py$14 a|n2|s1_y|s2_a|y$3 a|n3|s2_y|s3_a|y$2
+ vddr1 pfet
+ L=0.15U W=0.84U AS=0.3948P AD=0.3948P PS=2.62U PD=2.62U
* device instance $222 r0 *1 313.695,296.015 pfet
M$222 py$15 a|g_y|mnab_y|mpa_y|mpb_y|n1|s1_a|y$3 a|n2|s1_y|s2_a|y$3
+ vddr1 pfet
+ L=0.15U W=0.84U AS=0.3948P AD=0.3948P PS=2.62U PD=2.62U
* device instance $223 r0 *1 315.365,272.38 pfet
M$223 a|inv_mc_a|mb|mnab_y|mpa_y|mpb_y|nand_m_y|tg_s_a|y
+ a|b|m_east|m_west|nand_m_a|nand_m_a_ext_via|nand_m_a_ext_via2|nand_m_a_stub|tg_d_b|tg_d_b_via|tg_d_b_via2|tg_fbm_b|tg_fbm_b_alt_via|tg_fbm_b_alt_via2$5
+ vdd
+ vdd
+ pfet L=0.15U W=0.84U AS=0.3948P AD=0.3948P PS=2.62U PD=2.62U
* device instance $224 r0 *1 316.655,272.38 pfet
M$224
+ vdd
+ rst_n
+ a|inv_mc_a|mb|mnab_y|mpa_y|mpb_y|nand_m_y|tg_s_a|y
+ vdd
+ pfet L=0.15U W=0.84U AS=0.3948P AD=0.3948P PS=2.62U PD=2.62U
* device instance $225 r0 *1 321.705,296.015 pfet
M$225 a|g_y|mnab_y|mpa_y|mpb_y|n1|s1_a|y$3 a|g_a|rn1|ro|s4_y|y
+ mpa_py|mpb_py|mph_py|py$3
+ vddr1 pfet
+ L=0.15U W=0.84U AS=0.3948P AD=0.3948P PS=2.62U PD=2.62U
* device instance $226 r0 *1 322.995,296.015 pfet
M$226 mpa_py|mpb_py|mph_py|py$3 en1
+ a|g_y|mnab_y|mpa_y|mpb_y|n1|s1_a|y$3
+ vddr1 pfet
+ L=0.15U W=0.84U AS=0.3948P AD=0.3948P PS=2.62U PD=2.62U
* device instance $227 r0 *1 125.435,296.015 pfet
M$227 vddr4
+ vss
+ py vddr4
+ pfet L=2U W=0.48U AS=0.2016P AD=0.2016P PS=1.8U PD=1.8U
* device instance $228 r0 *1 133.61,296.015 pfet
M$228 vddr4
+ vss
+ py$1 vddr4
+ pfet L=2U W=0.48U AS=0.2016P AD=0.2016P PS=1.8U PD=1.8U
* device instance $229 r0 *1 141.785,296.015 pfet
M$229 vddr4
+ vss
+ py$2 vddr4
+ pfet L=2U W=0.48U AS=0.2016P AD=0.2016P PS=1.8U PD=1.8U
* device instance $230 r0 *1 149.96,296.015 pfet
M$230 vddr4
+ vss
+ py$3 vddr4
+ pfet L=2U W=0.48U AS=0.2016P AD=0.2016P PS=1.8U PD=1.8U
* device instance $231 r0 *1 159.26,296.015 pfet
M$231 vddr4
+ vss
+ mpa_py|mpb_py|mph_py|py
+ vddr4 pfet
+ L=2U W=0.48U AS=0.2016P AD=0.2016P PS=1.8U PD=1.8U
* device instance $232 r0 *1 180.735,296.015 pfet
M$232 vddr3
+ vss
+ py$4 vddr3
+ pfet L=2U W=0.46U AS=0.1932P AD=0.1932P PS=1.76U PD=1.76U
* device instance $233 r0 *1 188.91,296.015 pfet
M$233 vddr3
+ vss
+ py$5 vddr3
+ pfet L=2U W=0.46U AS=0.1932P AD=0.1932P PS=1.76U PD=1.76U
* device instance $234 r0 *1 197.085,296.015 pfet
M$234 vddr3
+ vss
+ py$6 vddr3
+ pfet L=2U W=0.46U AS=0.1932P AD=0.1932P PS=1.76U PD=1.76U
* device instance $235 r0 *1 205.26,296.015 pfet
M$235 vddr3
+ vss
+ py$7 vddr3
+ pfet L=2U W=0.46U AS=0.1932P AD=0.1932P PS=1.76U PD=1.76U
* device instance $236 r0 *1 214.56,296.015 pfet
M$236 vddr3
+ vss
+ mpa_py|mpb_py|mph_py|py$1
+ vddr3 pfet
+ L=2U W=0.46U AS=0.1932P AD=0.1932P PS=1.76U PD=1.76U
* device instance $237 r0 *1 236.035,296.015 pfet
M$237 vddr2
+ vss
+ py$8 vddr2
+ pfet L=2U W=0.44U AS=0.1848P AD=0.1848P PS=1.72U PD=1.72U
* device instance $238 r0 *1 244.21,296.015 pfet
M$238 vddr2
+ vss
+ py$9 vddr2
+ pfet L=2U W=0.44U AS=0.1848P AD=0.1848P PS=1.72U PD=1.72U
* device instance $239 r0 *1 249.21,313.5 pfet
M$239
+ vdd
+ a|b|b3|invb_a|mn12_g1|mp24_g0|t2|y bn|invb_y|mn34_g1|mp24_g1|y
+ vdd
+ pfet L=0.15U W=0.84U AS=0.3948P AD=0.3948P PS=2.62U PD=2.62U
* device instance $240 r0 *1 252.385,296.015 pfet
M$240 vddr2
+ vss
+ py$10 vddr2
+ pfet L=2U W=0.44U AS=0.1848P AD=0.1848P PS=1.72U PD=1.72U
* device instance $241 r0 *1 255.58,317.86 pfet
M$241 mid a|b|b3|invb_a|mn12_g1|mp24_g0|t2|y
+ vdd
+ vdd
+ pfet L=0.15U W=1.68U AS=0.7896P AD=0.4368P PS=4.3U PD=2.2U
* device instance $242 r0 *1 256.25,317.86 pfet
M$242 a|d|sb_d_stub|tg_d_a|xo|xo_dip|xo_hop|xo_stub|y
+ bn|invb_y|mn34_g1|mp24_g1|y mid
+ vdd
+ pfet L=0.15U W=1.68U AS=0.4368P AD=0.7896P PS=2.2U PD=4.3U
* device instance $243 r0 *1 260.56,296.015 pfet
M$243 vddr2
+ vss
+ py$11 vddr2
+ pfet L=2U W=0.44U AS=0.1848P AD=0.1848P PS=1.72U PD=1.72U
* device instance $244 r0 *1 262.73,317.86 pfet
M$244 mid an|inva_y|mn34_g0|mp13_g1|y
+ a|d|sb_d_stub|tg_d_a|xo|xo_dip|xo_hop|xo_stub|y
+ vdd
+ pfet L=0.15U W=1.68U AS=0.7896P AD=0.4368P PS=4.3U PD=2.2U
* device instance $245 r0 *1 263.4,317.86 pfet
M$245
+ vdd
+ a|inva_a|mn12_g0|mp13_g0|t1|y mid
+ vdd
+ pfet L=0.15U W=1.68U AS=0.4368P AD=0.7896P PS=2.2U PD=4.3U
* device instance $246 r0 *1 267.385,313.5 pfet
M$246
+ vdd
+ a|inva_a|mn12_g0|mp13_g0|t1|y an|inva_y|mn34_g0|mp13_g1|y
+ vdd
+ pfet L=0.15U W=0.84U AS=0.3948P AD=0.3948P PS=2.62U PD=2.62U
* device instance $247 r0 *1 269.86,296.015 pfet
M$247 vddr2
+ vss
+ mpa_py|mpb_py|mph_py|py$2
+ vddr2 pfet
+ L=2U W=0.44U AS=0.1848P AD=0.1848P PS=1.72U PD=1.72U
* device instance $248 r0 *1 278.18,313.5 pfet
M$248
+ vdd
+ a|b|d|invb_a|mn12_g1|mp24_g0|ro4|ro4_esc|sr4_d_stub|tg_d_a|y
+ bn|invb_y|mn34_g1|mp24_g1|y$1
+ vdd
+ pfet L=0.15U W=0.84U AS=0.3948P AD=0.3948P PS=2.62U PD=2.62U
* device instance $249 r0 *1 284.55,317.86 pfet
M$249 mid$1 a|b|d|invb_a|mn12_g1|mp24_g0|ro4|ro4_esc|sr4_d_stub|tg_d_a|y
+ vdd
+ vdd
+ pfet L=0.15U W=1.68U AS=0.7896P AD=0.4368P PS=4.3U PD=2.2U
* device instance $250 r0 *1 285.22,317.86 pfet
M$250 a|b|b3|invb_a|mn12_g1|mp24_g0|t2|y bn|invb_y|mn34_g1|mp24_g1|y$1 mid$1
+ vdd
+ pfet L=0.15U W=1.68U AS=0.4368P AD=0.7896P PS=2.2U PD=4.3U
* device instance $251 r0 *1 291.335,296.015 pfet
M$251 vddr1
+ vss
+ py$12 vddr1
+ pfet L=2U W=0.42U AS=0.1764P AD=0.1764P PS=1.68U PD=1.68U
* device instance $252 r0 *1 291.7,317.86 pfet
M$252 mid$1 an|inva_y|mn34_g0|mp13_g1|y$1 a|b|b3|invb_a|mn12_g1|mp24_g0|t2|y
+ vdd
+ pfet L=0.15U W=1.68U AS=0.7896P AD=0.4368P PS=4.3U PD=2.2U
* device instance $253 r0 *1 292.37,317.86 pfet
M$253
+ vdd
+ a|d|inva_a|mn12_g0|mp13_g0|ro3|ro3_esc_e|ro3_esc_w|ro3_hop|sr3_d_stub|tg_d_a|y
+ mid$1
+ vdd
+ pfet L=0.15U W=1.68U AS=0.4368P AD=0.7896P PS=2.2U PD=4.3U
* device instance $254 r0 *1 296.355,313.5 pfet
M$254
+ vdd
+ a|d|inva_a|mn12_g0|mp13_g0|ro3|ro3_esc_e|ro3_esc_w|ro3_hop|sr3_d_stub|tg_d_a|y
+ an|inva_y|mn34_g0|mp13_g1|y$1
+ vdd
+ pfet L=0.15U W=0.84U AS=0.3948P AD=0.3948P PS=2.62U PD=2.62U
* device instance $255 r0 *1 299.51,296.015 pfet
M$255 vddr1
+ vss
+ py$13 vddr1
+ pfet L=2U W=0.42U AS=0.1764P AD=0.1764P PS=1.68U PD=1.68U
* device instance $256 r0 *1 307.685,296.015 pfet
M$256 vddr1
+ vss
+ py$14 vddr1
+ pfet L=2U W=0.42U AS=0.1764P AD=0.1764P PS=1.68U PD=1.68U
* device instance $257 r0 *1 307.15,313.5 pfet
M$257
+ vdd
+ a|b|d|invb_a|mn12_g1|mp24_g0|ro2|ro2_esc|sr2_d_stub|tg_d_a|y
+ bn|invb_y|mn34_g1|mp24_g1|y$2
+ vdd
+ pfet L=0.15U W=0.84U AS=0.3948P AD=0.3948P PS=2.62U PD=2.62U
* device instance $258 r0 *1 313.52,317.86 pfet
M$258 mid$2 a|b|d|invb_a|mn12_g1|mp24_g0|ro2|ro2_esc|sr2_d_stub|tg_d_a|y
+ vdd
+ vdd
+ pfet L=0.15U W=1.68U AS=0.7896P AD=0.4368P PS=4.3U PD=2.2U
* device instance $259 r0 *1 314.19,317.86 pfet
M$259 a|inva_a|mn12_g0|mp13_g0|t1|y bn|invb_y|mn34_g1|mp24_g1|y$2 mid$2
+ vdd
+ pfet L=0.15U W=1.68U AS=0.4368P AD=0.7896P PS=2.2U PD=4.3U
* device instance $260 r0 *1 315.86,296.015 pfet
M$260 vddr1
+ vss
+ py$15 vddr1
+ pfet L=2U W=0.42U AS=0.1764P AD=0.1764P PS=1.68U PD=1.68U
* device instance $261 r0 *1 320.67,317.86 pfet
M$261 mid$2 an|inva_y|mn34_g0|mp13_g1|y$2 a|inva_a|mn12_g0|mp13_g0|t1|y
+ vdd
+ pfet L=0.15U W=1.68U AS=0.7896P AD=0.4368P PS=4.3U PD=2.2U
* device instance $262 r0 *1 321.34,317.86 pfet
M$262
+ vdd
+ a|d|inva_a|mn12_g0|mp13_g0|ro1|ro1_esc|sr1_d_stub|tg_d_a|y mid$2
+ vdd
+ pfet L=0.15U W=1.68U AS=0.4368P AD=0.7896P PS=2.2U PD=4.3U
* device instance $263 r0 *1 325.16,296.015 pfet
M$263 vddr1
+ vss
+ mpa_py|mpb_py|mph_py|py$3
+ vddr1 pfet
+ L=2U W=0.42U AS=0.1764P AD=0.1764P PS=1.68U PD=1.68U
* device instance $264 r0 *1 325.325,313.5 pfet
M$264
+ vdd
+ a|d|inva_a|mn12_g0|mp13_g0|ro1|ro1_esc|sr1_d_stub|tg_d_a|y
+ an|inva_y|mn34_g0|mp13_g1|y$2
+ vdd
+ pfet L=0.15U W=0.84U AS=0.3948P AD=0.3948P PS=2.62U PD=2.62U
.ENDS trng_whole

* cell sky130_fd_sc_hd__xor2_1
* pin A
* pin B
* pin VGND
* pin VPB
* pin VPWR
* pin X
.SUBCKT sky130_fd_sc_hd__xor2_1 A B VGND VPB VPWR X
.ENDS sky130_fd_sc_hd__xor2_1

* cell sky130_fd_sc_hd__xnor2_1
* pin A
* pin B
* pin VGND
* pin VPB
* pin VPWR
* pin Y
.SUBCKT sky130_fd_sc_hd__xnor2_1 A B VGND VPB VPWR Y
.ENDS sky130_fd_sc_hd__xnor2_1

* cell sky130_fd_sc_hd__tapvpwrvgnd_1
* pin VGND
* pin VPWR
.SUBCKT sky130_fd_sc_hd__tapvpwrvgnd_1 VGND VPWR
.ENDS sky130_fd_sc_hd__tapvpwrvgnd_1

* cell sky130_fd_sc_hd__or4b_2
* pin A
* pin B
* pin C
* pin D_N
* pin VGND
* pin VPB
* pin VPWR
* pin X
.SUBCKT sky130_fd_sc_hd__or4b_2 A B C D_N VGND VPB VPWR X
.ENDS sky130_fd_sc_hd__or4b_2

* cell sky130_fd_sc_hd__or4_1
* pin A
* pin B
* pin C
* pin D
* pin VGND
* pin VPB
* pin VPWR
* pin X
.SUBCKT sky130_fd_sc_hd__or4_1 A B C D VGND VPB VPWR X
.ENDS sky130_fd_sc_hd__or4_1

* cell sky130_fd_sc_hd__or3b_2
* pin A
* pin B
* pin C_N
* pin VGND
* pin VPB
* pin VPWR
* pin X
.SUBCKT sky130_fd_sc_hd__or3b_2 A B C_N VGND VPB VPWR X
.ENDS sky130_fd_sc_hd__or3b_2

* cell sky130_fd_sc_hd__or3_1
* pin A
* pin B
* pin C
* pin VGND
* pin VPB
* pin VPWR
* pin X
.SUBCKT sky130_fd_sc_hd__or3_1 A B C VGND VPB VPWR X
.ENDS sky130_fd_sc_hd__or3_1

* cell sky130_fd_sc_hd__or2_2
* pin A
* pin B
* pin VGND
* pin VPB
* pin VPWR
* pin X
.SUBCKT sky130_fd_sc_hd__or2_2 A B VGND VPB VPWR X
.ENDS sky130_fd_sc_hd__or2_2

* cell sky130_fd_sc_hd__o41ai_1
* pin A1
* pin A2
* pin A3
* pin A4
* pin B1
* pin VGND
* pin VPB
* pin VPWR
* pin Y
.SUBCKT sky130_fd_sc_hd__o41ai_1 A1 A2 A3 A4 B1 VGND VPB VPWR Y
.ENDS sky130_fd_sc_hd__o41ai_1

* cell sky130_fd_sc_hd__o41a_1
* pin A1
* pin A2
* pin A3
* pin A4
* pin B1
* pin VGND
* pin VPB
* pin VPWR
* pin X
.SUBCKT sky130_fd_sc_hd__o41a_1 A1 A2 A3 A4 B1 VGND VPB VPWR X
.ENDS sky130_fd_sc_hd__o41a_1

* cell sky130_fd_sc_hd__o31ai_1
* pin A1
* pin A2
* pin A3
* pin B1
* pin VGND
* pin VPB
* pin VPWR
* pin Y
.SUBCKT sky130_fd_sc_hd__o31ai_1 A1 A2 A3 B1 VGND VPB VPWR Y
.ENDS sky130_fd_sc_hd__o31ai_1

* cell sky130_fd_sc_hd__o31a_1
* pin A1
* pin A2
* pin A3
* pin B1
* pin VGND
* pin VPB
* pin VPWR
* pin X
.SUBCKT sky130_fd_sc_hd__o31a_1 A1 A2 A3 B1 VGND VPB VPWR X
.ENDS sky130_fd_sc_hd__o31a_1

* cell sky130_fd_sc_hd__o22ai_1
* pin A1
* pin A2
* pin B1
* pin B2
* pin VGND
* pin VPB
* pin VPWR
* pin Y
.SUBCKT sky130_fd_sc_hd__o22ai_1 A1 A2 B1 B2 VGND VPB VPWR Y
.ENDS sky130_fd_sc_hd__o22ai_1

* cell sky130_fd_sc_hd__o221ai_1
* pin A1
* pin A2
* pin B1
* pin B2
* pin C1
* pin VGND
* pin VPB
* pin VPWR
* pin Y
.SUBCKT sky130_fd_sc_hd__o221ai_1 A1 A2 B1 B2 C1 VGND VPB VPWR Y
.ENDS sky130_fd_sc_hd__o221ai_1

* cell sky130_fd_sc_hd__o21bai_1
* pin A1
* pin A2
* pin B1_N
* pin VGND
* pin VPB
* pin VPWR
* pin Y
.SUBCKT sky130_fd_sc_hd__o21bai_1 A1 A2 B1_N VGND VPB VPWR Y
.ENDS sky130_fd_sc_hd__o21bai_1

* cell sky130_fd_sc_hd__o21ba_2
* pin A1
* pin A2
* pin B1_N
* pin VGND
* pin VPB
* pin VPWR
* pin X
.SUBCKT sky130_fd_sc_hd__o21ba_2 A1 A2 B1_N VGND VPB VPWR X
.ENDS sky130_fd_sc_hd__o21ba_2

* cell sky130_fd_sc_hd__o21ai_0
* pin A1
* pin A2
* pin B1
* pin VGND
* pin VPB
* pin VPWR
* pin Y
.SUBCKT sky130_fd_sc_hd__o21ai_0 A1 A2 B1 VGND VPB VPWR Y
.ENDS sky130_fd_sc_hd__o21ai_0

* cell sky130_fd_sc_hd__o21a_1
* pin A1
* pin A2
* pin B1
* pin VGND
* pin VPB
* pin VPWR
* pin X
.SUBCKT sky130_fd_sc_hd__o21a_1 A1 A2 B1 VGND VPB VPWR X
.ENDS sky130_fd_sc_hd__o21a_1

* cell sky130_fd_sc_hd__o211ai_1
* pin A1
* pin A2
* pin B1
* pin C1
* pin VGND
* pin VPB
* pin VPWR
* pin Y
.SUBCKT sky130_fd_sc_hd__o211ai_1 A1 A2 B1 C1 VGND VPB VPWR Y
.ENDS sky130_fd_sc_hd__o211ai_1

* cell sky130_fd_sc_hd__o211a_1
* pin A1
* pin A2
* pin B1
* pin C1
* pin VGND
* pin VPB
* pin VPWR
* pin X
.SUBCKT sky130_fd_sc_hd__o211a_1 A1 A2 B1 C1 VGND VPB VPWR X
.ENDS sky130_fd_sc_hd__o211a_1

* cell sky130_fd_sc_hd__nor4b_1
* pin A
* pin B
* pin C
* pin D_N
* pin VGND
* pin VPB
* pin VPWR
* pin Y
.SUBCKT sky130_fd_sc_hd__nor4b_1 A B C D_N VGND VPB VPWR Y
.ENDS sky130_fd_sc_hd__nor4b_1

* cell sky130_fd_sc_hd__nor4_1
* pin A
* pin B
* pin C
* pin D
* pin VGND
* pin VPB
* pin VPWR
* pin Y
.SUBCKT sky130_fd_sc_hd__nor4_1 A B C D VGND VPB VPWR Y
.ENDS sky130_fd_sc_hd__nor4_1

* cell sky130_fd_sc_hd__nor3b_1
* pin A
* pin B
* pin C_N
* pin VGND
* pin VPB
* pin VPWR
* pin Y
.SUBCKT sky130_fd_sc_hd__nor3b_1 A B C_N VGND VPB VPWR Y
.ENDS sky130_fd_sc_hd__nor3b_1

* cell sky130_fd_sc_hd__nor3_1
* pin A
* pin B
* pin C
* pin VGND
* pin VPB
* pin VPWR
* pin Y
.SUBCKT sky130_fd_sc_hd__nor3_1 A B C VGND VPB VPWR Y
.ENDS sky130_fd_sc_hd__nor3_1

* cell sky130_fd_sc_hd__nor2b_1
* pin A
* pin B_N
* pin VGND
* pin VPB
* pin VPWR
* pin Y
.SUBCKT sky130_fd_sc_hd__nor2b_1 A B_N VGND VPB VPWR Y
.ENDS sky130_fd_sc_hd__nor2b_1

* cell sky130_fd_sc_hd__nor2_1
* pin A
* pin B
* pin VGND
* pin VPB
* pin VPWR
* pin Y
.SUBCKT sky130_fd_sc_hd__nor2_1 A B VGND VPB VPWR Y
.ENDS sky130_fd_sc_hd__nor2_1

* cell sky130_fd_sc_hd__nand4b_1
* pin A_N
* pin B
* pin C
* pin D
* pin VGND
* pin VPB
* pin VPWR
* pin Y
.SUBCKT sky130_fd_sc_hd__nand4b_1 A_N B C D VGND VPB VPWR Y
.ENDS sky130_fd_sc_hd__nand4b_1

* cell sky130_fd_sc_hd__nand4_1
* pin A
* pin B
* pin C
* pin D
* pin VGND
* pin VPB
* pin VPWR
* pin Y
.SUBCKT sky130_fd_sc_hd__nand4_1 A B C D VGND VPB VPWR Y
.ENDS sky130_fd_sc_hd__nand4_1

* cell sky130_fd_sc_hd__nand3b_1
* pin A_N
* pin B
* pin C
* pin VGND
* pin VPB
* pin VPWR
* pin Y
.SUBCKT sky130_fd_sc_hd__nand3b_1 A_N B C VGND VPB VPWR Y
.ENDS sky130_fd_sc_hd__nand3b_1

* cell sky130_fd_sc_hd__nand3_1
* pin A
* pin B
* pin C
* pin VGND
* pin VPB
* pin VPWR
* pin Y
.SUBCKT sky130_fd_sc_hd__nand3_1 A B C VGND VPB VPWR Y
.ENDS sky130_fd_sc_hd__nand3_1

* cell sky130_fd_sc_hd__nand2b_1
* pin A_N
* pin B
* pin VGND
* pin VPB
* pin VPWR
* pin Y
.SUBCKT sky130_fd_sc_hd__nand2b_1 A_N B VGND VPB VPWR Y
.ENDS sky130_fd_sc_hd__nand2b_1

* cell sky130_fd_sc_hd__nand2_1
* pin A
* pin B
* pin VGND
* pin VPB
* pin VPWR
* pin Y
.SUBCKT sky130_fd_sc_hd__nand2_1 A B VGND VPB VPWR Y
.ENDS sky130_fd_sc_hd__nand2_1

* cell sky130_fd_sc_hd__mux2i_1
* pin A0
* pin A1
* pin S
* pin VGND
* pin VPB
* pin VPWR
* pin Y
.SUBCKT sky130_fd_sc_hd__mux2i_1 A0 A1 S VGND VPB VPWR Y
.ENDS sky130_fd_sc_hd__mux2i_1

* cell sky130_fd_sc_hd__mux2_2
* pin A0
* pin A1
* pin S
* pin VGND
* pin VPB
* pin VPWR
* pin X
.SUBCKT sky130_fd_sc_hd__mux2_2 A0 A1 S VGND VPB VPWR X
.ENDS sky130_fd_sc_hd__mux2_2

* cell sky130_fd_sc_hd__inv_4
* pin A
* pin VGND
* pin VPB
* pin VPWR
* pin Y
.SUBCKT sky130_fd_sc_hd__inv_4 A VGND VPB VPWR Y
.ENDS sky130_fd_sc_hd__inv_4

* cell sky130_fd_sc_hd__inv_1
* pin A
* pin VGND
* pin VPB
* pin VPWR
* pin Y
.SUBCKT sky130_fd_sc_hd__inv_1 A VGND VPB VPWR Y
.ENDS sky130_fd_sc_hd__inv_1

* cell sky130_fd_sc_hd__fill_8
* pin VGND
* pin VPB
* pin VPWR
.SUBCKT sky130_fd_sc_hd__fill_8 VGND VPB VPWR
.ENDS sky130_fd_sc_hd__fill_8

* cell sky130_fd_sc_hd__fill_4
* pin VGND
* pin VPB
* pin VPWR
.SUBCKT sky130_fd_sc_hd__fill_4 VGND VPB VPWR
.ENDS sky130_fd_sc_hd__fill_4

* cell sky130_fd_sc_hd__fill_2
* pin VGND
* pin VPB
* pin VPWR
.SUBCKT sky130_fd_sc_hd__fill_2 VGND VPB VPWR
.ENDS sky130_fd_sc_hd__fill_2

* cell sky130_fd_sc_hd__fill_1
* pin VGND
* pin VPB
* pin VPWR
.SUBCKT sky130_fd_sc_hd__fill_1 VGND VPB VPWR
.ENDS sky130_fd_sc_hd__fill_1

* cell sky130_fd_sc_hd__diode_2
* pin DIODE
* pin VGND
* pin VPB
* pin VPWR
.SUBCKT sky130_fd_sc_hd__diode_2 DIODE VGND VPB VPWR
.ENDS sky130_fd_sc_hd__diode_2

* cell sky130_fd_sc_hd__dfstp_1
* pin CLK
* pin D
* pin Q
* pin SET_B
* pin VGND
* pin VPB
* pin VPWR
.SUBCKT sky130_fd_sc_hd__dfstp_1 CLK D Q SET_B VGND VPB VPWR
.ENDS sky130_fd_sc_hd__dfstp_1

* cell sky130_fd_sc_hd__dfrtp_1
* pin CLK
* pin D
* pin Q
* pin RESET_B
* pin VGND
* pin VPB
* pin VPWR
.SUBCKT sky130_fd_sc_hd__dfrtp_1 CLK D Q RESET_B VGND VPB VPWR
.ENDS sky130_fd_sc_hd__dfrtp_1

* cell sky130_fd_sc_hd__clkinvlp_2
* pin A
* pin VGND
* pin VPB
* pin VPWR
* pin Y
.SUBCKT sky130_fd_sc_hd__clkinvlp_2 A VGND VPB VPWR Y
.ENDS sky130_fd_sc_hd__clkinvlp_2

* cell sky130_fd_sc_hd__clkinv_4
* pin A
* pin VGND
* pin VPB
* pin VPWR
* pin Y
.SUBCKT sky130_fd_sc_hd__clkinv_4 A VGND VPB VPWR Y
.ENDS sky130_fd_sc_hd__clkinv_4

* cell sky130_fd_sc_hd__clkinv_2
* pin A
* pin VGND
* pin VPB
* pin VPWR
* pin Y
.SUBCKT sky130_fd_sc_hd__clkinv_2 A VGND VPB VPWR Y
.ENDS sky130_fd_sc_hd__clkinv_2

* cell sky130_fd_sc_hd__clkinv_1
* pin A
* pin VGND
* pin VPB
* pin VPWR
* pin Y
.SUBCKT sky130_fd_sc_hd__clkinv_1 A VGND VPB VPWR Y
.ENDS sky130_fd_sc_hd__clkinv_1

* cell sky130_fd_sc_hd__clkbuf_1
* pin A
* pin VGND
* pin VPB
* pin VPWR
* pin X
.SUBCKT sky130_fd_sc_hd__clkbuf_1 A VGND VPB VPWR X
.ENDS sky130_fd_sc_hd__clkbuf_1

* cell sky130_fd_sc_hd__bufinv_16
* pin A
* pin VGND
* pin VPB
* pin VPWR
* pin Y
.SUBCKT sky130_fd_sc_hd__bufinv_16 A VGND VPB VPWR Y
.ENDS sky130_fd_sc_hd__bufinv_16

* cell sky130_fd_sc_hd__buf_4
* pin A
* pin VGND
* pin VPB
* pin VPWR
* pin X
.SUBCKT sky130_fd_sc_hd__buf_4 A VGND VPB VPWR X
.ENDS sky130_fd_sc_hd__buf_4

* cell sky130_fd_sc_hd__and4b_1
* pin A_N
* pin B
* pin C
* pin D
* pin VGND
* pin VPB
* pin VPWR
* pin X
.SUBCKT sky130_fd_sc_hd__and4b_1 A_N B C D VGND VPB VPWR X
.ENDS sky130_fd_sc_hd__and4b_1

* cell sky130_fd_sc_hd__and4_1
* pin A
* pin B
* pin C
* pin D
* pin VGND
* pin VPB
* pin VPWR
* pin X
.SUBCKT sky130_fd_sc_hd__and4_1 A B C D VGND VPB VPWR X
.ENDS sky130_fd_sc_hd__and4_1

* cell sky130_fd_sc_hd__and3b_1
* pin A_N
* pin B
* pin C
* pin VGND
* pin VPB
* pin VPWR
* pin X
.SUBCKT sky130_fd_sc_hd__and3b_1 A_N B C VGND VPB VPWR X
.ENDS sky130_fd_sc_hd__and3b_1

* cell sky130_fd_sc_hd__and3_1
* pin A
* pin B
* pin C
* pin VGND
* pin VPB
* pin VPWR
* pin X
.SUBCKT sky130_fd_sc_hd__and3_1 A B C VGND VPB VPWR X
.ENDS sky130_fd_sc_hd__and3_1

* cell sky130_fd_sc_hd__and2_1
* pin A
* pin B
* pin VGND
* pin VPB
* pin VPWR
* pin X
.SUBCKT sky130_fd_sc_hd__and2_1 A B VGND VPB VPWR X
.ENDS sky130_fd_sc_hd__and2_1

* cell sky130_fd_sc_hd__a32oi_1
* pin A1
* pin A2
* pin A3
* pin B1
* pin B2
* pin VGND
* pin VPB
* pin VPWR
* pin Y
.SUBCKT sky130_fd_sc_hd__a32oi_1 A1 A2 A3 B1 B2 VGND VPB VPWR Y
.ENDS sky130_fd_sc_hd__a32oi_1

* cell sky130_fd_sc_hd__a32o_1
* pin A1
* pin A2
* pin A3
* pin B1
* pin B2
* pin VGND
* pin VPB
* pin VPWR
* pin X
.SUBCKT sky130_fd_sc_hd__a32o_1 A1 A2 A3 B1 B2 VGND VPB VPWR X
.ENDS sky130_fd_sc_hd__a32o_1

* cell sky130_fd_sc_hd__a31oi_1
* pin A1
* pin A2
* pin A3
* pin B1
* pin VGND
* pin VPB
* pin VPWR
* pin Y
.SUBCKT sky130_fd_sc_hd__a31oi_1 A1 A2 A3 B1 VGND VPB VPWR Y
.ENDS sky130_fd_sc_hd__a31oi_1

* cell sky130_fd_sc_hd__a31o_2
* pin A1
* pin A2
* pin A3
* pin B1
* pin VGND
* pin VPB
* pin VPWR
* pin X
.SUBCKT sky130_fd_sc_hd__a31o_2 A1 A2 A3 B1 VGND VPB VPWR X
.ENDS sky130_fd_sc_hd__a31o_2

* cell sky130_fd_sc_hd__a311oi_1
* pin A1
* pin A2
* pin A3
* pin B1
* pin C1
* pin VGND
* pin VPB
* pin VPWR
* pin Y
.SUBCKT sky130_fd_sc_hd__a311oi_1 A1 A2 A3 B1 C1 VGND VPB VPWR Y
.ENDS sky130_fd_sc_hd__a311oi_1

* cell sky130_fd_sc_hd__a311o_1
* pin A1
* pin A2
* pin A3
* pin B1
* pin C1
* pin VGND
* pin VPB
* pin VPWR
* pin X
.SUBCKT sky130_fd_sc_hd__a311o_1 A1 A2 A3 B1 C1 VGND VPB VPWR X
.ENDS sky130_fd_sc_hd__a311o_1

* cell sky130_fd_sc_hd__a22oi_1
* pin A1
* pin A2
* pin B1
* pin B2
* pin VGND
* pin VPB
* pin VPWR
* pin Y
.SUBCKT sky130_fd_sc_hd__a22oi_1 A1 A2 B1 B2 VGND VPB VPWR Y
.ENDS sky130_fd_sc_hd__a22oi_1

* cell sky130_fd_sc_hd__a22o_1
* pin A1
* pin A2
* pin B1
* pin B2
* pin VGND
* pin VPB
* pin VPWR
* pin X
.SUBCKT sky130_fd_sc_hd__a22o_1 A1 A2 B1 B2 VGND VPB VPWR X
.ENDS sky130_fd_sc_hd__a22o_1

* cell sky130_fd_sc_hd__a222oi_1
* pin A1
* pin A2
* pin B1
* pin B2
* pin C1
* pin C2
* pin VGND
* pin VPB
* pin VPWR
* pin Y
.SUBCKT sky130_fd_sc_hd__a222oi_1 A1 A2 B1 B2 C1 C2 VGND VPB VPWR Y
.ENDS sky130_fd_sc_hd__a222oi_1

* cell sky130_fd_sc_hd__a221oi_1
* pin A1
* pin A2
* pin B1
* pin B2
* pin C1
* pin VGND
* pin VPB
* pin VPWR
* pin Y
.SUBCKT sky130_fd_sc_hd__a221oi_1 A1 A2 B1 B2 C1 VGND VPB VPWR Y
.ENDS sky130_fd_sc_hd__a221oi_1

* cell sky130_fd_sc_hd__a221o_1
* pin A1
* pin A2
* pin B1
* pin B2
* pin C1
* pin VGND
* pin VPB
* pin VPWR
* pin X
.SUBCKT sky130_fd_sc_hd__a221o_1 A1 A2 B1 B2 C1 VGND VPB VPWR X
.ENDS sky130_fd_sc_hd__a221o_1

* cell sky130_fd_sc_hd__a21oi_1
* pin A1
* pin A2
* pin B1
* pin VGND
* pin VPB
* pin VPWR
* pin Y
.SUBCKT sky130_fd_sc_hd__a21oi_1 A1 A2 B1 VGND VPB VPWR Y
.ENDS sky130_fd_sc_hd__a21oi_1

* cell sky130_fd_sc_hd__a21o_1
* pin A1
* pin A2
* pin B1
* pin VGND
* pin VPB
* pin VPWR
* pin X
.SUBCKT sky130_fd_sc_hd__a21o_1 A1 A2 B1 VGND VPB VPWR X
.ENDS sky130_fd_sc_hd__a21o_1

* cell sky130_fd_sc_hd__a211oi_1
* pin A1
* pin A2
* pin B1
* pin C1
* pin VGND
* pin VPB
* pin VPWR
* pin Y
.SUBCKT sky130_fd_sc_hd__a211oi_1 A1 A2 B1 C1 VGND VPB VPWR Y
.ENDS sky130_fd_sc_hd__a211oi_1
