* trng_whole -- combined whole-block LVS reference, GENERATED by
* layout/bin/compose-whole.py (issue #172). Do not edit by hand;
* `compose-whole.py --check` fails if this file and its inputs disagree.
*
* Contents: (1) design/trng_top.spice VERBATIM -- the generated analog
* wrapper trng_top (one sampler_core instance) and the transistor-level
* hierarchy under it, unmodified; (2) a BLACK-BOX .subckt trng_digital for
* the standard-cell digital macro; (3) the top .subckt trng_whole that
* instantiates both and names every shared net.
*
* STANDARD-CELL ABSTRACTION. trng_digital is a placed-and-routed
* sky130_fd_sc_hd macro (layout/trng_digital/); its committed layout
* abstract netlist has 0 devices (the standard cells are black boxes to
* klt extract), so the body below is EMPTY. Whole-block LVS (#173) must
* either supply a cell-level digital reference or compare the digital
* instance as a black box; this file does not decide that.
* Port names are the RTL/GDS pin names: bus_rdata[N] is the pin label of
* net bus_rdata_r[N] and startup_done of startup_done_r inside the macro.
*
* SUPPLY / WELL ALIASES. trng_digital's VPWR is whole-block `vdd`, VGND is
* `vss`; its standard-cell VPB/VNB wells are tied to VPWR/VGND inside the
* macro (tap cells), so they are not separate ports here. The four ring
* supplies vddr1..vddr4 reach only the analog macro and stay four nets.
*
* Boundary connectivity: raw_bit / raw_valid (analog outputs) -> digital
* inputs; clk and rst_n are common to both macros; ring enables en1..en4,
* the four ring-bit monitors ring_bit1..ring_bit4 and vddr1..vddr4 are
* analog-only external pins; every other digital port is external.

* trng_top -- GENERATED by design/netlist.py from design/xschem/trng_top.sch
* Do not edit by hand: `python3 design/netlist.py --check` fails if this
* file and the schematic disagree. Regenerate with `python3 design/netlist.py`.
** sch_path: trng_top.sch
.subckt trng_top en1 en2 en3 en4 vddr1 vddr2 vddr3 vddr4 vdd vss clk rst_n raw_bit raw_valid ring_bit1 ring_bit2
+ ring_bit3 ring_bit4
*.ipin en1
*.ipin en2
*.ipin en3
*.ipin en4
*.iopin vddr1
*.iopin vddr2
*.iopin vddr3
*.iopin vddr4
*.iopin vdd
*.iopin vss
*.ipin clk
*.ipin rst_n
*.opin raw_bit
*.opin raw_valid
*.opin ring_bit1
*.opin ring_bit2
*.opin ring_bit3
*.opin ring_bit4
xsc en1 en2 en3 en4 vddr1 vddr2 vddr3 vddr4 vdd vss clk rst_n raw_bit raw_valid ring_bit1 ring_bit2 ring_bit3 ring_bit4
+ sampler_core
.ends

* expanding   symbol:  sampler_core.sym # of pins=18
** sym_path: sampler_core.sym
** sch_path: sampler_core.sch
.subckt sampler_core en1 en2 en3 en4 vddr1 vddr2 vddr3 vddr4 vdd vss clk rst_n raw_bit raw_valid ring_bit1 ring_bit2
+ ring_bit3 ring_bit4
*.ipin en1
*.ipin en2
*.ipin en3
*.ipin en4
*.iopin vddr1
*.iopin vddr2
*.iopin vddr3
*.iopin vddr4
*.iopin vdd
*.iopin vss
*.ipin clk
*.ipin rst_n
*.opin raw_bit
*.opin raw_valid
*.opin ring_bit1
*.opin ring_bit2
*.opin ring_bit3
*.opin ring_bit4
xdut en1 en2 en3 en4 vddr1 vddr2 vddr3 vddr4 vdd vss xo ro1 ro2 ro3 ro4 ro_array_core
xsb xo clk rst_n raw_bit vdd vss sampler_dff
xsv vdd clk rst_n raw_valid vdd vss sampler_dff
xsr1 ro1 clk rst_n ring_bit1 vdd vss sampler_dff
xsr2 ro2 clk rst_n ring_bit2 vdd vss sampler_dff
xsr3 ro3 clk rst_n ring_bit3 vdd vss sampler_dff
xsr4 ro4 clk rst_n ring_bit4 vdd vss sampler_dff
.ends

* expanding   symbol:  ro_array_core.sym # of pins=15
** sym_path: ro_array_core.sym
** sch_path: ro_array_core.sch
.subckt ro_array_core en1 en2 en3 en4 vddr1 vddr2 vddr3 vddr4 vdd vss xo ro1 ro2 ro3 ro4
*.ipin en1
*.ipin en2
*.ipin en3
*.ipin en4
*.iopin vddr1
*.iopin vddr2
*.iopin vddr3
*.iopin vddr4
*.iopin vdd
*.iopin vss
*.opin xo
*.opin ro1
*.opin ro2
*.opin ro3
*.opin ro4
xr1 en1 rn1 vddr1 vss ro_ring5 wstv=0.42 lstv=2 cld=0.5f
xr2 en2 rn2 vddr2 vss ro_ring5 wstv=0.44 lstv=2 cld=0.5f
xr3 en3 rn3 vddr3 vss ro_ring5 wstv=0.46 lstv=2 cld=0.5f
xr4 en4 rn4 vddr4 vss ro_ring5 wstv=0.48 lstv=2 cld=0.5f
xb1 rn1 ro1 vdd vss ro_buf
xb2 rn2 ro2 vdd vss ro_buf
xb3 rn3 ro3 vdd vss ro_buf
xb4 rn4 ro4 vdd vss ro_buf
xa1 ro1 ro2 t1 vdd vss xor2
xa2 ro3 ro4 t2 vdd vss xor2
xa3 t1 t2 xo vdd vss xor2
.ends

* expanding   symbol:  sampler_dff.sym # of pins=6
** sym_path: sampler_dff.sym
** sch_path: sampler_dff.sch
.subckt sampler_dff d clk rst_n q vdd vss
*.ipin d
*.ipin clk
*.ipin rst_n
*.opin q
*.iopin vdd
*.iopin vss
XMpc clkb clk vdd vdd sky130_fd_pr__pfet_01v8 L=0.15 W=0.84 nf=1 ad=0.2436 as=0.2436 pd=2.26 ps=2.26
+ nrd=0.345238095238095 nrs=0.345238095238095 sa=0 sb=0 sd=0 mult=1 m=1
XMnc clkb clk vss vss sky130_fd_pr__nfet_01v8 L=0.15 W=0.42 nf=1 ad=0.1218 as=0.1218 pd=1.42 ps=1.42
+ nrd=0.69047619047619 nrs=0.69047619047619 sa=0 sb=0 sd=0 mult=1 m=1
XMtdp d clk m vdd sky130_fd_pr__pfet_01v8 L=0.15 W=0.84 nf=1 ad=0.2436 as=0.2436 pd=2.26 ps=2.26 nrd=0.345238095238095
+ nrs=0.345238095238095 sa=0 sb=0 sd=0 mult=1 m=1
XMtdn d clkb m vss sky130_fd_pr__nfet_01v8 L=0.15 W=0.42 nf=1 ad=0.1218 as=0.1218 pd=1.42 ps=1.42 nrd=0.69047619047619
+ nrs=0.69047619047619 sa=0 sb=0 sd=0 mult=1 m=1
XMimpa mb m vdd vdd sky130_fd_pr__pfet_01v8 L=0.15 W=0.84 nf=1 ad=0.2436 as=0.2436 pd=2.26 ps=2.26 nrd=0.345238095238095
+ nrs=0.345238095238095 sa=0 sb=0 sd=0 mult=1 m=1
XMimpb mb rst_n vdd vdd sky130_fd_pr__pfet_01v8 L=0.15 W=0.84 nf=1 ad=0.2436 as=0.2436 pd=2.26 ps=2.26
+ nrd=0.345238095238095 nrs=0.345238095238095 sa=0 sb=0 sd=0 mult=1 m=1
XMimna mb m mmid vss sky130_fd_pr__nfet_01v8 L=0.15 W=0.84 nf=1 ad=0.2436 as=0.2436 pd=2.26 ps=2.26
+ nrd=0.345238095238095 nrs=0.345238095238095 sa=0 sb=0 sd=0 mult=1 m=1
XMimnb mmid rst_n vss vss sky130_fd_pr__nfet_01v8 L=0.15 W=0.84 nf=1 ad=0.2436 as=0.2436 pd=2.26 ps=2.26
+ nrd=0.345238095238095 nrs=0.345238095238095 sa=0 sb=0 sd=0 mult=1 m=1
XMim2p mc mb vdd vdd sky130_fd_pr__pfet_01v8 L=0.15 W=0.84 nf=1 ad=0.2436 as=0.2436 pd=2.26 ps=2.26
+ nrd=0.345238095238095 nrs=0.345238095238095 sa=0 sb=0 sd=0 mult=1 m=1
XMim2n mc mb vss vss sky130_fd_pr__nfet_01v8 L=0.15 W=0.42 nf=1 ad=0.1218 as=0.1218 pd=1.42 ps=1.42 nrd=0.69047619047619
+ nrs=0.69047619047619 sa=0 sb=0 sd=0 mult=1 m=1
XMfmp mc clkb m vdd sky130_fd_pr__pfet_01v8 L=0.15 W=0.84 nf=1 ad=0.2436 as=0.2436 pd=2.26 ps=2.26 nrd=0.345238095238095
+ nrs=0.345238095238095 sa=0 sb=0 sd=0 mult=1 m=1
XMfmn mc clk m vss sky130_fd_pr__nfet_01v8 L=0.15 W=0.42 nf=1 ad=0.1218 as=0.1218 pd=1.42 ps=1.42 nrd=0.69047619047619
+ nrs=0.69047619047619 sa=0 sb=0 sd=0 mult=1 m=1
XMtsp mb clkb s vdd sky130_fd_pr__pfet_01v8 L=0.15 W=0.84 nf=1 ad=0.2436 as=0.2436 pd=2.26 ps=2.26 nrd=0.345238095238095
+ nrs=0.345238095238095 sa=0 sb=0 sd=0 mult=1 m=1
XMtsn mb clk s vss sky130_fd_pr__nfet_01v8 L=0.15 W=0.42 nf=1 ad=0.1218 as=0.1218 pd=1.42 ps=1.42 nrd=0.69047619047619
+ nrs=0.69047619047619 sa=0 sb=0 sd=0 mult=1 m=1
XMisp q s vdd vdd sky130_fd_pr__pfet_01v8 L=0.15 W=0.84 nf=1 ad=0.2436 as=0.2436 pd=2.26 ps=2.26 nrd=0.345238095238095
+ nrs=0.345238095238095 sa=0 sb=0 sd=0 mult=1 m=1
XMisn q s vss vss sky130_fd_pr__nfet_01v8 L=0.15 W=0.42 nf=1 ad=0.1218 as=0.1218 pd=1.42 ps=1.42 nrd=0.69047619047619
+ nrs=0.69047619047619 sa=0 sb=0 sd=0 mult=1 m=1
XMis2pa qb q vdd vdd sky130_fd_pr__pfet_01v8 L=0.15 W=0.84 nf=1 ad=0.2436 as=0.2436 pd=2.26 ps=2.26
+ nrd=0.345238095238095 nrs=0.345238095238095 sa=0 sb=0 sd=0 mult=1 m=1
XMis2pb qb rst_n vdd vdd sky130_fd_pr__pfet_01v8 L=0.15 W=0.84 nf=1 ad=0.2436 as=0.2436 pd=2.26 ps=2.26
+ nrd=0.345238095238095 nrs=0.345238095238095 sa=0 sb=0 sd=0 mult=1 m=1
XMis2na qb q s2mid vss sky130_fd_pr__nfet_01v8 L=0.15 W=0.84 nf=1 ad=0.2436 as=0.2436 pd=2.26 ps=2.26
+ nrd=0.345238095238095 nrs=0.345238095238095 sa=0 sb=0 sd=0 mult=1 m=1
XMis2nb s2mid rst_n vss vss sky130_fd_pr__nfet_01v8 L=0.15 W=0.84 nf=1 ad=0.2436 as=0.2436 pd=2.26 ps=2.26
+ nrd=0.345238095238095 nrs=0.345238095238095 sa=0 sb=0 sd=0 mult=1 m=1
XMfsp qb clk s vdd sky130_fd_pr__pfet_01v8 L=0.15 W=0.84 nf=1 ad=0.2436 as=0.2436 pd=2.26 ps=2.26 nrd=0.345238095238095
+ nrs=0.345238095238095 sa=0 sb=0 sd=0 mult=1 m=1
XMfsn qb clkb s vss sky130_fd_pr__nfet_01v8 L=0.15 W=0.42 nf=1 ad=0.1218 as=0.1218 pd=1.42 ps=1.42 nrd=0.69047619047619
+ nrs=0.69047619047619 sa=0 sb=0 sd=0 mult=1 m=1
.ends

* expanding   symbol:  ro_ring5.sym # of pins=4
** sym_path: ro_ring5.sym
** sch_path: ro_ring5.sch
.subckt ro_ring5 en ro vddr vss wstv=0.42 lstv=2 cld=0.5f
*.ipin en
*.opin ro
*.iopin vddr
*.iopin vss
xg ro en n1 vddr vss ro_nand2 wstv=wstv lstv=lstv cld=cld
x1 n1 n2 vddr vss ro_stage wstv=wstv lstv=lstv cld=cld
x2 n2 n3 vddr vss ro_stage wstv=wstv lstv=lstv cld=cld
x3 n3 n4 vddr vss ro_stage wstv=wstv lstv=lstv cld=cld
x4 n4 ro vddr vss ro_stage wstv=wstv lstv=lstv cld=cld
.ends

* expanding   symbol:  ro_buf.sym # of pins=4
** sym_path: ro_buf.sym
** sch_path: ro_buf.sch
.subckt ro_buf a y vdd vss
*.ipin a
*.opin y
*.iopin vdd
*.iopin vss
XMp y a vdd vdd sky130_fd_pr__pfet_01v8 L=0.15 W=0.84 nf=1 ad=0.2436 as=0.2436 pd=2.26 ps=2.26 nrd=0.345238095238095
+ nrs=0.345238095238095 sa=0 sb=0 sd=0 mult=1 m=1
XMn y a vss vss sky130_fd_pr__nfet_01v8 L=0.15 W=0.42 nf=1 ad=0.1218 as=0.1218 pd=1.42 ps=1.42 nrd=0.69047619047619
+ nrs=0.69047619047619 sa=0 sb=0 sd=0 mult=1 m=1
.ends

* expanding   symbol:  xor2.sym # of pins=5
** sym_path: xor2.sym
** sch_path: xor2.sch
.subckt xor2 a b y vdd vss
*.ipin a
*.ipin b
*.opin y
*.iopin vdd
*.iopin vss
XMpiA an a vdd vdd sky130_fd_pr__pfet_01v8 L=0.15 W=0.84 nf=1 ad=0.2436 as=0.2436 pd=2.26 ps=2.26 nrd=0.345238095238095
+ nrs=0.345238095238095 sa=0 sb=0 sd=0 mult=1 m=1
XMniA an a vss vss sky130_fd_pr__nfet_01v8 L=0.15 W=0.42 nf=1 ad=0.1218 as=0.1218 pd=1.42 ps=1.42 nrd=0.69047619047619
+ nrs=0.69047619047619 sa=0 sb=0 sd=0 mult=1 m=1
XMpiB bn b vdd vdd sky130_fd_pr__pfet_01v8 L=0.15 W=0.84 nf=1 ad=0.2436 as=0.2436 pd=2.26 ps=2.26 nrd=0.345238095238095
+ nrs=0.345238095238095 sa=0 sb=0 sd=0 mult=1 m=1
XMniB bn b vss vss sky130_fd_pr__nfet_01v8 L=0.15 W=0.42 nf=1 ad=0.1218 as=0.1218 pd=1.42 ps=1.42 nrd=0.69047619047619
+ nrs=0.69047619047619 sa=0 sb=0 sd=0 mult=1 m=1
XMp1 mid a vdd vdd sky130_fd_pr__pfet_01v8 L=0.15 W=1.68 nf=1 ad=0.4872 as=0.4872 pd=3.94 ps=3.94 nrd=0.172619047619048
+ nrs=0.172619047619048 sa=0 sb=0 sd=0 mult=1 m=1
XMp2 mid b vdd vdd sky130_fd_pr__pfet_01v8 L=0.15 W=1.68 nf=1 ad=0.4872 as=0.4872 pd=3.94 ps=3.94 nrd=0.172619047619048
+ nrs=0.172619047619048 sa=0 sb=0 sd=0 mult=1 m=1
XMp3 y an mid vdd sky130_fd_pr__pfet_01v8 L=0.15 W=1.68 nf=1 ad=0.4872 as=0.4872 pd=3.94 ps=3.94 nrd=0.172619047619048
+ nrs=0.172619047619048 sa=0 sb=0 sd=0 mult=1 m=1
XMp4 y bn mid vdd sky130_fd_pr__pfet_01v8 L=0.15 W=1.68 nf=1 ad=0.4872 as=0.4872 pd=3.94 ps=3.94 nrd=0.172619047619048
+ nrs=0.172619047619048 sa=0 sb=0 sd=0 mult=1 m=1
XMn1 y a s1 vss sky130_fd_pr__nfet_01v8 L=0.15 W=0.84 nf=1 ad=0.2436 as=0.2436 pd=2.26 ps=2.26 nrd=0.345238095238095
+ nrs=0.345238095238095 sa=0 sb=0 sd=0 mult=1 m=1
XMn2 s1 b vss vss sky130_fd_pr__nfet_01v8 L=0.15 W=0.84 nf=1 ad=0.2436 as=0.2436 pd=2.26 ps=2.26 nrd=0.345238095238095
+ nrs=0.345238095238095 sa=0 sb=0 sd=0 mult=1 m=1
XMn3 y an s2 vss sky130_fd_pr__nfet_01v8 L=0.15 W=0.84 nf=1 ad=0.2436 as=0.2436 pd=2.26 ps=2.26 nrd=0.345238095238095
+ nrs=0.345238095238095 sa=0 sb=0 sd=0 mult=1 m=1
XMn4 s2 bn vss vss sky130_fd_pr__nfet_01v8 L=0.15 W=0.84 nf=1 ad=0.2436 as=0.2436 pd=2.26 ps=2.26 nrd=0.345238095238095
+ nrs=0.345238095238095 sa=0 sb=0 sd=0 mult=1 m=1
.ends

* expanding   symbol:  ro_nand2.sym # of pins=5
** sym_path: ro_nand2.sym
** sch_path: ro_nand2.sch
.subckt ro_nand2 a en y vddr vss wstv=0.42 lstv=2 cld=0.5f
*.ipin a
*.ipin en
*.opin y
*.iopin vddr
*.iopin vss
XMph py vss vddr vddr sky130_fd_pr__pfet_01v8 L=lstv W=wstv nf=1 ad='int((1 + 1)/2) * wstv / 1 * 0.29'
+ as='int((1 + 2)/2) * wstv / 1 * 0.29' pd='2*int((1 + 1)/2) * (wstv / 1 + 0.29)'
+ ps='2*int((1 + 2)/2) * (wstv / 1 + 0.29)' nrd='0.29 / wstv ' nrs='0.29 / wstv ' sa=0 sb=0 sd=0 mult=1 m=1
XMpa y a py vddr sky130_fd_pr__pfet_01v8 L=0.15 W=0.84 nf=1 ad=0.2436 as=0.2436 pd=2.26 ps=2.26 nrd=0.345238095238095
+ nrs=0.345238095238095 sa=0 sb=0 sd=0 mult=1 m=1
XMpb y en py vddr sky130_fd_pr__pfet_01v8 L=0.15 W=0.84 nf=1 ad=0.2436 as=0.2436 pd=2.26 ps=2.26 nrd=0.345238095238095
+ nrs=0.345238095238095 sa=0 sb=0 sd=0 mult=1 m=1
XMna y a nm vss sky130_fd_pr__nfet_01v8 L=0.15 W=0.84 nf=1 ad=0.2436 as=0.2436 pd=2.26 ps=2.26 nrd=0.345238095238095
+ nrs=0.345238095238095 sa=0 sb=0 sd=0 mult=1 m=1
XMnb nm en ny vss sky130_fd_pr__nfet_01v8 L=0.15 W=0.84 nf=1 ad=0.2436 as=0.2436 pd=2.26 ps=2.26 nrd=0.345238095238095
+ nrs=0.345238095238095 sa=0 sb=0 sd=0 mult=1 m=1
XMnt ny vddr vss vss sky130_fd_pr__nfet_01v8 L=lstv W=wstv nf=1 ad='int((1 + 1)/2) * wstv / 1 * 0.29'
+ as='int((1 + 2)/2) * wstv / 1 * 0.29' pd='2*int((1 + 1)/2) * (wstv / 1 + 0.29)'
+ ps='2*int((1 + 2)/2) * (wstv / 1 + 0.29)' nrd='0.29 / wstv ' nrs='0.29 / wstv ' sa=0 sb=0 sd=0 mult=1 m=1
Cld y vss 'cld' m=1
.ends

* expanding   symbol:  ro_stage.sym # of pins=4
** sym_path: ro_stage.sym
** sch_path: ro_stage.sch
.subckt ro_stage a y vddr vss wstv=0.42 lstv=2 cld=0.5f
*.ipin a
*.opin y
*.iopin vddr
*.iopin vss
XMph py vss vddr vddr sky130_fd_pr__pfet_01v8 L=lstv W=wstv nf=1 ad='int((1 + 1)/2) * wstv / 1 * 0.29'
+ as='int((1 + 2)/2) * wstv / 1 * 0.29' pd='2*int((1 + 1)/2) * (wstv / 1 + 0.29)'
+ ps='2*int((1 + 2)/2) * (wstv / 1 + 0.29)' nrd='0.29 / wstv ' nrs='0.29 / wstv ' sa=0 sb=0 sd=0 mult=1 m=1
XMp y a py vddr sky130_fd_pr__pfet_01v8 L=0.15 W=0.84 nf=1 ad=0.2436 as=0.2436 pd=2.26 ps=2.26 nrd=0.345238095238095
+ nrs=0.345238095238095 sa=0 sb=0 sd=0 mult=1 m=1
XMn y a ny vss sky130_fd_pr__nfet_01v8 L=0.15 W=0.42 nf=1 ad=0.1218 as=0.1218 pd=1.42 ps=1.42 nrd=0.69047619047619
+ nrs=0.69047619047619 sa=0 sb=0 sd=0 mult=1 m=1
XMnt ny vddr vss vss sky130_fd_pr__nfet_01v8 L=lstv W=wstv nf=1 ad='int((1 + 1)/2) * wstv / 1 * 0.29'
+ as='int((1 + 2)/2) * wstv / 1 * 0.29' pd='2*int((1 + 1)/2) * (wstv / 1 + 0.29)'
+ ps='2*int((1 + 2)/2) * (wstv / 1 + 0.29)' nrd='0.29 / wstv ' nrs='0.29 / wstv ' sa=0 sb=0 sd=0 mult=1 m=1
Cld y vss 'cld' m=1
.ends

* digital macro (black box; see STANDARD-CELL ABSTRACTION above)
.subckt trng_digital VPWR VGND clk rst_n raw_bit raw_valid bus_addr[0] bus_addr[1] bus_addr[2] bus_addr[3] bus_we bus_re bus_wdata[0] bus_wdata[1] bus_wdata[2] bus_wdata[3] bus_wdata[4] bus_wdata[5] bus_wdata[6] bus_wdata[7] bus_wdata[8] bus_wdata[9] bus_wdata[10] bus_wdata[11] bus_wdata[12] bus_wdata[13] bus_wdata[14] bus_wdata[15] bus_wdata[16] bus_wdata[17] bus_wdata[18] bus_wdata[19] bus_wdata[20] bus_wdata[21] bus_wdata[22] bus_wdata[23] bus_wdata[24] bus_wdata[25] bus_wdata[26] bus_wdata[27] bus_wdata[28] bus_wdata[29] bus_wdata[30] bus_wdata[31] bus_rdata[0] bus_rdata[1] bus_rdata[2] bus_rdata[3] bus_rdata[4] bus_rdata[5] bus_rdata[6] bus_rdata[7] bus_rdata[8] bus_rdata[9] bus_rdata[10] bus_rdata[11] bus_rdata[12] bus_rdata[13] bus_rdata[14] bus_rdata[15] bus_rdata[16] bus_rdata[17] bus_rdata[18] bus_rdata[19] bus_rdata[20] bus_rdata[21] bus_rdata[22] bus_rdata[23] bus_rdata[24] bus_rdata[25] bus_rdata[26] bus_rdata[27] bus_rdata[28] bus_rdata[29] bus_rdata[30] bus_rdata[31] out_data[0] out_data[1] out_data[2] out_data[3] out_data[4] out_data[5] out_data[6] out_data[7] out_data[8] out_data[9] out_data[10] out_data[11] out_data[12] out_data[13] out_data[14] out_data[15] out_data[16] out_data[17] out_data[18] out_data[19] out_data[20] out_data[21] out_data[22] out_data[23] out_data[24] out_data[25] out_data[26] out_data[27] out_data[28] out_data[29] out_data[30] out_data[31] out_valid out_ready alarm gated startup_done
.ends trng_digital

.subckt trng_whole vdd vss clk rst_n en1 en2 en3 en4 vddr1 vddr2 vddr3 vddr4 ring_bit1 ring_bit2 ring_bit3 ring_bit4 bus_addr[0] bus_addr[1] bus_addr[2] bus_addr[3] bus_we bus_re bus_wdata[0] bus_wdata[1] bus_wdata[2] bus_wdata[3] bus_wdata[4] bus_wdata[5] bus_wdata[6] bus_wdata[7] bus_wdata[8] bus_wdata[9] bus_wdata[10] bus_wdata[11] bus_wdata[12] bus_wdata[13] bus_wdata[14] bus_wdata[15] bus_wdata[16] bus_wdata[17] bus_wdata[18] bus_wdata[19] bus_wdata[20] bus_wdata[21] bus_wdata[22] bus_wdata[23] bus_wdata[24] bus_wdata[25] bus_wdata[26] bus_wdata[27] bus_wdata[28] bus_wdata[29] bus_wdata[30] bus_wdata[31] bus_rdata[0] bus_rdata[1] bus_rdata[2] bus_rdata[3] bus_rdata[4] bus_rdata[5] bus_rdata[6] bus_rdata[7] bus_rdata[8] bus_rdata[9] bus_rdata[10] bus_rdata[11] bus_rdata[12] bus_rdata[13] bus_rdata[14] bus_rdata[15] bus_rdata[16] bus_rdata[17] bus_rdata[18] bus_rdata[19] bus_rdata[20] bus_rdata[21] bus_rdata[22] bus_rdata[23] bus_rdata[24] bus_rdata[25] bus_rdata[26] bus_rdata[27] bus_rdata[28] bus_rdata[29] bus_rdata[30] bus_rdata[31] out_data[0] out_data[1] out_data[2] out_data[3] out_data[4] out_data[5] out_data[6] out_data[7] out_data[8] out_data[9] out_data[10] out_data[11] out_data[12] out_data[13] out_data[14] out_data[15] out_data[16] out_data[17] out_data[18] out_data[19] out_data[20] out_data[21] out_data[22] out_data[23] out_data[24] out_data[25] out_data[26] out_data[27] out_data[28] out_data[29] out_data[30] out_data[31] out_valid out_ready alarm gated startup_done
xan en1 en2 en3 en4 vddr1 vddr2 vddr3 vddr4 vdd vss clk rst_n raw_bit raw_valid ring_bit1 ring_bit2 ring_bit3 ring_bit4 trng_top
xdg vdd vss clk rst_n raw_bit raw_valid bus_addr[0] bus_addr[1] bus_addr[2] bus_addr[3] bus_we bus_re bus_wdata[0] bus_wdata[1] bus_wdata[2] bus_wdata[3] bus_wdata[4] bus_wdata[5] bus_wdata[6] bus_wdata[7] bus_wdata[8] bus_wdata[9] bus_wdata[10] bus_wdata[11] bus_wdata[12] bus_wdata[13] bus_wdata[14] bus_wdata[15] bus_wdata[16] bus_wdata[17] bus_wdata[18] bus_wdata[19] bus_wdata[20] bus_wdata[21] bus_wdata[22] bus_wdata[23] bus_wdata[24] bus_wdata[25] bus_wdata[26] bus_wdata[27] bus_wdata[28] bus_wdata[29] bus_wdata[30] bus_wdata[31] bus_rdata[0] bus_rdata[1] bus_rdata[2] bus_rdata[3] bus_rdata[4] bus_rdata[5] bus_rdata[6] bus_rdata[7] bus_rdata[8] bus_rdata[9] bus_rdata[10] bus_rdata[11] bus_rdata[12] bus_rdata[13] bus_rdata[14] bus_rdata[15] bus_rdata[16] bus_rdata[17] bus_rdata[18] bus_rdata[19] bus_rdata[20] bus_rdata[21] bus_rdata[22] bus_rdata[23] bus_rdata[24] bus_rdata[25] bus_rdata[26] bus_rdata[27] bus_rdata[28] bus_rdata[29] bus_rdata[30] bus_rdata[31] out_data[0] out_data[1] out_data[2] out_data[3] out_data[4] out_data[5] out_data[6] out_data[7] out_data[8] out_data[9] out_data[10] out_data[11] out_data[12] out_data[13] out_data[14] out_data[15] out_data[16] out_data[17] out_data[18] out_data[19] out_data[20] out_data[21] out_data[22] out_data[23] out_data[24] out_data[25] out_data[26] out_data[27] out_data[28] out_data[29] out_data[30] out_data[31] out_valid out_ready alarm gated startup_done trng_digital
.ends trng_whole
