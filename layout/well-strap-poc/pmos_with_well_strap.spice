* extracted by klt extract --deck sky130

* cell gen_compose_0
* pin vdd
.SUBCKT gen_compose_0 vdd
* device instance $1 r0 *1 1.63,1.49 pfet
M$1 \$2 \$3 \$1 vdd pfet L=0.28U W=0.84U AS=0.3528P AD=0.3528P PS=2.52U PD=2.52U
.ENDS gen_compose_0
