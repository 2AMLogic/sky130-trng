* extracted by klt extract --deck sky130

* cell ro_nand2_wstv0p48
* pin a
* pin en
* pin mnab_y,mpa_y,mpb_y,y
* pin mnt_g,vddr
* pin mpa_py,mpb_py,mph_py,py
* pin mph_g,vss
* pin ny
.SUBCKT ro_nand2_wstv0p48 a en mnab_y|mpa_y|mpb_y|y mnt_g|vddr
+ mpa_py|mpb_py|mph_py|py mph_g|vss ny
* device instance $1 r0 *1 1.42,0.21 nfet
M$1 ny mnt_g|vddr mph_g|vss mph_g|vss nfet L=2U W=0.48U AS=0.2016P AD=0.2016P
+ PS=1.8U PD=1.8U
* device instance $2 r0 *1 3.785,0.21 nfet
M$2 \$3 en ny mph_g|vss nfet L=0.15U W=0.84U AS=0.3948P AD=0.2184P PS=2.62U
+ PD=1.36U
* device instance $3 r0 *1 4.455,0.21 nfet
M$3 mnab_y|mpa_y|mpb_y|y a \$3 mph_g|vss nfet L=0.15U W=0.84U AS=0.2184P
+ AD=0.3948P PS=1.36U PD=2.62U
* device instance $4 r0 *1 1.42,3.74 pfet
M$4 mpa_py|mpb_py|mph_py|py mph_g|vss mnt_g|vddr mnt_g|vddr pfet L=2U W=0.48U
+ AS=0.2016P AD=0.2016P PS=1.8U PD=1.8U
* device instance $5 r0 *1 3.585,3.74 pfet
M$5 mnab_y|mpa_y|mpb_y|y en mpa_py|mpb_py|mph_py|py mnt_g|vddr pfet L=0.15U
+ W=0.84U AS=0.3948P AD=0.3948P PS=2.62U PD=2.62U
* device instance $6 r0 *1 4.875,3.74 pfet
M$6 mpa_py|mpb_py|mph_py|py a mnab_y|mpa_y|mpb_y|y mnt_g|vddr pfet L=0.15U
+ W=0.84U AS=0.3948P AD=0.3948P PS=2.62U PD=2.62U
.ENDS ro_nand2_wstv0p48
