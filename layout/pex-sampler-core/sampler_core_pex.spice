* Post-layout (parasitic) subcircuit library -- GENERATED by
* layout/bin/pex-netlist.py from layout/pex-sampler-core/pex.json. Do not edit by
* hand: `python3 layout/bin/pex-netlist.py layout/pex-sampler-core/pex.json --check`
* re-extracts every cell from its committed GDS and fails if this file
* and that extraction disagree.
*
* Each cell below is `klt extract --pdk <variant> --parasitics` output
* over a composed, DRC-clean and LVS-clean cell under layout/. --pdk is
* what makes its device cards subcircuit calls on the PDK's own devices
* with unitless geometry (this repo's decks run at .option scale=1u), so
* NO device card, geometry value, R value, C value or connection is
* rewritten here. Two things are: extractor-joined net names are renamed
* to their design-level names, and a design-port-order wrapper is added
* per cell. See layout/bin/pex-netlist.py's module docstring for why,
* and layout/pex/README.md for what the parasitic model does and does
* not contain.
*
* Substrate return node: `vsubs`, declared .global below --
* klayout-tools#1503 (the extractor scopes it per-instance, which
* isolates every ground capacitance behind a 1 TOhm tie once the cell
* is instantiated rather than simulated flat). A deck including this
* library MUST tie the node itself; every sim/ record minted from it
* states which tie it used.

.global vsubs

*-----------------------------------------------------------------------
* sampler_core_pex -- post-layout, from ../sampler_core/sampler_core.gds
* klt extract --parasitics: 264 devices, 152 nets
*-----------------------------------------------------------------------
.subckt sampler_core_pex__core t2 ro2 ro4 s sn1 sn2 sn3 sn4 sn5 m mn1 mn2 mn3 mn4 mn5 clk vdd ro1 ro3 xo rn1 rn2 rn3 rn4 sig_n1 sig_n1n1 sig_n1n2 sig_n1n3 mb mbn1 mbn2 mbn3 mbn4 mbn5 mc mcn1 mcn2 mcn3 mcn4 mcn5 raw_bit raw_valid ring_bit1 ring_bit2 ring_bit3 ring_bit4 t1 qb qbn1 qbn2 qbn3 qbn4 qbn5 sig_n2 sig_n2n1 sig_n2n2 sig_n2n3 sig_n3 sig_n3n1 sig_n3n2 sig_n3n3 sig_n4 sig_n4n1 sig_n4n2 sig_n4n3 xor_an xor_ann1 xor_ann2 xor_bn xor_bnn1 xor_bnn2 clkb clkbn1 clkbn2 clkbn3 clkbn4 clkbn5 en1 en2 en3 en4 rst_n vddr1 vddr2 vddr3 vddr4 vss mid midn1 midn2 py_g py_gn1 py_gn2 py_gn3 ny nyn1 nyn2 nyn3 nyn4 nyn5 nyn6 nyn7 nyn8 nyn9 nyn10 nyn11 nyn12 nyn13 nyn14 nyn15 nyn16 nyn17 nyn18 nyn19 py pyn1 pyn2 pyn3 pyn4 pyn5 pyn6 pyn7 pyn8 pyn9 pyn10 pyn11 pyn12 pyn13 pyn14 pyn15
* device instance $1 r0 *1 12.565,0.21 nfet
Xn1 n12__t1 rst_n__t0 vss__t0 vss__t86 sky130_fd_pr__nfet_01v8 L=0.15 W=0.84 AS=0.3948 AD=0.2184 PS=2.62 PD=1.36
* device instance $2 r0 *1 13.235,0.21 nfet
Xn2 mb__t0 m__t02 n12__t0 vss__t108 sky130_fd_pr__nfet_01v8 L=0.15 W=0.84 AS=0.2184 AD=0.3948 PS=1.36 PD=2.62
* device instance $3 r0 *1 43.425,0.21 nfet
Xn3 n14__t0 rst_n__t22 vss__t84 vss__t87 sky130_fd_pr__nfet_01v8 L=0.15 W=0.84 AS=0.3948 AD=0.2184 PS=2.62 PD=1.36
* device instance $4 r0 *1 44.095,0.21 nfet
Xn4 qb__t4 raw_bit__t3 n14__t1 vss__t109 sky130_fd_pr__nfet_01v8 L=0.15 W=0.84 AS=0.2184 AD=0.3948 PS=1.36 PD=2.62
* device instance $5 r0 *1 68.225,0.21 nfet
Xn5 n16__t0 rst_n__t23 vss__t85 vss__t88 sky130_fd_pr__nfet_01v8 L=0.15 W=0.84 AS=0.3948 AD=0.2184 PS=2.62 PD=1.36
* device instance $6 r0 *1 68.895,0.21 nfet
Xn6 mb__t62 m__t53 n16__t1 vss__t110 sky130_fd_pr__nfet_01v8 L=0.15 W=0.84 AS=0.2184 AD=0.3948 PS=1.36 PD=2.62
* device instance $7 r0 *1 99.085,0.21 nfet
Xn7 n18__t0 rst_n__t21 vss__t83 vss__t89 sky130_fd_pr__nfet_01v8 L=0.15 W=0.84 AS=0.3948 AD=0.2184 PS=2.62 PD=1.36
* device instance $8 r0 *1 99.755,0.21 nfet
Xn8 qb__t42 raw_bit__t32 n18__t1 vss__t111 sky130_fd_pr__nfet_01v8 L=0.15 W=0.84 AS=0.2184 AD=0.3948 PS=1.36 PD=2.62
* device instance $9 r0 *1 123.885,0.21 nfet
Xn9 n21__t0 rst_n__t20 vss__t82 vss__t90 sky130_fd_pr__nfet_01v8 L=0.15 W=0.84 AS=0.3948 AD=0.2184 PS=2.62 PD=1.36
* device instance $10 r0 *1 124.555,0.21 nfet
Xn10 mb__t63 m__t54 n21__t1 vss__t112 sky130_fd_pr__nfet_01v8 L=0.15 W=0.84 AS=0.2184 AD=0.3948 PS=1.36 PD=2.62
* device instance $11 r0 *1 154.745,0.21 nfet
Xn11 n23__t0 rst_n__t19 vss__t81 vss__t91 sky130_fd_pr__nfet_01v8 L=0.15 W=0.84 AS=0.3948 AD=0.2184 PS=2.62 PD=1.36
* device instance $12 r0 *1 155.415,0.21 nfet
Xn12 qb__t43 raw_bit__t33 n23__t1 vss__t113 sky130_fd_pr__nfet_01v8 L=0.15 W=0.84 AS=0.2184 AD=0.3948 PS=1.36 PD=2.62
* device instance $13 r0 *1 179.545,0.21 nfet
Xn13 n26__t0 rst_n__t18 vss__t80 vss__t92 sky130_fd_pr__nfet_01v8 L=0.15 W=0.84 AS=0.3948 AD=0.2184 PS=2.62 PD=1.36
* device instance $14 r0 *1 180.215,0.21 nfet
Xn14 mb__t64 m__t55 n26__t1 vss__t114 sky130_fd_pr__nfet_01v8 L=0.15 W=0.84 AS=0.2184 AD=0.3948 PS=1.36 PD=2.62
* device instance $15 r0 *1 210.405,0.21 nfet
Xn15 n28__t0 rst_n__t13 vss__t75 vss__t93 sky130_fd_pr__nfet_01v8 L=0.15 W=0.84 AS=0.3948 AD=0.2184 PS=2.62 PD=1.36
* device instance $16 r0 *1 211.075,0.21 nfet
Xn16 qb__t44 raw_bit__t34 n28__t1 vss__t115 sky130_fd_pr__nfet_01v8 L=0.15 W=0.84 AS=0.2184 AD=0.3948 PS=1.36 PD=2.62
* device instance $17 r0 *1 235.205,0.21 nfet
Xn17 n31__t0 rst_n__t14 vss__t76 vss__t94 sky130_fd_pr__nfet_01v8 L=0.15 W=0.84 AS=0.3948 AD=0.2184 PS=2.62 PD=1.36
* device instance $18 r0 *1 235.875,0.21 nfet
Xn18 mb__t65 m__t56 n31__t1 vss__t116 sky130_fd_pr__nfet_01v8 L=0.15 W=0.84 AS=0.2184 AD=0.3948 PS=1.36 PD=2.62
* device instance $19 r0 *1 266.065,0.21 nfet
Xn19 n33__t0 rst_n__t15 vss__t77 vss__t95 sky130_fd_pr__nfet_01v8 L=0.15 W=0.84 AS=0.3948 AD=0.2184 PS=2.62 PD=1.36
* device instance $20 r0 *1 266.735,0.21 nfet
Xn20 qb__t45 raw_bit__t35 n33__t1 vss__t117 sky130_fd_pr__nfet_01v8 L=0.15 W=0.84 AS=0.2184 AD=0.3948 PS=1.36 PD=2.62
* device instance $21 r0 *1 290.865,0.21 nfet
Xn21 n36__t0 rst_n__t16 vss__t78 vss__t96 sky130_fd_pr__nfet_01v8 L=0.15 W=0.84 AS=0.3948 AD=0.2184 PS=2.62 PD=1.36
* device instance $22 r0 *1 291.535,0.21 nfet
Xn22 mb__t66 m__t5 n36__t1 vss__t118 sky130_fd_pr__nfet_01v8 L=0.15 W=0.84 AS=0.2184 AD=0.3948 PS=1.36 PD=2.62
* device instance $23 r0 *1 321.725,0.21 nfet
Xn23 n38__t0 rst_n__t17 vss__t79 vss__t97 sky130_fd_pr__nfet_01v8 L=0.15 W=0.84 AS=0.3948 AD=0.2184 PS=2.62 PD=1.36
* device instance $24 r0 *1 322.395,0.21 nfet
Xn24 qb__t46 raw_bit__t36 n38__t1 vss__t119 sky130_fd_pr__nfet_01v8 L=0.15 W=0.84 AS=0.2184 AD=0.3948 PS=1.36 PD=2.62
* device instance $25 r0 *1 0.545,0.21 nfet
Xn25 clkb__t0 clk__t0 vss__t1 vss__t130 sky130_fd_pr__nfet_01v8 L=0.15 W=0.42 AS=0.1974 AD=0.1974 PS=1.78 PD=1.78
* device instance $26 r0 *1 5.31,0.21 nfet
Xn26 xo__t3 clkb__t4 m__t22 vss__t131 sky130_fd_pr__nfet_01v8 L=0.15 W=0.42 AS=0.1974 AD=0.1974 PS=1.78 PD=1.78
* device instance $27 r0 *1 19.835,0.21 nfet
Xn27 mc__t2 mb__t5 vss__t52 vss__t132 sky130_fd_pr__nfet_01v8 L=0.15 W=0.42 AS=0.1974 AD=0.1974 PS=1.78 PD=1.78
* device instance $28 r0 *1 24.6,0.21 nfet
Xn28 mc__t3 clk__t28 m__t32 vss__t133 sky130_fd_pr__nfet_01v8 L=0.15 W=0.42 AS=0.1974 AD=0.1974 PS=1.78 PD=1.78
* device instance $29 r0 *1 29.74,0.21 nfet
Xn29 mb__t3 clk__t29 s__t2 vss__t134 sky130_fd_pr__nfet_01v8 L=0.15 W=0.42 AS=0.1974 AD=0.1974 PS=1.78 PD=1.78
* device instance $30 r0 *1 36.545,0.21 nfet
Xn30 raw_bit__t1 s__t1 vss__t53 vss__t135 sky130_fd_pr__nfet_01v8 L=0.15 W=0.42 AS=0.1974 AD=0.1974 PS=1.78 PD=1.78
* device instance $31 r0 *1 49.03,0.21 nfet
Xn31 qb__t2 clkb__t5 s__t3 vss__t136 sky130_fd_pr__nfet_01v8 L=0.15 W=0.42 AS=0.1974 AD=0.1974 PS=1.78 PD=1.78
* device instance $32 r0 *1 56.205,0.21 nfet
Xn32 clkb__t12 clk__t30 vss__t54 vss__t137 sky130_fd_pr__nfet_01v8 L=0.15 W=0.42 AS=0.1974 AD=0.1974 PS=1.78 PD=1.78
* device instance $33 r0 *1 60.97,0.21 nfet
Xn33 vdd__t33 clkb__t42 m__t13 vss__t138 sky130_fd_pr__nfet_01v8 L=0.15 W=0.42 AS=0.1974 AD=0.1974 PS=1.78 PD=1.78
* device instance $34 r0 *1 75.495,0.21 nfet
Xn34 mc__t22 mb__t42 vss__t58 vss__t139 sky130_fd_pr__nfet_01v8 L=0.15 W=0.42 AS=0.1974 AD=0.1974 PS=1.78 PD=1.78
* device instance $35 r0 *1 80.26,0.21 nfet
Xn35 mc__t32 clk__t31 m__t23 vss__t140 sky130_fd_pr__nfet_01v8 L=0.15 W=0.42 AS=0.1974 AD=0.1974 PS=1.78 PD=1.78
* device instance $36 r0 *1 85.4,0.21 nfet
Xn36 mb__t22 clk__t35 s__t32 vss__t141 sky130_fd_pr__nfet_01v8 L=0.15 W=0.42 AS=0.1974 AD=0.1974 PS=1.78 PD=1.78
* device instance $37 r0 *1 92.205,0.21 nfet
Xn37 raw_bit__t12 s__t12 vss__t59 vss__t142 sky130_fd_pr__nfet_01v8 L=0.15 W=0.42 AS=0.1974 AD=0.1974 PS=1.78 PD=1.78
* device instance $38 r0 *1 104.69,0.21 nfet
Xn38 qb__t22 clkb__t52 s__t22 vss__t143 sky130_fd_pr__nfet_01v8 L=0.15 W=0.42 AS=0.1974 AD=0.1974 PS=1.78 PD=1.78
* device instance $39 r0 *1 111.865,0.21 nfet
Xn39 clkb__t13 clk__t34 vss__t60 vss__t144 sky130_fd_pr__nfet_01v8 L=0.15 W=0.42 AS=0.1974 AD=0.1974 PS=1.78 PD=1.78
* device instance $40 r0 *1 116.63,0.21 nfet
Xn40 ro1__t4 clkb__t53 m__t24 vss__t145 sky130_fd_pr__nfet_01v8 L=0.15 W=0.42 AS=0.1974 AD=0.1974 PS=1.78 PD=1.78
* device instance $41 r0 *1 131.155,0.21 nfet
Xn41 mc__t23 mb__t43 vss__t55 vss__t146 sky130_fd_pr__nfet_01v8 L=0.15 W=0.42 AS=0.1974 AD=0.1974 PS=1.78 PD=1.78
* device instance $42 r0 *1 135.92,0.21 nfet
Xn42 mc__t33 clk__t33 m__t14 vss__t147 sky130_fd_pr__nfet_01v8 L=0.15 W=0.42 AS=0.1974 AD=0.1974 PS=1.78 PD=1.78
* device instance $43 r0 *1 141.06,0.21 nfet
Xn43 mb__t23 clk__t32 s__t33 vss__t148 sky130_fd_pr__nfet_01v8 L=0.15 W=0.42 AS=0.1974 AD=0.1974 PS=1.78 PD=1.78
* device instance $44 r0 *1 147.865,0.21 nfet
Xn44 raw_bit__t13 s__t13 vss__t57 vss__t149 sky130_fd_pr__nfet_01v8 L=0.15 W=0.42 AS=0.1974 AD=0.1974 PS=1.78 PD=1.78
* device instance $45 r0 *1 160.35,0.21 nfet
Xn45 qb__t23 clkb__t43 s__t23 vss__t150 sky130_fd_pr__nfet_01v8 L=0.15 W=0.42 AS=0.1974 AD=0.1974 PS=1.78 PD=1.78
* device instance $46 r0 *1 167.525,0.21 nfet
Xn46 clkb__t14 clk__t23 vss__t46 vss__t151 sky130_fd_pr__nfet_01v8 L=0.15 W=0.42 AS=0.1974 AD=0.1974 PS=1.78 PD=1.78
* device instance $47 r0 *1 172.29,0.21 nfet
Xn47 ro2__t3 clkb__t54 m__t25 vss__t152 sky130_fd_pr__nfet_01v8 L=0.15 W=0.42 AS=0.1974 AD=0.1974 PS=1.78 PD=1.78
* device instance $48 r0 *1 186.815,0.21 nfet
Xn48 mc__t34 mb__t44 vss__t45 vss__t153 sky130_fd_pr__nfet_01v8 L=0.15 W=0.42 AS=0.1974 AD=0.1974 PS=1.78 PD=1.78
* device instance $49 r0 *1 191.58,0.21 nfet
Xn49 mc__t24 clk__t22 m__t15 vss__t154 sky130_fd_pr__nfet_01v8 L=0.15 W=0.42 AS=0.1974 AD=0.1974 PS=1.78 PD=1.78
* device instance $50 r0 *1 196.72,0.21 nfet
Xn50 mb__t24 clk__t21 s__t34 vss__t155 sky130_fd_pr__nfet_01v8 L=0.15 W=0.42 AS=0.1974 AD=0.1974 PS=1.78 PD=1.78
* device instance $51 r0 *1 203.525,0.21 nfet
Xn51 raw_bit__t14 s__t14 vss__t44 vss__t156 sky130_fd_pr__nfet_01v8 L=0.15 W=0.42 AS=0.1974 AD=0.1974 PS=1.78 PD=1.78
* device instance $52 r0 *1 216.01,0.21 nfet
Xn52 qb__t24 clkb__t44 s__t24 vss__t157 sky130_fd_pr__nfet_01v8 L=0.15 W=0.42 AS=0.1974 AD=0.1974 PS=1.78 PD=1.78
* device instance $53 r0 *1 223.185,0.21 nfet
Xn53 clkb__t15 clk__t20 vss__t43 vss__t158 sky130_fd_pr__nfet_01v8 L=0.15 W=0.42 AS=0.1974 AD=0.1974 PS=1.78 PD=1.78
* device instance $54 r0 *1 227.95,0.21 nfet
Xn54 ro3__t3 clkb__t45 m__t16 vss__t159 sky130_fd_pr__nfet_01v8 L=0.15 W=0.42 AS=0.1974 AD=0.1974 PS=1.78 PD=1.78
* device instance $55 r0 *1 242.475,0.21 nfet
Xn55 mc__t25 mb__t45 vss__t42 vss__t160 sky130_fd_pr__nfet_01v8 L=0.15 W=0.42 AS=0.1974 AD=0.1974 PS=1.78 PD=1.78
* device instance $56 r0 *1 247.24,0.21 nfet
Xn56 mc__t35 clk__t19 m__t26 vss__t161 sky130_fd_pr__nfet_01v8 L=0.15 W=0.42 AS=0.1974 AD=0.1974 PS=1.78 PD=1.78
* device instance $57 r0 *1 252.38,0.21 nfet
Xn57 mb__t25 clk__t24 s__t25 vss__t162 sky130_fd_pr__nfet_01v8 L=0.15 W=0.42 AS=0.1974 AD=0.1974 PS=1.78 PD=1.78
* device instance $58 r0 *1 259.185,0.21 nfet
Xn58 raw_bit__t15 s__t15 vss__t49 vss__t163 sky130_fd_pr__nfet_01v8 L=0.15 W=0.42 AS=0.1974 AD=0.1974 PS=1.78 PD=1.78
* device instance $59 r0 *1 271.67,0.21 nfet
Xn59 qb__t25 clkb__t55 s__t35 vss__t164 sky130_fd_pr__nfet_01v8 L=0.15 W=0.42 AS=0.1974 AD=0.1974 PS=1.78 PD=1.78
* device instance $60 r0 *1 278.845,0.21 nfet
Xn60 clkb__t16 clk__t25 vss__t50 vss__t165 sky130_fd_pr__nfet_01v8 L=0.15 W=0.42 AS=0.1974 AD=0.1974 PS=1.78 PD=1.78
* device instance $61 r0 *1 283.61,0.21 nfet
Xn61 ro4__t4 clkb__t56 m__t1 vss__t166 sky130_fd_pr__nfet_01v8 L=0.15 W=0.42 AS=0.1974 AD=0.1974 PS=1.78 PD=1.78
* device instance $62 r0 *1 298.135,0.21 nfet
Xn62 mc__t26 mb__t46 vss__t51 vss__t167 sky130_fd_pr__nfet_01v8 L=0.15 W=0.42 AS=0.1974 AD=0.1974 PS=1.78 PD=1.78
* device instance $63 r0 *1 302.9,0.21 nfet
Xn63 mc__t36 clk__t26 m__t2 vss__t168 sky130_fd_pr__nfet_01v8 L=0.15 W=0.42 AS=0.1974 AD=0.1974 PS=1.78 PD=1.78
* device instance $64 r0 *1 308.04,0.21 nfet
Xn64 mb__t26 clk__t27 s__t36 vss__t169 sky130_fd_pr__nfet_01v8 L=0.15 W=0.42 AS=0.1974 AD=0.1974 PS=1.78 PD=1.78
* device instance $65 r0 *1 314.845,0.21 nfet
Xn65 raw_bit__t16 s__t16 vss__t48 vss__t170 sky130_fd_pr__nfet_01v8 L=0.15 W=0.42 AS=0.1974 AD=0.1974 PS=1.78 PD=1.78
* device instance $66 r0 *1 327.33,0.21 nfet
Xn66 qb__t26 clkb__t46 s__t26 vss__t171 sky130_fd_pr__nfet_01v8 L=0.15 W=0.42 AS=0.1974 AD=0.1974 PS=1.78 PD=1.78
* device instance $67 r0 *1 3.61,23.845 nfet
Xn67 ny__t0 vddr1__t0 vss__t2 vss__t198 sky130_fd_pr__nfet_01v8 L=2 W=0.42 AS=0.1764 AD=0.1764 PS=1.68 PD=1.68
* device instance $68 r0 *1 3.445,41.54 nfet
Xn68 xor_an__t2 ro1__t6 vss__t62 vss__t192 sky130_fd_pr__nfet_01v8 L=0.15 W=0.42 AS=0.1974 AD=0.1974 PS=1.78 PD=1.78
* device instance $69 r0 *1 6.225,23.845 nfet
Xn69 n72__t0 en1__t1 ny__t1 vss__t98 sky130_fd_pr__nfet_01v8 L=0.15 W=0.84 AS=0.3948 AD=0.2184 PS=2.62 PD=1.36
* device instance $70 r0 *1 6.895,23.845 nfet
Xn70 sig_n1__t42 rn1__t5 n72__t1 vss__t120 sky130_fd_pr__nfet_01v8 L=0.15 W=0.84 AS=0.2184 AD=0.3948 PS=1.36 PD=2.62
* device instance $71 r0 *1 7.78,39.22 nfet
Xn71 n138__t0 xor_an__t3 t1__t6 vss__t102 sky130_fd_pr__nfet_01v8 L=0.15 W=0.84 AS=0.3948 AD=0.2184 PS=2.62 PD=1.36
* device instance $72 r0 *1 8.45,39.22 nfet
Xn72 vss__t70 xor_bn__t3 n138__t1 vss__t124 sky130_fd_pr__nfet_01v8 L=0.15 W=0.84 AS=0.2184 AD=0.3948 PS=1.36 PD=2.62
* device instance $73 r0 *1 12.91,23.845 nfet
Xn73 ny__t02 vddr1__t13 vss__t40 vss__t199 sky130_fd_pr__nfet_01v8 L=2 W=0.42 AS=0.1764 AD=0.1764 PS=1.68 PD=1.68
* device instance $74 r0 *1 14.78,39.22 nfet
Xn74 n139__t0 ro1__t7 t1__t7 vss__t103 sky130_fd_pr__nfet_01v8 L=0.15 W=0.84 AS=0.3948 AD=0.2184 PS=2.62 PD=1.36
* device instance $75 r0 *1 15.45,39.22 nfet
Xn75 vss__t71 ro2__t7 n139__t1 vss__t125 sky130_fd_pr__nfet_01v8 L=0.15 W=0.84 AS=0.2184 AD=0.3948 PS=1.36 PD=2.62
* device instance $76 r0 *1 15.515,23.845 nfet
Xn76 sig_n2__t1 sig_n1__t22 ny__t12 vss__t172 sky130_fd_pr__nfet_01v8 L=0.15 W=0.42 AS=0.1974 AD=0.1974 PS=1.78 PD=1.78
* device instance $77 r0 *1 21.085,23.845 nfet
Xn77 ny__t03 vddr1__t12 vss__t39 vss__t200 sky130_fd_pr__nfet_01v8 L=2 W=0.42 AS=0.1764 AD=0.1764 PS=1.68 PD=1.68
* device instance $78 r0 *1 21.62,41.54 nfet
Xn78 xor_bn__t2 ro2__t6 vss__t63 vss__t193 sky130_fd_pr__nfet_01v8 L=0.15 W=0.42 AS=0.1974 AD=0.1974 PS=1.78 PD=1.78
* device instance $79 r0 *1 23.69,23.845 nfet
Xn79 sig_n3__t1 sig_n2__t3 ny__t13 vss__t173 sky130_fd_pr__nfet_01v8 L=0.15 W=0.42 AS=0.1974 AD=0.1974 PS=1.78 PD=1.78
* device instance $80 r0 *1 29.26,23.845 nfet
Xn80 ny__t04 vddr1__t14 vss__t41 vss__t201 sky130_fd_pr__nfet_01v8 L=2 W=0.42 AS=0.1764 AD=0.1764 PS=1.68 PD=1.68
* device instance $81 r0 *1 31.865,23.845 nfet
Xn81 sig_n4__t1 sig_n3__t3 ny__t14 vss__t174 sky130_fd_pr__nfet_01v8 L=0.15 W=0.42 AS=0.1974 AD=0.1974 PS=1.78 PD=1.78
* device instance $82 r0 *1 32.415,41.54 nfet
Xn82 xor_an__t22 ro3__t6 vss__t64 vss__t194 sky130_fd_pr__nfet_01v8 L=0.15 W=0.42 AS=0.1974 AD=0.1974 PS=1.78 PD=1.78
* device instance $83 r0 *1 37.435,23.845 nfet
Xn83 ny__t05 vddr1__t11 vss__t38 vss__t202 sky130_fd_pr__nfet_01v8 L=2 W=0.42 AS=0.1764 AD=0.1764 PS=1.68 PD=1.68
* device instance $84 r0 *1 36.75,39.22 nfet
Xn84 n140__t0 xor_an__t32 t2__t6 vss__t104 sky130_fd_pr__nfet_01v8 L=0.15 W=0.84 AS=0.3948 AD=0.2184 PS=2.62 PD=1.36
* device instance $85 r0 *1 37.42,39.22 nfet
Xn85 vss__t74 xor_bn__t32 n140__t1 vss__t126 sky130_fd_pr__nfet_01v8 L=0.15 W=0.84 AS=0.2184 AD=0.3948 PS=1.36 PD=2.62
* device instance $86 r0 *1 40.04,23.845 nfet
Xn86 rn1__t1 sig_n4__t3 ny__t15 vss__t175 sky130_fd_pr__nfet_01v8 L=0.15 W=0.42 AS=0.1974 AD=0.1974 PS=1.78 PD=1.78
* device instance $87 r0 *1 43.75,39.22 nfet
Xn87 n142__t0 ro3__t7 t2__t7 vss__t105 sky130_fd_pr__nfet_01v8 L=0.15 W=0.84 AS=0.3948 AD=0.2184 PS=2.62 PD=1.36
* device instance $88 r0 *1 44.42,39.22 nfet
Xn88 vss__t73 ro4__t7 n142__t1 vss__t127 sky130_fd_pr__nfet_01v8 L=0.15 W=0.84 AS=0.2184 AD=0.3948 PS=1.36 PD=2.62
* device instance $89 r0 *1 48.86,23.845 nfet
Xn89 ro1__t3 rn1__t4 vss__t56 vss__t176 sky130_fd_pr__nfet_01v8 L=0.15 W=0.42 AS=0.1974 AD=0.1974 PS=1.78 PD=1.78
* device instance $90 r0 *1 50.59,41.54 nfet
Xn90 xor_bn__t22 ro4__t6 vss__t68 vss__t195 sky130_fd_pr__nfet_01v8 L=0.15 W=0.42 AS=0.1974 AD=0.1974 PS=1.78 PD=1.78
* device instance $91 r0 *1 58.91,23.845 nfet
Xn91 ny__t06 vddr2__t0 vss__t3 vss__t203 sky130_fd_pr__nfet_01v8 L=2 W=0.44 AS=0.1848 AD=0.1848 PS=1.72 PD=1.72
* device instance $92 r0 *1 61.385,41.54 nfet
Xn92 xor_an__t23 t1__t4 vss__t65 vss__t196 sky130_fd_pr__nfet_01v8 L=0.15 W=0.42 AS=0.1974 AD=0.1974 PS=1.78 PD=1.78
* device instance $93 r0 *1 61.525,23.845 nfet
Xn93 n79__t0 en2__t1 ny__t16 vss__t99 sky130_fd_pr__nfet_01v8 L=0.15 W=0.84 AS=0.3948 AD=0.2184 PS=2.62 PD=1.36
* device instance $94 r0 *1 62.195,23.845 nfet
Xn94 sig_n1__t4 rn2__t5 n79__t1 vss__t121 sky130_fd_pr__nfet_01v8 L=0.15 W=0.84 AS=0.2184 AD=0.3948 PS=1.36 PD=2.62
* device instance $95 r0 *1 65.72,39.22 nfet
Xn95 n143__t0 xor_an__t33 xo__t4 vss__t106 sky130_fd_pr__nfet_01v8 L=0.15 W=0.84 AS=0.3948 AD=0.2184 PS=2.62 PD=1.36
* device instance $96 r0 *1 66.39,39.22 nfet
Xn96 vss__t72 xor_bn__t33 n143__t1 vss__t128 sky130_fd_pr__nfet_01v8 L=0.15 W=0.84 AS=0.2184 AD=0.3948 PS=1.36 PD=2.62
* device instance $97 r0 *1 68.21,23.845 nfet
Xn97 ny__t07 vddr2__t13 vss__t36 vss__t204 sky130_fd_pr__nfet_01v8 L=2 W=0.44 AS=0.1848 AD=0.1848 PS=1.72 PD=1.72
* device instance $98 r0 *1 70.815,23.845 nfet
Xn98 sig_n2__t12 sig_n1__t2 ny__t17 vss__t177 sky130_fd_pr__nfet_01v8 L=0.15 W=0.42 AS=0.1974 AD=0.1974 PS=1.78 PD=1.78
* device instance $99 r0 *1 72.72,39.22 nfet
Xn99 n146__t0 t1__t5 xo__t5 vss__t107 sky130_fd_pr__nfet_01v8 L=0.15 W=0.84 AS=0.3948 AD=0.2184 PS=2.62 PD=1.36
* device instance $100 r0 *1 73.39,39.22 nfet
Xn100 vss__t69 t2__t5 n146__t1 vss__t129 sky130_fd_pr__nfet_01v8 L=0.15 W=0.84 AS=0.2184 AD=0.3948 PS=1.36 PD=2.62
* device instance $101 r0 *1 76.385,23.845 nfet
Xn101 ny__t08 vddr2__t12 vss__t35 vss__t205 sky130_fd_pr__nfet_01v8 L=2 W=0.44 AS=0.1848 AD=0.1848 PS=1.72 PD=1.72
* device instance $102 r0 *1 78.99,23.845 nfet
Xn102 sig_n3__t14 sig_n2__t32 ny__t18 vss__t178 sky130_fd_pr__nfet_01v8 L=0.15 W=0.42 AS=0.1974 AD=0.1974 PS=1.78 PD=1.78
* device instance $103 r0 *1 79.56,41.54 nfet
Xn103 xor_bn__t23 t2__t4 vss__t61 vss__t197 sky130_fd_pr__nfet_01v8 L=0.15 W=0.42 AS=0.1974 AD=0.1974 PS=1.78 PD=1.78
* device instance $104 r0 *1 84.56,23.845 nfet
Xn104 ny__t09 vddr2__t14 vss__t37 vss__t206 sky130_fd_pr__nfet_01v8 L=2 W=0.44 AS=0.1848 AD=0.1848 PS=1.72 PD=1.72
* device instance $105 r0 *1 87.165,23.845 nfet
Xn105 sig_n4__t13 sig_n3__t34 ny__t19 vss__t179 sky130_fd_pr__nfet_01v8 L=0.15 W=0.42 AS=0.1974 AD=0.1974 PS=1.78 PD=1.78
* device instance $106 r0 *1 92.735,23.845 nfet
Xn106 ny__t010 vddr2__t11 vss__t34 vss__t207 sky130_fd_pr__nfet_01v8 L=2 W=0.44 AS=0.1848 AD=0.1848 PS=1.72 PD=1.72
* device instance $107 r0 *1 95.34,23.845 nfet
Xn107 rn2__t1 sig_n4__t33 ny__t110 vss__t180 sky130_fd_pr__nfet_01v8 L=0.15 W=0.42 AS=0.1974 AD=0.1974 PS=1.78 PD=1.78
* device instance $108 r0 *1 104.16,23.845 nfet
Xn108 ro2__t4 rn2__t4 vss__t67 vss__t181 sky130_fd_pr__nfet_01v8 L=0.15 W=0.42 AS=0.1974 AD=0.1974 PS=1.78 PD=1.78
* device instance $109 r0 *1 114.21,23.845 nfet
Xn109 ny__t011 vddr3__t0 vss__t4 vss__t208 sky130_fd_pr__nfet_01v8 L=2 W=0.46 AS=0.1932 AD=0.1932 PS=1.76 PD=1.76
* device instance $110 r0 *1 116.825,23.845 nfet
Xn110 n88__t0 en3__t1 ny__t111 vss__t100 sky130_fd_pr__nfet_01v8 L=0.15 W=0.84 AS=0.3948 AD=0.2184 PS=2.62 PD=1.36
* device instance $111 r0 *1 117.495,23.845 nfet
Xn111 sig_n1__t43 rn3__t5 n88__t1 vss__t122 sky130_fd_pr__nfet_01v8 L=0.15 W=0.84 AS=0.2184 AD=0.3948 PS=1.36 PD=2.62
* device instance $112 r0 *1 123.51,23.845 nfet
Xn112 ny__t012 vddr3__t11 vss__t30 vss__t209 sky130_fd_pr__nfet_01v8 L=2 W=0.46 AS=0.1932 AD=0.1932 PS=1.76 PD=1.76
* device instance $113 r0 *1 126.115,23.845 nfet
Xn113 sig_n2__t13 sig_n1__t23 ny__t112 vss__t182 sky130_fd_pr__nfet_01v8 L=0.15 W=0.42 AS=0.1974 AD=0.1974 PS=1.78 PD=1.78
* device instance $114 r0 *1 131.685,23.845 nfet
Xn114 ny__t013 vddr3__t12 vss__t31 vss__t210 sky130_fd_pr__nfet_01v8 L=2 W=0.46 AS=0.1932 AD=0.1932 PS=1.76 PD=1.76
* device instance $115 r0 *1 134.29,23.845 nfet
Xn115 sig_n3__t12 sig_n2__t33 ny__t113 vss__t183 sky130_fd_pr__nfet_01v8 L=0.15 W=0.42 AS=0.1974 AD=0.1974 PS=1.78 PD=1.78
* device instance $116 r0 *1 139.86,23.845 nfet
Xn116 ny__t014 vddr3__t13 vss__t32 vss__t211 sky130_fd_pr__nfet_01v8 L=2 W=0.46 AS=0.1932 AD=0.1932 PS=1.76 PD=1.76
* device instance $117 r0 *1 142.465,23.845 nfet
Xn117 sig_n4__t12 sig_n3__t32 ny__t114 vss__t184 sky130_fd_pr__nfet_01v8 L=0.15 W=0.42 AS=0.1974 AD=0.1974 PS=1.78 PD=1.78
* device instance $118 r0 *1 148.035,23.845 nfet
Xn118 ny__t015 vddr3__t14 vss__t33 vss__t212 sky130_fd_pr__nfet_01v8 L=2 W=0.46 AS=0.1932 AD=0.1932 PS=1.76 PD=1.76
* device instance $119 r0 *1 150.64,23.845 nfet
Xn119 rn3__t1 sig_n4__t32 ny__t115 vss__t185 sky130_fd_pr__nfet_01v8 L=0.15 W=0.42 AS=0.1974 AD=0.1974 PS=1.78 PD=1.78
* device instance $120 r0 *1 159.46,23.845 nfet
Xn120 ro3__t4 rn3__t4 vss__t66 vss__t186 sky130_fd_pr__nfet_01v8 L=0.15 W=0.42 AS=0.1974 AD=0.1974 PS=1.78 PD=1.78
* device instance $121 r0 *1 169.51,23.845 nfet
Xn121 ny__t016 vddr4__t0 vss__t5 vss__t213 sky130_fd_pr__nfet_01v8 L=2 W=0.48 AS=0.2016 AD=0.2016 PS=1.8 PD=1.8
* device instance $122 r0 *1 172.125,23.845 nfet
Xn122 n96__t0 en4__t1 ny__t116 vss__t101 sky130_fd_pr__nfet_01v8 L=0.15 W=0.84 AS=0.3948 AD=0.2184 PS=2.62 PD=1.36
* device instance $123 r0 *1 172.795,23.845 nfet
Xn123 sig_n1__t44 rn4__t5 n96__t1 vss__t123 sky130_fd_pr__nfet_01v8 L=0.15 W=0.84 AS=0.2184 AD=0.3948 PS=1.36 PD=2.62
* device instance $124 r0 *1 178.81,23.845 nfet
Xn124 ny__t017 vddr4__t14 vss__t29 vss__t214 sky130_fd_pr__nfet_01v8 L=2 W=0.48 AS=0.2016 AD=0.2016 PS=1.8 PD=1.8
* device instance $125 r0 *1 181.415,23.845 nfet
Xn125 sig_n2__t14 sig_n1__t24 ny__t117 vss__t187 sky130_fd_pr__nfet_01v8 L=0.15 W=0.42 AS=0.1974 AD=0.1974 PS=1.78 PD=1.78
* device instance $126 r0 *1 186.985,23.845 nfet
Xn126 ny__t018 vddr4__t13 vss__t28 vss__t215 sky130_fd_pr__nfet_01v8 L=2 W=0.48 AS=0.2016 AD=0.2016 PS=1.8 PD=1.8
* device instance $127 r0 *1 189.59,23.845 nfet
Xn127 sig_n3__t13 sig_n2__t34 ny__t118 vss__t188 sky130_fd_pr__nfet_01v8 L=0.15 W=0.42 AS=0.1974 AD=0.1974 PS=1.78 PD=1.78
* device instance $128 r0 *1 195.16,23.845 nfet
Xn128 ny__t019 vddr4__t12 vss__t27 vss__t216 sky130_fd_pr__nfet_01v8 L=2 W=0.48 AS=0.2016 AD=0.2016 PS=1.8 PD=1.8
* device instance $129 r0 *1 197.765,23.845 nfet
Xn129 sig_n4__t14 sig_n3__t33 ny__t119 vss__t189 sky130_fd_pr__nfet_01v8 L=0.15 W=0.42 AS=0.1974 AD=0.1974 PS=1.78 PD=1.78
* device instance $130 r0 *1 203.335,23.845 nfet
Xn130 ny__t020 vddr4__t11 vss__t26 vss__t217 sky130_fd_pr__nfet_01v8 L=2 W=0.48 AS=0.2016 AD=0.2016 PS=1.8 PD=1.8
* device instance $131 r0 *1 205.94,23.845 nfet
Xn131 rn4__t1 sig_n4__t34 ny__t120 vss__t190 sky130_fd_pr__nfet_01v8 L=0.15 W=0.42 AS=0.1974 AD=0.1974 PS=1.78 PD=1.78
* device instance $132 r0 *1 214.76,23.845 nfet
Xn132 ro4__t3 rn4__t4 vss__t47 vss__t191 sky130_fd_pr__nfet_01v8 L=0.15 W=0.42 AS=0.1974 AD=0.1974 PS=1.78 PD=1.78
* device instance $133 r0 *1 0.545,3.53 pfet
Xn133 clkb__t1 clk__t1 vdd__t0 vdd__t1 sky130_fd_pr__pfet_01v8 L=0.15 W=0.84 AS=0.3948 AD=0.3948 PS=2.62 PD=2.62
* device instance $134 r0 *1 5.31,3.53 pfet
Xn134 xo__t2 clk__t7 m__t42 vdd__t67 sky130_fd_pr__pfet_01v8 L=0.15 W=0.84 AS=0.3948 AD=0.3948 PS=2.62 PD=2.62
* device instance $135 r0 *1 19.835,3.53 pfet
Xn135 mc__t0 mb__t4 vdd__t129 vdd__t68 sky130_fd_pr__pfet_01v8 L=0.15 W=0.84 AS=0.3948 AD=0.3948 PS=2.62 PD=2.62
* device instance $136 r0 *1 24.6,3.53 pfet
Xn136 mc__t1 clkb__t2 m__t52 vdd__t69 sky130_fd_pr__pfet_01v8 L=0.15 W=0.84 AS=0.3948 AD=0.3948 PS=2.62 PD=2.62
* device instance $137 r0 *1 29.74,3.53 pfet
Xn137 mb__t1 clkb__t3 s__t4 vdd__t70 sky130_fd_pr__pfet_01v8 L=0.15 W=0.84 AS=0.3948 AD=0.3948 PS=2.62 PD=2.62
* device instance $138 r0 *1 36.545,3.53 pfet
Xn138 raw_bit__t0 s__t0 vdd__t130 vdd__t71 sky130_fd_pr__pfet_01v8 L=0.15 W=0.84 AS=0.3948 AD=0.3948 PS=2.62 PD=2.62
* device instance $139 r0 *1 49.03,3.53 pfet
Xn139 qb__t0 clk__t8 s__t5 vdd__t73 sky130_fd_pr__pfet_01v8 L=0.15 W=0.84 AS=0.3948 AD=0.3948 PS=2.62 PD=2.62
* device instance $140 r0 *1 56.205,3.53 pfet
Xn140 clkb__t02 clk__t10 vdd__t133 vdd__t76 sky130_fd_pr__pfet_01v8 L=0.15 W=0.84 AS=0.3948 AD=0.3948 PS=2.62 PD=2.62
* device instance $141 r0 *1 60.97,3.53 pfet
Xn141 vdd__t27 clk__t11 m__t33 vdd__t77 sky130_fd_pr__pfet_01v8 L=0.15 W=0.84 AS=0.3948 AD=0.3948 PS=2.62 PD=2.62
* device instance $142 r0 *1 75.495,3.53 pfet
Xn142 mc__t02 mb__t32 vdd__t134 vdd__t79 sky130_fd_pr__pfet_01v8 L=0.15 W=0.84 AS=0.3948 AD=0.3948 PS=2.62 PD=2.62
* device instance $143 r0 *1 80.26,3.53 pfet
Xn143 mc__t12 clkb__t22 m__t43 vdd__t80 sky130_fd_pr__pfet_01v8 L=0.15 W=0.84 AS=0.3948 AD=0.3948 PS=2.62 PD=2.62
* device instance $144 r0 *1 85.4,3.53 pfet
Xn144 mb__t02 clkb__t32 s__t52 vdd__t84 sky130_fd_pr__pfet_01v8 L=0.15 W=0.84 AS=0.3948 AD=0.3948 PS=2.62 PD=2.62
* device instance $145 r0 *1 92.205,3.53 pfet
Xn145 raw_bit__t02 s__t02 vdd__t136 vdd__t83 sky130_fd_pr__pfet_01v8 L=0.15 W=0.84 AS=0.3948 AD=0.3948 PS=2.62 PD=2.62
* device instance $146 r0 *1 104.69,3.53 pfet
Xn146 qb__t12 clk__t12 s__t42 vdd__t82 sky130_fd_pr__pfet_01v8 L=0.15 W=0.84 AS=0.3948 AD=0.3948 PS=2.62 PD=2.62
* device instance $147 r0 *1 111.865,3.53 pfet
Xn147 clkb__t03 clk__t9 vdd__t132 vdd__t75 sky130_fd_pr__pfet_01v8 L=0.15 W=0.84 AS=0.3948 AD=0.3948 PS=2.62 PD=2.62
* device instance $148 r0 *1 116.63,3.53 pfet
Xn148 ro1__t2 clk__t6 m__t34 vdd__t66 sky130_fd_pr__pfet_01v8 L=0.15 W=0.84 AS=0.3948 AD=0.3948 PS=2.62 PD=2.62
* device instance $149 r0 *1 131.155,3.53 pfet
Xn149 mc__t03 mb__t33 vdd__t128 vdd__t65 sky130_fd_pr__pfet_01v8 L=0.15 W=0.84 AS=0.3948 AD=0.3948 PS=2.62 PD=2.62
* device instance $150 r0 *1 135.92,3.53 pfet
Xn150 mc__t13 clkb__t33 m__t44 vdd__t103 sky130_fd_pr__pfet_01v8 L=0.15 W=0.84 AS=0.3948 AD=0.3948 PS=2.62 PD=2.62
* device instance $151 r0 *1 141.06,3.53 pfet
Xn151 mb__t13 clkb__t23 s__t53 vdd__t100 sky130_fd_pr__pfet_01v8 L=0.15 W=0.84 AS=0.3948 AD=0.3948 PS=2.62 PD=2.62
* device instance $152 r0 *1 147.865,3.53 pfet
Xn152 raw_bit__t03 s__t03 vdd__t141 vdd__t94 sky130_fd_pr__pfet_01v8 L=0.15 W=0.84 AS=0.3948 AD=0.3948 PS=2.62 PD=2.62
* device instance $153 r0 *1 160.35,3.53 pfet
Xn153 qb__t03 clk__t16 s__t43 vdd__t93 sky130_fd_pr__pfet_01v8 L=0.15 W=0.84 AS=0.3948 AD=0.3948 PS=2.62 PD=2.62
* device instance $154 r0 *1 167.525,3.53 pfet
Xn154 clkb__t04 clk__t17 vdd__t143 vdd__t96 sky130_fd_pr__pfet_01v8 L=0.15 W=0.84 AS=0.3948 AD=0.3948 PS=2.62 PD=2.62
* device instance $155 r0 *1 172.29,3.53 pfet
Xn155 ro2__t2 clk__t18 m__t45 vdd__t107 sky130_fd_pr__pfet_01v8 L=0.15 W=0.84 AS=0.3948 AD=0.3948 PS=2.62 PD=2.62
* device instance $156 r0 *1 186.815,3.53 pfet
Xn156 mc__t14 mb__t34 vdd__t146 vdd__t104 sky130_fd_pr__pfet_01v8 L=0.15 W=0.84 AS=0.3948 AD=0.3948 PS=2.62 PD=2.62
* device instance $157 r0 *1 191.58,3.53 pfet
Xn157 mc__t04 clkb__t24 m__t35 vdd__t101 sky130_fd_pr__pfet_01v8 L=0.15 W=0.84 AS=0.3948 AD=0.3948 PS=2.62 PD=2.62
* device instance $158 r0 *1 196.72,3.53 pfet
Xn158 mb__t14 clkb__t34 s__t54 vdd__t108 sky130_fd_pr__pfet_01v8 L=0.15 W=0.84 AS=0.3948 AD=0.3948 PS=2.62 PD=2.62
* device instance $159 r0 *1 203.525,3.53 pfet
Xn159 raw_bit__t04 s__t04 vdd__t142 vdd__t95 sky130_fd_pr__pfet_01v8 L=0.15 W=0.84 AS=0.3948 AD=0.3948 PS=2.62 PD=2.62
* device instance $160 r0 *1 216.01,3.53 pfet
Xn160 qb__t14 clk__t15 s__t44 vdd__t90 sky130_fd_pr__pfet_01v8 L=0.15 W=0.84 AS=0.3948 AD=0.3948 PS=2.62 PD=2.62
* device instance $161 r0 *1 223.185,3.53 pfet
Xn161 clkb__t05 clk__t14 vdd__t139 vdd__t89 sky130_fd_pr__pfet_01v8 L=0.15 W=0.84 AS=0.3948 AD=0.3948 PS=2.62 PD=2.62
* device instance $162 r0 *1 227.95,3.53 pfet
Xn162 ro3__t2 clk__t13 m__t46 vdd__t88 sky130_fd_pr__pfet_01v8 L=0.15 W=0.84 AS=0.3948 AD=0.3948 PS=2.62 PD=2.62
* device instance $163 r0 *1 242.475,3.53 pfet
Xn163 mc__t15 mb__t35 vdd__t138 vdd__t87 sky130_fd_pr__pfet_01v8 L=0.15 W=0.84 AS=0.3948 AD=0.3948 PS=2.62 PD=2.62
* device instance $164 r0 *1 247.24,3.53 pfet
Xn164 mc__t05 clkb__t35 m__t36 vdd__t86 sky130_fd_pr__pfet_01v8 L=0.15 W=0.84 AS=0.3948 AD=0.3948 PS=2.62 PD=2.62
* device instance $165 r0 *1 252.38,3.53 pfet
Xn165 mb__t05 clkb__t25 s__t45 vdd__t34 sky130_fd_pr__pfet_01v8 L=0.15 W=0.84 AS=0.3948 AD=0.3948 PS=2.62 PD=2.62
* device instance $166 r0 *1 259.185,3.53 pfet
Xn166 raw_bit__t05 s__t05 vdd__t131 vdd__t74 sky130_fd_pr__pfet_01v8 L=0.15 W=0.84 AS=0.3948 AD=0.3948 PS=2.62 PD=2.62
* device instance $167 r0 *1 271.67,3.53 pfet
Xn167 qb__t05 clk__t2 s__t55 vdd__t35 sky130_fd_pr__pfet_01v8 L=0.15 W=0.84 AS=0.3948 AD=0.3948 PS=2.62 PD=2.62
* device instance $168 r0 *1 278.845,3.53 pfet
Xn168 clkb__t06 clk__t3 vdd__t109 vdd__t36 sky130_fd_pr__pfet_01v8 L=0.15 W=0.84 AS=0.3948 AD=0.3948 PS=2.62 PD=2.62
* device instance $169 r0 *1 283.61,3.53 pfet
Xn169 ro4__t1 clk__t4 m__t3 vdd__t39 sky130_fd_pr__pfet_01v8 L=0.15 W=0.84 AS=0.3948 AD=0.3948 PS=2.62 PD=2.62
* device instance $170 r0 *1 298.135,3.53 pfet
Xn170 mc__t16 mb__t36 vdd__t119 vdd__t51 sky130_fd_pr__pfet_01v8 L=0.15 W=0.84 AS=0.3948 AD=0.3948 PS=2.62 PD=2.62
* device instance $171 r0 *1 302.9,3.53 pfet
Xn171 mc__t06 clkb__t26 m__t4 vdd__t43 sky130_fd_pr__pfet_01v8 L=0.15 W=0.84 AS=0.3948 AD=0.3948 PS=2.62 PD=2.62
* device instance $172 r0 *1 308.04,3.53 pfet
Xn172 mb__t06 clkb__t36 s__t46 vdd__t44 sky130_fd_pr__pfet_01v8 L=0.15 W=0.84 AS=0.3948 AD=0.3948 PS=2.62 PD=2.62
* device instance $173 r0 *1 314.845,3.53 pfet
Xn173 raw_bit__t06 s__t06 vdd__t115 vdd__t45 sky130_fd_pr__pfet_01v8 L=0.15 W=0.84 AS=0.3948 AD=0.3948 PS=2.62 PD=2.62
* device instance $174 r0 *1 327.33,3.53 pfet
Xn174 qb__t06 clk__t5 s__t56 vdd__t46 sky130_fd_pr__pfet_01v8 L=0.15 W=0.84 AS=0.3948 AD=0.3948 PS=2.62 PD=2.62
* device instance $175 r0 *1 12.115,4.19 pfet
Xn175 mb__t2 rst_n__t9 vdd__t140 vdd__t91 sky130_fd_pr__pfet_01v8 L=0.15 W=0.84 AS=0.3948 AD=0.3948 PS=2.62 PD=2.62
* device instance $176 r0 *1 13.405,4.19 pfet
Xn176 vdd__t29 m__t12 mb__t6 vdd__t92 sky130_fd_pr__pfet_01v8 L=0.15 W=0.84 AS=0.3948 AD=0.3948 PS=2.62 PD=2.62
* device instance $177 r0 *1 15.075,27.375 pfet
Xn177 sig_n2__t0 sig_n1__t12 py__t1 vddr1__t15 sky130_fd_pr__pfet_01v8 L=0.15 W=0.84 AS=0.3948 AD=0.3948 PS=2.62 PD=2.62
* device instance $178 r0 *1 23.25,27.375 pfet
Xn178 sig_n3__t0 sig_n2__t2 py__t12 vddr1__t16 sky130_fd_pr__pfet_01v8 L=0.15 W=0.84 AS=0.3948 AD=0.3948 PS=2.62 PD=2.62
* device instance $179 r0 *1 31.425,27.375 pfet
Xn179 sig_n4__t0 sig_n3__t2 py__t13 vddr1__t18 sky130_fd_pr__pfet_01v8 L=0.15 W=0.84 AS=0.3948 AD=0.3948 PS=2.62 PD=2.62
* device instance $180 r0 *1 39.6,27.375 pfet
Xn180 rn1__t0 sig_n4__t2 py__t14 vddr1__t19 sky130_fd_pr__pfet_01v8 L=0.15 W=0.84 AS=0.3948 AD=0.3948 PS=2.62 PD=2.62
* device instance $181 r0 *1 42.975,4.19 pfet
Xn181 qb__t1 rst_n__t11 vdd__t145 vdd__t99 sky130_fd_pr__pfet_01v8 L=0.15 W=0.84 AS=0.3948 AD=0.3948 PS=2.62 PD=2.62
* device instance $182 r0 *1 44.265,4.19 pfet
Xn182 vdd__t31 raw_bit__t2 qb__t3 vdd__t102 sky130_fd_pr__pfet_01v8 L=0.15 W=0.84 AS=0.3948 AD=0.3948 PS=2.62 PD=2.62
* device instance $183 r0 *1 48.86,27.165 pfet
Xn183 ro1__t1 rn1__t2 vdd__t124 vdd__t59 sky130_fd_pr__pfet_01v8 L=0.15 W=0.84 AS=0.3948 AD=0.3948 PS=2.62 PD=2.62
* device instance $184 r0 *1 67.775,4.19 pfet
Xn184 mb__t12 rst_n__t12 vdd__t147 vdd__t105 sky130_fd_pr__pfet_01v8 L=0.15 W=0.84 AS=0.3948 AD=0.3948 PS=2.62 PD=2.62
* device instance $185 r0 *1 69.065,4.19 pfet
Xn185 vdd__t32 m__t03 mb__t52 vdd__t106 sky130_fd_pr__pfet_01v8 L=0.15 W=0.84 AS=0.3948 AD=0.3948 PS=2.62 PD=2.62
* device instance $186 r0 *1 70.375,27.375 pfet
Xn186 sig_n2__t02 sig_n1__t1 py__t15 vddr2__t19 sky130_fd_pr__pfet_01v8 L=0.15 W=0.84 AS=0.3948 AD=0.3948 PS=2.62 PD=2.62
* device instance $187 r0 *1 78.55,27.375 pfet
Xn187 sig_n3__t04 sig_n2__t22 py__t16 vddr2__t20 sky130_fd_pr__pfet_01v8 L=0.15 W=0.84 AS=0.3948 AD=0.3948 PS=2.62 PD=2.62
* device instance $188 r0 *1 86.725,27.375 pfet
Xn188 sig_n4__t03 sig_n3__t24 py__t17 vddr2__t16 sky130_fd_pr__pfet_01v8 L=0.15 W=0.84 AS=0.3948 AD=0.3948 PS=2.62 PD=2.62
* device instance $189 r0 *1 94.9,27.375 pfet
Xn189 rn2__t0 sig_n4__t23 py__t18 vddr2__t15 sky130_fd_pr__pfet_01v8 L=0.15 W=0.84 AS=0.3948 AD=0.3948 PS=2.62 PD=2.62
* device instance $190 r0 *1 98.635,4.19 pfet
Xn190 qb__t02 rst_n__t7 vdd__t135 vdd__t81 sky130_fd_pr__pfet_01v8 L=0.15 W=0.84 AS=0.3948 AD=0.3948 PS=2.62 PD=2.62
* device instance $191 r0 *1 99.925,4.19 pfet
Xn191 vdd__t28 raw_bit__t22 qb__t32 vdd__t78 sky130_fd_pr__pfet_01v8 L=0.15 W=0.84 AS=0.3948 AD=0.3948 PS=2.62 PD=2.62
* device instance $192 r0 *1 104.16,27.165 pfet
Xn192 ro2__t1 rn2__t2 vdd__t112 vdd__t40 sky130_fd_pr__pfet_01v8 L=0.15 W=0.84 AS=0.3948 AD=0.3948 PS=2.62 PD=2.62
* device instance $193 r0 *1 123.435,4.19 pfet
Xn193 mb__t03 rst_n__t8 vdd__t137 vdd__t85 sky130_fd_pr__pfet_01v8 L=0.15 W=0.84 AS=0.3948 AD=0.3948 PS=2.62 PD=2.62
* device instance $194 r0 *1 124.725,4.19 pfet
Xn194 vdd__t26 m__t04 mb__t53 vdd__t72 sky130_fd_pr__pfet_01v8 L=0.15 W=0.84 AS=0.3948 AD=0.3948 PS=2.62 PD=2.62
* device instance $195 r0 *1 125.675,27.375 pfet
Xn195 sig_n2__t03 sig_n1__t13 py__t19 vddr3__t18 sky130_fd_pr__pfet_01v8 L=0.15 W=0.84 AS=0.3948 AD=0.3948 PS=2.62 PD=2.62
* device instance $196 r0 *1 133.85,27.375 pfet
Xn196 sig_n3__t02 sig_n2__t23 py__t110 vddr3__t17 sky130_fd_pr__pfet_01v8 L=0.15 W=0.84 AS=0.3948 AD=0.3948 PS=2.62 PD=2.62
* device instance $197 r0 *1 142.025,27.375 pfet
Xn197 sig_n4__t02 sig_n3__t22 py__t111 vddr3__t16 sky130_fd_pr__pfet_01v8 L=0.15 W=0.84 AS=0.3948 AD=0.3948 PS=2.62 PD=2.62
* device instance $198 r0 *1 150.2,27.375 pfet
Xn198 rn3__t0 sig_n4__t22 py__t112 vddr3__t15 sky130_fd_pr__pfet_01v8 L=0.15 W=0.84 AS=0.3948 AD=0.3948 PS=2.62 PD=2.62
* device instance $199 r0 *1 154.295,4.19 pfet
Xn199 qb__t13 rst_n__t10 vdd__t144 vdd__t98 sky130_fd_pr__pfet_01v8 L=0.15 W=0.84 AS=0.3948 AD=0.3948 PS=2.62 PD=2.62
* device instance $200 r0 *1 155.585,4.19 pfet
Xn200 vdd__t30 raw_bit__t23 qb__t33 vdd__t97 sky130_fd_pr__pfet_01v8 L=0.15 W=0.84 AS=0.3948 AD=0.3948 PS=2.62 PD=2.62
* device instance $201 r0 *1 159.46,27.165 pfet
Xn201 ro3__t1 rn3__t2 vdd__t117 vdd__t48 sky130_fd_pr__pfet_01v8 L=0.15 W=0.84 AS=0.3948 AD=0.3948 PS=2.62 PD=2.62
* device instance $202 r0 *1 179.095,4.19 pfet
Xn202 mb__t04 rst_n__t1 vdd__t116 vdd__t47 sky130_fd_pr__pfet_01v8 L=0.15 W=0.84 AS=0.3948 AD=0.3948 PS=2.62 PD=2.62
* device instance $203 r0 *1 180.385,4.19 pfet
Xn203 vdd__t20 m__t05 mb__t54 vdd__t49 sky130_fd_pr__pfet_01v8 L=0.15 W=0.84 AS=0.3948 AD=0.3948 PS=2.62 PD=2.62
* device instance $204 r0 *1 180.975,27.375 pfet
Xn204 sig_n2__t04 sig_n1__t14 py__t113 vddr4__t15 sky130_fd_pr__pfet_01v8 L=0.15 W=0.84 AS=0.3948 AD=0.3948 PS=2.62 PD=2.62
* device instance $205 r0 *1 189.15,27.375 pfet
Xn205 sig_n3__t03 sig_n2__t24 py__t114 vddr4__t16 sky130_fd_pr__pfet_01v8 L=0.15 W=0.84 AS=0.3948 AD=0.3948 PS=2.62 PD=2.62
* device instance $206 r0 *1 197.325,27.375 pfet
Xn206 sig_n4__t04 sig_n3__t23 py__t115 vddr4__t20 sky130_fd_pr__pfet_01v8 L=0.15 W=0.84 AS=0.3948 AD=0.3948 PS=2.62 PD=2.62
* device instance $207 r0 *1 205.5,27.375 pfet
Xn207 rn4__t0 sig_n4__t24 py__t116 vddr4__t19 sky130_fd_pr__pfet_01v8 L=0.15 W=0.84 AS=0.3948 AD=0.3948 PS=2.62 PD=2.62
* device instance $208 r0 *1 209.955,4.19 pfet
Xn208 qb__t04 rst_n__t5 vdd__t123 vdd__t58 sky130_fd_pr__pfet_01v8 L=0.15 W=0.84 AS=0.3948 AD=0.3948 PS=2.62 PD=2.62
* device instance $209 r0 *1 211.245,4.19 pfet
Xn209 vdd__t25 raw_bit__t24 qb__t34 vdd__t63 sky130_fd_pr__pfet_01v8 L=0.15 W=0.84 AS=0.3948 AD=0.3948 PS=2.62 PD=2.62
* device instance $210 r0 *1 214.76,27.165 pfet
Xn210 ro4__t2 rn4__t3 vdd__t126 vdd__t62 sky130_fd_pr__pfet_01v8 L=0.15 W=0.84 AS=0.3948 AD=0.3948 PS=2.62 PD=2.62
* device instance $211 r0 *1 234.755,4.19 pfet
Xn211 mb__t15 rst_n__t6 vdd__t125 vdd__t61 sky130_fd_pr__pfet_01v8 L=0.15 W=0.84 AS=0.3948 AD=0.3948 PS=2.62 PD=2.62
* device instance $212 r0 *1 236.045,4.19 pfet
Xn212 vdd__t24 m__t06 mb__t55 vdd__t60 sky130_fd_pr__pfet_01v8 L=0.15 W=0.84 AS=0.3948 AD=0.3948 PS=2.62 PD=2.62
* device instance $213 r0 *1 265.615,4.19 pfet
Xn213 qb__t15 rst_n__t4 vdd__t122 vdd__t57 sky130_fd_pr__pfet_01v8 L=0.15 W=0.84 AS=0.3948 AD=0.3948 PS=2.62 PD=2.62
* device instance $214 r0 *1 266.905,4.19 pfet
Xn214 vdd__t23 raw_bit__t25 qb__t35 vdd__t56 sky130_fd_pr__pfet_01v8 L=0.15 W=0.84 AS=0.3948 AD=0.3948 PS=2.62 PD=2.62
* device instance $215 r0 *1 290.415,4.19 pfet
Xn215 mb__t16 rst_n__t3 vdd__t121 vdd__t55 sky130_fd_pr__pfet_01v8 L=0.15 W=0.84 AS=0.3948 AD=0.3948 PS=2.62 PD=2.62
* device instance $216 r0 *1 291.705,4.19 pfet
Xn216 vdd__t22 m__t0 mb__t56 vdd__t54 sky130_fd_pr__pfet_01v8 L=0.15 W=0.84 AS=0.3948 AD=0.3948 PS=2.62 PD=2.62
* device instance $217 r0 *1 321.275,4.19 pfet
Xn217 qb__t16 rst_n__t2 vdd__t120 vdd__t53 sky130_fd_pr__pfet_01v8 L=0.15 W=0.84 AS=0.3948 AD=0.3948 PS=2.62 PD=2.62
* device instance $218 r0 *1 322.565,4.19 pfet
Xn218 vdd__t21 raw_bit__t26 qb__t36 vdd__t52 sky130_fd_pr__pfet_01v8 L=0.15 W=0.84 AS=0.3948 AD=0.3948 PS=2.62 PD=2.62
* device instance $219 r0 *1 5.775,27.825 pfet
Xn219 sig_n1__t02 en1__t0 py_g__t2 vddr1__t17 sky130_fd_pr__pfet_01v8 L=0.15 W=0.84 AS=0.3948 AD=0.3948 PS=2.62 PD=2.62
* device instance $220 r0 *1 7.065,27.825 pfet
Xn220 py_g__t1 rn1__t3 sig_n1__t32 vddr1__t20 sky130_fd_pr__pfet_01v8 L=0.15 W=0.84 AS=0.3948 AD=0.3948 PS=2.62 PD=2.62
* device instance $221 r0 *1 12.91,27.375 pfet
Xn221 py__t0 vss__t22 vddr1__t7 vddr1__t3 sky130_fd_pr__pfet_01v8 L=2 W=0.42 AS=0.1764 AD=0.1764 PS=1.68 PD=1.68
* device instance $222 r0 *1 21.085,27.375 pfet
Xn222 py__t02 vss__t24 vddr1__t9 vddr1__t5 sky130_fd_pr__pfet_01v8 L=2 W=0.42 AS=0.1764 AD=0.1764 PS=1.68 PD=1.68
* device instance $223 r0 *1 29.26,27.375 pfet
Xn223 py__t03 vss__t25 vddr1__t10 vddr1__t6 sky130_fd_pr__pfet_01v8 L=2 W=0.42 AS=0.1764 AD=0.1764 PS=1.68 PD=1.68
* device instance $224 r0 *1 37.435,27.375 pfet
Xn224 py__t04 vss__t23 vddr1__t8 vddr1__t4 sky130_fd_pr__pfet_01v8 L=2 W=0.42 AS=0.1764 AD=0.1764 PS=1.68 PD=1.68
* device instance $225 r0 *1 61.075,27.825 pfet
Xn225 sig_n1__t0 en2__t0 py_g__t22 vddr2__t17 sky130_fd_pr__pfet_01v8 L=0.15 W=0.84 AS=0.3948 AD=0.3948 PS=2.62 PD=2.62
* device instance $226 r0 *1 62.365,27.825 pfet
Xn226 py_g__t12 rn2__t3 sig_n1__t3 vddr2__t18 sky130_fd_pr__pfet_01v8 L=0.15 W=0.84 AS=0.3948 AD=0.3948 PS=2.62 PD=2.62
* device instance $227 r0 *1 68.21,27.375 pfet
Xn227 py__t05 vss__t18 vddr2__t7 vddr2__t3 sky130_fd_pr__pfet_01v8 L=2 W=0.44 AS=0.1848 AD=0.1848 PS=1.72 PD=1.72
* device instance $228 r0 *1 76.385,27.375 pfet
Xn228 py__t06 vss__t19 vddr2__t8 vddr2__t4 sky130_fd_pr__pfet_01v8 L=2 W=0.44 AS=0.1848 AD=0.1848 PS=1.72 PD=1.72
* device instance $229 r0 *1 84.56,27.375 pfet
Xn229 py__t07 vss__t21 vddr2__t10 vddr2__t6 sky130_fd_pr__pfet_01v8 L=2 W=0.44 AS=0.1848 AD=0.1848 PS=1.72 PD=1.72
* device instance $230 r0 *1 92.735,27.375 pfet
Xn230 py__t08 vss__t20 vddr2__t9 vddr2__t5 sky130_fd_pr__pfet_01v8 L=2 W=0.44 AS=0.1848 AD=0.1848 PS=1.72 PD=1.72
* device instance $231 r0 *1 116.375,27.825 pfet
Xn231 sig_n1__t03 en3__t0 py_g__t23 vddr3__t20 sky130_fd_pr__pfet_01v8 L=0.15 W=0.84 AS=0.3948 AD=0.3948 PS=2.62 PD=2.62
* device instance $232 r0 *1 117.665,27.825 pfet
Xn232 py_g__t13 rn3__t3 sig_n1__t33 vddr3__t19 sky130_fd_pr__pfet_01v8 L=0.15 W=0.84 AS=0.3948 AD=0.3948 PS=2.62 PD=2.62
* device instance $233 r0 *1 123.51,27.375 pfet
Xn233 py__t09 vss__t14 vddr3__t7 vddr3__t3 sky130_fd_pr__pfet_01v8 L=2 W=0.46 AS=0.1932 AD=0.1932 PS=1.76 PD=1.76
* device instance $234 r0 *1 131.685,27.375 pfet
Xn234 py__t010 vss__t15 vddr3__t8 vddr3__t4 sky130_fd_pr__pfet_01v8 L=2 W=0.46 AS=0.1932 AD=0.1932 PS=1.76 PD=1.76
* device instance $235 r0 *1 139.86,27.375 pfet
Xn235 py__t011 vss__t16 vddr3__t9 vddr3__t5 sky130_fd_pr__pfet_01v8 L=2 W=0.46 AS=0.1932 AD=0.1932 PS=1.76 PD=1.76
* device instance $236 r0 *1 148.035,27.375 pfet
Xn236 py__t012 vss__t17 vddr3__t10 vddr3__t6 sky130_fd_pr__pfet_01v8 L=2 W=0.46 AS=0.1932 AD=0.1932 PS=1.76 PD=1.76
* device instance $237 r0 *1 171.675,27.825 pfet
Xn237 sig_n1__t04 en4__t0 py_g__t24 vddr4__t18 sky130_fd_pr__pfet_01v8 L=0.15 W=0.84 AS=0.3948 AD=0.3948 PS=2.62 PD=2.62
* device instance $238 r0 *1 172.965,27.825 pfet
Xn238 py_g__t14 rn4__t2 sig_n1__t34 vddr4__t17 sky130_fd_pr__pfet_01v8 L=0.15 W=0.84 AS=0.3948 AD=0.3948 PS=2.62 PD=2.62
* device instance $239 r0 *1 178.81,27.375 pfet
Xn239 py__t013 vss__t11 vddr4__t8 vddr4__t4 sky130_fd_pr__pfet_01v8 L=2 W=0.48 AS=0.2016 AD=0.2016 PS=1.8 PD=1.8
* device instance $240 r0 *1 186.985,27.375 pfet
Xn240 py__t014 vss__t10 vddr4__t7 vddr4__t3 sky130_fd_pr__pfet_01v8 L=2 W=0.48 AS=0.2016 AD=0.2016 PS=1.8 PD=1.8
* device instance $241 r0 *1 195.16,27.375 pfet
Xn241 py__t015 vss__t13 vddr4__t10 vddr4__t6 sky130_fd_pr__pfet_01v8 L=2 W=0.48 AS=0.2016 AD=0.2016 PS=1.8 PD=1.8
* device instance $242 r0 *1 203.335,27.375 pfet
Xn242 py__t016 vss__t12 vddr4__t9 vddr4__t5 sky130_fd_pr__pfet_01v8 L=2 W=0.48 AS=0.2016 AD=0.2016 PS=1.8 PD=1.8
* device instance $243 r0 *1 3.61,27.825 pfet
Xn243 py_g__t0 vss__t6 vddr1__t1 vddr1__t2 sky130_fd_pr__pfet_01v8 L=2 W=0.42 AS=0.1764 AD=0.1764 PS=1.68 PD=1.68
* device instance $244 r0 *1 3.445,44.86 pfet
Xn244 xor_an__t1 ro1__t5 vdd__t127 vdd__t64 sky130_fd_pr__pfet_01v8 L=0.15 W=0.84 AS=0.3948 AD=0.3948 PS=2.62 PD=2.62
* device instance $245 r0 *1 7.43,49.22 pfet
Xn245 mid__t1 ro1__t0 vdd__t2 vdd__t3 sky130_fd_pr__pfet_01v8 L=0.15 W=1.68 AS=0.7896 AD=0.4368 PS=4.3 PD=2.2
* device instance $246 r0 *1 8.1,49.22 pfet
Xn246 t1__t0 xor_an__t0 mid__t0 vdd__t4 sky130_fd_pr__pfet_01v8 L=0.15 W=1.68 AS=0.4368 AD=0.7896 PS=2.2 PD=4.3
* device instance $247 r0 *1 14.58,49.22 pfet
Xn247 mid__t2 xor_bn__t0 t1__t2 vdd__t17 sky130_fd_pr__pfet_01v8 L=0.15 W=1.68 AS=0.7896 AD=0.4368 PS=4.3 PD=2.2
* device instance $248 r0 *1 15.25,49.22 pfet
Xn248 vdd__t7 ro2__t0 mid__t3 vdd__t12 sky130_fd_pr__pfet_01v8 L=0.15 W=1.68 AS=0.4368 AD=0.7896 PS=2.2 PD=4.3
* device instance $249 r0 *1 21.62,44.86 pfet
Xn249 xor_bn__t1 ro2__t5 vdd__t110 vdd__t37 sky130_fd_pr__pfet_01v8 L=0.15 W=0.84 AS=0.3948 AD=0.3948 PS=2.62 PD=2.62
* device instance $250 r0 *1 32.415,44.86 pfet
Xn250 xor_an__t12 ro3__t5 vdd__t111 vdd__t38 sky130_fd_pr__pfet_01v8 L=0.15 W=0.84 AS=0.3948 AD=0.3948 PS=2.62 PD=2.62
* device instance $251 r0 *1 36.4,49.22 pfet
Xn251 mid__t12 ro3__t0 vdd__t19 vdd__t16 sky130_fd_pr__pfet_01v8 L=0.15 W=1.68 AS=0.7896 AD=0.4368 PS=4.3 PD=2.2
* device instance $252 r0 *1 37.07,49.22 pfet
Xn252 t2__t0 xor_an__t02 mid__t32 vdd__t11 sky130_fd_pr__pfet_01v8 L=0.15 W=1.68 AS=0.4368 AD=0.7896 PS=2.2 PD=4.3
* device instance $253 r0 *1 43.55,49.22 pfet
Xn253 mid__t02 xor_bn__t02 t2__t2 vdd__t15 sky130_fd_pr__pfet_01v8 L=0.15 W=1.68 AS=0.7896 AD=0.4368 PS=4.3 PD=2.2
* device instance $254 r0 *1 44.22,49.22 pfet
Xn254 vdd__t6 ro4__t0 mid__t22 vdd__t10 sky130_fd_pr__pfet_01v8 L=0.15 W=1.68 AS=0.4368 AD=0.7896 PS=2.2 PD=4.3
* device instance $255 r0 *1 50.59,44.86 pfet
Xn255 xor_bn__t12 ro4__t5 vdd__t113 vdd__t41 sky130_fd_pr__pfet_01v8 L=0.15 W=0.84 AS=0.3948 AD=0.3948 PS=2.62 PD=2.62
* device instance $256 r0 *1 58.91,27.825 pfet
Xn256 py_g__t02 vss__t7 vddr2__t1 vddr2__t2 sky130_fd_pr__pfet_01v8 L=2 W=0.44 AS=0.1848 AD=0.1848 PS=1.72 PD=1.72
* device instance $257 r0 *1 61.385,44.86 pfet
Xn257 xor_an__t13 t1__t3 vdd__t114 vdd__t42 sky130_fd_pr__pfet_01v8 L=0.15 W=0.84 AS=0.3948 AD=0.3948 PS=2.62 PD=2.62
* device instance $258 r0 *1 65.37,49.22 pfet
Xn258 mid__t13 t1__t1 vdd__t18 vdd__t14 sky130_fd_pr__pfet_01v8 L=0.15 W=1.68 AS=0.7896 AD=0.4368 PS=4.3 PD=2.2
* device instance $259 r0 *1 66.04,49.22 pfet
Xn259 xo__t0 xor_an__t03 mid__t33 vdd__t9 sky130_fd_pr__pfet_01v8 L=0.15 W=1.68 AS=0.4368 AD=0.7896 PS=2.2 PD=4.3
* device instance $260 r0 *1 72.52,49.22 pfet
Xn260 mid__t03 xor_bn__t03 xo__t1 vdd__t13 sky130_fd_pr__pfet_01v8 L=0.15 W=1.68 AS=0.7896 AD=0.4368 PS=4.3 PD=2.2
* device instance $261 r0 *1 73.19,49.22 pfet
Xn261 vdd__t5 t2__t1 mid__t23 vdd__t8 sky130_fd_pr__pfet_01v8 L=0.15 W=1.68 AS=0.4368 AD=0.7896 PS=2.2 PD=4.3
* device instance $262 r0 *1 79.56,44.86 pfet
Xn262 xor_bn__t13 t2__t3 vdd__t118 vdd__t50 sky130_fd_pr__pfet_01v8 L=0.15 W=0.84 AS=0.3948 AD=0.3948 PS=2.62 PD=2.62
* device instance $263 r0 *1 114.21,27.825 pfet
Xn263 py_g__t03 vss__t8 vddr3__t1 vddr3__t2 sky130_fd_pr__pfet_01v8 L=2 W=0.46 AS=0.1932 AD=0.1932 PS=1.76 PD=1.76
* device instance $264 r0 *1 169.51,27.825 pfet
Xn264 py_g__t04 vss__t9 vddr4__t1 vddr4__t2 sky130_fd_pr__pfet_01v8 L=2 W=0.48 AS=0.2016 AD=0.2016 PS=1.8 PD=1.8
* device instance _12_t0 r0 *1 0,0
R_12_t0 n12__t0 n12 12.8
* device instance _12_t1 r0 *1 0,0
R_12_t1 n12__t1 n12 12.8
* device instance _12 r0 *1 0,0
C_12 n12 vsubs 1.15618e-16
* device instance _138_t0 r0 *1 0,0
R_138_t0 n138__t0 n138 12.8
* device instance _138_t1 r0 *1 0,0
R_138_t1 n138__t1 n138 12.8
* device instance _138 r0 *1 0,0
C_138 n138 vsubs 1.15618e-16
* device instance _139_t0 r0 *1 0,0
R_139_t0 n139__t0 n139 12.8
* device instance _139_t1 r0 *1 0,0
R_139_t1 n139__t1 n139 12.8
* device instance _139 r0 *1 0,0
C_139 n139 vsubs 1.15618e-16
* device instance _14_t0 r0 *1 0,0
R_14_t0 n14__t0 n14 12.8
* device instance _14_t1 r0 *1 0,0
R_14_t1 n14__t1 n14 12.8
* device instance _14 r0 *1 0,0
C_14 n14 vsubs 1.15618e-16
* device instance _140_t0 r0 *1 0,0
R_140_t0 n140__t0 n140 12.8
* device instance _140_t1 r0 *1 0,0
R_140_t1 n140__t1 n140 12.8
* device instance _140 r0 *1 0,0
C_140 n140 vsubs 1.15618e-16
* device instance _142_t0 r0 *1 0,0
R_142_t0 n142__t0 n142 12.8
* device instance _142_t1 r0 *1 0,0
R_142_t1 n142__t1 n142 12.8
* device instance _142 r0 *1 0,0
C_142 n142 vsubs 1.15618e-16
* device instance _143_t0 r0 *1 0,0
R_143_t0 n143__t0 n143 12.8
* device instance _143_t1 r0 *1 0,0
R_143_t1 n143__t1 n143 12.8
* device instance _143 r0 *1 0,0
C_143 n143 vsubs 1.15618e-16
* device instance _146_t0 r0 *1 0,0
R_146_t0 n146__t0 n146 12.8
* device instance _146_t1 r0 *1 0,0
R_146_t1 n146__t1 n146 12.8
* device instance _146 r0 *1 0,0
C_146 n146 vsubs 1.15618e-16
* device instance _16_t0 r0 *1 0,0
R_16_t0 n16__t0 n16 12.8
* device instance _16_t1 r0 *1 0,0
R_16_t1 n16__t1 n16 12.8
* device instance _16 r0 *1 0,0
C_16 n16 vsubs 1.15618e-16
* device instance _18_t0 r0 *1 0,0
R_18_t0 n18__t0 n18 12.8
* device instance _18_t1 r0 *1 0,0
R_18_t1 n18__t1 n18 12.8
* device instance _18 r0 *1 0,0
C_18 n18 vsubs 1.15618e-16
* device instance _21_t0 r0 *1 0,0
R_21_t0 n21__t0 n21 12.8
* device instance _21_t1 r0 *1 0,0
R_21_t1 n21__t1 n21 12.8
* device instance _21 r0 *1 0,0
C_21 n21 vsubs 1.15618e-16
* device instance _23_t0 r0 *1 0,0
R_23_t0 n23__t0 n23 12.8
* device instance _23_t1 r0 *1 0,0
R_23_t1 n23__t1 n23 12.8
* device instance _23 r0 *1 0,0
C_23 n23 vsubs 1.15618e-16
* device instance _26_t0 r0 *1 0,0
R_26_t0 n26__t0 n26 12.8
* device instance _26_t1 r0 *1 0,0
R_26_t1 n26__t1 n26 12.8
* device instance _26 r0 *1 0,0
C_26 n26 vsubs 1.15618e-16
* device instance _28_t0 r0 *1 0,0
R_28_t0 n28__t0 n28 12.8
* device instance _28_t1 r0 *1 0,0
R_28_t1 n28__t1 n28 12.8
* device instance _28 r0 *1 0,0
C_28 n28 vsubs 1.15618e-16
* device instance _31_t0 r0 *1 0,0
R_31_t0 n31__t0 n31 12.8
* device instance _31_t1 r0 *1 0,0
R_31_t1 n31__t1 n31 12.8
* device instance _31 r0 *1 0,0
C_31 n31 vsubs 1.15618e-16
* device instance _33_t0 r0 *1 0,0
R_33_t0 n33__t0 n33 12.8
* device instance _33_t1 r0 *1 0,0
R_33_t1 n33__t1 n33 12.8
* device instance _33 r0 *1 0,0
C_33 n33 vsubs 1.15618e-16
* device instance _36_t0 r0 *1 0,0
R_36_t0 n36__t0 n36 12.8
* device instance _36_t1 r0 *1 0,0
R_36_t1 n36__t1 n36 12.8
* device instance _36 r0 *1 0,0
C_36 n36 vsubs 1.15618e-16
* device instance _38_t0 r0 *1 0,0
R_38_t0 n38__t0 n38 12.8
* device instance _38_t1 r0 *1 0,0
R_38_t1 n38__t1 n38 12.8
* device instance _38 r0 *1 0,0
C_38 n38 vsubs 1.15618e-16
* device instance _72_t0 r0 *1 0,0
R_72_t0 n72__t0 n72 12.8
* device instance _72_t1 r0 *1 0,0
R_72_t1 n72__t1 n72 12.8
* device instance _72 r0 *1 0,0
C_72 n72 vsubs 1.15618e-16
* device instance _79_t0 r0 *1 0,0
R_79_t0 n79__t0 n79 12.8
* device instance _79_t1 r0 *1 0,0
R_79_t1 n79__t1 n79 12.8
* device instance _79 r0 *1 0,0
C_79 n79 vsubs 1.15618e-16
* device instance _88_t0 r0 *1 0,0
R_88_t0 n88__t0 n88 12.8
* device instance _88_t1 r0 *1 0,0
R_88_t1 n88__t1 n88 12.8
* device instance _88 r0 *1 0,0
C_88 n88 vsubs 1.15618e-16
* device instance _96_t0 r0 *1 0,0
R_96_t0 n96__t0 n96 12.8
* device instance _96_t1 r0 *1 0,0
R_96_t1 n96__t1 n96 12.8
* device instance _96 r0 *1 0,0
C_96 n96 vsubs 1.15618e-16
* device instance a_b_b3_invb_a_mn12_g1_mp24_g0_t2_y_t0 r0 *1 0,0
Ra_b_b3_invb_a_mn12_g1_mp24_g0_t2_y_t0 t2__t0 t2 409.635106767
* device instance a_b_b3_invb_a_mn12_g1_mp24_g0_t2_y_t1 r0 *1 0,0
Ra_b_b3_invb_a_mn12_g1_mp24_g0_t2_y_t1 t2__t1 t2 294.133620825
* device instance a_b_b3_invb_a_mn12_g1_mp24_g0_t2_y_t2 r0 *1 0,0
Ra_b_b3_invb_a_mn12_g1_mp24_g0_t2_y_t2 t2__t2 t2 293.51720502
* device instance a_b_b3_invb_a_mn12_g1_mp24_g0_t2_y_t3 r0 *1 0,0
Ra_b_b3_invb_a_mn12_g1_mp24_g0_t2_y_t3 t2__t3 t2 396.642557999
* device instance a_b_b3_invb_a_mn12_g1_mp24_g0_t2_y_t4 r0 *1 0,0
Ra_b_b3_invb_a_mn12_g1_mp24_g0_t2_y_t4 t2__t4 t2 398.872164213
* device instance a_b_b3_invb_a_mn12_g1_mp24_g0_t2_y_t5 r0 *1 0,0
Ra_b_b3_invb_a_mn12_g1_mp24_g0_t2_y_t5 t2__t5 t2 294.652537151
* device instance a_b_b3_invb_a_mn12_g1_mp24_g0_t2_y_t6 r0 *1 0,0
Ra_b_b3_invb_a_mn12_g1_mp24_g0_t2_y_t6 t2__t6 t2 413.294026601
* device instance a_b_b3_invb_a_mn12_g1_mp24_g0_t2_y_t7 r0 *1 0,0
Ra_b_b3_invb_a_mn12_g1_mp24_g0_t2_y_t7 t2__t7 t2 286.911181424
* device instance a_b_b3_invb_a_mn12_g1_mp24_g0_t2_y r0 *1 0,0
Ca_b_b3_invb_a_mn12_g1_mp24_g0_t2_y t2 vsubs 1.0147503e-14
* device instance a_b_d_invb_a_mn12_g1_mp24_g0_ro2_ro2_esc_sr2_d_stub_tg_d_a_y_t0 r0 *1 0,0
Ra_b_d_invb_a_mn12_g1_mp24_g0_ro2_ro2_esc_sr2_d_stub_tg_d_a_y_t0 ro2__t0 ro2 255.012528793
* device instance a_b_d_invb_a_mn12_g1_mp24_g0_ro2_ro2_esc_sr2_d_stub_tg_d_a_y_t1 r0 *1 0,0
Ra_b_d_invb_a_mn12_g1_mp24_g0_ro2_ro2_esc_sr2_d_stub_tg_d_a_y_t1 ro2__t1 ro2 99.3433738514
* device instance a_b_d_invb_a_mn12_g1_mp24_g0_ro2_ro2_esc_sr2_d_stub_tg_d_a_y_t2 r0 *1 0,0
Ra_b_d_invb_a_mn12_g1_mp24_g0_ro2_ro2_esc_sr2_d_stub_tg_d_a_y_t2 ro2__t2 ro2 373.724634993
* device instance a_b_d_invb_a_mn12_g1_mp24_g0_ro2_ro2_esc_sr2_d_stub_tg_d_a_y_t3 r0 *1 0,0
Ra_b_d_invb_a_mn12_g1_mp24_g0_ro2_ro2_esc_sr2_d_stub_tg_d_a_y_t3 ro2__t3 ro2 377.228073538
* device instance a_b_d_invb_a_mn12_g1_mp24_g0_ro2_ro2_esc_sr2_d_stub_tg_d_a_y_t4 r0 *1 0,0
Ra_b_d_invb_a_mn12_g1_mp24_g0_ro2_ro2_esc_sr2_d_stub_tg_d_a_y_t4 ro2__t4 ro2 100.907361972
* device instance a_b_d_invb_a_mn12_g1_mp24_g0_ro2_ro2_esc_sr2_d_stub_tg_d_a_y_t5 r0 *1 0,0
Ra_b_d_invb_a_mn12_g1_mp24_g0_ro2_ro2_esc_sr2_d_stub_tg_d_a_y_t5 ro2__t5 ro2 226.705362657
* device instance a_b_d_invb_a_mn12_g1_mp24_g0_ro2_ro2_esc_sr2_d_stub_tg_d_a_y_t6 r0 *1 0,0
Ra_b_d_invb_a_mn12_g1_mp24_g0_ro2_ro2_esc_sr2_d_stub_tg_d_a_y_t6 ro2__t6 ro2 223.547043236
* device instance a_b_d_invb_a_mn12_g1_mp24_g0_ro2_ro2_esc_sr2_d_stub_tg_d_a_y_t7 r0 *1 0,0
Ra_b_d_invb_a_mn12_g1_mp24_g0_ro2_ro2_esc_sr2_d_stub_tg_d_a_y_t7 ro2__t7 ro2 245.10132096
* device instance a_b_d_invb_a_mn12_g1_mp24_g0_ro2_ro2_esc_sr2_d_stub_tg_d_a_y r0 *1 0,0
Ca_b_d_invb_a_mn12_g1_mp24_g0_ro2_ro2_esc_sr2_d_stub_tg_d_a_y ro2 vsubs 3.0668813e-14
* device instance a_b_d_invb_a_mn12_g1_mp24_g0_ro4_ro4_esc_sr4_d_stub_tg_d_a_y_t0 r0 *1 0,0
Ra_b_d_invb_a_mn12_g1_mp24_g0_ro4_ro4_esc_sr4_d_stub_tg_d_a_y_t0 ro4__t0 ro4 243.020425688
* device instance a_b_d_invb_a_mn12_g1_mp24_g0_ro4_ro4_esc_sr4_d_stub_tg_d_a_y_t1 r0 *1 0,0
Ra_b_d_invb_a_mn12_g1_mp24_g0_ro4_ro4_esc_sr4_d_stub_tg_d_a_y_t1 ro4__t1 ro4 315.186307889
* device instance a_b_d_invb_a_mn12_g1_mp24_g0_ro4_ro4_esc_sr4_d_stub_tg_d_a_y_t2 r0 *1 0,0
Ra_b_d_invb_a_mn12_g1_mp24_g0_ro4_ro4_esc_sr4_d_stub_tg_d_a_y_t2 ro4__t2 ro4 152.215466951
* device instance a_b_d_invb_a_mn12_g1_mp24_g0_ro4_ro4_esc_sr4_d_stub_tg_d_a_y_t3 r0 *1 0,0
Ra_b_d_invb_a_mn12_g1_mp24_g0_ro4_ro4_esc_sr4_d_stub_tg_d_a_y_t3 ro4__t3 ro4 152.580461837
* device instance a_b_d_invb_a_mn12_g1_mp24_g0_ro4_ro4_esc_sr4_d_stub_tg_d_a_y_t4 r0 *1 0,0
Ra_b_d_invb_a_mn12_g1_mp24_g0_ro4_ro4_esc_sr4_d_stub_tg_d_a_y_t4 ro4__t4 ro4 316.665349301
* device instance a_b_d_invb_a_mn12_g1_mp24_g0_ro4_ro4_esc_sr4_d_stub_tg_d_a_y_t5 r0 *1 0,0
Ra_b_d_invb_a_mn12_g1_mp24_g0_ro4_ro4_esc_sr4_d_stub_tg_d_a_y_t5 ro4__t5 ro4 226.881843467
* device instance a_b_d_invb_a_mn12_g1_mp24_g0_ro4_ro4_esc_sr4_d_stub_tg_d_a_y_t6 r0 *1 0,0
Ra_b_d_invb_a_mn12_g1_mp24_g0_ro4_ro4_esc_sr4_d_stub_tg_d_a_y_t6 ro4__t6 ro4 225.765905383
* device instance a_b_d_invb_a_mn12_g1_mp24_g0_ro4_ro4_esc_sr4_d_stub_tg_d_a_y_t7 r0 *1 0,0
Ra_b_d_invb_a_mn12_g1_mp24_g0_ro4_ro4_esc_sr4_d_stub_tg_d_a_y_t7 ro4__t7 ro4 239.190739485
* device instance a_b_d_invb_a_mn12_g1_mp24_g0_ro4_ro4_esc_sr4_d_stub_tg_d_a_y r0 *1 0,0
Ca_b_d_invb_a_mn12_g1_mp24_g0_ro4_ro4_esc_sr4_d_stub_tg_d_a_y ro4 vsubs 2.8023156e-14
* device instance a_b_inv_q_a_inv_q_a_via_s_tg_fbs_b_tg_fbs_b_via_tg_s_b_tg_s_b_via_t0 r0 *1 0,0
Ra_b_inv_q_a_inv_q_a_via_s_tg_fbs_b_tg_fbs_b_via_tg_s_b_tg_s_b_via_t0 s__t0 s 65.5799158739
* device instance a_b_inv_q_a_inv_q_a_via_s_tg_fbs_b_tg_fbs_b_via_tg_s_b_tg_s_b_via_t1 r0 *1 0,0
Ra_b_inv_q_a_inv_q_a_via_s_tg_fbs_b_tg_fbs_b_via_tg_s_b_tg_s_b_via_t1 s__t1 s 65.5799158739
* device instance a_b_inv_q_a_inv_q_a_via_s_tg_fbs_b_tg_fbs_b_via_tg_s_b_tg_s_b_via_t2 r0 *1 0,0
Ra_b_inv_q_a_inv_q_a_via_s_tg_fbs_b_tg_fbs_b_via_tg_s_b_tg_s_b_via_t2 s__t2 s 230.632009296
* device instance a_b_inv_q_a_inv_q_a_via_s_tg_fbs_b_tg_fbs_b_via_tg_s_b_tg_s_b_via_t3 r0 *1 0,0
Ra_b_inv_q_a_inv_q_a_via_s_tg_fbs_b_tg_fbs_b_via_tg_s_b_tg_s_b_via_t3 s__t3 s 279.22177483
* device instance a_b_inv_q_a_inv_q_a_via_s_tg_fbs_b_tg_fbs_b_via_tg_s_b_tg_s_b_via_t4 r0 *1 0,0
Ra_b_inv_q_a_inv_q_a_via_s_tg_fbs_b_tg_fbs_b_via_tg_s_b_tg_s_b_via_t4 s__t4 s 230.632009296
* device instance a_b_inv_q_a_inv_q_a_via_s_tg_fbs_b_tg_fbs_b_via_tg_s_b_tg_s_b_via_t5 r0 *1 0,0
Ra_b_inv_q_a_inv_q_a_via_s_tg_fbs_b_tg_fbs_b_via_tg_s_b_tg_s_b_via_t5 s__t5 s 279.22177483
* device instance a_b_inv_q_a_inv_q_a_via_s_tg_fbs_b_tg_fbs_b_via_tg_s_b_tg_s_b_via r0 *1 0,0
Ca_b_inv_q_a_inv_q_a_via_s_tg_fbs_b_tg_fbs_b_via_tg_s_b_tg_s_b_via s vsubs 3.962997e-15
* device instance a_b_inv_q_a_inv_q_a_via_s_tg_fbs_b_tg_fbs_b_via_tg_s_b_tg_s_b_via_dup1_t0 r0 *1 0,0
Ra_b_inv_q_a_inv_q_a_via_s_tg_fbs_b_tg_fbs_b_via_tg_s_b_tg_s_b_via_dup1_t0 s__t02 sn1 65.5799158739
* device instance a_b_inv_q_a_inv_q_a_via_s_tg_fbs_b_tg_fbs_b_via_tg_s_b_tg_s_b_via_dup1_t1 r0 *1 0,0
Ra_b_inv_q_a_inv_q_a_via_s_tg_fbs_b_tg_fbs_b_via_tg_s_b_tg_s_b_via_dup1_t1 s__t12 sn1 65.5799158739
* device instance a_b_inv_q_a_inv_q_a_via_s_tg_fbs_b_tg_fbs_b_via_tg_s_b_tg_s_b_via_dup1_t2 r0 *1 0,0
Ra_b_inv_q_a_inv_q_a_via_s_tg_fbs_b_tg_fbs_b_via_tg_s_b_tg_s_b_via_dup1_t2 s__t22 sn1 279.22177483
* device instance a_b_inv_q_a_inv_q_a_via_s_tg_fbs_b_tg_fbs_b_via_tg_s_b_tg_s_b_via_dup1_t3 r0 *1 0,0
Ra_b_inv_q_a_inv_q_a_via_s_tg_fbs_b_tg_fbs_b_via_tg_s_b_tg_s_b_via_dup1_t3 s__t32 sn1 230.632009296
* device instance a_b_inv_q_a_inv_q_a_via_s_tg_fbs_b_tg_fbs_b_via_tg_s_b_tg_s_b_via_dup1_t4 r0 *1 0,0
Ra_b_inv_q_a_inv_q_a_via_s_tg_fbs_b_tg_fbs_b_via_tg_s_b_tg_s_b_via_dup1_t4 s__t42 sn1 279.22177483
* device instance a_b_inv_q_a_inv_q_a_via_s_tg_fbs_b_tg_fbs_b_via_tg_s_b_tg_s_b_via_dup1_t5 r0 *1 0,0
Ra_b_inv_q_a_inv_q_a_via_s_tg_fbs_b_tg_fbs_b_via_tg_s_b_tg_s_b_via_dup1_t5 s__t52 sn1 230.632009296
* device instance a_b_inv_q_a_inv_q_a_via_s_tg_fbs_b_tg_fbs_b_via_tg_s_b_tg_s_b_via_dup1 r0 *1 0,0
Ca_b_inv_q_a_inv_q_a_via_s_tg_fbs_b_tg_fbs_b_via_tg_s_b_tg_s_b_via_dup1 sn1 vsubs 3.962997e-15
* device instance a_b_inv_q_a_inv_q_a_via_s_tg_fbs_b_tg_fbs_b_via_tg_s_b_tg_s_b_via_dup2_t0 r0 *1 0,0
Ra_b_inv_q_a_inv_q_a_via_s_tg_fbs_b_tg_fbs_b_via_tg_s_b_tg_s_b_via_dup2_t0 s__t03 sn2 65.5799158739
* device instance a_b_inv_q_a_inv_q_a_via_s_tg_fbs_b_tg_fbs_b_via_tg_s_b_tg_s_b_via_dup2_t1 r0 *1 0,0
Ra_b_inv_q_a_inv_q_a_via_s_tg_fbs_b_tg_fbs_b_via_tg_s_b_tg_s_b_via_dup2_t1 s__t13 sn2 65.5799158739
* device instance a_b_inv_q_a_inv_q_a_via_s_tg_fbs_b_tg_fbs_b_via_tg_s_b_tg_s_b_via_dup2_t2 r0 *1 0,0
Ra_b_inv_q_a_inv_q_a_via_s_tg_fbs_b_tg_fbs_b_via_tg_s_b_tg_s_b_via_dup2_t2 s__t23 sn2 279.22177483
* device instance a_b_inv_q_a_inv_q_a_via_s_tg_fbs_b_tg_fbs_b_via_tg_s_b_tg_s_b_via_dup2_t3 r0 *1 0,0
Ra_b_inv_q_a_inv_q_a_via_s_tg_fbs_b_tg_fbs_b_via_tg_s_b_tg_s_b_via_dup2_t3 s__t33 sn2 230.632009296
* device instance a_b_inv_q_a_inv_q_a_via_s_tg_fbs_b_tg_fbs_b_via_tg_s_b_tg_s_b_via_dup2_t4 r0 *1 0,0
Ra_b_inv_q_a_inv_q_a_via_s_tg_fbs_b_tg_fbs_b_via_tg_s_b_tg_s_b_via_dup2_t4 s__t43 sn2 279.22177483
* device instance a_b_inv_q_a_inv_q_a_via_s_tg_fbs_b_tg_fbs_b_via_tg_s_b_tg_s_b_via_dup2_t5 r0 *1 0,0
Ra_b_inv_q_a_inv_q_a_via_s_tg_fbs_b_tg_fbs_b_via_tg_s_b_tg_s_b_via_dup2_t5 s__t53 sn2 230.632009296
* device instance a_b_inv_q_a_inv_q_a_via_s_tg_fbs_b_tg_fbs_b_via_tg_s_b_tg_s_b_via_dup2 r0 *1 0,0
Ca_b_inv_q_a_inv_q_a_via_s_tg_fbs_b_tg_fbs_b_via_tg_s_b_tg_s_b_via_dup2 sn2 vsubs 3.962997e-15
* device instance a_b_inv_q_a_inv_q_a_via_s_tg_fbs_b_tg_fbs_b_via_tg_s_b_tg_s_b_via_dup3_t0 r0 *1 0,0
Ra_b_inv_q_a_inv_q_a_via_s_tg_fbs_b_tg_fbs_b_via_tg_s_b_tg_s_b_via_dup3_t0 s__t04 sn3 65.5799158739
* device instance a_b_inv_q_a_inv_q_a_via_s_tg_fbs_b_tg_fbs_b_via_tg_s_b_tg_s_b_via_dup3_t1 r0 *1 0,0
Ra_b_inv_q_a_inv_q_a_via_s_tg_fbs_b_tg_fbs_b_via_tg_s_b_tg_s_b_via_dup3_t1 s__t14 sn3 65.5799158739
* device instance a_b_inv_q_a_inv_q_a_via_s_tg_fbs_b_tg_fbs_b_via_tg_s_b_tg_s_b_via_dup3_t2 r0 *1 0,0
Ra_b_inv_q_a_inv_q_a_via_s_tg_fbs_b_tg_fbs_b_via_tg_s_b_tg_s_b_via_dup3_t2 s__t24 sn3 279.22177483
* device instance a_b_inv_q_a_inv_q_a_via_s_tg_fbs_b_tg_fbs_b_via_tg_s_b_tg_s_b_via_dup3_t3 r0 *1 0,0
Ra_b_inv_q_a_inv_q_a_via_s_tg_fbs_b_tg_fbs_b_via_tg_s_b_tg_s_b_via_dup3_t3 s__t34 sn3 230.632009296
* device instance a_b_inv_q_a_inv_q_a_via_s_tg_fbs_b_tg_fbs_b_via_tg_s_b_tg_s_b_via_dup3_t4 r0 *1 0,0
Ra_b_inv_q_a_inv_q_a_via_s_tg_fbs_b_tg_fbs_b_via_tg_s_b_tg_s_b_via_dup3_t4 s__t44 sn3 279.22177483
* device instance a_b_inv_q_a_inv_q_a_via_s_tg_fbs_b_tg_fbs_b_via_tg_s_b_tg_s_b_via_dup3_t5 r0 *1 0,0
Ra_b_inv_q_a_inv_q_a_via_s_tg_fbs_b_tg_fbs_b_via_tg_s_b_tg_s_b_via_dup3_t5 s__t54 sn3 230.632009296
* device instance a_b_inv_q_a_inv_q_a_via_s_tg_fbs_b_tg_fbs_b_via_tg_s_b_tg_s_b_via_dup3 r0 *1 0,0
Ca_b_inv_q_a_inv_q_a_via_s_tg_fbs_b_tg_fbs_b_via_tg_s_b_tg_s_b_via_dup3 sn3 vsubs 3.962997e-15
* device instance a_b_inv_q_a_inv_q_a_via_s_tg_fbs_b_tg_fbs_b_via_tg_s_b_tg_s_b_via_dup4_t0 r0 *1 0,0
Ra_b_inv_q_a_inv_q_a_via_s_tg_fbs_b_tg_fbs_b_via_tg_s_b_tg_s_b_via_dup4_t0 s__t05 sn4 65.5799158739
* device instance a_b_inv_q_a_inv_q_a_via_s_tg_fbs_b_tg_fbs_b_via_tg_s_b_tg_s_b_via_dup4_t1 r0 *1 0,0
Ra_b_inv_q_a_inv_q_a_via_s_tg_fbs_b_tg_fbs_b_via_tg_s_b_tg_s_b_via_dup4_t1 s__t15 sn4 65.5799158739
* device instance a_b_inv_q_a_inv_q_a_via_s_tg_fbs_b_tg_fbs_b_via_tg_s_b_tg_s_b_via_dup4_t2 r0 *1 0,0
Ra_b_inv_q_a_inv_q_a_via_s_tg_fbs_b_tg_fbs_b_via_tg_s_b_tg_s_b_via_dup4_t2 s__t25 sn4 230.632009296
* device instance a_b_inv_q_a_inv_q_a_via_s_tg_fbs_b_tg_fbs_b_via_tg_s_b_tg_s_b_via_dup4_t3 r0 *1 0,0
Ra_b_inv_q_a_inv_q_a_via_s_tg_fbs_b_tg_fbs_b_via_tg_s_b_tg_s_b_via_dup4_t3 s__t35 sn4 279.22177483
* device instance a_b_inv_q_a_inv_q_a_via_s_tg_fbs_b_tg_fbs_b_via_tg_s_b_tg_s_b_via_dup4_t4 r0 *1 0,0
Ra_b_inv_q_a_inv_q_a_via_s_tg_fbs_b_tg_fbs_b_via_tg_s_b_tg_s_b_via_dup4_t4 s__t45 sn4 230.632009296
* device instance a_b_inv_q_a_inv_q_a_via_s_tg_fbs_b_tg_fbs_b_via_tg_s_b_tg_s_b_via_dup4_t5 r0 *1 0,0
Ra_b_inv_q_a_inv_q_a_via_s_tg_fbs_b_tg_fbs_b_via_tg_s_b_tg_s_b_via_dup4_t5 s__t55 sn4 279.22177483
* device instance a_b_inv_q_a_inv_q_a_via_s_tg_fbs_b_tg_fbs_b_via_tg_s_b_tg_s_b_via_dup4 r0 *1 0,0
Ca_b_inv_q_a_inv_q_a_via_s_tg_fbs_b_tg_fbs_b_via_tg_s_b_tg_s_b_via_dup4 sn4 vsubs 3.962997e-15
* device instance a_b_inv_q_a_inv_q_a_via_s_tg_fbs_b_tg_fbs_b_via_tg_s_b_tg_s_b_via_dup5_t0 r0 *1 0,0
Ra_b_inv_q_a_inv_q_a_via_s_tg_fbs_b_tg_fbs_b_via_tg_s_b_tg_s_b_via_dup5_t0 s__t06 sn5 65.5799158739
* device instance a_b_inv_q_a_inv_q_a_via_s_tg_fbs_b_tg_fbs_b_via_tg_s_b_tg_s_b_via_dup5_t1 r0 *1 0,0
Ra_b_inv_q_a_inv_q_a_via_s_tg_fbs_b_tg_fbs_b_via_tg_s_b_tg_s_b_via_dup5_t1 s__t16 sn5 65.5799158739
* device instance a_b_inv_q_a_inv_q_a_via_s_tg_fbs_b_tg_fbs_b_via_tg_s_b_tg_s_b_via_dup5_t2 r0 *1 0,0
Ra_b_inv_q_a_inv_q_a_via_s_tg_fbs_b_tg_fbs_b_via_tg_s_b_tg_s_b_via_dup5_t2 s__t26 sn5 279.22177483
* device instance a_b_inv_q_a_inv_q_a_via_s_tg_fbs_b_tg_fbs_b_via_tg_s_b_tg_s_b_via_dup5_t3 r0 *1 0,0
Ra_b_inv_q_a_inv_q_a_via_s_tg_fbs_b_tg_fbs_b_via_tg_s_b_tg_s_b_via_dup5_t3 s__t36 sn5 230.632009296
* device instance a_b_inv_q_a_inv_q_a_via_s_tg_fbs_b_tg_fbs_b_via_tg_s_b_tg_s_b_via_dup5_t4 r0 *1 0,0
Ra_b_inv_q_a_inv_q_a_via_s_tg_fbs_b_tg_fbs_b_via_tg_s_b_tg_s_b_via_dup5_t4 s__t46 sn5 230.632009296
* device instance a_b_inv_q_a_inv_q_a_via_s_tg_fbs_b_tg_fbs_b_via_tg_s_b_tg_s_b_via_dup5_t5 r0 *1 0,0
Ra_b_inv_q_a_inv_q_a_via_s_tg_fbs_b_tg_fbs_b_via_tg_s_b_tg_s_b_via_dup5_t5 s__t56 sn5 279.22177483
* device instance a_b_inv_q_a_inv_q_a_via_s_tg_fbs_b_tg_fbs_b_via_tg_s_b_tg_s_b_via_dup5 r0 *1 0,0
Ca_b_inv_q_a_inv_q_a_via_s_tg_fbs_b_tg_fbs_b_via_tg_s_b_tg_s_b_via_dup5 sn5 vsubs 3.962997e-15
* device instance a_b_m_east_m_west_nand_m_a_nand_m_a_ext_via_nand_m_a_ext_via2_nand_m_a_stub_tg_d_b_tg_d_b_via_tg_d_b_via2_tg_fbm_b_tg_fbm_b_alt_via_tg_fbm_b_alt_via2_t0 r0 *1 0,0
Ra_b_m_east_m_west_nand_m_a_nand_m_a_ext_via_nand_m_a_ext_via2_nand_m_a_stub_tg_d_b_tg_d_b_via_tg_d_b_via2_tg_fbm_b_tg_fbm_b_alt_via_tg_fbm_b_alt_via2_t0 m__t0 m 68.7741894738
* device instance a_b_m_east_m_west_nand_m_a_nand_m_a_ext_via_nand_m_a_ext_via2_nand_m_a_stub_tg_d_b_tg_d_b_via_tg_d_b_via2_tg_fbm_b_tg_fbm_b_alt_via_tg_fbm_b_alt_via2_t1 r0 *1 0,0
Ra_b_m_east_m_west_nand_m_a_nand_m_a_ext_via_nand_m_a_ext_via2_nand_m_a_stub_tg_d_b_tg_d_b_via_tg_d_b_via2_tg_fbm_b_tg_fbm_b_alt_via_tg_fbm_b_alt_via2_t1 m__t1 m 262.615776106
* device instance a_b_m_east_m_west_nand_m_a_nand_m_a_ext_via_nand_m_a_ext_via2_nand_m_a_stub_tg_d_b_tg_d_b_via_tg_d_b_via2_tg_fbm_b_tg_fbm_b_alt_via_tg_fbm_b_alt_via2_t2 r0 *1 0,0
Ra_b_m_east_m_west_nand_m_a_nand_m_a_ext_via_nand_m_a_ext_via2_nand_m_a_stub_tg_d_b_tg_d_b_via_tg_d_b_via2_tg_fbm_b_tg_fbm_b_alt_via_tg_fbm_b_alt_via2_t2 m__t2 m 292.98458946
* device instance a_b_m_east_m_west_nand_m_a_nand_m_a_ext_via_nand_m_a_ext_via2_nand_m_a_stub_tg_d_b_tg_d_b_via_tg_d_b_via2_tg_fbm_b_tg_fbm_b_alt_via_tg_fbm_b_alt_via2_t3 r0 *1 0,0
Ra_b_m_east_m_west_nand_m_a_nand_m_a_ext_via_nand_m_a_ext_via2_nand_m_a_stub_tg_d_b_tg_d_b_via_tg_d_b_via2_tg_fbm_b_tg_fbm_b_alt_via_tg_fbm_b_alt_via2_t3 m__t3 m 261.497453093
* device instance a_b_m_east_m_west_nand_m_a_nand_m_a_ext_via_nand_m_a_ext_via2_nand_m_a_stub_tg_d_b_tg_d_b_via_tg_d_b_via2_tg_fbm_b_tg_fbm_b_alt_via_tg_fbm_b_alt_via2_t4 r0 *1 0,0
Ra_b_m_east_m_west_nand_m_a_nand_m_a_ext_via_nand_m_a_ext_via2_nand_m_a_stub_tg_d_b_tg_d_b_via_tg_d_b_via2_tg_fbm_b_tg_fbm_b_alt_via_tg_fbm_b_alt_via2_t4 m__t4 m 291.982605261
* device instance a_b_m_east_m_west_nand_m_a_nand_m_a_ext_via_nand_m_a_ext_via2_nand_m_a_stub_tg_d_b_tg_d_b_via_tg_d_b_via2_tg_fbm_b_tg_fbm_b_alt_via_tg_fbm_b_alt_via2_t5 r0 *1 0,0
Ra_b_m_east_m_west_nand_m_a_nand_m_a_ext_via_nand_m_a_ext_via2_nand_m_a_stub_tg_d_b_tg_d_b_via_tg_d_b_via2_tg_fbm_b_tg_fbm_b_alt_via_tg_fbm_b_alt_via2_t5 m__t5 m 60.1829866055
* device instance a_b_m_east_m_west_nand_m_a_nand_m_a_ext_via_nand_m_a_ext_via2_nand_m_a_stub_tg_d_b_tg_d_b_via_tg_d_b_via2_tg_fbm_b_tg_fbm_b_alt_via_tg_fbm_b_alt_via2 r0 *1 0,0
Ca_b_m_east_m_west_nand_m_a_nand_m_a_ext_via_nand_m_a_ext_via2_nand_m_a_stub_tg_d_b_tg_d_b_via_tg_d_b_via2_tg_fbm_b_tg_fbm_b_alt_via_tg_fbm_b_alt_via2 m vsubs 3.895867e-15
* device instance a_b_m_east_m_west_nand_m_a_nand_m_a_ext_via_nand_m_a_ext_via2_nand_m_a_stub_tg_d_b_tg_d_b_via_tg_d_b_via2_tg_fbm_b_tg_fbm_b_alt_via_tg_fbm_b_alt_via2_dup1_t0 r0 *1 0,0
Ra_b_m_east_m_west_nand_m_a_nand_m_a_ext_via_nand_m_a_ext_via2_nand_m_a_stub_tg_d_b_tg_d_b_via_tg_d_b_via2_tg_fbm_b_tg_fbm_b_alt_via_tg_fbm_b_alt_via2_dup1_t0 m__t02 mn1 60.1829866055
* device instance a_b_m_east_m_west_nand_m_a_nand_m_a_ext_via_nand_m_a_ext_via2_nand_m_a_stub_tg_d_b_tg_d_b_via_tg_d_b_via2_tg_fbm_b_tg_fbm_b_alt_via_tg_fbm_b_alt_via2_dup1_t1 r0 *1 0,0
Ra_b_m_east_m_west_nand_m_a_nand_m_a_ext_via_nand_m_a_ext_via2_nand_m_a_stub_tg_d_b_tg_d_b_via_tg_d_b_via2_tg_fbm_b_tg_fbm_b_alt_via_tg_fbm_b_alt_via2_dup1_t1 m__t12 mn1 68.7741894738
* device instance a_b_m_east_m_west_nand_m_a_nand_m_a_ext_via_nand_m_a_ext_via2_nand_m_a_stub_tg_d_b_tg_d_b_via_tg_d_b_via2_tg_fbm_b_tg_fbm_b_alt_via_tg_fbm_b_alt_via2_dup1_t2 r0 *1 0,0
Ra_b_m_east_m_west_nand_m_a_nand_m_a_ext_via_nand_m_a_ext_via2_nand_m_a_stub_tg_d_b_tg_d_b_via_tg_d_b_via2_tg_fbm_b_tg_fbm_b_alt_via_tg_fbm_b_alt_via2_dup1_t2 m__t22 mn1 262.615776106
* device instance a_b_m_east_m_west_nand_m_a_nand_m_a_ext_via_nand_m_a_ext_via2_nand_m_a_stub_tg_d_b_tg_d_b_via_tg_d_b_via2_tg_fbm_b_tg_fbm_b_alt_via_tg_fbm_b_alt_via2_dup1_t3 r0 *1 0,0
Ra_b_m_east_m_west_nand_m_a_nand_m_a_ext_via_nand_m_a_ext_via2_nand_m_a_stub_tg_d_b_tg_d_b_via_tg_d_b_via2_tg_fbm_b_tg_fbm_b_alt_via_tg_fbm_b_alt_via2_dup1_t3 m__t32 mn1 292.98458946
* device instance a_b_m_east_m_west_nand_m_a_nand_m_a_ext_via_nand_m_a_ext_via2_nand_m_a_stub_tg_d_b_tg_d_b_via_tg_d_b_via2_tg_fbm_b_tg_fbm_b_alt_via_tg_fbm_b_alt_via2_dup1_t4 r0 *1 0,0
Ra_b_m_east_m_west_nand_m_a_nand_m_a_ext_via_nand_m_a_ext_via2_nand_m_a_stub_tg_d_b_tg_d_b_via_tg_d_b_via2_tg_fbm_b_tg_fbm_b_alt_via_tg_fbm_b_alt_via2_dup1_t4 m__t42 mn1 261.497453093
* device instance a_b_m_east_m_west_nand_m_a_nand_m_a_ext_via_nand_m_a_ext_via2_nand_m_a_stub_tg_d_b_tg_d_b_via_tg_d_b_via2_tg_fbm_b_tg_fbm_b_alt_via_tg_fbm_b_alt_via2_dup1_t5 r0 *1 0,0
Ra_b_m_east_m_west_nand_m_a_nand_m_a_ext_via_nand_m_a_ext_via2_nand_m_a_stub_tg_d_b_tg_d_b_via_tg_d_b_via2_tg_fbm_b_tg_fbm_b_alt_via_tg_fbm_b_alt_via2_dup1_t5 m__t52 mn1 291.982605261
* device instance a_b_m_east_m_west_nand_m_a_nand_m_a_ext_via_nand_m_a_ext_via2_nand_m_a_stub_tg_d_b_tg_d_b_via_tg_d_b_via2_tg_fbm_b_tg_fbm_b_alt_via_tg_fbm_b_alt_via2_dup1 r0 *1 0,0
Ca_b_m_east_m_west_nand_m_a_nand_m_a_ext_via_nand_m_a_ext_via2_nand_m_a_stub_tg_d_b_tg_d_b_via_tg_d_b_via2_tg_fbm_b_tg_fbm_b_alt_via_tg_fbm_b_alt_via2_dup1 mn1 vsubs 3.895867e-15
* device instance a_b_m_east_m_west_nand_m_a_nand_m_a_ext_via_nand_m_a_ext_via2_nand_m_a_stub_tg_d_b_tg_d_b_via_tg_d_b_via2_tg_fbm_b_tg_fbm_b_alt_via_tg_fbm_b_alt_via2_dup2_t0 r0 *1 0,0
Ra_b_m_east_m_west_nand_m_a_nand_m_a_ext_via_nand_m_a_ext_via2_nand_m_a_stub_tg_d_b_tg_d_b_via_tg_d_b_via2_tg_fbm_b_tg_fbm_b_alt_via_tg_fbm_b_alt_via2_dup2_t0 m__t03 mn2 68.7741894738
* device instance a_b_m_east_m_west_nand_m_a_nand_m_a_ext_via_nand_m_a_ext_via2_nand_m_a_stub_tg_d_b_tg_d_b_via_tg_d_b_via2_tg_fbm_b_tg_fbm_b_alt_via_tg_fbm_b_alt_via2_dup2_t1 r0 *1 0,0
Ra_b_m_east_m_west_nand_m_a_nand_m_a_ext_via_nand_m_a_ext_via2_nand_m_a_stub_tg_d_b_tg_d_b_via_tg_d_b_via2_tg_fbm_b_tg_fbm_b_alt_via_tg_fbm_b_alt_via2_dup2_t1 m__t13 mn2 262.615776106
* device instance a_b_m_east_m_west_nand_m_a_nand_m_a_ext_via_nand_m_a_ext_via2_nand_m_a_stub_tg_d_b_tg_d_b_via_tg_d_b_via2_tg_fbm_b_tg_fbm_b_alt_via_tg_fbm_b_alt_via2_dup2_t2 r0 *1 0,0
Ra_b_m_east_m_west_nand_m_a_nand_m_a_ext_via_nand_m_a_ext_via2_nand_m_a_stub_tg_d_b_tg_d_b_via_tg_d_b_via2_tg_fbm_b_tg_fbm_b_alt_via_tg_fbm_b_alt_via2_dup2_t2 m__t23 mn2 292.98458946
* device instance a_b_m_east_m_west_nand_m_a_nand_m_a_ext_via_nand_m_a_ext_via2_nand_m_a_stub_tg_d_b_tg_d_b_via_tg_d_b_via2_tg_fbm_b_tg_fbm_b_alt_via_tg_fbm_b_alt_via2_dup2_t3 r0 *1 0,0
Ra_b_m_east_m_west_nand_m_a_nand_m_a_ext_via_nand_m_a_ext_via2_nand_m_a_stub_tg_d_b_tg_d_b_via_tg_d_b_via2_tg_fbm_b_tg_fbm_b_alt_via_tg_fbm_b_alt_via2_dup2_t3 m__t33 mn2 261.497453093
* device instance a_b_m_east_m_west_nand_m_a_nand_m_a_ext_via_nand_m_a_ext_via2_nand_m_a_stub_tg_d_b_tg_d_b_via_tg_d_b_via2_tg_fbm_b_tg_fbm_b_alt_via_tg_fbm_b_alt_via2_dup2_t4 r0 *1 0,0
Ra_b_m_east_m_west_nand_m_a_nand_m_a_ext_via_nand_m_a_ext_via2_nand_m_a_stub_tg_d_b_tg_d_b_via_tg_d_b_via2_tg_fbm_b_tg_fbm_b_alt_via_tg_fbm_b_alt_via2_dup2_t4 m__t43 mn2 291.982605261
* device instance a_b_m_east_m_west_nand_m_a_nand_m_a_ext_via_nand_m_a_ext_via2_nand_m_a_stub_tg_d_b_tg_d_b_via_tg_d_b_via2_tg_fbm_b_tg_fbm_b_alt_via_tg_fbm_b_alt_via2_dup2_t5 r0 *1 0,0
Ra_b_m_east_m_west_nand_m_a_nand_m_a_ext_via_nand_m_a_ext_via2_nand_m_a_stub_tg_d_b_tg_d_b_via_tg_d_b_via2_tg_fbm_b_tg_fbm_b_alt_via_tg_fbm_b_alt_via2_dup2_t5 m__t53 mn2 60.1829866055
* device instance a_b_m_east_m_west_nand_m_a_nand_m_a_ext_via_nand_m_a_ext_via2_nand_m_a_stub_tg_d_b_tg_d_b_via_tg_d_b_via2_tg_fbm_b_tg_fbm_b_alt_via_tg_fbm_b_alt_via2_dup2 r0 *1 0,0
Ca_b_m_east_m_west_nand_m_a_nand_m_a_ext_via_nand_m_a_ext_via2_nand_m_a_stub_tg_d_b_tg_d_b_via_tg_d_b_via2_tg_fbm_b_tg_fbm_b_alt_via_tg_fbm_b_alt_via2_dup2 mn2 vsubs 3.895867e-15
* device instance a_b_m_east_m_west_nand_m_a_nand_m_a_ext_via_nand_m_a_ext_via2_nand_m_a_stub_tg_d_b_tg_d_b_via_tg_d_b_via2_tg_fbm_b_tg_fbm_b_alt_via_tg_fbm_b_alt_via2_dup3_t0 r0 *1 0,0
Ra_b_m_east_m_west_nand_m_a_nand_m_a_ext_via_nand_m_a_ext_via2_nand_m_a_stub_tg_d_b_tg_d_b_via_tg_d_b_via2_tg_fbm_b_tg_fbm_b_alt_via_tg_fbm_b_alt_via2_dup3_t0 m__t04 mn3 68.7741894738
* device instance a_b_m_east_m_west_nand_m_a_nand_m_a_ext_via_nand_m_a_ext_via2_nand_m_a_stub_tg_d_b_tg_d_b_via_tg_d_b_via2_tg_fbm_b_tg_fbm_b_alt_via_tg_fbm_b_alt_via2_dup3_t1 r0 *1 0,0
Ra_b_m_east_m_west_nand_m_a_nand_m_a_ext_via_nand_m_a_ext_via2_nand_m_a_stub_tg_d_b_tg_d_b_via_tg_d_b_via2_tg_fbm_b_tg_fbm_b_alt_via_tg_fbm_b_alt_via2_dup3_t1 m__t14 mn3 292.98458946
* device instance a_b_m_east_m_west_nand_m_a_nand_m_a_ext_via_nand_m_a_ext_via2_nand_m_a_stub_tg_d_b_tg_d_b_via_tg_d_b_via2_tg_fbm_b_tg_fbm_b_alt_via_tg_fbm_b_alt_via2_dup3_t2 r0 *1 0,0
Ra_b_m_east_m_west_nand_m_a_nand_m_a_ext_via_nand_m_a_ext_via2_nand_m_a_stub_tg_d_b_tg_d_b_via_tg_d_b_via2_tg_fbm_b_tg_fbm_b_alt_via_tg_fbm_b_alt_via2_dup3_t2 m__t24 mn3 262.615776106
* device instance a_b_m_east_m_west_nand_m_a_nand_m_a_ext_via_nand_m_a_ext_via2_nand_m_a_stub_tg_d_b_tg_d_b_via_tg_d_b_via2_tg_fbm_b_tg_fbm_b_alt_via_tg_fbm_b_alt_via2_dup3_t3 r0 *1 0,0
Ra_b_m_east_m_west_nand_m_a_nand_m_a_ext_via_nand_m_a_ext_via2_nand_m_a_stub_tg_d_b_tg_d_b_via_tg_d_b_via2_tg_fbm_b_tg_fbm_b_alt_via_tg_fbm_b_alt_via2_dup3_t3 m__t34 mn3 261.497453093
* device instance a_b_m_east_m_west_nand_m_a_nand_m_a_ext_via_nand_m_a_ext_via2_nand_m_a_stub_tg_d_b_tg_d_b_via_tg_d_b_via2_tg_fbm_b_tg_fbm_b_alt_via_tg_fbm_b_alt_via2_dup3_t4 r0 *1 0,0
Ra_b_m_east_m_west_nand_m_a_nand_m_a_ext_via_nand_m_a_ext_via2_nand_m_a_stub_tg_d_b_tg_d_b_via_tg_d_b_via2_tg_fbm_b_tg_fbm_b_alt_via_tg_fbm_b_alt_via2_dup3_t4 m__t44 mn3 291.982605261
* device instance a_b_m_east_m_west_nand_m_a_nand_m_a_ext_via_nand_m_a_ext_via2_nand_m_a_stub_tg_d_b_tg_d_b_via_tg_d_b_via2_tg_fbm_b_tg_fbm_b_alt_via_tg_fbm_b_alt_via2_dup3_t5 r0 *1 0,0
Ra_b_m_east_m_west_nand_m_a_nand_m_a_ext_via_nand_m_a_ext_via2_nand_m_a_stub_tg_d_b_tg_d_b_via_tg_d_b_via2_tg_fbm_b_tg_fbm_b_alt_via_tg_fbm_b_alt_via2_dup3_t5 m__t54 mn3 60.1829866055
* device instance a_b_m_east_m_west_nand_m_a_nand_m_a_ext_via_nand_m_a_ext_via2_nand_m_a_stub_tg_d_b_tg_d_b_via_tg_d_b_via2_tg_fbm_b_tg_fbm_b_alt_via_tg_fbm_b_alt_via2_dup3 r0 *1 0,0
Ca_b_m_east_m_west_nand_m_a_nand_m_a_ext_via_nand_m_a_ext_via2_nand_m_a_stub_tg_d_b_tg_d_b_via_tg_d_b_via2_tg_fbm_b_tg_fbm_b_alt_via_tg_fbm_b_alt_via2_dup3 mn3 vsubs 3.895867e-15
* device instance a_b_m_east_m_west_nand_m_a_nand_m_a_ext_via_nand_m_a_ext_via2_nand_m_a_stub_tg_d_b_tg_d_b_via_tg_d_b_via2_tg_fbm_b_tg_fbm_b_alt_via_tg_fbm_b_alt_via2_dup4_t0 r0 *1 0,0
Ra_b_m_east_m_west_nand_m_a_nand_m_a_ext_via_nand_m_a_ext_via2_nand_m_a_stub_tg_d_b_tg_d_b_via_tg_d_b_via2_tg_fbm_b_tg_fbm_b_alt_via_tg_fbm_b_alt_via2_dup4_t0 m__t05 mn4 68.7741894738
* device instance a_b_m_east_m_west_nand_m_a_nand_m_a_ext_via_nand_m_a_ext_via2_nand_m_a_stub_tg_d_b_tg_d_b_via_tg_d_b_via2_tg_fbm_b_tg_fbm_b_alt_via_tg_fbm_b_alt_via2_dup4_t1 r0 *1 0,0
Ra_b_m_east_m_west_nand_m_a_nand_m_a_ext_via_nand_m_a_ext_via2_nand_m_a_stub_tg_d_b_tg_d_b_via_tg_d_b_via2_tg_fbm_b_tg_fbm_b_alt_via_tg_fbm_b_alt_via2_dup4_t1 m__t15 mn4 292.98458946
* device instance a_b_m_east_m_west_nand_m_a_nand_m_a_ext_via_nand_m_a_ext_via2_nand_m_a_stub_tg_d_b_tg_d_b_via_tg_d_b_via2_tg_fbm_b_tg_fbm_b_alt_via_tg_fbm_b_alt_via2_dup4_t2 r0 *1 0,0
Ra_b_m_east_m_west_nand_m_a_nand_m_a_ext_via_nand_m_a_ext_via2_nand_m_a_stub_tg_d_b_tg_d_b_via_tg_d_b_via2_tg_fbm_b_tg_fbm_b_alt_via_tg_fbm_b_alt_via2_dup4_t2 m__t25 mn4 262.615776106
* device instance a_b_m_east_m_west_nand_m_a_nand_m_a_ext_via_nand_m_a_ext_via2_nand_m_a_stub_tg_d_b_tg_d_b_via_tg_d_b_via2_tg_fbm_b_tg_fbm_b_alt_via_tg_fbm_b_alt_via2_dup4_t3 r0 *1 0,0
Ra_b_m_east_m_west_nand_m_a_nand_m_a_ext_via_nand_m_a_ext_via2_nand_m_a_stub_tg_d_b_tg_d_b_via_tg_d_b_via2_tg_fbm_b_tg_fbm_b_alt_via_tg_fbm_b_alt_via2_dup4_t3 m__t35 mn4 291.982605261
* device instance a_b_m_east_m_west_nand_m_a_nand_m_a_ext_via_nand_m_a_ext_via2_nand_m_a_stub_tg_d_b_tg_d_b_via_tg_d_b_via2_tg_fbm_b_tg_fbm_b_alt_via_tg_fbm_b_alt_via2_dup4_t4 r0 *1 0,0
Ra_b_m_east_m_west_nand_m_a_nand_m_a_ext_via_nand_m_a_ext_via2_nand_m_a_stub_tg_d_b_tg_d_b_via_tg_d_b_via2_tg_fbm_b_tg_fbm_b_alt_via_tg_fbm_b_alt_via2_dup4_t4 m__t45 mn4 261.497453093
* device instance a_b_m_east_m_west_nand_m_a_nand_m_a_ext_via_nand_m_a_ext_via2_nand_m_a_stub_tg_d_b_tg_d_b_via_tg_d_b_via2_tg_fbm_b_tg_fbm_b_alt_via_tg_fbm_b_alt_via2_dup4_t5 r0 *1 0,0
Ra_b_m_east_m_west_nand_m_a_nand_m_a_ext_via_nand_m_a_ext_via2_nand_m_a_stub_tg_d_b_tg_d_b_via_tg_d_b_via2_tg_fbm_b_tg_fbm_b_alt_via_tg_fbm_b_alt_via2_dup4_t5 m__t55 mn4 60.1829866055
* device instance a_b_m_east_m_west_nand_m_a_nand_m_a_ext_via_nand_m_a_ext_via2_nand_m_a_stub_tg_d_b_tg_d_b_via_tg_d_b_via2_tg_fbm_b_tg_fbm_b_alt_via_tg_fbm_b_alt_via2_dup4 r0 *1 0,0
Ca_b_m_east_m_west_nand_m_a_nand_m_a_ext_via_nand_m_a_ext_via2_nand_m_a_stub_tg_d_b_tg_d_b_via_tg_d_b_via2_tg_fbm_b_tg_fbm_b_alt_via_tg_fbm_b_alt_via2_dup4 mn4 vsubs 3.895867e-15
* device instance a_b_m_east_m_west_nand_m_a_nand_m_a_ext_via_nand_m_a_ext_via2_nand_m_a_stub_tg_d_b_tg_d_b_via_tg_d_b_via2_tg_fbm_b_tg_fbm_b_alt_via_tg_fbm_b_alt_via2_dup5_t0 r0 *1 0,0
Ra_b_m_east_m_west_nand_m_a_nand_m_a_ext_via_nand_m_a_ext_via2_nand_m_a_stub_tg_d_b_tg_d_b_via_tg_d_b_via2_tg_fbm_b_tg_fbm_b_alt_via_tg_fbm_b_alt_via2_dup5_t0 m__t06 mn5 68.7741894738
* device instance a_b_m_east_m_west_nand_m_a_nand_m_a_ext_via_nand_m_a_ext_via2_nand_m_a_stub_tg_d_b_tg_d_b_via_tg_d_b_via2_tg_fbm_b_tg_fbm_b_alt_via_tg_fbm_b_alt_via2_dup5_t1 r0 *1 0,0
Ra_b_m_east_m_west_nand_m_a_nand_m_a_ext_via_nand_m_a_ext_via2_nand_m_a_stub_tg_d_b_tg_d_b_via_tg_d_b_via2_tg_fbm_b_tg_fbm_b_alt_via_tg_fbm_b_alt_via2_dup5_t1 m__t16 mn5 262.615776106
* device instance a_b_m_east_m_west_nand_m_a_nand_m_a_ext_via_nand_m_a_ext_via2_nand_m_a_stub_tg_d_b_tg_d_b_via_tg_d_b_via2_tg_fbm_b_tg_fbm_b_alt_via_tg_fbm_b_alt_via2_dup5_t2 r0 *1 0,0
Ra_b_m_east_m_west_nand_m_a_nand_m_a_ext_via_nand_m_a_ext_via2_nand_m_a_stub_tg_d_b_tg_d_b_via_tg_d_b_via2_tg_fbm_b_tg_fbm_b_alt_via_tg_fbm_b_alt_via2_dup5_t2 m__t26 mn5 292.98458946
* device instance a_b_m_east_m_west_nand_m_a_nand_m_a_ext_via_nand_m_a_ext_via2_nand_m_a_stub_tg_d_b_tg_d_b_via_tg_d_b_via2_tg_fbm_b_tg_fbm_b_alt_via_tg_fbm_b_alt_via2_dup5_t3 r0 *1 0,0
Ra_b_m_east_m_west_nand_m_a_nand_m_a_ext_via_nand_m_a_ext_via2_nand_m_a_stub_tg_d_b_tg_d_b_via_tg_d_b_via2_tg_fbm_b_tg_fbm_b_alt_via_tg_fbm_b_alt_via2_dup5_t3 m__t36 mn5 291.982605261
* device instance a_b_m_east_m_west_nand_m_a_nand_m_a_ext_via_nand_m_a_ext_via2_nand_m_a_stub_tg_d_b_tg_d_b_via_tg_d_b_via2_tg_fbm_b_tg_fbm_b_alt_via_tg_fbm_b_alt_via2_dup5_t4 r0 *1 0,0
Ra_b_m_east_m_west_nand_m_a_nand_m_a_ext_via_nand_m_a_ext_via2_nand_m_a_stub_tg_d_b_tg_d_b_via_tg_d_b_via2_tg_fbm_b_tg_fbm_b_alt_via_tg_fbm_b_alt_via2_dup5_t4 m__t46 mn5 261.497453093
* device instance a_b_m_east_m_west_nand_m_a_nand_m_a_ext_via_nand_m_a_ext_via2_nand_m_a_stub_tg_d_b_tg_d_b_via_tg_d_b_via2_tg_fbm_b_tg_fbm_b_alt_via_tg_fbm_b_alt_via2_dup5_t5 r0 *1 0,0
Ra_b_m_east_m_west_nand_m_a_nand_m_a_ext_via_nand_m_a_ext_via2_nand_m_a_stub_tg_d_b_tg_d_b_via_tg_d_b_via2_tg_fbm_b_tg_fbm_b_alt_via_tg_fbm_b_alt_via2_dup5_t5 m__t56 mn5 60.1829866055
* device instance a_b_m_east_m_west_nand_m_a_nand_m_a_ext_via_nand_m_a_ext_via2_nand_m_a_stub_tg_d_b_tg_d_b_via_tg_d_b_via2_tg_fbm_b_tg_fbm_b_alt_via_tg_fbm_b_alt_via2_dup5 r0 *1 0,0
Ca_b_m_east_m_west_nand_m_a_nand_m_a_ext_via_nand_m_a_ext_via2_nand_m_a_stub_tg_d_b_tg_d_b_via_tg_d_b_via2_tg_fbm_b_tg_fbm_b_alt_via_tg_fbm_b_alt_via2_dup5 mn5 vsubs 3.895867e-15
* device instance a_clk_ctrl_ctrlb_inv_clk_a_inv_clk_clk_via_tg_d_ctrl_tg_d_ctrl_via_tg_fbm_ctrlb_tg_fbm_ctrlb_via_tg_fbs_ctrl_tg_fbs_ctrl_via_tg_s_ctrlb_tg_s_ctrlb_via_t0 r0 *1 0,0
Ra_clk_ctrl_ctrlb_inv_clk_a_inv_clk_clk_via_tg_d_ctrl_tg_d_ctrl_via_tg_fbm_ctrlb_tg_fbm_ctrlb_via_tg_fbs_ctrl_tg_fbs_ctrl_via_tg_s_ctrlb_tg_s_ctrlb_via_t0 clk__t0 clk 388.751018027
* device instance a_clk_ctrl_ctrlb_inv_clk_a_inv_clk_clk_via_tg_d_ctrl_tg_d_ctrl_via_tg_fbm_ctrlb_tg_fbm_ctrlb_via_tg_fbs_ctrl_tg_fbs_ctrl_via_tg_s_ctrlb_tg_s_ctrlb_via_t1 r0 *1 0,0
Ra_clk_ctrl_ctrlb_inv_clk_a_inv_clk_clk_via_tg_d_ctrl_tg_d_ctrl_via_tg_fbm_ctrlb_tg_fbm_ctrlb_via_tg_fbs_ctrl_tg_fbs_ctrl_via_tg_s_ctrlb_tg_s_ctrlb_via_t1 clk__t1 clk 388.751018027
* device instance a_clk_ctrl_ctrlb_inv_clk_a_inv_clk_clk_via_tg_d_ctrl_tg_d_ctrl_via_tg_fbm_ctrlb_tg_fbm_ctrlb_via_tg_fbs_ctrl_tg_fbs_ctrl_via_tg_s_ctrlb_tg_s_ctrlb_via_t2 r0 *1 0,0
Ra_clk_ctrl_ctrlb_inv_clk_a_inv_clk_clk_via_tg_d_ctrl_tg_d_ctrl_via_tg_fbm_ctrlb_tg_fbm_ctrlb_via_tg_fbs_ctrl_tg_fbs_ctrl_via_tg_s_ctrlb_tg_s_ctrlb_via_t2 clk__t2 clk 283.029245649
* device instance a_clk_ctrl_ctrlb_inv_clk_a_inv_clk_clk_via_tg_d_ctrl_tg_d_ctrl_via_tg_fbm_ctrlb_tg_fbm_ctrlb_via_tg_fbs_ctrl_tg_fbs_ctrl_via_tg_s_ctrlb_tg_s_ctrlb_via_t3 r0 *1 0,0
Ra_clk_ctrl_ctrlb_inv_clk_a_inv_clk_clk_via_tg_d_ctrl_tg_d_ctrl_via_tg_fbm_ctrlb_tg_fbm_ctrlb_via_tg_fbs_ctrl_tg_fbs_ctrl_via_tg_s_ctrlb_tg_s_ctrlb_via_t3 clk__t3 clk 300.803977152
* device instance a_clk_ctrl_ctrlb_inv_clk_a_inv_clk_clk_via_tg_d_ctrl_tg_d_ctrl_via_tg_fbm_ctrlb_tg_fbm_ctrlb_via_tg_fbs_ctrl_tg_fbs_ctrl_via_tg_s_ctrlb_tg_s_ctrlb_via_t4 r0 *1 0,0
Ra_clk_ctrl_ctrlb_inv_clk_a_inv_clk_clk_via_tg_d_ctrl_tg_d_ctrl_via_tg_fbm_ctrlb_tg_fbm_ctrlb_via_tg_fbs_ctrl_tg_fbs_ctrl_via_tg_s_ctrlb_tg_s_ctrlb_via_t4 clk__t4 clk 312.6084917
* device instance a_clk_ctrl_ctrlb_inv_clk_a_inv_clk_clk_via_tg_d_ctrl_tg_d_ctrl_via_tg_fbm_ctrlb_tg_fbm_ctrlb_via_tg_fbs_ctrl_tg_fbs_ctrl_via_tg_s_ctrlb_tg_s_ctrlb_via_t5 r0 *1 0,0
Ra_clk_ctrl_ctrlb_inv_clk_a_inv_clk_clk_via_tg_d_ctrl_tg_d_ctrl_via_tg_fbm_ctrlb_tg_fbm_ctrlb_via_tg_fbs_ctrl_tg_fbs_ctrl_via_tg_s_ctrlb_tg_s_ctrlb_via_t5 clk__t5 clk 420.920479953
* device instance a_clk_ctrl_ctrlb_inv_clk_a_inv_clk_clk_via_tg_d_ctrl_tg_d_ctrl_via_tg_fbm_ctrlb_tg_fbm_ctrlb_via_tg_fbs_ctrl_tg_fbs_ctrl_via_tg_s_ctrlb_tg_s_ctrlb_via_t6 r0 *1 0,0
Ra_clk_ctrl_ctrlb_inv_clk_a_inv_clk_clk_via_tg_d_ctrl_tg_d_ctrl_via_tg_fbm_ctrlb_tg_fbm_ctrlb_via_tg_fbs_ctrl_tg_fbs_ctrl_via_tg_s_ctrlb_tg_s_ctrlb_via_t6 clk__t6 clk 101.205237893
* device instance a_clk_ctrl_ctrlb_inv_clk_a_inv_clk_clk_via_tg_d_ctrl_tg_d_ctrl_via_tg_fbm_ctrlb_tg_fbm_ctrlb_via_tg_fbs_ctrl_tg_fbs_ctrl_via_tg_s_ctrlb_tg_s_ctrlb_via_t7 r0 *1 0,0
Ra_clk_ctrl_ctrlb_inv_clk_a_inv_clk_clk_via_tg_d_ctrl_tg_d_ctrl_via_tg_fbm_ctrlb_tg_fbm_ctrlb_via_tg_fbs_ctrl_tg_fbs_ctrl_via_tg_s_ctrlb_tg_s_ctrlb_via_t7 clk__t7 clk 376.946123016
* device instance a_clk_ctrl_ctrlb_inv_clk_a_inv_clk_clk_via_tg_d_ctrl_tg_d_ctrl_via_tg_fbm_ctrlb_tg_fbm_ctrlb_via_tg_fbs_ctrl_tg_fbs_ctrl_via_tg_s_ctrlb_tg_s_ctrlb_via_t8 r0 *1 0,0
Ra_clk_ctrl_ctrlb_inv_clk_a_inv_clk_clk_via_tg_d_ctrl_tg_d_ctrl_via_tg_fbm_ctrlb_tg_fbm_ctrlb_via_tg_fbs_ctrl_tg_fbs_ctrl_via_tg_s_ctrlb_tg_s_ctrlb_via_t8 clk__t8 clk 268.636219679
* device instance a_clk_ctrl_ctrlb_inv_clk_a_inv_clk_clk_via_tg_d_ctrl_tg_d_ctrl_via_tg_fbm_ctrlb_tg_fbm_ctrlb_via_tg_fbs_ctrl_tg_fbs_ctrl_via_tg_s_ctrlb_tg_s_ctrlb_via_t9 r0 *1 0,0
Ra_clk_ctrl_ctrlb_inv_clk_a_inv_clk_clk_via_tg_d_ctrl_tg_d_ctrl_via_tg_fbm_ctrlb_tg_fbm_ctrlb_via_tg_fbs_ctrl_tg_fbs_ctrl_via_tg_s_ctrlb_tg_s_ctrlb_via_t9 clk__t9 clk 113.002080638
* device instance a_clk_ctrl_ctrlb_inv_clk_a_inv_clk_clk_via_tg_d_ctrl_tg_d_ctrl_via_tg_fbm_ctrlb_tg_fbm_ctrlb_via_tg_fbs_ctrl_tg_fbs_ctrl_via_tg_s_ctrlb_tg_s_ctrlb_via_t10 r0 *1 0,0
Ra_clk_ctrl_ctrlb_inv_clk_a_inv_clk_clk_via_tg_d_ctrl_tg_d_ctrl_via_tg_fbm_ctrlb_tg_fbm_ctrlb_via_tg_fbs_ctrl_tg_fbs_ctrl_via_tg_s_ctrlb_tg_s_ctrlb_via_t10 clk__t10 clk 250.861953236
* device instance a_clk_ctrl_ctrlb_inv_clk_a_inv_clk_clk_via_tg_d_ctrl_tg_d_ctrl_via_tg_fbm_ctrlb_tg_fbm_ctrlb_via_tg_fbs_ctrl_tg_fbs_ctrl_via_tg_s_ctrlb_tg_s_ctrlb_via_t11 r0 *1 0,0
Ra_clk_ctrl_ctrlb_inv_clk_a_inv_clk_clk_via_tg_d_ctrl_tg_d_ctrl_via_tg_fbm_ctrlb_tg_fbm_ctrlb_via_tg_fbs_ctrl_tg_fbs_ctrl_via_tg_s_ctrlb_tg_s_ctrlb_via_t11 clk__t11 clk 239.058041854
* device instance a_clk_ctrl_ctrlb_inv_clk_a_inv_clk_clk_via_tg_d_ctrl_tg_d_ctrl_via_tg_fbm_ctrlb_tg_fbm_ctrlb_via_tg_fbs_ctrl_tg_fbs_ctrl_via_tg_s_ctrlb_tg_s_ctrlb_via_t12 r0 *1 0,0
Ra_clk_ctrl_ctrlb_inv_clk_a_inv_clk_clk_via_tg_d_ctrl_tg_d_ctrl_via_tg_fbm_ctrlb_tg_fbm_ctrlb_via_tg_fbs_ctrl_tg_fbs_ctrl_via_tg_s_ctrlb_tg_s_ctrlb_via_t12 clk__t12 clk 130.768401154
* device instance a_clk_ctrl_ctrlb_inv_clk_a_inv_clk_clk_via_tg_d_ctrl_tg_d_ctrl_via_tg_fbm_ctrlb_tg_fbm_ctrlb_via_tg_fbs_ctrl_tg_fbs_ctrl_via_tg_s_ctrlb_tg_s_ctrlb_via_t13 r0 *1 0,0
Ra_clk_ctrl_ctrlb_inv_clk_a_inv_clk_clk_via_tg_d_ctrl_tg_d_ctrl_via_tg_fbm_ctrlb_tg_fbm_ctrlb_via_tg_fbs_ctrl_tg_fbs_ctrl_via_tg_s_ctrlb_tg_s_ctrlb_via_t13 clk__t13 clk 174.728821408
* device instance a_clk_ctrl_ctrlb_inv_clk_a_inv_clk_clk_via_tg_d_ctrl_tg_d_ctrl_via_tg_fbm_ctrlb_tg_fbm_ctrlb_via_tg_fbs_ctrl_tg_fbs_ctrl_via_tg_s_ctrlb_tg_s_ctrlb_via_t14 r0 *1 0,0
Ra_clk_ctrl_ctrlb_inv_clk_a_inv_clk_clk_via_tg_d_ctrl_tg_d_ctrl_via_tg_fbm_ctrlb_tg_fbm_ctrlb_via_tg_fbs_ctrl_tg_fbs_ctrl_via_tg_s_ctrlb_tg_s_ctrlb_via_t14 clk__t14 clk 162.926752786
* device instance a_clk_ctrl_ctrlb_inv_clk_a_inv_clk_clk_via_tg_d_ctrl_tg_d_ctrl_via_tg_fbm_ctrlb_tg_fbm_ctrlb_via_tg_fbs_ctrl_tg_fbs_ctrl_via_tg_s_ctrlb_tg_s_ctrlb_via_t15 r0 *1 0,0
Ra_clk_ctrl_ctrlb_inv_clk_a_inv_clk_clk_via_tg_d_ctrl_tg_d_ctrl_via_tg_fbm_ctrlb_tg_fbm_ctrlb_via_tg_fbs_ctrl_tg_fbs_ctrl_via_tg_s_ctrlb_tg_s_ctrlb_via_t15 clk__t15 clk 145.15661344
* device instance a_clk_ctrl_ctrlb_inv_clk_a_inv_clk_clk_via_tg_d_ctrl_tg_d_ctrl_via_tg_fbm_ctrlb_tg_fbm_ctrlb_via_tg_fbs_ctrl_tg_fbs_ctrl_via_tg_s_ctrlb_tg_s_ctrlb_via_t16 r0 *1 0,0
Ra_clk_ctrl_ctrlb_inv_clk_a_inv_clk_clk_via_tg_d_ctrl_tg_d_ctrl_via_tg_fbm_ctrlb_tg_fbm_ctrlb_via_tg_fbs_ctrl_tg_fbs_ctrl_via_tg_s_ctrlb_tg_s_ctrlb_via_t16 clk__t16 clk 8.28951392668
* device instance a_clk_ctrl_ctrlb_inv_clk_a_inv_clk_clk_via_tg_d_ctrl_tg_d_ctrl_via_tg_fbm_ctrlb_tg_fbm_ctrlb_via_tg_fbs_ctrl_tg_fbs_ctrl_via_tg_s_ctrlb_tg_s_ctrlb_via_t17 r0 *1 0,0
Ra_clk_ctrl_ctrlb_inv_clk_a_inv_clk_clk_via_tg_d_ctrl_tg_d_ctrl_via_tg_fbm_ctrlb_tg_fbm_ctrlb_via_tg_fbs_ctrl_tg_fbs_ctrl_via_tg_s_ctrlb_tg_s_ctrlb_via_t17 clk__t17 clk 25.3101947672
* device instance a_clk_ctrl_ctrlb_inv_clk_a_inv_clk_clk_via_tg_d_ctrl_tg_d_ctrl_via_tg_fbm_ctrlb_tg_fbm_ctrlb_via_tg_fbs_ctrl_tg_fbs_ctrl_via_tg_s_ctrlb_tg_s_ctrlb_via_t18 r0 *1 0,0
Ra_clk_ctrl_ctrlb_inv_clk_a_inv_clk_clk_via_tg_d_ctrl_tg_d_ctrl_via_tg_fbm_ctrlb_tg_fbm_ctrlb_via_tg_fbs_ctrl_tg_fbs_ctrl_via_tg_s_ctrlb_tg_s_ctrlb_via_t18 clk__t18 clk 37.0086214567
* device instance a_clk_ctrl_ctrlb_inv_clk_a_inv_clk_clk_via_tg_d_ctrl_tg_d_ctrl_via_tg_fbm_ctrlb_tg_fbm_ctrlb_via_tg_fbs_ctrl_tg_fbs_ctrl_via_tg_s_ctrlb_tg_s_ctrlb_via_t19 r0 *1 0,0
Ra_clk_ctrl_ctrlb_inv_clk_a_inv_clk_clk_via_tg_d_ctrl_tg_d_ctrl_via_tg_fbm_ctrlb_tg_fbm_ctrlb_via_tg_fbs_ctrl_tg_fbs_ctrl_via_tg_s_ctrlb_tg_s_ctrlb_via_t19 clk__t19 clk 222.51056845
* device instance a_clk_ctrl_ctrlb_inv_clk_a_inv_clk_clk_via_tg_d_ctrl_tg_d_ctrl_via_tg_fbm_ctrlb_tg_fbm_ctrlb_via_tg_fbs_ctrl_tg_fbs_ctrl_via_tg_s_ctrlb_tg_s_ctrlb_via_t20 r0 *1 0,0
Ra_clk_ctrl_ctrlb_inv_clk_a_inv_clk_clk_via_tg_d_ctrl_tg_d_ctrl_via_tg_fbm_ctrlb_tg_fbm_ctrlb_via_tg_fbs_ctrl_tg_fbs_ctrl_via_tg_s_ctrlb_tg_s_ctrlb_via_t20 clk__t20 clk 162.926752786
* device instance a_clk_ctrl_ctrlb_inv_clk_a_inv_clk_clk_via_tg_d_ctrl_tg_d_ctrl_via_tg_fbm_ctrlb_tg_fbm_ctrlb_via_tg_fbs_ctrl_tg_fbs_ctrl_via_tg_s_ctrlb_tg_s_ctrlb_via_t21 r0 *1 0,0
Ra_clk_ctrl_ctrlb_inv_clk_a_inv_clk_clk_via_tg_d_ctrl_tg_d_ctrl_via_tg_fbm_ctrlb_tg_fbm_ctrlb_via_tg_fbs_ctrl_tg_fbs_ctrl_via_tg_s_ctrlb_tg_s_ctrlb_via_t21 clk__t21 clk 97.3930697106
* device instance a_clk_ctrl_ctrlb_inv_clk_a_inv_clk_clk_via_tg_d_ctrl_tg_d_ctrl_via_tg_fbm_ctrlb_tg_fbm_ctrlb_via_tg_fbs_ctrl_tg_fbs_ctrl_via_tg_s_ctrlb_tg_s_ctrlb_via_t22 r0 *1 0,0
Ra_clk_ctrl_ctrlb_inv_clk_a_inv_clk_clk_via_tg_d_ctrl_tg_d_ctrl_via_tg_fbm_ctrlb_tg_fbm_ctrlb_via_tg_fbs_ctrl_tg_fbs_ctrl_via_tg_s_ctrlb_tg_s_ctrlb_via_t22 clk__t22 clk 84.6714753446
* device instance a_clk_ctrl_ctrlb_inv_clk_a_inv_clk_clk_via_tg_d_ctrl_tg_d_ctrl_via_tg_fbm_ctrlb_tg_fbm_ctrlb_via_tg_fbs_ctrl_tg_fbs_ctrl_via_tg_s_ctrlb_tg_s_ctrlb_via_t23 r0 *1 0,0
Ra_clk_ctrl_ctrlb_inv_clk_a_inv_clk_clk_via_tg_d_ctrl_tg_d_ctrl_via_tg_fbm_ctrlb_tg_fbm_ctrlb_via_tg_fbs_ctrl_tg_fbs_ctrl_via_tg_s_ctrlb_tg_s_ctrlb_via_t23 clk__t23 clk 25.3101947672
* device instance a_clk_ctrl_ctrlb_inv_clk_a_inv_clk_clk_via_tg_d_ctrl_tg_d_ctrl_via_tg_fbm_ctrlb_tg_fbm_ctrlb_via_tg_fbs_ctrl_tg_fbs_ctrl_via_tg_s_ctrlb_tg_s_ctrlb_via_t24 r0 *1 0,0
Ra_clk_ctrl_ctrlb_inv_clk_a_inv_clk_clk_via_tg_d_ctrl_tg_d_ctrl_via_tg_fbm_ctrlb_tg_fbm_ctrlb_via_tg_fbs_ctrl_tg_fbs_ctrl_via_tg_s_ctrlb_tg_s_ctrlb_via_t24 clk__t24 clk 235.243172332
* device instance a_clk_ctrl_ctrlb_inv_clk_a_inv_clk_clk_via_tg_d_ctrl_tg_d_ctrl_via_tg_fbm_ctrlb_tg_fbm_ctrlb_via_tg_fbs_ctrl_tg_fbs_ctrl_via_tg_s_ctrlb_tg_s_ctrlb_via_t25 r0 *1 0,0
Ra_clk_ctrl_ctrlb_inv_clk_a_inv_clk_clk_via_tg_d_ctrl_tg_d_ctrl_via_tg_fbm_ctrlb_tg_fbm_ctrlb_via_tg_fbs_ctrl_tg_fbs_ctrl_via_tg_s_ctrlb_tg_s_ctrlb_via_t25 clk__t25 clk 300.803977152
* device instance a_clk_ctrl_ctrlb_inv_clk_a_inv_clk_clk_via_tg_d_ctrl_tg_d_ctrl_via_tg_fbm_ctrlb_tg_fbm_ctrlb_via_tg_fbs_ctrl_tg_fbs_ctrl_via_tg_s_ctrlb_tg_s_ctrlb_via_t26 r0 *1 0,0
Ra_clk_ctrl_ctrlb_inv_clk_a_inv_clk_clk_via_tg_d_ctrl_tg_d_ctrl_via_tg_fbm_ctrlb_tg_fbm_ctrlb_via_tg_fbs_ctrl_tg_fbs_ctrl_via_tg_s_ctrlb_tg_s_ctrlb_via_t26 clk__t26 clk 360.397048393
* device instance a_clk_ctrl_ctrlb_inv_clk_a_inv_clk_clk_via_tg_d_ctrl_tg_d_ctrl_via_tg_fbm_ctrlb_tg_fbm_ctrlb_via_tg_fbs_ctrl_tg_fbs_ctrl_via_tg_s_ctrlb_tg_s_ctrlb_via_t27 r0 *1 0,0
Ra_clk_ctrl_ctrlb_inv_clk_a_inv_clk_clk_via_tg_d_ctrl_tg_d_ctrl_via_tg_fbm_ctrlb_tg_fbm_ctrlb_via_tg_fbs_ctrl_tg_fbs_ctrl_via_tg_s_ctrlb_tg_s_ctrlb_via_t27 clk__t27 clk 373.130909083
* device instance a_clk_ctrl_ctrlb_inv_clk_a_inv_clk_clk_via_tg_d_ctrl_tg_d_ctrl_via_tg_fbm_ctrlb_tg_fbm_ctrlb_via_tg_fbs_ctrl_tg_fbs_ctrl_via_tg_s_ctrlb_tg_s_ctrlb_via_t28 r0 *1 0,0
Ra_clk_ctrl_ctrlb_inv_clk_a_inv_clk_clk_via_tg_d_ctrl_tg_d_ctrl_via_tg_fbm_ctrlb_tg_fbm_ctrlb_via_tg_fbs_ctrl_tg_fbs_ctrl_via_tg_s_ctrlb_tg_s_ctrlb_via_t28 clk__t28 clk 329.157236336
* device instance a_clk_ctrl_ctrlb_inv_clk_a_inv_clk_clk_via_tg_d_ctrl_tg_d_ctrl_via_tg_fbm_ctrlb_tg_fbm_ctrlb_via_tg_fbs_ctrl_tg_fbs_ctrl_via_tg_s_ctrlb_tg_s_ctrlb_via_t29 r0 *1 0,0
Ra_clk_ctrl_ctrlb_inv_clk_a_inv_clk_clk_via_tg_d_ctrl_tg_d_ctrl_via_tg_fbm_ctrlb_tg_fbm_ctrlb_via_tg_fbs_ctrl_tg_fbs_ctrl_via_tg_s_ctrlb_tg_s_ctrlb_via_t29 clk__t29 clk 316.42360883
* device instance a_clk_ctrl_ctrlb_inv_clk_a_inv_clk_clk_via_tg_d_ctrl_tg_d_ctrl_via_tg_fbm_ctrlb_tg_fbm_ctrlb_via_tg_fbs_ctrl_tg_fbs_ctrl_via_tg_s_ctrlb_tg_s_ctrlb_via_t30 r0 *1 0,0
Ra_clk_ctrl_ctrlb_inv_clk_a_inv_clk_clk_via_tg_d_ctrl_tg_d_ctrl_via_tg_fbm_ctrlb_tg_fbm_ctrlb_via_tg_fbs_ctrl_tg_fbs_ctrl_via_tg_s_ctrlb_tg_s_ctrlb_via_t30 clk__t30 clk 250.861953236
* device instance a_clk_ctrl_ctrlb_inv_clk_a_inv_clk_clk_via_tg_d_ctrl_tg_d_ctrl_via_tg_fbm_ctrlb_tg_fbm_ctrlb_via_tg_fbs_ctrl_tg_fbs_ctrl_via_tg_s_ctrlb_tg_s_ctrlb_via_t31 r0 *1 0,0
Ra_clk_ctrl_ctrlb_inv_clk_a_inv_clk_clk_via_tg_d_ctrl_tg_d_ctrl_via_tg_fbm_ctrlb_tg_fbm_ctrlb_via_tg_fbs_ctrl_tg_fbs_ctrl_via_tg_s_ctrlb_tg_s_ctrlb_via_t31 clk__t31 clk 191.274737791
* device instance a_clk_ctrl_ctrlb_inv_clk_a_inv_clk_clk_via_tg_d_ctrl_tg_d_ctrl_via_tg_fbm_ctrlb_tg_fbm_ctrlb_via_tg_fbs_ctrl_tg_fbs_ctrl_via_tg_s_ctrlb_tg_s_ctrlb_via_t32 r0 *1 0,0
Ra_clk_ctrl_ctrlb_inv_clk_a_inv_clk_clk_via_tg_d_ctrl_tg_d_ctrl_via_tg_fbm_ctrlb_tg_fbm_ctrlb_via_tg_fbs_ctrl_tg_fbs_ctrl_via_tg_s_ctrlb_tg_s_ctrlb_via_t32 clk__t32 clk 40.8026348421
* device instance a_clk_ctrl_ctrlb_inv_clk_a_inv_clk_clk_via_tg_d_ctrl_tg_d_ctrl_via_tg_fbm_ctrlb_tg_fbm_ctrlb_via_tg_fbs_ctrl_tg_fbs_ctrl_via_tg_s_ctrlb_tg_s_ctrlb_via_t33 r0 *1 0,0
Ra_clk_ctrl_ctrlb_inv_clk_a_inv_clk_clk_via_tg_d_ctrl_tg_d_ctrl_via_tg_fbm_ctrlb_tg_fbm_ctrlb_via_tg_fbs_ctrl_tg_fbs_ctrl_via_tg_s_ctrlb_tg_s_ctrlb_via_t33 clk__t33 clk 53.4878442761
* device instance a_clk_ctrl_ctrlb_inv_clk_a_inv_clk_clk_via_tg_d_ctrl_tg_d_ctrl_via_tg_fbm_ctrlb_tg_fbm_ctrlb_via_tg_fbs_ctrl_tg_fbs_ctrl_via_tg_s_ctrlb_tg_s_ctrlb_via_t34 r0 *1 0,0
Ra_clk_ctrl_ctrlb_inv_clk_a_inv_clk_clk_via_tg_d_ctrl_tg_d_ctrl_via_tg_fbm_ctrlb_tg_fbm_ctrlb_via_tg_fbs_ctrl_tg_fbs_ctrl_via_tg_s_ctrlb_tg_s_ctrlb_via_t34 clk__t34 clk 113.002080638
* device instance a_clk_ctrl_ctrlb_inv_clk_a_inv_clk_clk_via_tg_d_ctrl_tg_d_ctrl_via_tg_fbm_ctrlb_tg_fbm_ctrlb_via_tg_fbs_ctrl_tg_fbs_ctrl_via_tg_s_ctrlb_tg_s_ctrlb_via_t35 r0 *1 0,0
Ra_clk_ctrl_ctrlb_inv_clk_a_inv_clk_clk_via_tg_d_ctrl_tg_d_ctrl_via_tg_fbm_ctrlb_tg_fbm_ctrlb_via_tg_fbs_ctrl_tg_fbs_ctrl_via_tg_s_ctrlb_tg_s_ctrlb_via_t35 clk__t35 clk 178.543230272
* device instance a_clk_ctrl_ctrlb_inv_clk_a_inv_clk_clk_via_tg_d_ctrl_tg_d_ctrl_via_tg_fbm_ctrlb_tg_fbm_ctrlb_via_tg_fbs_ctrl_tg_fbs_ctrl_via_tg_s_ctrlb_tg_s_ctrlb_via r0 *1 0,0
Ca_clk_ctrl_ctrlb_inv_clk_a_inv_clk_clk_via_tg_d_ctrl_tg_d_ctrl_via_tg_fbm_ctrlb_tg_fbm_ctrlb_via_tg_fbs_ctrl_tg_fbs_ctrl_via_tg_s_ctrlb_tg_s_ctrlb_via clk vsubs 4.7831927e-14
* device instance a_d_inv_clk_vdd_inv_mc_vdd_inv_q_vdd_mpa_py_mpb_py_nand_m_vdd_nand_s2_vdd_nwell_vdd_sb_vdd_sr1_vdd_sr2_vdd_sr3_vdd_sr4_vdd_sv_d_vdd_tie_sv_vdd_tg_d_a_tg_d_vdd_tg_fbm_vdd_tg_fbs_vdd_tg_s_vdd_vdd_vdd_b1_vdd_b2_vdd_b3_vdd_b4_vdd_link_vdd_link_dip_vdd_x1_vdd_x2_vdd_x3_t0 r0 *1 0,0
Ra_d_inv_clk_vdd_inv_mc_vdd_inv_q_vdd_mpa_py_mpb_py_nand_m_vdd_nand_s2_vdd_nwell_vdd_sb_vdd_sr1_vdd_sr2_vdd_sr3_vdd_sr4_vdd_sv_d_vdd_tie_sv_vdd_tg_d_a_tg_d_vdd_tg_fbm_vdd_tg_fbs_vdd_tg_s_vdd_vdd_vdd_b1_vdd_b2_vdd_b3_vdd_b4_vdd_link_vdd_link_dip_vdd_x1_vdd_x2_vdd_x3_t0 vdd__t0 vdd 199.396312919
* device instance a_d_inv_clk_vdd_inv_mc_vdd_inv_q_vdd_mpa_py_mpb_py_nand_m_vdd_nand_s2_vdd_nwell_vdd_sb_vdd_sr1_vdd_sr2_vdd_sr3_vdd_sr4_vdd_sv_d_vdd_tie_sv_vdd_tg_d_a_tg_d_vdd_tg_fbm_vdd_tg_fbs_vdd_tg_s_vdd_vdd_vdd_b1_vdd_b2_vdd_b3_vdd_b4_vdd_link_vdd_link_dip_vdd_x1_vdd_x2_vdd_x3_t1 r0 *1 0,0
Ra_d_inv_clk_vdd_inv_mc_vdd_inv_q_vdd_mpa_py_mpb_py_nand_m_vdd_nand_s2_vdd_nwell_vdd_sb_vdd_sr1_vdd_sr2_vdd_sr3_vdd_sr4_vdd_sv_d_vdd_tie_sv_vdd_tg_d_a_tg_d_vdd_tg_fbm_vdd_tg_fbs_vdd_tg_s_vdd_vdd_vdd_b1_vdd_b2_vdd_b3_vdd_b4_vdd_link_vdd_link_dip_vdd_x1_vdd_x2_vdd_x3_t1 vdd__t1 vdd 199.396312919
* device instance a_d_inv_clk_vdd_inv_mc_vdd_inv_q_vdd_mpa_py_mpb_py_nand_m_vdd_nand_s2_vdd_nwell_vdd_sb_vdd_sr1_vdd_sr2_vdd_sr3_vdd_sr4_vdd_sv_d_vdd_tie_sv_vdd_tg_d_a_tg_d_vdd_tg_fbm_vdd_tg_fbs_vdd_tg_s_vdd_vdd_vdd_b1_vdd_b2_vdd_b3_vdd_b4_vdd_link_vdd_link_dip_vdd_x1_vdd_x2_vdd_x3_t2 r0 *1 0,0
Ra_d_inv_clk_vdd_inv_mc_vdd_inv_q_vdd_mpa_py_mpb_py_nand_m_vdd_nand_s2_vdd_nwell_vdd_sb_vdd_sr1_vdd_sr2_vdd_sr3_vdd_sr4_vdd_sv_d_vdd_tie_sv_vdd_tg_d_a_tg_d_vdd_tg_fbm_vdd_tg_fbs_vdd_tg_s_vdd_vdd_vdd_b1_vdd_b2_vdd_b3_vdd_b4_vdd_link_vdd_link_dip_vdd_x1_vdd_x2_vdd_x3_t2 vdd__t2 vdd 195.698348688
* device instance a_d_inv_clk_vdd_inv_mc_vdd_inv_q_vdd_mpa_py_mpb_py_nand_m_vdd_nand_s2_vdd_nwell_vdd_sb_vdd_sr1_vdd_sr2_vdd_sr3_vdd_sr4_vdd_sv_d_vdd_tie_sv_vdd_tg_d_a_tg_d_vdd_tg_fbm_vdd_tg_fbs_vdd_tg_s_vdd_vdd_vdd_b1_vdd_b2_vdd_b3_vdd_b4_vdd_link_vdd_link_dip_vdd_x1_vdd_x2_vdd_x3_t3 r0 *1 0,0
Ra_d_inv_clk_vdd_inv_mc_vdd_inv_q_vdd_mpa_py_mpb_py_nand_m_vdd_nand_s2_vdd_nwell_vdd_sb_vdd_sr1_vdd_sr2_vdd_sr3_vdd_sr4_vdd_sv_d_vdd_tie_sv_vdd_tg_d_a_tg_d_vdd_tg_fbm_vdd_tg_fbs_vdd_tg_s_vdd_vdd_vdd_b1_vdd_b2_vdd_b3_vdd_b4_vdd_link_vdd_link_dip_vdd_x1_vdd_x2_vdd_x3_t3 vdd__t3 vdd 195.698348688
* device instance a_d_inv_clk_vdd_inv_mc_vdd_inv_q_vdd_mpa_py_mpb_py_nand_m_vdd_nand_s2_vdd_nwell_vdd_sb_vdd_sr1_vdd_sr2_vdd_sr3_vdd_sr4_vdd_sv_d_vdd_tie_sv_vdd_tg_d_a_tg_d_vdd_tg_fbm_vdd_tg_fbs_vdd_tg_s_vdd_vdd_vdd_b1_vdd_b2_vdd_b3_vdd_b4_vdd_link_vdd_link_dip_vdd_x1_vdd_x2_vdd_x3_t4 r0 *1 0,0
Ra_d_inv_clk_vdd_inv_mc_vdd_inv_q_vdd_mpa_py_mpb_py_nand_m_vdd_nand_s2_vdd_nwell_vdd_sb_vdd_sr1_vdd_sr2_vdd_sr3_vdd_sr4_vdd_sv_d_vdd_tie_sv_vdd_tg_d_a_tg_d_vdd_tg_fbm_vdd_tg_fbs_vdd_tg_s_vdd_vdd_vdd_b1_vdd_b2_vdd_b3_vdd_b4_vdd_link_vdd_link_dip_vdd_x1_vdd_x2_vdd_x3_t4 vdd__t4 vdd 194.749750182
* device instance a_d_inv_clk_vdd_inv_mc_vdd_inv_q_vdd_mpa_py_mpb_py_nand_m_vdd_nand_s2_vdd_nwell_vdd_sb_vdd_sr1_vdd_sr2_vdd_sr3_vdd_sr4_vdd_sv_d_vdd_tie_sv_vdd_tg_d_a_tg_d_vdd_tg_fbm_vdd_tg_fbs_vdd_tg_s_vdd_vdd_vdd_b1_vdd_b2_vdd_b3_vdd_b4_vdd_link_vdd_link_dip_vdd_x1_vdd_x2_vdd_x3_t5 r0 *1 0,0
Ra_d_inv_clk_vdd_inv_mc_vdd_inv_q_vdd_mpa_py_mpb_py_nand_m_vdd_nand_s2_vdd_nwell_vdd_sb_vdd_sr1_vdd_sr2_vdd_sr3_vdd_sr4_vdd_sv_d_vdd_tie_sv_vdd_tg_d_a_tg_d_vdd_tg_fbm_vdd_tg_fbs_vdd_tg_s_vdd_vdd_vdd_b1_vdd_b2_vdd_b3_vdd_b4_vdd_link_vdd_link_dip_vdd_x1_vdd_x2_vdd_x3_t5 vdd__t5 vdd 105.721272036
* device instance a_d_inv_clk_vdd_inv_mc_vdd_inv_q_vdd_mpa_py_mpb_py_nand_m_vdd_nand_s2_vdd_nwell_vdd_sb_vdd_sr1_vdd_sr2_vdd_sr3_vdd_sr4_vdd_sv_d_vdd_tie_sv_vdd_tg_d_a_tg_d_vdd_tg_fbm_vdd_tg_fbs_vdd_tg_s_vdd_vdd_vdd_b1_vdd_b2_vdd_b3_vdd_b4_vdd_link_vdd_link_dip_vdd_x1_vdd_x2_vdd_x3_t6 r0 *1 0,0
Ra_d_inv_clk_vdd_inv_mc_vdd_inv_q_vdd_mpa_py_mpb_py_nand_m_vdd_nand_s2_vdd_nwell_vdd_sb_vdd_sr1_vdd_sr2_vdd_sr3_vdd_sr4_vdd_sv_d_vdd_tie_sv_vdd_tg_d_a_tg_d_vdd_tg_fbm_vdd_tg_fbs_vdd_tg_s_vdd_vdd_vdd_b1_vdd_b2_vdd_b3_vdd_b4_vdd_link_vdd_link_dip_vdd_x1_vdd_x2_vdd_x3_t6 vdd__t6 vdd 144.312798732
* device instance a_d_inv_clk_vdd_inv_mc_vdd_inv_q_vdd_mpa_py_mpb_py_nand_m_vdd_nand_s2_vdd_nwell_vdd_sb_vdd_sr1_vdd_sr2_vdd_sr3_vdd_sr4_vdd_sv_d_vdd_tie_sv_vdd_tg_d_a_tg_d_vdd_tg_fbm_vdd_tg_fbs_vdd_tg_s_vdd_vdd_vdd_b1_vdd_b2_vdd_b3_vdd_b4_vdd_link_vdd_link_dip_vdd_x1_vdd_x2_vdd_x3_t7 r0 *1 0,0
Ra_d_inv_clk_vdd_inv_mc_vdd_inv_q_vdd_mpa_py_mpb_py_nand_m_vdd_nand_s2_vdd_nwell_vdd_sb_vdd_sr1_vdd_sr2_vdd_sr3_vdd_sr4_vdd_sv_d_vdd_tie_sv_vdd_tg_d_a_tg_d_vdd_tg_fbm_vdd_tg_fbs_vdd_tg_s_vdd_vdd_vdd_b1_vdd_b2_vdd_b3_vdd_b4_vdd_link_vdd_link_dip_vdd_x1_vdd_x2_vdd_x3_t7 vdd__t7 vdd 184.649690647
* device instance a_d_inv_clk_vdd_inv_mc_vdd_inv_q_vdd_mpa_py_mpb_py_nand_m_vdd_nand_s2_vdd_nwell_vdd_sb_vdd_sr1_vdd_sr2_vdd_sr3_vdd_sr4_vdd_sv_d_vdd_tie_sv_vdd_tg_d_a_tg_d_vdd_tg_fbm_vdd_tg_fbs_vdd_tg_s_vdd_vdd_vdd_b1_vdd_b2_vdd_b3_vdd_b4_vdd_link_vdd_link_dip_vdd_x1_vdd_x2_vdd_x3_t8 r0 *1 0,0
Ra_d_inv_clk_vdd_inv_mc_vdd_inv_q_vdd_mpa_py_mpb_py_nand_m_vdd_nand_s2_vdd_nwell_vdd_sb_vdd_sr1_vdd_sr2_vdd_sr3_vdd_sr4_vdd_sv_d_vdd_tie_sv_vdd_tg_d_a_tg_d_vdd_tg_fbm_vdd_tg_fbs_vdd_tg_s_vdd_vdd_vdd_b1_vdd_b2_vdd_b3_vdd_b4_vdd_link_vdd_link_dip_vdd_x1_vdd_x2_vdd_x3_t8 vdd__t8 vdd 105.721272036
* device instance a_d_inv_clk_vdd_inv_mc_vdd_inv_q_vdd_mpa_py_mpb_py_nand_m_vdd_nand_s2_vdd_nwell_vdd_sb_vdd_sr1_vdd_sr2_vdd_sr3_vdd_sr4_vdd_sv_d_vdd_tie_sv_vdd_tg_d_a_tg_d_vdd_tg_fbm_vdd_tg_fbs_vdd_tg_s_vdd_vdd_vdd_b1_vdd_b2_vdd_b3_vdd_b4_vdd_link_vdd_link_dip_vdd_x1_vdd_x2_vdd_x3_t9 r0 *1 0,0
Ra_d_inv_clk_vdd_inv_mc_vdd_inv_q_vdd_mpa_py_mpb_py_nand_m_vdd_nand_s2_vdd_nwell_vdd_sb_vdd_sr1_vdd_sr2_vdd_sr3_vdd_sr4_vdd_sv_d_vdd_tie_sv_vdd_tg_d_a_tg_d_vdd_tg_fbm_vdd_tg_fbs_vdd_tg_s_vdd_vdd_vdd_b1_vdd_b2_vdd_b3_vdd_b4_vdd_link_vdd_link_dip_vdd_x1_vdd_x2_vdd_x3_t9 vdd__t9 vdd 114.986947975
* device instance a_d_inv_clk_vdd_inv_mc_vdd_inv_q_vdd_mpa_py_mpb_py_nand_m_vdd_nand_s2_vdd_nwell_vdd_sb_vdd_sr1_vdd_sr2_vdd_sr3_vdd_sr4_vdd_sv_d_vdd_tie_sv_vdd_tg_d_a_tg_d_vdd_tg_fbm_vdd_tg_fbs_vdd_tg_s_vdd_vdd_vdd_b1_vdd_b2_vdd_b3_vdd_b4_vdd_link_vdd_link_dip_vdd_x1_vdd_x2_vdd_x3_t10 r0 *1 0,0
Ra_d_inv_clk_vdd_inv_mc_vdd_inv_q_vdd_mpa_py_mpb_py_nand_m_vdd_nand_s2_vdd_nwell_vdd_sb_vdd_sr1_vdd_sr2_vdd_sr3_vdd_sr4_vdd_sv_d_vdd_tie_sv_vdd_tg_d_a_tg_d_vdd_tg_fbm_vdd_tg_fbs_vdd_tg_s_vdd_vdd_vdd_b1_vdd_b2_vdd_b3_vdd_b4_vdd_link_vdd_link_dip_vdd_x1_vdd_x2_vdd_x3_t10 vdd__t10 vdd 144.312798732
* device instance a_d_inv_clk_vdd_inv_mc_vdd_inv_q_vdd_mpa_py_mpb_py_nand_m_vdd_nand_s2_vdd_nwell_vdd_sb_vdd_sr1_vdd_sr2_vdd_sr3_vdd_sr4_vdd_sv_d_vdd_tie_sv_vdd_tg_d_a_tg_d_vdd_tg_fbm_vdd_tg_fbs_vdd_tg_s_vdd_vdd_vdd_b1_vdd_b2_vdd_b3_vdd_b4_vdd_link_vdd_link_dip_vdd_x1_vdd_x2_vdd_x3_t11 r0 *1 0,0
Ra_d_inv_clk_vdd_inv_mc_vdd_inv_q_vdd_mpa_py_mpb_py_nand_m_vdd_nand_s2_vdd_nwell_vdd_sb_vdd_sr1_vdd_sr2_vdd_sr3_vdd_sr4_vdd_sv_d_vdd_tie_sv_vdd_tg_d_a_tg_d_vdd_tg_fbm_vdd_tg_fbs_vdd_tg_s_vdd_vdd_vdd_b1_vdd_b2_vdd_b3_vdd_b4_vdd_link_vdd_link_dip_vdd_x1_vdd_x2_vdd_x3_t11 vdd__t11 vdd 154.157931258
* device instance a_d_inv_clk_vdd_inv_mc_vdd_inv_q_vdd_mpa_py_mpb_py_nand_m_vdd_nand_s2_vdd_nwell_vdd_sb_vdd_sr1_vdd_sr2_vdd_sr3_vdd_sr4_vdd_sv_d_vdd_tie_sv_vdd_tg_d_a_tg_d_vdd_tg_fbm_vdd_tg_fbs_vdd_tg_s_vdd_vdd_vdd_b1_vdd_b2_vdd_b3_vdd_b4_vdd_link_vdd_link_dip_vdd_x1_vdd_x2_vdd_x3_t12 r0 *1 0,0
Ra_d_inv_clk_vdd_inv_mc_vdd_inv_q_vdd_mpa_py_mpb_py_nand_m_vdd_nand_s2_vdd_nwell_vdd_sb_vdd_sr1_vdd_sr2_vdd_sr3_vdd_sr4_vdd_sv_d_vdd_tie_sv_vdd_tg_d_a_tg_d_vdd_tg_fbm_vdd_tg_fbs_vdd_tg_s_vdd_vdd_vdd_b1_vdd_b2_vdd_b3_vdd_b4_vdd_link_vdd_link_dip_vdd_x1_vdd_x2_vdd_x3_t12 vdd__t12 vdd 184.649690647
* device instance a_d_inv_clk_vdd_inv_mc_vdd_inv_q_vdd_mpa_py_mpb_py_nand_m_vdd_nand_s2_vdd_nwell_vdd_sb_vdd_sr1_vdd_sr2_vdd_sr3_vdd_sr4_vdd_sv_d_vdd_tie_sv_vdd_tg_d_a_tg_d_vdd_tg_fbm_vdd_tg_fbs_vdd_tg_s_vdd_vdd_vdd_b1_vdd_b2_vdd_b3_vdd_b4_vdd_link_vdd_link_dip_vdd_x1_vdd_x2_vdd_x3_t13 r0 *1 0,0
Ra_d_inv_clk_vdd_inv_mc_vdd_inv_q_vdd_mpa_py_mpb_py_nand_m_vdd_nand_s2_vdd_nwell_vdd_sb_vdd_sr1_vdd_sr2_vdd_sr3_vdd_sr4_vdd_sv_d_vdd_tie_sv_vdd_tg_d_a_tg_d_vdd_tg_fbm_vdd_tg_fbs_vdd_tg_s_vdd_vdd_vdd_b1_vdd_b2_vdd_b3_vdd_b4_vdd_link_vdd_link_dip_vdd_x1_vdd_x2_vdd_x3_t13 vdd__t13 vdd 106.579801389
* device instance a_d_inv_clk_vdd_inv_mc_vdd_inv_q_vdd_mpa_py_mpb_py_nand_m_vdd_nand_s2_vdd_nwell_vdd_sb_vdd_sr1_vdd_sr2_vdd_sr3_vdd_sr4_vdd_sv_d_vdd_tie_sv_vdd_tg_d_a_tg_d_vdd_tg_fbm_vdd_tg_fbs_vdd_tg_s_vdd_vdd_vdd_b1_vdd_b2_vdd_b3_vdd_b4_vdd_link_vdd_link_dip_vdd_x1_vdd_x2_vdd_x3_t14 r0 *1 0,0
Ra_d_inv_clk_vdd_inv_mc_vdd_inv_q_vdd_mpa_py_mpb_py_nand_m_vdd_nand_s2_vdd_nwell_vdd_sb_vdd_sr1_vdd_sr2_vdd_sr3_vdd_sr4_vdd_sv_d_vdd_tie_sv_vdd_tg_d_a_tg_d_vdd_tg_fbm_vdd_tg_fbs_vdd_tg_s_vdd_vdd_vdd_b1_vdd_b2_vdd_b3_vdd_b4_vdd_link_vdd_link_dip_vdd_x1_vdd_x2_vdd_x3_t14 vdd__t14 vdd 115.865994115
* device instance a_d_inv_clk_vdd_inv_mc_vdd_inv_q_vdd_mpa_py_mpb_py_nand_m_vdd_nand_s2_vdd_nwell_vdd_sb_vdd_sr1_vdd_sr2_vdd_sr3_vdd_sr4_vdd_sv_d_vdd_tie_sv_vdd_tg_d_a_tg_d_vdd_tg_fbm_vdd_tg_fbs_vdd_tg_s_vdd_vdd_vdd_b1_vdd_b2_vdd_b3_vdd_b4_vdd_link_vdd_link_dip_vdd_x1_vdd_x2_vdd_x3_t15 r0 *1 0,0
Ra_d_inv_clk_vdd_inv_mc_vdd_inv_q_vdd_mpa_py_mpb_py_nand_m_vdd_nand_s2_vdd_nwell_vdd_sb_vdd_sr1_vdd_sr2_vdd_sr3_vdd_sr4_vdd_sv_d_vdd_tie_sv_vdd_tg_d_a_tg_d_vdd_tg_fbm_vdd_tg_fbs_vdd_tg_s_vdd_vdd_vdd_b1_vdd_b2_vdd_b3_vdd_b4_vdd_link_vdd_link_dip_vdd_x1_vdd_x2_vdd_x3_t15 vdd__t15 vdd 145.231451927
* device instance a_d_inv_clk_vdd_inv_mc_vdd_inv_q_vdd_mpa_py_mpb_py_nand_m_vdd_nand_s2_vdd_nwell_vdd_sb_vdd_sr1_vdd_sr2_vdd_sr3_vdd_sr4_vdd_sv_d_vdd_tie_sv_vdd_tg_d_a_tg_d_vdd_tg_fbm_vdd_tg_fbs_vdd_tg_s_vdd_vdd_vdd_b1_vdd_b2_vdd_b3_vdd_b4_vdd_link_vdd_link_dip_vdd_x1_vdd_x2_vdd_x3_t16 r0 *1 0,0
Ra_d_inv_clk_vdd_inv_mc_vdd_inv_q_vdd_mpa_py_mpb_py_nand_m_vdd_nand_s2_vdd_nwell_vdd_sb_vdd_sr1_vdd_sr2_vdd_sr3_vdd_sr4_vdd_sv_d_vdd_tie_sv_vdd_tg_d_a_tg_d_vdd_tg_fbm_vdd_tg_fbs_vdd_tg_s_vdd_vdd_vdd_b1_vdd_b2_vdd_b3_vdd_b4_vdd_link_vdd_link_dip_vdd_x1_vdd_x2_vdd_x3_t16 vdd__t16 vdd 155.084887095
* device instance a_d_inv_clk_vdd_inv_mc_vdd_inv_q_vdd_mpa_py_mpb_py_nand_m_vdd_nand_s2_vdd_nwell_vdd_sb_vdd_sr1_vdd_sr2_vdd_sr3_vdd_sr4_vdd_sv_d_vdd_tie_sv_vdd_tg_d_a_tg_d_vdd_tg_fbm_vdd_tg_fbs_vdd_tg_s_vdd_vdd_vdd_b1_vdd_b2_vdd_b3_vdd_b4_vdd_link_vdd_link_dip_vdd_x1_vdd_x2_vdd_x3_t17 r0 *1 0,0
Ra_d_inv_clk_vdd_inv_mc_vdd_inv_q_vdd_mpa_py_mpb_py_nand_m_vdd_nand_s2_vdd_nwell_vdd_sb_vdd_sr1_vdd_sr2_vdd_sr3_vdd_sr4_vdd_sv_d_vdd_tie_sv_vdd_tg_d_a_tg_d_vdd_tg_fbm_vdd_tg_fbs_vdd_tg_s_vdd_vdd_vdd_b1_vdd_b2_vdd_b3_vdd_b4_vdd_link_vdd_link_dip_vdd_x1_vdd_x2_vdd_x3_t17 vdd__t17 vdd 185.594243054
* device instance a_d_inv_clk_vdd_inv_mc_vdd_inv_q_vdd_mpa_py_mpb_py_nand_m_vdd_nand_s2_vdd_nwell_vdd_sb_vdd_sr1_vdd_sr2_vdd_sr3_vdd_sr4_vdd_sv_d_vdd_tie_sv_vdd_tg_d_a_tg_d_vdd_tg_fbm_vdd_tg_fbs_vdd_tg_s_vdd_vdd_vdd_b1_vdd_b2_vdd_b3_vdd_b4_vdd_link_vdd_link_dip_vdd_x1_vdd_x2_vdd_x3_t18 r0 *1 0,0
Ra_d_inv_clk_vdd_inv_mc_vdd_inv_q_vdd_mpa_py_mpb_py_nand_m_vdd_nand_s2_vdd_nwell_vdd_sb_vdd_sr1_vdd_sr2_vdd_sr3_vdd_sr4_vdd_sv_d_vdd_tie_sv_vdd_tg_d_a_tg_d_vdd_tg_fbm_vdd_tg_fbs_vdd_tg_s_vdd_vdd_vdd_b1_vdd_b2_vdd_b3_vdd_b4_vdd_link_vdd_link_dip_vdd_x1_vdd_x2_vdd_x3_t18 vdd__t18 vdd 115.865994115
* device instance a_d_inv_clk_vdd_inv_mc_vdd_inv_q_vdd_mpa_py_mpb_py_nand_m_vdd_nand_s2_vdd_nwell_vdd_sb_vdd_sr1_vdd_sr2_vdd_sr3_vdd_sr4_vdd_sv_d_vdd_tie_sv_vdd_tg_d_a_tg_d_vdd_tg_fbm_vdd_tg_fbs_vdd_tg_s_vdd_vdd_vdd_b1_vdd_b2_vdd_b3_vdd_b4_vdd_link_vdd_link_dip_vdd_x1_vdd_x2_vdd_x3_t19 r0 *1 0,0
Ra_d_inv_clk_vdd_inv_mc_vdd_inv_q_vdd_mpa_py_mpb_py_nand_m_vdd_nand_s2_vdd_nwell_vdd_sb_vdd_sr1_vdd_sr2_vdd_sr3_vdd_sr4_vdd_sv_d_vdd_tie_sv_vdd_tg_d_a_tg_d_vdd_tg_fbm_vdd_tg_fbs_vdd_tg_s_vdd_vdd_vdd_b1_vdd_b2_vdd_b3_vdd_b4_vdd_link_vdd_link_dip_vdd_x1_vdd_x2_vdd_x3_t19 vdd__t19 vdd 155.084887095
* device instance a_d_inv_clk_vdd_inv_mc_vdd_inv_q_vdd_mpa_py_mpb_py_nand_m_vdd_nand_s2_vdd_nwell_vdd_sb_vdd_sr1_vdd_sr2_vdd_sr3_vdd_sr4_vdd_sv_d_vdd_tie_sv_vdd_tg_d_a_tg_d_vdd_tg_fbm_vdd_tg_fbs_vdd_tg_s_vdd_vdd_vdd_b1_vdd_b2_vdd_b3_vdd_b4_vdd_link_vdd_link_dip_vdd_x1_vdd_x2_vdd_x3_t20 r0 *1 0,0
Ra_d_inv_clk_vdd_inv_mc_vdd_inv_q_vdd_mpa_py_mpb_py_nand_m_vdd_nand_s2_vdd_nwell_vdd_sb_vdd_sr1_vdd_sr2_vdd_sr3_vdd_sr4_vdd_sv_d_vdd_tie_sv_vdd_tg_d_a_tg_d_vdd_tg_fbm_vdd_tg_fbs_vdd_tg_s_vdd_vdd_vdd_b1_vdd_b2_vdd_b3_vdd_b4_vdd_link_vdd_link_dip_vdd_x1_vdd_x2_vdd_x3_t20 vdd__t20 vdd 66.8380635271
* device instance a_d_inv_clk_vdd_inv_mc_vdd_inv_q_vdd_mpa_py_mpb_py_nand_m_vdd_nand_s2_vdd_nwell_vdd_sb_vdd_sr1_vdd_sr2_vdd_sr3_vdd_sr4_vdd_sv_d_vdd_tie_sv_vdd_tg_d_a_tg_d_vdd_tg_fbm_vdd_tg_fbs_vdd_tg_s_vdd_vdd_vdd_b1_vdd_b2_vdd_b3_vdd_b4_vdd_link_vdd_link_dip_vdd_x1_vdd_x2_vdd_x3_t21 r0 *1 0,0
Ra_d_inv_clk_vdd_inv_mc_vdd_inv_q_vdd_mpa_py_mpb_py_nand_m_vdd_nand_s2_vdd_nwell_vdd_sb_vdd_sr1_vdd_sr2_vdd_sr3_vdd_sr4_vdd_sv_d_vdd_tie_sv_vdd_tg_d_a_tg_d_vdd_tg_fbm_vdd_tg_fbs_vdd_tg_s_vdd_vdd_vdd_b1_vdd_b2_vdd_b3_vdd_b4_vdd_link_vdd_link_dip_vdd_x1_vdd_x2_vdd_x3_t21 vdd__t21 vdd 274.471210464
* device instance a_d_inv_clk_vdd_inv_mc_vdd_inv_q_vdd_mpa_py_mpb_py_nand_m_vdd_nand_s2_vdd_nwell_vdd_sb_vdd_sr1_vdd_sr2_vdd_sr3_vdd_sr4_vdd_sv_d_vdd_tie_sv_vdd_tg_d_a_tg_d_vdd_tg_fbm_vdd_tg_fbs_vdd_tg_s_vdd_vdd_vdd_b1_vdd_b2_vdd_b3_vdd_b4_vdd_link_vdd_link_dip_vdd_x1_vdd_x2_vdd_x3_t22 r0 *1 0,0
Ra_d_inv_clk_vdd_inv_mc_vdd_inv_q_vdd_mpa_py_mpb_py_nand_m_vdd_nand_s2_vdd_nwell_vdd_sb_vdd_sr1_vdd_sr2_vdd_sr3_vdd_sr4_vdd_sv_d_vdd_tie_sv_vdd_tg_d_a_tg_d_vdd_tg_fbm_vdd_tg_fbs_vdd_tg_s_vdd_vdd_vdd_b1_vdd_b2_vdd_b3_vdd_b4_vdd_link_vdd_link_dip_vdd_x1_vdd_x2_vdd_x3_t22 vdd__t22 vdd 229.224151213
* device instance a_d_inv_clk_vdd_inv_mc_vdd_inv_q_vdd_mpa_py_mpb_py_nand_m_vdd_nand_s2_vdd_nwell_vdd_sb_vdd_sr1_vdd_sr2_vdd_sr3_vdd_sr4_vdd_sv_d_vdd_tie_sv_vdd_tg_d_a_tg_d_vdd_tg_fbm_vdd_tg_fbs_vdd_tg_s_vdd_vdd_vdd_b1_vdd_b2_vdd_b3_vdd_b4_vdd_link_vdd_link_dip_vdd_x1_vdd_x2_vdd_x3_t23 r0 *1 0,0
Ra_d_inv_clk_vdd_inv_mc_vdd_inv_q_vdd_mpa_py_mpb_py_nand_m_vdd_nand_s2_vdd_nwell_vdd_sb_vdd_sr1_vdd_sr2_vdd_sr3_vdd_sr4_vdd_sv_d_vdd_tie_sv_vdd_tg_d_a_tg_d_vdd_tg_fbm_vdd_tg_fbs_vdd_tg_s_vdd_vdd_vdd_b1_vdd_b2_vdd_b3_vdd_b4_vdd_link_vdd_link_dip_vdd_x1_vdd_x2_vdd_x3_t23 vdd__t23 vdd 192.887270334
* device instance a_d_inv_clk_vdd_inv_mc_vdd_inv_q_vdd_mpa_py_mpb_py_nand_m_vdd_nand_s2_vdd_nwell_vdd_sb_vdd_sr1_vdd_sr2_vdd_sr3_vdd_sr4_vdd_sv_d_vdd_tie_sv_vdd_tg_d_a_tg_d_vdd_tg_fbm_vdd_tg_fbs_vdd_tg_s_vdd_vdd_vdd_b1_vdd_b2_vdd_b3_vdd_b4_vdd_link_vdd_link_dip_vdd_x1_vdd_x2_vdd_x3_t24 r0 *1 0,0
Ra_d_inv_clk_vdd_inv_mc_vdd_inv_q_vdd_mpa_py_mpb_py_nand_m_vdd_nand_s2_vdd_nwell_vdd_sb_vdd_sr1_vdd_sr2_vdd_sr3_vdd_sr4_vdd_sv_d_vdd_tie_sv_vdd_tg_d_a_tg_d_vdd_tg_fbm_vdd_tg_fbs_vdd_tg_s_vdd_vdd_vdd_b1_vdd_b2_vdd_b3_vdd_b4_vdd_link_vdd_link_dip_vdd_x1_vdd_x2_vdd_x3_t24 vdd__t24 vdd 147.729060078
* device instance a_d_inv_clk_vdd_inv_mc_vdd_inv_q_vdd_mpa_py_mpb_py_nand_m_vdd_nand_s2_vdd_nwell_vdd_sb_vdd_sr1_vdd_sr2_vdd_sr3_vdd_sr4_vdd_sv_d_vdd_tie_sv_vdd_tg_d_a_tg_d_vdd_tg_fbm_vdd_tg_fbs_vdd_tg_s_vdd_vdd_vdd_b1_vdd_b2_vdd_b3_vdd_b4_vdd_link_vdd_link_dip_vdd_x1_vdd_x2_vdd_x3_t25 r0 *1 0,0
Ra_d_inv_clk_vdd_inv_mc_vdd_inv_q_vdd_mpa_py_mpb_py_nand_m_vdd_nand_s2_vdd_nwell_vdd_sb_vdd_sr1_vdd_sr2_vdd_sr3_vdd_sr4_vdd_sv_d_vdd_tie_sv_vdd_tg_d_a_tg_d_vdd_tg_fbm_vdd_tg_fbs_vdd_tg_s_vdd_vdd_vdd_b1_vdd_b2_vdd_b3_vdd_b4_vdd_link_vdd_link_dip_vdd_x1_vdd_x2_vdd_x3_t25 vdd__t25 vdd 111.534033335
* device instance a_d_inv_clk_vdd_inv_mc_vdd_inv_q_vdd_mpa_py_mpb_py_nand_m_vdd_nand_s2_vdd_nwell_vdd_sb_vdd_sr1_vdd_sr2_vdd_sr3_vdd_sr4_vdd_sv_d_vdd_tie_sv_vdd_tg_d_a_tg_d_vdd_tg_fbm_vdd_tg_fbs_vdd_tg_s_vdd_vdd_vdd_b1_vdd_b2_vdd_b3_vdd_b4_vdd_link_vdd_link_dip_vdd_x1_vdd_x2_vdd_x3_t26 r0 *1 0,0
Ra_d_inv_clk_vdd_inv_mc_vdd_inv_q_vdd_mpa_py_mpb_py_nand_m_vdd_nand_s2_vdd_nwell_vdd_sb_vdd_sr1_vdd_sr2_vdd_sr3_vdd_sr4_vdd_sv_d_vdd_tie_sv_vdd_tg_d_a_tg_d_vdd_tg_fbm_vdd_tg_fbs_vdd_tg_s_vdd_vdd_vdd_b1_vdd_b2_vdd_b3_vdd_b4_vdd_link_vdd_link_dip_vdd_x1_vdd_x2_vdd_x3_t26 vdd__t26 vdd 21.7730597858
* device instance a_d_inv_clk_vdd_inv_mc_vdd_inv_q_vdd_mpa_py_mpb_py_nand_m_vdd_nand_s2_vdd_nwell_vdd_sb_vdd_sr1_vdd_sr2_vdd_sr3_vdd_sr4_vdd_sv_d_vdd_tie_sv_vdd_tg_d_a_tg_d_vdd_tg_fbm_vdd_tg_fbs_vdd_tg_s_vdd_vdd_vdd_b1_vdd_b2_vdd_b3_vdd_b4_vdd_link_vdd_link_dip_vdd_x1_vdd_x2_vdd_x3_t27 r0 *1 0,0
Ra_d_inv_clk_vdd_inv_mc_vdd_inv_q_vdd_mpa_py_mpb_py_nand_m_vdd_nand_s2_vdd_nwell_vdd_sb_vdd_sr1_vdd_sr2_vdd_sr3_vdd_sr4_vdd_sv_d_vdd_tie_sv_vdd_tg_d_a_tg_d_vdd_tg_fbm_vdd_tg_fbs_vdd_tg_s_vdd_vdd_vdd_b1_vdd_b2_vdd_b3_vdd_b4_vdd_link_vdd_link_dip_vdd_x1_vdd_x2_vdd_x3_t27 vdd__t27 vdd 111.123919524
* device instance a_d_inv_clk_vdd_inv_mc_vdd_inv_q_vdd_mpa_py_mpb_py_nand_m_vdd_nand_s2_vdd_nwell_vdd_sb_vdd_sr1_vdd_sr2_vdd_sr3_vdd_sr4_vdd_sv_d_vdd_tie_sv_vdd_tg_d_a_tg_d_vdd_tg_fbm_vdd_tg_fbs_vdd_tg_s_vdd_vdd_vdd_b1_vdd_b2_vdd_b3_vdd_b4_vdd_link_vdd_link_dip_vdd_x1_vdd_x2_vdd_x3_t28 r0 *1 0,0
Ra_d_inv_clk_vdd_inv_mc_vdd_inv_q_vdd_mpa_py_mpb_py_nand_m_vdd_nand_s2_vdd_nwell_vdd_sb_vdd_sr1_vdd_sr2_vdd_sr3_vdd_sr4_vdd_sv_d_vdd_tie_sv_vdd_tg_d_a_tg_d_vdd_tg_fbm_vdd_tg_fbs_vdd_tg_s_vdd_vdd_vdd_b1_vdd_b2_vdd_b3_vdd_b4_vdd_link_vdd_link_dip_vdd_x1_vdd_x2_vdd_x3_t28 vdd__t28 vdd 54.7575311569
* device instance a_d_inv_clk_vdd_inv_mc_vdd_inv_q_vdd_mpa_py_mpb_py_nand_m_vdd_nand_s2_vdd_nwell_vdd_sb_vdd_sr1_vdd_sr2_vdd_sr3_vdd_sr4_vdd_sv_d_vdd_tie_sv_vdd_tg_d_a_tg_d_vdd_tg_fbm_vdd_tg_fbs_vdd_tg_s_vdd_vdd_vdd_b1_vdd_b2_vdd_b3_vdd_b4_vdd_link_vdd_link_dip_vdd_x1_vdd_x2_vdd_x3_t29 r0 *1 0,0
Ra_d_inv_clk_vdd_inv_mc_vdd_inv_q_vdd_mpa_py_mpb_py_nand_m_vdd_nand_s2_vdd_nwell_vdd_sb_vdd_sr1_vdd_sr2_vdd_sr3_vdd_sr4_vdd_sv_d_vdd_tie_sv_vdd_tg_d_a_tg_d_vdd_tg_fbm_vdd_tg_fbs_vdd_tg_s_vdd_vdd_vdd_b1_vdd_b2_vdd_b3_vdd_b4_vdd_link_vdd_link_dip_vdd_x1_vdd_x2_vdd_x3_t29 vdd__t29 vdd 180.492128585
* device instance a_d_inv_clk_vdd_inv_mc_vdd_inv_q_vdd_mpa_py_mpb_py_nand_m_vdd_nand_s2_vdd_nwell_vdd_sb_vdd_sr1_vdd_sr2_vdd_sr3_vdd_sr4_vdd_sv_d_vdd_tie_sv_vdd_tg_d_a_tg_d_vdd_tg_fbm_vdd_tg_fbs_vdd_tg_s_vdd_vdd_vdd_b1_vdd_b2_vdd_b3_vdd_b4_vdd_link_vdd_link_dip_vdd_x1_vdd_x2_vdd_x3_t30 r0 *1 0,0
Ra_d_inv_clk_vdd_inv_mc_vdd_inv_q_vdd_mpa_py_mpb_py_nand_m_vdd_nand_s2_vdd_nwell_vdd_sb_vdd_sr1_vdd_sr2_vdd_sr3_vdd_sr4_vdd_sv_d_vdd_tie_sv_vdd_tg_d_a_tg_d_vdd_tg_fbm_vdd_tg_fbs_vdd_tg_s_vdd_vdd_vdd_b1_vdd_b2_vdd_b3_vdd_b4_vdd_link_vdd_link_dip_vdd_x1_vdd_x2_vdd_x3_t30 vdd__t30 vdd 32.209780801
* device instance a_d_inv_clk_vdd_inv_mc_vdd_inv_q_vdd_mpa_py_mpb_py_nand_m_vdd_nand_s2_vdd_nwell_vdd_sb_vdd_sr1_vdd_sr2_vdd_sr3_vdd_sr4_vdd_sv_d_vdd_tie_sv_vdd_tg_d_a_tg_d_vdd_tg_fbm_vdd_tg_fbs_vdd_tg_s_vdd_vdd_vdd_b1_vdd_b2_vdd_b3_vdd_b4_vdd_link_vdd_link_dip_vdd_x1_vdd_x2_vdd_x3_t31 r0 *1 0,0
Ra_d_inv_clk_vdd_inv_mc_vdd_inv_q_vdd_mpa_py_mpb_py_nand_m_vdd_nand_s2_vdd_nwell_vdd_sb_vdd_sr1_vdd_sr2_vdd_sr3_vdd_sr4_vdd_sv_d_vdd_tie_sv_vdd_tg_d_a_tg_d_vdd_tg_fbm_vdd_tg_fbs_vdd_tg_s_vdd_vdd_vdd_b1_vdd_b2_vdd_b3_vdd_b4_vdd_link_vdd_link_dip_vdd_x1_vdd_x2_vdd_x3_t31 vdd__t31 vdd 135.360970407
* device instance a_d_inv_clk_vdd_inv_mc_vdd_inv_q_vdd_mpa_py_mpb_py_nand_m_vdd_nand_s2_vdd_nwell_vdd_sb_vdd_sr1_vdd_sr2_vdd_sr3_vdd_sr4_vdd_sv_d_vdd_tie_sv_vdd_tg_d_a_tg_d_vdd_tg_fbm_vdd_tg_fbs_vdd_tg_s_vdd_vdd_vdd_b1_vdd_b2_vdd_b3_vdd_b4_vdd_link_vdd_link_dip_vdd_x1_vdd_x2_vdd_x3_t32 r0 *1 0,0
Ra_d_inv_clk_vdd_inv_mc_vdd_inv_q_vdd_mpa_py_mpb_py_nand_m_vdd_nand_s2_vdd_nwell_vdd_sb_vdd_sr1_vdd_sr2_vdd_sr3_vdd_sr4_vdd_sv_d_vdd_tie_sv_vdd_tg_d_a_tg_d_vdd_tg_fbm_vdd_tg_fbs_vdd_tg_s_vdd_vdd_vdd_b1_vdd_b2_vdd_b3_vdd_b4_vdd_link_vdd_link_dip_vdd_x1_vdd_x2_vdd_x3_t32 vdd__t32 vdd 99.2174046262
* device instance a_d_inv_clk_vdd_inv_mc_vdd_inv_q_vdd_mpa_py_mpb_py_nand_m_vdd_nand_s2_vdd_nwell_vdd_sb_vdd_sr1_vdd_sr2_vdd_sr3_vdd_sr4_vdd_sv_d_vdd_tie_sv_vdd_tg_d_a_tg_d_vdd_tg_fbm_vdd_tg_fbs_vdd_tg_s_vdd_vdd_vdd_b1_vdd_b2_vdd_b3_vdd_b4_vdd_link_vdd_link_dip_vdd_x1_vdd_x2_vdd_x3_t33 r0 *1 0,0
Ra_d_inv_clk_vdd_inv_mc_vdd_inv_q_vdd_mpa_py_mpb_py_nand_m_vdd_nand_s2_vdd_nwell_vdd_sb_vdd_sr1_vdd_sr2_vdd_sr3_vdd_sr4_vdd_sv_d_vdd_tie_sv_vdd_tg_d_a_tg_d_vdd_tg_fbm_vdd_tg_fbs_vdd_tg_s_vdd_vdd_vdd_b1_vdd_b2_vdd_b3_vdd_b4_vdd_link_vdd_link_dip_vdd_x1_vdd_x2_vdd_x3_t33 vdd__t33 vdd 111.896855982
* device instance a_d_inv_clk_vdd_inv_mc_vdd_inv_q_vdd_mpa_py_mpb_py_nand_m_vdd_nand_s2_vdd_nwell_vdd_sb_vdd_sr1_vdd_sr2_vdd_sr3_vdd_sr4_vdd_sv_d_vdd_tie_sv_vdd_tg_d_a_tg_d_vdd_tg_fbm_vdd_tg_fbs_vdd_tg_s_vdd_vdd_vdd_b1_vdd_b2_vdd_b3_vdd_b4_vdd_link_vdd_link_dip_vdd_x1_vdd_x2_vdd_x3_t34 r0 *1 0,0
Ra_d_inv_clk_vdd_inv_mc_vdd_inv_q_vdd_mpa_py_mpb_py_nand_m_vdd_nand_s2_vdd_nwell_vdd_sb_vdd_sr1_vdd_sr2_vdd_sr3_vdd_sr4_vdd_sv_d_vdd_tie_sv_vdd_tg_d_a_tg_d_vdd_tg_fbm_vdd_tg_fbs_vdd_tg_s_vdd_vdd_vdd_b1_vdd_b2_vdd_b3_vdd_b4_vdd_link_vdd_link_dip_vdd_x1_vdd_x2_vdd_x3_t34 vdd__t34 vdd 171.705130511
* device instance a_d_inv_clk_vdd_inv_mc_vdd_inv_q_vdd_mpa_py_mpb_py_nand_m_vdd_nand_s2_vdd_nwell_vdd_sb_vdd_sr1_vdd_sr2_vdd_sr3_vdd_sr4_vdd_sv_d_vdd_tie_sv_vdd_tg_d_a_tg_d_vdd_tg_fbm_vdd_tg_fbs_vdd_tg_s_vdd_vdd_vdd_b1_vdd_b2_vdd_b3_vdd_b4_vdd_link_vdd_link_dip_vdd_x1_vdd_x2_vdd_x3_t35 r0 *1 0,0
Ra_d_inv_clk_vdd_inv_mc_vdd_inv_q_vdd_mpa_py_mpb_py_nand_m_vdd_nand_s2_vdd_nwell_vdd_sb_vdd_sr1_vdd_sr2_vdd_sr3_vdd_sr4_vdd_sv_d_vdd_tie_sv_vdd_tg_d_a_tg_d_vdd_tg_fbm_vdd_tg_fbs_vdd_tg_s_vdd_vdd_vdd_b1_vdd_b2_vdd_b3_vdd_b4_vdd_link_vdd_link_dip_vdd_x1_vdd_x2_vdd_x3_t35 vdd__t35 vdd 199.938103526
* device instance a_d_inv_clk_vdd_inv_mc_vdd_inv_q_vdd_mpa_py_mpb_py_nand_m_vdd_nand_s2_vdd_nwell_vdd_sb_vdd_sr1_vdd_sr2_vdd_sr3_vdd_sr4_vdd_sv_d_vdd_tie_sv_vdd_tg_d_a_tg_d_vdd_tg_fbm_vdd_tg_fbs_vdd_tg_s_vdd_vdd_vdd_b1_vdd_b2_vdd_b3_vdd_b4_vdd_link_vdd_link_dip_vdd_x1_vdd_x2_vdd_x3_t36 r0 *1 0,0
Ra_d_inv_clk_vdd_inv_mc_vdd_inv_q_vdd_mpa_py_mpb_py_nand_m_vdd_nand_s2_vdd_nwell_vdd_sb_vdd_sr1_vdd_sr2_vdd_sr3_vdd_sr4_vdd_sv_d_vdd_tie_sv_vdd_tg_d_a_tg_d_vdd_tg_fbm_vdd_tg_fbs_vdd_tg_s_vdd_vdd_vdd_b1_vdd_b2_vdd_b3_vdd_b4_vdd_link_vdd_link_dip_vdd_x1_vdd_x2_vdd_x3_t36 vdd__t36 vdd 210.446064443
* device instance a_d_inv_clk_vdd_inv_mc_vdd_inv_q_vdd_mpa_py_mpb_py_nand_m_vdd_nand_s2_vdd_nwell_vdd_sb_vdd_sr1_vdd_sr2_vdd_sr3_vdd_sr4_vdd_sv_d_vdd_tie_sv_vdd_tg_d_a_tg_d_vdd_tg_fbm_vdd_tg_fbs_vdd_tg_s_vdd_vdd_vdd_b1_vdd_b2_vdd_b3_vdd_b4_vdd_link_vdd_link_dip_vdd_x1_vdd_x2_vdd_x3_t37 r0 *1 0,0
Ra_d_inv_clk_vdd_inv_mc_vdd_inv_q_vdd_mpa_py_mpb_py_nand_m_vdd_nand_s2_vdd_nwell_vdd_sb_vdd_sr1_vdd_sr2_vdd_sr3_vdd_sr4_vdd_sv_d_vdd_tie_sv_vdd_tg_d_a_tg_d_vdd_tg_fbm_vdd_tg_fbs_vdd_tg_s_vdd_vdd_vdd_b1_vdd_b2_vdd_b3_vdd_b4_vdd_link_vdd_link_dip_vdd_x1_vdd_x2_vdd_x3_t37 vdd__t37 vdd 173.908613154
* device instance a_d_inv_clk_vdd_inv_mc_vdd_inv_q_vdd_mpa_py_mpb_py_nand_m_vdd_nand_s2_vdd_nwell_vdd_sb_vdd_sr1_vdd_sr2_vdd_sr3_vdd_sr4_vdd_sv_d_vdd_tie_sv_vdd_tg_d_a_tg_d_vdd_tg_fbm_vdd_tg_fbs_vdd_tg_s_vdd_vdd_vdd_b1_vdd_b2_vdd_b3_vdd_b4_vdd_link_vdd_link_dip_vdd_x1_vdd_x2_vdd_x3_t38 r0 *1 0,0
Ra_d_inv_clk_vdd_inv_mc_vdd_inv_q_vdd_mpa_py_mpb_py_nand_m_vdd_nand_s2_vdd_nwell_vdd_sb_vdd_sr1_vdd_sr2_vdd_sr3_vdd_sr4_vdd_sv_d_vdd_tie_sv_vdd_tg_d_a_tg_d_vdd_tg_fbm_vdd_tg_fbs_vdd_tg_s_vdd_vdd_vdd_b1_vdd_b2_vdd_b3_vdd_b4_vdd_link_vdd_link_dip_vdd_x1_vdd_x2_vdd_x3_t38 vdd__t38 vdd 158.660523292
* device instance a_d_inv_clk_vdd_inv_mc_vdd_inv_q_vdd_mpa_py_mpb_py_nand_m_vdd_nand_s2_vdd_nwell_vdd_sb_vdd_sr1_vdd_sr2_vdd_sr3_vdd_sr4_vdd_sv_d_vdd_tie_sv_vdd_tg_d_a_tg_d_vdd_tg_fbm_vdd_tg_fbs_vdd_tg_s_vdd_vdd_vdd_b1_vdd_b2_vdd_b3_vdd_b4_vdd_link_vdd_link_dip_vdd_x1_vdd_x2_vdd_x3_t39 r0 *1 0,0
Ra_d_inv_clk_vdd_inv_mc_vdd_inv_q_vdd_mpa_py_mpb_py_nand_m_vdd_nand_s2_vdd_nwell_vdd_sb_vdd_sr1_vdd_sr2_vdd_sr3_vdd_sr4_vdd_sv_d_vdd_tie_sv_vdd_tg_d_a_tg_d_vdd_tg_fbm_vdd_tg_fbs_vdd_tg_s_vdd_vdd_vdd_b1_vdd_b2_vdd_b3_vdd_b4_vdd_link_vdd_link_dip_vdd_x1_vdd_x2_vdd_x3_t39 vdd__t39 vdd 217.426079666
* device instance a_d_inv_clk_vdd_inv_mc_vdd_inv_q_vdd_mpa_py_mpb_py_nand_m_vdd_nand_s2_vdd_nwell_vdd_sb_vdd_sr1_vdd_sr2_vdd_sr3_vdd_sr4_vdd_sv_d_vdd_tie_sv_vdd_tg_d_a_tg_d_vdd_tg_fbm_vdd_tg_fbs_vdd_tg_s_vdd_vdd_vdd_b1_vdd_b2_vdd_b3_vdd_b4_vdd_link_vdd_link_dip_vdd_x1_vdd_x2_vdd_x3_t40 r0 *1 0,0
Ra_d_inv_clk_vdd_inv_mc_vdd_inv_q_vdd_mpa_py_mpb_py_nand_m_vdd_nand_s2_vdd_nwell_vdd_sb_vdd_sr1_vdd_sr2_vdd_sr3_vdd_sr4_vdd_sv_d_vdd_tie_sv_vdd_tg_d_a_tg_d_vdd_tg_fbm_vdd_tg_fbs_vdd_tg_s_vdd_vdd_vdd_b1_vdd_b2_vdd_b3_vdd_b4_vdd_link_vdd_link_dip_vdd_x1_vdd_x2_vdd_x3_t40 vdd__t40 vdd 50.5462818726
* device instance a_d_inv_clk_vdd_inv_mc_vdd_inv_q_vdd_mpa_py_mpb_py_nand_m_vdd_nand_s2_vdd_nwell_vdd_sb_vdd_sr1_vdd_sr2_vdd_sr3_vdd_sr4_vdd_sv_d_vdd_tie_sv_vdd_tg_d_a_tg_d_vdd_tg_fbm_vdd_tg_fbs_vdd_tg_s_vdd_vdd_vdd_b1_vdd_b2_vdd_b3_vdd_b4_vdd_link_vdd_link_dip_vdd_x1_vdd_x2_vdd_x3_t41 r0 *1 0,0
Ra_d_inv_clk_vdd_inv_mc_vdd_inv_q_vdd_mpa_py_mpb_py_nand_m_vdd_nand_s2_vdd_nwell_vdd_sb_vdd_sr1_vdd_sr2_vdd_sr3_vdd_sr4_vdd_sv_d_vdd_tie_sv_vdd_tg_d_a_tg_d_vdd_tg_fbm_vdd_tg_fbs_vdd_tg_s_vdd_vdd_vdd_b1_vdd_b2_vdd_b3_vdd_b4_vdd_link_vdd_link_dip_vdd_x1_vdd_x2_vdd_x3_t41 vdd__t41 vdd 133.307481456
* device instance a_d_inv_clk_vdd_inv_mc_vdd_inv_q_vdd_mpa_py_mpb_py_nand_m_vdd_nand_s2_vdd_nwell_vdd_sb_vdd_sr1_vdd_sr2_vdd_sr3_vdd_sr4_vdd_sv_d_vdd_tie_sv_vdd_tg_d_a_tg_d_vdd_tg_fbm_vdd_tg_fbs_vdd_tg_s_vdd_vdd_vdd_b1_vdd_b2_vdd_b3_vdd_b4_vdd_link_vdd_link_dip_vdd_x1_vdd_x2_vdd_x3_t42 r0 *1 0,0
Ra_d_inv_clk_vdd_inv_mc_vdd_inv_q_vdd_mpa_py_mpb_py_nand_m_vdd_nand_s2_vdd_nwell_vdd_sb_vdd_sr1_vdd_sr2_vdd_sr3_vdd_sr4_vdd_sv_d_vdd_tie_sv_vdd_tg_d_a_tg_d_vdd_tg_fbm_vdd_tg_fbs_vdd_tg_s_vdd_vdd_vdd_b1_vdd_b2_vdd_b3_vdd_b4_vdd_link_vdd_link_dip_vdd_x1_vdd_x2_vdd_x3_t42 vdd__t42 vdd 118.527622922
* device instance a_d_inv_clk_vdd_inv_mc_vdd_inv_q_vdd_mpa_py_mpb_py_nand_m_vdd_nand_s2_vdd_nwell_vdd_sb_vdd_sr1_vdd_sr2_vdd_sr3_vdd_sr4_vdd_sv_d_vdd_tie_sv_vdd_tg_d_a_tg_d_vdd_tg_fbm_vdd_tg_fbs_vdd_tg_s_vdd_vdd_vdd_b1_vdd_b2_vdd_b3_vdd_b4_vdd_link_vdd_link_dip_vdd_x1_vdd_x2_vdd_x3_t43 r0 *1 0,0
Ra_d_inv_clk_vdd_inv_mc_vdd_inv_q_vdd_mpa_py_mpb_py_nand_m_vdd_nand_s2_vdd_nwell_vdd_sb_vdd_sr1_vdd_sr2_vdd_sr3_vdd_sr4_vdd_sv_d_vdd_tie_sv_vdd_tg_d_a_tg_d_vdd_tg_fbm_vdd_tg_fbs_vdd_tg_s_vdd_vdd_vdd_b1_vdd_b2_vdd_b3_vdd_b4_vdd_link_vdd_link_dip_vdd_x1_vdd_x2_vdd_x3_t43 vdd__t43 vdd 245.693393963
* device instance a_d_inv_clk_vdd_inv_mc_vdd_inv_q_vdd_mpa_py_mpb_py_nand_m_vdd_nand_s2_vdd_nwell_vdd_sb_vdd_sr1_vdd_sr2_vdd_sr3_vdd_sr4_vdd_sv_d_vdd_tie_sv_vdd_tg_d_a_tg_d_vdd_tg_fbm_vdd_tg_fbs_vdd_tg_s_vdd_vdd_vdd_b1_vdd_b2_vdd_b3_vdd_b4_vdd_link_vdd_link_dip_vdd_x1_vdd_x2_vdd_x3_t44 r0 *1 0,0
Ra_d_inv_clk_vdd_inv_mc_vdd_inv_q_vdd_mpa_py_mpb_py_nand_m_vdd_nand_s2_vdd_nwell_vdd_sb_vdd_sr1_vdd_sr2_vdd_sr3_vdd_sr4_vdd_sv_d_vdd_tie_sv_vdd_tg_d_a_tg_d_vdd_tg_fbm_vdd_tg_fbs_vdd_tg_s_vdd_vdd_vdd_b1_vdd_b2_vdd_b3_vdd_b4_vdd_link_vdd_link_dip_vdd_x1_vdd_x2_vdd_x3_t44 vdd__t44 vdd 253.227807773
* device instance a_d_inv_clk_vdd_inv_mc_vdd_inv_q_vdd_mpa_py_mpb_py_nand_m_vdd_nand_s2_vdd_nwell_vdd_sb_vdd_sr1_vdd_sr2_vdd_sr3_vdd_sr4_vdd_sv_d_vdd_tie_sv_vdd_tg_d_a_tg_d_vdd_tg_fbm_vdd_tg_fbs_vdd_tg_s_vdd_vdd_vdd_b1_vdd_b2_vdd_b3_vdd_b4_vdd_link_vdd_link_dip_vdd_x1_vdd_x2_vdd_x3_t45 r0 *1 0,0
Ra_d_inv_clk_vdd_inv_mc_vdd_inv_q_vdd_mpa_py_mpb_py_nand_m_vdd_nand_s2_vdd_nwell_vdd_sb_vdd_sr1_vdd_sr2_vdd_sr3_vdd_sr4_vdd_sv_d_vdd_tie_sv_vdd_tg_d_a_tg_d_vdd_tg_fbm_vdd_tg_fbs_vdd_tg_s_vdd_vdd_vdd_b1_vdd_b2_vdd_b3_vdd_b4_vdd_link_vdd_link_dip_vdd_x1_vdd_x2_vdd_x3_t45 vdd__t45 vdd 263.20408715
* device instance a_d_inv_clk_vdd_inv_mc_vdd_inv_q_vdd_mpa_py_mpb_py_nand_m_vdd_nand_s2_vdd_nwell_vdd_sb_vdd_sr1_vdd_sr2_vdd_sr3_vdd_sr4_vdd_sv_d_vdd_tie_sv_vdd_tg_d_a_tg_d_vdd_tg_fbm_vdd_tg_fbs_vdd_tg_s_vdd_vdd_vdd_b1_vdd_b2_vdd_b3_vdd_b4_vdd_link_vdd_link_dip_vdd_x1_vdd_x2_vdd_x3_t46 r0 *1 0,0
Ra_d_inv_clk_vdd_inv_mc_vdd_inv_q_vdd_mpa_py_mpb_py_nand_m_vdd_nand_s2_vdd_nwell_vdd_sb_vdd_sr1_vdd_sr2_vdd_sr3_vdd_sr4_vdd_sv_d_vdd_tie_sv_vdd_tg_d_a_tg_d_vdd_tg_fbm_vdd_tg_fbs_vdd_tg_s_vdd_vdd_vdd_b1_vdd_b2_vdd_b3_vdd_b4_vdd_link_vdd_link_dip_vdd_x1_vdd_x2_vdd_x3_t46 vdd__t46 vdd 281.510585951
* device instance a_d_inv_clk_vdd_inv_mc_vdd_inv_q_vdd_mpa_py_mpb_py_nand_m_vdd_nand_s2_vdd_nwell_vdd_sb_vdd_sr1_vdd_sr2_vdd_sr3_vdd_sr4_vdd_sv_d_vdd_tie_sv_vdd_tg_d_a_tg_d_vdd_tg_fbm_vdd_tg_fbs_vdd_tg_s_vdd_vdd_vdd_b1_vdd_b2_vdd_b3_vdd_b4_vdd_link_vdd_link_dip_vdd_x1_vdd_x2_vdd_x3_t47 r0 *1 0,0
Ra_d_inv_clk_vdd_inv_mc_vdd_inv_q_vdd_mpa_py_mpb_py_nand_m_vdd_nand_s2_vdd_nwell_vdd_sb_vdd_sr1_vdd_sr2_vdd_sr3_vdd_sr4_vdd_sv_d_vdd_tie_sv_vdd_tg_d_a_tg_d_vdd_tg_fbm_vdd_tg_fbs_vdd_tg_s_vdd_vdd_vdd_b1_vdd_b2_vdd_b3_vdd_b4_vdd_link_vdd_link_dip_vdd_x1_vdd_x2_vdd_x3_t47 vdd__t47 vdd 64.9885343757
* device instance a_d_inv_clk_vdd_inv_mc_vdd_inv_q_vdd_mpa_py_mpb_py_nand_m_vdd_nand_s2_vdd_nwell_vdd_sb_vdd_sr1_vdd_sr2_vdd_sr3_vdd_sr4_vdd_sv_d_vdd_tie_sv_vdd_tg_d_a_tg_d_vdd_tg_fbm_vdd_tg_fbs_vdd_tg_s_vdd_vdd_vdd_b1_vdd_b2_vdd_b3_vdd_b4_vdd_link_vdd_link_dip_vdd_x1_vdd_x2_vdd_x3_t48 r0 *1 0,0
Ra_d_inv_clk_vdd_inv_mc_vdd_inv_q_vdd_mpa_py_mpb_py_nand_m_vdd_nand_s2_vdd_nwell_vdd_sb_vdd_sr1_vdd_sr2_vdd_sr3_vdd_sr4_vdd_sv_d_vdd_tie_sv_vdd_tg_d_a_tg_d_vdd_tg_fbm_vdd_tg_fbs_vdd_tg_s_vdd_vdd_vdd_b1_vdd_b2_vdd_b3_vdd_b4_vdd_link_vdd_link_dip_vdd_x1_vdd_x2_vdd_x3_t48 vdd__t48 vdd 39.6730583799
* device instance a_d_inv_clk_vdd_inv_mc_vdd_inv_q_vdd_mpa_py_mpb_py_nand_m_vdd_nand_s2_vdd_nwell_vdd_sb_vdd_sr1_vdd_sr2_vdd_sr3_vdd_sr4_vdd_sv_d_vdd_tie_sv_vdd_tg_d_a_tg_d_vdd_tg_fbm_vdd_tg_fbs_vdd_tg_s_vdd_vdd_vdd_b1_vdd_b2_vdd_b3_vdd_b4_vdd_link_vdd_link_dip_vdd_x1_vdd_x2_vdd_x3_t49 r0 *1 0,0
Ra_d_inv_clk_vdd_inv_mc_vdd_inv_q_vdd_mpa_py_mpb_py_nand_m_vdd_nand_s2_vdd_nwell_vdd_sb_vdd_sr1_vdd_sr2_vdd_sr3_vdd_sr4_vdd_sv_d_vdd_tie_sv_vdd_tg_d_a_tg_d_vdd_tg_fbm_vdd_tg_fbs_vdd_tg_s_vdd_vdd_vdd_b1_vdd_b2_vdd_b3_vdd_b4_vdd_link_vdd_link_dip_vdd_x1_vdd_x2_vdd_x3_t49 vdd__t49 vdd 66.8380635271
* device instance a_d_inv_clk_vdd_inv_mc_vdd_inv_q_vdd_mpa_py_mpb_py_nand_m_vdd_nand_s2_vdd_nwell_vdd_sb_vdd_sr1_vdd_sr2_vdd_sr3_vdd_sr4_vdd_sv_d_vdd_tie_sv_vdd_tg_d_a_tg_d_vdd_tg_fbm_vdd_tg_fbs_vdd_tg_s_vdd_vdd_vdd_b1_vdd_b2_vdd_b3_vdd_b4_vdd_link_vdd_link_dip_vdd_x1_vdd_x2_vdd_x3_t50 r0 *1 0,0
Ra_d_inv_clk_vdd_inv_mc_vdd_inv_q_vdd_mpa_py_mpb_py_nand_m_vdd_nand_s2_vdd_nwell_vdd_sb_vdd_sr1_vdd_sr2_vdd_sr3_vdd_sr4_vdd_sv_d_vdd_tie_sv_vdd_tg_d_a_tg_d_vdd_tg_fbm_vdd_tg_fbs_vdd_tg_s_vdd_vdd_vdd_b1_vdd_b2_vdd_b3_vdd_b4_vdd_link_vdd_link_dip_vdd_x1_vdd_x2_vdd_x3_t50 vdd__t50 vdd 94.4335287718
* device instance a_d_inv_clk_vdd_inv_mc_vdd_inv_q_vdd_mpa_py_mpb_py_nand_m_vdd_nand_s2_vdd_nwell_vdd_sb_vdd_sr1_vdd_sr2_vdd_sr3_vdd_sr4_vdd_sv_d_vdd_tie_sv_vdd_tg_d_a_tg_d_vdd_tg_fbm_vdd_tg_fbs_vdd_tg_s_vdd_vdd_vdd_b1_vdd_b2_vdd_b3_vdd_b4_vdd_link_vdd_link_dip_vdd_x1_vdd_x2_vdd_x3_t51 r0 *1 0,0
Ra_d_inv_clk_vdd_inv_mc_vdd_inv_q_vdd_mpa_py_mpb_py_nand_m_vdd_nand_s2_vdd_nwell_vdd_sb_vdd_sr1_vdd_sr2_vdd_sr3_vdd_sr4_vdd_sv_d_vdd_tie_sv_vdd_tg_d_a_tg_d_vdd_tg_fbm_vdd_tg_fbs_vdd_tg_s_vdd_vdd_vdd_b1_vdd_b2_vdd_b3_vdd_b4_vdd_link_vdd_link_dip_vdd_x1_vdd_x2_vdd_x3_t51 vdd__t51 vdd 238.709465789
* device instance a_d_inv_clk_vdd_inv_mc_vdd_inv_q_vdd_mpa_py_mpb_py_nand_m_vdd_nand_s2_vdd_nwell_vdd_sb_vdd_sr1_vdd_sr2_vdd_sr3_vdd_sr4_vdd_sv_d_vdd_tie_sv_vdd_tg_d_a_tg_d_vdd_tg_fbm_vdd_tg_fbs_vdd_tg_s_vdd_vdd_vdd_b1_vdd_b2_vdd_b3_vdd_b4_vdd_link_vdd_link_dip_vdd_x1_vdd_x2_vdd_x3_t52 r0 *1 0,0
Ra_d_inv_clk_vdd_inv_mc_vdd_inv_q_vdd_mpa_py_mpb_py_nand_m_vdd_nand_s2_vdd_nwell_vdd_sb_vdd_sr1_vdd_sr2_vdd_sr3_vdd_sr4_vdd_sv_d_vdd_tie_sv_vdd_tg_d_a_tg_d_vdd_tg_fbm_vdd_tg_fbs_vdd_tg_s_vdd_vdd_vdd_b1_vdd_b2_vdd_b3_vdd_b4_vdd_link_vdd_link_dip_vdd_x1_vdd_x2_vdd_x3_t52 vdd__t52 vdd 274.471210464
* device instance a_d_inv_clk_vdd_inv_mc_vdd_inv_q_vdd_mpa_py_mpb_py_nand_m_vdd_nand_s2_vdd_nwell_vdd_sb_vdd_sr1_vdd_sr2_vdd_sr3_vdd_sr4_vdd_sv_d_vdd_tie_sv_vdd_tg_d_a_tg_d_vdd_tg_fbm_vdd_tg_fbs_vdd_tg_s_vdd_vdd_vdd_b1_vdd_b2_vdd_b3_vdd_b4_vdd_link_vdd_link_dip_vdd_x1_vdd_x2_vdd_x3_t53 r0 *1 0,0
Ra_d_inv_clk_vdd_inv_mc_vdd_inv_q_vdd_mpa_py_mpb_py_nand_m_vdd_nand_s2_vdd_nwell_vdd_sb_vdd_sr1_vdd_sr2_vdd_sr3_vdd_sr4_vdd_sv_d_vdd_tie_sv_vdd_tg_d_a_tg_d_vdd_tg_fbm_vdd_tg_fbs_vdd_tg_s_vdd_vdd_vdd_b1_vdd_b2_vdd_b3_vdd_b4_vdd_link_vdd_link_dip_vdd_x1_vdd_x2_vdd_x3_t53 vdd__t53 vdd 272.579318667
* device instance a_d_inv_clk_vdd_inv_mc_vdd_inv_q_vdd_mpa_py_mpb_py_nand_m_vdd_nand_s2_vdd_nwell_vdd_sb_vdd_sr1_vdd_sr2_vdd_sr3_vdd_sr4_vdd_sv_d_vdd_tie_sv_vdd_tg_d_a_tg_d_vdd_tg_fbm_vdd_tg_fbs_vdd_tg_s_vdd_vdd_vdd_b1_vdd_b2_vdd_b3_vdd_b4_vdd_link_vdd_link_dip_vdd_x1_vdd_x2_vdd_x3_t54 r0 *1 0,0
Ra_d_inv_clk_vdd_inv_mc_vdd_inv_q_vdd_mpa_py_mpb_py_nand_m_vdd_nand_s2_vdd_nwell_vdd_sb_vdd_sr1_vdd_sr2_vdd_sr3_vdd_sr4_vdd_sv_d_vdd_tie_sv_vdd_tg_d_a_tg_d_vdd_tg_fbm_vdd_tg_fbs_vdd_tg_s_vdd_vdd_vdd_b1_vdd_b2_vdd_b3_vdd_b4_vdd_link_vdd_link_dip_vdd_x1_vdd_x2_vdd_x3_t54 vdd__t54 vdd 229.224151213
* device instance a_d_inv_clk_vdd_inv_mc_vdd_inv_q_vdd_mpa_py_mpb_py_nand_m_vdd_nand_s2_vdd_nwell_vdd_sb_vdd_sr1_vdd_sr2_vdd_sr3_vdd_sr4_vdd_sv_d_vdd_tie_sv_vdd_tg_d_a_tg_d_vdd_tg_fbm_vdd_tg_fbs_vdd_tg_s_vdd_vdd_vdd_b1_vdd_b2_vdd_b3_vdd_b4_vdd_link_vdd_link_dip_vdd_x1_vdd_x2_vdd_x3_t55 r0 *1 0,0
Ra_d_inv_clk_vdd_inv_mc_vdd_inv_q_vdd_mpa_py_mpb_py_nand_m_vdd_nand_s2_vdd_nwell_vdd_sb_vdd_sr1_vdd_sr2_vdd_sr3_vdd_sr4_vdd_sv_d_vdd_tie_sv_vdd_tg_d_a_tg_d_vdd_tg_fbm_vdd_tg_fbs_vdd_tg_s_vdd_vdd_vdd_b1_vdd_b2_vdd_b3_vdd_b4_vdd_link_vdd_link_dip_vdd_x1_vdd_x2_vdd_x3_t55 vdd__t55 vdd 227.333384696
* device instance a_d_inv_clk_vdd_inv_mc_vdd_inv_q_vdd_mpa_py_mpb_py_nand_m_vdd_nand_s2_vdd_nwell_vdd_sb_vdd_sr1_vdd_sr2_vdd_sr3_vdd_sr4_vdd_sv_d_vdd_tie_sv_vdd_tg_d_a_tg_d_vdd_tg_fbm_vdd_tg_fbs_vdd_tg_s_vdd_vdd_vdd_b1_vdd_b2_vdd_b3_vdd_b4_vdd_link_vdd_link_dip_vdd_x1_vdd_x2_vdd_x3_t56 r0 *1 0,0
Ra_d_inv_clk_vdd_inv_mc_vdd_inv_q_vdd_mpa_py_mpb_py_nand_m_vdd_nand_s2_vdd_nwell_vdd_sb_vdd_sr1_vdd_sr2_vdd_sr3_vdd_sr4_vdd_sv_d_vdd_tie_sv_vdd_tg_d_a_tg_d_vdd_tg_fbm_vdd_tg_fbs_vdd_tg_s_vdd_vdd_vdd_b1_vdd_b2_vdd_b3_vdd_b4_vdd_link_vdd_link_dip_vdd_x1_vdd_x2_vdd_x3_t56 vdd__t56 vdd 192.887270334
* device instance a_d_inv_clk_vdd_inv_mc_vdd_inv_q_vdd_mpa_py_mpb_py_nand_m_vdd_nand_s2_vdd_nwell_vdd_sb_vdd_sr1_vdd_sr2_vdd_sr3_vdd_sr4_vdd_sv_d_vdd_tie_sv_vdd_tg_d_a_tg_d_vdd_tg_fbm_vdd_tg_fbs_vdd_tg_s_vdd_vdd_vdd_b1_vdd_b2_vdd_b3_vdd_b4_vdd_link_vdd_link_dip_vdd_x1_vdd_x2_vdd_x3_t57 r0 *1 0,0
Ra_d_inv_clk_vdd_inv_mc_vdd_inv_q_vdd_mpa_py_mpb_py_nand_m_vdd_nand_s2_vdd_nwell_vdd_sb_vdd_sr1_vdd_sr2_vdd_sr3_vdd_sr4_vdd_sv_d_vdd_tie_sv_vdd_tg_d_a_tg_d_vdd_tg_fbm_vdd_tg_fbs_vdd_tg_s_vdd_vdd_vdd_b1_vdd_b2_vdd_b3_vdd_b4_vdd_link_vdd_link_dip_vdd_x1_vdd_x2_vdd_x3_t57 vdd__t57 vdd 190.998041694
* device instance a_d_inv_clk_vdd_inv_mc_vdd_inv_q_vdd_mpa_py_mpb_py_nand_m_vdd_nand_s2_vdd_nwell_vdd_sb_vdd_sr1_vdd_sr2_vdd_sr3_vdd_sr4_vdd_sv_d_vdd_tie_sv_vdd_tg_d_a_tg_d_vdd_tg_fbm_vdd_tg_fbs_vdd_tg_s_vdd_vdd_vdd_b1_vdd_b2_vdd_b3_vdd_b4_vdd_link_vdd_link_dip_vdd_x1_vdd_x2_vdd_x3_t58 r0 *1 0,0
Ra_d_inv_clk_vdd_inv_mc_vdd_inv_q_vdd_mpa_py_mpb_py_nand_m_vdd_nand_s2_vdd_nwell_vdd_sb_vdd_sr1_vdd_sr2_vdd_sr3_vdd_sr4_vdd_sv_d_vdd_tie_sv_vdd_tg_d_a_tg_d_vdd_tg_fbm_vdd_tg_fbs_vdd_tg_s_vdd_vdd_vdd_b1_vdd_b2_vdd_b3_vdd_b4_vdd_link_vdd_link_dip_vdd_x1_vdd_x2_vdd_x3_t58 vdd__t58 vdd 109.655400001
* device instance a_d_inv_clk_vdd_inv_mc_vdd_inv_q_vdd_mpa_py_mpb_py_nand_m_vdd_nand_s2_vdd_nwell_vdd_sb_vdd_sr1_vdd_sr2_vdd_sr3_vdd_sr4_vdd_sv_d_vdd_tie_sv_vdd_tg_d_a_tg_d_vdd_tg_fbm_vdd_tg_fbs_vdd_tg_s_vdd_vdd_vdd_b1_vdd_b2_vdd_b3_vdd_b4_vdd_link_vdd_link_dip_vdd_x1_vdd_x2_vdd_x3_t59 r0 *1 0,0
Ra_d_inv_clk_vdd_inv_mc_vdd_inv_q_vdd_mpa_py_mpb_py_nand_m_vdd_nand_s2_vdd_nwell_vdd_sb_vdd_sr1_vdd_sr2_vdd_sr3_vdd_sr4_vdd_sv_d_vdd_tie_sv_vdd_tg_d_a_tg_d_vdd_tg_fbm_vdd_tg_fbs_vdd_tg_s_vdd_vdd_vdd_b1_vdd_b2_vdd_b3_vdd_b4_vdd_link_vdd_link_dip_vdd_x1_vdd_x2_vdd_x3_t59 vdd__t59 vdd 129.332460393
* device instance a_d_inv_clk_vdd_inv_mc_vdd_inv_q_vdd_mpa_py_mpb_py_nand_m_vdd_nand_s2_vdd_nwell_vdd_sb_vdd_sr1_vdd_sr2_vdd_sr3_vdd_sr4_vdd_sv_d_vdd_tie_sv_vdd_tg_d_a_tg_d_vdd_tg_fbm_vdd_tg_fbs_vdd_tg_s_vdd_vdd_vdd_b1_vdd_b2_vdd_b3_vdd_b4_vdd_link_vdd_link_dip_vdd_x1_vdd_x2_vdd_x3_t60 r0 *1 0,0
Ra_d_inv_clk_vdd_inv_mc_vdd_inv_q_vdd_mpa_py_mpb_py_nand_m_vdd_nand_s2_vdd_nwell_vdd_sb_vdd_sr1_vdd_sr2_vdd_sr3_vdd_sr4_vdd_sv_d_vdd_tie_sv_vdd_tg_d_a_tg_d_vdd_tg_fbm_vdd_tg_fbs_vdd_tg_s_vdd_vdd_vdd_b1_vdd_b2_vdd_b3_vdd_b4_vdd_link_vdd_link_dip_vdd_x1_vdd_x2_vdd_x3_t60 vdd__t60 vdd 147.729060078
* device instance a_d_inv_clk_vdd_inv_mc_vdd_inv_q_vdd_mpa_py_mpb_py_nand_m_vdd_nand_s2_vdd_nwell_vdd_sb_vdd_sr1_vdd_sr2_vdd_sr3_vdd_sr4_vdd_sv_d_vdd_tie_sv_vdd_tg_d_a_tg_d_vdd_tg_fbm_vdd_tg_fbs_vdd_tg_s_vdd_vdd_vdd_b1_vdd_b2_vdd_b3_vdd_b4_vdd_link_vdd_link_dip_vdd_x1_vdd_x2_vdd_x3_t61 r0 *1 0,0
Ra_d_inv_clk_vdd_inv_mc_vdd_inv_q_vdd_mpa_py_mpb_py_nand_m_vdd_nand_s2_vdd_nwell_vdd_sb_vdd_sr1_vdd_sr2_vdd_sr3_vdd_sr4_vdd_sv_d_vdd_tie_sv_vdd_tg_d_a_tg_d_vdd_tg_fbm_vdd_tg_fbs_vdd_tg_s_vdd_vdd_vdd_b1_vdd_b2_vdd_b3_vdd_b4_vdd_link_vdd_link_dip_vdd_x1_vdd_x2_vdd_x3_t61 vdd__t61 vdd 145.843562672
* device instance a_d_inv_clk_vdd_inv_mc_vdd_inv_q_vdd_mpa_py_mpb_py_nand_m_vdd_nand_s2_vdd_nwell_vdd_sb_vdd_sr1_vdd_sr2_vdd_sr3_vdd_sr4_vdd_sv_d_vdd_tie_sv_vdd_tg_d_a_tg_d_vdd_tg_fbm_vdd_tg_fbs_vdd_tg_s_vdd_vdd_vdd_b1_vdd_b2_vdd_b3_vdd_b4_vdd_link_vdd_link_dip_vdd_x1_vdd_x2_vdd_x3_t62 r0 *1 0,0
Ra_d_inv_clk_vdd_inv_mc_vdd_inv_q_vdd_mpa_py_mpb_py_nand_m_vdd_nand_s2_vdd_nwell_vdd_sb_vdd_sr1_vdd_sr2_vdd_sr3_vdd_sr4_vdd_sv_d_vdd_tie_sv_vdd_tg_d_a_tg_d_vdd_tg_fbm_vdd_tg_fbs_vdd_tg_s_vdd_vdd_vdd_b1_vdd_b2_vdd_b3_vdd_b4_vdd_link_vdd_link_dip_vdd_x1_vdd_x2_vdd_x3_t62 vdd__t62 vdd 117.405111309
* device instance a_d_inv_clk_vdd_inv_mc_vdd_inv_q_vdd_mpa_py_mpb_py_nand_m_vdd_nand_s2_vdd_nwell_vdd_sb_vdd_sr1_vdd_sr2_vdd_sr3_vdd_sr4_vdd_sv_d_vdd_tie_sv_vdd_tg_d_a_tg_d_vdd_tg_fbm_vdd_tg_fbs_vdd_tg_s_vdd_vdd_vdd_b1_vdd_b2_vdd_b3_vdd_b4_vdd_link_vdd_link_dip_vdd_x1_vdd_x2_vdd_x3_t63 r0 *1 0,0
Ra_d_inv_clk_vdd_inv_mc_vdd_inv_q_vdd_mpa_py_mpb_py_nand_m_vdd_nand_s2_vdd_nwell_vdd_sb_vdd_sr1_vdd_sr2_vdd_sr3_vdd_sr4_vdd_sv_d_vdd_tie_sv_vdd_tg_d_a_tg_d_vdd_tg_fbm_vdd_tg_fbs_vdd_tg_s_vdd_vdd_vdd_b1_vdd_b2_vdd_b3_vdd_b4_vdd_link_vdd_link_dip_vdd_x1_vdd_x2_vdd_x3_t63 vdd__t63 vdd 111.534033335
* device instance a_d_inv_clk_vdd_inv_mc_vdd_inv_q_vdd_mpa_py_mpb_py_nand_m_vdd_nand_s2_vdd_nwell_vdd_sb_vdd_sr1_vdd_sr2_vdd_sr3_vdd_sr4_vdd_sv_d_vdd_tie_sv_vdd_tg_d_a_tg_d_vdd_tg_fbm_vdd_tg_fbs_vdd_tg_s_vdd_vdd_vdd_b1_vdd_b2_vdd_b3_vdd_b4_vdd_link_vdd_link_dip_vdd_x1_vdd_x2_vdd_x3_t64 r0 *1 0,0
Ra_d_inv_clk_vdd_inv_mc_vdd_inv_q_vdd_mpa_py_mpb_py_nand_m_vdd_nand_s2_vdd_nwell_vdd_sb_vdd_sr1_vdd_sr2_vdd_sr3_vdd_sr4_vdd_sv_d_vdd_tie_sv_vdd_tg_d_a_tg_d_vdd_tg_fbm_vdd_tg_fbs_vdd_tg_s_vdd_vdd_vdd_b1_vdd_b2_vdd_b3_vdd_b4_vdd_link_vdd_link_dip_vdd_x1_vdd_x2_vdd_x3_t64 vdd__t64 vdd 199.79402836
* device instance a_d_inv_clk_vdd_inv_mc_vdd_inv_q_vdd_mpa_py_mpb_py_nand_m_vdd_nand_s2_vdd_nwell_vdd_sb_vdd_sr1_vdd_sr2_vdd_sr3_vdd_sr4_vdd_sv_d_vdd_tie_sv_vdd_tg_d_a_tg_d_vdd_tg_fbm_vdd_tg_fbs_vdd_tg_s_vdd_vdd_vdd_b1_vdd_b2_vdd_b3_vdd_b4_vdd_link_vdd_link_dip_vdd_x1_vdd_x2_vdd_x3_t65 r0 *1 0,0
Ra_d_inv_clk_vdd_inv_mc_vdd_inv_q_vdd_mpa_py_mpb_py_nand_m_vdd_nand_s2_vdd_nwell_vdd_sb_vdd_sr1_vdd_sr2_vdd_sr3_vdd_sr4_vdd_sv_d_vdd_tie_sv_vdd_tg_d_a_tg_d_vdd_tg_fbm_vdd_tg_fbs_vdd_tg_s_vdd_vdd_vdd_b1_vdd_b2_vdd_b3_vdd_b4_vdd_link_vdd_link_dip_vdd_x1_vdd_x2_vdd_x3_t65 vdd__t65 vdd 16.7710976171
* device instance a_d_inv_clk_vdd_inv_mc_vdd_inv_q_vdd_mpa_py_mpb_py_nand_m_vdd_nand_s2_vdd_nwell_vdd_sb_vdd_sr1_vdd_sr2_vdd_sr3_vdd_sr4_vdd_sv_d_vdd_tie_sv_vdd_tg_d_a_tg_d_vdd_tg_fbm_vdd_tg_fbs_vdd_tg_s_vdd_vdd_vdd_b1_vdd_b2_vdd_b3_vdd_b4_vdd_link_vdd_link_dip_vdd_x1_vdd_x2_vdd_x3_t66 r0 *1 0,0
Ra_d_inv_clk_vdd_inv_mc_vdd_inv_q_vdd_mpa_py_mpb_py_nand_m_vdd_nand_s2_vdd_nwell_vdd_sb_vdd_sr1_vdd_sr2_vdd_sr3_vdd_sr4_vdd_sv_d_vdd_tie_sv_vdd_tg_d_a_tg_d_vdd_tg_fbm_vdd_tg_fbs_vdd_tg_s_vdd_vdd_vdd_b1_vdd_b2_vdd_b3_vdd_b4_vdd_link_vdd_link_dip_vdd_x1_vdd_x2_vdd_x3_t66 vdd__t66 vdd 32.1712195844
* device instance a_d_inv_clk_vdd_inv_mc_vdd_inv_q_vdd_mpa_py_mpb_py_nand_m_vdd_nand_s2_vdd_nwell_vdd_sb_vdd_sr1_vdd_sr2_vdd_sr3_vdd_sr4_vdd_sv_d_vdd_tie_sv_vdd_tg_d_a_tg_d_vdd_tg_fbm_vdd_tg_fbs_vdd_tg_s_vdd_vdd_vdd_b1_vdd_b2_vdd_b3_vdd_b4_vdd_link_vdd_link_dip_vdd_x1_vdd_x2_vdd_x3_t67 r0 *1 0,0
Ra_d_inv_clk_vdd_inv_mc_vdd_inv_q_vdd_mpa_py_mpb_py_nand_m_vdd_nand_s2_vdd_nwell_vdd_sb_vdd_sr1_vdd_sr2_vdd_sr3_vdd_sr4_vdd_sv_d_vdd_tie_sv_vdd_tg_d_a_tg_d_vdd_tg_fbm_vdd_tg_fbs_vdd_tg_s_vdd_vdd_vdd_b1_vdd_b2_vdd_b3_vdd_b4_vdd_link_vdd_link_dip_vdd_x1_vdd_x2_vdd_x3_t67 vdd__t67 vdd 192.419727323
* device instance a_d_inv_clk_vdd_inv_mc_vdd_inv_q_vdd_mpa_py_mpb_py_nand_m_vdd_nand_s2_vdd_nwell_vdd_sb_vdd_sr1_vdd_sr2_vdd_sr3_vdd_sr4_vdd_sv_d_vdd_tie_sv_vdd_tg_d_a_tg_d_vdd_tg_fbm_vdd_tg_fbs_vdd_tg_s_vdd_vdd_vdd_b1_vdd_b2_vdd_b3_vdd_b4_vdd_link_vdd_link_dip_vdd_x1_vdd_x2_vdd_x3_t68 r0 *1 0,0
Ra_d_inv_clk_vdd_inv_mc_vdd_inv_q_vdd_mpa_py_mpb_py_nand_m_vdd_nand_s2_vdd_nwell_vdd_sb_vdd_sr1_vdd_sr2_vdd_sr3_vdd_sr4_vdd_sv_d_vdd_tie_sv_vdd_tg_d_a_tg_d_vdd_tg_fbm_vdd_tg_fbs_vdd_tg_s_vdd_vdd_vdd_b1_vdd_b2_vdd_b3_vdd_b4_vdd_link_vdd_link_dip_vdd_x1_vdd_x2_vdd_x3_t68 vdd__t68 vdd 171.163906087
* device instance a_d_inv_clk_vdd_inv_mc_vdd_inv_q_vdd_mpa_py_mpb_py_nand_m_vdd_nand_s2_vdd_nwell_vdd_sb_vdd_sr1_vdd_sr2_vdd_sr3_vdd_sr4_vdd_sv_d_vdd_tie_sv_vdd_tg_d_a_tg_d_vdd_tg_fbm_vdd_tg_fbs_vdd_tg_s_vdd_vdd_vdd_b1_vdd_b2_vdd_b3_vdd_b4_vdd_link_vdd_link_dip_vdd_x1_vdd_x2_vdd_x3_t69 r0 *1 0,0
Ra_d_inv_clk_vdd_inv_mc_vdd_inv_q_vdd_mpa_py_mpb_py_nand_m_vdd_nand_s2_vdd_nwell_vdd_sb_vdd_sr1_vdd_sr2_vdd_sr3_vdd_sr4_vdd_sv_d_vdd_tie_sv_vdd_tg_d_a_tg_d_vdd_tg_fbm_vdd_tg_fbs_vdd_tg_s_vdd_vdd_vdd_b1_vdd_b2_vdd_b3_vdd_b4_vdd_link_vdd_link_dip_vdd_x1_vdd_x2_vdd_x3_t69 vdd__t69 vdd 164.195083072
* device instance a_d_inv_clk_vdd_inv_mc_vdd_inv_q_vdd_mpa_py_mpb_py_nand_m_vdd_nand_s2_vdd_nwell_vdd_sb_vdd_sr1_vdd_sr2_vdd_sr3_vdd_sr4_vdd_sv_d_vdd_tie_sv_vdd_tg_d_a_tg_d_vdd_tg_fbm_vdd_tg_fbs_vdd_tg_s_vdd_vdd_vdd_b1_vdd_b2_vdd_b3_vdd_b4_vdd_link_vdd_link_dip_vdd_x1_vdd_x2_vdd_x3_t70 r0 *1 0,0
Ra_d_inv_clk_vdd_inv_mc_vdd_inv_q_vdd_mpa_py_mpb_py_nand_m_vdd_nand_s2_vdd_nwell_vdd_sb_vdd_sr1_vdd_sr2_vdd_sr3_vdd_sr4_vdd_sv_d_vdd_tie_sv_vdd_tg_d_a_tg_d_vdd_tg_fbm_vdd_tg_fbs_vdd_tg_s_vdd_vdd_vdd_b1_vdd_b2_vdd_b3_vdd_b4_vdd_link_vdd_link_dip_vdd_x1_vdd_x2_vdd_x3_t70 vdd__t70 vdd 156.680717448
* device instance a_d_inv_clk_vdd_inv_mc_vdd_inv_q_vdd_mpa_py_mpb_py_nand_m_vdd_nand_s2_vdd_nwell_vdd_sb_vdd_sr1_vdd_sr2_vdd_sr3_vdd_sr4_vdd_sv_d_vdd_tie_sv_vdd_tg_d_a_tg_d_vdd_tg_fbm_vdd_tg_fbs_vdd_tg_s_vdd_vdd_vdd_b1_vdd_b2_vdd_b3_vdd_b4_vdd_link_vdd_link_dip_vdd_x1_vdd_x2_vdd_x3_t71 r0 *1 0,0
Ra_d_inv_clk_vdd_inv_mc_vdd_inv_q_vdd_mpa_py_mpb_py_nand_m_vdd_nand_s2_vdd_nwell_vdd_sb_vdd_sr1_vdd_sr2_vdd_sr3_vdd_sr4_vdd_sv_d_vdd_tie_sv_vdd_tg_d_a_tg_d_vdd_tg_fbm_vdd_tg_fbs_vdd_tg_s_vdd_vdd_vdd_b1_vdd_b2_vdd_b3_vdd_b4_vdd_link_vdd_link_dip_vdd_x1_vdd_x2_vdd_x3_t71 vdd__t71 vdd 146.737616634
* device instance a_d_inv_clk_vdd_inv_mc_vdd_inv_q_vdd_mpa_py_mpb_py_nand_m_vdd_nand_s2_vdd_nwell_vdd_sb_vdd_sr1_vdd_sr2_vdd_sr3_vdd_sr4_vdd_sv_d_vdd_tie_sv_vdd_tg_d_a_tg_d_vdd_tg_fbm_vdd_tg_fbs_vdd_tg_s_vdd_vdd_vdd_b1_vdd_b2_vdd_b3_vdd_b4_vdd_link_vdd_link_dip_vdd_x1_vdd_x2_vdd_x3_t72 r0 *1 0,0
Ra_d_inv_clk_vdd_inv_mc_vdd_inv_q_vdd_mpa_py_mpb_py_nand_m_vdd_nand_s2_vdd_nwell_vdd_sb_vdd_sr1_vdd_sr2_vdd_sr3_vdd_sr4_vdd_sv_d_vdd_tie_sv_vdd_tg_d_a_tg_d_vdd_tg_fbm_vdd_tg_fbs_vdd_tg_s_vdd_vdd_vdd_b1_vdd_b2_vdd_b3_vdd_b4_vdd_link_vdd_link_dip_vdd_x1_vdd_x2_vdd_x3_t72 vdd__t72 vdd 21.7730597858
* device instance a_d_inv_clk_vdd_inv_mc_vdd_inv_q_vdd_mpa_py_mpb_py_nand_m_vdd_nand_s2_vdd_nwell_vdd_sb_vdd_sr1_vdd_sr2_vdd_sr3_vdd_sr4_vdd_sv_d_vdd_tie_sv_vdd_tg_d_a_tg_d_vdd_tg_fbm_vdd_tg_fbs_vdd_tg_s_vdd_vdd_vdd_b1_vdd_b2_vdd_b3_vdd_b4_vdd_link_vdd_link_dip_vdd_x1_vdd_x2_vdd_x3_t73 r0 *1 0,0
Ra_d_inv_clk_vdd_inv_mc_vdd_inv_q_vdd_mpa_py_mpb_py_nand_m_vdd_nand_s2_vdd_nwell_vdd_sb_vdd_sr1_vdd_sr2_vdd_sr3_vdd_sr4_vdd_sv_d_vdd_tie_sv_vdd_tg_d_a_tg_d_vdd_tg_fbm_vdd_tg_fbs_vdd_tg_s_vdd_vdd_vdd_b1_vdd_b2_vdd_b3_vdd_b4_vdd_link_vdd_link_dip_vdd_x1_vdd_x2_vdd_x3_t73 vdd__t73 vdd 128.515620516
* device instance a_d_inv_clk_vdd_inv_mc_vdd_inv_q_vdd_mpa_py_mpb_py_nand_m_vdd_nand_s2_vdd_nwell_vdd_sb_vdd_sr1_vdd_sr2_vdd_sr3_vdd_sr4_vdd_sv_d_vdd_tie_sv_vdd_tg_d_a_tg_d_vdd_tg_fbm_vdd_tg_fbs_vdd_tg_s_vdd_vdd_vdd_b1_vdd_b2_vdd_b3_vdd_b4_vdd_link_vdd_link_dip_vdd_x1_vdd_x2_vdd_x3_t74 r0 *1 0,0
Ra_d_inv_clk_vdd_inv_mc_vdd_inv_q_vdd_mpa_py_mpb_py_nand_m_vdd_nand_s2_vdd_nwell_vdd_sb_vdd_sr1_vdd_sr2_vdd_sr3_vdd_sr4_vdd_sv_d_vdd_tie_sv_vdd_tg_d_a_tg_d_vdd_tg_fbm_vdd_tg_fbs_vdd_tg_s_vdd_vdd_vdd_b1_vdd_b2_vdd_b3_vdd_b4_vdd_link_vdd_link_dip_vdd_x1_vdd_x2_vdd_x3_t74 vdd__t74 vdd 181.661562025
* device instance a_d_inv_clk_vdd_inv_mc_vdd_inv_q_vdd_mpa_py_mpb_py_nand_m_vdd_nand_s2_vdd_nwell_vdd_sb_vdd_sr1_vdd_sr2_vdd_sr3_vdd_sr4_vdd_sv_d_vdd_tie_sv_vdd_tg_d_a_tg_d_vdd_tg_fbm_vdd_tg_fbs_vdd_tg_s_vdd_vdd_vdd_b1_vdd_b2_vdd_b3_vdd_b4_vdd_link_vdd_link_dip_vdd_x1_vdd_x2_vdd_x3_t75 r0 *1 0,0
Ra_d_inv_clk_vdd_inv_mc_vdd_inv_q_vdd_mpa_py_mpb_py_nand_m_vdd_nand_s2_vdd_nwell_vdd_sb_vdd_sr1_vdd_sr2_vdd_sr3_vdd_sr4_vdd_sv_d_vdd_tie_sv_vdd_tg_d_a_tg_d_vdd_tg_fbm_vdd_tg_fbs_vdd_tg_s_vdd_vdd_vdd_b1_vdd_b2_vdd_b3_vdd_b4_vdd_link_vdd_link_dip_vdd_x1_vdd_x2_vdd_x3_t75 vdd__t75 vdd 38.4771181778
* device instance a_d_inv_clk_vdd_inv_mc_vdd_inv_q_vdd_mpa_py_mpb_py_nand_m_vdd_nand_s2_vdd_nwell_vdd_sb_vdd_sr1_vdd_sr2_vdd_sr3_vdd_sr4_vdd_sv_d_vdd_tie_sv_vdd_tg_d_a_tg_d_vdd_tg_fbm_vdd_tg_fbs_vdd_tg_s_vdd_vdd_vdd_b1_vdd_b2_vdd_b3_vdd_b4_vdd_link_vdd_link_dip_vdd_x1_vdd_x2_vdd_x3_t76 r0 *1 0,0
Ra_d_inv_clk_vdd_inv_mc_vdd_inv_q_vdd_mpa_py_mpb_py_nand_m_vdd_nand_s2_vdd_nwell_vdd_sb_vdd_sr1_vdd_sr2_vdd_sr3_vdd_sr4_vdd_sv_d_vdd_tie_sv_vdd_tg_d_a_tg_d_vdd_tg_fbm_vdd_tg_fbs_vdd_tg_s_vdd_vdd_vdd_b1_vdd_b2_vdd_b3_vdd_b4_vdd_link_vdd_link_dip_vdd_x1_vdd_x2_vdd_x3_t76 vdd__t76 vdd 118.05949851
* device instance a_d_inv_clk_vdd_inv_mc_vdd_inv_q_vdd_mpa_py_mpb_py_nand_m_vdd_nand_s2_vdd_nwell_vdd_sb_vdd_sr1_vdd_sr2_vdd_sr3_vdd_sr4_vdd_sv_d_vdd_tie_sv_vdd_tg_d_a_tg_d_vdd_tg_fbm_vdd_tg_fbs_vdd_tg_s_vdd_vdd_vdd_b1_vdd_b2_vdd_b3_vdd_b4_vdd_link_vdd_link_dip_vdd_x1_vdd_x2_vdd_x3_t77 r0 *1 0,0
Ra_d_inv_clk_vdd_inv_mc_vdd_inv_q_vdd_mpa_py_mpb_py_nand_m_vdd_nand_s2_vdd_nwell_vdd_sb_vdd_sr1_vdd_sr2_vdd_sr3_vdd_sr4_vdd_sv_d_vdd_tie_sv_vdd_tg_d_a_tg_d_vdd_tg_fbm_vdd_tg_fbs_vdd_tg_s_vdd_vdd_vdd_b1_vdd_b2_vdd_b3_vdd_b4_vdd_link_vdd_link_dip_vdd_x1_vdd_x2_vdd_x3_t77 vdd__t77 vdd 111.123919524
* device instance a_d_inv_clk_vdd_inv_mc_vdd_inv_q_vdd_mpa_py_mpb_py_nand_m_vdd_nand_s2_vdd_nwell_vdd_sb_vdd_sr1_vdd_sr2_vdd_sr3_vdd_sr4_vdd_sv_d_vdd_tie_sv_vdd_tg_d_a_tg_d_vdd_tg_fbm_vdd_tg_fbs_vdd_tg_s_vdd_vdd_vdd_b1_vdd_b2_vdd_b3_vdd_b4_vdd_link_vdd_link_dip_vdd_x1_vdd_x2_vdd_x3_t78 r0 *1 0,0
Ra_d_inv_clk_vdd_inv_mc_vdd_inv_q_vdd_mpa_py_mpb_py_nand_m_vdd_nand_s2_vdd_nwell_vdd_sb_vdd_sr1_vdd_sr2_vdd_sr3_vdd_sr4_vdd_sv_d_vdd_tie_sv_vdd_tg_d_a_tg_d_vdd_tg_fbm_vdd_tg_fbs_vdd_tg_s_vdd_vdd_vdd_b1_vdd_b2_vdd_b3_vdd_b4_vdd_link_vdd_link_dip_vdd_x1_vdd_x2_vdd_x3_t78 vdd__t78 vdd 54.7575311569
* device instance a_d_inv_clk_vdd_inv_mc_vdd_inv_q_vdd_mpa_py_mpb_py_nand_m_vdd_nand_s2_vdd_nwell_vdd_sb_vdd_sr1_vdd_sr2_vdd_sr3_vdd_sr4_vdd_sv_d_vdd_tie_sv_vdd_tg_d_a_tg_d_vdd_tg_fbm_vdd_tg_fbs_vdd_tg_s_vdd_vdd_vdd_b1_vdd_b2_vdd_b3_vdd_b4_vdd_link_vdd_link_dip_vdd_x1_vdd_x2_vdd_x3_t79 r0 *1 0,0
Ra_d_inv_clk_vdd_inv_mc_vdd_inv_q_vdd_mpa_py_mpb_py_nand_m_vdd_nand_s2_vdd_nwell_vdd_sb_vdd_sr1_vdd_sr2_vdd_sr3_vdd_sr4_vdd_sv_d_vdd_tie_sv_vdd_tg_d_a_tg_d_vdd_tg_fbm_vdd_tg_fbs_vdd_tg_s_vdd_vdd_vdd_b1_vdd_b2_vdd_b3_vdd_b4_vdd_link_vdd_link_dip_vdd_x1_vdd_x2_vdd_x3_t79 vdd__t79 vdd 90.041836416
* device instance a_d_inv_clk_vdd_inv_mc_vdd_inv_q_vdd_mpa_py_mpb_py_nand_m_vdd_nand_s2_vdd_nwell_vdd_sb_vdd_sr1_vdd_sr2_vdd_sr3_vdd_sr4_vdd_sv_d_vdd_tie_sv_vdd_tg_d_a_tg_d_vdd_tg_fbm_vdd_tg_fbs_vdd_tg_s_vdd_vdd_vdd_b1_vdd_b2_vdd_b3_vdd_b4_vdd_link_vdd_link_dip_vdd_x1_vdd_x2_vdd_x3_t80 r0 *1 0,0
Ra_d_inv_clk_vdd_inv_mc_vdd_inv_q_vdd_mpa_py_mpb_py_nand_m_vdd_nand_s2_vdd_nwell_vdd_sb_vdd_sr1_vdd_sr2_vdd_sr3_vdd_sr4_vdd_sv_d_vdd_tie_sv_vdd_tg_d_a_tg_d_vdd_tg_fbm_vdd_tg_fbs_vdd_tg_s_vdd_vdd_vdd_b1_vdd_b2_vdd_b3_vdd_b4_vdd_link_vdd_link_dip_vdd_x1_vdd_x2_vdd_x3_t80 vdd__t80 vdd 83.1534323261
* device instance a_d_inv_clk_vdd_inv_mc_vdd_inv_q_vdd_mpa_py_mpb_py_nand_m_vdd_nand_s2_vdd_nwell_vdd_sb_vdd_sr1_vdd_sr2_vdd_sr3_vdd_sr4_vdd_sv_d_vdd_tie_sv_vdd_tg_d_a_tg_d_vdd_tg_fbm_vdd_tg_fbs_vdd_tg_s_vdd_vdd_vdd_b1_vdd_b2_vdd_b3_vdd_b4_vdd_link_vdd_link_dip_vdd_x1_vdd_x2_vdd_x3_t81 r0 *1 0,0
Ra_d_inv_clk_vdd_inv_mc_vdd_inv_q_vdd_mpa_py_mpb_py_nand_m_vdd_nand_s2_vdd_nwell_vdd_sb_vdd_sr1_vdd_sr2_vdd_sr3_vdd_sr4_vdd_sv_d_vdd_tie_sv_vdd_tg_d_a_tg_d_vdd_tg_fbm_vdd_tg_fbs_vdd_tg_s_vdd_vdd_vdd_b1_vdd_b2_vdd_b3_vdd_b4_vdd_link_vdd_link_dip_vdd_x1_vdd_x2_vdd_x3_t81 vdd__t81 vdd 56.5886909333
* device instance a_d_inv_clk_vdd_inv_mc_vdd_inv_q_vdd_mpa_py_mpb_py_nand_m_vdd_nand_s2_vdd_nwell_vdd_sb_vdd_sr1_vdd_sr2_vdd_sr3_vdd_sr4_vdd_sv_d_vdd_tie_sv_vdd_tg_d_a_tg_d_vdd_tg_fbm_vdd_tg_fbs_vdd_tg_s_vdd_vdd_vdd_b1_vdd_b2_vdd_b3_vdd_b4_vdd_link_vdd_link_dip_vdd_x1_vdd_x2_vdd_x3_t82 r0 *1 0,0
Ra_d_inv_clk_vdd_inv_mc_vdd_inv_q_vdd_mpa_py_mpb_py_nand_m_vdd_nand_s2_vdd_nwell_vdd_sb_vdd_sr1_vdd_sr2_vdd_sr3_vdd_sr4_vdd_sv_d_vdd_tie_sv_vdd_tg_d_a_tg_d_vdd_tg_fbm_vdd_tg_fbs_vdd_tg_s_vdd_vdd_vdd_b1_vdd_b2_vdd_b3_vdd_b4_vdd_link_vdd_link_dip_vdd_x1_vdd_x2_vdd_x3_t82 vdd__t82 vdd 48.3329915273
* device instance a_d_inv_clk_vdd_inv_mc_vdd_inv_q_vdd_mpa_py_mpb_py_nand_m_vdd_nand_s2_vdd_nwell_vdd_sb_vdd_sr1_vdd_sr2_vdd_sr3_vdd_sr4_vdd_sv_d_vdd_tie_sv_vdd_tg_d_a_tg_d_vdd_tg_fbm_vdd_tg_fbs_vdd_tg_s_vdd_vdd_vdd_b1_vdd_b2_vdd_b3_vdd_b4_vdd_link_vdd_link_dip_vdd_x1_vdd_x2_vdd_x3_t83 r0 *1 0,0
Ra_d_inv_clk_vdd_inv_mc_vdd_inv_q_vdd_mpa_py_mpb_py_nand_m_vdd_nand_s2_vdd_nwell_vdd_sb_vdd_sr1_vdd_sr2_vdd_sr3_vdd_sr4_vdd_sv_d_vdd_tie_sv_vdd_tg_d_a_tg_d_vdd_tg_fbm_vdd_tg_fbs_vdd_tg_s_vdd_vdd_vdd_b1_vdd_b2_vdd_b3_vdd_b4_vdd_link_vdd_link_dip_vdd_x1_vdd_x2_vdd_x3_t83 vdd__t83 vdd 65.9867039863
* device instance a_d_inv_clk_vdd_inv_mc_vdd_inv_q_vdd_mpa_py_mpb_py_nand_m_vdd_nand_s2_vdd_nwell_vdd_sb_vdd_sr1_vdd_sr2_vdd_sr3_vdd_sr4_vdd_sv_d_vdd_tie_sv_vdd_tg_d_a_tg_d_vdd_tg_fbm_vdd_tg_fbs_vdd_tg_s_vdd_vdd_vdd_b1_vdd_b2_vdd_b3_vdd_b4_vdd_link_vdd_link_dip_vdd_x1_vdd_x2_vdd_x3_t84 r0 *1 0,0
Ra_d_inv_clk_vdd_inv_mc_vdd_inv_q_vdd_mpa_py_mpb_py_nand_m_vdd_nand_s2_vdd_nwell_vdd_sb_vdd_sr1_vdd_sr2_vdd_sr3_vdd_sr4_vdd_sv_d_vdd_tie_sv_vdd_tg_d_a_tg_d_vdd_tg_fbm_vdd_tg_fbs_vdd_tg_s_vdd_vdd_vdd_b1_vdd_b2_vdd_b3_vdd_b4_vdd_link_vdd_link_dip_vdd_x1_vdd_x2_vdd_x3_t84 vdd__t84 vdd 75.7454064487
* device instance a_d_inv_clk_vdd_inv_mc_vdd_inv_q_vdd_mpa_py_mpb_py_nand_m_vdd_nand_s2_vdd_nwell_vdd_sb_vdd_sr1_vdd_sr2_vdd_sr3_vdd_sr4_vdd_sv_d_vdd_tie_sv_vdd_tg_d_a_tg_d_vdd_tg_fbm_vdd_tg_fbs_vdd_tg_s_vdd_vdd_vdd_b1_vdd_b2_vdd_b3_vdd_b4_vdd_link_vdd_link_dip_vdd_x1_vdd_x2_vdd_x3_t85 r0 *1 0,0
Ra_d_inv_clk_vdd_inv_mc_vdd_inv_q_vdd_mpa_py_mpb_py_nand_m_vdd_nand_s2_vdd_nwell_vdd_sb_vdd_sr1_vdd_sr2_vdd_sr3_vdd_sr4_vdd_sv_d_vdd_tie_sv_vdd_tg_d_a_tg_d_vdd_tg_fbm_vdd_tg_fbs_vdd_tg_s_vdd_vdd_vdd_b1_vdd_b2_vdd_b3_vdd_b4_vdd_link_vdd_link_dip_vdd_x1_vdd_x2_vdd_x3_t85 vdd__t85 vdd 23.2370884501
* device instance a_d_inv_clk_vdd_inv_mc_vdd_inv_q_vdd_mpa_py_mpb_py_nand_m_vdd_nand_s2_vdd_nwell_vdd_sb_vdd_sr1_vdd_sr2_vdd_sr3_vdd_sr4_vdd_sv_d_vdd_tie_sv_vdd_tg_d_a_tg_d_vdd_tg_fbm_vdd_tg_fbs_vdd_tg_s_vdd_vdd_vdd_b1_vdd_b2_vdd_b3_vdd_b4_vdd_link_vdd_link_dip_vdd_x1_vdd_x2_vdd_x3_t86 r0 *1 0,0
Ra_d_inv_clk_vdd_inv_mc_vdd_inv_q_vdd_mpa_py_mpb_py_nand_m_vdd_nand_s2_vdd_nwell_vdd_sb_vdd_sr1_vdd_sr2_vdd_sr3_vdd_sr4_vdd_sv_d_vdd_tie_sv_vdd_tg_d_a_tg_d_vdd_tg_fbm_vdd_tg_fbs_vdd_tg_s_vdd_vdd_vdd_b1_vdd_b2_vdd_b3_vdd_b4_vdd_link_vdd_link_dip_vdd_x1_vdd_x2_vdd_x3_t86 vdd__t86 vdd 164.187771856
* device instance a_d_inv_clk_vdd_inv_mc_vdd_inv_q_vdd_mpa_py_mpb_py_nand_m_vdd_nand_s2_vdd_nwell_vdd_sb_vdd_sr1_vdd_sr2_vdd_sr3_vdd_sr4_vdd_sv_d_vdd_tie_sv_vdd_tg_d_a_tg_d_vdd_tg_fbm_vdd_tg_fbs_vdd_tg_s_vdd_vdd_vdd_b1_vdd_b2_vdd_b3_vdd_b4_vdd_link_vdd_link_dip_vdd_x1_vdd_x2_vdd_x3_t87 r0 *1 0,0
Ra_d_inv_clk_vdd_inv_mc_vdd_inv_q_vdd_mpa_py_mpb_py_nand_m_vdd_nand_s2_vdd_nwell_vdd_sb_vdd_sr1_vdd_sr2_vdd_sr3_vdd_sr4_vdd_sv_d_vdd_tie_sv_vdd_tg_d_a_tg_d_vdd_tg_fbm_vdd_tg_fbs_vdd_tg_s_vdd_vdd_vdd_b1_vdd_b2_vdd_b3_vdd_b4_vdd_link_vdd_link_dip_vdd_x1_vdd_x2_vdd_x3_t87 vdd__t87 vdd 157.221525534
* device instance a_d_inv_clk_vdd_inv_mc_vdd_inv_q_vdd_mpa_py_mpb_py_nand_m_vdd_nand_s2_vdd_nwell_vdd_sb_vdd_sr1_vdd_sr2_vdd_sr3_vdd_sr4_vdd_sv_d_vdd_tie_sv_vdd_tg_d_a_tg_d_vdd_tg_fbm_vdd_tg_fbs_vdd_tg_s_vdd_vdd_vdd_b1_vdd_b2_vdd_b3_vdd_b4_vdd_link_vdd_link_dip_vdd_x1_vdd_x2_vdd_x3_t88 r0 *1 0,0
Ra_d_inv_clk_vdd_inv_mc_vdd_inv_q_vdd_mpa_py_mpb_py_nand_m_vdd_nand_s2_vdd_nwell_vdd_sb_vdd_sr1_vdd_sr2_vdd_sr3_vdd_sr4_vdd_sv_d_vdd_tie_sv_vdd_tg_d_a_tg_d_vdd_tg_fbm_vdd_tg_fbs_vdd_tg_s_vdd_vdd_vdd_b1_vdd_b2_vdd_b3_vdd_b4_vdd_link_vdd_link_dip_vdd_x1_vdd_x2_vdd_x3_t88 vdd__t88 vdd 136.006524416
* device instance a_d_inv_clk_vdd_inv_mc_vdd_inv_q_vdd_mpa_py_mpb_py_nand_m_vdd_nand_s2_vdd_nwell_vdd_sb_vdd_sr1_vdd_sr2_vdd_sr3_vdd_sr4_vdd_sv_d_vdd_tie_sv_vdd_tg_d_a_tg_d_vdd_tg_fbm_vdd_tg_fbs_vdd_tg_s_vdd_vdd_vdd_b1_vdd_b2_vdd_b3_vdd_b4_vdd_link_vdd_link_dip_vdd_x1_vdd_x2_vdd_x3_t89 r0 *1 0,0
Ra_d_inv_clk_vdd_inv_mc_vdd_inv_q_vdd_mpa_py_mpb_py_nand_m_vdd_nand_s2_vdd_nwell_vdd_sb_vdd_sr1_vdd_sr2_vdd_sr3_vdd_sr4_vdd_sv_d_vdd_tie_sv_vdd_tg_d_a_tg_d_vdd_tg_fbm_vdd_tg_fbs_vdd_tg_s_vdd_vdd_vdd_b1_vdd_b2_vdd_b3_vdd_b4_vdd_link_vdd_link_dip_vdd_x1_vdd_x2_vdd_x3_t89 vdd__t89 vdd 129.05517831
* device instance a_d_inv_clk_vdd_inv_mc_vdd_inv_q_vdd_mpa_py_mpb_py_nand_m_vdd_nand_s2_vdd_nwell_vdd_sb_vdd_sr1_vdd_sr2_vdd_sr3_vdd_sr4_vdd_sv_d_vdd_tie_sv_vdd_tg_d_a_tg_d_vdd_tg_fbm_vdd_tg_fbs_vdd_tg_s_vdd_vdd_vdd_b1_vdd_b2_vdd_b3_vdd_b4_vdd_link_vdd_link_dip_vdd_x1_vdd_x2_vdd_x3_t90 r0 *1 0,0
Ra_d_inv_clk_vdd_inv_mc_vdd_inv_q_vdd_mpa_py_mpb_py_nand_m_vdd_nand_s2_vdd_nwell_vdd_sb_vdd_sr1_vdd_sr2_vdd_sr3_vdd_sr4_vdd_sv_d_vdd_tie_sv_vdd_tg_d_a_tg_d_vdd_tg_fbm_vdd_tg_fbs_vdd_tg_s_vdd_vdd_vdd_b1_vdd_b2_vdd_b3_vdd_b4_vdd_link_vdd_link_dip_vdd_x1_vdd_x2_vdd_x3_t90 vdd__t90 vdd 118.598348776
* device instance a_d_inv_clk_vdd_inv_mc_vdd_inv_q_vdd_mpa_py_mpb_py_nand_m_vdd_nand_s2_vdd_nwell_vdd_sb_vdd_sr1_vdd_sr2_vdd_sr3_vdd_sr4_vdd_sv_d_vdd_tie_sv_vdd_tg_d_a_tg_d_vdd_tg_fbm_vdd_tg_fbs_vdd_tg_s_vdd_vdd_vdd_b1_vdd_b2_vdd_b3_vdd_b4_vdd_link_vdd_link_dip_vdd_x1_vdd_x2_vdd_x3_t91 r0 *1 0,0
Ra_d_inv_clk_vdd_inv_mc_vdd_inv_q_vdd_mpa_py_mpb_py_nand_m_vdd_nand_s2_vdd_nwell_vdd_sb_vdd_sr1_vdd_sr2_vdd_sr3_vdd_sr4_vdd_sv_d_vdd_tie_sv_vdd_tg_d_a_tg_d_vdd_tg_fbm_vdd_tg_fbs_vdd_tg_s_vdd_vdd_vdd_b1_vdd_b2_vdd_b3_vdd_b4_vdd_link_vdd_link_dip_vdd_x1_vdd_x2_vdd_x3_t91 vdd__t91 vdd 182.380731422
* device instance a_d_inv_clk_vdd_inv_mc_vdd_inv_q_vdd_mpa_py_mpb_py_nand_m_vdd_nand_s2_vdd_nwell_vdd_sb_vdd_sr1_vdd_sr2_vdd_sr3_vdd_sr4_vdd_sv_d_vdd_tie_sv_vdd_tg_d_a_tg_d_vdd_tg_fbm_vdd_tg_fbs_vdd_tg_s_vdd_vdd_vdd_b1_vdd_b2_vdd_b3_vdd_b4_vdd_link_vdd_link_dip_vdd_x1_vdd_x2_vdd_x3_t92 r0 *1 0,0
Ra_d_inv_clk_vdd_inv_mc_vdd_inv_q_vdd_mpa_py_mpb_py_nand_m_vdd_nand_s2_vdd_nwell_vdd_sb_vdd_sr1_vdd_sr2_vdd_sr3_vdd_sr4_vdd_sv_d_vdd_tie_sv_vdd_tg_d_a_tg_d_vdd_tg_fbm_vdd_tg_fbs_vdd_tg_s_vdd_vdd_vdd_b1_vdd_b2_vdd_b3_vdd_b4_vdd_link_vdd_link_dip_vdd_x1_vdd_x2_vdd_x3_t92 vdd__t92 vdd 180.492128585
* device instance a_d_inv_clk_vdd_inv_mc_vdd_inv_q_vdd_mpa_py_mpb_py_nand_m_vdd_nand_s2_vdd_nwell_vdd_sb_vdd_sr1_vdd_sr2_vdd_sr3_vdd_sr4_vdd_sv_d_vdd_tie_sv_vdd_tg_d_a_tg_d_vdd_tg_fbm_vdd_tg_fbs_vdd_tg_s_vdd_vdd_vdd_b1_vdd_b2_vdd_b3_vdd_b4_vdd_link_vdd_link_dip_vdd_x1_vdd_x2_vdd_x3_t93 r0 *1 0,0
Ra_d_inv_clk_vdd_inv_mc_vdd_inv_q_vdd_mpa_py_mpb_py_nand_m_vdd_nand_s2_vdd_nwell_vdd_sb_vdd_sr1_vdd_sr2_vdd_sr3_vdd_sr4_vdd_sv_d_vdd_tie_sv_vdd_tg_d_a_tg_d_vdd_tg_fbm_vdd_tg_fbs_vdd_tg_s_vdd_vdd_vdd_b1_vdd_b2_vdd_b3_vdd_b4_vdd_link_vdd_link_dip_vdd_x1_vdd_x2_vdd_x3_t93 vdd__t93 vdd 38.9766503848
* device instance a_d_inv_clk_vdd_inv_mc_vdd_inv_q_vdd_mpa_py_mpb_py_nand_m_vdd_nand_s2_vdd_nwell_vdd_sb_vdd_sr1_vdd_sr2_vdd_sr3_vdd_sr4_vdd_sv_d_vdd_tie_sv_vdd_tg_d_a_tg_d_vdd_tg_fbm_vdd_tg_fbs_vdd_tg_s_vdd_vdd_vdd_b1_vdd_b2_vdd_b3_vdd_b4_vdd_link_vdd_link_dip_vdd_x1_vdd_x2_vdd_x3_t94 r0 *1 0,0
Ra_d_inv_clk_vdd_inv_mc_vdd_inv_q_vdd_mpa_py_mpb_py_nand_m_vdd_nand_s2_vdd_nwell_vdd_sb_vdd_sr1_vdd_sr2_vdd_sr3_vdd_sr4_vdd_sv_d_vdd_tie_sv_vdd_tg_d_a_tg_d_vdd_tg_fbm_vdd_tg_fbs_vdd_tg_s_vdd_vdd_vdd_b1_vdd_b2_vdd_b3_vdd_b4_vdd_link_vdd_link_dip_vdd_x1_vdd_x2_vdd_x3_t94 vdd__t94 vdd 23.2346706982
* device instance a_d_inv_clk_vdd_inv_mc_vdd_inv_q_vdd_mpa_py_mpb_py_nand_m_vdd_nand_s2_vdd_nwell_vdd_sb_vdd_sr1_vdd_sr2_vdd_sr3_vdd_sr4_vdd_sv_d_vdd_tie_sv_vdd_tg_d_a_tg_d_vdd_tg_fbm_vdd_tg_fbs_vdd_tg_s_vdd_vdd_vdd_b1_vdd_b2_vdd_b3_vdd_b4_vdd_link_vdd_link_dip_vdd_x1_vdd_x2_vdd_x3_t95 r0 *1 0,0
Ra_d_inv_clk_vdd_inv_mc_vdd_inv_q_vdd_mpa_py_mpb_py_nand_m_vdd_nand_s2_vdd_nwell_vdd_sb_vdd_sr1_vdd_sr2_vdd_sr3_vdd_sr4_vdd_sv_d_vdd_tie_sv_vdd_tg_d_a_tg_d_vdd_tg_fbm_vdd_tg_fbs_vdd_tg_s_vdd_vdd_vdd_b1_vdd_b2_vdd_b3_vdd_b4_vdd_link_vdd_link_dip_vdd_x1_vdd_x2_vdd_x3_t95 vdd__t95 vdd 100.442732907
* device instance a_d_inv_clk_vdd_inv_mc_vdd_inv_q_vdd_mpa_py_mpb_py_nand_m_vdd_nand_s2_vdd_nwell_vdd_sb_vdd_sr1_vdd_sr2_vdd_sr3_vdd_sr4_vdd_sv_d_vdd_tie_sv_vdd_tg_d_a_tg_d_vdd_tg_fbm_vdd_tg_fbs_vdd_tg_s_vdd_vdd_vdd_b1_vdd_b2_vdd_b3_vdd_b4_vdd_link_vdd_link_dip_vdd_x1_vdd_x2_vdd_x3_t96 r0 *1 0,0
Ra_d_inv_clk_vdd_inv_mc_vdd_inv_q_vdd_mpa_py_mpb_py_nand_m_vdd_nand_s2_vdd_nwell_vdd_sb_vdd_sr1_vdd_sr2_vdd_sr3_vdd_sr4_vdd_sv_d_vdd_tie_sv_vdd_tg_d_a_tg_d_vdd_tg_fbm_vdd_tg_fbs_vdd_tg_s_vdd_vdd_vdd_b1_vdd_b2_vdd_b3_vdd_b4_vdd_link_vdd_link_dip_vdd_x1_vdd_x2_vdd_x3_t96 vdd__t96 vdd 48.8489499379
* device instance a_d_inv_clk_vdd_inv_mc_vdd_inv_q_vdd_mpa_py_mpb_py_nand_m_vdd_nand_s2_vdd_nwell_vdd_sb_vdd_sr1_vdd_sr2_vdd_sr3_vdd_sr4_vdd_sv_d_vdd_tie_sv_vdd_tg_d_a_tg_d_vdd_tg_fbm_vdd_tg_fbs_vdd_tg_s_vdd_vdd_vdd_b1_vdd_b2_vdd_b3_vdd_b4_vdd_link_vdd_link_dip_vdd_x1_vdd_x2_vdd_x3_t97 r0 *1 0,0
Ra_d_inv_clk_vdd_inv_mc_vdd_inv_q_vdd_mpa_py_mpb_py_nand_m_vdd_nand_s2_vdd_nwell_vdd_sb_vdd_sr1_vdd_sr2_vdd_sr3_vdd_sr4_vdd_sv_d_vdd_tie_sv_vdd_tg_d_a_tg_d_vdd_tg_fbm_vdd_tg_fbs_vdd_tg_s_vdd_vdd_vdd_b1_vdd_b2_vdd_b3_vdd_b4_vdd_link_vdd_link_dip_vdd_x1_vdd_x2_vdd_x3_t97 vdd__t97 vdd 32.209780801
* device instance a_d_inv_clk_vdd_inv_mc_vdd_inv_q_vdd_mpa_py_mpb_py_nand_m_vdd_nand_s2_vdd_nwell_vdd_sb_vdd_sr1_vdd_sr2_vdd_sr3_vdd_sr4_vdd_sv_d_vdd_tie_sv_vdd_tg_d_a_tg_d_vdd_tg_fbm_vdd_tg_fbs_vdd_tg_s_vdd_vdd_vdd_b1_vdd_b2_vdd_b3_vdd_b4_vdd_link_vdd_link_dip_vdd_x1_vdd_x2_vdd_x3_t98 r0 *1 0,0
Ra_d_inv_clk_vdd_inv_mc_vdd_inv_q_vdd_mpa_py_mpb_py_nand_m_vdd_nand_s2_vdd_nwell_vdd_sb_vdd_sr1_vdd_sr2_vdd_sr3_vdd_sr4_vdd_sv_d_vdd_tie_sv_vdd_tg_d_a_tg_d_vdd_tg_fbm_vdd_tg_fbs_vdd_tg_s_vdd_vdd_vdd_b1_vdd_b2_vdd_b3_vdd_b4_vdd_link_vdd_link_dip_vdd_x1_vdd_x2_vdd_x3_t98 vdd__t98 vdd 30.522932681
* device instance a_d_inv_clk_vdd_inv_mc_vdd_inv_q_vdd_mpa_py_mpb_py_nand_m_vdd_nand_s2_vdd_nwell_vdd_sb_vdd_sr1_vdd_sr2_vdd_sr3_vdd_sr4_vdd_sv_d_vdd_tie_sv_vdd_tg_d_a_tg_d_vdd_tg_fbm_vdd_tg_fbs_vdd_tg_s_vdd_vdd_vdd_b1_vdd_b2_vdd_b3_vdd_b4_vdd_link_vdd_link_dip_vdd_x1_vdd_x2_vdd_x3_t99 r0 *1 0,0
Ra_d_inv_clk_vdd_inv_mc_vdd_inv_q_vdd_mpa_py_mpb_py_nand_m_vdd_nand_s2_vdd_nwell_vdd_sb_vdd_sr1_vdd_sr2_vdd_sr3_vdd_sr4_vdd_sv_d_vdd_tie_sv_vdd_tg_d_a_tg_d_vdd_tg_fbm_vdd_tg_fbs_vdd_tg_s_vdd_vdd_vdd_b1_vdd_b2_vdd_b3_vdd_b4_vdd_link_vdd_link_dip_vdd_x1_vdd_x2_vdd_x3_t99 vdd__t99 vdd 137.245030204
* device instance a_d_inv_clk_vdd_inv_mc_vdd_inv_q_vdd_mpa_py_mpb_py_nand_m_vdd_nand_s2_vdd_nwell_vdd_sb_vdd_sr1_vdd_sr2_vdd_sr3_vdd_sr4_vdd_sv_d_vdd_tie_sv_vdd_tg_d_a_tg_d_vdd_tg_fbm_vdd_tg_fbs_vdd_tg_s_vdd_vdd_vdd_b1_vdd_b2_vdd_b3_vdd_b4_vdd_link_vdd_link_dip_vdd_x1_vdd_x2_vdd_x3_t100 r0 *1 0,0
Ra_d_inv_clk_vdd_inv_mc_vdd_inv_q_vdd_mpa_py_mpb_py_nand_m_vdd_nand_s2_vdd_nwell_vdd_sb_vdd_sr1_vdd_sr2_vdd_sr3_vdd_sr4_vdd_sv_d_vdd_tie_sv_vdd_tg_d_a_tg_d_vdd_tg_fbm_vdd_tg_fbs_vdd_tg_s_vdd_vdd_vdd_b1_vdd_b2_vdd_b3_vdd_b4_vdd_link_vdd_link_dip_vdd_x1_vdd_x2_vdd_x3_t100 vdd__t100 vdd 17.0051118211
* device instance a_d_inv_clk_vdd_inv_mc_vdd_inv_q_vdd_mpa_py_mpb_py_nand_m_vdd_nand_s2_vdd_nwell_vdd_sb_vdd_sr1_vdd_sr2_vdd_sr3_vdd_sr4_vdd_sv_d_vdd_tie_sv_vdd_tg_d_a_tg_d_vdd_tg_fbm_vdd_tg_fbs_vdd_tg_s_vdd_vdd_vdd_b1_vdd_b2_vdd_b3_vdd_b4_vdd_link_vdd_link_dip_vdd_x1_vdd_x2_vdd_x3_t101 r0 *1 0,0
Ra_d_inv_clk_vdd_inv_mc_vdd_inv_q_vdd_mpa_py_mpb_py_nand_m_vdd_nand_s2_vdd_nwell_vdd_sb_vdd_sr1_vdd_sr2_vdd_sr3_vdd_sr4_vdd_sv_d_vdd_tie_sv_vdd_tg_d_a_tg_d_vdd_tg_fbm_vdd_tg_fbs_vdd_tg_s_vdd_vdd_vdd_b1_vdd_b2_vdd_b3_vdd_b4_vdd_link_vdd_link_dip_vdd_x1_vdd_x2_vdd_x3_t101 vdd__t101 vdd 83.1462137955
* device instance a_d_inv_clk_vdd_inv_mc_vdd_inv_q_vdd_mpa_py_mpb_py_nand_m_vdd_nand_s2_vdd_nwell_vdd_sb_vdd_sr1_vdd_sr2_vdd_sr3_vdd_sr4_vdd_sv_d_vdd_tie_sv_vdd_tg_d_a_tg_d_vdd_tg_fbm_vdd_tg_fbs_vdd_tg_s_vdd_vdd_vdd_b1_vdd_b2_vdd_b3_vdd_b4_vdd_link_vdd_link_dip_vdd_x1_vdd_x2_vdd_x3_t102 r0 *1 0,0
Ra_d_inv_clk_vdd_inv_mc_vdd_inv_q_vdd_mpa_py_mpb_py_nand_m_vdd_nand_s2_vdd_nwell_vdd_sb_vdd_sr1_vdd_sr2_vdd_sr3_vdd_sr4_vdd_sv_d_vdd_tie_sv_vdd_tg_d_a_tg_d_vdd_tg_fbm_vdd_tg_fbs_vdd_tg_s_vdd_vdd_vdd_b1_vdd_b2_vdd_b3_vdd_b4_vdd_link_vdd_link_dip_vdd_x1_vdd_x2_vdd_x3_t102 vdd__t102 vdd 135.360970407
* device instance a_d_inv_clk_vdd_inv_mc_vdd_inv_q_vdd_mpa_py_mpb_py_nand_m_vdd_nand_s2_vdd_nwell_vdd_sb_vdd_sr1_vdd_sr2_vdd_sr3_vdd_sr4_vdd_sv_d_vdd_tie_sv_vdd_tg_d_a_tg_d_vdd_tg_fbm_vdd_tg_fbs_vdd_tg_s_vdd_vdd_vdd_b1_vdd_b2_vdd_b3_vdd_b4_vdd_link_vdd_link_dip_vdd_x1_vdd_x2_vdd_x3_t103 r0 *1 0,0
Ra_d_inv_clk_vdd_inv_mc_vdd_inv_q_vdd_mpa_py_mpb_py_nand_m_vdd_nand_s2_vdd_nwell_vdd_sb_vdd_sr1_vdd_sr2_vdd_sr3_vdd_sr4_vdd_sv_d_vdd_tie_sv_vdd_tg_d_a_tg_d_vdd_tg_fbm_vdd_tg_fbs_vdd_tg_s_vdd_vdd_vdd_b1_vdd_b2_vdd_b3_vdd_b4_vdd_link_vdd_link_dip_vdd_x1_vdd_x2_vdd_x3_t103 vdd__t103 vdd 15.2397231636
* device instance a_d_inv_clk_vdd_inv_mc_vdd_inv_q_vdd_mpa_py_mpb_py_nand_m_vdd_nand_s2_vdd_nwell_vdd_sb_vdd_sr1_vdd_sr2_vdd_sr3_vdd_sr4_vdd_sv_d_vdd_tie_sv_vdd_tg_d_a_tg_d_vdd_tg_fbm_vdd_tg_fbs_vdd_tg_s_vdd_vdd_vdd_b1_vdd_b2_vdd_b3_vdd_b4_vdd_link_vdd_link_dip_vdd_x1_vdd_x2_vdd_x3_t104 r0 *1 0,0
Ra_d_inv_clk_vdd_inv_mc_vdd_inv_q_vdd_mpa_py_mpb_py_nand_m_vdd_nand_s2_vdd_nwell_vdd_sb_vdd_sr1_vdd_sr2_vdd_sr3_vdd_sr4_vdd_sv_d_vdd_tie_sv_vdd_tg_d_a_tg_d_vdd_tg_fbm_vdd_tg_fbs_vdd_tg_s_vdd_vdd_vdd_b1_vdd_b2_vdd_b3_vdd_b4_vdd_link_vdd_link_dip_vdd_x1_vdd_x2_vdd_x3_t104 vdd__t104 vdd 76.2777489005
* device instance a_d_inv_clk_vdd_inv_mc_vdd_inv_q_vdd_mpa_py_mpb_py_nand_m_vdd_nand_s2_vdd_nwell_vdd_sb_vdd_sr1_vdd_sr2_vdd_sr3_vdd_sr4_vdd_sv_d_vdd_tie_sv_vdd_tg_d_a_tg_d_vdd_tg_fbm_vdd_tg_fbs_vdd_tg_s_vdd_vdd_vdd_b1_vdd_b2_vdd_b3_vdd_b4_vdd_link_vdd_link_dip_vdd_x1_vdd_x2_vdd_x3_t105 r0 *1 0,0
Ra_d_inv_clk_vdd_inv_mc_vdd_inv_q_vdd_mpa_py_mpb_py_nand_m_vdd_nand_s2_vdd_nwell_vdd_sb_vdd_sr1_vdd_sr2_vdd_sr3_vdd_sr4_vdd_sv_d_vdd_tie_sv_vdd_tg_d_a_tg_d_vdd_tg_fbm_vdd_tg_fbs_vdd_tg_s_vdd_vdd_vdd_b1_vdd_b2_vdd_b3_vdd_b4_vdd_link_vdd_link_dip_vdd_x1_vdd_x2_vdd_x3_t105 vdd__t105 vdd 101.092545773
* device instance a_d_inv_clk_vdd_inv_mc_vdd_inv_q_vdd_mpa_py_mpb_py_nand_m_vdd_nand_s2_vdd_nwell_vdd_sb_vdd_sr1_vdd_sr2_vdd_sr3_vdd_sr4_vdd_sv_d_vdd_tie_sv_vdd_tg_d_a_tg_d_vdd_tg_fbm_vdd_tg_fbs_vdd_tg_s_vdd_vdd_vdd_b1_vdd_b2_vdd_b3_vdd_b4_vdd_link_vdd_link_dip_vdd_x1_vdd_x2_vdd_x3_t106 r0 *1 0,0
Ra_d_inv_clk_vdd_inv_mc_vdd_inv_q_vdd_mpa_py_mpb_py_nand_m_vdd_nand_s2_vdd_nwell_vdd_sb_vdd_sr1_vdd_sr2_vdd_sr3_vdd_sr4_vdd_sv_d_vdd_tie_sv_vdd_tg_d_a_tg_d_vdd_tg_fbm_vdd_tg_fbs_vdd_tg_s_vdd_vdd_vdd_b1_vdd_b2_vdd_b3_vdd_b4_vdd_link_vdd_link_dip_vdd_x1_vdd_x2_vdd_x3_t106 vdd__t106 vdd 99.2174046262
* device instance a_d_inv_clk_vdd_inv_mc_vdd_inv_q_vdd_mpa_py_mpb_py_nand_m_vdd_nand_s2_vdd_nwell_vdd_sb_vdd_sr1_vdd_sr2_vdd_sr3_vdd_sr4_vdd_sv_d_vdd_tie_sv_vdd_tg_d_a_tg_d_vdd_tg_fbm_vdd_tg_fbs_vdd_tg_s_vdd_vdd_vdd_b1_vdd_b2_vdd_b3_vdd_b4_vdd_link_vdd_link_dip_vdd_x1_vdd_x2_vdd_x3_t107 r0 *1 0,0
Ra_d_inv_clk_vdd_inv_mc_vdd_inv_q_vdd_mpa_py_mpb_py_nand_m_vdd_nand_s2_vdd_nwell_vdd_sb_vdd_sr1_vdd_sr2_vdd_sr3_vdd_sr4_vdd_sv_d_vdd_tie_sv_vdd_tg_d_a_tg_d_vdd_tg_fbm_vdd_tg_fbs_vdd_tg_s_vdd_vdd_vdd_b1_vdd_b2_vdd_b3_vdd_b4_vdd_link_vdd_link_dip_vdd_x1_vdd_x2_vdd_x3_t107 vdd__t107 vdd 55.5404096195
* device instance a_d_inv_clk_vdd_inv_mc_vdd_inv_q_vdd_mpa_py_mpb_py_nand_m_vdd_nand_s2_vdd_nwell_vdd_sb_vdd_sr1_vdd_sr2_vdd_sr3_vdd_sr4_vdd_sv_d_vdd_tie_sv_vdd_tg_d_a_tg_d_vdd_tg_fbm_vdd_tg_fbs_vdd_tg_s_vdd_vdd_vdd_b1_vdd_b2_vdd_b3_vdd_b4_vdd_link_vdd_link_dip_vdd_x1_vdd_x2_vdd_x3_t108 r0 *1 0,0
Ra_d_inv_clk_vdd_inv_mc_vdd_inv_q_vdd_mpa_py_mpb_py_nand_m_vdd_nand_s2_vdd_nwell_vdd_sb_vdd_sr1_vdd_sr2_vdd_sr3_vdd_sr4_vdd_sv_d_vdd_tie_sv_vdd_tg_d_a_tg_d_vdd_tg_fbm_vdd_tg_fbs_vdd_tg_s_vdd_vdd_vdd_b1_vdd_b2_vdd_b3_vdd_b4_vdd_link_vdd_link_dip_vdd_x1_vdd_x2_vdd_x3_t108 vdd__t108 vdd 90.5774194264
* device instance a_d_inv_clk_vdd_inv_mc_vdd_inv_q_vdd_mpa_py_mpb_py_nand_m_vdd_nand_s2_vdd_nwell_vdd_sb_vdd_sr1_vdd_sr2_vdd_sr3_vdd_sr4_vdd_sv_d_vdd_tie_sv_vdd_tg_d_a_tg_d_vdd_tg_fbm_vdd_tg_fbs_vdd_tg_s_vdd_vdd_vdd_b1_vdd_b2_vdd_b3_vdd_b4_vdd_link_vdd_link_dip_vdd_x1_vdd_x2_vdd_x3_t109 r0 *1 0,0
Ra_d_inv_clk_vdd_inv_mc_vdd_inv_q_vdd_mpa_py_mpb_py_nand_m_vdd_nand_s2_vdd_nwell_vdd_sb_vdd_sr1_vdd_sr2_vdd_sr3_vdd_sr4_vdd_sv_d_vdd_tie_sv_vdd_tg_d_a_tg_d_vdd_tg_fbm_vdd_tg_fbs_vdd_tg_s_vdd_vdd_vdd_b1_vdd_b2_vdd_b3_vdd_b4_vdd_link_vdd_link_dip_vdd_x1_vdd_x2_vdd_x3_t109 vdd__t109 vdd 210.446064443
* device instance a_d_inv_clk_vdd_inv_mc_vdd_inv_q_vdd_mpa_py_mpb_py_nand_m_vdd_nand_s2_vdd_nwell_vdd_sb_vdd_sr1_vdd_sr2_vdd_sr3_vdd_sr4_vdd_sv_d_vdd_tie_sv_vdd_tg_d_a_tg_d_vdd_tg_fbm_vdd_tg_fbs_vdd_tg_s_vdd_vdd_vdd_b1_vdd_b2_vdd_b3_vdd_b4_vdd_link_vdd_link_dip_vdd_x1_vdd_x2_vdd_x3_t110 r0 *1 0,0
Ra_d_inv_clk_vdd_inv_mc_vdd_inv_q_vdd_mpa_py_mpb_py_nand_m_vdd_nand_s2_vdd_nwell_vdd_sb_vdd_sr1_vdd_sr2_vdd_sr3_vdd_sr4_vdd_sv_d_vdd_tie_sv_vdd_tg_d_a_tg_d_vdd_tg_fbm_vdd_tg_fbs_vdd_tg_s_vdd_vdd_vdd_b1_vdd_b2_vdd_b3_vdd_b4_vdd_link_vdd_link_dip_vdd_x1_vdd_x2_vdd_x3_t110 vdd__t110 vdd 173.908613154
* device instance a_d_inv_clk_vdd_inv_mc_vdd_inv_q_vdd_mpa_py_mpb_py_nand_m_vdd_nand_s2_vdd_nwell_vdd_sb_vdd_sr1_vdd_sr2_vdd_sr3_vdd_sr4_vdd_sv_d_vdd_tie_sv_vdd_tg_d_a_tg_d_vdd_tg_fbm_vdd_tg_fbs_vdd_tg_s_vdd_vdd_vdd_b1_vdd_b2_vdd_b3_vdd_b4_vdd_link_vdd_link_dip_vdd_x1_vdd_x2_vdd_x3_t111 r0 *1 0,0
Ra_d_inv_clk_vdd_inv_mc_vdd_inv_q_vdd_mpa_py_mpb_py_nand_m_vdd_nand_s2_vdd_nwell_vdd_sb_vdd_sr1_vdd_sr2_vdd_sr3_vdd_sr4_vdd_sv_d_vdd_tie_sv_vdd_tg_d_a_tg_d_vdd_tg_fbm_vdd_tg_fbs_vdd_tg_s_vdd_vdd_vdd_b1_vdd_b2_vdd_b3_vdd_b4_vdd_link_vdd_link_dip_vdd_x1_vdd_x2_vdd_x3_t111 vdd__t111 vdd 158.660523292
* device instance a_d_inv_clk_vdd_inv_mc_vdd_inv_q_vdd_mpa_py_mpb_py_nand_m_vdd_nand_s2_vdd_nwell_vdd_sb_vdd_sr1_vdd_sr2_vdd_sr3_vdd_sr4_vdd_sv_d_vdd_tie_sv_vdd_tg_d_a_tg_d_vdd_tg_fbm_vdd_tg_fbs_vdd_tg_s_vdd_vdd_vdd_b1_vdd_b2_vdd_b3_vdd_b4_vdd_link_vdd_link_dip_vdd_x1_vdd_x2_vdd_x3_t112 r0 *1 0,0
Ra_d_inv_clk_vdd_inv_mc_vdd_inv_q_vdd_mpa_py_mpb_py_nand_m_vdd_nand_s2_vdd_nwell_vdd_sb_vdd_sr1_vdd_sr2_vdd_sr3_vdd_sr4_vdd_sv_d_vdd_tie_sv_vdd_tg_d_a_tg_d_vdd_tg_fbm_vdd_tg_fbs_vdd_tg_s_vdd_vdd_vdd_b1_vdd_b2_vdd_b3_vdd_b4_vdd_link_vdd_link_dip_vdd_x1_vdd_x2_vdd_x3_t112 vdd__t112 vdd 50.5462818726
* device instance a_d_inv_clk_vdd_inv_mc_vdd_inv_q_vdd_mpa_py_mpb_py_nand_m_vdd_nand_s2_vdd_nwell_vdd_sb_vdd_sr1_vdd_sr2_vdd_sr3_vdd_sr4_vdd_sv_d_vdd_tie_sv_vdd_tg_d_a_tg_d_vdd_tg_fbm_vdd_tg_fbs_vdd_tg_s_vdd_vdd_vdd_b1_vdd_b2_vdd_b3_vdd_b4_vdd_link_vdd_link_dip_vdd_x1_vdd_x2_vdd_x3_t113 r0 *1 0,0
Ra_d_inv_clk_vdd_inv_mc_vdd_inv_q_vdd_mpa_py_mpb_py_nand_m_vdd_nand_s2_vdd_nwell_vdd_sb_vdd_sr1_vdd_sr2_vdd_sr3_vdd_sr4_vdd_sv_d_vdd_tie_sv_vdd_tg_d_a_tg_d_vdd_tg_fbm_vdd_tg_fbs_vdd_tg_s_vdd_vdd_vdd_b1_vdd_b2_vdd_b3_vdd_b4_vdd_link_vdd_link_dip_vdd_x1_vdd_x2_vdd_x3_t113 vdd__t113 vdd 133.307481456
* device instance a_d_inv_clk_vdd_inv_mc_vdd_inv_q_vdd_mpa_py_mpb_py_nand_m_vdd_nand_s2_vdd_nwell_vdd_sb_vdd_sr1_vdd_sr2_vdd_sr3_vdd_sr4_vdd_sv_d_vdd_tie_sv_vdd_tg_d_a_tg_d_vdd_tg_fbm_vdd_tg_fbs_vdd_tg_s_vdd_vdd_vdd_b1_vdd_b2_vdd_b3_vdd_b4_vdd_link_vdd_link_dip_vdd_x1_vdd_x2_vdd_x3_t114 r0 *1 0,0
Ra_d_inv_clk_vdd_inv_mc_vdd_inv_q_vdd_mpa_py_mpb_py_nand_m_vdd_nand_s2_vdd_nwell_vdd_sb_vdd_sr1_vdd_sr2_vdd_sr3_vdd_sr4_vdd_sv_d_vdd_tie_sv_vdd_tg_d_a_tg_d_vdd_tg_fbm_vdd_tg_fbs_vdd_tg_s_vdd_vdd_vdd_b1_vdd_b2_vdd_b3_vdd_b4_vdd_link_vdd_link_dip_vdd_x1_vdd_x2_vdd_x3_t114 vdd__t114 vdd 118.527622922
* device instance a_d_inv_clk_vdd_inv_mc_vdd_inv_q_vdd_mpa_py_mpb_py_nand_m_vdd_nand_s2_vdd_nwell_vdd_sb_vdd_sr1_vdd_sr2_vdd_sr3_vdd_sr4_vdd_sv_d_vdd_tie_sv_vdd_tg_d_a_tg_d_vdd_tg_fbm_vdd_tg_fbs_vdd_tg_s_vdd_vdd_vdd_b1_vdd_b2_vdd_b3_vdd_b4_vdd_link_vdd_link_dip_vdd_x1_vdd_x2_vdd_x3_t115 r0 *1 0,0
Ra_d_inv_clk_vdd_inv_mc_vdd_inv_q_vdd_mpa_py_mpb_py_nand_m_vdd_nand_s2_vdd_nwell_vdd_sb_vdd_sr1_vdd_sr2_vdd_sr3_vdd_sr4_vdd_sv_d_vdd_tie_sv_vdd_tg_d_a_tg_d_vdd_tg_fbm_vdd_tg_fbs_vdd_tg_s_vdd_vdd_vdd_b1_vdd_b2_vdd_b3_vdd_b4_vdd_link_vdd_link_dip_vdd_x1_vdd_x2_vdd_x3_t115 vdd__t115 vdd 263.20408715
* device instance a_d_inv_clk_vdd_inv_mc_vdd_inv_q_vdd_mpa_py_mpb_py_nand_m_vdd_nand_s2_vdd_nwell_vdd_sb_vdd_sr1_vdd_sr2_vdd_sr3_vdd_sr4_vdd_sv_d_vdd_tie_sv_vdd_tg_d_a_tg_d_vdd_tg_fbm_vdd_tg_fbs_vdd_tg_s_vdd_vdd_vdd_b1_vdd_b2_vdd_b3_vdd_b4_vdd_link_vdd_link_dip_vdd_x1_vdd_x2_vdd_x3_t116 r0 *1 0,0
Ra_d_inv_clk_vdd_inv_mc_vdd_inv_q_vdd_mpa_py_mpb_py_nand_m_vdd_nand_s2_vdd_nwell_vdd_sb_vdd_sr1_vdd_sr2_vdd_sr3_vdd_sr4_vdd_sv_d_vdd_tie_sv_vdd_tg_d_a_tg_d_vdd_tg_fbm_vdd_tg_fbs_vdd_tg_s_vdd_vdd_vdd_b1_vdd_b2_vdd_b3_vdd_b4_vdd_link_vdd_link_dip_vdd_x1_vdd_x2_vdd_x3_t116 vdd__t116 vdd 64.9885343757
* device instance a_d_inv_clk_vdd_inv_mc_vdd_inv_q_vdd_mpa_py_mpb_py_nand_m_vdd_nand_s2_vdd_nwell_vdd_sb_vdd_sr1_vdd_sr2_vdd_sr3_vdd_sr4_vdd_sv_d_vdd_tie_sv_vdd_tg_d_a_tg_d_vdd_tg_fbm_vdd_tg_fbs_vdd_tg_s_vdd_vdd_vdd_b1_vdd_b2_vdd_b3_vdd_b4_vdd_link_vdd_link_dip_vdd_x1_vdd_x2_vdd_x3_t117 r0 *1 0,0
Ra_d_inv_clk_vdd_inv_mc_vdd_inv_q_vdd_mpa_py_mpb_py_nand_m_vdd_nand_s2_vdd_nwell_vdd_sb_vdd_sr1_vdd_sr2_vdd_sr3_vdd_sr4_vdd_sv_d_vdd_tie_sv_vdd_tg_d_a_tg_d_vdd_tg_fbm_vdd_tg_fbs_vdd_tg_s_vdd_vdd_vdd_b1_vdd_b2_vdd_b3_vdd_b4_vdd_link_vdd_link_dip_vdd_x1_vdd_x2_vdd_x3_t117 vdd__t117 vdd 39.6730583799
* device instance a_d_inv_clk_vdd_inv_mc_vdd_inv_q_vdd_mpa_py_mpb_py_nand_m_vdd_nand_s2_vdd_nwell_vdd_sb_vdd_sr1_vdd_sr2_vdd_sr3_vdd_sr4_vdd_sv_d_vdd_tie_sv_vdd_tg_d_a_tg_d_vdd_tg_fbm_vdd_tg_fbs_vdd_tg_s_vdd_vdd_vdd_b1_vdd_b2_vdd_b3_vdd_b4_vdd_link_vdd_link_dip_vdd_x1_vdd_x2_vdd_x3_t118 r0 *1 0,0
Ra_d_inv_clk_vdd_inv_mc_vdd_inv_q_vdd_mpa_py_mpb_py_nand_m_vdd_nand_s2_vdd_nwell_vdd_sb_vdd_sr1_vdd_sr2_vdd_sr3_vdd_sr4_vdd_sv_d_vdd_tie_sv_vdd_tg_d_a_tg_d_vdd_tg_fbm_vdd_tg_fbs_vdd_tg_s_vdd_vdd_vdd_b1_vdd_b2_vdd_b3_vdd_b4_vdd_link_vdd_link_dip_vdd_x1_vdd_x2_vdd_x3_t118 vdd__t118 vdd 94.4335287718
* device instance a_d_inv_clk_vdd_inv_mc_vdd_inv_q_vdd_mpa_py_mpb_py_nand_m_vdd_nand_s2_vdd_nwell_vdd_sb_vdd_sr1_vdd_sr2_vdd_sr3_vdd_sr4_vdd_sv_d_vdd_tie_sv_vdd_tg_d_a_tg_d_vdd_tg_fbm_vdd_tg_fbs_vdd_tg_s_vdd_vdd_vdd_b1_vdd_b2_vdd_b3_vdd_b4_vdd_link_vdd_link_dip_vdd_x1_vdd_x2_vdd_x3_t119 r0 *1 0,0
Ra_d_inv_clk_vdd_inv_mc_vdd_inv_q_vdd_mpa_py_mpb_py_nand_m_vdd_nand_s2_vdd_nwell_vdd_sb_vdd_sr1_vdd_sr2_vdd_sr3_vdd_sr4_vdd_sv_d_vdd_tie_sv_vdd_tg_d_a_tg_d_vdd_tg_fbm_vdd_tg_fbs_vdd_tg_s_vdd_vdd_vdd_b1_vdd_b2_vdd_b3_vdd_b4_vdd_link_vdd_link_dip_vdd_x1_vdd_x2_vdd_x3_t119 vdd__t119 vdd 238.709465789
* device instance a_d_inv_clk_vdd_inv_mc_vdd_inv_q_vdd_mpa_py_mpb_py_nand_m_vdd_nand_s2_vdd_nwell_vdd_sb_vdd_sr1_vdd_sr2_vdd_sr3_vdd_sr4_vdd_sv_d_vdd_tie_sv_vdd_tg_d_a_tg_d_vdd_tg_fbm_vdd_tg_fbs_vdd_tg_s_vdd_vdd_vdd_b1_vdd_b2_vdd_b3_vdd_b4_vdd_link_vdd_link_dip_vdd_x1_vdd_x2_vdd_x3_t120 r0 *1 0,0
Ra_d_inv_clk_vdd_inv_mc_vdd_inv_q_vdd_mpa_py_mpb_py_nand_m_vdd_nand_s2_vdd_nwell_vdd_sb_vdd_sr1_vdd_sr2_vdd_sr3_vdd_sr4_vdd_sv_d_vdd_tie_sv_vdd_tg_d_a_tg_d_vdd_tg_fbm_vdd_tg_fbs_vdd_tg_s_vdd_vdd_vdd_b1_vdd_b2_vdd_b3_vdd_b4_vdd_link_vdd_link_dip_vdd_x1_vdd_x2_vdd_x3_t120 vdd__t120 vdd 272.579318667
* device instance a_d_inv_clk_vdd_inv_mc_vdd_inv_q_vdd_mpa_py_mpb_py_nand_m_vdd_nand_s2_vdd_nwell_vdd_sb_vdd_sr1_vdd_sr2_vdd_sr3_vdd_sr4_vdd_sv_d_vdd_tie_sv_vdd_tg_d_a_tg_d_vdd_tg_fbm_vdd_tg_fbs_vdd_tg_s_vdd_vdd_vdd_b1_vdd_b2_vdd_b3_vdd_b4_vdd_link_vdd_link_dip_vdd_x1_vdd_x2_vdd_x3_t121 r0 *1 0,0
Ra_d_inv_clk_vdd_inv_mc_vdd_inv_q_vdd_mpa_py_mpb_py_nand_m_vdd_nand_s2_vdd_nwell_vdd_sb_vdd_sr1_vdd_sr2_vdd_sr3_vdd_sr4_vdd_sv_d_vdd_tie_sv_vdd_tg_d_a_tg_d_vdd_tg_fbm_vdd_tg_fbs_vdd_tg_s_vdd_vdd_vdd_b1_vdd_b2_vdd_b3_vdd_b4_vdd_link_vdd_link_dip_vdd_x1_vdd_x2_vdd_x3_t121 vdd__t121 vdd 227.333384696
* device instance a_d_inv_clk_vdd_inv_mc_vdd_inv_q_vdd_mpa_py_mpb_py_nand_m_vdd_nand_s2_vdd_nwell_vdd_sb_vdd_sr1_vdd_sr2_vdd_sr3_vdd_sr4_vdd_sv_d_vdd_tie_sv_vdd_tg_d_a_tg_d_vdd_tg_fbm_vdd_tg_fbs_vdd_tg_s_vdd_vdd_vdd_b1_vdd_b2_vdd_b3_vdd_b4_vdd_link_vdd_link_dip_vdd_x1_vdd_x2_vdd_x3_t122 r0 *1 0,0
Ra_d_inv_clk_vdd_inv_mc_vdd_inv_q_vdd_mpa_py_mpb_py_nand_m_vdd_nand_s2_vdd_nwell_vdd_sb_vdd_sr1_vdd_sr2_vdd_sr3_vdd_sr4_vdd_sv_d_vdd_tie_sv_vdd_tg_d_a_tg_d_vdd_tg_fbm_vdd_tg_fbs_vdd_tg_s_vdd_vdd_vdd_b1_vdd_b2_vdd_b3_vdd_b4_vdd_link_vdd_link_dip_vdd_x1_vdd_x2_vdd_x3_t122 vdd__t122 vdd 190.998041694
* device instance a_d_inv_clk_vdd_inv_mc_vdd_inv_q_vdd_mpa_py_mpb_py_nand_m_vdd_nand_s2_vdd_nwell_vdd_sb_vdd_sr1_vdd_sr2_vdd_sr3_vdd_sr4_vdd_sv_d_vdd_tie_sv_vdd_tg_d_a_tg_d_vdd_tg_fbm_vdd_tg_fbs_vdd_tg_s_vdd_vdd_vdd_b1_vdd_b2_vdd_b3_vdd_b4_vdd_link_vdd_link_dip_vdd_x1_vdd_x2_vdd_x3_t123 r0 *1 0,0
Ra_d_inv_clk_vdd_inv_mc_vdd_inv_q_vdd_mpa_py_mpb_py_nand_m_vdd_nand_s2_vdd_nwell_vdd_sb_vdd_sr1_vdd_sr2_vdd_sr3_vdd_sr4_vdd_sv_d_vdd_tie_sv_vdd_tg_d_a_tg_d_vdd_tg_fbm_vdd_tg_fbs_vdd_tg_s_vdd_vdd_vdd_b1_vdd_b2_vdd_b3_vdd_b4_vdd_link_vdd_link_dip_vdd_x1_vdd_x2_vdd_x3_t123 vdd__t123 vdd 109.655400001
* device instance a_d_inv_clk_vdd_inv_mc_vdd_inv_q_vdd_mpa_py_mpb_py_nand_m_vdd_nand_s2_vdd_nwell_vdd_sb_vdd_sr1_vdd_sr2_vdd_sr3_vdd_sr4_vdd_sv_d_vdd_tie_sv_vdd_tg_d_a_tg_d_vdd_tg_fbm_vdd_tg_fbs_vdd_tg_s_vdd_vdd_vdd_b1_vdd_b2_vdd_b3_vdd_b4_vdd_link_vdd_link_dip_vdd_x1_vdd_x2_vdd_x3_t124 r0 *1 0,0
Ra_d_inv_clk_vdd_inv_mc_vdd_inv_q_vdd_mpa_py_mpb_py_nand_m_vdd_nand_s2_vdd_nwell_vdd_sb_vdd_sr1_vdd_sr2_vdd_sr3_vdd_sr4_vdd_sv_d_vdd_tie_sv_vdd_tg_d_a_tg_d_vdd_tg_fbm_vdd_tg_fbs_vdd_tg_s_vdd_vdd_vdd_b1_vdd_b2_vdd_b3_vdd_b4_vdd_link_vdd_link_dip_vdd_x1_vdd_x2_vdd_x3_t124 vdd__t124 vdd 129.332460393
* device instance a_d_inv_clk_vdd_inv_mc_vdd_inv_q_vdd_mpa_py_mpb_py_nand_m_vdd_nand_s2_vdd_nwell_vdd_sb_vdd_sr1_vdd_sr2_vdd_sr3_vdd_sr4_vdd_sv_d_vdd_tie_sv_vdd_tg_d_a_tg_d_vdd_tg_fbm_vdd_tg_fbs_vdd_tg_s_vdd_vdd_vdd_b1_vdd_b2_vdd_b3_vdd_b4_vdd_link_vdd_link_dip_vdd_x1_vdd_x2_vdd_x3_t125 r0 *1 0,0
Ra_d_inv_clk_vdd_inv_mc_vdd_inv_q_vdd_mpa_py_mpb_py_nand_m_vdd_nand_s2_vdd_nwell_vdd_sb_vdd_sr1_vdd_sr2_vdd_sr3_vdd_sr4_vdd_sv_d_vdd_tie_sv_vdd_tg_d_a_tg_d_vdd_tg_fbm_vdd_tg_fbs_vdd_tg_s_vdd_vdd_vdd_b1_vdd_b2_vdd_b3_vdd_b4_vdd_link_vdd_link_dip_vdd_x1_vdd_x2_vdd_x3_t125 vdd__t125 vdd 145.843562672
* device instance a_d_inv_clk_vdd_inv_mc_vdd_inv_q_vdd_mpa_py_mpb_py_nand_m_vdd_nand_s2_vdd_nwell_vdd_sb_vdd_sr1_vdd_sr2_vdd_sr3_vdd_sr4_vdd_sv_d_vdd_tie_sv_vdd_tg_d_a_tg_d_vdd_tg_fbm_vdd_tg_fbs_vdd_tg_s_vdd_vdd_vdd_b1_vdd_b2_vdd_b3_vdd_b4_vdd_link_vdd_link_dip_vdd_x1_vdd_x2_vdd_x3_t126 r0 *1 0,0
Ra_d_inv_clk_vdd_inv_mc_vdd_inv_q_vdd_mpa_py_mpb_py_nand_m_vdd_nand_s2_vdd_nwell_vdd_sb_vdd_sr1_vdd_sr2_vdd_sr3_vdd_sr4_vdd_sv_d_vdd_tie_sv_vdd_tg_d_a_tg_d_vdd_tg_fbm_vdd_tg_fbs_vdd_tg_s_vdd_vdd_vdd_b1_vdd_b2_vdd_b3_vdd_b4_vdd_link_vdd_link_dip_vdd_x1_vdd_x2_vdd_x3_t126 vdd__t126 vdd 117.405111309
* device instance a_d_inv_clk_vdd_inv_mc_vdd_inv_q_vdd_mpa_py_mpb_py_nand_m_vdd_nand_s2_vdd_nwell_vdd_sb_vdd_sr1_vdd_sr2_vdd_sr3_vdd_sr4_vdd_sv_d_vdd_tie_sv_vdd_tg_d_a_tg_d_vdd_tg_fbm_vdd_tg_fbs_vdd_tg_s_vdd_vdd_vdd_b1_vdd_b2_vdd_b3_vdd_b4_vdd_link_vdd_link_dip_vdd_x1_vdd_x2_vdd_x3_t127 r0 *1 0,0
Ra_d_inv_clk_vdd_inv_mc_vdd_inv_q_vdd_mpa_py_mpb_py_nand_m_vdd_nand_s2_vdd_nwell_vdd_sb_vdd_sr1_vdd_sr2_vdd_sr3_vdd_sr4_vdd_sv_d_vdd_tie_sv_vdd_tg_d_a_tg_d_vdd_tg_fbm_vdd_tg_fbs_vdd_tg_s_vdd_vdd_vdd_b1_vdd_b2_vdd_b3_vdd_b4_vdd_link_vdd_link_dip_vdd_x1_vdd_x2_vdd_x3_t127 vdd__t127 vdd 199.79402836
* device instance a_d_inv_clk_vdd_inv_mc_vdd_inv_q_vdd_mpa_py_mpb_py_nand_m_vdd_nand_s2_vdd_nwell_vdd_sb_vdd_sr1_vdd_sr2_vdd_sr3_vdd_sr4_vdd_sv_d_vdd_tie_sv_vdd_tg_d_a_tg_d_vdd_tg_fbm_vdd_tg_fbs_vdd_tg_s_vdd_vdd_vdd_b1_vdd_b2_vdd_b3_vdd_b4_vdd_link_vdd_link_dip_vdd_x1_vdd_x2_vdd_x3_t128 r0 *1 0,0
Ra_d_inv_clk_vdd_inv_mc_vdd_inv_q_vdd_mpa_py_mpb_py_nand_m_vdd_nand_s2_vdd_nwell_vdd_sb_vdd_sr1_vdd_sr2_vdd_sr3_vdd_sr4_vdd_sv_d_vdd_tie_sv_vdd_tg_d_a_tg_d_vdd_tg_fbm_vdd_tg_fbs_vdd_tg_s_vdd_vdd_vdd_b1_vdd_b2_vdd_b3_vdd_b4_vdd_link_vdd_link_dip_vdd_x1_vdd_x2_vdd_x3_t128 vdd__t128 vdd 16.7710976171
* device instance a_d_inv_clk_vdd_inv_mc_vdd_inv_q_vdd_mpa_py_mpb_py_nand_m_vdd_nand_s2_vdd_nwell_vdd_sb_vdd_sr1_vdd_sr2_vdd_sr3_vdd_sr4_vdd_sv_d_vdd_tie_sv_vdd_tg_d_a_tg_d_vdd_tg_fbm_vdd_tg_fbs_vdd_tg_s_vdd_vdd_vdd_b1_vdd_b2_vdd_b3_vdd_b4_vdd_link_vdd_link_dip_vdd_x1_vdd_x2_vdd_x3_t129 r0 *1 0,0
Ra_d_inv_clk_vdd_inv_mc_vdd_inv_q_vdd_mpa_py_mpb_py_nand_m_vdd_nand_s2_vdd_nwell_vdd_sb_vdd_sr1_vdd_sr2_vdd_sr3_vdd_sr4_vdd_sv_d_vdd_tie_sv_vdd_tg_d_a_tg_d_vdd_tg_fbm_vdd_tg_fbs_vdd_tg_s_vdd_vdd_vdd_b1_vdd_b2_vdd_b3_vdd_b4_vdd_link_vdd_link_dip_vdd_x1_vdd_x2_vdd_x3_t129 vdd__t129 vdd 171.163906087
* device instance a_d_inv_clk_vdd_inv_mc_vdd_inv_q_vdd_mpa_py_mpb_py_nand_m_vdd_nand_s2_vdd_nwell_vdd_sb_vdd_sr1_vdd_sr2_vdd_sr3_vdd_sr4_vdd_sv_d_vdd_tie_sv_vdd_tg_d_a_tg_d_vdd_tg_fbm_vdd_tg_fbs_vdd_tg_s_vdd_vdd_vdd_b1_vdd_b2_vdd_b3_vdd_b4_vdd_link_vdd_link_dip_vdd_x1_vdd_x2_vdd_x3_t130 r0 *1 0,0
Ra_d_inv_clk_vdd_inv_mc_vdd_inv_q_vdd_mpa_py_mpb_py_nand_m_vdd_nand_s2_vdd_nwell_vdd_sb_vdd_sr1_vdd_sr2_vdd_sr3_vdd_sr4_vdd_sv_d_vdd_tie_sv_vdd_tg_d_a_tg_d_vdd_tg_fbm_vdd_tg_fbs_vdd_tg_s_vdd_vdd_vdd_b1_vdd_b2_vdd_b3_vdd_b4_vdd_link_vdd_link_dip_vdd_x1_vdd_x2_vdd_x3_t130 vdd__t130 vdd 146.737616634
* device instance a_d_inv_clk_vdd_inv_mc_vdd_inv_q_vdd_mpa_py_mpb_py_nand_m_vdd_nand_s2_vdd_nwell_vdd_sb_vdd_sr1_vdd_sr2_vdd_sr3_vdd_sr4_vdd_sv_d_vdd_tie_sv_vdd_tg_d_a_tg_d_vdd_tg_fbm_vdd_tg_fbs_vdd_tg_s_vdd_vdd_vdd_b1_vdd_b2_vdd_b3_vdd_b4_vdd_link_vdd_link_dip_vdd_x1_vdd_x2_vdd_x3_t131 r0 *1 0,0
Ra_d_inv_clk_vdd_inv_mc_vdd_inv_q_vdd_mpa_py_mpb_py_nand_m_vdd_nand_s2_vdd_nwell_vdd_sb_vdd_sr1_vdd_sr2_vdd_sr3_vdd_sr4_vdd_sv_d_vdd_tie_sv_vdd_tg_d_a_tg_d_vdd_tg_fbm_vdd_tg_fbs_vdd_tg_s_vdd_vdd_vdd_b1_vdd_b2_vdd_b3_vdd_b4_vdd_link_vdd_link_dip_vdd_x1_vdd_x2_vdd_x3_t131 vdd__t131 vdd 181.661562025
* device instance a_d_inv_clk_vdd_inv_mc_vdd_inv_q_vdd_mpa_py_mpb_py_nand_m_vdd_nand_s2_vdd_nwell_vdd_sb_vdd_sr1_vdd_sr2_vdd_sr3_vdd_sr4_vdd_sv_d_vdd_tie_sv_vdd_tg_d_a_tg_d_vdd_tg_fbm_vdd_tg_fbs_vdd_tg_s_vdd_vdd_vdd_b1_vdd_b2_vdd_b3_vdd_b4_vdd_link_vdd_link_dip_vdd_x1_vdd_x2_vdd_x3_t132 r0 *1 0,0
Ra_d_inv_clk_vdd_inv_mc_vdd_inv_q_vdd_mpa_py_mpb_py_nand_m_vdd_nand_s2_vdd_nwell_vdd_sb_vdd_sr1_vdd_sr2_vdd_sr3_vdd_sr4_vdd_sv_d_vdd_tie_sv_vdd_tg_d_a_tg_d_vdd_tg_fbm_vdd_tg_fbs_vdd_tg_s_vdd_vdd_vdd_b1_vdd_b2_vdd_b3_vdd_b4_vdd_link_vdd_link_dip_vdd_x1_vdd_x2_vdd_x3_t132 vdd__t132 vdd 38.4771181778
* device instance a_d_inv_clk_vdd_inv_mc_vdd_inv_q_vdd_mpa_py_mpb_py_nand_m_vdd_nand_s2_vdd_nwell_vdd_sb_vdd_sr1_vdd_sr2_vdd_sr3_vdd_sr4_vdd_sv_d_vdd_tie_sv_vdd_tg_d_a_tg_d_vdd_tg_fbm_vdd_tg_fbs_vdd_tg_s_vdd_vdd_vdd_b1_vdd_b2_vdd_b3_vdd_b4_vdd_link_vdd_link_dip_vdd_x1_vdd_x2_vdd_x3_t133 r0 *1 0,0
Ra_d_inv_clk_vdd_inv_mc_vdd_inv_q_vdd_mpa_py_mpb_py_nand_m_vdd_nand_s2_vdd_nwell_vdd_sb_vdd_sr1_vdd_sr2_vdd_sr3_vdd_sr4_vdd_sv_d_vdd_tie_sv_vdd_tg_d_a_tg_d_vdd_tg_fbm_vdd_tg_fbs_vdd_tg_s_vdd_vdd_vdd_b1_vdd_b2_vdd_b3_vdd_b4_vdd_link_vdd_link_dip_vdd_x1_vdd_x2_vdd_x3_t133 vdd__t133 vdd 118.05949851
* device instance a_d_inv_clk_vdd_inv_mc_vdd_inv_q_vdd_mpa_py_mpb_py_nand_m_vdd_nand_s2_vdd_nwell_vdd_sb_vdd_sr1_vdd_sr2_vdd_sr3_vdd_sr4_vdd_sv_d_vdd_tie_sv_vdd_tg_d_a_tg_d_vdd_tg_fbm_vdd_tg_fbs_vdd_tg_s_vdd_vdd_vdd_b1_vdd_b2_vdd_b3_vdd_b4_vdd_link_vdd_link_dip_vdd_x1_vdd_x2_vdd_x3_t134 r0 *1 0,0
Ra_d_inv_clk_vdd_inv_mc_vdd_inv_q_vdd_mpa_py_mpb_py_nand_m_vdd_nand_s2_vdd_nwell_vdd_sb_vdd_sr1_vdd_sr2_vdd_sr3_vdd_sr4_vdd_sv_d_vdd_tie_sv_vdd_tg_d_a_tg_d_vdd_tg_fbm_vdd_tg_fbs_vdd_tg_s_vdd_vdd_vdd_b1_vdd_b2_vdd_b3_vdd_b4_vdd_link_vdd_link_dip_vdd_x1_vdd_x2_vdd_x3_t134 vdd__t134 vdd 90.041836416
* device instance a_d_inv_clk_vdd_inv_mc_vdd_inv_q_vdd_mpa_py_mpb_py_nand_m_vdd_nand_s2_vdd_nwell_vdd_sb_vdd_sr1_vdd_sr2_vdd_sr3_vdd_sr4_vdd_sv_d_vdd_tie_sv_vdd_tg_d_a_tg_d_vdd_tg_fbm_vdd_tg_fbs_vdd_tg_s_vdd_vdd_vdd_b1_vdd_b2_vdd_b3_vdd_b4_vdd_link_vdd_link_dip_vdd_x1_vdd_x2_vdd_x3_t135 r0 *1 0,0
Ra_d_inv_clk_vdd_inv_mc_vdd_inv_q_vdd_mpa_py_mpb_py_nand_m_vdd_nand_s2_vdd_nwell_vdd_sb_vdd_sr1_vdd_sr2_vdd_sr3_vdd_sr4_vdd_sv_d_vdd_tie_sv_vdd_tg_d_a_tg_d_vdd_tg_fbm_vdd_tg_fbs_vdd_tg_s_vdd_vdd_vdd_b1_vdd_b2_vdd_b3_vdd_b4_vdd_link_vdd_link_dip_vdd_x1_vdd_x2_vdd_x3_t135 vdd__t135 vdd 56.5886909333
* device instance a_d_inv_clk_vdd_inv_mc_vdd_inv_q_vdd_mpa_py_mpb_py_nand_m_vdd_nand_s2_vdd_nwell_vdd_sb_vdd_sr1_vdd_sr2_vdd_sr3_vdd_sr4_vdd_sv_d_vdd_tie_sv_vdd_tg_d_a_tg_d_vdd_tg_fbm_vdd_tg_fbs_vdd_tg_s_vdd_vdd_vdd_b1_vdd_b2_vdd_b3_vdd_b4_vdd_link_vdd_link_dip_vdd_x1_vdd_x2_vdd_x3_t136 r0 *1 0,0
Ra_d_inv_clk_vdd_inv_mc_vdd_inv_q_vdd_mpa_py_mpb_py_nand_m_vdd_nand_s2_vdd_nwell_vdd_sb_vdd_sr1_vdd_sr2_vdd_sr3_vdd_sr4_vdd_sv_d_vdd_tie_sv_vdd_tg_d_a_tg_d_vdd_tg_fbm_vdd_tg_fbs_vdd_tg_s_vdd_vdd_vdd_b1_vdd_b2_vdd_b3_vdd_b4_vdd_link_vdd_link_dip_vdd_x1_vdd_x2_vdd_x3_t136 vdd__t136 vdd 65.9867039863
* device instance a_d_inv_clk_vdd_inv_mc_vdd_inv_q_vdd_mpa_py_mpb_py_nand_m_vdd_nand_s2_vdd_nwell_vdd_sb_vdd_sr1_vdd_sr2_vdd_sr3_vdd_sr4_vdd_sv_d_vdd_tie_sv_vdd_tg_d_a_tg_d_vdd_tg_fbm_vdd_tg_fbs_vdd_tg_s_vdd_vdd_vdd_b1_vdd_b2_vdd_b3_vdd_b4_vdd_link_vdd_link_dip_vdd_x1_vdd_x2_vdd_x3_t137 r0 *1 0,0
Ra_d_inv_clk_vdd_inv_mc_vdd_inv_q_vdd_mpa_py_mpb_py_nand_m_vdd_nand_s2_vdd_nwell_vdd_sb_vdd_sr1_vdd_sr2_vdd_sr3_vdd_sr4_vdd_sv_d_vdd_tie_sv_vdd_tg_d_a_tg_d_vdd_tg_fbm_vdd_tg_fbs_vdd_tg_s_vdd_vdd_vdd_b1_vdd_b2_vdd_b3_vdd_b4_vdd_link_vdd_link_dip_vdd_x1_vdd_x2_vdd_x3_t137 vdd__t137 vdd 23.2370884501
* device instance a_d_inv_clk_vdd_inv_mc_vdd_inv_q_vdd_mpa_py_mpb_py_nand_m_vdd_nand_s2_vdd_nwell_vdd_sb_vdd_sr1_vdd_sr2_vdd_sr3_vdd_sr4_vdd_sv_d_vdd_tie_sv_vdd_tg_d_a_tg_d_vdd_tg_fbm_vdd_tg_fbs_vdd_tg_s_vdd_vdd_vdd_b1_vdd_b2_vdd_b3_vdd_b4_vdd_link_vdd_link_dip_vdd_x1_vdd_x2_vdd_x3_t138 r0 *1 0,0
Ra_d_inv_clk_vdd_inv_mc_vdd_inv_q_vdd_mpa_py_mpb_py_nand_m_vdd_nand_s2_vdd_nwell_vdd_sb_vdd_sr1_vdd_sr2_vdd_sr3_vdd_sr4_vdd_sv_d_vdd_tie_sv_vdd_tg_d_a_tg_d_vdd_tg_fbm_vdd_tg_fbs_vdd_tg_s_vdd_vdd_vdd_b1_vdd_b2_vdd_b3_vdd_b4_vdd_link_vdd_link_dip_vdd_x1_vdd_x2_vdd_x3_t138 vdd__t138 vdd 157.221525534
* device instance a_d_inv_clk_vdd_inv_mc_vdd_inv_q_vdd_mpa_py_mpb_py_nand_m_vdd_nand_s2_vdd_nwell_vdd_sb_vdd_sr1_vdd_sr2_vdd_sr3_vdd_sr4_vdd_sv_d_vdd_tie_sv_vdd_tg_d_a_tg_d_vdd_tg_fbm_vdd_tg_fbs_vdd_tg_s_vdd_vdd_vdd_b1_vdd_b2_vdd_b3_vdd_b4_vdd_link_vdd_link_dip_vdd_x1_vdd_x2_vdd_x3_t139 r0 *1 0,0
Ra_d_inv_clk_vdd_inv_mc_vdd_inv_q_vdd_mpa_py_mpb_py_nand_m_vdd_nand_s2_vdd_nwell_vdd_sb_vdd_sr1_vdd_sr2_vdd_sr3_vdd_sr4_vdd_sv_d_vdd_tie_sv_vdd_tg_d_a_tg_d_vdd_tg_fbm_vdd_tg_fbs_vdd_tg_s_vdd_vdd_vdd_b1_vdd_b2_vdd_b3_vdd_b4_vdd_link_vdd_link_dip_vdd_x1_vdd_x2_vdd_x3_t139 vdd__t139 vdd 129.05517831
* device instance a_d_inv_clk_vdd_inv_mc_vdd_inv_q_vdd_mpa_py_mpb_py_nand_m_vdd_nand_s2_vdd_nwell_vdd_sb_vdd_sr1_vdd_sr2_vdd_sr3_vdd_sr4_vdd_sv_d_vdd_tie_sv_vdd_tg_d_a_tg_d_vdd_tg_fbm_vdd_tg_fbs_vdd_tg_s_vdd_vdd_vdd_b1_vdd_b2_vdd_b3_vdd_b4_vdd_link_vdd_link_dip_vdd_x1_vdd_x2_vdd_x3_t140 r0 *1 0,0
Ra_d_inv_clk_vdd_inv_mc_vdd_inv_q_vdd_mpa_py_mpb_py_nand_m_vdd_nand_s2_vdd_nwell_vdd_sb_vdd_sr1_vdd_sr2_vdd_sr3_vdd_sr4_vdd_sv_d_vdd_tie_sv_vdd_tg_d_a_tg_d_vdd_tg_fbm_vdd_tg_fbs_vdd_tg_s_vdd_vdd_vdd_b1_vdd_b2_vdd_b3_vdd_b4_vdd_link_vdd_link_dip_vdd_x1_vdd_x2_vdd_x3_t140 vdd__t140 vdd 182.380731422
* device instance a_d_inv_clk_vdd_inv_mc_vdd_inv_q_vdd_mpa_py_mpb_py_nand_m_vdd_nand_s2_vdd_nwell_vdd_sb_vdd_sr1_vdd_sr2_vdd_sr3_vdd_sr4_vdd_sv_d_vdd_tie_sv_vdd_tg_d_a_tg_d_vdd_tg_fbm_vdd_tg_fbs_vdd_tg_s_vdd_vdd_vdd_b1_vdd_b2_vdd_b3_vdd_b4_vdd_link_vdd_link_dip_vdd_x1_vdd_x2_vdd_x3_t141 r0 *1 0,0
Ra_d_inv_clk_vdd_inv_mc_vdd_inv_q_vdd_mpa_py_mpb_py_nand_m_vdd_nand_s2_vdd_nwell_vdd_sb_vdd_sr1_vdd_sr2_vdd_sr3_vdd_sr4_vdd_sv_d_vdd_tie_sv_vdd_tg_d_a_tg_d_vdd_tg_fbm_vdd_tg_fbs_vdd_tg_s_vdd_vdd_vdd_b1_vdd_b2_vdd_b3_vdd_b4_vdd_link_vdd_link_dip_vdd_x1_vdd_x2_vdd_x3_t141 vdd__t141 vdd 23.2346706982
* device instance a_d_inv_clk_vdd_inv_mc_vdd_inv_q_vdd_mpa_py_mpb_py_nand_m_vdd_nand_s2_vdd_nwell_vdd_sb_vdd_sr1_vdd_sr2_vdd_sr3_vdd_sr4_vdd_sv_d_vdd_tie_sv_vdd_tg_d_a_tg_d_vdd_tg_fbm_vdd_tg_fbs_vdd_tg_s_vdd_vdd_vdd_b1_vdd_b2_vdd_b3_vdd_b4_vdd_link_vdd_link_dip_vdd_x1_vdd_x2_vdd_x3_t142 r0 *1 0,0
Ra_d_inv_clk_vdd_inv_mc_vdd_inv_q_vdd_mpa_py_mpb_py_nand_m_vdd_nand_s2_vdd_nwell_vdd_sb_vdd_sr1_vdd_sr2_vdd_sr3_vdd_sr4_vdd_sv_d_vdd_tie_sv_vdd_tg_d_a_tg_d_vdd_tg_fbm_vdd_tg_fbs_vdd_tg_s_vdd_vdd_vdd_b1_vdd_b2_vdd_b3_vdd_b4_vdd_link_vdd_link_dip_vdd_x1_vdd_x2_vdd_x3_t142 vdd__t142 vdd 100.442732907
* device instance a_d_inv_clk_vdd_inv_mc_vdd_inv_q_vdd_mpa_py_mpb_py_nand_m_vdd_nand_s2_vdd_nwell_vdd_sb_vdd_sr1_vdd_sr2_vdd_sr3_vdd_sr4_vdd_sv_d_vdd_tie_sv_vdd_tg_d_a_tg_d_vdd_tg_fbm_vdd_tg_fbs_vdd_tg_s_vdd_vdd_vdd_b1_vdd_b2_vdd_b3_vdd_b4_vdd_link_vdd_link_dip_vdd_x1_vdd_x2_vdd_x3_t143 r0 *1 0,0
Ra_d_inv_clk_vdd_inv_mc_vdd_inv_q_vdd_mpa_py_mpb_py_nand_m_vdd_nand_s2_vdd_nwell_vdd_sb_vdd_sr1_vdd_sr2_vdd_sr3_vdd_sr4_vdd_sv_d_vdd_tie_sv_vdd_tg_d_a_tg_d_vdd_tg_fbm_vdd_tg_fbs_vdd_tg_s_vdd_vdd_vdd_b1_vdd_b2_vdd_b3_vdd_b4_vdd_link_vdd_link_dip_vdd_x1_vdd_x2_vdd_x3_t143 vdd__t143 vdd 48.8489499379
* device instance a_d_inv_clk_vdd_inv_mc_vdd_inv_q_vdd_mpa_py_mpb_py_nand_m_vdd_nand_s2_vdd_nwell_vdd_sb_vdd_sr1_vdd_sr2_vdd_sr3_vdd_sr4_vdd_sv_d_vdd_tie_sv_vdd_tg_d_a_tg_d_vdd_tg_fbm_vdd_tg_fbs_vdd_tg_s_vdd_vdd_vdd_b1_vdd_b2_vdd_b3_vdd_b4_vdd_link_vdd_link_dip_vdd_x1_vdd_x2_vdd_x3_t144 r0 *1 0,0
Ra_d_inv_clk_vdd_inv_mc_vdd_inv_q_vdd_mpa_py_mpb_py_nand_m_vdd_nand_s2_vdd_nwell_vdd_sb_vdd_sr1_vdd_sr2_vdd_sr3_vdd_sr4_vdd_sv_d_vdd_tie_sv_vdd_tg_d_a_tg_d_vdd_tg_fbm_vdd_tg_fbs_vdd_tg_s_vdd_vdd_vdd_b1_vdd_b2_vdd_b3_vdd_b4_vdd_link_vdd_link_dip_vdd_x1_vdd_x2_vdd_x3_t144 vdd__t144 vdd 30.522932681
* device instance a_d_inv_clk_vdd_inv_mc_vdd_inv_q_vdd_mpa_py_mpb_py_nand_m_vdd_nand_s2_vdd_nwell_vdd_sb_vdd_sr1_vdd_sr2_vdd_sr3_vdd_sr4_vdd_sv_d_vdd_tie_sv_vdd_tg_d_a_tg_d_vdd_tg_fbm_vdd_tg_fbs_vdd_tg_s_vdd_vdd_vdd_b1_vdd_b2_vdd_b3_vdd_b4_vdd_link_vdd_link_dip_vdd_x1_vdd_x2_vdd_x3_t145 r0 *1 0,0
Ra_d_inv_clk_vdd_inv_mc_vdd_inv_q_vdd_mpa_py_mpb_py_nand_m_vdd_nand_s2_vdd_nwell_vdd_sb_vdd_sr1_vdd_sr2_vdd_sr3_vdd_sr4_vdd_sv_d_vdd_tie_sv_vdd_tg_d_a_tg_d_vdd_tg_fbm_vdd_tg_fbs_vdd_tg_s_vdd_vdd_vdd_b1_vdd_b2_vdd_b3_vdd_b4_vdd_link_vdd_link_dip_vdd_x1_vdd_x2_vdd_x3_t145 vdd__t145 vdd 137.245030204
* device instance a_d_inv_clk_vdd_inv_mc_vdd_inv_q_vdd_mpa_py_mpb_py_nand_m_vdd_nand_s2_vdd_nwell_vdd_sb_vdd_sr1_vdd_sr2_vdd_sr3_vdd_sr4_vdd_sv_d_vdd_tie_sv_vdd_tg_d_a_tg_d_vdd_tg_fbm_vdd_tg_fbs_vdd_tg_s_vdd_vdd_vdd_b1_vdd_b2_vdd_b3_vdd_b4_vdd_link_vdd_link_dip_vdd_x1_vdd_x2_vdd_x3_t146 r0 *1 0,0
Ra_d_inv_clk_vdd_inv_mc_vdd_inv_q_vdd_mpa_py_mpb_py_nand_m_vdd_nand_s2_vdd_nwell_vdd_sb_vdd_sr1_vdd_sr2_vdd_sr3_vdd_sr4_vdd_sv_d_vdd_tie_sv_vdd_tg_d_a_tg_d_vdd_tg_fbm_vdd_tg_fbs_vdd_tg_s_vdd_vdd_vdd_b1_vdd_b2_vdd_b3_vdd_b4_vdd_link_vdd_link_dip_vdd_x1_vdd_x2_vdd_x3_t146 vdd__t146 vdd 76.2777489005
* device instance a_d_inv_clk_vdd_inv_mc_vdd_inv_q_vdd_mpa_py_mpb_py_nand_m_vdd_nand_s2_vdd_nwell_vdd_sb_vdd_sr1_vdd_sr2_vdd_sr3_vdd_sr4_vdd_sv_d_vdd_tie_sv_vdd_tg_d_a_tg_d_vdd_tg_fbm_vdd_tg_fbs_vdd_tg_s_vdd_vdd_vdd_b1_vdd_b2_vdd_b3_vdd_b4_vdd_link_vdd_link_dip_vdd_x1_vdd_x2_vdd_x3_t147 r0 *1 0,0
Ra_d_inv_clk_vdd_inv_mc_vdd_inv_q_vdd_mpa_py_mpb_py_nand_m_vdd_nand_s2_vdd_nwell_vdd_sb_vdd_sr1_vdd_sr2_vdd_sr3_vdd_sr4_vdd_sv_d_vdd_tie_sv_vdd_tg_d_a_tg_d_vdd_tg_fbm_vdd_tg_fbs_vdd_tg_s_vdd_vdd_vdd_b1_vdd_b2_vdd_b3_vdd_b4_vdd_link_vdd_link_dip_vdd_x1_vdd_x2_vdd_x3_t147 vdd__t147 vdd 101.092545773
* device instance a_d_inv_clk_vdd_inv_mc_vdd_inv_q_vdd_mpa_py_mpb_py_nand_m_vdd_nand_s2_vdd_nwell_vdd_sb_vdd_sr1_vdd_sr2_vdd_sr3_vdd_sr4_vdd_sv_d_vdd_tie_sv_vdd_tg_d_a_tg_d_vdd_tg_fbm_vdd_tg_fbs_vdd_tg_s_vdd_vdd_vdd_b1_vdd_b2_vdd_b3_vdd_b4_vdd_link_vdd_link_dip_vdd_x1_vdd_x2_vdd_x3 r0 *1 0,0
Ca_d_inv_clk_vdd_inv_mc_vdd_inv_q_vdd_mpa_py_mpb_py_nand_m_vdd_nand_s2_vdd_nwell_vdd_sb_vdd_sr1_vdd_sr2_vdd_sr3_vdd_sr4_vdd_sv_d_vdd_tie_sv_vdd_tg_d_a_tg_d_vdd_tg_fbm_vdd_tg_fbs_vdd_tg_s_vdd_vdd_vdd_b1_vdd_b2_vdd_b3_vdd_b4_vdd_link_vdd_link_dip_vdd_x1_vdd_x2_vdd_x3 vdd vsubs 1.30595139e-13
* device instance a_d_inva_a_mn12_g0_mp13_g0_ro1_ro1_esc_sr1_d_stub_tg_d_a_y_t0 r0 *1 0,0
Ra_d_inva_a_mn12_g0_mp13_g0_ro1_ro1_esc_sr1_d_stub_tg_d_a_y_t0 ro1__t0 ro1 241.625140689
* device instance a_d_inva_a_mn12_g0_mp13_g0_ro1_ro1_esc_sr1_d_stub_tg_d_a_y_t1 r0 *1 0,0
Ra_d_inva_a_mn12_g0_mp13_g0_ro1_ro1_esc_sr1_d_stub_tg_d_a_y_t1 ro1__t1 ro1 23.3863836703
* device instance a_d_inva_a_mn12_g0_mp13_g0_ro1_ro1_esc_sr1_d_stub_tg_d_a_y_t2 r0 *1 0,0
Ra_d_inva_a_mn12_g0_mp13_g0_ro1_ro1_esc_sr1_d_stub_tg_d_a_y_t2 ro1__t2 ro1 428.386996214
* device instance a_d_inva_a_mn12_g0_mp13_g0_ro1_ro1_esc_sr1_d_stub_tg_d_a_y_t3 r0 *1 0,0
Ra_d_inva_a_mn12_g0_mp13_g0_ro1_ro1_esc_sr1_d_stub_tg_d_a_y_t3 ro1__t3 ro1 34.9604041223
* device instance a_d_inva_a_mn12_g0_mp13_g0_ro1_ro1_esc_sr1_d_stub_tg_d_a_y_t4 r0 *1 0,0
Ra_d_inva_a_mn12_g0_mp13_g0_ro1_ro1_esc_sr1_d_stub_tg_d_a_y_t4 ro1__t4 ro1 434.957769124
* device instance a_d_inva_a_mn12_g0_mp13_g0_ro1_ro1_esc_sr1_d_stub_tg_d_a_y_t5 r0 *1 0,0
Ra_d_inva_a_mn12_g0_mp13_g0_ro1_ro1_esc_sr1_d_stub_tg_d_a_y_t5 ro1__t5 ro1 251.660758886
* device instance a_d_inva_a_mn12_g0_mp13_g0_ro1_ro1_esc_sr1_d_stub_tg_d_a_y_t6 r0 *1 0,0
Ra_d_inva_a_mn12_g0_mp13_g0_ro1_ro1_esc_sr1_d_stub_tg_d_a_y_t6 ro1__t6 ro1 245.493178251
* device instance a_d_inva_a_mn12_g0_mp13_g0_ro1_ro1_esc_sr1_d_stub_tg_d_a_y_t7 r0 *1 0,0
Ra_d_inva_a_mn12_g0_mp13_g0_ro1_ro1_esc_sr1_d_stub_tg_d_a_y_t7 ro1__t7 ro1 180.626969044
* device instance a_d_inva_a_mn12_g0_mp13_g0_ro1_ro1_esc_sr1_d_stub_tg_d_a_y r0 *1 0,0
Ca_d_inva_a_mn12_g0_mp13_g0_ro1_ro1_esc_sr1_d_stub_tg_d_a_y ro1 vsubs 2.4132638e-14
* device instance a_d_inva_a_mn12_g0_mp13_g0_ro3_ro3_esc_e_ro3_esc_w_ro3_hop_sr3_d_stub_tg_d_a_y_t0 r0 *1 0,0
Ra_d_inva_a_mn12_g0_mp13_g0_ro3_ro3_esc_e_ro3_esc_w_ro3_hop_sr3_d_stub_tg_d_a_y_t0 ro3__t0 ro3 253.173111403
* device instance a_d_inva_a_mn12_g0_mp13_g0_ro3_ro3_esc_e_ro3_esc_w_ro3_hop_sr3_d_stub_tg_d_a_y_t1 r0 *1 0,0
Ra_d_inva_a_mn12_g0_mp13_g0_ro3_ro3_esc_e_ro3_esc_w_ro3_hop_sr3_d_stub_tg_d_a_y_t1 ro3__t1 ro3 138.763975578
* device instance a_d_inva_a_mn12_g0_mp13_g0_ro3_ro3_esc_e_ro3_esc_w_ro3_hop_sr3_d_stub_tg_d_a_y_t2 r0 *1 0,0
Ra_d_inva_a_mn12_g0_mp13_g0_ro3_ro3_esc_e_ro3_esc_w_ro3_hop_sr3_d_stub_tg_d_a_y_t2 ro3__t2 ro3 360.832767757
* device instance a_d_inva_a_mn12_g0_mp13_g0_ro3_ro3_esc_e_ro3_esc_w_ro3_hop_sr3_d_stub_tg_d_a_y_t3 r0 *1 0,0
Ra_d_inva_a_mn12_g0_mp13_g0_ro3_ro3_esc_e_ro3_esc_w_ro3_hop_sr3_d_stub_tg_d_a_y_t3 ro3__t3 ro3 363.223914773
* device instance a_d_inva_a_mn12_g0_mp13_g0_ro3_ro3_esc_e_ro3_esc_w_ro3_hop_sr3_d_stub_tg_d_a_y_t4 r0 *1 0,0
Ra_d_inva_a_mn12_g0_mp13_g0_ro3_ro3_esc_e_ro3_esc_w_ro3_hop_sr3_d_stub_tg_d_a_y_t4 ro3__t4 ro3 139.504629136
* device instance a_d_inva_a_mn12_g0_mp13_g0_ro3_ro3_esc_e_ro3_esc_w_ro3_hop_sr3_d_stub_tg_d_a_y_t5 r0 *1 0,0
Ra_d_inva_a_mn12_g0_mp13_g0_ro3_ro3_esc_e_ro3_esc_w_ro3_hop_sr3_d_stub_tg_d_a_y_t5 ro3__t5 ro3 262.264906181
* device instance a_d_inva_a_mn12_g0_mp13_g0_ro3_ro3_esc_e_ro3_esc_w_ro3_hop_sr3_d_stub_tg_d_a_y_t6 r0 *1 0,0
Ra_d_inva_a_mn12_g0_mp13_g0_ro3_ro3_esc_e_ro3_esc_w_ro3_hop_sr3_d_stub_tg_d_a_y_t6 ro3__t6 ro3 260.474719078
* device instance a_d_inva_a_mn12_g0_mp13_g0_ro3_ro3_esc_e_ro3_esc_w_ro3_hop_sr3_d_stub_tg_d_a_y_t7 r0 *1 0,0
Ra_d_inva_a_mn12_g0_mp13_g0_ro3_ro3_esc_e_ro3_esc_w_ro3_hop_sr3_d_stub_tg_d_a_y_t7 ro3__t7 ro3 224.452776094
* device instance a_d_inva_a_mn12_g0_mp13_g0_ro3_ro3_esc_e_ro3_esc_w_ro3_hop_sr3_d_stub_tg_d_a_y r0 *1 0,0
Ca_d_inva_a_mn12_g0_mp13_g0_ro3_ro3_esc_e_ro3_esc_w_ro3_hop_sr3_d_stub_tg_d_a_y ro3 vsubs 4.2174205e-14
* device instance a_d_sb_d_stub_tg_d_a_xo_xo_dip_xo_hop_xo_stub_y_t0 r0 *1 0,0
Ra_d_sb_d_stub_tg_d_a_xo_xo_dip_xo_hop_xo_stub_y_t0 xo__t0 xo 309.65915439
* device instance a_d_sb_d_stub_tg_d_a_xo_xo_dip_xo_hop_xo_stub_y_t1 r0 *1 0,0
Ra_d_sb_d_stub_tg_d_a_xo_xo_dip_xo_hop_xo_stub_y_t1 xo__t1 xo 366.268766032
* device instance a_d_sb_d_stub_tg_d_a_xo_xo_dip_xo_hop_xo_stub_y_t2 r0 *1 0,0
Ra_d_sb_d_stub_tg_d_a_xo_xo_dip_xo_hop_xo_stub_y_t2 xo__t2 xo 590.792974152
* device instance a_d_sb_d_stub_tg_d_a_xo_xo_dip_xo_hop_xo_stub_y_t3 r0 *1 0,0
Ra_d_sb_d_stub_tg_d_a_xo_xo_dip_xo_hop_xo_stub_y_t3 xo__t3 xo 612.347438434
* device instance a_d_sb_d_stub_tg_d_a_xo_xo_dip_xo_hop_xo_stub_y_t4 r0 *1 0,0
Ra_d_sb_d_stub_tg_d_a_xo_xo_dip_xo_hop_xo_stub_y_t4 xo__t4 xo 235.041332418
* device instance a_d_sb_d_stub_tg_d_a_xo_xo_dip_xo_hop_xo_stub_y_t5 r0 *1 0,0
Ra_d_sb_d_stub_tg_d_a_xo_xo_dip_xo_hop_xo_stub_y_t5 xo__t5 xo 310.584634574
* device instance a_d_sb_d_stub_tg_d_a_xo_xo_dip_xo_hop_xo_stub_y r0 *1 0,0
Ca_d_sb_d_stub_tg_d_a_xo_xo_dip_xo_hop_xo_stub_y xo vsubs 1.4299822e-14
* device instance a_g_a_rn1_ro_s4_y_y_t0 r0 *1 0,0
Ra_g_a_rn1_ro_s4_y_y_t0 rn1__t0 rn1 108.856657591
* device instance a_g_a_rn1_ro_s4_y_y_t1 r0 *1 0,0
Ra_g_a_rn1_ro_s4_y_y_t1 rn1__t1 rn1 115.011240917
* device instance a_g_a_rn1_ro_s4_y_y_t2 r0 *1 0,0
Ra_g_a_rn1_ro_s4_y_y_t2 rn1__t2 rn1 234.695939179
* device instance a_g_a_rn1_ro_s4_y_y_t3 r0 *1 0,0
Ra_g_a_rn1_ro_s4_y_y_t3 rn1__t3 rn1 343.168292152
* device instance a_g_a_rn1_ro_s4_y_y_t4 r0 *1 0,0
Ra_g_a_rn1_ro_s4_y_y_t4 rn1__t4 rn1 235.084690218
* device instance a_g_a_rn1_ro_s4_y_y_t5 r0 *1 0,0
Ra_g_a_rn1_ro_s4_y_y_t5 rn1__t5 rn1 345.096279942
* device instance a_g_a_rn1_ro_s4_y_y r0 *1 0,0
Ca_g_a_rn1_ro_s4_y_y rn1 vsubs 6.563292e-15
* device instance a_g_a_rn2_ro_s4_y_y_t0 r0 *1 0,0
Ra_g_a_rn2_ro_s4_y_y_t0 rn2__t0 rn2 108.856657591
* device instance a_g_a_rn2_ro_s4_y_y_t1 r0 *1 0,0
Ra_g_a_rn2_ro_s4_y_y_t1 rn2__t1 rn2 115.011240917
* device instance a_g_a_rn2_ro_s4_y_y_t2 r0 *1 0,0
Ra_g_a_rn2_ro_s4_y_y_t2 rn2__t2 rn2 234.695939179
* device instance a_g_a_rn2_ro_s4_y_y_t3 r0 *1 0,0
Ra_g_a_rn2_ro_s4_y_y_t3 rn2__t3 rn2 343.168292152
* device instance a_g_a_rn2_ro_s4_y_y_t4 r0 *1 0,0
Ra_g_a_rn2_ro_s4_y_y_t4 rn2__t4 rn2 235.084690218
* device instance a_g_a_rn2_ro_s4_y_y_t5 r0 *1 0,0
Ra_g_a_rn2_ro_s4_y_y_t5 rn2__t5 rn2 345.096279942
* device instance a_g_a_rn2_ro_s4_y_y r0 *1 0,0
Ca_g_a_rn2_ro_s4_y_y rn2 vsubs 6.563292e-15
* device instance a_g_a_rn3_ro_s4_y_y_t0 r0 *1 0,0
Ra_g_a_rn3_ro_s4_y_y_t0 rn3__t0 rn3 108.856657591
* device instance a_g_a_rn3_ro_s4_y_y_t1 r0 *1 0,0
Ra_g_a_rn3_ro_s4_y_y_t1 rn3__t1 rn3 115.011240917
* device instance a_g_a_rn3_ro_s4_y_y_t2 r0 *1 0,0
Ra_g_a_rn3_ro_s4_y_y_t2 rn3__t2 rn3 234.695939179
* device instance a_g_a_rn3_ro_s4_y_y_t3 r0 *1 0,0
Ra_g_a_rn3_ro_s4_y_y_t3 rn3__t3 rn3 343.168292152
* device instance a_g_a_rn3_ro_s4_y_y_t4 r0 *1 0,0
Ra_g_a_rn3_ro_s4_y_y_t4 rn3__t4 rn3 235.084690218
* device instance a_g_a_rn3_ro_s4_y_y_t5 r0 *1 0,0
Ra_g_a_rn3_ro_s4_y_y_t5 rn3__t5 rn3 345.096279942
* device instance a_g_a_rn3_ro_s4_y_y r0 *1 0,0
Ca_g_a_rn3_ro_s4_y_y rn3 vsubs 6.563292e-15
* device instance a_g_a_rn4_ro_s4_y_y_t0 r0 *1 0,0
Ra_g_a_rn4_ro_s4_y_y_t0 rn4__t0 rn4 108.856657591
* device instance a_g_a_rn4_ro_s4_y_y_t1 r0 *1 0,0
Ra_g_a_rn4_ro_s4_y_y_t1 rn4__t1 rn4 115.011240917
* device instance a_g_a_rn4_ro_s4_y_y_t2 r0 *1 0,0
Ra_g_a_rn4_ro_s4_y_y_t2 rn4__t2 rn4 343.168292152
* device instance a_g_a_rn4_ro_s4_y_y_t3 r0 *1 0,0
Ra_g_a_rn4_ro_s4_y_y_t3 rn4__t3 rn4 234.695939179
* device instance a_g_a_rn4_ro_s4_y_y_t4 r0 *1 0,0
Ra_g_a_rn4_ro_s4_y_y_t4 rn4__t4 rn4 235.084690218
* device instance a_g_a_rn4_ro_s4_y_y_t5 r0 *1 0,0
Ra_g_a_rn4_ro_s4_y_y_t5 rn4__t5 rn4 345.096279942
* device instance a_g_a_rn4_ro_s4_y_y r0 *1 0,0
Ca_g_a_rn4_ro_s4_y_y rn4 vsubs 6.557229e-15
* device instance a_g_y_mnab_y_mpa_y_mpb_y_n1_s1_a_y_t0 r0 *1 0,0
Ra_g_y_mnab_y_mpa_y_mpb_y_n1_s1_a_y_t0 sig_n1__t0 sig_n1 118.690159634
* device instance a_g_y_mnab_y_mpa_y_mpb_y_n1_s1_a_y_t1 r0 *1 0,0
Ra_g_y_mnab_y_mpa_y_mpb_y_n1_s1_a_y_t1 sig_n1__t1 sig_n1 132.890468841
* device instance a_g_y_mnab_y_mpa_y_mpb_y_n1_s1_a_y_t2 r0 *1 0,0
Ra_g_y_mnab_y_mpa_y_mpb_y_n1_s1_a_y_t2 sig_n1__t2 sig_n1 152.348139631
* device instance a_g_y_mnab_y_mpa_y_mpb_y_n1_s1_a_y_t3 r0 *1 0,0
Ra_g_y_mnab_y_mpa_y_mpb_y_n1_s1_a_y_t3 sig_n1__t3 sig_n1 88.589660111
* device instance a_g_y_mnab_y_mpa_y_mpb_y_n1_s1_a_y_t4 r0 *1 0,0
Ra_g_y_mnab_y_mpa_y_mpb_y_n1_s1_a_y_t4 sig_n1__t4 sig_n1 100.849471782
* device instance a_g_y_mnab_y_mpa_y_mpb_y_n1_s1_a_y r0 *1 0,0
Ca_g_y_mnab_y_mpa_y_mpb_y_n1_s1_a_y sig_n1 vsubs 2.784627e-15
* device instance a_g_y_mnab_y_mpa_y_mpb_y_n1_s1_a_y_dup1_t0 r0 *1 0,0
Ra_g_y_mnab_y_mpa_y_mpb_y_n1_s1_a_y_dup1_t0 sig_n1__t02 sig_n1n1 118.690159634
* device instance a_g_y_mnab_y_mpa_y_mpb_y_n1_s1_a_y_dup1_t1 r0 *1 0,0
Ra_g_y_mnab_y_mpa_y_mpb_y_n1_s1_a_y_dup1_t1 sig_n1__t12 sig_n1n1 132.890468841
* device instance a_g_y_mnab_y_mpa_y_mpb_y_n1_s1_a_y_dup1_t2 r0 *1 0,0
Ra_g_y_mnab_y_mpa_y_mpb_y_n1_s1_a_y_dup1_t2 sig_n1__t22 sig_n1n1 152.348139631
* device instance a_g_y_mnab_y_mpa_y_mpb_y_n1_s1_a_y_dup1_t3 r0 *1 0,0
Ra_g_y_mnab_y_mpa_y_mpb_y_n1_s1_a_y_dup1_t3 sig_n1__t32 sig_n1n1 88.589660111
* device instance a_g_y_mnab_y_mpa_y_mpb_y_n1_s1_a_y_dup1_t4 r0 *1 0,0
Ra_g_y_mnab_y_mpa_y_mpb_y_n1_s1_a_y_dup1_t4 sig_n1__t42 sig_n1n1 100.849471782
* device instance a_g_y_mnab_y_mpa_y_mpb_y_n1_s1_a_y_dup1 r0 *1 0,0
Ca_g_y_mnab_y_mpa_y_mpb_y_n1_s1_a_y_dup1 sig_n1n1 vsubs 2.784627e-15
* device instance a_g_y_mnab_y_mpa_y_mpb_y_n1_s1_a_y_dup2_t0 r0 *1 0,0
Ra_g_y_mnab_y_mpa_y_mpb_y_n1_s1_a_y_dup2_t0 sig_n1__t03 sig_n1n2 118.690159634
* device instance a_g_y_mnab_y_mpa_y_mpb_y_n1_s1_a_y_dup2_t1 r0 *1 0,0
Ra_g_y_mnab_y_mpa_y_mpb_y_n1_s1_a_y_dup2_t1 sig_n1__t13 sig_n1n2 132.890468841
* device instance a_g_y_mnab_y_mpa_y_mpb_y_n1_s1_a_y_dup2_t2 r0 *1 0,0
Ra_g_y_mnab_y_mpa_y_mpb_y_n1_s1_a_y_dup2_t2 sig_n1__t23 sig_n1n2 152.348139631
* device instance a_g_y_mnab_y_mpa_y_mpb_y_n1_s1_a_y_dup2_t3 r0 *1 0,0
Ra_g_y_mnab_y_mpa_y_mpb_y_n1_s1_a_y_dup2_t3 sig_n1__t33 sig_n1n2 88.589660111
* device instance a_g_y_mnab_y_mpa_y_mpb_y_n1_s1_a_y_dup2_t4 r0 *1 0,0
Ra_g_y_mnab_y_mpa_y_mpb_y_n1_s1_a_y_dup2_t4 sig_n1__t43 sig_n1n2 100.849471782
* device instance a_g_y_mnab_y_mpa_y_mpb_y_n1_s1_a_y_dup2 r0 *1 0,0
Ca_g_y_mnab_y_mpa_y_mpb_y_n1_s1_a_y_dup2 sig_n1n2 vsubs 2.784627e-15
* device instance a_g_y_mnab_y_mpa_y_mpb_y_n1_s1_a_y_dup3_t0 r0 *1 0,0
Ra_g_y_mnab_y_mpa_y_mpb_y_n1_s1_a_y_dup3_t0 sig_n1__t04 sig_n1n3 118.690159634
* device instance a_g_y_mnab_y_mpa_y_mpb_y_n1_s1_a_y_dup3_t1 r0 *1 0,0
Ra_g_y_mnab_y_mpa_y_mpb_y_n1_s1_a_y_dup3_t1 sig_n1__t14 sig_n1n3 132.890468841
* device instance a_g_y_mnab_y_mpa_y_mpb_y_n1_s1_a_y_dup3_t2 r0 *1 0,0
Ra_g_y_mnab_y_mpa_y_mpb_y_n1_s1_a_y_dup3_t2 sig_n1__t24 sig_n1n3 152.348139631
* device instance a_g_y_mnab_y_mpa_y_mpb_y_n1_s1_a_y_dup3_t3 r0 *1 0,0
Ra_g_y_mnab_y_mpa_y_mpb_y_n1_s1_a_y_dup3_t3 sig_n1__t34 sig_n1n3 88.589660111
* device instance a_g_y_mnab_y_mpa_y_mpb_y_n1_s1_a_y_dup3_t4 r0 *1 0,0
Ra_g_y_mnab_y_mpa_y_mpb_y_n1_s1_a_y_dup3_t4 sig_n1__t44 sig_n1n3 100.849471782
* device instance a_g_y_mnab_y_mpa_y_mpb_y_n1_s1_a_y_dup3 r0 *1 0,0
Ca_g_y_mnab_y_mpa_y_mpb_y_n1_s1_a_y_dup3 sig_n1n3 vsubs 2.784627e-15
* device instance a_inv_mc_a_mb_mnab_y_mpa_y_mpb_y_nand_m_y_tg_s_a_y_t0 r0 *1 0,0
Ra_inv_mc_a_mb_mnab_y_mpa_y_mpb_y_nand_m_y_tg_s_a_y_t0 mb__t0 mb 145.790727379
* device instance a_inv_mc_a_mb_mnab_y_mpa_y_mpb_y_nand_m_y_tg_s_a_y_t1 r0 *1 0,0
Ra_inv_mc_a_mb_mnab_y_mpa_y_mpb_y_nand_m_y_tg_s_a_y_t1 mb__t1 mb 217.059082598
* device instance a_inv_mc_a_mb_mnab_y_mpa_y_mpb_y_nand_m_y_tg_s_a_y_t2 r0 *1 0,0
Ra_inv_mc_a_mb_mnab_y_mpa_y_mpb_y_nand_m_y_tg_s_a_y_t2 mb__t2 mb 167.783594207
* device instance a_inv_mc_a_mb_mnab_y_mpa_y_mpb_y_nand_m_y_tg_s_a_y_t3 r0 *1 0,0
Ra_inv_mc_a_mb_mnab_y_mpa_y_mpb_y_nand_m_y_tg_s_a_y_t3 mb__t3 mb 220.037214754
* device instance a_inv_mc_a_mb_mnab_y_mpa_y_mpb_y_nand_m_y_tg_s_a_y_t4 r0 *1 0,0
Ra_inv_mc_a_mb_mnab_y_mpa_y_mpb_y_nand_m_y_tg_s_a_y_t4 mb__t4 mb 26.6433173121
* device instance a_inv_mc_a_mb_mnab_y_mpa_y_mpb_y_nand_m_y_tg_s_a_y_t5 r0 *1 0,0
Ra_inv_mc_a_mb_mnab_y_mpa_y_mpb_y_nand_m_y_tg_s_a_y_t5 mb__t5 mb 44.8508293778
* device instance a_inv_mc_a_mb_mnab_y_mpa_y_mpb_y_nand_m_y_tg_s_a_y_t6 r0 *1 0,0
Ra_inv_mc_a_mb_mnab_y_mpa_y_mpb_y_nand_m_y_tg_s_a_y_t6 mb__t6 mb 141.085234372
* device instance a_inv_mc_a_mb_mnab_y_mpa_y_mpb_y_nand_m_y_tg_s_a_y r0 *1 0,0
Ca_inv_mc_a_mb_mnab_y_mpa_y_mpb_y_nand_m_y_tg_s_a_y mb vsubs 4.160899e-15
* device instance a_inv_mc_a_mb_mnab_y_mpa_y_mpb_y_nand_m_y_tg_s_a_y_dup1_t0 r0 *1 0,0
Ra_inv_mc_a_mb_mnab_y_mpa_y_mpb_y_nand_m_y_tg_s_a_y_dup1_t0 mb__t02 mbn1 217.059082598
* device instance a_inv_mc_a_mb_mnab_y_mpa_y_mpb_y_nand_m_y_tg_s_a_y_dup1_t1 r0 *1 0,0
Ra_inv_mc_a_mb_mnab_y_mpa_y_mpb_y_nand_m_y_tg_s_a_y_dup1_t1 mb__t12 mbn1 167.783594207
* device instance a_inv_mc_a_mb_mnab_y_mpa_y_mpb_y_nand_m_y_tg_s_a_y_dup1_t2 r0 *1 0,0
Ra_inv_mc_a_mb_mnab_y_mpa_y_mpb_y_nand_m_y_tg_s_a_y_dup1_t2 mb__t22 mbn1 220.037214754
* device instance a_inv_mc_a_mb_mnab_y_mpa_y_mpb_y_nand_m_y_tg_s_a_y_dup1_t3 r0 *1 0,0
Ra_inv_mc_a_mb_mnab_y_mpa_y_mpb_y_nand_m_y_tg_s_a_y_dup1_t3 mb__t32 mbn1 26.6433173121
* device instance a_inv_mc_a_mb_mnab_y_mpa_y_mpb_y_nand_m_y_tg_s_a_y_dup1_t4 r0 *1 0,0
Ra_inv_mc_a_mb_mnab_y_mpa_y_mpb_y_nand_m_y_tg_s_a_y_dup1_t4 mb__t42 mbn1 44.8508293778
* device instance a_inv_mc_a_mb_mnab_y_mpa_y_mpb_y_nand_m_y_tg_s_a_y_dup1_t5 r0 *1 0,0
Ra_inv_mc_a_mb_mnab_y_mpa_y_mpb_y_nand_m_y_tg_s_a_y_dup1_t5 mb__t52 mbn1 141.085234372
* device instance a_inv_mc_a_mb_mnab_y_mpa_y_mpb_y_nand_m_y_tg_s_a_y_dup1_t6 r0 *1 0,0
Ra_inv_mc_a_mb_mnab_y_mpa_y_mpb_y_nand_m_y_tg_s_a_y_dup1_t6 mb__t62 mbn1 145.790727379
* device instance a_inv_mc_a_mb_mnab_y_mpa_y_mpb_y_nand_m_y_tg_s_a_y_dup1 r0 *1 0,0
Ca_inv_mc_a_mb_mnab_y_mpa_y_mpb_y_nand_m_y_tg_s_a_y_dup1 mbn1 vsubs 4.160899e-15
* device instance a_inv_mc_a_mb_mnab_y_mpa_y_mpb_y_nand_m_y_tg_s_a_y_dup2_t0 r0 *1 0,0
Ra_inv_mc_a_mb_mnab_y_mpa_y_mpb_y_nand_m_y_tg_s_a_y_dup2_t0 mb__t03 mbn2 167.783594207
* device instance a_inv_mc_a_mb_mnab_y_mpa_y_mpb_y_nand_m_y_tg_s_a_y_dup2_t1 r0 *1 0,0
Ra_inv_mc_a_mb_mnab_y_mpa_y_mpb_y_nand_m_y_tg_s_a_y_dup2_t1 mb__t13 mbn2 217.059082598
* device instance a_inv_mc_a_mb_mnab_y_mpa_y_mpb_y_nand_m_y_tg_s_a_y_dup2_t2 r0 *1 0,0
Ra_inv_mc_a_mb_mnab_y_mpa_y_mpb_y_nand_m_y_tg_s_a_y_dup2_t2 mb__t23 mbn2 220.037214754
* device instance a_inv_mc_a_mb_mnab_y_mpa_y_mpb_y_nand_m_y_tg_s_a_y_dup2_t3 r0 *1 0,0
Ra_inv_mc_a_mb_mnab_y_mpa_y_mpb_y_nand_m_y_tg_s_a_y_dup2_t3 mb__t33 mbn2 26.6433173121
* device instance a_inv_mc_a_mb_mnab_y_mpa_y_mpb_y_nand_m_y_tg_s_a_y_dup2_t4 r0 *1 0,0
Ra_inv_mc_a_mb_mnab_y_mpa_y_mpb_y_nand_m_y_tg_s_a_y_dup2_t4 mb__t43 mbn2 44.8508293778
* device instance a_inv_mc_a_mb_mnab_y_mpa_y_mpb_y_nand_m_y_tg_s_a_y_dup2_t5 r0 *1 0,0
Ra_inv_mc_a_mb_mnab_y_mpa_y_mpb_y_nand_m_y_tg_s_a_y_dup2_t5 mb__t53 mbn2 141.085234372
* device instance a_inv_mc_a_mb_mnab_y_mpa_y_mpb_y_nand_m_y_tg_s_a_y_dup2_t6 r0 *1 0,0
Ra_inv_mc_a_mb_mnab_y_mpa_y_mpb_y_nand_m_y_tg_s_a_y_dup2_t6 mb__t63 mbn2 145.790727379
* device instance a_inv_mc_a_mb_mnab_y_mpa_y_mpb_y_nand_m_y_tg_s_a_y_dup2 r0 *1 0,0
Ca_inv_mc_a_mb_mnab_y_mpa_y_mpb_y_nand_m_y_tg_s_a_y_dup2 mbn2 vsubs 4.160899e-15
* device instance a_inv_mc_a_mb_mnab_y_mpa_y_mpb_y_nand_m_y_tg_s_a_y_dup3_t0 r0 *1 0,0
Ra_inv_mc_a_mb_mnab_y_mpa_y_mpb_y_nand_m_y_tg_s_a_y_dup3_t0 mb__t04 mbn3 167.783594207
* device instance a_inv_mc_a_mb_mnab_y_mpa_y_mpb_y_nand_m_y_tg_s_a_y_dup3_t1 r0 *1 0,0
Ra_inv_mc_a_mb_mnab_y_mpa_y_mpb_y_nand_m_y_tg_s_a_y_dup3_t1 mb__t14 mbn3 217.059082598
* device instance a_inv_mc_a_mb_mnab_y_mpa_y_mpb_y_nand_m_y_tg_s_a_y_dup3_t2 r0 *1 0,0
Ra_inv_mc_a_mb_mnab_y_mpa_y_mpb_y_nand_m_y_tg_s_a_y_dup3_t2 mb__t24 mbn3 220.037214754
* device instance a_inv_mc_a_mb_mnab_y_mpa_y_mpb_y_nand_m_y_tg_s_a_y_dup3_t3 r0 *1 0,0
Ra_inv_mc_a_mb_mnab_y_mpa_y_mpb_y_nand_m_y_tg_s_a_y_dup3_t3 mb__t34 mbn3 26.6433173121
* device instance a_inv_mc_a_mb_mnab_y_mpa_y_mpb_y_nand_m_y_tg_s_a_y_dup3_t4 r0 *1 0,0
Ra_inv_mc_a_mb_mnab_y_mpa_y_mpb_y_nand_m_y_tg_s_a_y_dup3_t4 mb__t44 mbn3 44.8508293778
* device instance a_inv_mc_a_mb_mnab_y_mpa_y_mpb_y_nand_m_y_tg_s_a_y_dup3_t5 r0 *1 0,0
Ra_inv_mc_a_mb_mnab_y_mpa_y_mpb_y_nand_m_y_tg_s_a_y_dup3_t5 mb__t54 mbn3 141.085234372
* device instance a_inv_mc_a_mb_mnab_y_mpa_y_mpb_y_nand_m_y_tg_s_a_y_dup3_t6 r0 *1 0,0
Ra_inv_mc_a_mb_mnab_y_mpa_y_mpb_y_nand_m_y_tg_s_a_y_dup3_t6 mb__t64 mbn3 145.790727379
* device instance a_inv_mc_a_mb_mnab_y_mpa_y_mpb_y_nand_m_y_tg_s_a_y_dup3 r0 *1 0,0
Ca_inv_mc_a_mb_mnab_y_mpa_y_mpb_y_nand_m_y_tg_s_a_y_dup3 mbn3 vsubs 4.160899e-15
* device instance a_inv_mc_a_mb_mnab_y_mpa_y_mpb_y_nand_m_y_tg_s_a_y_dup4_t0 r0 *1 0,0
Ra_inv_mc_a_mb_mnab_y_mpa_y_mpb_y_nand_m_y_tg_s_a_y_dup4_t0 mb__t05 mbn4 217.059082598
* device instance a_inv_mc_a_mb_mnab_y_mpa_y_mpb_y_nand_m_y_tg_s_a_y_dup4_t1 r0 *1 0,0
Ra_inv_mc_a_mb_mnab_y_mpa_y_mpb_y_nand_m_y_tg_s_a_y_dup4_t1 mb__t15 mbn4 167.783594207
* device instance a_inv_mc_a_mb_mnab_y_mpa_y_mpb_y_nand_m_y_tg_s_a_y_dup4_t2 r0 *1 0,0
Ra_inv_mc_a_mb_mnab_y_mpa_y_mpb_y_nand_m_y_tg_s_a_y_dup4_t2 mb__t25 mbn4 220.037214754
* device instance a_inv_mc_a_mb_mnab_y_mpa_y_mpb_y_nand_m_y_tg_s_a_y_dup4_t3 r0 *1 0,0
Ra_inv_mc_a_mb_mnab_y_mpa_y_mpb_y_nand_m_y_tg_s_a_y_dup4_t3 mb__t35 mbn4 26.6433173121
* device instance a_inv_mc_a_mb_mnab_y_mpa_y_mpb_y_nand_m_y_tg_s_a_y_dup4_t4 r0 *1 0,0
Ra_inv_mc_a_mb_mnab_y_mpa_y_mpb_y_nand_m_y_tg_s_a_y_dup4_t4 mb__t45 mbn4 44.8508293778
* device instance a_inv_mc_a_mb_mnab_y_mpa_y_mpb_y_nand_m_y_tg_s_a_y_dup4_t5 r0 *1 0,0
Ra_inv_mc_a_mb_mnab_y_mpa_y_mpb_y_nand_m_y_tg_s_a_y_dup4_t5 mb__t55 mbn4 141.085234372
* device instance a_inv_mc_a_mb_mnab_y_mpa_y_mpb_y_nand_m_y_tg_s_a_y_dup4_t6 r0 *1 0,0
Ra_inv_mc_a_mb_mnab_y_mpa_y_mpb_y_nand_m_y_tg_s_a_y_dup4_t6 mb__t65 mbn4 145.790727379
* device instance a_inv_mc_a_mb_mnab_y_mpa_y_mpb_y_nand_m_y_tg_s_a_y_dup4 r0 *1 0,0
Ca_inv_mc_a_mb_mnab_y_mpa_y_mpb_y_nand_m_y_tg_s_a_y_dup4 mbn4 vsubs 4.160899e-15
* device instance a_inv_mc_a_mb_mnab_y_mpa_y_mpb_y_nand_m_y_tg_s_a_y_dup5_t0 r0 *1 0,0
Ra_inv_mc_a_mb_mnab_y_mpa_y_mpb_y_nand_m_y_tg_s_a_y_dup5_t0 mb__t06 mbn5 217.059082598
* device instance a_inv_mc_a_mb_mnab_y_mpa_y_mpb_y_nand_m_y_tg_s_a_y_dup5_t1 r0 *1 0,0
Ra_inv_mc_a_mb_mnab_y_mpa_y_mpb_y_nand_m_y_tg_s_a_y_dup5_t1 mb__t16 mbn5 167.783594207
* device instance a_inv_mc_a_mb_mnab_y_mpa_y_mpb_y_nand_m_y_tg_s_a_y_dup5_t2 r0 *1 0,0
Ra_inv_mc_a_mb_mnab_y_mpa_y_mpb_y_nand_m_y_tg_s_a_y_dup5_t2 mb__t26 mbn5 220.037214754
* device instance a_inv_mc_a_mb_mnab_y_mpa_y_mpb_y_nand_m_y_tg_s_a_y_dup5_t3 r0 *1 0,0
Ra_inv_mc_a_mb_mnab_y_mpa_y_mpb_y_nand_m_y_tg_s_a_y_dup5_t3 mb__t36 mbn5 26.6433173121
* device instance a_inv_mc_a_mb_mnab_y_mpa_y_mpb_y_nand_m_y_tg_s_a_y_dup5_t4 r0 *1 0,0
Ra_inv_mc_a_mb_mnab_y_mpa_y_mpb_y_nand_m_y_tg_s_a_y_dup5_t4 mb__t46 mbn5 44.8508293778
* device instance a_inv_mc_a_mb_mnab_y_mpa_y_mpb_y_nand_m_y_tg_s_a_y_dup5_t5 r0 *1 0,0
Ra_inv_mc_a_mb_mnab_y_mpa_y_mpb_y_nand_m_y_tg_s_a_y_dup5_t5 mb__t56 mbn5 141.085234372
* device instance a_inv_mc_a_mb_mnab_y_mpa_y_mpb_y_nand_m_y_tg_s_a_y_dup5_t6 r0 *1 0,0
Ra_inv_mc_a_mb_mnab_y_mpa_y_mpb_y_nand_m_y_tg_s_a_y_dup5_t6 mb__t66 mbn5 145.790727379
* device instance a_inv_mc_a_mb_mnab_y_mpa_y_mpb_y_nand_m_y_tg_s_a_y_dup5 r0 *1 0,0
Ca_inv_mc_a_mb_mnab_y_mpa_y_mpb_y_nand_m_y_tg_s_a_y_dup5 mbn5 vsubs 4.160899e-15
* device instance a_inv_mc_y_inv_mc_y_via_mc_tg_fbm_a_tg_fbm_a_via_y_t0 r0 *1 0,0
Ra_inv_mc_y_inv_mc_y_via_mc_tg_fbm_a_tg_fbm_a_via_y_t0 mc__t0 mc 208.313425
* device instance a_inv_mc_y_inv_mc_y_via_mc_tg_fbm_a_tg_fbm_a_via_y_t1 r0 *1 0,0
Ra_inv_mc_y_inv_mc_y_via_mc_tg_fbm_a_tg_fbm_a_via_y_t1 mc__t1 mc 208.313425
* device instance a_inv_mc_y_inv_mc_y_via_mc_tg_fbm_a_tg_fbm_a_via_y_t2 r0 *1 0,0
Ra_inv_mc_y_inv_mc_y_via_mc_tg_fbm_a_tg_fbm_a_via_y_t2 mc__t2 mc 208.313425
* device instance a_inv_mc_y_inv_mc_y_via_mc_tg_fbm_a_tg_fbm_a_via_y_t3 r0 *1 0,0
Ra_inv_mc_y_inv_mc_y_via_mc_tg_fbm_a_tg_fbm_a_via_y_t3 mc__t3 mc 208.313425
* device instance a_inv_mc_y_inv_mc_y_via_mc_tg_fbm_a_tg_fbm_a_via_y r0 *1 0,0
Ca_inv_mc_y_inv_mc_y_via_mc_tg_fbm_a_tg_fbm_a_via_y mc vsubs 1.955756e-15
* device instance a_inv_mc_y_inv_mc_y_via_mc_tg_fbm_a_tg_fbm_a_via_y_dup1_t0 r0 *1 0,0
Ra_inv_mc_y_inv_mc_y_via_mc_tg_fbm_a_tg_fbm_a_via_y_dup1_t0 mc__t02 mcn1 208.313425
* device instance a_inv_mc_y_inv_mc_y_via_mc_tg_fbm_a_tg_fbm_a_via_y_dup1_t1 r0 *1 0,0
Ra_inv_mc_y_inv_mc_y_via_mc_tg_fbm_a_tg_fbm_a_via_y_dup1_t1 mc__t12 mcn1 208.313425
* device instance a_inv_mc_y_inv_mc_y_via_mc_tg_fbm_a_tg_fbm_a_via_y_dup1_t2 r0 *1 0,0
Ra_inv_mc_y_inv_mc_y_via_mc_tg_fbm_a_tg_fbm_a_via_y_dup1_t2 mc__t22 mcn1 208.313425
* device instance a_inv_mc_y_inv_mc_y_via_mc_tg_fbm_a_tg_fbm_a_via_y_dup1_t3 r0 *1 0,0
Ra_inv_mc_y_inv_mc_y_via_mc_tg_fbm_a_tg_fbm_a_via_y_dup1_t3 mc__t32 mcn1 208.313425
* device instance a_inv_mc_y_inv_mc_y_via_mc_tg_fbm_a_tg_fbm_a_via_y_dup1 r0 *1 0,0
Ca_inv_mc_y_inv_mc_y_via_mc_tg_fbm_a_tg_fbm_a_via_y_dup1 mcn1 vsubs 1.955756e-15
* device instance a_inv_mc_y_inv_mc_y_via_mc_tg_fbm_a_tg_fbm_a_via_y_dup2_t0 r0 *1 0,0
Ra_inv_mc_y_inv_mc_y_via_mc_tg_fbm_a_tg_fbm_a_via_y_dup2_t0 mc__t03 mcn2 208.313425
* device instance a_inv_mc_y_inv_mc_y_via_mc_tg_fbm_a_tg_fbm_a_via_y_dup2_t1 r0 *1 0,0
Ra_inv_mc_y_inv_mc_y_via_mc_tg_fbm_a_tg_fbm_a_via_y_dup2_t1 mc__t13 mcn2 208.313425
* device instance a_inv_mc_y_inv_mc_y_via_mc_tg_fbm_a_tg_fbm_a_via_y_dup2_t2 r0 *1 0,0
Ra_inv_mc_y_inv_mc_y_via_mc_tg_fbm_a_tg_fbm_a_via_y_dup2_t2 mc__t23 mcn2 208.313425
* device instance a_inv_mc_y_inv_mc_y_via_mc_tg_fbm_a_tg_fbm_a_via_y_dup2_t3 r0 *1 0,0
Ra_inv_mc_y_inv_mc_y_via_mc_tg_fbm_a_tg_fbm_a_via_y_dup2_t3 mc__t33 mcn2 208.313425
* device instance a_inv_mc_y_inv_mc_y_via_mc_tg_fbm_a_tg_fbm_a_via_y_dup2 r0 *1 0,0
Ca_inv_mc_y_inv_mc_y_via_mc_tg_fbm_a_tg_fbm_a_via_y_dup2 mcn2 vsubs 1.955756e-15
* device instance a_inv_mc_y_inv_mc_y_via_mc_tg_fbm_a_tg_fbm_a_via_y_dup3_t0 r0 *1 0,0
Ra_inv_mc_y_inv_mc_y_via_mc_tg_fbm_a_tg_fbm_a_via_y_dup3_t0 mc__t04 mcn3 208.313425
* device instance a_inv_mc_y_inv_mc_y_via_mc_tg_fbm_a_tg_fbm_a_via_y_dup3_t1 r0 *1 0,0
Ra_inv_mc_y_inv_mc_y_via_mc_tg_fbm_a_tg_fbm_a_via_y_dup3_t1 mc__t14 mcn3 208.313425
* device instance a_inv_mc_y_inv_mc_y_via_mc_tg_fbm_a_tg_fbm_a_via_y_dup3_t2 r0 *1 0,0
Ra_inv_mc_y_inv_mc_y_via_mc_tg_fbm_a_tg_fbm_a_via_y_dup3_t2 mc__t24 mcn3 208.313425
* device instance a_inv_mc_y_inv_mc_y_via_mc_tg_fbm_a_tg_fbm_a_via_y_dup3_t3 r0 *1 0,0
Ra_inv_mc_y_inv_mc_y_via_mc_tg_fbm_a_tg_fbm_a_via_y_dup3_t3 mc__t34 mcn3 208.313425
* device instance a_inv_mc_y_inv_mc_y_via_mc_tg_fbm_a_tg_fbm_a_via_y_dup3 r0 *1 0,0
Ca_inv_mc_y_inv_mc_y_via_mc_tg_fbm_a_tg_fbm_a_via_y_dup3 mcn3 vsubs 1.955756e-15
* device instance a_inv_mc_y_inv_mc_y_via_mc_tg_fbm_a_tg_fbm_a_via_y_dup4_t0 r0 *1 0,0
Ra_inv_mc_y_inv_mc_y_via_mc_tg_fbm_a_tg_fbm_a_via_y_dup4_t0 mc__t05 mcn4 208.313425
* device instance a_inv_mc_y_inv_mc_y_via_mc_tg_fbm_a_tg_fbm_a_via_y_dup4_t1 r0 *1 0,0
Ra_inv_mc_y_inv_mc_y_via_mc_tg_fbm_a_tg_fbm_a_via_y_dup4_t1 mc__t15 mcn4 208.313425
* device instance a_inv_mc_y_inv_mc_y_via_mc_tg_fbm_a_tg_fbm_a_via_y_dup4_t2 r0 *1 0,0
Ra_inv_mc_y_inv_mc_y_via_mc_tg_fbm_a_tg_fbm_a_via_y_dup4_t2 mc__t25 mcn4 208.313425
* device instance a_inv_mc_y_inv_mc_y_via_mc_tg_fbm_a_tg_fbm_a_via_y_dup4_t3 r0 *1 0,0
Ra_inv_mc_y_inv_mc_y_via_mc_tg_fbm_a_tg_fbm_a_via_y_dup4_t3 mc__t35 mcn4 208.313425
* device instance a_inv_mc_y_inv_mc_y_via_mc_tg_fbm_a_tg_fbm_a_via_y_dup4 r0 *1 0,0
Ca_inv_mc_y_inv_mc_y_via_mc_tg_fbm_a_tg_fbm_a_via_y_dup4 mcn4 vsubs 1.955756e-15
* device instance a_inv_mc_y_inv_mc_y_via_mc_tg_fbm_a_tg_fbm_a_via_y_dup5_t0 r0 *1 0,0
Ra_inv_mc_y_inv_mc_y_via_mc_tg_fbm_a_tg_fbm_a_via_y_dup5_t0 mc__t06 mcn5 208.313425
* device instance a_inv_mc_y_inv_mc_y_via_mc_tg_fbm_a_tg_fbm_a_via_y_dup5_t1 r0 *1 0,0
Ra_inv_mc_y_inv_mc_y_via_mc_tg_fbm_a_tg_fbm_a_via_y_dup5_t1 mc__t16 mcn5 208.313425
* device instance a_inv_mc_y_inv_mc_y_via_mc_tg_fbm_a_tg_fbm_a_via_y_dup5_t2 r0 *1 0,0
Ra_inv_mc_y_inv_mc_y_via_mc_tg_fbm_a_tg_fbm_a_via_y_dup5_t2 mc__t26 mcn5 208.313425
* device instance a_inv_mc_y_inv_mc_y_via_mc_tg_fbm_a_tg_fbm_a_via_y_dup5_t3 r0 *1 0,0
Ra_inv_mc_y_inv_mc_y_via_mc_tg_fbm_a_tg_fbm_a_via_y_dup5_t3 mc__t36 mcn5 208.313425
* device instance a_inv_mc_y_inv_mc_y_via_mc_tg_fbm_a_tg_fbm_a_via_y_dup5 r0 *1 0,0
Ca_inv_mc_y_inv_mc_y_via_mc_tg_fbm_a_tg_fbm_a_via_y_dup5 mcn5 vsubs 1.955756e-15
* device instance a_inv_q_y_inv_q_y_via_inv_q_y_via2_nand_s2_a_nand_s2_a_stub_nand_s2_a_via_nand_s2_a_via2_q_y_t0 r0 *1 0,0
Ra_inv_q_y_inv_q_y_via_inv_q_y_via2_nand_s2_a_nand_s2_a_stub_nand_s2_a_via_nand_s2_a_via2_q_y_t0 raw_bit__t0 raw_bit 233.614896758
* device instance a_inv_q_y_inv_q_y_via_inv_q_y_via2_nand_s2_a_nand_s2_a_stub_nand_s2_a_via_nand_s2_a_via2_q_y_t1 r0 *1 0,0
Ra_inv_q_y_inv_q_y_via_inv_q_y_via2_nand_s2_a_nand_s2_a_stub_nand_s2_a_via_nand_s2_a_via2_q_y_t1 raw_bit__t1 raw_bit 241.108451742
* device instance a_inv_q_y_inv_q_y_via_inv_q_y_via2_nand_s2_a_nand_s2_a_stub_nand_s2_a_via_nand_s2_a_via2_q_y_t2 r0 *1 0,0
Ra_inv_q_y_inv_q_y_via_inv_q_y_via2_nand_s2_a_nand_s2_a_stub_nand_s2_a_via_nand_s2_a_via2_q_y_t2 raw_bit__t2 raw_bit 254.024587343
* device instance a_inv_q_y_inv_q_y_via_inv_q_y_via2_nand_s2_a_nand_s2_a_stub_nand_s2_a_via_nand_s2_a_via2_q_y_t3 r0 *1 0,0
Ra_inv_q_y_inv_q_y_via_inv_q_y_via2_nand_s2_a_nand_s2_a_stub_nand_s2_a_via_nand_s2_a_via2_q_y_t3 raw_bit__t3 raw_bit 236.747864158
* device instance a_inv_q_y_inv_q_y_via_inv_q_y_via2_nand_s2_a_nand_s2_a_stub_nand_s2_a_via_nand_s2_a_via2_q_y r0 *1 0,0
Ca_inv_q_y_inv_q_y_via_inv_q_y_via2_nand_s2_a_nand_s2_a_stub_nand_s2_a_via_nand_s2_a_via2_q_y raw_bit vsubs 2.344911e-15
* device instance a_inv_q_y_inv_q_y_via_inv_q_y_via2_nand_s2_a_nand_s2_a_stub_nand_s2_a_via_nand_s2_a_via2_q_y_dup1_t0 r0 *1 0,0
Ra_inv_q_y_inv_q_y_via_inv_q_y_via2_nand_s2_a_nand_s2_a_stub_nand_s2_a_via_nand_s2_a_via2_q_y_dup1_t0 raw_bit__t02 raw_valid 233.614896758
* device instance a_inv_q_y_inv_q_y_via_inv_q_y_via2_nand_s2_a_nand_s2_a_stub_nand_s2_a_via_nand_s2_a_via2_q_y_dup1_t1 r0 *1 0,0
Ra_inv_q_y_inv_q_y_via_inv_q_y_via2_nand_s2_a_nand_s2_a_stub_nand_s2_a_via_nand_s2_a_via2_q_y_dup1_t1 raw_bit__t12 raw_valid 241.108451742
* device instance a_inv_q_y_inv_q_y_via_inv_q_y_via2_nand_s2_a_nand_s2_a_stub_nand_s2_a_via_nand_s2_a_via2_q_y_dup1_t2 r0 *1 0,0
Ra_inv_q_y_inv_q_y_via_inv_q_y_via2_nand_s2_a_nand_s2_a_stub_nand_s2_a_via_nand_s2_a_via2_q_y_dup1_t2 raw_bit__t22 raw_valid 254.024587343
* device instance a_inv_q_y_inv_q_y_via_inv_q_y_via2_nand_s2_a_nand_s2_a_stub_nand_s2_a_via_nand_s2_a_via2_q_y_dup1_t3 r0 *1 0,0
Ra_inv_q_y_inv_q_y_via_inv_q_y_via2_nand_s2_a_nand_s2_a_stub_nand_s2_a_via_nand_s2_a_via2_q_y_dup1_t3 raw_bit__t32 raw_valid 236.747864158
* device instance a_inv_q_y_inv_q_y_via_inv_q_y_via2_nand_s2_a_nand_s2_a_stub_nand_s2_a_via_nand_s2_a_via2_q_y_dup1 r0 *1 0,0
Ca_inv_q_y_inv_q_y_via_inv_q_y_via2_nand_s2_a_nand_s2_a_stub_nand_s2_a_via_nand_s2_a_via2_q_y_dup1 raw_valid vsubs 2.344911e-15
* device instance a_inv_q_y_inv_q_y_via_inv_q_y_via2_nand_s2_a_nand_s2_a_stub_nand_s2_a_via_nand_s2_a_via2_q_y_dup2_t0 r0 *1 0,0
Ra_inv_q_y_inv_q_y_via_inv_q_y_via2_nand_s2_a_nand_s2_a_stub_nand_s2_a_via_nand_s2_a_via2_q_y_dup2_t0 raw_bit__t03 ring_bit1 233.614896758
* device instance a_inv_q_y_inv_q_y_via_inv_q_y_via2_nand_s2_a_nand_s2_a_stub_nand_s2_a_via_nand_s2_a_via2_q_y_dup2_t1 r0 *1 0,0
Ra_inv_q_y_inv_q_y_via_inv_q_y_via2_nand_s2_a_nand_s2_a_stub_nand_s2_a_via_nand_s2_a_via2_q_y_dup2_t1 raw_bit__t13 ring_bit1 241.108451742
* device instance a_inv_q_y_inv_q_y_via_inv_q_y_via2_nand_s2_a_nand_s2_a_stub_nand_s2_a_via_nand_s2_a_via2_q_y_dup2_t2 r0 *1 0,0
Ra_inv_q_y_inv_q_y_via_inv_q_y_via2_nand_s2_a_nand_s2_a_stub_nand_s2_a_via_nand_s2_a_via2_q_y_dup2_t2 raw_bit__t23 ring_bit1 254.024587343
* device instance a_inv_q_y_inv_q_y_via_inv_q_y_via2_nand_s2_a_nand_s2_a_stub_nand_s2_a_via_nand_s2_a_via2_q_y_dup2_t3 r0 *1 0,0
Ra_inv_q_y_inv_q_y_via_inv_q_y_via2_nand_s2_a_nand_s2_a_stub_nand_s2_a_via_nand_s2_a_via2_q_y_dup2_t3 raw_bit__t33 ring_bit1 236.747864158
* device instance a_inv_q_y_inv_q_y_via_inv_q_y_via2_nand_s2_a_nand_s2_a_stub_nand_s2_a_via_nand_s2_a_via2_q_y_dup2 r0 *1 0,0
Ca_inv_q_y_inv_q_y_via_inv_q_y_via2_nand_s2_a_nand_s2_a_stub_nand_s2_a_via_nand_s2_a_via2_q_y_dup2 ring_bit1 vsubs 2.344911e-15
* device instance a_inv_q_y_inv_q_y_via_inv_q_y_via2_nand_s2_a_nand_s2_a_stub_nand_s2_a_via_nand_s2_a_via2_q_y_dup3_t0 r0 *1 0,0
Ra_inv_q_y_inv_q_y_via_inv_q_y_via2_nand_s2_a_nand_s2_a_stub_nand_s2_a_via_nand_s2_a_via2_q_y_dup3_t0 raw_bit__t04 ring_bit2 233.614896758
* device instance a_inv_q_y_inv_q_y_via_inv_q_y_via2_nand_s2_a_nand_s2_a_stub_nand_s2_a_via_nand_s2_a_via2_q_y_dup3_t1 r0 *1 0,0
Ra_inv_q_y_inv_q_y_via_inv_q_y_via2_nand_s2_a_nand_s2_a_stub_nand_s2_a_via_nand_s2_a_via2_q_y_dup3_t1 raw_bit__t14 ring_bit2 241.108451742
* device instance a_inv_q_y_inv_q_y_via_inv_q_y_via2_nand_s2_a_nand_s2_a_stub_nand_s2_a_via_nand_s2_a_via2_q_y_dup3_t2 r0 *1 0,0
Ra_inv_q_y_inv_q_y_via_inv_q_y_via2_nand_s2_a_nand_s2_a_stub_nand_s2_a_via_nand_s2_a_via2_q_y_dup3_t2 raw_bit__t24 ring_bit2 254.024587343
* device instance a_inv_q_y_inv_q_y_via_inv_q_y_via2_nand_s2_a_nand_s2_a_stub_nand_s2_a_via_nand_s2_a_via2_q_y_dup3_t3 r0 *1 0,0
Ra_inv_q_y_inv_q_y_via_inv_q_y_via2_nand_s2_a_nand_s2_a_stub_nand_s2_a_via_nand_s2_a_via2_q_y_dup3_t3 raw_bit__t34 ring_bit2 236.747864158
* device instance a_inv_q_y_inv_q_y_via_inv_q_y_via2_nand_s2_a_nand_s2_a_stub_nand_s2_a_via_nand_s2_a_via2_q_y_dup3 r0 *1 0,0
Ca_inv_q_y_inv_q_y_via_inv_q_y_via2_nand_s2_a_nand_s2_a_stub_nand_s2_a_via_nand_s2_a_via2_q_y_dup3 ring_bit2 vsubs 2.344911e-15
* device instance a_inv_q_y_inv_q_y_via_inv_q_y_via2_nand_s2_a_nand_s2_a_stub_nand_s2_a_via_nand_s2_a_via2_q_y_dup4_t0 r0 *1 0,0
Ra_inv_q_y_inv_q_y_via_inv_q_y_via2_nand_s2_a_nand_s2_a_stub_nand_s2_a_via_nand_s2_a_via2_q_y_dup4_t0 raw_bit__t05 ring_bit3 233.614896758
* device instance a_inv_q_y_inv_q_y_via_inv_q_y_via2_nand_s2_a_nand_s2_a_stub_nand_s2_a_via_nand_s2_a_via2_q_y_dup4_t1 r0 *1 0,0
Ra_inv_q_y_inv_q_y_via_inv_q_y_via2_nand_s2_a_nand_s2_a_stub_nand_s2_a_via_nand_s2_a_via2_q_y_dup4_t1 raw_bit__t15 ring_bit3 241.108451742
* device instance a_inv_q_y_inv_q_y_via_inv_q_y_via2_nand_s2_a_nand_s2_a_stub_nand_s2_a_via_nand_s2_a_via2_q_y_dup4_t2 r0 *1 0,0
Ra_inv_q_y_inv_q_y_via_inv_q_y_via2_nand_s2_a_nand_s2_a_stub_nand_s2_a_via_nand_s2_a_via2_q_y_dup4_t2 raw_bit__t25 ring_bit3 254.024587343
* device instance a_inv_q_y_inv_q_y_via_inv_q_y_via2_nand_s2_a_nand_s2_a_stub_nand_s2_a_via_nand_s2_a_via2_q_y_dup4_t3 r0 *1 0,0
Ra_inv_q_y_inv_q_y_via_inv_q_y_via2_nand_s2_a_nand_s2_a_stub_nand_s2_a_via_nand_s2_a_via2_q_y_dup4_t3 raw_bit__t35 ring_bit3 236.747864158
* device instance a_inv_q_y_inv_q_y_via_inv_q_y_via2_nand_s2_a_nand_s2_a_stub_nand_s2_a_via_nand_s2_a_via2_q_y_dup4 r0 *1 0,0
Ca_inv_q_y_inv_q_y_via_inv_q_y_via2_nand_s2_a_nand_s2_a_stub_nand_s2_a_via_nand_s2_a_via2_q_y_dup4 ring_bit3 vsubs 2.344911e-15
* device instance a_inv_q_y_inv_q_y_via_inv_q_y_via2_nand_s2_a_nand_s2_a_stub_nand_s2_a_via_nand_s2_a_via2_q_y_dup5_t0 r0 *1 0,0
Ra_inv_q_y_inv_q_y_via_inv_q_y_via2_nand_s2_a_nand_s2_a_stub_nand_s2_a_via_nand_s2_a_via2_q_y_dup5_t0 raw_bit__t06 ring_bit4 233.614896758
* device instance a_inv_q_y_inv_q_y_via_inv_q_y_via2_nand_s2_a_nand_s2_a_stub_nand_s2_a_via_nand_s2_a_via2_q_y_dup5_t1 r0 *1 0,0
Ra_inv_q_y_inv_q_y_via_inv_q_y_via2_nand_s2_a_nand_s2_a_stub_nand_s2_a_via_nand_s2_a_via2_q_y_dup5_t1 raw_bit__t16 ring_bit4 241.108451742
* device instance a_inv_q_y_inv_q_y_via_inv_q_y_via2_nand_s2_a_nand_s2_a_stub_nand_s2_a_via_nand_s2_a_via2_q_y_dup5_t2 r0 *1 0,0
Ra_inv_q_y_inv_q_y_via_inv_q_y_via2_nand_s2_a_nand_s2_a_stub_nand_s2_a_via_nand_s2_a_via2_q_y_dup5_t2 raw_bit__t26 ring_bit4 254.024587343
* device instance a_inv_q_y_inv_q_y_via_inv_q_y_via2_nand_s2_a_nand_s2_a_stub_nand_s2_a_via_nand_s2_a_via2_q_y_dup5_t3 r0 *1 0,0
Ra_inv_q_y_inv_q_y_via_inv_q_y_via2_nand_s2_a_nand_s2_a_stub_nand_s2_a_via_nand_s2_a_via2_q_y_dup5_t3 raw_bit__t36 ring_bit4 236.747864158
* device instance a_inv_q_y_inv_q_y_via_inv_q_y_via2_nand_s2_a_nand_s2_a_stub_nand_s2_a_via_nand_s2_a_via2_q_y_dup5 r0 *1 0,0
Ca_inv_q_y_inv_q_y_via_inv_q_y_via2_nand_s2_a_nand_s2_a_stub_nand_s2_a_via_nand_s2_a_via2_q_y_dup5 ring_bit4 vsubs 2.344911e-15
* device instance a_inva_a_mn12_g0_mp13_g0_t1_y_t0 r0 *1 0,0
Ra_inva_a_mn12_g0_mp13_g0_t1_y_t0 t1__t0 t1 393.96501156
* device instance a_inva_a_mn12_g0_mp13_g0_t1_y_t1 r0 *1 0,0
Ra_inva_a_mn12_g0_mp13_g0_t1_y_t1 t1__t1 t1 355.301959278
* device instance a_inva_a_mn12_g0_mp13_g0_t1_y_t2 r0 *1 0,0
Ra_inva_a_mn12_g0_mp13_g0_t1_y_t2 t1__t2 t1 312.148663125
* device instance a_inva_a_mn12_g0_mp13_g0_t1_y_t3 r0 *1 0,0
Ra_inva_a_mn12_g0_mp13_g0_t1_y_t3 t1__t3 t1 297.753615342
* device instance a_inva_a_mn12_g0_mp13_g0_t1_y_t4 r0 *1 0,0
Ra_inva_a_mn12_g0_mp13_g0_t1_y_t4 t1__t4 t1 299.162613598
* device instance a_inva_a_mn12_g0_mp13_g0_t1_y_t5 r0 *1 0,0
Ra_inva_a_mn12_g0_mp13_g0_t1_y_t5 t1__t5 t1 447.569121132
* device instance a_inva_a_mn12_g0_mp13_g0_t1_y_t6 r0 *1 0,0
Ra_inva_a_mn12_g0_mp13_g0_t1_y_t6 t1__t6 t1 396.959960366
* device instance a_inva_a_mn12_g0_mp13_g0_t1_y_t7 r0 *1 0,0
Ra_inva_a_mn12_g0_mp13_g0_t1_y_t7 t1__t7 t1 308.270155599
* device instance a_inva_a_mn12_g0_mp13_g0_t1_y r0 *1 0,0
Ca_inva_a_mn12_g0_mp13_g0_t1_y t1 vsubs 1.3119286e-14
* device instance a_mnab_y_mpa_y_mpb_y_nand_s2_y_qb_tg_fbs_a_y_t0 r0 *1 0,0
Ra_mnab_y_mpa_y_mpb_y_nand_s2_y_qb_tg_fbs_a_y_t0 qb__t0 qb 102.854507587
* device instance a_mnab_y_mpa_y_mpb_y_nand_s2_y_qb_tg_fbs_a_y_t1 r0 *1 0,0
Ra_mnab_y_mpa_y_mpb_y_nand_s2_y_qb_tg_fbs_a_y_t1 qb__t1 qb 104.443944063
* device instance a_mnab_y_mpa_y_mpb_y_nand_s2_y_qb_tg_fbs_a_y_t2 r0 *1 0,0
Ra_mnab_y_mpa_y_mpb_y_nand_s2_y_qb_tg_fbs_a_y_t2 qb__t2 qb 119.850286886
* device instance a_mnab_y_mpa_y_mpb_y_nand_s2_y_qb_tg_fbs_a_y_t3 r0 *1 0,0
Ra_mnab_y_mpa_y_mpb_y_nand_s2_y_qb_tg_fbs_a_y_t3 qb__t3 qb 73.0356963663
* device instance a_mnab_y_mpa_y_mpb_y_nand_s2_y_qb_tg_fbs_a_y_t4 r0 *1 0,0
Ra_mnab_y_mpa_y_mpb_y_nand_s2_y_qb_tg_fbs_a_y_t4 qb__t4 qb 88.9484650974
* device instance a_mnab_y_mpa_y_mpb_y_nand_s2_y_qb_tg_fbs_a_y r0 *1 0,0
Ca_mnab_y_mpa_y_mpb_y_nand_s2_y_qb_tg_fbs_a_y qb vsubs 2.243998e-15
* device instance a_mnab_y_mpa_y_mpb_y_nand_s2_y_qb_tg_fbs_a_y_dup1_t0 r0 *1 0,0
Ra_mnab_y_mpa_y_mpb_y_nand_s2_y_qb_tg_fbs_a_y_dup1_t0 qb__t02 qbn1 104.443944063
* device instance a_mnab_y_mpa_y_mpb_y_nand_s2_y_qb_tg_fbs_a_y_dup1_t1 r0 *1 0,0
Ra_mnab_y_mpa_y_mpb_y_nand_s2_y_qb_tg_fbs_a_y_dup1_t1 qb__t12 qbn1 102.854507587
* device instance a_mnab_y_mpa_y_mpb_y_nand_s2_y_qb_tg_fbs_a_y_dup1_t2 r0 *1 0,0
Ra_mnab_y_mpa_y_mpb_y_nand_s2_y_qb_tg_fbs_a_y_dup1_t2 qb__t22 qbn1 119.850286886
* device instance a_mnab_y_mpa_y_mpb_y_nand_s2_y_qb_tg_fbs_a_y_dup1_t3 r0 *1 0,0
Ra_mnab_y_mpa_y_mpb_y_nand_s2_y_qb_tg_fbs_a_y_dup1_t3 qb__t32 qbn1 73.0356963663
* device instance a_mnab_y_mpa_y_mpb_y_nand_s2_y_qb_tg_fbs_a_y_dup1_t4 r0 *1 0,0
Ra_mnab_y_mpa_y_mpb_y_nand_s2_y_qb_tg_fbs_a_y_dup1_t4 qb__t42 qbn1 88.9484650974
* device instance a_mnab_y_mpa_y_mpb_y_nand_s2_y_qb_tg_fbs_a_y_dup1 r0 *1 0,0
Ca_mnab_y_mpa_y_mpb_y_nand_s2_y_qb_tg_fbs_a_y_dup1 qbn1 vsubs 2.243998e-15
* device instance a_mnab_y_mpa_y_mpb_y_nand_s2_y_qb_tg_fbs_a_y_dup2_t0 r0 *1 0,0
Ra_mnab_y_mpa_y_mpb_y_nand_s2_y_qb_tg_fbs_a_y_dup2_t0 qb__t03 qbn2 102.854507587
* device instance a_mnab_y_mpa_y_mpb_y_nand_s2_y_qb_tg_fbs_a_y_dup2_t1 r0 *1 0,0
Ra_mnab_y_mpa_y_mpb_y_nand_s2_y_qb_tg_fbs_a_y_dup2_t1 qb__t13 qbn2 104.443944063
* device instance a_mnab_y_mpa_y_mpb_y_nand_s2_y_qb_tg_fbs_a_y_dup2_t2 r0 *1 0,0
Ra_mnab_y_mpa_y_mpb_y_nand_s2_y_qb_tg_fbs_a_y_dup2_t2 qb__t23 qbn2 119.850286886
* device instance a_mnab_y_mpa_y_mpb_y_nand_s2_y_qb_tg_fbs_a_y_dup2_t3 r0 *1 0,0
Ra_mnab_y_mpa_y_mpb_y_nand_s2_y_qb_tg_fbs_a_y_dup2_t3 qb__t33 qbn2 73.0356963663
* device instance a_mnab_y_mpa_y_mpb_y_nand_s2_y_qb_tg_fbs_a_y_dup2_t4 r0 *1 0,0
Ra_mnab_y_mpa_y_mpb_y_nand_s2_y_qb_tg_fbs_a_y_dup2_t4 qb__t43 qbn2 88.9484650974
* device instance a_mnab_y_mpa_y_mpb_y_nand_s2_y_qb_tg_fbs_a_y_dup2 r0 *1 0,0
Ca_mnab_y_mpa_y_mpb_y_nand_s2_y_qb_tg_fbs_a_y_dup2 qbn2 vsubs 2.243998e-15
* device instance a_mnab_y_mpa_y_mpb_y_nand_s2_y_qb_tg_fbs_a_y_dup3_t0 r0 *1 0,0
Ra_mnab_y_mpa_y_mpb_y_nand_s2_y_qb_tg_fbs_a_y_dup3_t0 qb__t04 qbn3 104.443944063
* device instance a_mnab_y_mpa_y_mpb_y_nand_s2_y_qb_tg_fbs_a_y_dup3_t1 r0 *1 0,0
Ra_mnab_y_mpa_y_mpb_y_nand_s2_y_qb_tg_fbs_a_y_dup3_t1 qb__t14 qbn3 102.854507587
* device instance a_mnab_y_mpa_y_mpb_y_nand_s2_y_qb_tg_fbs_a_y_dup3_t2 r0 *1 0,0
Ra_mnab_y_mpa_y_mpb_y_nand_s2_y_qb_tg_fbs_a_y_dup3_t2 qb__t24 qbn3 119.850286886
* device instance a_mnab_y_mpa_y_mpb_y_nand_s2_y_qb_tg_fbs_a_y_dup3_t3 r0 *1 0,0
Ra_mnab_y_mpa_y_mpb_y_nand_s2_y_qb_tg_fbs_a_y_dup3_t3 qb__t34 qbn3 73.0356963663
* device instance a_mnab_y_mpa_y_mpb_y_nand_s2_y_qb_tg_fbs_a_y_dup3_t4 r0 *1 0,0
Ra_mnab_y_mpa_y_mpb_y_nand_s2_y_qb_tg_fbs_a_y_dup3_t4 qb__t44 qbn3 88.9484650974
* device instance a_mnab_y_mpa_y_mpb_y_nand_s2_y_qb_tg_fbs_a_y_dup3 r0 *1 0,0
Ca_mnab_y_mpa_y_mpb_y_nand_s2_y_qb_tg_fbs_a_y_dup3 qbn3 vsubs 2.243998e-15
* device instance a_mnab_y_mpa_y_mpb_y_nand_s2_y_qb_tg_fbs_a_y_dup4_t0 r0 *1 0,0
Ra_mnab_y_mpa_y_mpb_y_nand_s2_y_qb_tg_fbs_a_y_dup4_t0 qb__t05 qbn4 102.854507587
* device instance a_mnab_y_mpa_y_mpb_y_nand_s2_y_qb_tg_fbs_a_y_dup4_t1 r0 *1 0,0
Ra_mnab_y_mpa_y_mpb_y_nand_s2_y_qb_tg_fbs_a_y_dup4_t1 qb__t15 qbn4 104.443944063
* device instance a_mnab_y_mpa_y_mpb_y_nand_s2_y_qb_tg_fbs_a_y_dup4_t2 r0 *1 0,0
Ra_mnab_y_mpa_y_mpb_y_nand_s2_y_qb_tg_fbs_a_y_dup4_t2 qb__t25 qbn4 119.850286886
* device instance a_mnab_y_mpa_y_mpb_y_nand_s2_y_qb_tg_fbs_a_y_dup4_t3 r0 *1 0,0
Ra_mnab_y_mpa_y_mpb_y_nand_s2_y_qb_tg_fbs_a_y_dup4_t3 qb__t35 qbn4 73.0356963663
* device instance a_mnab_y_mpa_y_mpb_y_nand_s2_y_qb_tg_fbs_a_y_dup4_t4 r0 *1 0,0
Ra_mnab_y_mpa_y_mpb_y_nand_s2_y_qb_tg_fbs_a_y_dup4_t4 qb__t45 qbn4 88.9484650974
* device instance a_mnab_y_mpa_y_mpb_y_nand_s2_y_qb_tg_fbs_a_y_dup4 r0 *1 0,0
Ca_mnab_y_mpa_y_mpb_y_nand_s2_y_qb_tg_fbs_a_y_dup4 qbn4 vsubs 2.243998e-15
* device instance a_mnab_y_mpa_y_mpb_y_nand_s2_y_qb_tg_fbs_a_y_dup5_t0 r0 *1 0,0
Ra_mnab_y_mpa_y_mpb_y_nand_s2_y_qb_tg_fbs_a_y_dup5_t0 qb__t06 qbn5 102.854507587
* device instance a_mnab_y_mpa_y_mpb_y_nand_s2_y_qb_tg_fbs_a_y_dup5_t1 r0 *1 0,0
Ra_mnab_y_mpa_y_mpb_y_nand_s2_y_qb_tg_fbs_a_y_dup5_t1 qb__t16 qbn5 104.443944063
* device instance a_mnab_y_mpa_y_mpb_y_nand_s2_y_qb_tg_fbs_a_y_dup5_t2 r0 *1 0,0
Ra_mnab_y_mpa_y_mpb_y_nand_s2_y_qb_tg_fbs_a_y_dup5_t2 qb__t26 qbn5 119.850286886
* device instance a_mnab_y_mpa_y_mpb_y_nand_s2_y_qb_tg_fbs_a_y_dup5_t3 r0 *1 0,0
Ra_mnab_y_mpa_y_mpb_y_nand_s2_y_qb_tg_fbs_a_y_dup5_t3 qb__t36 qbn5 73.0356963663
* device instance a_mnab_y_mpa_y_mpb_y_nand_s2_y_qb_tg_fbs_a_y_dup5_t4 r0 *1 0,0
Ra_mnab_y_mpa_y_mpb_y_nand_s2_y_qb_tg_fbs_a_y_dup5_t4 qb__t46 qbn5 88.9484650974
* device instance a_mnab_y_mpa_y_mpb_y_nand_s2_y_qb_tg_fbs_a_y_dup5 r0 *1 0,0
Ca_mnab_y_mpa_y_mpb_y_nand_s2_y_qb_tg_fbs_a_y_dup5 qbn5 vsubs 2.243998e-15
* device instance a_n2_s1_y_s2_a_y_t0 r0 *1 0,0
Ra_n2_s1_y_s2_a_y_t0 sig_n2__t0 sig_n2 236.534411421
* device instance a_n2_s1_y_s2_a_y_t1 r0 *1 0,0
Ra_n2_s1_y_s2_a_y_t1 sig_n2__t1 sig_n2 216.012838579
* device instance a_n2_s1_y_s2_a_y_t2 r0 *1 0,0
Ra_n2_s1_y_s2_a_y_t2 sig_n2__t2 sig_n2 216.012838579
* device instance a_n2_s1_y_s2_a_y_t3 r0 *1 0,0
Ra_n2_s1_y_s2_a_y_t3 sig_n2__t3 sig_n2 236.534411421
* device instance a_n2_s1_y_s2_a_y r0 *1 0,0
Ca_n2_s1_y_s2_a_y sig_n2 vsubs 2.620771e-15
* device instance a_n2_s1_y_s2_a_y_dup1_t0 r0 *1 0,0
Ra_n2_s1_y_s2_a_y_dup1_t0 sig_n2__t02 sig_n2n1 236.534411421
* device instance a_n2_s1_y_s2_a_y_dup1_t1 r0 *1 0,0
Ra_n2_s1_y_s2_a_y_dup1_t1 sig_n2__t12 sig_n2n1 216.012838579
* device instance a_n2_s1_y_s2_a_y_dup1_t2 r0 *1 0,0
Ra_n2_s1_y_s2_a_y_dup1_t2 sig_n2__t22 sig_n2n1 216.012838579
* device instance a_n2_s1_y_s2_a_y_dup1_t3 r0 *1 0,0
Ra_n2_s1_y_s2_a_y_dup1_t3 sig_n2__t32 sig_n2n1 236.534411421
* device instance a_n2_s1_y_s2_a_y_dup1 r0 *1 0,0
Ca_n2_s1_y_s2_a_y_dup1 sig_n2n1 vsubs 2.620771e-15
* device instance a_n2_s1_y_s2_a_y_dup2_t0 r0 *1 0,0
Ra_n2_s1_y_s2_a_y_dup2_t0 sig_n2__t03 sig_n2n2 236.534411421
* device instance a_n2_s1_y_s2_a_y_dup2_t1 r0 *1 0,0
Ra_n2_s1_y_s2_a_y_dup2_t1 sig_n2__t13 sig_n2n2 216.012838579
* device instance a_n2_s1_y_s2_a_y_dup2_t2 r0 *1 0,0
Ra_n2_s1_y_s2_a_y_dup2_t2 sig_n2__t23 sig_n2n2 216.012838579
* device instance a_n2_s1_y_s2_a_y_dup2_t3 r0 *1 0,0
Ra_n2_s1_y_s2_a_y_dup2_t3 sig_n2__t33 sig_n2n2 236.534411421
* device instance a_n2_s1_y_s2_a_y_dup2 r0 *1 0,0
Ca_n2_s1_y_s2_a_y_dup2 sig_n2n2 vsubs 2.620771e-15
* device instance a_n2_s1_y_s2_a_y_dup3_t0 r0 *1 0,0
Ra_n2_s1_y_s2_a_y_dup3_t0 sig_n2__t04 sig_n2n3 236.534411421
* device instance a_n2_s1_y_s2_a_y_dup3_t1 r0 *1 0,0
Ra_n2_s1_y_s2_a_y_dup3_t1 sig_n2__t14 sig_n2n3 216.012838579
* device instance a_n2_s1_y_s2_a_y_dup3_t2 r0 *1 0,0
Ra_n2_s1_y_s2_a_y_dup3_t2 sig_n2__t24 sig_n2n3 216.012838579
* device instance a_n2_s1_y_s2_a_y_dup3_t3 r0 *1 0,0
Ra_n2_s1_y_s2_a_y_dup3_t3 sig_n2__t34 sig_n2n3 236.534411421
* device instance a_n2_s1_y_s2_a_y_dup3 r0 *1 0,0
Ca_n2_s1_y_s2_a_y_dup3 sig_n2n3 vsubs 2.620771e-15
* device instance a_n3_s2_y_s3_a_y_t0 r0 *1 0,0
Ra_n3_s2_y_s3_a_y_t0 sig_n3__t0 sig_n3 236.534411421
* device instance a_n3_s2_y_s3_a_y_t1 r0 *1 0,0
Ra_n3_s2_y_s3_a_y_t1 sig_n3__t1 sig_n3 216.012838579
* device instance a_n3_s2_y_s3_a_y_t2 r0 *1 0,0
Ra_n3_s2_y_s3_a_y_t2 sig_n3__t2 sig_n3 216.012838579
* device instance a_n3_s2_y_s3_a_y_t3 r0 *1 0,0
Ra_n3_s2_y_s3_a_y_t3 sig_n3__t3 sig_n3 236.534411421
* device instance a_n3_s2_y_s3_a_y r0 *1 0,0
Ca_n3_s2_y_s3_a_y sig_n3 vsubs 2.620771e-15
* device instance a_n3_s2_y_s3_a_y_dup1_t0 r0 *1 0,0
Ra_n3_s2_y_s3_a_y_dup1_t0 sig_n3__t02 sig_n3n1 236.534411421
* device instance a_n3_s2_y_s3_a_y_dup1_t1 r0 *1 0,0
Ra_n3_s2_y_s3_a_y_dup1_t1 sig_n3__t12 sig_n3n1 216.012838579
* device instance a_n3_s2_y_s3_a_y_dup1_t2 r0 *1 0,0
Ra_n3_s2_y_s3_a_y_dup1_t2 sig_n3__t22 sig_n3n1 216.012838579
* device instance a_n3_s2_y_s3_a_y_dup1_t3 r0 *1 0,0
Ra_n3_s2_y_s3_a_y_dup1_t3 sig_n3__t32 sig_n3n1 236.534411421
* device instance a_n3_s2_y_s3_a_y_dup1 r0 *1 0,0
Ca_n3_s2_y_s3_a_y_dup1 sig_n3n1 vsubs 2.620771e-15
* device instance a_n3_s2_y_s3_a_y_dup2_t0 r0 *1 0,0
Ra_n3_s2_y_s3_a_y_dup2_t0 sig_n3__t03 sig_n3n2 236.534411421
* device instance a_n3_s2_y_s3_a_y_dup2_t1 r0 *1 0,0
Ra_n3_s2_y_s3_a_y_dup2_t1 sig_n3__t13 sig_n3n2 216.012838579
* device instance a_n3_s2_y_s3_a_y_dup2_t2 r0 *1 0,0
Ra_n3_s2_y_s3_a_y_dup2_t2 sig_n3__t23 sig_n3n2 216.012838579
* device instance a_n3_s2_y_s3_a_y_dup2_t3 r0 *1 0,0
Ra_n3_s2_y_s3_a_y_dup2_t3 sig_n3__t33 sig_n3n2 236.534411421
* device instance a_n3_s2_y_s3_a_y_dup2 r0 *1 0,0
Ca_n3_s2_y_s3_a_y_dup2 sig_n3n2 vsubs 2.620771e-15
* device instance a_n3_s2_y_s3_a_y_dup3_t0 r0 *1 0,0
Ra_n3_s2_y_s3_a_y_dup3_t0 sig_n3__t04 sig_n3n3 236.534411421
* device instance a_n3_s2_y_s3_a_y_dup3_t1 r0 *1 0,0
Ra_n3_s2_y_s3_a_y_dup3_t1 sig_n3__t14 sig_n3n3 216.012838579
* device instance a_n3_s2_y_s3_a_y_dup3_t2 r0 *1 0,0
Ra_n3_s2_y_s3_a_y_dup3_t2 sig_n3__t24 sig_n3n3 216.012838579
* device instance a_n3_s2_y_s3_a_y_dup3_t3 r0 *1 0,0
Ra_n3_s2_y_s3_a_y_dup3_t3 sig_n3__t34 sig_n3n3 236.534411421
* device instance a_n3_s2_y_s3_a_y_dup3 r0 *1 0,0
Ca_n3_s2_y_s3_a_y_dup3 sig_n3n3 vsubs 2.620771e-15
* device instance a_n4_s3_y_s4_a_y_t0 r0 *1 0,0
Ra_n4_s3_y_s4_a_y_t0 sig_n4__t0 sig_n4 236.534411421
* device instance a_n4_s3_y_s4_a_y_t1 r0 *1 0,0
Ra_n4_s3_y_s4_a_y_t1 sig_n4__t1 sig_n4 216.012838579
* device instance a_n4_s3_y_s4_a_y_t2 r0 *1 0,0
Ra_n4_s3_y_s4_a_y_t2 sig_n4__t2 sig_n4 216.012838579
* device instance a_n4_s3_y_s4_a_y_t3 r0 *1 0,0
Ra_n4_s3_y_s4_a_y_t3 sig_n4__t3 sig_n4 236.534411421
* device instance a_n4_s3_y_s4_a_y r0 *1 0,0
Ca_n4_s3_y_s4_a_y sig_n4 vsubs 2.620771e-15
* device instance a_n4_s3_y_s4_a_y_dup1_t0 r0 *1 0,0
Ra_n4_s3_y_s4_a_y_dup1_t0 sig_n4__t02 sig_n4n1 236.534411421
* device instance a_n4_s3_y_s4_a_y_dup1_t1 r0 *1 0,0
Ra_n4_s3_y_s4_a_y_dup1_t1 sig_n4__t12 sig_n4n1 216.012838579
* device instance a_n4_s3_y_s4_a_y_dup1_t2 r0 *1 0,0
Ra_n4_s3_y_s4_a_y_dup1_t2 sig_n4__t22 sig_n4n1 216.012838579
* device instance a_n4_s3_y_s4_a_y_dup1_t3 r0 *1 0,0
Ra_n4_s3_y_s4_a_y_dup1_t3 sig_n4__t32 sig_n4n1 236.534411421
* device instance a_n4_s3_y_s4_a_y_dup1 r0 *1 0,0
Ca_n4_s3_y_s4_a_y_dup1 sig_n4n1 vsubs 2.620771e-15
* device instance a_n4_s3_y_s4_a_y_dup2_t0 r0 *1 0,0
Ra_n4_s3_y_s4_a_y_dup2_t0 sig_n4__t03 sig_n4n2 236.534411421
* device instance a_n4_s3_y_s4_a_y_dup2_t1 r0 *1 0,0
Ra_n4_s3_y_s4_a_y_dup2_t1 sig_n4__t13 sig_n4n2 216.012838579
* device instance a_n4_s3_y_s4_a_y_dup2_t2 r0 *1 0,0
Ra_n4_s3_y_s4_a_y_dup2_t2 sig_n4__t23 sig_n4n2 216.012838579
* device instance a_n4_s3_y_s4_a_y_dup2_t3 r0 *1 0,0
Ra_n4_s3_y_s4_a_y_dup2_t3 sig_n4__t33 sig_n4n2 236.534411421
* device instance a_n4_s3_y_s4_a_y_dup2 r0 *1 0,0
Ca_n4_s3_y_s4_a_y_dup2 sig_n4n2 vsubs 2.620771e-15
* device instance a_n4_s3_y_s4_a_y_dup3_t0 r0 *1 0,0
Ra_n4_s3_y_s4_a_y_dup3_t0 sig_n4__t04 sig_n4n3 236.534411421
* device instance a_n4_s3_y_s4_a_y_dup3_t1 r0 *1 0,0
Ra_n4_s3_y_s4_a_y_dup3_t1 sig_n4__t14 sig_n4n3 216.012838579
* device instance a_n4_s3_y_s4_a_y_dup3_t2 r0 *1 0,0
Ra_n4_s3_y_s4_a_y_dup3_t2 sig_n4__t24 sig_n4n3 216.012838579
* device instance a_n4_s3_y_s4_a_y_dup3_t3 r0 *1 0,0
Ra_n4_s3_y_s4_a_y_dup3_t3 sig_n4__t34 sig_n4n3 236.534411421
* device instance a_n4_s3_y_s4_a_y_dup3 r0 *1 0,0
Ca_n4_s3_y_s4_a_y_dup3 sig_n4n3 vsubs 2.620771e-15
* device instance an_inva_y_mn34_g0_mp13_g1_y_t0 r0 *1 0,0
Ran_inva_y_mn34_g0_mp13_g1_y_t0 xor_an__t0 xor_an 286.425880004
* device instance an_inva_y_mn34_g0_mp13_g1_y_t1 r0 *1 0,0
Ran_inva_y_mn34_g0_mp13_g1_y_t1 xor_an__t1 xor_an 120.259350571
* device instance an_inva_y_mn34_g0_mp13_g1_y_t2 r0 *1 0,0
Ran_inva_y_mn34_g0_mp13_g1_y_t2 xor_an__t2 xor_an 148.815961258
* device instance an_inva_y_mn34_g0_mp13_g1_y_t3 r0 *1 0,0
Ran_inva_y_mn34_g0_mp13_g1_y_t3 xor_an__t3 xor_an 235.863908166
* device instance an_inva_y_mn34_g0_mp13_g1_y r0 *1 0,0
Can_inva_y_mn34_g0_mp13_g1_y xor_an vsubs 2.26736e-15
* device instance an_inva_y_mn34_g0_mp13_g1_y_dup1_t0 r0 *1 0,0
Ran_inva_y_mn34_g0_mp13_g1_y_dup1_t0 xor_an__t02 xor_ann1 286.425880004
* device instance an_inva_y_mn34_g0_mp13_g1_y_dup1_t1 r0 *1 0,0
Ran_inva_y_mn34_g0_mp13_g1_y_dup1_t1 xor_an__t12 xor_ann1 120.259350571
* device instance an_inva_y_mn34_g0_mp13_g1_y_dup1_t2 r0 *1 0,0
Ran_inva_y_mn34_g0_mp13_g1_y_dup1_t2 xor_an__t22 xor_ann1 148.815961258
* device instance an_inva_y_mn34_g0_mp13_g1_y_dup1_t3 r0 *1 0,0
Ran_inva_y_mn34_g0_mp13_g1_y_dup1_t3 xor_an__t32 xor_ann1 235.863908166
* device instance an_inva_y_mn34_g0_mp13_g1_y_dup1 r0 *1 0,0
Can_inva_y_mn34_g0_mp13_g1_y_dup1 xor_ann1 vsubs 2.26736e-15
* device instance an_inva_y_mn34_g0_mp13_g1_y_dup2_t0 r0 *1 0,0
Ran_inva_y_mn34_g0_mp13_g1_y_dup2_t0 xor_an__t03 xor_ann2 286.425880004
* device instance an_inva_y_mn34_g0_mp13_g1_y_dup2_t1 r0 *1 0,0
Ran_inva_y_mn34_g0_mp13_g1_y_dup2_t1 xor_an__t13 xor_ann2 120.259350571
* device instance an_inva_y_mn34_g0_mp13_g1_y_dup2_t2 r0 *1 0,0
Ran_inva_y_mn34_g0_mp13_g1_y_dup2_t2 xor_an__t23 xor_ann2 148.815961258
* device instance an_inva_y_mn34_g0_mp13_g1_y_dup2_t3 r0 *1 0,0
Ran_inva_y_mn34_g0_mp13_g1_y_dup2_t3 xor_an__t33 xor_ann2 235.863908166
* device instance an_inva_y_mn34_g0_mp13_g1_y_dup2 r0 *1 0,0
Can_inva_y_mn34_g0_mp13_g1_y_dup2 xor_ann2 vsubs 2.26736e-15
* device instance bn_invb_y_mn34_g1_mp24_g1_y_t0 r0 *1 0,0
Rbn_invb_y_mn34_g1_mp24_g1_y_t0 xor_bn__t0 xor_bn 185.302815577
* device instance bn_invb_y_mn34_g1_mp24_g1_y_t1 r0 *1 0,0
Rbn_invb_y_mn34_g1_mp24_g1_y_t1 xor_bn__t1 xor_bn 163.924646135
* device instance bn_invb_y_mn34_g1_mp24_g1_y_t2 r0 *1 0,0
Rbn_invb_y_mn34_g1_mp24_g1_y_t2 xor_bn__t2 xor_bn 173.955001003
* device instance bn_invb_y_mn34_g1_mp24_g1_y_t3 r0 *1 0,0
Rbn_invb_y_mn34_g1_mp24_g1_y_t3 xor_bn__t3 xor_bn 293.464337285
* device instance bn_invb_y_mn34_g1_mp24_g1_y r0 *1 0,0
Cbn_invb_y_mn34_g1_mp24_g1_y xor_bn vsubs 5.210763e-15
* device instance bn_invb_y_mn34_g1_mp24_g1_y_dup1_t0 r0 *1 0,0
Rbn_invb_y_mn34_g1_mp24_g1_y_dup1_t0 xor_bn__t02 xor_bnn1 185.302815577
* device instance bn_invb_y_mn34_g1_mp24_g1_y_dup1_t1 r0 *1 0,0
Rbn_invb_y_mn34_g1_mp24_g1_y_dup1_t1 xor_bn__t12 xor_bnn1 163.924646135
* device instance bn_invb_y_mn34_g1_mp24_g1_y_dup1_t2 r0 *1 0,0
Rbn_invb_y_mn34_g1_mp24_g1_y_dup1_t2 xor_bn__t22 xor_bnn1 173.955001003
* device instance bn_invb_y_mn34_g1_mp24_g1_y_dup1_t3 r0 *1 0,0
Rbn_invb_y_mn34_g1_mp24_g1_y_dup1_t3 xor_bn__t32 xor_bnn1 293.464337285
* device instance bn_invb_y_mn34_g1_mp24_g1_y_dup1 r0 *1 0,0
Cbn_invb_y_mn34_g1_mp24_g1_y_dup1 xor_bnn1 vsubs 5.210763e-15
* device instance bn_invb_y_mn34_g1_mp24_g1_y_dup2_t0 r0 *1 0,0
Rbn_invb_y_mn34_g1_mp24_g1_y_dup2_t0 xor_bn__t03 xor_bnn2 185.302815577
* device instance bn_invb_y_mn34_g1_mp24_g1_y_dup2_t1 r0 *1 0,0
Rbn_invb_y_mn34_g1_mp24_g1_y_dup2_t1 xor_bn__t13 xor_bnn2 163.924646135
* device instance bn_invb_y_mn34_g1_mp24_g1_y_dup2_t2 r0 *1 0,0
Rbn_invb_y_mn34_g1_mp24_g1_y_dup2_t2 xor_bn__t23 xor_bnn2 173.955001003
* device instance bn_invb_y_mn34_g1_mp24_g1_y_dup2_t3 r0 *1 0,0
Rbn_invb_y_mn34_g1_mp24_g1_y_dup2_t3 xor_bn__t33 xor_bnn2 293.464337285
* device instance bn_invb_y_mn34_g1_mp24_g1_y_dup2 r0 *1 0,0
Cbn_invb_y_mn34_g1_mp24_g1_y_dup2 xor_bnn2 vsubs 5.210018e-15
* device instance clkb_clkb_bridge1_clkb_bridge2_clkb_mid_clkb_w_ctrl_ctrlb_inv_clk_y_tg_d_ctrlb_tg_fbm_ctrl_tg_fbs_ctrlb_tg_s_ctrl_y_t0 r0 *1 0,0
Rclkb_clkb_bridge1_clkb_bridge2_clkb_mid_clkb_w_ctrl_ctrlb_inv_clk_y_tg_d_ctrlb_tg_fbm_ctrl_tg_fbs_ctrlb_tg_s_ctrl_y_t0 clkb__t0 clkb 217.842328504
* device instance clkb_clkb_bridge1_clkb_bridge2_clkb_mid_clkb_w_ctrl_ctrlb_inv_clk_y_tg_d_ctrlb_tg_fbm_ctrl_tg_fbs_ctrlb_tg_s_ctrl_y_t1 r0 *1 0,0
Rclkb_clkb_bridge1_clkb_bridge2_clkb_mid_clkb_w_ctrl_ctrlb_inv_clk_y_tg_d_ctrlb_tg_fbm_ctrl_tg_fbs_ctrlb_tg_s_ctrl_y_t1 clkb__t1 clkb 217.842328504
* device instance clkb_clkb_bridge1_clkb_bridge2_clkb_mid_clkb_w_ctrl_ctrlb_inv_clk_y_tg_d_ctrlb_tg_fbm_ctrl_tg_fbs_ctrlb_tg_s_ctrl_y_t2 r0 *1 0,0
Rclkb_clkb_bridge1_clkb_bridge2_clkb_mid_clkb_w_ctrl_ctrlb_inv_clk_y_tg_d_ctrlb_tg_fbm_ctrl_tg_fbs_ctrlb_tg_s_ctrl_y_t2 clkb__t2 clkb 79.6693888508
* device instance clkb_clkb_bridge1_clkb_bridge2_clkb_mid_clkb_w_ctrl_ctrlb_inv_clk_y_tg_d_ctrlb_tg_fbm_ctrl_tg_fbs_ctrlb_tg_s_ctrl_y_t3 r0 *1 0,0
Rclkb_clkb_bridge1_clkb_bridge2_clkb_mid_clkb_w_ctrl_ctrlb_inv_clk_y_tg_d_ctrlb_tg_fbm_ctrl_tg_fbs_ctrlb_tg_s_ctrl_y_t3 clkb__t3 clkb 141.315403239
* device instance clkb_clkb_bridge1_clkb_bridge2_clkb_mid_clkb_w_ctrl_ctrlb_inv_clk_y_tg_d_ctrlb_tg_fbm_ctrl_tg_fbs_ctrlb_tg_s_ctrl_y_t4 r0 *1 0,0
Rclkb_clkb_bridge1_clkb_bridge2_clkb_mid_clkb_w_ctrl_ctrlb_inv_clk_y_tg_d_ctrlb_tg_fbm_ctrl_tg_fbs_ctrlb_tg_s_ctrl_y_t4 clkb__t4 clkb 159.961351597
* device instance clkb_clkb_bridge1_clkb_bridge2_clkb_mid_clkb_w_ctrl_ctrlb_inv_clk_y_tg_d_ctrlb_tg_fbm_ctrl_tg_fbs_ctrlb_tg_s_ctrl_y_t5 r0 *1 0,0
Rclkb_clkb_bridge1_clkb_bridge2_clkb_mid_clkb_w_ctrl_ctrlb_inv_clk_y_tg_d_ctrlb_tg_fbm_ctrl_tg_fbs_ctrlb_tg_s_ctrl_y_t5 clkb__t5 clkb 376.113299304
* device instance clkb_clkb_bridge1_clkb_bridge2_clkb_mid_clkb_w_ctrl_ctrlb_inv_clk_y_tg_d_ctrlb_tg_fbm_ctrl_tg_fbs_ctrlb_tg_s_ctrl_y r0 *1 0,0
Cclkb_clkb_bridge1_clkb_bridge2_clkb_mid_clkb_w_ctrl_ctrlb_inv_clk_y_tg_d_ctrlb_tg_fbm_ctrl_tg_fbs_ctrlb_tg_s_ctrl_y clkb vsubs 6.914554e-15
* device instance clkb_clkb_bridge1_clkb_bridge2_clkb_mid_clkb_w_ctrl_ctrlb_inv_clk_y_tg_d_ctrlb_tg_fbm_ctrl_tg_fbs_ctrlb_tg_s_ctrl_y_dup1_t0 r0 *1 0,0
Rclkb_clkb_bridge1_clkb_bridge2_clkb_mid_clkb_w_ctrl_ctrlb_inv_clk_y_tg_d_ctrlb_tg_fbm_ctrl_tg_fbs_ctrlb_tg_s_ctrl_y_dup1_t0 clkb__t02 clkbn1 217.842328504
* device instance clkb_clkb_bridge1_clkb_bridge2_clkb_mid_clkb_w_ctrl_ctrlb_inv_clk_y_tg_d_ctrlb_tg_fbm_ctrl_tg_fbs_ctrlb_tg_s_ctrl_y_dup1_t1 r0 *1 0,0
Rclkb_clkb_bridge1_clkb_bridge2_clkb_mid_clkb_w_ctrl_ctrlb_inv_clk_y_tg_d_ctrlb_tg_fbm_ctrl_tg_fbs_ctrlb_tg_s_ctrl_y_dup1_t1 clkb__t12 clkbn1 217.842328504
* device instance clkb_clkb_bridge1_clkb_bridge2_clkb_mid_clkb_w_ctrl_ctrlb_inv_clk_y_tg_d_ctrlb_tg_fbm_ctrl_tg_fbs_ctrlb_tg_s_ctrl_y_dup1_t2 r0 *1 0,0
Rclkb_clkb_bridge1_clkb_bridge2_clkb_mid_clkb_w_ctrl_ctrlb_inv_clk_y_tg_d_ctrlb_tg_fbm_ctrl_tg_fbs_ctrlb_tg_s_ctrl_y_dup1_t2 clkb__t22 clkbn1 79.6693888508
* device instance clkb_clkb_bridge1_clkb_bridge2_clkb_mid_clkb_w_ctrl_ctrlb_inv_clk_y_tg_d_ctrlb_tg_fbm_ctrl_tg_fbs_ctrlb_tg_s_ctrl_y_dup1_t3 r0 *1 0,0
Rclkb_clkb_bridge1_clkb_bridge2_clkb_mid_clkb_w_ctrl_ctrlb_inv_clk_y_tg_d_ctrlb_tg_fbm_ctrl_tg_fbs_ctrlb_tg_s_ctrl_y_dup1_t3 clkb__t32 clkbn1 141.315403239
* device instance clkb_clkb_bridge1_clkb_bridge2_clkb_mid_clkb_w_ctrl_ctrlb_inv_clk_y_tg_d_ctrlb_tg_fbm_ctrl_tg_fbs_ctrlb_tg_s_ctrl_y_dup1_t4 r0 *1 0,0
Rclkb_clkb_bridge1_clkb_bridge2_clkb_mid_clkb_w_ctrl_ctrlb_inv_clk_y_tg_d_ctrlb_tg_fbm_ctrl_tg_fbs_ctrlb_tg_s_ctrl_y_dup1_t4 clkb__t42 clkbn1 159.961351597
* device instance clkb_clkb_bridge1_clkb_bridge2_clkb_mid_clkb_w_ctrl_ctrlb_inv_clk_y_tg_d_ctrlb_tg_fbm_ctrl_tg_fbs_ctrlb_tg_s_ctrl_y_dup1_t5 r0 *1 0,0
Rclkb_clkb_bridge1_clkb_bridge2_clkb_mid_clkb_w_ctrl_ctrlb_inv_clk_y_tg_d_ctrlb_tg_fbm_ctrl_tg_fbs_ctrlb_tg_s_ctrl_y_dup1_t5 clkb__t52 clkbn1 376.113299304
* device instance clkb_clkb_bridge1_clkb_bridge2_clkb_mid_clkb_w_ctrl_ctrlb_inv_clk_y_tg_d_ctrlb_tg_fbm_ctrl_tg_fbs_ctrlb_tg_s_ctrl_y_dup1 r0 *1 0,0
Cclkb_clkb_bridge1_clkb_bridge2_clkb_mid_clkb_w_ctrl_ctrlb_inv_clk_y_tg_d_ctrlb_tg_fbm_ctrl_tg_fbs_ctrlb_tg_s_ctrl_y_dup1 clkbn1 vsubs 6.914554e-15
* device instance clkb_clkb_bridge1_clkb_bridge2_clkb_mid_clkb_w_ctrl_ctrlb_inv_clk_y_tg_d_ctrlb_tg_fbm_ctrl_tg_fbs_ctrlb_tg_s_ctrl_y_dup2_t0 r0 *1 0,0
Rclkb_clkb_bridge1_clkb_bridge2_clkb_mid_clkb_w_ctrl_ctrlb_inv_clk_y_tg_d_ctrlb_tg_fbm_ctrl_tg_fbs_ctrlb_tg_s_ctrl_y_dup2_t0 clkb__t03 clkbn2 217.842328504
* device instance clkb_clkb_bridge1_clkb_bridge2_clkb_mid_clkb_w_ctrl_ctrlb_inv_clk_y_tg_d_ctrlb_tg_fbm_ctrl_tg_fbs_ctrlb_tg_s_ctrl_y_dup2_t1 r0 *1 0,0
Rclkb_clkb_bridge1_clkb_bridge2_clkb_mid_clkb_w_ctrl_ctrlb_inv_clk_y_tg_d_ctrlb_tg_fbm_ctrl_tg_fbs_ctrlb_tg_s_ctrl_y_dup2_t1 clkb__t13 clkbn2 217.842328504
* device instance clkb_clkb_bridge1_clkb_bridge2_clkb_mid_clkb_w_ctrl_ctrlb_inv_clk_y_tg_d_ctrlb_tg_fbm_ctrl_tg_fbs_ctrlb_tg_s_ctrl_y_dup2_t2 r0 *1 0,0
Rclkb_clkb_bridge1_clkb_bridge2_clkb_mid_clkb_w_ctrl_ctrlb_inv_clk_y_tg_d_ctrlb_tg_fbm_ctrl_tg_fbs_ctrlb_tg_s_ctrl_y_dup2_t2 clkb__t23 clkbn2 141.315403239
* device instance clkb_clkb_bridge1_clkb_bridge2_clkb_mid_clkb_w_ctrl_ctrlb_inv_clk_y_tg_d_ctrlb_tg_fbm_ctrl_tg_fbs_ctrlb_tg_s_ctrl_y_dup2_t3 r0 *1 0,0
Rclkb_clkb_bridge1_clkb_bridge2_clkb_mid_clkb_w_ctrl_ctrlb_inv_clk_y_tg_d_ctrlb_tg_fbm_ctrl_tg_fbs_ctrlb_tg_s_ctrl_y_dup2_t3 clkb__t33 clkbn2 79.6693888508
* device instance clkb_clkb_bridge1_clkb_bridge2_clkb_mid_clkb_w_ctrl_ctrlb_inv_clk_y_tg_d_ctrlb_tg_fbm_ctrl_tg_fbs_ctrlb_tg_s_ctrl_y_dup2_t4 r0 *1 0,0
Rclkb_clkb_bridge1_clkb_bridge2_clkb_mid_clkb_w_ctrl_ctrlb_inv_clk_y_tg_d_ctrlb_tg_fbm_ctrl_tg_fbs_ctrlb_tg_s_ctrl_y_dup2_t4 clkb__t43 clkbn2 376.113299304
* device instance clkb_clkb_bridge1_clkb_bridge2_clkb_mid_clkb_w_ctrl_ctrlb_inv_clk_y_tg_d_ctrlb_tg_fbm_ctrl_tg_fbs_ctrlb_tg_s_ctrl_y_dup2_t5 r0 *1 0,0
Rclkb_clkb_bridge1_clkb_bridge2_clkb_mid_clkb_w_ctrl_ctrlb_inv_clk_y_tg_d_ctrlb_tg_fbm_ctrl_tg_fbs_ctrlb_tg_s_ctrl_y_dup2_t5 clkb__t53 clkbn2 159.961351597
* device instance clkb_clkb_bridge1_clkb_bridge2_clkb_mid_clkb_w_ctrl_ctrlb_inv_clk_y_tg_d_ctrlb_tg_fbm_ctrl_tg_fbs_ctrlb_tg_s_ctrl_y_dup2 r0 *1 0,0
Cclkb_clkb_bridge1_clkb_bridge2_clkb_mid_clkb_w_ctrl_ctrlb_inv_clk_y_tg_d_ctrlb_tg_fbm_ctrl_tg_fbs_ctrlb_tg_s_ctrl_y_dup2 clkbn2 vsubs 6.914554e-15
* device instance clkb_clkb_bridge1_clkb_bridge2_clkb_mid_clkb_w_ctrl_ctrlb_inv_clk_y_tg_d_ctrlb_tg_fbm_ctrl_tg_fbs_ctrlb_tg_s_ctrl_y_dup3_t0 r0 *1 0,0
Rclkb_clkb_bridge1_clkb_bridge2_clkb_mid_clkb_w_ctrl_ctrlb_inv_clk_y_tg_d_ctrlb_tg_fbm_ctrl_tg_fbs_ctrlb_tg_s_ctrl_y_dup3_t0 clkb__t04 clkbn3 217.842328504
* device instance clkb_clkb_bridge1_clkb_bridge2_clkb_mid_clkb_w_ctrl_ctrlb_inv_clk_y_tg_d_ctrlb_tg_fbm_ctrl_tg_fbs_ctrlb_tg_s_ctrl_y_dup3_t1 r0 *1 0,0
Rclkb_clkb_bridge1_clkb_bridge2_clkb_mid_clkb_w_ctrl_ctrlb_inv_clk_y_tg_d_ctrlb_tg_fbm_ctrl_tg_fbs_ctrlb_tg_s_ctrl_y_dup3_t1 clkb__t14 clkbn3 217.842328504
* device instance clkb_clkb_bridge1_clkb_bridge2_clkb_mid_clkb_w_ctrl_ctrlb_inv_clk_y_tg_d_ctrlb_tg_fbm_ctrl_tg_fbs_ctrlb_tg_s_ctrl_y_dup3_t2 r0 *1 0,0
Rclkb_clkb_bridge1_clkb_bridge2_clkb_mid_clkb_w_ctrl_ctrlb_inv_clk_y_tg_d_ctrlb_tg_fbm_ctrl_tg_fbs_ctrlb_tg_s_ctrl_y_dup3_t2 clkb__t24 clkbn3 79.6693888508
* device instance clkb_clkb_bridge1_clkb_bridge2_clkb_mid_clkb_w_ctrl_ctrlb_inv_clk_y_tg_d_ctrlb_tg_fbm_ctrl_tg_fbs_ctrlb_tg_s_ctrl_y_dup3_t3 r0 *1 0,0
Rclkb_clkb_bridge1_clkb_bridge2_clkb_mid_clkb_w_ctrl_ctrlb_inv_clk_y_tg_d_ctrlb_tg_fbm_ctrl_tg_fbs_ctrlb_tg_s_ctrl_y_dup3_t3 clkb__t34 clkbn3 141.315403239
* device instance clkb_clkb_bridge1_clkb_bridge2_clkb_mid_clkb_w_ctrl_ctrlb_inv_clk_y_tg_d_ctrlb_tg_fbm_ctrl_tg_fbs_ctrlb_tg_s_ctrl_y_dup3_t4 r0 *1 0,0
Rclkb_clkb_bridge1_clkb_bridge2_clkb_mid_clkb_w_ctrl_ctrlb_inv_clk_y_tg_d_ctrlb_tg_fbm_ctrl_tg_fbs_ctrlb_tg_s_ctrl_y_dup3_t4 clkb__t44 clkbn3 376.113299304
* device instance clkb_clkb_bridge1_clkb_bridge2_clkb_mid_clkb_w_ctrl_ctrlb_inv_clk_y_tg_d_ctrlb_tg_fbm_ctrl_tg_fbs_ctrlb_tg_s_ctrl_y_dup3_t5 r0 *1 0,0
Rclkb_clkb_bridge1_clkb_bridge2_clkb_mid_clkb_w_ctrl_ctrlb_inv_clk_y_tg_d_ctrlb_tg_fbm_ctrl_tg_fbs_ctrlb_tg_s_ctrl_y_dup3_t5 clkb__t54 clkbn3 159.961351597
* device instance clkb_clkb_bridge1_clkb_bridge2_clkb_mid_clkb_w_ctrl_ctrlb_inv_clk_y_tg_d_ctrlb_tg_fbm_ctrl_tg_fbs_ctrlb_tg_s_ctrl_y_dup3 r0 *1 0,0
Cclkb_clkb_bridge1_clkb_bridge2_clkb_mid_clkb_w_ctrl_ctrlb_inv_clk_y_tg_d_ctrlb_tg_fbm_ctrl_tg_fbs_ctrlb_tg_s_ctrl_y_dup3 clkbn3 vsubs 6.914554e-15
* device instance clkb_clkb_bridge1_clkb_bridge2_clkb_mid_clkb_w_ctrl_ctrlb_inv_clk_y_tg_d_ctrlb_tg_fbm_ctrl_tg_fbs_ctrlb_tg_s_ctrl_y_dup4_t0 r0 *1 0,0
Rclkb_clkb_bridge1_clkb_bridge2_clkb_mid_clkb_w_ctrl_ctrlb_inv_clk_y_tg_d_ctrlb_tg_fbm_ctrl_tg_fbs_ctrlb_tg_s_ctrl_y_dup4_t0 clkb__t05 clkbn4 217.842328504
* device instance clkb_clkb_bridge1_clkb_bridge2_clkb_mid_clkb_w_ctrl_ctrlb_inv_clk_y_tg_d_ctrlb_tg_fbm_ctrl_tg_fbs_ctrlb_tg_s_ctrl_y_dup4_t1 r0 *1 0,0
Rclkb_clkb_bridge1_clkb_bridge2_clkb_mid_clkb_w_ctrl_ctrlb_inv_clk_y_tg_d_ctrlb_tg_fbm_ctrl_tg_fbs_ctrlb_tg_s_ctrl_y_dup4_t1 clkb__t15 clkbn4 217.842328504
* device instance clkb_clkb_bridge1_clkb_bridge2_clkb_mid_clkb_w_ctrl_ctrlb_inv_clk_y_tg_d_ctrlb_tg_fbm_ctrl_tg_fbs_ctrlb_tg_s_ctrl_y_dup4_t2 r0 *1 0,0
Rclkb_clkb_bridge1_clkb_bridge2_clkb_mid_clkb_w_ctrl_ctrlb_inv_clk_y_tg_d_ctrlb_tg_fbm_ctrl_tg_fbs_ctrlb_tg_s_ctrl_y_dup4_t2 clkb__t25 clkbn4 141.315403239
* device instance clkb_clkb_bridge1_clkb_bridge2_clkb_mid_clkb_w_ctrl_ctrlb_inv_clk_y_tg_d_ctrlb_tg_fbm_ctrl_tg_fbs_ctrlb_tg_s_ctrl_y_dup4_t3 r0 *1 0,0
Rclkb_clkb_bridge1_clkb_bridge2_clkb_mid_clkb_w_ctrl_ctrlb_inv_clk_y_tg_d_ctrlb_tg_fbm_ctrl_tg_fbs_ctrlb_tg_s_ctrl_y_dup4_t3 clkb__t35 clkbn4 79.6693888508
* device instance clkb_clkb_bridge1_clkb_bridge2_clkb_mid_clkb_w_ctrl_ctrlb_inv_clk_y_tg_d_ctrlb_tg_fbm_ctrl_tg_fbs_ctrlb_tg_s_ctrl_y_dup4_t4 r0 *1 0,0
Rclkb_clkb_bridge1_clkb_bridge2_clkb_mid_clkb_w_ctrl_ctrlb_inv_clk_y_tg_d_ctrlb_tg_fbm_ctrl_tg_fbs_ctrlb_tg_s_ctrl_y_dup4_t4 clkb__t45 clkbn4 159.961351597
* device instance clkb_clkb_bridge1_clkb_bridge2_clkb_mid_clkb_w_ctrl_ctrlb_inv_clk_y_tg_d_ctrlb_tg_fbm_ctrl_tg_fbs_ctrlb_tg_s_ctrl_y_dup4_t5 r0 *1 0,0
Rclkb_clkb_bridge1_clkb_bridge2_clkb_mid_clkb_w_ctrl_ctrlb_inv_clk_y_tg_d_ctrlb_tg_fbm_ctrl_tg_fbs_ctrlb_tg_s_ctrl_y_dup4_t5 clkb__t55 clkbn4 376.113299304
* device instance clkb_clkb_bridge1_clkb_bridge2_clkb_mid_clkb_w_ctrl_ctrlb_inv_clk_y_tg_d_ctrlb_tg_fbm_ctrl_tg_fbs_ctrlb_tg_s_ctrl_y_dup4 r0 *1 0,0
Cclkb_clkb_bridge1_clkb_bridge2_clkb_mid_clkb_w_ctrl_ctrlb_inv_clk_y_tg_d_ctrlb_tg_fbm_ctrl_tg_fbs_ctrlb_tg_s_ctrl_y_dup4 clkbn4 vsubs 6.914554e-15
* device instance clkb_clkb_bridge1_clkb_bridge2_clkb_mid_clkb_w_ctrl_ctrlb_inv_clk_y_tg_d_ctrlb_tg_fbm_ctrl_tg_fbs_ctrlb_tg_s_ctrl_y_dup5_t0 r0 *1 0,0
Rclkb_clkb_bridge1_clkb_bridge2_clkb_mid_clkb_w_ctrl_ctrlb_inv_clk_y_tg_d_ctrlb_tg_fbm_ctrl_tg_fbs_ctrlb_tg_s_ctrl_y_dup5_t0 clkb__t06 clkbn5 217.842328504
* device instance clkb_clkb_bridge1_clkb_bridge2_clkb_mid_clkb_w_ctrl_ctrlb_inv_clk_y_tg_d_ctrlb_tg_fbm_ctrl_tg_fbs_ctrlb_tg_s_ctrl_y_dup5_t1 r0 *1 0,0
Rclkb_clkb_bridge1_clkb_bridge2_clkb_mid_clkb_w_ctrl_ctrlb_inv_clk_y_tg_d_ctrlb_tg_fbm_ctrl_tg_fbs_ctrlb_tg_s_ctrl_y_dup5_t1 clkb__t16 clkbn5 217.842328504
* device instance clkb_clkb_bridge1_clkb_bridge2_clkb_mid_clkb_w_ctrl_ctrlb_inv_clk_y_tg_d_ctrlb_tg_fbm_ctrl_tg_fbs_ctrlb_tg_s_ctrl_y_dup5_t2 r0 *1 0,0
Rclkb_clkb_bridge1_clkb_bridge2_clkb_mid_clkb_w_ctrl_ctrlb_inv_clk_y_tg_d_ctrlb_tg_fbm_ctrl_tg_fbs_ctrlb_tg_s_ctrl_y_dup5_t2 clkb__t26 clkbn5 79.6693888508
* device instance clkb_clkb_bridge1_clkb_bridge2_clkb_mid_clkb_w_ctrl_ctrlb_inv_clk_y_tg_d_ctrlb_tg_fbm_ctrl_tg_fbs_ctrlb_tg_s_ctrl_y_dup5_t3 r0 *1 0,0
Rclkb_clkb_bridge1_clkb_bridge2_clkb_mid_clkb_w_ctrl_ctrlb_inv_clk_y_tg_d_ctrlb_tg_fbm_ctrl_tg_fbs_ctrlb_tg_s_ctrl_y_dup5_t3 clkb__t36 clkbn5 141.315403239
* device instance clkb_clkb_bridge1_clkb_bridge2_clkb_mid_clkb_w_ctrl_ctrlb_inv_clk_y_tg_d_ctrlb_tg_fbm_ctrl_tg_fbs_ctrlb_tg_s_ctrl_y_dup5_t4 r0 *1 0,0
Rclkb_clkb_bridge1_clkb_bridge2_clkb_mid_clkb_w_ctrl_ctrlb_inv_clk_y_tg_d_ctrlb_tg_fbm_ctrl_tg_fbs_ctrlb_tg_s_ctrl_y_dup5_t4 clkb__t46 clkbn5 376.113299304
* device instance clkb_clkb_bridge1_clkb_bridge2_clkb_mid_clkb_w_ctrl_ctrlb_inv_clk_y_tg_d_ctrlb_tg_fbm_ctrl_tg_fbs_ctrlb_tg_s_ctrl_y_dup5_t5 r0 *1 0,0
Rclkb_clkb_bridge1_clkb_bridge2_clkb_mid_clkb_w_ctrl_ctrlb_inv_clk_y_tg_d_ctrlb_tg_fbm_ctrl_tg_fbs_ctrlb_tg_s_ctrl_y_dup5_t5 clkb__t56 clkbn5 159.961351597
* device instance clkb_clkb_bridge1_clkb_bridge2_clkb_mid_clkb_w_ctrl_ctrlb_inv_clk_y_tg_d_ctrlb_tg_fbm_ctrl_tg_fbs_ctrlb_tg_s_ctrl_y_dup5 r0 *1 0,0
Cclkb_clkb_bridge1_clkb_bridge2_clkb_mid_clkb_w_ctrl_ctrlb_inv_clk_y_tg_d_ctrlb_tg_fbm_ctrl_tg_fbs_ctrlb_tg_s_ctrl_y_dup5 clkbn5 vsubs 6.914554e-15
* device instance en_en1_g_en_t0 r0 *1 0,0
Ren_en1_g_en_t0 en1__t0 en1 259.452
* device instance en_en1_g_en_t1 r0 *1 0,0
Ren_en1_g_en_t1 en1__t1 en1 259.452
* device instance en_en1_g_en r0 *1 0,0
Cen_en1_g_en en1 vsubs 7.37613e-16
* device instance en_en2_g_en_t0 r0 *1 0,0
Ren_en2_g_en_t0 en2__t0 en2 259.452
* device instance en_en2_g_en_t1 r0 *1 0,0
Ren_en2_g_en_t1 en2__t1 en2 259.452
* device instance en_en2_g_en r0 *1 0,0
Cen_en2_g_en en2 vsubs 7.37613e-16
* device instance en_en3_g_en_t0 r0 *1 0,0
Ren_en3_g_en_t0 en3__t0 en3 259.452
* device instance en_en3_g_en_t1 r0 *1 0,0
Ren_en3_g_en_t1 en3__t1 en3 259.452
* device instance en_en3_g_en r0 *1 0,0
Cen_en3_g_en en3 vsubs 7.37613e-16
* device instance en_en4_g_en_t0 r0 *1 0,0
Ren_en4_g_en_t0 en4__t0 en4 259.452
* device instance en_en4_g_en_t1 r0 *1 0,0
Ren_en4_g_en_t1 en4__t1 en4 259.452
* device instance en_en4_g_en r0 *1 0,0
Cen_en4_g_en en4 vsubs 7.37613e-16
* device instance en_nand_m_en_nand_m_en_via_nand_s2_en_nand_s2_en_via_rst_n_t0 r0 *1 0,0
Ren_nand_m_en_nand_m_en_via_nand_s2_en_nand_s2_en_via_rst_n_t0 rst_n__t0 rst_n 508.887095444
* device instance en_nand_m_en_nand_m_en_via_nand_s2_en_nand_s2_en_via_rst_n_t1 r0 *1 0,0
Ren_nand_m_en_nand_m_en_via_nand_s2_en_nand_s2_en_via_rst_n_t1 rst_n__t1 rst_n 40.6685547659
* device instance en_nand_m_en_nand_m_en_via_nand_s2_en_nand_s2_en_via_rst_n_t2 r0 *1 0,0
Ren_nand_m_en_nand_m_en_via_nand_s2_en_nand_s2_en_via_rst_n_t2 rst_n__t2 rst_n 508.887095444
* device instance en_nand_m_en_nand_m_en_via_nand_s2_en_nand_s2_en_via_rst_n_t3 r0 *1 0,0
Ren_nand_m_en_nand_m_en_via_nand_s2_en_nand_s2_en_via_rst_n_t3 rst_n__t3 rst_n 407.164961817
* device instance en_nand_m_en_nand_m_en_via_nand_s2_en_nand_s2_en_via_rst_n_t4 r0 *1 0,0
Ren_nand_m_en_nand_m_en_via_nand_s2_en_nand_s2_en_via_rst_n_t4 rst_n__t4 rst_n 325.422862766
* device instance en_nand_m_en_nand_m_en_via_nand_s2_en_nand_s2_en_via_rst_n_t5 r0 *1 0,0
Ren_nand_m_en_nand_m_en_via_nand_s2_en_nand_s2_en_via_rst_n_t5 rst_n__t5 rst_n 142.020251455
* device instance en_nand_m_en_nand_m_en_via_nand_s2_en_nand_s2_en_via_rst_n_t6 r0 *1 0,0
Ren_nand_m_en_nand_m_en_via_nand_s2_en_nand_s2_en_via_rst_n_t6 rst_n__t6 rst_n 223.72023709
* device instance en_nand_m_en_nand_m_en_via_nand_s2_en_nand_s2_en_via_rst_n_t7 r0 *1 0,0
Ren_nand_m_en_nand_m_en_via_nand_s2_en_nand_s2_en_via_rst_n_t7 rst_n__t7 rst_n 225.203067879
* device instance en_nand_m_en_nand_m_en_via_nand_s2_en_nand_s2_en_via_rst_n_t8 r0 *1 0,0
Ren_nand_m_en_nand_m_en_via_nand_s2_en_nand_s2_en_via_rst_n_t8 rst_n__t8 rst_n 143.502148838
* device instance en_nand_m_en_nand_m_en_via_nand_s2_en_nand_s2_en_via_rst_n_t9 r0 *1 0,0
Ren_nand_m_en_nand_m_en_via_nand_s2_en_nand_s2_en_via_rst_n_t9 rst_n__t9 rst_n 510.37043704
* device instance en_nand_m_en_nand_m_en_via_nand_s2_en_nand_s2_en_via_rst_n_t10 r0 *1 0,0
Ren_nand_m_en_nand_m_en_via_nand_s2_en_nand_s2_en_via_rst_n_t10 rst_n__t10 rst_n 42.1332712618
* device instance en_nand_m_en_nand_m_en_via_nand_s2_en_nand_s2_en_via_rst_n_t11 r0 *1 0,0
Ren_nand_m_en_nand_m_en_via_nand_s2_en_nand_s2_en_via_rst_n_t11 rst_n__t11 rst_n 408.648234462
* device instance en_nand_m_en_nand_m_en_via_nand_s2_en_nand_s2_en_via_rst_n_t12 r0 *1 0,0
Ren_nand_m_en_nand_m_en_via_nand_s2_en_nand_s2_en_via_rst_n_t12 rst_n__t12 rst_n 326.906027181
* device instance en_nand_m_en_nand_m_en_via_nand_s2_en_nand_s2_en_via_rst_n_t13 r0 *1 0,0
Ren_nand_m_en_nand_m_en_via_nand_s2_en_nand_s2_en_via_rst_n_t13 rst_n__t13 rst_n 143.502148838
* device instance en_nand_m_en_nand_m_en_via_nand_s2_en_nand_s2_en_via_rst_n_t14 r0 *1 0,0
Ren_nand_m_en_nand_m_en_via_nand_s2_en_nand_s2_en_via_rst_n_t14 rst_n__t14 rst_n 225.203067879
* device instance en_nand_m_en_nand_m_en_via_nand_s2_en_nand_s2_en_via_rst_n_t15 r0 *1 0,0
Ren_nand_m_en_nand_m_en_via_nand_s2_en_nand_s2_en_via_rst_n_t15 rst_n__t15 rst_n 326.906027181
* device instance en_nand_m_en_nand_m_en_via_nand_s2_en_nand_s2_en_via_rst_n_t16 r0 *1 0,0
Ren_nand_m_en_nand_m_en_via_nand_s2_en_nand_s2_en_via_rst_n_t16 rst_n__t16 rst_n 408.648234462
* device instance en_nand_m_en_nand_m_en_via_nand_s2_en_nand_s2_en_via_rst_n_t17 r0 *1 0,0
Ren_nand_m_en_nand_m_en_via_nand_s2_en_nand_s2_en_via_rst_n_t17 rst_n__t17 rst_n 510.37043704
* device instance en_nand_m_en_nand_m_en_via_nand_s2_en_nand_s2_en_via_rst_n_t18 r0 *1 0,0
Ren_nand_m_en_nand_m_en_via_nand_s2_en_nand_s2_en_via_rst_n_t18 rst_n__t18 rst_n 42.1332712618
* device instance en_nand_m_en_nand_m_en_via_nand_s2_en_nand_s2_en_via_rst_n_t19 r0 *1 0,0
Ren_nand_m_en_nand_m_en_via_nand_s2_en_nand_s2_en_via_rst_n_t19 rst_n__t19 rst_n 40.6685547659
* device instance en_nand_m_en_nand_m_en_via_nand_s2_en_nand_s2_en_via_rst_n_t20 r0 *1 0,0
Ren_nand_m_en_nand_m_en_via_nand_s2_en_nand_s2_en_via_rst_n_t20 rst_n__t20 rst_n 142.020251455
* device instance en_nand_m_en_nand_m_en_via_nand_s2_en_nand_s2_en_via_rst_n_t21 r0 *1 0,0
Ren_nand_m_en_nand_m_en_via_nand_s2_en_nand_s2_en_via_rst_n_t21 rst_n__t21 rst_n 223.72023709
* device instance en_nand_m_en_nand_m_en_via_nand_s2_en_nand_s2_en_via_rst_n_t22 r0 *1 0,0
Ren_nand_m_en_nand_m_en_via_nand_s2_en_nand_s2_en_via_rst_n_t22 rst_n__t22 rst_n 407.164961817
* device instance en_nand_m_en_nand_m_en_via_nand_s2_en_nand_s2_en_via_rst_n_t23 r0 *1 0,0
Ren_nand_m_en_nand_m_en_via_nand_s2_en_nand_s2_en_via_rst_n_t23 rst_n__t23 rst_n 325.422862766
* device instance en_nand_m_en_nand_m_en_via_nand_s2_en_nand_s2_en_via_rst_n r0 *1 0,0
Cen_nand_m_en_nand_m_en_via_nand_s2_en_nand_s2_en_via_rst_n rst_n vsubs 4.799164e-14
* device instance g_vddr_m1_mnt_g_s1_vddr_m1_s2_vddr_m1_s3_vddr_m1_s4_vddr_m1_vddr_vddr1_t0 r0 *1 0,0
Rg_vddr_m1_mnt_g_s1_vddr_m1_s2_vddr_m1_s3_vddr_m1_s4_vddr_m1_vddr_vddr1_t0 vddr1__t0 vddr1 548.247137452
* device instance g_vddr_m1_mnt_g_s1_vddr_m1_s2_vddr_m1_s3_vddr_m1_s4_vddr_m1_vddr_vddr1_t1 r0 *1 0,0
Rg_vddr_m1_mnt_g_s1_vddr_m1_s2_vddr_m1_s3_vddr_m1_s4_vddr_m1_vddr_vddr1_t1 vddr1__t1 vddr1 542.513498718
* device instance g_vddr_m1_mnt_g_s1_vddr_m1_s2_vddr_m1_s3_vddr_m1_s4_vddr_m1_vddr_vddr1_t2 r0 *1 0,0
Rg_vddr_m1_mnt_g_s1_vddr_m1_s2_vddr_m1_s3_vddr_m1_s4_vddr_m1_vddr_vddr1_t2 vddr1__t2 vddr1 542.513498718
* device instance g_vddr_m1_mnt_g_s1_vddr_m1_s2_vddr_m1_s3_vddr_m1_s4_vddr_m1_vddr_vddr1_t3 r0 *1 0,0
Rg_vddr_m1_mnt_g_s1_vddr_m1_s2_vddr_m1_s3_vddr_m1_s4_vddr_m1_vddr_vddr1_t3 vddr1__t3 vddr1 248.149615946
* device instance g_vddr_m1_mnt_g_s1_vddr_m1_s2_vddr_m1_s3_vddr_m1_s4_vddr_m1_vddr_vddr1_t4 r0 *1 0,0
Rg_vddr_m1_mnt_g_s1_vddr_m1_s2_vddr_m1_s3_vddr_m1_s4_vddr_m1_vddr_vddr1_t4 vddr1__t4 vddr1 529.307929685
* device instance g_vddr_m1_mnt_g_s1_vddr_m1_s2_vddr_m1_s3_vddr_m1_s4_vddr_m1_vddr_vddr1_t5 r0 *1 0,0
Rg_vddr_m1_mnt_g_s1_vddr_m1_s2_vddr_m1_s3_vddr_m1_s4_vddr_m1_vddr_vddr1_t5 vddr1__t5 vddr1 26.5392771065
* device instance g_vddr_m1_mnt_g_s1_vddr_m1_s2_vddr_m1_s3_vddr_m1_s4_vddr_m1_vddr_vddr1_t6 r0 *1 0,0
Rg_vddr_m1_mnt_g_s1_vddr_m1_s2_vddr_m1_s3_vddr_m1_s4_vddr_m1_vddr_vddr1_t6 vddr1__t6 vddr1 271.232773475
* device instance g_vddr_m1_mnt_g_s1_vddr_m1_s2_vddr_m1_s3_vddr_m1_s4_vddr_m1_vddr_vddr1_t7 r0 *1 0,0
Rg_vddr_m1_mnt_g_s1_vddr_m1_s2_vddr_m1_s3_vddr_m1_s4_vddr_m1_vddr_vddr1_t7 vddr1__t7 vddr1 248.149615946
* device instance g_vddr_m1_mnt_g_s1_vddr_m1_s2_vddr_m1_s3_vddr_m1_s4_vddr_m1_vddr_vddr1_t8 r0 *1 0,0
Rg_vddr_m1_mnt_g_s1_vddr_m1_s2_vddr_m1_s3_vddr_m1_s4_vddr_m1_vddr_vddr1_t8 vddr1__t8 vddr1 529.307929685
* device instance g_vddr_m1_mnt_g_s1_vddr_m1_s2_vddr_m1_s3_vddr_m1_s4_vddr_m1_vddr_vddr1_t9 r0 *1 0,0
Rg_vddr_m1_mnt_g_s1_vddr_m1_s2_vddr_m1_s3_vddr_m1_s4_vddr_m1_vddr_vddr1_t9 vddr1__t9 vddr1 26.5392771065
* device instance g_vddr_m1_mnt_g_s1_vddr_m1_s2_vddr_m1_s3_vddr_m1_s4_vddr_m1_vddr_vddr1_t10 r0 *1 0,0
Rg_vddr_m1_mnt_g_s1_vddr_m1_s2_vddr_m1_s3_vddr_m1_s4_vddr_m1_vddr_vddr1_t10 vddr1__t10 vddr1 271.232773475
* device instance g_vddr_m1_mnt_g_s1_vddr_m1_s2_vddr_m1_s3_vddr_m1_s4_vddr_m1_vddr_vddr1_t11 r0 *1 0,0
Rg_vddr_m1_mnt_g_s1_vddr_m1_s2_vddr_m1_s3_vddr_m1_s4_vddr_m1_vddr_vddr1_t11 vddr1__t11 vddr1 536.006712531
* device instance g_vddr_m1_mnt_g_s1_vddr_m1_s2_vddr_m1_s3_vddr_m1_s4_vddr_m1_vddr_vddr1_t12 r0 *1 0,0
Rg_vddr_m1_mnt_g_s1_vddr_m1_s2_vddr_m1_s3_vddr_m1_s4_vddr_m1_vddr_vddr1_t12 vddr1__t12 vddr1 88.5474148697
* device instance g_vddr_m1_mnt_g_s1_vddr_m1_s2_vddr_m1_s3_vddr_m1_s4_vddr_m1_vddr_vddr1_t13 r0 *1 0,0
Rg_vddr_m1_mnt_g_s1_vddr_m1_s2_vddr_m1_s3_vddr_m1_s4_vddr_m1_vddr_vddr1_t13 vddr1__t13 vddr1 262.134590134
* device instance g_vddr_m1_mnt_g_s1_vddr_m1_s2_vddr_m1_s3_vddr_m1_s4_vddr_m1_vddr_vddr1_t14 r0 *1 0,0
Rg_vddr_m1_mnt_g_s1_vddr_m1_s2_vddr_m1_s3_vddr_m1_s4_vddr_m1_vddr_vddr1_t14 vddr1__t14 vddr1 284.083665243
* device instance g_vddr_m1_mnt_g_s1_vddr_m1_s2_vddr_m1_s3_vddr_m1_s4_vddr_m1_vddr_vddr1_t15 r0 *1 0,0
Rg_vddr_m1_mnt_g_s1_vddr_m1_s2_vddr_m1_s3_vddr_m1_s4_vddr_m1_vddr_vddr1_t15 vddr1__t15 vddr1 180.105204003
* device instance g_vddr_m1_mnt_g_s1_vddr_m1_s2_vddr_m1_s3_vddr_m1_s4_vddr_m1_vddr_vddr1_t16 r0 *1 0,0
Rg_vddr_m1_mnt_g_s1_vddr_m1_s2_vddr_m1_s3_vddr_m1_s4_vddr_m1_vddr_vddr1_t16 vddr1__t16 vddr1 83.5568030932
* device instance g_vddr_m1_mnt_g_s1_vddr_m1_s2_vddr_m1_s3_vddr_m1_s4_vddr_m1_vddr_vddr1_t17 r0 *1 0,0
Rg_vddr_m1_mnt_g_s1_vddr_m1_s2_vddr_m1_s3_vddr_m1_s4_vddr_m1_vddr_vddr1_t17 vddr1__t17 vddr1 474.224411679
* device instance g_vddr_m1_mnt_g_s1_vddr_m1_s2_vddr_m1_s3_vddr_m1_s4_vddr_m1_vddr_vddr1_t18 r0 *1 0,0
Rg_vddr_m1_mnt_g_s1_vddr_m1_s2_vddr_m1_s3_vddr_m1_s4_vddr_m1_vddr_vddr1_t18 vddr1__t18 vddr1 339.503132563
* device instance g_vddr_m1_mnt_g_s1_vddr_m1_s2_vddr_m1_s3_vddr_m1_s4_vddr_m1_vddr_vddr1_t19 r0 *1 0,0
Rg_vddr_m1_mnt_g_s1_vddr_m1_s2_vddr_m1_s3_vddr_m1_s4_vddr_m1_vddr_vddr1_t19 vddr1__t19 vddr1 597.728866242
* device instance g_vddr_m1_mnt_g_s1_vddr_m1_s2_vddr_m1_s3_vddr_m1_s4_vddr_m1_vddr_vddr1_t20 r0 *1 0,0
Rg_vddr_m1_mnt_g_s1_vddr_m1_s2_vddr_m1_s3_vddr_m1_s4_vddr_m1_vddr_vddr1_t20 vddr1__t20 vddr1 433.56387233
* device instance g_vddr_m1_mnt_g_s1_vddr_m1_s2_vddr_m1_s3_vddr_m1_s4_vddr_m1_vddr_vddr1 r0 *1 0,0
Cg_vddr_m1_mnt_g_s1_vddr_m1_s2_vddr_m1_s3_vddr_m1_s4_vddr_m1_vddr_vddr1 vddr1 vsubs 1.4763978e-14
* device instance g_vddr_m1_mnt_g_s1_vddr_m1_s2_vddr_m1_s3_vddr_m1_s4_vddr_m1_vddr_vddr2_t0 r0 *1 0,0
Rg_vddr_m1_mnt_g_s1_vddr_m1_s2_vddr_m1_s3_vddr_m1_s4_vddr_m1_vddr_vddr2_t0 vddr2__t0 vddr2 548.481147289
* device instance g_vddr_m1_mnt_g_s1_vddr_m1_s2_vddr_m1_s3_vddr_m1_s4_vddr_m1_vddr_vddr2_t1 r0 *1 0,0
Rg_vddr_m1_mnt_g_s1_vddr_m1_s2_vddr_m1_s3_vddr_m1_s4_vddr_m1_vddr_vddr2_t1 vddr2__t1 vddr2 542.74506125
* device instance g_vddr_m1_mnt_g_s1_vddr_m1_s2_vddr_m1_s3_vddr_m1_s4_vddr_m1_vddr_vddr2_t2 r0 *1 0,0
Rg_vddr_m1_mnt_g_s1_vddr_m1_s2_vddr_m1_s3_vddr_m1_s4_vddr_m1_vddr_vddr2_t2 vddr2__t2 vddr2 542.74506125
* device instance g_vddr_m1_mnt_g_s1_vddr_m1_s2_vddr_m1_s3_vddr_m1_s4_vddr_m1_vddr_vddr2_t3 r0 *1 0,0
Rg_vddr_m1_mnt_g_s1_vddr_m1_s2_vddr_m1_s3_vddr_m1_s4_vddr_m1_vddr_vddr2_t3 vddr2__t3 vddr2 248.25553433
* device instance g_vddr_m1_mnt_g_s1_vddr_m1_s2_vddr_m1_s3_vddr_m1_s4_vddr_m1_vddr_vddr2_t4 r0 *1 0,0
Rg_vddr_m1_mnt_g_s1_vddr_m1_s2_vddr_m1_s3_vddr_m1_s4_vddr_m1_vddr_vddr2_t4 vddr2__t4 vddr2 26.5506049392
* device instance g_vddr_m1_mnt_g_s1_vddr_m1_s2_vddr_m1_s3_vddr_m1_s4_vddr_m1_vddr_vddr2_t5 r0 *1 0,0
Rg_vddr_m1_mnt_g_s1_vddr_m1_s2_vddr_m1_s3_vddr_m1_s4_vddr_m1_vddr_vddr2_t5 vddr2__t5 vddr2 529.533855647
* device instance g_vddr_m1_mnt_g_s1_vddr_m1_s2_vddr_m1_s3_vddr_m1_s4_vddr_m1_vddr_vddr2_t6 r0 *1 0,0
Rg_vddr_m1_mnt_g_s1_vddr_m1_s2_vddr_m1_s3_vddr_m1_s4_vddr_m1_vddr_vddr2_t6 vddr2__t6 vddr2 271.348544507
* device instance g_vddr_m1_mnt_g_s1_vddr_m1_s2_vddr_m1_s3_vddr_m1_s4_vddr_m1_vddr_vddr2_t7 r0 *1 0,0
Rg_vddr_m1_mnt_g_s1_vddr_m1_s2_vddr_m1_s3_vddr_m1_s4_vddr_m1_vddr_vddr2_t7 vddr2__t7 vddr2 248.25553433
* device instance g_vddr_m1_mnt_g_s1_vddr_m1_s2_vddr_m1_s3_vddr_m1_s4_vddr_m1_vddr_vddr2_t8 r0 *1 0,0
Rg_vddr_m1_mnt_g_s1_vddr_m1_s2_vddr_m1_s3_vddr_m1_s4_vddr_m1_vddr_vddr2_t8 vddr2__t8 vddr2 26.5506049392
* device instance g_vddr_m1_mnt_g_s1_vddr_m1_s2_vddr_m1_s3_vddr_m1_s4_vddr_m1_vddr_vddr2_t9 r0 *1 0,0
Rg_vddr_m1_mnt_g_s1_vddr_m1_s2_vddr_m1_s3_vddr_m1_s4_vddr_m1_vddr_vddr2_t9 vddr2__t9 vddr2 529.533855647
* device instance g_vddr_m1_mnt_g_s1_vddr_m1_s2_vddr_m1_s3_vddr_m1_s4_vddr_m1_vddr_vddr2_t10 r0 *1 0,0
Rg_vddr_m1_mnt_g_s1_vddr_m1_s2_vddr_m1_s3_vddr_m1_s4_vddr_m1_vddr_vddr2_t10 vddr2__t10 vddr2 271.348544507
* device instance g_vddr_m1_mnt_g_s1_vddr_m1_s2_vddr_m1_s3_vddr_m1_s4_vddr_m1_vddr_vddr2_t11 r0 *1 0,0
Rg_vddr_m1_mnt_g_s1_vddr_m1_s2_vddr_m1_s3_vddr_m1_s4_vddr_m1_vddr_vddr2_t11 vddr2__t11 vddr2 536.235497753
* device instance g_vddr_m1_mnt_g_s1_vddr_m1_s2_vddr_m1_s3_vddr_m1_s4_vddr_m1_vddr_vddr2_t12 r0 *1 0,0
Rg_vddr_m1_mnt_g_s1_vddr_m1_s2_vddr_m1_s3_vddr_m1_s4_vddr_m1_vddr_vddr2_t12 vddr2__t12 vddr2 88.5852098068
* device instance g_vddr_m1_mnt_g_s1_vddr_m1_s2_vddr_m1_s3_vddr_m1_s4_vddr_m1_vddr_vddr2_t13 r0 *1 0,0
Rg_vddr_m1_mnt_g_s1_vddr_m1_s2_vddr_m1_s3_vddr_m1_s4_vddr_m1_vddr_vddr2_t13 vddr2__t13 vddr2 262.246477764
* device instance g_vddr_m1_mnt_g_s1_vddr_m1_s2_vddr_m1_s3_vddr_m1_s4_vddr_m1_vddr_vddr2_t14 r0 *1 0,0
Rg_vddr_m1_mnt_g_s1_vddr_m1_s2_vddr_m1_s3_vddr_m1_s4_vddr_m1_vddr_vddr2_t14 vddr2__t14 vddr2 284.204921457
* device instance g_vddr_m1_mnt_g_s1_vddr_m1_s2_vddr_m1_s3_vddr_m1_s4_vddr_m1_vddr_vddr2_t15 r0 *1 0,0
Rg_vddr_m1_mnt_g_s1_vddr_m1_s2_vddr_m1_s3_vddr_m1_s4_vddr_m1_vddr_vddr2_t15 vddr2__t15 vddr2 597.983996501
* device instance g_vddr_m1_mnt_g_s1_vddr_m1_s2_vddr_m1_s3_vddr_m1_s4_vddr_m1_vddr_vddr2_t16 r0 *1 0,0
Rg_vddr_m1_mnt_g_s1_vddr_m1_s2_vddr_m1_s3_vddr_m1_s4_vddr_m1_vddr_vddr2_t16 vddr2__t16 vddr2 339.64804362
* device instance g_vddr_m1_mnt_g_s1_vddr_m1_s2_vddr_m1_s3_vddr_m1_s4_vddr_m1_vddr_vddr2_t17 r0 *1 0,0
Rg_vddr_m1_mnt_g_s1_vddr_m1_s2_vddr_m1_s3_vddr_m1_s4_vddr_m1_vddr_vddr2_t17 vddr2__t17 vddr2 474.426826191
* device instance g_vddr_m1_mnt_g_s1_vddr_m1_s2_vddr_m1_s3_vddr_m1_s4_vddr_m1_vddr_vddr2_t18 r0 *1 0,0
Rg_vddr_m1_mnt_g_s1_vddr_m1_s2_vddr_m1_s3_vddr_m1_s4_vddr_m1_vddr_vddr2_t18 vddr2__t18 vddr2 433.748931592
* device instance g_vddr_m1_mnt_g_s1_vddr_m1_s2_vddr_m1_s3_vddr_m1_s4_vddr_m1_vddr_vddr2_t19 r0 *1 0,0
Rg_vddr_m1_mnt_g_s1_vddr_m1_s2_vddr_m1_s3_vddr_m1_s4_vddr_m1_vddr_vddr2_t19 vddr2__t19 vddr2 180.182078803
* device instance g_vddr_m1_mnt_g_s1_vddr_m1_s2_vddr_m1_s3_vddr_m1_s4_vddr_m1_vddr_vddr2_t20 r0 *1 0,0
Rg_vddr_m1_mnt_g_s1_vddr_m1_s2_vddr_m1_s3_vddr_m1_s4_vddr_m1_vddr_vddr2_t20 vddr2__t20 vddr2 83.5924678737
* device instance g_vddr_m1_mnt_g_s1_vddr_m1_s2_vddr_m1_s3_vddr_m1_s4_vddr_m1_vddr_vddr2 r0 *1 0,0
Cg_vddr_m1_mnt_g_s1_vddr_m1_s2_vddr_m1_s3_vddr_m1_s4_vddr_m1_vddr_vddr2 vddr2 vsubs 1.4773157e-14
* device instance g_vddr_m1_mnt_g_s1_vddr_m1_s2_vddr_m1_s3_vddr_m1_s4_vddr_m1_vddr_vddr3_t0 r0 *1 0,0
Rg_vddr_m1_mnt_g_s1_vddr_m1_s2_vddr_m1_s3_vddr_m1_s4_vddr_m1_vddr_vddr3_t0 vddr3__t0 vddr3 548.715164888
* device instance g_vddr_m1_mnt_g_s1_vddr_m1_s2_vddr_m1_s3_vddr_m1_s4_vddr_m1_vddr_vddr3_t1 r0 *1 0,0
Rg_vddr_m1_mnt_g_s1_vddr_m1_s2_vddr_m1_s3_vddr_m1_s4_vddr_m1_vddr_vddr3_t1 vddr3__t1 vddr3 542.976631462
* device instance g_vddr_m1_mnt_g_s1_vddr_m1_s2_vddr_m1_s3_vddr_m1_s4_vddr_m1_vddr_vddr3_t2 r0 *1 0,0
Rg_vddr_m1_mnt_g_s1_vddr_m1_s2_vddr_m1_s3_vddr_m1_s4_vddr_m1_vddr_vddr3_t2 vddr3__t2 vddr3 542.976631462
* device instance g_vddr_m1_mnt_g_s1_vddr_m1_s2_vddr_m1_s3_vddr_m1_s4_vddr_m1_vddr_vddr3_t3 r0 *1 0,0
Rg_vddr_m1_mnt_g_s1_vddr_m1_s2_vddr_m1_s3_vddr_m1_s4_vddr_m1_vddr_vddr3_t3 vddr3__t3 vddr3 248.361456228
* device instance g_vddr_m1_mnt_g_s1_vddr_m1_s2_vddr_m1_s3_vddr_m1_s4_vddr_m1_vddr_vddr3_t4 r0 *1 0,0
Rg_vddr_m1_mnt_g_s1_vddr_m1_s2_vddr_m1_s3_vddr_m1_s4_vddr_m1_vddr_vddr3_t4 vddr3__t4 vddr3 26.5619331478
* device instance g_vddr_m1_mnt_g_s1_vddr_m1_s2_vddr_m1_s3_vddr_m1_s4_vddr_m1_vddr_vddr3_t5 r0 *1 0,0
Rg_vddr_m1_mnt_g_s1_vddr_m1_s2_vddr_m1_s3_vddr_m1_s4_vddr_m1_vddr_vddr3_t5 vddr3__t5 vddr3 271.46431938
* device instance g_vddr_m1_mnt_g_s1_vddr_m1_s2_vddr_m1_s3_vddr_m1_s4_vddr_m1_vddr_vddr3_t6 r0 *1 0,0
Rg_vddr_m1_mnt_g_s1_vddr_m1_s2_vddr_m1_s3_vddr_m1_s4_vddr_m1_vddr_vddr3_t6 vddr3__t6 vddr3 529.759789104
* device instance g_vddr_m1_mnt_g_s1_vddr_m1_s2_vddr_m1_s3_vddr_m1_s4_vddr_m1_vddr_vddr3_t7 r0 *1 0,0
Rg_vddr_m1_mnt_g_s1_vddr_m1_s2_vddr_m1_s3_vddr_m1_s4_vddr_m1_vddr_vddr3_t7 vddr3__t7 vddr3 248.361456228
* device instance g_vddr_m1_mnt_g_s1_vddr_m1_s2_vddr_m1_s3_vddr_m1_s4_vddr_m1_vddr_vddr3_t8 r0 *1 0,0
Rg_vddr_m1_mnt_g_s1_vddr_m1_s2_vddr_m1_s3_vddr_m1_s4_vddr_m1_vddr_vddr3_t8 vddr3__t8 vddr3 26.5619331478
* device instance g_vddr_m1_mnt_g_s1_vddr_m1_s2_vddr_m1_s3_vddr_m1_s4_vddr_m1_vddr_vddr3_t9 r0 *1 0,0
Rg_vddr_m1_mnt_g_s1_vddr_m1_s2_vddr_m1_s3_vddr_m1_s4_vddr_m1_vddr_vddr3_t9 vddr3__t9 vddr3 271.46431938
* device instance g_vddr_m1_mnt_g_s1_vddr_m1_s2_vddr_m1_s3_vddr_m1_s4_vddr_m1_vddr_vddr3_t10 r0 *1 0,0
Rg_vddr_m1_mnt_g_s1_vddr_m1_s2_vddr_m1_s3_vddr_m1_s4_vddr_m1_vddr_vddr3_t10 vddr3__t10 vddr3 529.759789104
* device instance g_vddr_m1_mnt_g_s1_vddr_m1_s2_vddr_m1_s3_vddr_m1_s4_vddr_m1_vddr_vddr3_t11 r0 *1 0,0
Rg_vddr_m1_mnt_g_s1_vddr_m1_s2_vddr_m1_s3_vddr_m1_s4_vddr_m1_vddr_vddr3_t11 vddr3__t11 vddr3 262.358369105
* device instance g_vddr_m1_mnt_g_s1_vddr_m1_s2_vddr_m1_s3_vddr_m1_s4_vddr_m1_vddr_vddr3_t12 r0 *1 0,0
Rg_vddr_m1_mnt_g_s1_vddr_m1_s2_vddr_m1_s3_vddr_m1_s4_vddr_m1_vddr_vddr3_t12 vddr3__t12 vddr3 88.6230059976
* device instance g_vddr_m1_mnt_g_s1_vddr_m1_s2_vddr_m1_s3_vddr_m1_s4_vddr_m1_vddr_vddr3_t13 r0 *1 0,0
Rg_vddr_m1_mnt_g_s1_vddr_m1_s2_vddr_m1_s3_vddr_m1_s4_vddr_m1_vddr_vddr3_t13 vddr3__t13 vddr3 284.326181692
* device instance g_vddr_m1_mnt_g_s1_vddr_m1_s2_vddr_m1_s3_vddr_m1_s4_vddr_m1_vddr_vddr3_t14 r0 *1 0,0
Rg_vddr_m1_mnt_g_s1_vddr_m1_s2_vddr_m1_s3_vddr_m1_s4_vddr_m1_vddr_vddr3_t14 vddr3__t14 vddr3 536.464290564
* device instance g_vddr_m1_mnt_g_s1_vddr_m1_s2_vddr_m1_s3_vddr_m1_s4_vddr_m1_vddr_vddr3_t15 r0 *1 0,0
Rg_vddr_m1_mnt_g_s1_vddr_m1_s2_vddr_m1_s3_vddr_m1_s4_vddr_m1_vddr_vddr3_t15 vddr3__t15 vddr3 598.239135223
* device instance g_vddr_m1_mnt_g_s1_vddr_m1_s2_vddr_m1_s3_vddr_m1_s4_vddr_m1_vddr_vddr3_t16 r0 *1 0,0
Rg_vddr_m1_mnt_g_s1_vddr_m1_s2_vddr_m1_s3_vddr_m1_s4_vddr_m1_vddr_vddr3_t16 vddr3__t16 vddr3 339.792959485
* device instance g_vddr_m1_mnt_g_s1_vddr_m1_s2_vddr_m1_s3_vddr_m1_s4_vddr_m1_vddr_vddr3_t17 r0 *1 0,0
Rg_vddr_m1_mnt_g_s1_vddr_m1_s2_vddr_m1_s3_vddr_m1_s4_vddr_m1_vddr_vddr3_t17 vddr3__t17 vddr3 83.6281338372
* device instance g_vddr_m1_mnt_g_s1_vddr_m1_s2_vddr_m1_s3_vddr_m1_s4_vddr_m1_vddr_vddr3_t18 r0 *1 0,0
Rg_vddr_m1_mnt_g_s1_vddr_m1_s2_vddr_m1_s3_vddr_m1_s4_vddr_m1_vddr_vddr3_t18 vddr3__t18 vddr3 180.258956154
* device instance g_vddr_m1_mnt_g_s1_vddr_m1_s2_vddr_m1_s3_vddr_m1_s4_vddr_m1_vddr_vddr3_t19 r0 *1 0,0
Rg_vddr_m1_mnt_g_s1_vddr_m1_s2_vddr_m1_s3_vddr_m1_s4_vddr_m1_vddr_vddr3_t19 vddr3__t19 vddr3 433.933996993
* device instance g_vddr_m1_mnt_g_s1_vddr_m1_s2_vddr_m1_s3_vddr_m1_s4_vddr_m1_vddr_vddr3_t20 r0 *1 0,0
Rg_vddr_m1_mnt_g_s1_vddr_m1_s2_vddr_m1_s3_vddr_m1_s4_vddr_m1_vddr_vddr3_t20 vddr3__t20 vddr3 474.629247418
* device instance g_vddr_m1_mnt_g_s1_vddr_m1_s2_vddr_m1_s3_vddr_m1_s4_vddr_m1_vddr_vddr3 r0 *1 0,0
Cg_vddr_m1_mnt_g_s1_vddr_m1_s2_vddr_m1_s3_vddr_m1_s4_vddr_m1_vddr_vddr3 vddr3 vsubs 1.4778441e-14
* device instance g_vddr_m1_mnt_g_s1_vddr_m1_s2_vddr_m1_s3_vddr_m1_s4_vddr_m1_vddr_vddr4_t0 r0 *1 0,0
Rg_vddr_m1_mnt_g_s1_vddr_m1_s2_vddr_m1_s3_vddr_m1_s4_vddr_m1_vddr_vddr4_t0 vddr4__t0 vddr4 548.949174724
* device instance g_vddr_m1_mnt_g_s1_vddr_m1_s2_vddr_m1_s3_vddr_m1_s4_vddr_m1_vddr_vddr4_t1 r0 *1 0,0
Rg_vddr_m1_mnt_g_s1_vddr_m1_s2_vddr_m1_s3_vddr_m1_s4_vddr_m1_vddr_vddr4_t1 vddr4__t1 vddr4 543.208193994
* device instance g_vddr_m1_mnt_g_s1_vddr_m1_s2_vddr_m1_s3_vddr_m1_s4_vddr_m1_vddr_vddr4_t2 r0 *1 0,0
Rg_vddr_m1_mnt_g_s1_vddr_m1_s2_vddr_m1_s3_vddr_m1_s4_vddr_m1_vddr_vddr4_t2 vddr4__t2 vddr4 543.208193994
* device instance g_vddr_m1_mnt_g_s1_vddr_m1_s2_vddr_m1_s3_vddr_m1_s4_vddr_m1_vddr_vddr4_t3 r0 *1 0,0
Rg_vddr_m1_mnt_g_s1_vddr_m1_s2_vddr_m1_s3_vddr_m1_s4_vddr_m1_vddr_vddr4_t3 vddr4__t3 vddr4 26.5732609806
* device instance g_vddr_m1_mnt_g_s1_vddr_m1_s2_vddr_m1_s3_vddr_m1_s4_vddr_m1_vddr_vddr4_t4 r0 *1 0,0
Rg_vddr_m1_mnt_g_s1_vddr_m1_s2_vddr_m1_s3_vddr_m1_s4_vddr_m1_vddr_vddr4_t4 vddr4__t4 vddr4 248.467374613
* device instance g_vddr_m1_mnt_g_s1_vddr_m1_s2_vddr_m1_s3_vddr_m1_s4_vddr_m1_vddr_vddr4_t5 r0 *1 0,0
Rg_vddr_m1_mnt_g_s1_vddr_m1_s2_vddr_m1_s3_vddr_m1_s4_vddr_m1_vddr_vddr4_t5 vddr4__t5 vddr4 529.985715066
* device instance g_vddr_m1_mnt_g_s1_vddr_m1_s2_vddr_m1_s3_vddr_m1_s4_vddr_m1_vddr_vddr4_t6 r0 *1 0,0
Rg_vddr_m1_mnt_g_s1_vddr_m1_s2_vddr_m1_s3_vddr_m1_s4_vddr_m1_vddr_vddr4_t6 vddr4__t6 vddr4 271.580090412
* device instance g_vddr_m1_mnt_g_s1_vddr_m1_s2_vddr_m1_s3_vddr_m1_s4_vddr_m1_vddr_vddr4_t7 r0 *1 0,0
Rg_vddr_m1_mnt_g_s1_vddr_m1_s2_vddr_m1_s3_vddr_m1_s4_vddr_m1_vddr_vddr4_t7 vddr4__t7 vddr4 26.5732609806
* device instance g_vddr_m1_mnt_g_s1_vddr_m1_s2_vddr_m1_s3_vddr_m1_s4_vddr_m1_vddr_vddr4_t8 r0 *1 0,0
Rg_vddr_m1_mnt_g_s1_vddr_m1_s2_vddr_m1_s3_vddr_m1_s4_vddr_m1_vddr_vddr4_t8 vddr4__t8 vddr4 248.467374613
* device instance g_vddr_m1_mnt_g_s1_vddr_m1_s2_vddr_m1_s3_vddr_m1_s4_vddr_m1_vddr_vddr4_t9 r0 *1 0,0
Rg_vddr_m1_mnt_g_s1_vddr_m1_s2_vddr_m1_s3_vddr_m1_s4_vddr_m1_vddr_vddr4_t9 vddr4__t9 vddr4 529.985715066
* device instance g_vddr_m1_mnt_g_s1_vddr_m1_s2_vddr_m1_s3_vddr_m1_s4_vddr_m1_vddr_vddr4_t10 r0 *1 0,0
Rg_vddr_m1_mnt_g_s1_vddr_m1_s2_vddr_m1_s3_vddr_m1_s4_vddr_m1_vddr_vddr4_t10 vddr4__t10 vddr4 271.580090412
* device instance g_vddr_m1_mnt_g_s1_vddr_m1_s2_vddr_m1_s3_vddr_m1_s4_vddr_m1_vddr_vddr4_t11 r0 *1 0,0
Rg_vddr_m1_mnt_g_s1_vddr_m1_s2_vddr_m1_s3_vddr_m1_s4_vddr_m1_vddr_vddr4_t11 vddr4__t11 vddr4 536.693075787
* device instance g_vddr_m1_mnt_g_s1_vddr_m1_s2_vddr_m1_s3_vddr_m1_s4_vddr_m1_vddr_vddr4_t12 r0 *1 0,0
Rg_vddr_m1_mnt_g_s1_vddr_m1_s2_vddr_m1_s3_vddr_m1_s4_vddr_m1_vddr_vddr4_t12 vddr4__t12 vddr4 284.447437906
* device instance g_vddr_m1_mnt_g_s1_vddr_m1_s2_vddr_m1_s3_vddr_m1_s4_vddr_m1_vddr_vddr4_t13 r0 *1 0,0
Rg_vddr_m1_mnt_g_s1_vddr_m1_s2_vddr_m1_s3_vddr_m1_s4_vddr_m1_vddr_vddr4_t13 vddr4__t13 vddr4 88.6608009347
* device instance g_vddr_m1_mnt_g_s1_vddr_m1_s2_vddr_m1_s3_vddr_m1_s4_vddr_m1_vddr_vddr4_t14 r0 *1 0,0
Rg_vddr_m1_mnt_g_s1_vddr_m1_s2_vddr_m1_s3_vddr_m1_s4_vddr_m1_vddr_vddr4_t14 vddr4__t14 vddr4 262.470256734
* device instance g_vddr_m1_mnt_g_s1_vddr_m1_s2_vddr_m1_s3_vddr_m1_s4_vddr_m1_vddr_vddr4_t15 r0 *1 0,0
Rg_vddr_m1_mnt_g_s1_vddr_m1_s2_vddr_m1_s3_vddr_m1_s4_vddr_m1_vddr_vddr4_t15 vddr4__t15 vddr4 180.335830955
* device instance g_vddr_m1_mnt_g_s1_vddr_m1_s2_vddr_m1_s3_vddr_m1_s4_vddr_m1_vddr_vddr4_t16 r0 *1 0,0
Rg_vddr_m1_mnt_g_s1_vddr_m1_s2_vddr_m1_s3_vddr_m1_s4_vddr_m1_vddr_vddr4_t16 vddr4__t16 vddr4 83.6637986178
* device instance g_vddr_m1_mnt_g_s1_vddr_m1_s2_vddr_m1_s3_vddr_m1_s4_vddr_m1_vddr_vddr4_t17 r0 *1 0,0
Rg_vddr_m1_mnt_g_s1_vddr_m1_s2_vddr_m1_s3_vddr_m1_s4_vddr_m1_vddr_vddr4_t17 vddr4__t17 vddr4 434.119056256
* device instance g_vddr_m1_mnt_g_s1_vddr_m1_s2_vddr_m1_s3_vddr_m1_s4_vddr_m1_vddr_vddr4_t18 r0 *1 0,0
Rg_vddr_m1_mnt_g_s1_vddr_m1_s2_vddr_m1_s3_vddr_m1_s4_vddr_m1_vddr_vddr4_t18 vddr4__t18 vddr4 474.831661931
* device instance g_vddr_m1_mnt_g_s1_vddr_m1_s2_vddr_m1_s3_vddr_m1_s4_vddr_m1_vddr_vddr4_t19 r0 *1 0,0
Rg_vddr_m1_mnt_g_s1_vddr_m1_s2_vddr_m1_s3_vddr_m1_s4_vddr_m1_vddr_vddr4_t19 vddr4__t19 vddr4 598.494265483
* device instance g_vddr_m1_mnt_g_s1_vddr_m1_s2_vddr_m1_s3_vddr_m1_s4_vddr_m1_vddr_vddr4_t20 r0 *1 0,0
Rg_vddr_m1_mnt_g_s1_vddr_m1_s2_vddr_m1_s3_vddr_m1_s4_vddr_m1_vddr_vddr4_t20 vddr4__t20 vddr4 339.937870542
* device instance g_vddr_m1_mnt_g_s1_vddr_m1_s2_vddr_m1_s3_vddr_m1_s4_vddr_m1_vddr_vddr4 r0 *1 0,0
Cg_vddr_m1_mnt_g_s1_vddr_m1_s2_vddr_m1_s3_vddr_m1_s4_vddr_m1_vddr_vddr4 vddr4 vsubs 1.4783725e-14
* device instance g_vss_m1_inv_clk_vss_inv_mc_vss_inv_q_vss_mph_g_nand_m_vss_nand_s2_vss_s1_vss_m1_s2_vss_m1_s3_vss_m1_s4_vss_m1_sb_vss_sr1_vss_sr2_vss_sr3_vss_sr4_vss_sv_vss_tg_d_vss_tg_fbm_vss_tg_fbs_vss_tg_s_vss_vss_vss_link_vss_link_bridge_vss_link_dip_vss_link_m1_vss_x1_vss_x2_vss_x3_t0 r0 *1 0,0
Rg_vss_m1_inv_clk_vss_inv_mc_vss_inv_q_vss_mph_g_nand_m_vss_nand_s2_vss_s1_vss_m1_s2_vss_m1_s3_vss_m1_s4_vss_m1_sb_vss_sr1_vss_sr2_vss_sr3_vss_sr4_vss_sv_vss_tg_d_vss_tg_fbm_vss_tg_fbs_vss_tg_s_vss_vss_vss_link_vss_link_bridge_vss_link_dip_vss_link_m1_vss_x1_vss_x2_vss_x3_t0 vss__t0 vss 307.732923931
* device instance g_vss_m1_inv_clk_vss_inv_mc_vss_inv_q_vss_mph_g_nand_m_vss_nand_s2_vss_s1_vss_m1_s2_vss_m1_s3_vss_m1_s4_vss_m1_sb_vss_sr1_vss_sr2_vss_sr3_vss_sr4_vss_sv_vss_tg_d_vss_tg_fbm_vss_tg_fbs_vss_tg_s_vss_vss_vss_link_vss_link_bridge_vss_link_dip_vss_link_m1_vss_x1_vss_x2_vss_x3_t1 r0 *1 0,0
Rg_vss_m1_inv_clk_vss_inv_mc_vss_inv_q_vss_mph_g_nand_m_vss_nand_s2_vss_s1_vss_m1_s2_vss_m1_s3_vss_m1_s4_vss_m1_sb_vss_sr1_vss_sr2_vss_sr3_vss_sr4_vss_sv_vss_tg_d_vss_tg_fbm_vss_tg_fbs_vss_tg_s_vss_vss_vss_link_vss_link_bridge_vss_link_dip_vss_link_m1_vss_x1_vss_x2_vss_x3_t1 vss__t1 vss 340.723725532
* device instance g_vss_m1_inv_clk_vss_inv_mc_vss_inv_q_vss_mph_g_nand_m_vss_nand_s2_vss_s1_vss_m1_s2_vss_m1_s3_vss_m1_s4_vss_m1_sb_vss_sr1_vss_sr2_vss_sr3_vss_sr4_vss_sv_vss_tg_d_vss_tg_fbm_vss_tg_fbs_vss_tg_s_vss_vss_vss_link_vss_link_bridge_vss_link_dip_vss_link_m1_vss_x1_vss_x2_vss_x3_t2 r0 *1 0,0
Rg_vss_m1_inv_clk_vss_inv_mc_vss_inv_q_vss_mph_g_nand_m_vss_nand_s2_vss_s1_vss_m1_s2_vss_m1_s3_vss_m1_s4_vss_m1_sb_vss_sr1_vss_sr2_vss_sr3_vss_sr4_vss_sv_vss_tg_d_vss_tg_fbm_vss_tg_fbs_vss_tg_s_vss_vss_vss_link_vss_link_bridge_vss_link_dip_vss_link_m1_vss_x1_vss_x2_vss_x3_t2 vss__t2 vss 330.123479448
* device instance g_vss_m1_inv_clk_vss_inv_mc_vss_inv_q_vss_mph_g_nand_m_vss_nand_s2_vss_s1_vss_m1_s2_vss_m1_s3_vss_m1_s4_vss_m1_sb_vss_sr1_vss_sr2_vss_sr3_vss_sr4_vss_sv_vss_tg_d_vss_tg_fbm_vss_tg_fbs_vss_tg_s_vss_vss_vss_link_vss_link_bridge_vss_link_dip_vss_link_m1_vss_x1_vss_x2_vss_x3_t3 r0 *1 0,0
Rg_vss_m1_inv_clk_vss_inv_mc_vss_inv_q_vss_mph_g_nand_m_vss_nand_s2_vss_s1_vss_m1_s2_vss_m1_s3_vss_m1_s4_vss_m1_sb_vss_sr1_vss_sr2_vss_sr3_vss_sr4_vss_sv_vss_tg_d_vss_tg_fbm_vss_tg_fbs_vss_tg_s_vss_vss_vss_link_vss_link_bridge_vss_link_dip_vss_link_m1_vss_x1_vss_x2_vss_x3_t3 vss__t3 vss 177.55440599
* device instance g_vss_m1_inv_clk_vss_inv_mc_vss_inv_q_vss_mph_g_nand_m_vss_nand_s2_vss_s1_vss_m1_s2_vss_m1_s3_vss_m1_s4_vss_m1_sb_vss_sr1_vss_sr2_vss_sr3_vss_sr4_vss_sv_vss_tg_d_vss_tg_fbm_vss_tg_fbs_vss_tg_s_vss_vss_vss_link_vss_link_bridge_vss_link_dip_vss_link_m1_vss_x1_vss_x2_vss_x3_t4 r0 *1 0,0
Rg_vss_m1_inv_clk_vss_inv_mc_vss_inv_q_vss_mph_g_nand_m_vss_nand_s2_vss_s1_vss_m1_s2_vss_m1_s3_vss_m1_s4_vss_m1_sb_vss_sr1_vss_sr2_vss_sr3_vss_sr4_vss_sv_vss_tg_d_vss_tg_fbm_vss_tg_fbs_vss_tg_s_vss_vss_vss_link_vss_link_bridge_vss_link_dip_vss_link_m1_vss_x1_vss_x2_vss_x3_t4 vss__t4 vss 31.6462135368
* device instance g_vss_m1_inv_clk_vss_inv_mc_vss_inv_q_vss_mph_g_nand_m_vss_nand_s2_vss_s1_vss_m1_s2_vss_m1_s3_vss_m1_s4_vss_m1_sb_vss_sr1_vss_sr2_vss_sr3_vss_sr4_vss_sv_vss_tg_d_vss_tg_fbm_vss_tg_fbs_vss_tg_s_vss_vss_vss_link_vss_link_bridge_vss_link_dip_vss_link_m1_vss_x1_vss_x2_vss_x3_t5 r0 *1 0,0
Rg_vss_m1_inv_clk_vss_inv_mc_vss_inv_q_vss_mph_g_nand_m_vss_nand_s2_vss_s1_vss_m1_s2_vss_m1_s3_vss_m1_s4_vss_m1_sb_vss_sr1_vss_sr2_vss_sr3_vss_sr4_vss_sv_vss_tg_d_vss_tg_fbm_vss_tg_fbs_vss_tg_s_vss_vss_vss_link_vss_link_bridge_vss_link_dip_vss_link_m1_vss_x1_vss_x2_vss_x3_t5 vss__t5 vss 131.944150749
* device instance g_vss_m1_inv_clk_vss_inv_mc_vss_inv_q_vss_mph_g_nand_m_vss_nand_s2_vss_s1_vss_m1_s2_vss_m1_s3_vss_m1_s4_vss_m1_sb_vss_sr1_vss_sr2_vss_sr3_vss_sr4_vss_sv_vss_tg_d_vss_tg_fbm_vss_tg_fbs_vss_tg_s_vss_vss_vss_link_vss_link_bridge_vss_link_dip_vss_link_m1_vss_x1_vss_x2_vss_x3_t6 r0 *1 0,0
Rg_vss_m1_inv_clk_vss_inv_mc_vss_inv_q_vss_mph_g_nand_m_vss_nand_s2_vss_s1_vss_m1_s2_vss_m1_s3_vss_m1_s4_vss_m1_sb_vss_sr1_vss_sr2_vss_sr3_vss_sr4_vss_sv_vss_tg_d_vss_tg_fbm_vss_tg_fbs_vss_tg_s_vss_vss_vss_link_vss_link_bridge_vss_link_dip_vss_link_m1_vss_x1_vss_x2_vss_x3_t6 vss__t6 vss 331.030916868
* device instance g_vss_m1_inv_clk_vss_inv_mc_vss_inv_q_vss_mph_g_nand_m_vss_nand_s2_vss_s1_vss_m1_s2_vss_m1_s3_vss_m1_s4_vss_m1_sb_vss_sr1_vss_sr2_vss_sr3_vss_sr4_vss_sv_vss_tg_d_vss_tg_fbm_vss_tg_fbs_vss_tg_s_vss_vss_vss_link_vss_link_bridge_vss_link_dip_vss_link_m1_vss_x1_vss_x2_vss_x3_t7 r0 *1 0,0
Rg_vss_m1_inv_clk_vss_inv_mc_vss_inv_q_vss_mph_g_nand_m_vss_nand_s2_vss_s1_vss_m1_s2_vss_m1_s3_vss_m1_s4_vss_m1_sb_vss_sr1_vss_sr2_vss_sr3_vss_sr4_vss_sv_vss_tg_d_vss_tg_fbm_vss_tg_fbs_vss_tg_s_vss_vss_vss_link_vss_link_bridge_vss_link_dip_vss_link_m1_vss_x1_vss_x2_vss_x3_t7 vss__t7 vss 179.235943175
* device instance g_vss_m1_inv_clk_vss_inv_mc_vss_inv_q_vss_mph_g_nand_m_vss_nand_s2_vss_s1_vss_m1_s2_vss_m1_s3_vss_m1_s4_vss_m1_sb_vss_sr1_vss_sr2_vss_sr3_vss_sr4_vss_sv_vss_tg_d_vss_tg_fbm_vss_tg_fbs_vss_tg_s_vss_vss_vss_link_vss_link_bridge_vss_link_dip_vss_link_m1_vss_x1_vss_x2_vss_x3_t8 r0 *1 0,0
Rg_vss_m1_inv_clk_vss_inv_mc_vss_inv_q_vss_mph_g_nand_m_vss_nand_s2_vss_s1_vss_m1_s2_vss_m1_s3_vss_m1_s4_vss_m1_sb_vss_sr1_vss_sr2_vss_sr3_vss_sr4_vss_sv_vss_tg_d_vss_tg_fbm_vss_tg_fbs_vss_tg_s_vss_vss_vss_link_vss_link_bridge_vss_link_dip_vss_link_m1_vss_x1_vss_x2_vss_x3_t8 vss__t8 vss 40.0179843408
* device instance g_vss_m1_inv_clk_vss_inv_mc_vss_inv_q_vss_mph_g_nand_m_vss_nand_s2_vss_s1_vss_m1_s2_vss_m1_s3_vss_m1_s4_vss_m1_sb_vss_sr1_vss_sr2_vss_sr3_vss_sr4_vss_sv_vss_tg_d_vss_tg_fbm_vss_tg_fbs_vss_tg_s_vss_vss_vss_link_vss_link_bridge_vss_link_dip_vss_link_m1_vss_x1_vss_x2_vss_x3_t9 r0 *1 0,0
Rg_vss_m1_inv_clk_vss_inv_mc_vss_inv_q_vss_mph_g_nand_m_vss_nand_s2_vss_s1_vss_m1_s2_vss_m1_s3_vss_m1_s4_vss_m1_sb_vss_sr1_vss_sr2_vss_sr3_vss_sr4_vss_sv_vss_tg_d_vss_tg_fbm_vss_tg_fbs_vss_tg_s_vss_vss_vss_link_vss_link_bridge_vss_link_dip_vss_link_m1_vss_x1_vss_x2_vss_x3_t9 vss__t9 vss 134.198417116
* device instance g_vss_m1_inv_clk_vss_inv_mc_vss_inv_q_vss_mph_g_nand_m_vss_nand_s2_vss_s1_vss_m1_s2_vss_m1_s3_vss_m1_s4_vss_m1_sb_vss_sr1_vss_sr2_vss_sr3_vss_sr4_vss_sv_vss_tg_d_vss_tg_fbm_vss_tg_fbs_vss_tg_s_vss_vss_vss_link_vss_link_bridge_vss_link_dip_vss_link_m1_vss_x1_vss_x2_vss_x3_t10 r0 *1 0,0
Rg_vss_m1_inv_clk_vss_inv_mc_vss_inv_q_vss_mph_g_nand_m_vss_nand_s2_vss_s1_vss_m1_s2_vss_m1_s3_vss_m1_s4_vss_m1_sb_vss_sr1_vss_sr2_vss_sr3_vss_sr4_vss_sv_vss_tg_d_vss_tg_fbm_vss_tg_fbs_vss_tg_s_vss_vss_vss_link_vss_link_bridge_vss_link_dip_vss_link_m1_vss_x1_vss_x2_vss_x3_t10 vss__t10 vss 181.308286261
* device instance g_vss_m1_inv_clk_vss_inv_mc_vss_inv_q_vss_mph_g_nand_m_vss_nand_s2_vss_s1_vss_m1_s2_vss_m1_s3_vss_m1_s4_vss_m1_sb_vss_sr1_vss_sr2_vss_sr3_vss_sr4_vss_sv_vss_tg_d_vss_tg_fbm_vss_tg_fbs_vss_tg_s_vss_vss_vss_link_vss_link_bridge_vss_link_dip_vss_link_m1_vss_x1_vss_x2_vss_x3_t11 r0 *1 0,0
Rg_vss_m1_inv_clk_vss_inv_mc_vss_inv_q_vss_mph_g_nand_m_vss_nand_s2_vss_s1_vss_m1_s2_vss_m1_s3_vss_m1_s4_vss_m1_sb_vss_sr1_vss_sr2_vss_sr3_vss_sr4_vss_sv_vss_tg_d_vss_tg_fbm_vss_tg_fbs_vss_tg_s_vss_vss_vss_link_vss_link_bridge_vss_link_dip_vss_link_m1_vss_x1_vss_x2_vss_x3_t11 vss__t11 vss 159.055236498
* device instance g_vss_m1_inv_clk_vss_inv_mc_vss_inv_q_vss_mph_g_nand_m_vss_nand_s2_vss_s1_vss_m1_s2_vss_m1_s3_vss_m1_s4_vss_m1_sb_vss_sr1_vss_sr2_vss_sr3_vss_sr4_vss_sv_vss_tg_d_vss_tg_fbm_vss_tg_fbs_vss_tg_s_vss_vss_vss_link_vss_link_bridge_vss_link_dip_vss_link_m1_vss_x1_vss_x2_vss_x3_t12 r0 *1 0,0
Rg_vss_m1_inv_clk_vss_inv_mc_vss_inv_q_vss_mph_g_nand_m_vss_nand_s2_vss_s1_vss_m1_s2_vss_m1_s3_vss_m1_s4_vss_m1_sb_vss_sr1_vss_sr2_vss_sr3_vss_sr4_vss_sv_vss_tg_d_vss_tg_fbm_vss_tg_fbs_vss_tg_s_vss_vss_vss_link_vss_link_bridge_vss_link_dip_vss_link_m1_vss_x1_vss_x2_vss_x3_t12 vss__t12 vss 226.048344123
* device instance g_vss_m1_inv_clk_vss_inv_mc_vss_inv_q_vss_mph_g_nand_m_vss_nand_s2_vss_s1_vss_m1_s2_vss_m1_s3_vss_m1_s4_vss_m1_sb_vss_sr1_vss_sr2_vss_sr3_vss_sr4_vss_sv_vss_tg_d_vss_tg_fbm_vss_tg_fbs_vss_tg_s_vss_vss_vss_link_vss_link_bridge_vss_link_dip_vss_link_m1_vss_x1_vss_x2_vss_x3_t13 r0 *1 0,0
Rg_vss_m1_inv_clk_vss_inv_mc_vss_inv_q_vss_mph_g_nand_m_vss_nand_s2_vss_s1_vss_m1_s2_vss_m1_s3_vss_m1_s4_vss_m1_sb_vss_sr1_vss_sr2_vss_sr3_vss_sr4_vss_sv_vss_tg_d_vss_tg_fbm_vss_tg_fbs_vss_tg_s_vss_vss_vss_link_vss_link_bridge_vss_link_dip_vss_link_m1_vss_x1_vss_x2_vss_x3_t13 vss__t13 vss 203.647873894
* device instance g_vss_m1_inv_clk_vss_inv_mc_vss_inv_q_vss_mph_g_nand_m_vss_nand_s2_vss_s1_vss_m1_s2_vss_m1_s3_vss_m1_s4_vss_m1_sb_vss_sr1_vss_sr2_vss_sr3_vss_sr4_vss_sv_vss_tg_d_vss_tg_fbm_vss_tg_fbs_vss_tg_s_vss_vss_vss_link_vss_link_bridge_vss_link_dip_vss_link_m1_vss_x1_vss_x2_vss_x3_t14 r0 *1 0,0
Rg_vss_m1_inv_clk_vss_inv_mc_vss_inv_q_vss_mph_g_nand_m_vss_nand_s2_vss_s1_vss_m1_s2_vss_m1_s3_vss_m1_s4_vss_m1_sb_vss_sr1_vss_sr2_vss_sr3_vss_sr4_vss_sv_vss_tg_d_vss_tg_fbm_vss_tg_fbs_vss_tg_s_vss_vss_vss_link_vss_link_bridge_vss_link_dip_vss_link_m1_vss_x1_vss_x2_vss_x3_t14 vss__t14 vss 31.592599314
* device instance g_vss_m1_inv_clk_vss_inv_mc_vss_inv_q_vss_mph_g_nand_m_vss_nand_s2_vss_s1_vss_m1_s2_vss_m1_s3_vss_m1_s4_vss_m1_sb_vss_sr1_vss_sr2_vss_sr3_vss_sr4_vss_sv_vss_tg_d_vss_tg_fbm_vss_tg_fbs_vss_tg_s_vss_vss_vss_link_vss_link_bridge_vss_link_dip_vss_link_m1_vss_x1_vss_x2_vss_x3_t15 r0 *1 0,0
Rg_vss_m1_inv_clk_vss_inv_mc_vss_inv_q_vss_mph_g_nand_m_vss_nand_s2_vss_s1_vss_m1_s2_vss_m1_s3_vss_m1_s4_vss_m1_sb_vss_sr1_vss_sr2_vss_sr3_vss_sr4_vss_sv_vss_tg_d_vss_tg_fbm_vss_tg_fbs_vss_tg_s_vss_vss_vss_link_vss_link_bridge_vss_link_dip_vss_link_m1_vss_x1_vss_x2_vss_x3_t15 vss__t15 vss 40.4262412057
* device instance g_vss_m1_inv_clk_vss_inv_mc_vss_inv_q_vss_mph_g_nand_m_vss_nand_s2_vss_s1_vss_m1_s2_vss_m1_s3_vss_m1_s4_vss_m1_sb_vss_sr1_vss_sr2_vss_sr3_vss_sr4_vss_sv_vss_tg_d_vss_tg_fbm_vss_tg_fbs_vss_tg_s_vss_vss_vss_link_vss_link_bridge_vss_link_dip_vss_link_m1_vss_x1_vss_x2_vss_x3_t16 r0 *1 0,0
Rg_vss_m1_inv_clk_vss_inv_mc_vss_inv_q_vss_mph_g_nand_m_vss_nand_s2_vss_s1_vss_m1_s2_vss_m1_s3_vss_m1_s4_vss_m1_sb_vss_sr1_vss_sr2_vss_sr3_vss_sr4_vss_sv_vss_tg_d_vss_tg_fbm_vss_tg_fbs_vss_tg_s_vss_vss_vss_link_vss_link_bridge_vss_link_dip_vss_link_m1_vss_x1_vss_x2_vss_x3_t16 vss__t16 vss 57.4117156125
* device instance g_vss_m1_inv_clk_vss_inv_mc_vss_inv_q_vss_mph_g_nand_m_vss_nand_s2_vss_s1_vss_m1_s2_vss_m1_s3_vss_m1_s4_vss_m1_sb_vss_sr1_vss_sr2_vss_sr3_vss_sr4_vss_sv_vss_tg_d_vss_tg_fbm_vss_tg_fbs_vss_tg_s_vss_vss_vss_link_vss_link_bridge_vss_link_dip_vss_link_m1_vss_x1_vss_x2_vss_x3_t17 r0 *1 0,0
Rg_vss_m1_inv_clk_vss_inv_mc_vss_inv_q_vss_mph_g_nand_m_vss_nand_s2_vss_s1_vss_m1_s2_vss_m1_s3_vss_m1_s4_vss_m1_sb_vss_sr1_vss_sr2_vss_sr3_vss_sr4_vss_sv_vss_tg_d_vss_tg_fbm_vss_tg_fbs_vss_tg_s_vss_vss_vss_link_vss_link_bridge_vss_link_dip_vss_link_m1_vss_x1_vss_x2_vss_x3_t17 vss__t17 vss 77.3535045494
* device instance g_vss_m1_inv_clk_vss_inv_mc_vss_inv_q_vss_mph_g_nand_m_vss_nand_s2_vss_s1_vss_m1_s2_vss_m1_s3_vss_m1_s4_vss_m1_sb_vss_sr1_vss_sr2_vss_sr3_vss_sr4_vss_sv_vss_tg_d_vss_tg_fbm_vss_tg_fbs_vss_tg_s_vss_vss_vss_link_vss_link_bridge_vss_link_dip_vss_link_m1_vss_x1_vss_x2_vss_x3_t18 r0 *1 0,0
Rg_vss_m1_inv_clk_vss_inv_mc_vss_inv_q_vss_mph_g_nand_m_vss_nand_s2_vss_s1_vss_m1_s2_vss_m1_s3_vss_m1_s4_vss_m1_sb_vss_sr1_vss_sr2_vss_sr3_vss_sr4_vss_sv_vss_tg_d_vss_tg_fbm_vss_tg_fbs_vss_tg_s_vss_vss_vss_link_vss_link_bridge_vss_link_dip_vss_link_m1_vss_x1_vss_x2_vss_x3_t18 vss__t18 vss 153.718823657
* device instance g_vss_m1_inv_clk_vss_inv_mc_vss_inv_q_vss_mph_g_nand_m_vss_nand_s2_vss_s1_vss_m1_s2_vss_m1_s3_vss_m1_s4_vss_m1_sb_vss_sr1_vss_sr2_vss_sr3_vss_sr4_vss_sv_vss_tg_d_vss_tg_fbm_vss_tg_fbs_vss_tg_s_vss_vss_vss_link_vss_link_bridge_vss_link_dip_vss_link_m1_vss_x1_vss_x2_vss_x3_t19 r0 *1 0,0
Rg_vss_m1_inv_clk_vss_inv_mc_vss_inv_q_vss_mph_g_nand_m_vss_nand_s2_vss_s1_vss_m1_s2_vss_m1_s3_vss_m1_s4_vss_m1_sb_vss_sr1_vss_sr2_vss_sr3_vss_sr4_vss_sv_vss_tg_d_vss_tg_fbm_vss_tg_fbs_vss_tg_s_vss_vss_vss_link_vss_link_bridge_vss_link_dip_vss_link_m1_vss_x1_vss_x2_vss_x3_t19 vss__t19 vss 131.634826813
* device instance g_vss_m1_inv_clk_vss_inv_mc_vss_inv_q_vss_mph_g_nand_m_vss_nand_s2_vss_s1_vss_m1_s2_vss_m1_s3_vss_m1_s4_vss_m1_sb_vss_sr1_vss_sr2_vss_sr3_vss_sr4_vss_sv_vss_tg_d_vss_tg_fbm_vss_tg_fbs_vss_tg_s_vss_vss_vss_link_vss_link_bridge_vss_link_dip_vss_link_m1_vss_x1_vss_x2_vss_x3_t20 r0 *1 0,0
Rg_vss_m1_inv_clk_vss_inv_mc_vss_inv_q_vss_mph_g_nand_m_vss_nand_s2_vss_s1_vss_m1_s2_vss_m1_s3_vss_m1_s4_vss_m1_sb_vss_sr1_vss_sr2_vss_sr3_vss_sr4_vss_sv_vss_tg_d_vss_tg_fbm_vss_tg_fbs_vss_tg_s_vss_vss_vss_link_vss_link_bridge_vss_link_dip_vss_link_m1_vss_x1_vss_x2_vss_x3_t20 vss__t20 vss 88.3240385873
* device instance g_vss_m1_inv_clk_vss_inv_mc_vss_inv_q_vss_mph_g_nand_m_vss_nand_s2_vss_s1_vss_m1_s2_vss_m1_s3_vss_m1_s4_vss_m1_sb_vss_sr1_vss_sr2_vss_sr3_vss_sr4_vss_sv_vss_tg_d_vss_tg_fbm_vss_tg_fbs_vss_tg_s_vss_vss_vss_link_vss_link_bridge_vss_link_dip_vss_link_m1_vss_x1_vss_x2_vss_x3_t21 r0 *1 0,0
Rg_vss_m1_inv_clk_vss_inv_mc_vss_inv_q_vss_mph_g_nand_m_vss_nand_s2_vss_s1_vss_m1_s2_vss_m1_s3_vss_m1_s4_vss_m1_sb_vss_sr1_vss_sr2_vss_sr3_vss_sr4_vss_sv_vss_tg_d_vss_tg_fbm_vss_tg_fbs_vss_tg_s_vss_vss_vss_link_vss_link_bridge_vss_link_dip_vss_link_m1_vss_x1_vss_x2_vss_x3_t21 vss__t21 vss 109.779843226
* device instance g_vss_m1_inv_clk_vss_inv_mc_vss_inv_q_vss_mph_g_nand_m_vss_nand_s2_vss_s1_vss_m1_s2_vss_m1_s3_vss_m1_s4_vss_m1_sb_vss_sr1_vss_sr2_vss_sr3_vss_sr4_vss_sv_vss_tg_d_vss_tg_fbm_vss_tg_fbs_vss_tg_s_vss_vss_vss_link_vss_link_bridge_vss_link_dip_vss_link_m1_vss_x1_vss_x2_vss_x3_t22 r0 *1 0,0
Rg_vss_m1_inv_clk_vss_inv_mc_vss_inv_q_vss_mph_g_nand_m_vss_nand_s2_vss_s1_vss_m1_s2_vss_m1_s3_vss_m1_s4_vss_m1_sb_vss_sr1_vss_sr2_vss_sr3_vss_sr4_vss_sv_vss_tg_d_vss_tg_fbm_vss_tg_fbs_vss_tg_s_vss_vss_vss_link_vss_link_bridge_vss_link_dip_vss_link_m1_vss_x1_vss_x2_vss_x3_t22 vss__t22 vss 305.274829461
* device instance g_vss_m1_inv_clk_vss_inv_mc_vss_inv_q_vss_mph_g_nand_m_vss_nand_s2_vss_s1_vss_m1_s2_vss_m1_s3_vss_m1_s4_vss_m1_sb_vss_sr1_vss_sr2_vss_sr3_vss_sr4_vss_sv_vss_tg_d_vss_tg_fbm_vss_tg_fbs_vss_tg_s_vss_vss_vss_link_vss_link_bridge_vss_link_dip_vss_link_m1_vss_x1_vss_x2_vss_x3_t23 r0 *1 0,0
Rg_vss_m1_inv_clk_vss_inv_mc_vss_inv_q_vss_mph_g_nand_m_vss_nand_s2_vss_s1_vss_m1_s2_vss_m1_s3_vss_m1_s4_vss_m1_sb_vss_sr1_vss_sr2_vss_sr3_vss_sr4_vss_sv_vss_tg_d_vss_tg_fbm_vss_tg_fbs_vss_tg_s_vss_vss_vss_link_vss_link_bridge_vss_link_dip_vss_link_m1_vss_x1_vss_x2_vss_x3_t23 vss__t23 vss 237.803631721
* device instance g_vss_m1_inv_clk_vss_inv_mc_vss_inv_q_vss_mph_g_nand_m_vss_nand_s2_vss_s1_vss_m1_s2_vss_m1_s3_vss_m1_s4_vss_m1_sb_vss_sr1_vss_sr2_vss_sr3_vss_sr4_vss_sv_vss_tg_d_vss_tg_fbm_vss_tg_fbs_vss_tg_s_vss_vss_vss_link_vss_link_bridge_vss_link_dip_vss_link_m1_vss_x1_vss_x2_vss_x3_t24 r0 *1 0,0
Rg_vss_m1_inv_clk_vss_inv_mc_vss_inv_q_vss_mph_g_nand_m_vss_nand_s2_vss_s1_vss_m1_s2_vss_m1_s3_vss_m1_s4_vss_m1_sb_vss_sr1_vss_sr2_vss_sr3_vss_sr4_vss_sv_vss_tg_d_vss_tg_fbm_vss_tg_fbs_vss_tg_s_vss_vss_vss_link_vss_link_bridge_vss_link_dip_vss_link_m1_vss_x1_vss_x2_vss_x3_t24 vss__t24 vss 282.759676445
* device instance g_vss_m1_inv_clk_vss_inv_mc_vss_inv_q_vss_mph_g_nand_m_vss_nand_s2_vss_s1_vss_m1_s2_vss_m1_s3_vss_m1_s4_vss_m1_sb_vss_sr1_vss_sr2_vss_sr3_vss_sr4_vss_sv_vss_tg_d_vss_tg_fbm_vss_tg_fbs_vss_tg_s_vss_vss_vss_link_vss_link_bridge_vss_link_dip_vss_link_m1_vss_x1_vss_x2_vss_x3_t25 r0 *1 0,0
Rg_vss_m1_inv_clk_vss_inv_mc_vss_inv_q_vss_mph_g_nand_m_vss_nand_s2_vss_s1_vss_m1_s2_vss_m1_s3_vss_m1_s4_vss_m1_sb_vss_sr1_vss_sr2_vss_sr3_vss_sr4_vss_sv_vss_tg_d_vss_tg_fbm_vss_tg_fbs_vss_tg_s_vss_vss_vss_link_vss_link_bridge_vss_link_dip_vss_link_m1_vss_x1_vss_x2_vss_x3_t25 vss__t25 vss 260.267138166
* device instance g_vss_m1_inv_clk_vss_inv_mc_vss_inv_q_vss_mph_g_nand_m_vss_nand_s2_vss_s1_vss_m1_s2_vss_m1_s3_vss_m1_s4_vss_m1_sb_vss_sr1_vss_sr2_vss_sr3_vss_sr4_vss_sv_vss_tg_d_vss_tg_fbm_vss_tg_fbs_vss_tg_s_vss_vss_vss_link_vss_link_bridge_vss_link_dip_vss_link_m1_vss_x1_vss_x2_vss_x3_t26 r0 *1 0,0
Rg_vss_m1_inv_clk_vss_inv_mc_vss_inv_q_vss_mph_g_nand_m_vss_nand_s2_vss_s1_vss_m1_s2_vss_m1_s3_vss_m1_s4_vss_m1_sb_vss_sr1_vss_sr2_vss_sr3_vss_sr4_vss_sv_vss_tg_d_vss_tg_fbm_vss_tg_fbs_vss_tg_s_vss_vss_vss_link_vss_link_bridge_vss_link_dip_vss_link_m1_vss_x1_vss_x2_vss_x3_t26 vss__t26 vss 224.895355835
* device instance g_vss_m1_inv_clk_vss_inv_mc_vss_inv_q_vss_mph_g_nand_m_vss_nand_s2_vss_s1_vss_m1_s2_vss_m1_s3_vss_m1_s4_vss_m1_sb_vss_sr1_vss_sr2_vss_sr3_vss_sr4_vss_sv_vss_tg_d_vss_tg_fbm_vss_tg_fbs_vss_tg_s_vss_vss_vss_link_vss_link_bridge_vss_link_dip_vss_link_m1_vss_x1_vss_x2_vss_x3_t27 r0 *1 0,0
Rg_vss_m1_inv_clk_vss_inv_mc_vss_inv_q_vss_mph_g_nand_m_vss_nand_s2_vss_s1_vss_m1_s2_vss_m1_s3_vss_m1_s4_vss_m1_sb_vss_sr1_vss_sr2_vss_sr3_vss_sr4_vss_sv_vss_tg_d_vss_tg_fbm_vss_tg_fbs_vss_tg_s_vss_vss_vss_link_vss_link_bridge_vss_link_dip_vss_link_m1_vss_x1_vss_x2_vss_x3_t27 vss__t27 vss 202.36729908
* device instance g_vss_m1_inv_clk_vss_inv_mc_vss_inv_q_vss_mph_g_nand_m_vss_nand_s2_vss_s1_vss_m1_s2_vss_m1_s3_vss_m1_s4_vss_m1_sb_vss_sr1_vss_sr2_vss_sr3_vss_sr4_vss_sv_vss_tg_d_vss_tg_fbm_vss_tg_fbs_vss_tg_s_vss_vss_vss_link_vss_link_bridge_vss_link_dip_vss_link_m1_vss_x1_vss_x2_vss_x3_t28 r0 *1 0,0
Rg_vss_m1_inv_clk_vss_inv_mc_vss_inv_q_vss_mph_g_nand_m_vss_nand_s2_vss_s1_vss_m1_s2_vss_m1_s3_vss_m1_s4_vss_m1_sb_vss_sr1_vss_sr2_vss_sr3_vss_sr4_vss_sv_vss_tg_d_vss_tg_fbm_vss_tg_fbs_vss_tg_s_vss_vss_vss_link_vss_link_bridge_vss_link_dip_vss_link_m1_vss_x1_vss_x2_vss_x3_t28 vss__t28 vss 179.868735089
* device instance g_vss_m1_inv_clk_vss_inv_mc_vss_inv_q_vss_mph_g_nand_m_vss_nand_s2_vss_s1_vss_m1_s2_vss_m1_s3_vss_m1_s4_vss_m1_sb_vss_sr1_vss_sr2_vss_sr3_vss_sr4_vss_sv_vss_tg_d_vss_tg_fbm_vss_tg_fbs_vss_tg_s_vss_vss_vss_link_vss_link_bridge_vss_link_dip_vss_link_m1_vss_x1_vss_x2_vss_x3_t29 r0 *1 0,0
Rg_vss_m1_inv_clk_vss_inv_mc_vss_inv_q_vss_mph_g_nand_m_vss_nand_s2_vss_s1_vss_m1_s2_vss_m1_s3_vss_m1_s4_vss_m1_sb_vss_sr1_vss_sr2_vss_sr3_vss_sr4_vss_sv_vss_tg_d_vss_tg_fbm_vss_tg_fbs_vss_tg_s_vss_vss_vss_link_vss_link_bridge_vss_link_dip_vss_link_m1_vss_x1_vss_x2_vss_x3_t29 vss__t29 vss 157.41231036
* device instance g_vss_m1_inv_clk_vss_inv_mc_vss_inv_q_vss_mph_g_nand_m_vss_nand_s2_vss_s1_vss_m1_s2_vss_m1_s3_vss_m1_s4_vss_m1_sb_vss_sr1_vss_sr2_vss_sr3_vss_sr4_vss_sv_vss_tg_d_vss_tg_fbm_vss_tg_fbs_vss_tg_s_vss_vss_vss_link_vss_link_bridge_vss_link_dip_vss_link_m1_vss_x1_vss_x2_vss_x3_t30 r0 *1 0,0
Rg_vss_m1_inv_clk_vss_inv_mc_vss_inv_q_vss_mph_g_nand_m_vss_nand_s2_vss_s1_vss_m1_s2_vss_m1_s3_vss_m1_s4_vss_m1_sb_vss_sr1_vss_sr2_vss_sr3_vss_sr4_vss_sv_vss_tg_d_vss_tg_fbm_vss_tg_fbs_vss_tg_s_vss_vss_vss_link_vss_link_bridge_vss_link_dip_vss_link_m1_vss_x1_vss_x2_vss_x3_t30 vss__t30 vss 21.866859099
* device instance g_vss_m1_inv_clk_vss_inv_mc_vss_inv_q_vss_mph_g_nand_m_vss_nand_s2_vss_s1_vss_m1_s2_vss_m1_s3_vss_m1_s4_vss_m1_sb_vss_sr1_vss_sr2_vss_sr3_vss_sr4_vss_sv_vss_tg_d_vss_tg_fbm_vss_tg_fbs_vss_tg_s_vss_vss_vss_link_vss_link_bridge_vss_link_dip_vss_link_m1_vss_x1_vss_x2_vss_x3_t31 r0 *1 0,0
Rg_vss_m1_inv_clk_vss_inv_mc_vss_inv_q_vss_mph_g_nand_m_vss_nand_s2_vss_s1_vss_m1_s2_vss_m1_s3_vss_m1_s4_vss_m1_sb_vss_sr1_vss_sr2_vss_sr3_vss_sr4_vss_sv_vss_tg_d_vss_tg_fbm_vss_tg_fbs_vss_tg_s_vss_vss_vss_link_vss_link_bridge_vss_link_dip_vss_link_m1_vss_x1_vss_x2_vss_x3_t31 vss__t31 vss 33.3818539549
* device instance g_vss_m1_inv_clk_vss_inv_mc_vss_inv_q_vss_mph_g_nand_m_vss_nand_s2_vss_s1_vss_m1_s2_vss_m1_s3_vss_m1_s4_vss_m1_sb_vss_sr1_vss_sr2_vss_sr3_vss_sr4_vss_sv_vss_tg_d_vss_tg_fbm_vss_tg_fbs_vss_tg_s_vss_vss_vss_link_vss_link_bridge_vss_link_dip_vss_link_m1_vss_x1_vss_x2_vss_x3_t32 r0 *1 0,0
Rg_vss_m1_inv_clk_vss_inv_mc_vss_inv_q_vss_mph_g_nand_m_vss_nand_s2_vss_s1_vss_m1_s2_vss_m1_s3_vss_m1_s4_vss_m1_sb_vss_sr1_vss_sr2_vss_sr3_vss_sr4_vss_sv_vss_tg_d_vss_tg_fbm_vss_tg_fbs_vss_tg_s_vss_vss_vss_link_vss_link_bridge_vss_link_dip_vss_link_m1_vss_x1_vss_x2_vss_x3_t32 vss__t32 vss 52.6893944264
* device instance g_vss_m1_inv_clk_vss_inv_mc_vss_inv_q_vss_mph_g_nand_m_vss_nand_s2_vss_s1_vss_m1_s2_vss_m1_s3_vss_m1_s4_vss_m1_sb_vss_sr1_vss_sr2_vss_sr3_vss_sr4_vss_sv_vss_tg_d_vss_tg_fbm_vss_tg_fbs_vss_tg_s_vss_vss_vss_link_vss_link_bridge_vss_link_dip_vss_link_m1_vss_x1_vss_x2_vss_x3_t33 r0 *1 0,0
Rg_vss_m1_inv_clk_vss_inv_mc_vss_inv_q_vss_mph_g_nand_m_vss_nand_s2_vss_s1_vss_m1_s2_vss_m1_s3_vss_m1_s4_vss_m1_sb_vss_sr1_vss_sr2_vss_sr3_vss_sr4_vss_sv_vss_tg_d_vss_tg_fbm_vss_tg_fbs_vss_tg_s_vss_vss_vss_link_vss_link_bridge_vss_link_dip_vss_link_m1_vss_x1_vss_x2_vss_x3_t33 vss__t33 vss 73.9163842563
* device instance g_vss_m1_inv_clk_vss_inv_mc_vss_inv_q_vss_mph_g_nand_m_vss_nand_s2_vss_s1_vss_m1_s2_vss_m1_s3_vss_m1_s4_vss_m1_sb_vss_sr1_vss_sr2_vss_sr3_vss_sr4_vss_sv_vss_tg_d_vss_tg_fbm_vss_tg_fbs_vss_tg_s_vss_vss_vss_link_vss_link_bridge_vss_link_dip_vss_link_m1_vss_x1_vss_x2_vss_x3_t34 r0 *1 0,0
Rg_vss_m1_inv_clk_vss_inv_mc_vss_inv_q_vss_mph_g_nand_m_vss_nand_s2_vss_s1_vss_m1_s2_vss_m1_s3_vss_m1_s4_vss_m1_sb_vss_sr1_vss_sr2_vss_sr3_vss_sr4_vss_sv_vss_tg_d_vss_tg_fbm_vss_tg_fbs_vss_tg_s_vss_vss_vss_link_vss_link_bridge_vss_link_dip_vss_link_m1_vss_x1_vss_x2_vss_x3_t34 vss__t34 vss 85.329965357
* device instance g_vss_m1_inv_clk_vss_inv_mc_vss_inv_q_vss_mph_g_nand_m_vss_nand_s2_vss_s1_vss_m1_s2_vss_m1_s3_vss_m1_s4_vss_m1_sb_vss_sr1_vss_sr2_vss_sr3_vss_sr4_vss_sv_vss_tg_d_vss_tg_fbm_vss_tg_fbs_vss_tg_s_vss_vss_vss_link_vss_link_bridge_vss_link_dip_vss_link_m1_vss_x1_vss_x2_vss_x3_t35 r0 *1 0,0
Rg_vss_m1_inv_clk_vss_inv_mc_vss_inv_q_vss_mph_g_nand_m_vss_nand_s2_vss_s1_vss_m1_s2_vss_m1_s3_vss_m1_s4_vss_m1_sb_vss_sr1_vss_sr2_vss_sr3_vss_sr4_vss_sv_vss_tg_d_vss_tg_fbm_vss_tg_fbs_vss_tg_s_vss_vss_vss_link_vss_link_bridge_vss_link_dip_vss_link_m1_vss_x1_vss_x2_vss_x3_t35 vss__t35 vss 129.644879673
* device instance g_vss_m1_inv_clk_vss_inv_mc_vss_inv_q_vss_mph_g_nand_m_vss_nand_s2_vss_s1_vss_m1_s2_vss_m1_s3_vss_m1_s4_vss_m1_sb_vss_sr1_vss_sr2_vss_sr3_vss_sr4_vss_sv_vss_tg_d_vss_tg_fbm_vss_tg_fbs_vss_tg_s_vss_vss_vss_link_vss_link_bridge_vss_link_dip_vss_link_m1_vss_x1_vss_x2_vss_x3_t36 r0 *1 0,0
Rg_vss_m1_inv_clk_vss_inv_mc_vss_inv_q_vss_mph_g_nand_m_vss_nand_s2_vss_s1_vss_m1_s2_vss_m1_s3_vss_m1_s4_vss_m1_sb_vss_sr1_vss_sr2_vss_sr3_vss_sr4_vss_sv_vss_tg_d_vss_tg_fbm_vss_tg_fbs_vss_tg_s_vss_vss_vss_link_vss_link_bridge_vss_link_dip_vss_link_m1_vss_x1_vss_x2_vss_x3_t36 vss__t36 vss 152.018235557
* device instance g_vss_m1_inv_clk_vss_inv_mc_vss_inv_q_vss_mph_g_nand_m_vss_nand_s2_vss_s1_vss_m1_s2_vss_m1_s3_vss_m1_s4_vss_m1_sb_vss_sr1_vss_sr2_vss_sr3_vss_sr4_vss_sv_vss_tg_d_vss_tg_fbm_vss_tg_fbs_vss_tg_s_vss_vss_vss_link_vss_link_bridge_vss_link_dip_vss_link_m1_vss_x1_vss_x2_vss_x3_t37 r0 *1 0,0
Rg_vss_m1_inv_clk_vss_inv_mc_vss_inv_q_vss_mph_g_nand_m_vss_nand_s2_vss_s1_vss_m1_s2_vss_m1_s3_vss_m1_s4_vss_m1_sb_vss_sr1_vss_sr2_vss_sr3_vss_sr4_vss_sv_vss_tg_d_vss_tg_fbm_vss_tg_fbs_vss_tg_s_vss_vss_vss_link_vss_link_bridge_vss_link_dip_vss_link_m1_vss_x1_vss_x2_vss_x3_t37 vss__t37 vss 107.38566559
* device instance g_vss_m1_inv_clk_vss_inv_mc_vss_inv_q_vss_mph_g_nand_m_vss_nand_s2_vss_s1_vss_m1_s2_vss_m1_s3_vss_m1_s4_vss_m1_sb_vss_sr1_vss_sr2_vss_sr3_vss_sr4_vss_sv_vss_tg_d_vss_tg_fbm_vss_tg_fbs_vss_tg_s_vss_vss_vss_link_vss_link_bridge_vss_link_dip_vss_link_m1_vss_x1_vss_x2_vss_x3_t38 r0 *1 0,0
Rg_vss_m1_inv_clk_vss_inv_mc_vss_inv_q_vss_mph_g_nand_m_vss_nand_s2_vss_s1_vss_m1_s2_vss_m1_s3_vss_m1_s4_vss_m1_sb_vss_sr1_vss_sr2_vss_sr3_vss_sr4_vss_sv_vss_tg_d_vss_tg_fbm_vss_tg_fbs_vss_tg_s_vss_vss_vss_link_vss_link_bridge_vss_link_dip_vss_link_m1_vss_x1_vss_x2_vss_x3_t38 vss__t38 vss 236.707909574
* device instance g_vss_m1_inv_clk_vss_inv_mc_vss_inv_q_vss_mph_g_nand_m_vss_nand_s2_vss_s1_vss_m1_s2_vss_m1_s3_vss_m1_s4_vss_m1_sb_vss_sr1_vss_sr2_vss_sr3_vss_sr4_vss_sv_vss_tg_d_vss_tg_fbm_vss_tg_fbs_vss_tg_s_vss_vss_vss_link_vss_link_bridge_vss_link_dip_vss_link_m1_vss_x1_vss_x2_vss_x3_t39 r0 *1 0,0
Rg_vss_m1_inv_clk_vss_inv_mc_vss_inv_q_vss_mph_g_nand_m_vss_nand_s2_vss_s1_vss_m1_s2_vss_m1_s3_vss_m1_s4_vss_m1_sb_vss_sr1_vss_sr2_vss_sr3_vss_sr4_vss_sv_vss_tg_d_vss_tg_fbm_vss_tg_fbs_vss_tg_s_vss_vss_vss_link_vss_link_bridge_vss_link_dip_vss_link_m1_vss_x1_vss_x2_vss_x3_t39 vss__t39 vss 281.838786931
* device instance g_vss_m1_inv_clk_vss_inv_mc_vss_inv_q_vss_mph_g_nand_m_vss_nand_s2_vss_s1_vss_m1_s2_vss_m1_s3_vss_m1_s4_vss_m1_sb_vss_sr1_vss_sr2_vss_sr3_vss_sr4_vss_sv_vss_tg_d_vss_tg_fbm_vss_tg_fbs_vss_tg_s_vss_vss_vss_link_vss_link_bridge_vss_link_dip_vss_link_m1_vss_x1_vss_x2_vss_x3_t40 r0 *1 0,0
Rg_vss_m1_inv_clk_vss_inv_mc_vss_inv_q_vss_mph_g_nand_m_vss_nand_s2_vss_s1_vss_m1_s2_vss_m1_s3_vss_m1_s4_vss_m1_sb_vss_sr1_vss_sr2_vss_sr3_vss_sr4_vss_sv_vss_tg_d_vss_tg_fbm_vss_tg_fbs_vss_tg_s_vss_vss_vss_link_vss_link_bridge_vss_link_dip_vss_link_m1_vss_x1_vss_x2_vss_x3_t40 vss__t40 vss 304.422056852
* device instance g_vss_m1_inv_clk_vss_inv_mc_vss_inv_q_vss_mph_g_nand_m_vss_nand_s2_vss_s1_vss_m1_s2_vss_m1_s3_vss_m1_s4_vss_m1_sb_vss_sr1_vss_sr2_vss_sr3_vss_sr4_vss_sv_vss_tg_d_vss_tg_fbm_vss_tg_fbs_vss_tg_s_vss_vss_vss_link_vss_link_bridge_vss_link_dip_vss_link_m1_vss_x1_vss_x2_vss_x3_t41 r0 *1 0,0
Rg_vss_m1_inv_clk_vss_inv_mc_vss_inv_q_vss_mph_g_nand_m_vss_nand_s2_vss_s1_vss_m1_s2_vss_m1_s3_vss_m1_s4_vss_m1_sb_vss_sr1_vss_sr2_vss_sr3_vss_sr4_vss_sv_vss_tg_d_vss_tg_fbm_vss_tg_fbs_vss_tg_s_vss_vss_vss_link_vss_link_bridge_vss_link_dip_vss_link_m1_vss_x1_vss_x2_vss_x3_t41 vss__t41 vss 259.266369598
* device instance g_vss_m1_inv_clk_vss_inv_mc_vss_inv_q_vss_mph_g_nand_m_vss_nand_s2_vss_s1_vss_m1_s2_vss_m1_s3_vss_m1_s4_vss_m1_sb_vss_sr1_vss_sr2_vss_sr3_vss_sr4_vss_sv_vss_tg_d_vss_tg_fbm_vss_tg_fbs_vss_tg_s_vss_vss_vss_link_vss_link_bridge_vss_link_dip_vss_link_m1_vss_x1_vss_x2_vss_x3_t42 r0 *1 0,0
Rg_vss_m1_inv_clk_vss_inv_mc_vss_inv_q_vss_mph_g_nand_m_vss_nand_s2_vss_s1_vss_m1_s2_vss_m1_s3_vss_m1_s4_vss_m1_sb_vss_sr1_vss_sr2_vss_sr3_vss_sr4_vss_sv_vss_tg_d_vss_tg_fbm_vss_tg_fbs_vss_tg_s_vss_vss_vss_link_vss_link_bridge_vss_link_dip_vss_link_m1_vss_x1_vss_x2_vss_x3_t42 vss__t42 vss 335.138754204
* device instance g_vss_m1_inv_clk_vss_inv_mc_vss_inv_q_vss_mph_g_nand_m_vss_nand_s2_vss_s1_vss_m1_s2_vss_m1_s3_vss_m1_s4_vss_m1_sb_vss_sr1_vss_sr2_vss_sr3_vss_sr4_vss_sv_vss_tg_d_vss_tg_fbm_vss_tg_fbs_vss_tg_s_vss_vss_vss_link_vss_link_bridge_vss_link_dip_vss_link_m1_vss_x1_vss_x2_vss_x3_t43 r0 *1 0,0
Rg_vss_m1_inv_clk_vss_inv_mc_vss_inv_q_vss_mph_g_nand_m_vss_nand_s2_vss_s1_vss_m1_s2_vss_m1_s3_vss_m1_s4_vss_m1_sb_vss_sr1_vss_sr2_vss_sr3_vss_sr4_vss_sv_vss_tg_d_vss_tg_fbm_vss_tg_fbs_vss_tg_s_vss_vss_vss_link_vss_link_bridge_vss_link_dip_vss_link_m1_vss_x1_vss_x2_vss_x3_t43 vss__t43 vss 282.247818296
* device instance g_vss_m1_inv_clk_vss_inv_mc_vss_inv_q_vss_mph_g_nand_m_vss_nand_s2_vss_s1_vss_m1_s2_vss_m1_s3_vss_m1_s4_vss_m1_sb_vss_sr1_vss_sr2_vss_sr3_vss_sr4_vss_sv_vss_tg_d_vss_tg_fbm_vss_tg_fbs_vss_tg_s_vss_vss_vss_link_vss_link_bridge_vss_link_dip_vss_link_m1_vss_x1_vss_x2_vss_x3_t44 r0 *1 0,0
Rg_vss_m1_inv_clk_vss_inv_mc_vss_inv_q_vss_mph_g_nand_m_vss_nand_s2_vss_s1_vss_m1_s2_vss_m1_s3_vss_m1_s4_vss_m1_sb_vss_sr1_vss_sr2_vss_sr3_vss_sr4_vss_sv_vss_tg_d_vss_tg_fbm_vss_tg_fbs_vss_tg_s_vss_vss_vss_link_vss_link_bridge_vss_link_dip_vss_link_m1_vss_x1_vss_x2_vss_x3_t44 vss__t44 vss 228.602921778
* device instance g_vss_m1_inv_clk_vss_inv_mc_vss_inv_q_vss_mph_g_nand_m_vss_nand_s2_vss_s1_vss_m1_s2_vss_m1_s3_vss_m1_s4_vss_m1_sb_vss_sr1_vss_sr2_vss_sr3_vss_sr4_vss_sv_vss_tg_d_vss_tg_fbm_vss_tg_fbs_vss_tg_s_vss_vss_vss_link_vss_link_bridge_vss_link_dip_vss_link_m1_vss_x1_vss_x2_vss_x3_t45 r0 *1 0,0
Rg_vss_m1_inv_clk_vss_inv_mc_vss_inv_q_vss_mph_g_nand_m_vss_nand_s2_vss_s1_vss_m1_s2_vss_m1_s3_vss_m1_s4_vss_m1_sb_vss_sr1_vss_sr2_vss_sr3_vss_sr4_vss_sv_vss_tg_d_vss_tg_fbm_vss_tg_fbs_vss_tg_s_vss_vss_vss_link_vss_link_bridge_vss_link_dip_vss_link_m1_vss_x1_vss_x2_vss_x3_t45 vss__t45 vss 183.385616322
* device instance g_vss_m1_inv_clk_vss_inv_mc_vss_inv_q_vss_mph_g_nand_m_vss_nand_s2_vss_s1_vss_m1_s2_vss_m1_s3_vss_m1_s4_vss_m1_sb_vss_sr1_vss_sr2_vss_sr3_vss_sr4_vss_sv_vss_tg_d_vss_tg_fbm_vss_tg_fbs_vss_tg_s_vss_vss_vss_link_vss_link_bridge_vss_link_dip_vss_link_m1_vss_x1_vss_x2_vss_x3_t46 r0 *1 0,0
Rg_vss_m1_inv_clk_vss_inv_mc_vss_inv_q_vss_mph_g_nand_m_vss_nand_s2_vss_s1_vss_m1_s2_vss_m1_s3_vss_m1_s4_vss_m1_sb_vss_sr1_vss_sr2_vss_sr3_vss_sr4_vss_sv_vss_tg_d_vss_tg_fbm_vss_tg_fbs_vss_tg_s_vss_vss_vss_link_vss_link_bridge_vss_link_dip_vss_link_m1_vss_x1_vss_x2_vss_x3_t46 vss__t46 vss 132.112421684
* device instance g_vss_m1_inv_clk_vss_inv_mc_vss_inv_q_vss_mph_g_nand_m_vss_nand_s2_vss_s1_vss_m1_s2_vss_m1_s3_vss_m1_s4_vss_m1_sb_vss_sr1_vss_sr2_vss_sr3_vss_sr4_vss_sv_vss_tg_d_vss_tg_fbm_vss_tg_fbs_vss_tg_s_vss_vss_vss_link_vss_link_bridge_vss_link_dip_vss_link_m1_vss_x1_vss_x2_vss_x3_t47 r0 *1 0,0
Rg_vss_m1_inv_clk_vss_inv_mc_vss_inv_q_vss_mph_g_nand_m_vss_nand_s2_vss_s1_vss_m1_s2_vss_m1_s3_vss_m1_s4_vss_m1_sb_vss_sr1_vss_sr2_vss_sr3_vss_sr4_vss_sv_vss_tg_d_vss_tg_fbm_vss_tg_fbs_vss_tg_s_vss_vss_vss_link_vss_link_bridge_vss_link_dip_vss_link_m1_vss_x1_vss_x2_vss_x3_t47 vss__t47 vss 256.414180866
* device instance g_vss_m1_inv_clk_vss_inv_mc_vss_inv_q_vss_mph_g_nand_m_vss_nand_s2_vss_s1_vss_m1_s2_vss_m1_s3_vss_m1_s4_vss_m1_sb_vss_sr1_vss_sr2_vss_sr3_vss_sr4_vss_sv_vss_tg_d_vss_tg_fbm_vss_tg_fbs_vss_tg_s_vss_vss_vss_link_vss_link_bridge_vss_link_dip_vss_link_m1_vss_x1_vss_x2_vss_x3_t48 r0 *1 0,0
Rg_vss_m1_inv_clk_vss_inv_mc_vss_inv_q_vss_mph_g_nand_m_vss_nand_s2_vss_s1_vss_m1_s2_vss_m1_s3_vss_m1_s4_vss_m1_sb_vss_sr1_vss_sr2_vss_sr3_vss_sr4_vss_sv_vss_tg_d_vss_tg_fbm_vss_tg_fbs_vss_tg_s_vss_vss_vss_link_vss_link_bridge_vss_link_dip_vss_link_m1_vss_x1_vss_x2_vss_x3_t48 vss__t48 vss 534.534407231
* device instance g_vss_m1_inv_clk_vss_inv_mc_vss_inv_q_vss_mph_g_nand_m_vss_nand_s2_vss_s1_vss_m1_s2_vss_m1_s3_vss_m1_s4_vss_m1_sb_vss_sr1_vss_sr2_vss_sr3_vss_sr4_vss_sv_vss_tg_d_vss_tg_fbm_vss_tg_fbs_vss_tg_s_vss_vss_vss_link_vss_link_bridge_vss_link_dip_vss_link_m1_vss_x1_vss_x2_vss_x3_t49 r0 *1 0,0
Rg_vss_m1_inv_clk_vss_inv_mc_vss_inv_q_vss_mph_g_nand_m_vss_nand_s2_vss_s1_vss_m1_s2_vss_m1_s3_vss_m1_s4_vss_m1_sb_vss_sr1_vss_sr2_vss_sr3_vss_sr4_vss_sv_vss_tg_d_vss_tg_fbm_vss_tg_fbs_vss_tg_s_vss_vss_vss_link_vss_link_bridge_vss_link_dip_vss_link_m1_vss_x1_vss_x2_vss_x3_t49 vss__t49 vss 381.078358966
* device instance g_vss_m1_inv_clk_vss_inv_mc_vss_inv_q_vss_mph_g_nand_m_vss_nand_s2_vss_s1_vss_m1_s2_vss_m1_s3_vss_m1_s4_vss_m1_sb_vss_sr1_vss_sr2_vss_sr3_vss_sr4_vss_sv_vss_tg_d_vss_tg_fbm_vss_tg_fbs_vss_tg_s_vss_vss_vss_link_vss_link_bridge_vss_link_dip_vss_link_m1_vss_x1_vss_x2_vss_x3_t50 r0 *1 0,0
Rg_vss_m1_inv_clk_vss_inv_mc_vss_inv_q_vss_mph_g_nand_m_vss_nand_s2_vss_s1_vss_m1_s2_vss_m1_s3_vss_m1_s4_vss_m1_sb_vss_sr1_vss_sr2_vss_sr3_vss_sr4_vss_sv_vss_tg_d_vss_tg_fbm_vss_tg_fbs_vss_tg_s_vss_vss_vss_link_vss_link_bridge_vss_link_dip_vss_link_m1_vss_x1_vss_x2_vss_x3_t50 vss__t50 vss 435.22277849
* device instance g_vss_m1_inv_clk_vss_inv_mc_vss_inv_q_vss_mph_g_nand_m_vss_nand_s2_vss_s1_vss_m1_s2_vss_m1_s3_vss_m1_s4_vss_m1_sb_vss_sr1_vss_sr2_vss_sr3_vss_sr4_vss_sv_vss_tg_d_vss_tg_fbm_vss_tg_fbs_vss_tg_s_vss_vss_vss_link_vss_link_bridge_vss_link_dip_vss_link_m1_vss_x1_vss_x2_vss_x3_t51 r0 *1 0,0
Rg_vss_m1_inv_clk_vss_inv_mc_vss_inv_q_vss_mph_g_nand_m_vss_nand_s2_vss_s1_vss_m1_s2_vss_m1_s3_vss_m1_s4_vss_m1_sb_vss_sr1_vss_sr2_vss_sr3_vss_sr4_vss_sv_vss_tg_d_vss_tg_fbm_vss_tg_fbs_vss_tg_s_vss_vss_vss_link_vss_link_bridge_vss_link_dip_vss_link_m1_vss_x1_vss_x2_vss_x3_t51 vss__t51 vss 488.41640214
* device instance g_vss_m1_inv_clk_vss_inv_mc_vss_inv_q_vss_mph_g_nand_m_vss_nand_s2_vss_s1_vss_m1_s2_vss_m1_s3_vss_m1_s4_vss_m1_sb_vss_sr1_vss_sr2_vss_sr3_vss_sr4_vss_sv_vss_tg_d_vss_tg_fbm_vss_tg_fbs_vss_tg_s_vss_vss_vss_link_vss_link_bridge_vss_link_dip_vss_link_m1_vss_x1_vss_x2_vss_x3_t52 r0 *1 0,0
Rg_vss_m1_inv_clk_vss_inv_mc_vss_inv_q_vss_mph_g_nand_m_vss_nand_s2_vss_s1_vss_m1_s2_vss_m1_s3_vss_m1_s4_vss_m1_sb_vss_sr1_vss_sr2_vss_sr3_vss_sr4_vss_sv_vss_tg_d_vss_tg_fbm_vss_tg_fbs_vss_tg_s_vss_vss_vss_link_vss_link_bridge_vss_link_dip_vss_link_m1_vss_x1_vss_x2_vss_x3_t52 vss__t52 vss 287.813421287
* device instance g_vss_m1_inv_clk_vss_inv_mc_vss_inv_q_vss_mph_g_nand_m_vss_nand_s2_vss_s1_vss_m1_s2_vss_m1_s3_vss_m1_s4_vss_m1_sb_vss_sr1_vss_sr2_vss_sr3_vss_sr4_vss_sv_vss_tg_d_vss_tg_fbm_vss_tg_fbs_vss_tg_s_vss_vss_vss_link_vss_link_bridge_vss_link_dip_vss_link_m1_vss_x1_vss_x2_vss_x3_t53 r0 *1 0,0
Rg_vss_m1_inv_clk_vss_inv_mc_vss_inv_q_vss_mph_g_nand_m_vss_nand_s2_vss_s1_vss_m1_s2_vss_m1_s3_vss_m1_s4_vss_m1_sb_vss_sr1_vss_sr2_vss_sr3_vss_sr4_vss_sv_vss_tg_d_vss_tg_fbm_vss_tg_fbs_vss_tg_s_vss_vss_vss_link_vss_link_bridge_vss_link_dip_vss_link_m1_vss_x1_vss_x2_vss_x3_t53 vss__t53 vss 242.166096824
* device instance g_vss_m1_inv_clk_vss_inv_mc_vss_inv_q_vss_mph_g_nand_m_vss_nand_s2_vss_s1_vss_m1_s2_vss_m1_s3_vss_m1_s4_vss_m1_sb_vss_sr1_vss_sr2_vss_sr3_vss_sr4_vss_sv_vss_tg_d_vss_tg_fbm_vss_tg_fbs_vss_tg_s_vss_vss_vss_link_vss_link_bridge_vss_link_dip_vss_link_m1_vss_x1_vss_x2_vss_x3_t54 r0 *1 0,0
Rg_vss_m1_inv_clk_vss_inv_mc_vss_inv_q_vss_mph_g_nand_m_vss_nand_s2_vss_s1_vss_m1_s2_vss_m1_s3_vss_m1_s4_vss_m1_sb_vss_sr1_vss_sr2_vss_sr3_vss_sr4_vss_sv_vss_tg_d_vss_tg_fbm_vss_tg_fbs_vss_tg_s_vss_vss_vss_link_vss_link_bridge_vss_link_dip_vss_link_m1_vss_x1_vss_x2_vss_x3_t54 vss__t54 vss 188.860014474
* device instance g_vss_m1_inv_clk_vss_inv_mc_vss_inv_q_vss_mph_g_nand_m_vss_nand_s2_vss_s1_vss_m1_s2_vss_m1_s3_vss_m1_s4_vss_m1_sb_vss_sr1_vss_sr2_vss_sr3_vss_sr4_vss_sv_vss_tg_d_vss_tg_fbm_vss_tg_fbs_vss_tg_s_vss_vss_vss_link_vss_link_bridge_vss_link_dip_vss_link_m1_vss_x1_vss_x2_vss_x3_t55 r0 *1 0,0
Rg_vss_m1_inv_clk_vss_inv_mc_vss_inv_q_vss_mph_g_nand_m_vss_nand_s2_vss_s1_vss_m1_s2_vss_m1_s3_vss_m1_s4_vss_m1_sb_vss_sr1_vss_sr2_vss_sr3_vss_sr4_vss_sv_vss_tg_d_vss_tg_fbm_vss_tg_fbs_vss_tg_s_vss_vss_vss_link_vss_link_bridge_vss_link_dip_vss_link_m1_vss_x1_vss_x2_vss_x3_t55 vss__t55 vss 49.8746528061
* device instance g_vss_m1_inv_clk_vss_inv_mc_vss_inv_q_vss_mph_g_nand_m_vss_nand_s2_vss_s1_vss_m1_s2_vss_m1_s3_vss_m1_s4_vss_m1_sb_vss_sr1_vss_sr2_vss_sr3_vss_sr4_vss_sv_vss_tg_d_vss_tg_fbm_vss_tg_fbs_vss_tg_s_vss_vss_vss_link_vss_link_bridge_vss_link_dip_vss_link_m1_vss_x1_vss_x2_vss_x3_t56 r0 *1 0,0
Rg_vss_m1_inv_clk_vss_inv_mc_vss_inv_q_vss_mph_g_nand_m_vss_nand_s2_vss_s1_vss_m1_s2_vss_m1_s3_vss_m1_s4_vss_m1_sb_vss_sr1_vss_sr2_vss_sr3_vss_sr4_vss_sv_vss_tg_d_vss_tg_fbm_vss_tg_fbs_vss_tg_s_vss_vss_vss_link_vss_link_bridge_vss_link_dip_vss_link_m1_vss_x1_vss_x2_vss_x3_t56 vss__t56 vss 205.213370832
* device instance g_vss_m1_inv_clk_vss_inv_mc_vss_inv_q_vss_mph_g_nand_m_vss_nand_s2_vss_s1_vss_m1_s2_vss_m1_s3_vss_m1_s4_vss_m1_sb_vss_sr1_vss_sr2_vss_sr3_vss_sr4_vss_sv_vss_tg_d_vss_tg_fbm_vss_tg_fbs_vss_tg_s_vss_vss_vss_link_vss_link_bridge_vss_link_dip_vss_link_m1_vss_x1_vss_x2_vss_x3_t57 r0 *1 0,0
Rg_vss_m1_inv_clk_vss_inv_mc_vss_inv_q_vss_mph_g_nand_m_vss_nand_s2_vss_s1_vss_m1_s2_vss_m1_s3_vss_m1_s4_vss_m1_sb_vss_sr1_vss_sr2_vss_sr3_vss_sr4_vss_sv_vss_tg_d_vss_tg_fbm_vss_tg_fbs_vss_tg_s_vss_vss_vss_link_vss_link_bridge_vss_link_dip_vss_link_m1_vss_x1_vss_x2_vss_x3_t57 vss__t57 vss 82.7210555587
* device instance g_vss_m1_inv_clk_vss_inv_mc_vss_inv_q_vss_mph_g_nand_m_vss_nand_s2_vss_s1_vss_m1_s2_vss_m1_s3_vss_m1_s4_vss_m1_sb_vss_sr1_vss_sr2_vss_sr3_vss_sr4_vss_sv_vss_tg_d_vss_tg_fbm_vss_tg_fbs_vss_tg_s_vss_vss_vss_link_vss_link_bridge_vss_link_dip_vss_link_m1_vss_x1_vss_x2_vss_x3_t58 r0 *1 0,0
Rg_vss_m1_inv_clk_vss_inv_mc_vss_inv_q_vss_mph_g_nand_m_vss_nand_s2_vss_s1_vss_m1_s2_vss_m1_s3_vss_m1_s4_vss_m1_sb_vss_sr1_vss_sr2_vss_sr3_vss_sr4_vss_sv_vss_tg_d_vss_tg_fbm_vss_tg_fbs_vss_tg_s_vss_vss_vss_link_vss_link_bridge_vss_link_dip_vss_link_m1_vss_x1_vss_x2_vss_x3_t58 vss__t58 vss 137.439349262
* device instance g_vss_m1_inv_clk_vss_inv_mc_vss_inv_q_vss_mph_g_nand_m_vss_nand_s2_vss_s1_vss_m1_s2_vss_m1_s3_vss_m1_s4_vss_m1_sb_vss_sr1_vss_sr2_vss_sr3_vss_sr4_vss_sv_vss_tg_d_vss_tg_fbm_vss_tg_fbs_vss_tg_s_vss_vss_vss_link_vss_link_bridge_vss_link_dip_vss_link_m1_vss_x1_vss_x2_vss_x3_t59 r0 *1 0,0
Rg_vss_m1_inv_clk_vss_inv_mc_vss_inv_q_vss_mph_g_nand_m_vss_nand_s2_vss_s1_vss_m1_s2_vss_m1_s3_vss_m1_s4_vss_m1_sb_vss_sr1_vss_sr2_vss_sr3_vss_sr4_vss_sv_vss_tg_d_vss_tg_fbm_vss_tg_fbs_vss_tg_s_vss_vss_vss_link_vss_link_bridge_vss_link_dip_vss_link_m1_vss_x1_vss_x2_vss_x3_t59 vss__t59 vss 94.7161403067
* device instance g_vss_m1_inv_clk_vss_inv_mc_vss_inv_q_vss_mph_g_nand_m_vss_nand_s2_vss_s1_vss_m1_s2_vss_m1_s3_vss_m1_s4_vss_m1_sb_vss_sr1_vss_sr2_vss_sr3_vss_sr4_vss_sv_vss_tg_d_vss_tg_fbm_vss_tg_fbs_vss_tg_s_vss_vss_vss_link_vss_link_bridge_vss_link_dip_vss_link_m1_vss_x1_vss_x2_vss_x3_t60 r0 *1 0,0
Rg_vss_m1_inv_clk_vss_inv_mc_vss_inv_q_vss_mph_g_nand_m_vss_nand_s2_vss_s1_vss_m1_s2_vss_m1_s3_vss_m1_s4_vss_m1_sb_vss_sr1_vss_sr2_vss_sr3_vss_sr4_vss_sv_vss_tg_d_vss_tg_fbm_vss_tg_fbs_vss_tg_s_vss_vss_vss_link_vss_link_bridge_vss_link_dip_vss_link_m1_vss_x1_vss_x2_vss_x3_t60 vss__t60 vss 52.8057762744
* device instance g_vss_m1_inv_clk_vss_inv_mc_vss_inv_q_vss_mph_g_nand_m_vss_nand_s2_vss_s1_vss_m1_s2_vss_m1_s3_vss_m1_s4_vss_m1_sb_vss_sr1_vss_sr2_vss_sr3_vss_sr4_vss_sv_vss_tg_d_vss_tg_fbm_vss_tg_fbs_vss_tg_s_vss_vss_vss_link_vss_link_bridge_vss_link_dip_vss_link_m1_vss_x1_vss_x2_vss_x3_t61 r0 *1 0,0
Rg_vss_m1_inv_clk_vss_inv_mc_vss_inv_q_vss_mph_g_nand_m_vss_nand_s2_vss_s1_vss_m1_s2_vss_m1_s3_vss_m1_s4_vss_m1_sb_vss_sr1_vss_sr2_vss_sr3_vss_sr4_vss_sv_vss_tg_d_vss_tg_fbm_vss_tg_fbs_vss_tg_s_vss_vss_vss_link_vss_link_bridge_vss_link_dip_vss_link_m1_vss_x1_vss_x2_vss_x3_t61 vss__t61 vss 138.443030519
* device instance g_vss_m1_inv_clk_vss_inv_mc_vss_inv_q_vss_mph_g_nand_m_vss_nand_s2_vss_s1_vss_m1_s2_vss_m1_s3_vss_m1_s4_vss_m1_sb_vss_sr1_vss_sr2_vss_sr3_vss_sr4_vss_sv_vss_tg_d_vss_tg_fbm_vss_tg_fbs_vss_tg_s_vss_vss_vss_link_vss_link_bridge_vss_link_dip_vss_link_m1_vss_x1_vss_x2_vss_x3_t62 r0 *1 0,0
Rg_vss_m1_inv_clk_vss_inv_mc_vss_inv_q_vss_mph_g_nand_m_vss_nand_s2_vss_s1_vss_m1_s2_vss_m1_s3_vss_m1_s4_vss_m1_sb_vss_sr1_vss_sr2_vss_sr3_vss_sr4_vss_sv_vss_tg_d_vss_tg_fbm_vss_tg_fbs_vss_tg_s_vss_vss_vss_link_vss_link_bridge_vss_link_dip_vss_link_m1_vss_x1_vss_x2_vss_x3_t62 vss__t62 vss 337.361037403
* device instance g_vss_m1_inv_clk_vss_inv_mc_vss_inv_q_vss_mph_g_nand_m_vss_nand_s2_vss_s1_vss_m1_s2_vss_m1_s3_vss_m1_s4_vss_m1_sb_vss_sr1_vss_sr2_vss_sr3_vss_sr4_vss_sv_vss_tg_d_vss_tg_fbm_vss_tg_fbs_vss_tg_s_vss_vss_vss_link_vss_link_bridge_vss_link_dip_vss_link_m1_vss_x1_vss_x2_vss_x3_t63 r0 *1 0,0
Rg_vss_m1_inv_clk_vss_inv_mc_vss_inv_q_vss_mph_g_nand_m_vss_nand_s2_vss_s1_vss_m1_s2_vss_m1_s3_vss_m1_s4_vss_m1_sb_vss_sr1_vss_sr2_vss_sr3_vss_sr4_vss_sv_vss_tg_d_vss_tg_fbm_vss_tg_fbs_vss_tg_s_vss_vss_vss_link_vss_link_bridge_vss_link_dip_vss_link_m1_vss_x1_vss_x2_vss_x3_t63 vss__t63 vss 288.326263217
* device instance g_vss_m1_inv_clk_vss_inv_mc_vss_inv_q_vss_mph_g_nand_m_vss_nand_s2_vss_s1_vss_m1_s2_vss_m1_s3_vss_m1_s4_vss_m1_sb_vss_sr1_vss_sr2_vss_sr3_vss_sr4_vss_sv_vss_tg_d_vss_tg_fbm_vss_tg_fbs_vss_tg_s_vss_vss_vss_link_vss_link_bridge_vss_link_dip_vss_link_m1_vss_x1_vss_x2_vss_x3_t64 r0 *1 0,0
Rg_vss_m1_inv_clk_vss_inv_mc_vss_inv_q_vss_mph_g_nand_m_vss_nand_s2_vss_s1_vss_m1_s2_vss_m1_s3_vss_m1_s4_vss_m1_sb_vss_sr1_vss_sr2_vss_sr3_vss_sr4_vss_sv_vss_tg_d_vss_tg_fbm_vss_tg_fbs_vss_tg_s_vss_vss_vss_link_vss_link_bridge_vss_link_dip_vss_link_m1_vss_x1_vss_x2_vss_x3_t64 vss__t64 vss 259.440105674
* device instance g_vss_m1_inv_clk_vss_inv_mc_vss_inv_q_vss_mph_g_nand_m_vss_nand_s2_vss_s1_vss_m1_s2_vss_m1_s3_vss_m1_s4_vss_m1_sb_vss_sr1_vss_sr2_vss_sr3_vss_sr4_vss_sv_vss_tg_d_vss_tg_fbm_vss_tg_fbs_vss_tg_s_vss_vss_vss_link_vss_link_bridge_vss_link_dip_vss_link_m1_vss_x1_vss_x2_vss_x3_t65 r0 *1 0,0
Rg_vss_m1_inv_clk_vss_inv_mc_vss_inv_q_vss_mph_g_nand_m_vss_nand_s2_vss_s1_vss_m1_s2_vss_m1_s3_vss_m1_s4_vss_m1_sb_vss_sr1_vss_sr2_vss_sr3_vss_sr4_vss_sv_vss_tg_d_vss_tg_fbm_vss_tg_fbs_vss_tg_s_vss_vss_vss_link_vss_link_bridge_vss_link_dip_vss_link_m1_vss_x1_vss_x2_vss_x3_t65 vss__t65 vss 183.536990297
* device instance g_vss_m1_inv_clk_vss_inv_mc_vss_inv_q_vss_mph_g_nand_m_vss_nand_s2_vss_s1_vss_m1_s2_vss_m1_s3_vss_m1_s4_vss_m1_sb_vss_sr1_vss_sr2_vss_sr3_vss_sr4_vss_sv_vss_tg_d_vss_tg_fbm_vss_tg_fbs_vss_tg_s_vss_vss_vss_link_vss_link_bridge_vss_link_dip_vss_link_m1_vss_x1_vss_x2_vss_x3_t66 r0 *1 0,0
Rg_vss_m1_inv_clk_vss_inv_mc_vss_inv_q_vss_mph_g_nand_m_vss_nand_s2_vss_s1_vss_m1_s2_vss_m1_s3_vss_m1_s4_vss_m1_sb_vss_sr1_vss_sr2_vss_sr3_vss_sr4_vss_sv_vss_tg_d_vss_tg_fbm_vss_tg_fbs_vss_tg_s_vss_vss_vss_link_vss_link_bridge_vss_link_dip_vss_link_m1_vss_x1_vss_x2_vss_x3_t66 vss__t66 vss 104.583954862
* device instance g_vss_m1_inv_clk_vss_inv_mc_vss_inv_q_vss_mph_g_nand_m_vss_nand_s2_vss_s1_vss_m1_s2_vss_m1_s3_vss_m1_s4_vss_m1_sb_vss_sr1_vss_sr2_vss_sr3_vss_sr4_vss_sv_vss_tg_d_vss_tg_fbm_vss_tg_fbs_vss_tg_s_vss_vss_vss_link_vss_link_bridge_vss_link_dip_vss_link_m1_vss_x1_vss_x2_vss_x3_t67 r0 *1 0,0
Rg_vss_m1_inv_clk_vss_inv_mc_vss_inv_q_vss_mph_g_nand_m_vss_nand_s2_vss_s1_vss_m1_s2_vss_m1_s3_vss_m1_s4_vss_m1_sb_vss_sr1_vss_sr2_vss_sr3_vss_sr4_vss_sv_vss_tg_d_vss_tg_fbm_vss_tg_fbs_vss_tg_s_vss_vss_vss_link_vss_link_bridge_vss_link_dip_vss_link_m1_vss_x1_vss_x2_vss_x3_t67 vss__t67 vss 55.3103554581
* device instance g_vss_m1_inv_clk_vss_inv_mc_vss_inv_q_vss_mph_g_nand_m_vss_nand_s2_vss_s1_vss_m1_s2_vss_m1_s3_vss_m1_s4_vss_m1_sb_vss_sr1_vss_sr2_vss_sr3_vss_sr4_vss_sv_vss_tg_d_vss_tg_fbm_vss_tg_fbs_vss_tg_s_vss_vss_vss_link_vss_link_bridge_vss_link_dip_vss_link_m1_vss_x1_vss_x2_vss_x3_t68 r0 *1 0,0
Rg_vss_m1_inv_clk_vss_inv_mc_vss_inv_q_vss_mph_g_nand_m_vss_nand_s2_vss_s1_vss_m1_s2_vss_m1_s3_vss_m1_s4_vss_m1_sb_vss_sr1_vss_sr2_vss_sr3_vss_sr4_vss_sv_vss_tg_d_vss_tg_fbm_vss_tg_fbs_vss_tg_s_vss_vss_vss_link_vss_link_bridge_vss_link_dip_vss_link_m1_vss_x1_vss_x2_vss_x3_t68 vss__t68 vss 211.445675363
* device instance g_vss_m1_inv_clk_vss_inv_mc_vss_inv_q_vss_mph_g_nand_m_vss_nand_s2_vss_s1_vss_m1_s2_vss_m1_s3_vss_m1_s4_vss_m1_sb_vss_sr1_vss_sr2_vss_sr3_vss_sr4_vss_sv_vss_tg_d_vss_tg_fbm_vss_tg_fbs_vss_tg_s_vss_vss_vss_link_vss_link_bridge_vss_link_dip_vss_link_m1_vss_x1_vss_x2_vss_x3_t69 r0 *1 0,0
Rg_vss_m1_inv_clk_vss_inv_mc_vss_inv_q_vss_mph_g_nand_m_vss_nand_s2_vss_s1_vss_m1_s2_vss_m1_s3_vss_m1_s4_vss_m1_sb_vss_sr1_vss_sr2_vss_sr3_vss_sr4_vss_sv_vss_tg_d_vss_tg_fbm_vss_tg_fbs_vss_tg_s_vss_vss_vss_link_vss_link_bridge_vss_link_dip_vss_link_m1_vss_x1_vss_x2_vss_x3_t69 vss__t69 vss 150.530719956
* device instance g_vss_m1_inv_clk_vss_inv_mc_vss_inv_q_vss_mph_g_nand_m_vss_nand_s2_vss_s1_vss_m1_s2_vss_m1_s3_vss_m1_s4_vss_m1_sb_vss_sr1_vss_sr2_vss_sr3_vss_sr4_vss_sv_vss_tg_d_vss_tg_fbm_vss_tg_fbs_vss_tg_s_vss_vss_vss_link_vss_link_bridge_vss_link_dip_vss_link_m1_vss_x1_vss_x2_vss_x3_t70 r0 *1 0,0
Rg_vss_m1_inv_clk_vss_inv_mc_vss_inv_q_vss_mph_g_nand_m_vss_nand_s2_vss_s1_vss_m1_s2_vss_m1_s3_vss_m1_s4_vss_m1_sb_vss_sr1_vss_sr2_vss_sr3_vss_sr4_vss_sv_vss_tg_d_vss_tg_fbm_vss_tg_fbs_vss_tg_s_vss_vss_vss_link_vss_link_bridge_vss_link_dip_vss_link_m1_vss_x1_vss_x2_vss_x3_t70 vss__t70 vss 322.475355178
* device instance g_vss_m1_inv_clk_vss_inv_mc_vss_inv_q_vss_mph_g_nand_m_vss_nand_s2_vss_s1_vss_m1_s2_vss_m1_s3_vss_m1_s4_vss_m1_sb_vss_sr1_vss_sr2_vss_sr3_vss_sr4_vss_sv_vss_tg_d_vss_tg_fbm_vss_tg_fbs_vss_tg_s_vss_vss_vss_link_vss_link_bridge_vss_link_dip_vss_link_m1_vss_x1_vss_x2_vss_x3_t71 r0 *1 0,0
Rg_vss_m1_inv_clk_vss_inv_mc_vss_inv_q_vss_mph_g_nand_m_vss_nand_s2_vss_s1_vss_m1_s2_vss_m1_s3_vss_m1_s4_vss_m1_sb_vss_sr1_vss_sr2_vss_sr3_vss_sr4_vss_sv_vss_tg_d_vss_tg_fbm_vss_tg_fbs_vss_tg_s_vss_vss_vss_link_vss_link_bridge_vss_link_dip_vss_link_m1_vss_x1_vss_x2_vss_x3_t71 vss__t71 vss 303.498565649
* device instance g_vss_m1_inv_clk_vss_inv_mc_vss_inv_q_vss_mph_g_nand_m_vss_nand_s2_vss_s1_vss_m1_s2_vss_m1_s3_vss_m1_s4_vss_m1_sb_vss_sr1_vss_sr2_vss_sr3_vss_sr4_vss_sv_vss_tg_d_vss_tg_fbm_vss_tg_fbs_vss_tg_s_vss_vss_vss_link_vss_link_bridge_vss_link_dip_vss_link_m1_vss_x1_vss_x2_vss_x3_t72 r0 *1 0,0
Rg_vss_m1_inv_clk_vss_inv_mc_vss_inv_q_vss_mph_g_nand_m_vss_nand_s2_vss_s1_vss_m1_s2_vss_m1_s3_vss_m1_s4_vss_m1_sb_vss_sr1_vss_sr2_vss_sr3_vss_sr4_vss_sv_vss_tg_d_vss_tg_fbm_vss_tg_fbs_vss_tg_s_vss_vss_vss_link_vss_link_bridge_vss_link_dip_vss_link_m1_vss_x1_vss_x2_vss_x3_t72 vss__t72 vss 168.268008042
* device instance g_vss_m1_inv_clk_vss_inv_mc_vss_inv_q_vss_mph_g_nand_m_vss_nand_s2_vss_s1_vss_m1_s2_vss_m1_s3_vss_m1_s4_vss_m1_sb_vss_sr1_vss_sr2_vss_sr3_vss_sr4_vss_sv_vss_tg_d_vss_tg_fbm_vss_tg_fbs_vss_tg_s_vss_vss_vss_link_vss_link_bridge_vss_link_dip_vss_link_m1_vss_x1_vss_x2_vss_x3_t73 r0 *1 0,0
Rg_vss_m1_inv_clk_vss_inv_mc_vss_inv_q_vss_mph_g_nand_m_vss_nand_s2_vss_s1_vss_m1_s2_vss_m1_s3_vss_m1_s4_vss_m1_sb_vss_sr1_vss_sr2_vss_sr3_vss_sr4_vss_sv_vss_tg_d_vss_tg_fbm_vss_tg_fbs_vss_tg_s_vss_vss_vss_link_vss_link_bridge_vss_link_dip_vss_link_m1_vss_x1_vss_x2_vss_x3_t73 vss__t73 vss 225.711007155
* device instance g_vss_m1_inv_clk_vss_inv_mc_vss_inv_q_vss_mph_g_nand_m_vss_nand_s2_vss_s1_vss_m1_s2_vss_m1_s3_vss_m1_s4_vss_m1_sb_vss_sr1_vss_sr2_vss_sr3_vss_sr4_vss_sv_vss_tg_d_vss_tg_fbm_vss_tg_fbs_vss_tg_s_vss_vss_vss_link_vss_link_bridge_vss_link_dip_vss_link_m1_vss_x1_vss_x2_vss_x3_t74 r0 *1 0,0
Rg_vss_m1_inv_clk_vss_inv_mc_vss_inv_q_vss_mph_g_nand_m_vss_nand_s2_vss_s1_vss_m1_s2_vss_m1_s3_vss_m1_s4_vss_m1_sb_vss_sr1_vss_sr2_vss_sr3_vss_sr4_vss_sv_vss_tg_d_vss_tg_fbm_vss_tg_fbs_vss_tg_s_vss_vss_vss_link_vss_link_bridge_vss_link_dip_vss_link_m1_vss_x1_vss_x2_vss_x3_t74 vss__t74 vss 244.360919264
* device instance g_vss_m1_inv_clk_vss_inv_mc_vss_inv_q_vss_mph_g_nand_m_vss_nand_s2_vss_s1_vss_m1_s2_vss_m1_s3_vss_m1_s4_vss_m1_sb_vss_sr1_vss_sr2_vss_sr3_vss_sr4_vss_sv_vss_tg_d_vss_tg_fbm_vss_tg_fbs_vss_tg_s_vss_vss_vss_link_vss_link_bridge_vss_link_dip_vss_link_m1_vss_x1_vss_x2_vss_x3_t75 r0 *1 0,0
Rg_vss_m1_inv_clk_vss_inv_mc_vss_inv_q_vss_mph_g_nand_m_vss_nand_s2_vss_s1_vss_m1_s2_vss_m1_s3_vss_m1_s4_vss_m1_sb_vss_sr1_vss_sr2_vss_sr3_vss_sr4_vss_sv_vss_tg_d_vss_tg_fbm_vss_tg_fbs_vss_tg_s_vss_vss_vss_link_vss_link_bridge_vss_link_dip_vss_link_m1_vss_x1_vss_x2_vss_x3_t75 vss__t75 vss 247.335390253
* device instance g_vss_m1_inv_clk_vss_inv_mc_vss_inv_q_vss_mph_g_nand_m_vss_nand_s2_vss_s1_vss_m1_s2_vss_m1_s3_vss_m1_s4_vss_m1_sb_vss_sr1_vss_sr2_vss_sr3_vss_sr4_vss_sv_vss_tg_d_vss_tg_fbm_vss_tg_fbs_vss_tg_s_vss_vss_vss_link_vss_link_bridge_vss_link_dip_vss_link_m1_vss_x1_vss_x2_vss_x3_t76 r0 *1 0,0
Rg_vss_m1_inv_clk_vss_inv_mc_vss_inv_q_vss_mph_g_nand_m_vss_nand_s2_vss_s1_vss_m1_s2_vss_m1_s3_vss_m1_s4_vss_m1_sb_vss_sr1_vss_sr2_vss_sr3_vss_sr4_vss_sv_vss_tg_d_vss_tg_fbm_vss_tg_fbs_vss_tg_s_vss_vss_vss_link_vss_link_bridge_vss_link_dip_vss_link_m1_vss_x1_vss_x2_vss_x3_t76 vss__t76 vss 315.183708737
* device instance g_vss_m1_inv_clk_vss_inv_mc_vss_inv_q_vss_mph_g_nand_m_vss_nand_s2_vss_s1_vss_m1_s2_vss_m1_s3_vss_m1_s4_vss_m1_sb_vss_sr1_vss_sr2_vss_sr3_vss_sr4_vss_sv_vss_tg_d_vss_tg_fbm_vss_tg_fbs_vss_tg_s_vss_vss_vss_link_vss_link_bridge_vss_link_dip_vss_link_m1_vss_x1_vss_x2_vss_x3_t77 r0 *1 0,0
Rg_vss_m1_inv_clk_vss_inv_mc_vss_inv_q_vss_mph_g_nand_m_vss_nand_s2_vss_s1_vss_m1_s2_vss_m1_s3_vss_m1_s4_vss_m1_sb_vss_sr1_vss_sr2_vss_sr3_vss_sr4_vss_sv_vss_tg_d_vss_tg_fbm_vss_tg_fbs_vss_tg_s_vss_vss_vss_link_vss_link_bridge_vss_link_dip_vss_link_m1_vss_x1_vss_x2_vss_x3_t77 vss__t77 vss 400.016407853
* device instance g_vss_m1_inv_clk_vss_inv_mc_vss_inv_q_vss_mph_g_nand_m_vss_nand_s2_vss_s1_vss_m1_s2_vss_m1_s3_vss_m1_s4_vss_m1_sb_vss_sr1_vss_sr2_vss_sr3_vss_sr4_vss_sv_vss_tg_d_vss_tg_fbm_vss_tg_fbs_vss_tg_s_vss_vss_vss_link_vss_link_bridge_vss_link_dip_vss_link_m1_vss_x1_vss_x2_vss_x3_t78 r0 *1 0,0
Rg_vss_m1_inv_clk_vss_inv_mc_vss_inv_q_vss_mph_g_nand_m_vss_nand_s2_vss_s1_vss_m1_s2_vss_m1_s3_vss_m1_s4_vss_m1_sb_vss_sr1_vss_sr2_vss_sr3_vss_sr4_vss_sv_vss_tg_d_vss_tg_fbm_vss_tg_fbs_vss_tg_s_vss_vss_vss_link_vss_link_bridge_vss_link_dip_vss_link_m1_vss_x1_vss_x2_vss_x3_t78 vss__t78 vss 468.362378116
* device instance g_vss_m1_inv_clk_vss_inv_mc_vss_inv_q_vss_mph_g_nand_m_vss_nand_s2_vss_s1_vss_m1_s2_vss_m1_s3_vss_m1_s4_vss_m1_sb_vss_sr1_vss_sr2_vss_sr3_vss_sr4_vss_sv_vss_tg_d_vss_tg_fbm_vss_tg_fbs_vss_tg_s_vss_vss_vss_link_vss_link_bridge_vss_link_dip_vss_link_m1_vss_x1_vss_x2_vss_x3_t79 r0 *1 0,0
Rg_vss_m1_inv_clk_vss_inv_mc_vss_inv_q_vss_mph_g_nand_m_vss_nand_s2_vss_s1_vss_m1_s2_vss_m1_s3_vss_m1_s4_vss_m1_sb_vss_sr1_vss_sr2_vss_sr3_vss_sr4_vss_sv_vss_tg_d_vss_tg_fbm_vss_tg_fbs_vss_tg_s_vss_vss_vss_link_vss_link_bridge_vss_link_dip_vss_link_m1_vss_x1_vss_x2_vss_x3_t79 vss__t79 vss 553.530807494
* device instance g_vss_m1_inv_clk_vss_inv_mc_vss_inv_q_vss_mph_g_nand_m_vss_nand_s2_vss_s1_vss_m1_s2_vss_m1_s3_vss_m1_s4_vss_m1_sb_vss_sr1_vss_sr2_vss_sr3_vss_sr4_vss_sv_vss_tg_d_vss_tg_fbm_vss_tg_fbs_vss_tg_s_vss_vss_vss_link_vss_link_bridge_vss_link_dip_vss_link_m1_vss_x1_vss_x2_vss_x3_t80 r0 *1 0,0
Rg_vss_m1_inv_clk_vss_inv_mc_vss_inv_q_vss_mph_g_nand_m_vss_nand_s2_vss_s1_vss_m1_s2_vss_m1_s3_vss_m1_s4_vss_m1_sb_vss_sr1_vss_sr2_vss_sr3_vss_sr4_vss_sv_vss_tg_d_vss_tg_fbm_vss_tg_fbs_vss_tg_s_vss_vss_vss_link_vss_link_bridge_vss_link_dip_vss_link_m1_vss_x1_vss_x2_vss_x3_t80 vss__t80 vss 163.899726315
* device instance g_vss_m1_inv_clk_vss_inv_mc_vss_inv_q_vss_mph_g_nand_m_vss_nand_s2_vss_s1_vss_m1_s2_vss_m1_s3_vss_m1_s4_vss_m1_sb_vss_sr1_vss_sr2_vss_sr3_vss_sr4_vss_sv_vss_tg_d_vss_tg_fbm_vss_tg_fbs_vss_tg_s_vss_vss_vss_link_vss_link_bridge_vss_link_dip_vss_link_m1_vss_x1_vss_x2_vss_x3_t81 r0 *1 0,0
Rg_vss_m1_inv_clk_vss_inv_mc_vss_inv_q_vss_mph_g_nand_m_vss_nand_s2_vss_s1_vss_m1_s2_vss_m1_s3_vss_m1_s4_vss_m1_sb_vss_sr1_vss_sr2_vss_sr3_vss_sr4_vss_sv_vss_tg_d_vss_tg_fbm_vss_tg_fbs_vss_tg_s_vss_vss_vss_link_vss_link_bridge_vss_link_dip_vss_link_m1_vss_x1_vss_x2_vss_x3_t81 vss__t81 vss 99.4050351164
* device instance g_vss_m1_inv_clk_vss_inv_mc_vss_inv_q_vss_mph_g_nand_m_vss_nand_s2_vss_s1_vss_m1_s2_vss_m1_s3_vss_m1_s4_vss_m1_sb_vss_sr1_vss_sr2_vss_sr3_vss_sr4_vss_sv_vss_tg_d_vss_tg_fbm_vss_tg_fbs_vss_tg_s_vss_vss_vss_link_vss_link_bridge_vss_link_dip_vss_link_m1_vss_x1_vss_x2_vss_x3_t82 r0 *1 0,0
Rg_vss_m1_inv_clk_vss_inv_mc_vss_inv_q_vss_mph_g_nand_m_vss_nand_s2_vss_s1_vss_m1_s2_vss_m1_s3_vss_m1_s4_vss_m1_sb_vss_sr1_vss_sr2_vss_sr3_vss_sr4_vss_sv_vss_tg_d_vss_tg_fbm_vss_tg_fbs_vss_tg_s_vss_vss_vss_link_vss_link_bridge_vss_link_dip_vss_link_m1_vss_x1_vss_x2_vss_x3_t82 vss__t82 vss 43.9359458016
* device instance g_vss_m1_inv_clk_vss_inv_mc_vss_inv_q_vss_mph_g_nand_m_vss_nand_s2_vss_s1_vss_m1_s2_vss_m1_s3_vss_m1_s4_vss_m1_sb_vss_sr1_vss_sr2_vss_sr3_vss_sr4_vss_sv_vss_tg_d_vss_tg_fbm_vss_tg_fbs_vss_tg_s_vss_vss_vss_link_vss_link_bridge_vss_link_dip_vss_link_m1_vss_x1_vss_x2_vss_x3_t83 r0 *1 0,0
Rg_vss_m1_inv_clk_vss_inv_mc_vss_inv_q_vss_mph_g_nand_m_vss_nand_s2_vss_s1_vss_m1_s2_vss_m1_s3_vss_m1_s4_vss_m1_sb_vss_sr1_vss_sr2_vss_sr3_vss_sr4_vss_sv_vss_tg_d_vss_tg_fbm_vss_tg_fbs_vss_tg_s_vss_vss_vss_link_vss_link_bridge_vss_link_dip_vss_link_m1_vss_x1_vss_x2_vss_x3_t83 vss__t83 vss 78.3123474019
* device instance g_vss_m1_inv_clk_vss_inv_mc_vss_inv_q_vss_mph_g_nand_m_vss_nand_s2_vss_s1_vss_m1_s2_vss_m1_s3_vss_m1_s4_vss_m1_sb_vss_sr1_vss_sr2_vss_sr3_vss_sr4_vss_sv_vss_tg_d_vss_tg_fbm_vss_tg_fbs_vss_tg_s_vss_vss_vss_link_vss_link_bridge_vss_link_dip_vss_link_m1_vss_x1_vss_x2_vss_x3_t84 r0 *1 0,0
Rg_vss_m1_inv_clk_vss_inv_mc_vss_inv_q_vss_mph_g_nand_m_vss_nand_s2_vss_s1_vss_m1_s2_vss_m1_s3_vss_m1_s4_vss_m1_sb_vss_sr1_vss_sr2_vss_sr3_vss_sr4_vss_sv_vss_tg_d_vss_tg_fbm_vss_tg_fbs_vss_tg_s_vss_vss_vss_link_vss_link_bridge_vss_link_dip_vss_link_m1_vss_x1_vss_x2_vss_x3_t84 vss__t84 vss 223.448391176
* device instance g_vss_m1_inv_clk_vss_inv_mc_vss_inv_q_vss_mph_g_nand_m_vss_nand_s2_vss_s1_vss_m1_s2_vss_m1_s3_vss_m1_s4_vss_m1_sb_vss_sr1_vss_sr2_vss_sr3_vss_sr4_vss_sv_vss_tg_d_vss_tg_fbm_vss_tg_fbs_vss_tg_s_vss_vss_vss_link_vss_link_bridge_vss_link_dip_vss_link_m1_vss_x1_vss_x2_vss_x3_t85 r0 *1 0,0
Rg_vss_m1_inv_clk_vss_inv_mc_vss_inv_q_vss_mph_g_nand_m_vss_nand_s2_vss_s1_vss_m1_s2_vss_m1_s3_vss_m1_s4_vss_m1_sb_vss_sr1_vss_sr2_vss_sr3_vss_sr4_vss_sv_vss_tg_d_vss_tg_fbm_vss_tg_fbs_vss_tg_s_vss_vss_vss_link_vss_link_bridge_vss_link_dip_vss_link_m1_vss_x1_vss_x2_vss_x3_t85 vss__t85 vss 156.660497239
* device instance g_vss_m1_inv_clk_vss_inv_mc_vss_inv_q_vss_mph_g_nand_m_vss_nand_s2_vss_s1_vss_m1_s2_vss_m1_s3_vss_m1_s4_vss_m1_sb_vss_sr1_vss_sr2_vss_sr3_vss_sr4_vss_sv_vss_tg_d_vss_tg_fbm_vss_tg_fbs_vss_tg_s_vss_vss_vss_link_vss_link_bridge_vss_link_dip_vss_link_m1_vss_x1_vss_x2_vss_x3_t86 r0 *1 0,0
Rg_vss_m1_inv_clk_vss_inv_mc_vss_inv_q_vss_mph_g_nand_m_vss_nand_s2_vss_s1_vss_m1_s2_vss_m1_s3_vss_m1_s4_vss_m1_sb_vss_sr1_vss_sr2_vss_sr3_vss_sr4_vss_sv_vss_tg_d_vss_tg_fbm_vss_tg_fbs_vss_tg_s_vss_vss_vss_link_vss_link_bridge_vss_link_dip_vss_link_m1_vss_x1_vss_x2_vss_x3_t86 vss__t86 vss 307.732923931
* device instance g_vss_m1_inv_clk_vss_inv_mc_vss_inv_q_vss_mph_g_nand_m_vss_nand_s2_vss_s1_vss_m1_s2_vss_m1_s3_vss_m1_s4_vss_m1_sb_vss_sr1_vss_sr2_vss_sr3_vss_sr4_vss_sv_vss_tg_d_vss_tg_fbm_vss_tg_fbs_vss_tg_s_vss_vss_vss_link_vss_link_bridge_vss_link_dip_vss_link_m1_vss_x1_vss_x2_vss_x3_t87 r0 *1 0,0
Rg_vss_m1_inv_clk_vss_inv_mc_vss_inv_q_vss_mph_g_nand_m_vss_nand_s2_vss_s1_vss_m1_s2_vss_m1_s3_vss_m1_s4_vss_m1_sb_vss_sr1_vss_sr2_vss_sr3_vss_sr4_vss_sv_vss_tg_d_vss_tg_fbm_vss_tg_fbs_vss_tg_s_vss_vss_vss_link_vss_link_bridge_vss_link_dip_vss_link_m1_vss_x1_vss_x2_vss_x3_t87 vss__t87 vss 223.448391176
* device instance g_vss_m1_inv_clk_vss_inv_mc_vss_inv_q_vss_mph_g_nand_m_vss_nand_s2_vss_s1_vss_m1_s2_vss_m1_s3_vss_m1_s4_vss_m1_sb_vss_sr1_vss_sr2_vss_sr3_vss_sr4_vss_sv_vss_tg_d_vss_tg_fbm_vss_tg_fbs_vss_tg_s_vss_vss_vss_link_vss_link_bridge_vss_link_dip_vss_link_m1_vss_x1_vss_x2_vss_x3_t88 r0 *1 0,0
Rg_vss_m1_inv_clk_vss_inv_mc_vss_inv_q_vss_mph_g_nand_m_vss_nand_s2_vss_s1_vss_m1_s2_vss_m1_s3_vss_m1_s4_vss_m1_sb_vss_sr1_vss_sr2_vss_sr3_vss_sr4_vss_sv_vss_tg_d_vss_tg_fbm_vss_tg_fbs_vss_tg_s_vss_vss_vss_link_vss_link_bridge_vss_link_dip_vss_link_m1_vss_x1_vss_x2_vss_x3_t88 vss__t88 vss 156.660497239
* device instance g_vss_m1_inv_clk_vss_inv_mc_vss_inv_q_vss_mph_g_nand_m_vss_nand_s2_vss_s1_vss_m1_s2_vss_m1_s3_vss_m1_s4_vss_m1_sb_vss_sr1_vss_sr2_vss_sr3_vss_sr4_vss_sv_vss_tg_d_vss_tg_fbm_vss_tg_fbs_vss_tg_s_vss_vss_vss_link_vss_link_bridge_vss_link_dip_vss_link_m1_vss_x1_vss_x2_vss_x3_t89 r0 *1 0,0
Rg_vss_m1_inv_clk_vss_inv_mc_vss_inv_q_vss_mph_g_nand_m_vss_nand_s2_vss_s1_vss_m1_s2_vss_m1_s3_vss_m1_s4_vss_m1_sb_vss_sr1_vss_sr2_vss_sr3_vss_sr4_vss_sv_vss_tg_d_vss_tg_fbm_vss_tg_fbs_vss_tg_s_vss_vss_vss_link_vss_link_bridge_vss_link_dip_vss_link_m1_vss_x1_vss_x2_vss_x3_t89 vss__t89 vss 78.3123474019
* device instance g_vss_m1_inv_clk_vss_inv_mc_vss_inv_q_vss_mph_g_nand_m_vss_nand_s2_vss_s1_vss_m1_s2_vss_m1_s3_vss_m1_s4_vss_m1_sb_vss_sr1_vss_sr2_vss_sr3_vss_sr4_vss_sv_vss_tg_d_vss_tg_fbm_vss_tg_fbs_vss_tg_s_vss_vss_vss_link_vss_link_bridge_vss_link_dip_vss_link_m1_vss_x1_vss_x2_vss_x3_t90 r0 *1 0,0
Rg_vss_m1_inv_clk_vss_inv_mc_vss_inv_q_vss_mph_g_nand_m_vss_nand_s2_vss_s1_vss_m1_s2_vss_m1_s3_vss_m1_s4_vss_m1_sb_vss_sr1_vss_sr2_vss_sr3_vss_sr4_vss_sv_vss_tg_d_vss_tg_fbm_vss_tg_fbs_vss_tg_s_vss_vss_vss_link_vss_link_bridge_vss_link_dip_vss_link_m1_vss_x1_vss_x2_vss_x3_t90 vss__t90 vss 43.9359458016
* device instance g_vss_m1_inv_clk_vss_inv_mc_vss_inv_q_vss_mph_g_nand_m_vss_nand_s2_vss_s1_vss_m1_s2_vss_m1_s3_vss_m1_s4_vss_m1_sb_vss_sr1_vss_sr2_vss_sr3_vss_sr4_vss_sv_vss_tg_d_vss_tg_fbm_vss_tg_fbs_vss_tg_s_vss_vss_vss_link_vss_link_bridge_vss_link_dip_vss_link_m1_vss_x1_vss_x2_vss_x3_t91 r0 *1 0,0
Rg_vss_m1_inv_clk_vss_inv_mc_vss_inv_q_vss_mph_g_nand_m_vss_nand_s2_vss_s1_vss_m1_s2_vss_m1_s3_vss_m1_s4_vss_m1_sb_vss_sr1_vss_sr2_vss_sr3_vss_sr4_vss_sv_vss_tg_d_vss_tg_fbm_vss_tg_fbs_vss_tg_s_vss_vss_vss_link_vss_link_bridge_vss_link_dip_vss_link_m1_vss_x1_vss_x2_vss_x3_t91 vss__t91 vss 99.4050351164
* device instance g_vss_m1_inv_clk_vss_inv_mc_vss_inv_q_vss_mph_g_nand_m_vss_nand_s2_vss_s1_vss_m1_s2_vss_m1_s3_vss_m1_s4_vss_m1_sb_vss_sr1_vss_sr2_vss_sr3_vss_sr4_vss_sv_vss_tg_d_vss_tg_fbm_vss_tg_fbs_vss_tg_s_vss_vss_vss_link_vss_link_bridge_vss_link_dip_vss_link_m1_vss_x1_vss_x2_vss_x3_t92 r0 *1 0,0
Rg_vss_m1_inv_clk_vss_inv_mc_vss_inv_q_vss_mph_g_nand_m_vss_nand_s2_vss_s1_vss_m1_s2_vss_m1_s3_vss_m1_s4_vss_m1_sb_vss_sr1_vss_sr2_vss_sr3_vss_sr4_vss_sv_vss_tg_d_vss_tg_fbm_vss_tg_fbs_vss_tg_s_vss_vss_vss_link_vss_link_bridge_vss_link_dip_vss_link_m1_vss_x1_vss_x2_vss_x3_t92 vss__t92 vss 163.899726315
* device instance g_vss_m1_inv_clk_vss_inv_mc_vss_inv_q_vss_mph_g_nand_m_vss_nand_s2_vss_s1_vss_m1_s2_vss_m1_s3_vss_m1_s4_vss_m1_sb_vss_sr1_vss_sr2_vss_sr3_vss_sr4_vss_sv_vss_tg_d_vss_tg_fbm_vss_tg_fbs_vss_tg_s_vss_vss_vss_link_vss_link_bridge_vss_link_dip_vss_link_m1_vss_x1_vss_x2_vss_x3_t93 r0 *1 0,0
Rg_vss_m1_inv_clk_vss_inv_mc_vss_inv_q_vss_mph_g_nand_m_vss_nand_s2_vss_s1_vss_m1_s2_vss_m1_s3_vss_m1_s4_vss_m1_sb_vss_sr1_vss_sr2_vss_sr3_vss_sr4_vss_sv_vss_tg_d_vss_tg_fbm_vss_tg_fbs_vss_tg_s_vss_vss_vss_link_vss_link_bridge_vss_link_dip_vss_link_m1_vss_x1_vss_x2_vss_x3_t93 vss__t93 vss 247.335390253
* device instance g_vss_m1_inv_clk_vss_inv_mc_vss_inv_q_vss_mph_g_nand_m_vss_nand_s2_vss_s1_vss_m1_s2_vss_m1_s3_vss_m1_s4_vss_m1_sb_vss_sr1_vss_sr2_vss_sr3_vss_sr4_vss_sv_vss_tg_d_vss_tg_fbm_vss_tg_fbs_vss_tg_s_vss_vss_vss_link_vss_link_bridge_vss_link_dip_vss_link_m1_vss_x1_vss_x2_vss_x3_t94 r0 *1 0,0
Rg_vss_m1_inv_clk_vss_inv_mc_vss_inv_q_vss_mph_g_nand_m_vss_nand_s2_vss_s1_vss_m1_s2_vss_m1_s3_vss_m1_s4_vss_m1_sb_vss_sr1_vss_sr2_vss_sr3_vss_sr4_vss_sv_vss_tg_d_vss_tg_fbm_vss_tg_fbs_vss_tg_s_vss_vss_vss_link_vss_link_bridge_vss_link_dip_vss_link_m1_vss_x1_vss_x2_vss_x3_t94 vss__t94 vss 315.183708737
* device instance g_vss_m1_inv_clk_vss_inv_mc_vss_inv_q_vss_mph_g_nand_m_vss_nand_s2_vss_s1_vss_m1_s2_vss_m1_s3_vss_m1_s4_vss_m1_sb_vss_sr1_vss_sr2_vss_sr3_vss_sr4_vss_sv_vss_tg_d_vss_tg_fbm_vss_tg_fbs_vss_tg_s_vss_vss_vss_link_vss_link_bridge_vss_link_dip_vss_link_m1_vss_x1_vss_x2_vss_x3_t95 r0 *1 0,0
Rg_vss_m1_inv_clk_vss_inv_mc_vss_inv_q_vss_mph_g_nand_m_vss_nand_s2_vss_s1_vss_m1_s2_vss_m1_s3_vss_m1_s4_vss_m1_sb_vss_sr1_vss_sr2_vss_sr3_vss_sr4_vss_sv_vss_tg_d_vss_tg_fbm_vss_tg_fbs_vss_tg_s_vss_vss_vss_link_vss_link_bridge_vss_link_dip_vss_link_m1_vss_x1_vss_x2_vss_x3_t95 vss__t95 vss 400.016407853
* device instance g_vss_m1_inv_clk_vss_inv_mc_vss_inv_q_vss_mph_g_nand_m_vss_nand_s2_vss_s1_vss_m1_s2_vss_m1_s3_vss_m1_s4_vss_m1_sb_vss_sr1_vss_sr2_vss_sr3_vss_sr4_vss_sv_vss_tg_d_vss_tg_fbm_vss_tg_fbs_vss_tg_s_vss_vss_vss_link_vss_link_bridge_vss_link_dip_vss_link_m1_vss_x1_vss_x2_vss_x3_t96 r0 *1 0,0
Rg_vss_m1_inv_clk_vss_inv_mc_vss_inv_q_vss_mph_g_nand_m_vss_nand_s2_vss_s1_vss_m1_s2_vss_m1_s3_vss_m1_s4_vss_m1_sb_vss_sr1_vss_sr2_vss_sr3_vss_sr4_vss_sv_vss_tg_d_vss_tg_fbm_vss_tg_fbs_vss_tg_s_vss_vss_vss_link_vss_link_bridge_vss_link_dip_vss_link_m1_vss_x1_vss_x2_vss_x3_t96 vss__t96 vss 468.362378116
* device instance g_vss_m1_inv_clk_vss_inv_mc_vss_inv_q_vss_mph_g_nand_m_vss_nand_s2_vss_s1_vss_m1_s2_vss_m1_s3_vss_m1_s4_vss_m1_sb_vss_sr1_vss_sr2_vss_sr3_vss_sr4_vss_sv_vss_tg_d_vss_tg_fbm_vss_tg_fbs_vss_tg_s_vss_vss_vss_link_vss_link_bridge_vss_link_dip_vss_link_m1_vss_x1_vss_x2_vss_x3_t97 r0 *1 0,0
Rg_vss_m1_inv_clk_vss_inv_mc_vss_inv_q_vss_mph_g_nand_m_vss_nand_s2_vss_s1_vss_m1_s2_vss_m1_s3_vss_m1_s4_vss_m1_sb_vss_sr1_vss_sr2_vss_sr3_vss_sr4_vss_sv_vss_tg_d_vss_tg_fbm_vss_tg_fbs_vss_tg_s_vss_vss_vss_link_vss_link_bridge_vss_link_dip_vss_link_m1_vss_x1_vss_x2_vss_x3_t97 vss__t97 vss 553.530807494
* device instance g_vss_m1_inv_clk_vss_inv_mc_vss_inv_q_vss_mph_g_nand_m_vss_nand_s2_vss_s1_vss_m1_s2_vss_m1_s3_vss_m1_s4_vss_m1_sb_vss_sr1_vss_sr2_vss_sr3_vss_sr4_vss_sv_vss_tg_d_vss_tg_fbm_vss_tg_fbs_vss_tg_s_vss_vss_vss_link_vss_link_bridge_vss_link_dip_vss_link_m1_vss_x1_vss_x2_vss_x3_t98 r0 *1 0,0
Rg_vss_m1_inv_clk_vss_inv_mc_vss_inv_q_vss_mph_g_nand_m_vss_nand_s2_vss_s1_vss_m1_s2_vss_m1_s3_vss_m1_s4_vss_m1_sb_vss_sr1_vss_sr2_vss_sr3_vss_sr4_vss_sv_vss_tg_d_vss_tg_fbm_vss_tg_fbs_vss_tg_s_vss_vss_vss_link_vss_link_bridge_vss_link_dip_vss_link_m1_vss_x1_vss_x2_vss_x3_t98 vss__t98 vss 322.895708619
* device instance g_vss_m1_inv_clk_vss_inv_mc_vss_inv_q_vss_mph_g_nand_m_vss_nand_s2_vss_s1_vss_m1_s2_vss_m1_s3_vss_m1_s4_vss_m1_sb_vss_sr1_vss_sr2_vss_sr3_vss_sr4_vss_sv_vss_tg_d_vss_tg_fbm_vss_tg_fbs_vss_tg_s_vss_vss_vss_link_vss_link_bridge_vss_link_dip_vss_link_m1_vss_x1_vss_x2_vss_x3_t99 r0 *1 0,0
Rg_vss_m1_inv_clk_vss_inv_mc_vss_inv_q_vss_mph_g_nand_m_vss_nand_s2_vss_s1_vss_m1_s2_vss_m1_s3_vss_m1_s4_vss_m1_sb_vss_sr1_vss_sr2_vss_sr3_vss_sr4_vss_sv_vss_tg_d_vss_tg_fbm_vss_tg_fbs_vss_tg_s_vss_vss_vss_link_vss_link_bridge_vss_link_dip_vss_link_m1_vss_x1_vss_x2_vss_x3_t99 vss__t99 vss 170.367207688
* device instance g_vss_m1_inv_clk_vss_inv_mc_vss_inv_q_vss_mph_g_nand_m_vss_nand_s2_vss_s1_vss_m1_s2_vss_m1_s3_vss_m1_s4_vss_m1_sb_vss_sr1_vss_sr2_vss_sr3_vss_sr4_vss_sv_vss_tg_d_vss_tg_fbm_vss_tg_fbs_vss_tg_s_vss_vss_vss_link_vss_link_bridge_vss_link_dip_vss_link_m1_vss_x1_vss_x2_vss_x3_t100 r0 *1 0,0
Rg_vss_m1_inv_clk_vss_inv_mc_vss_inv_q_vss_mph_g_nand_m_vss_nand_s2_vss_s1_vss_m1_s2_vss_m1_s3_vss_m1_s4_vss_m1_sb_vss_sr1_vss_sr2_vss_sr3_vss_sr4_vss_sv_vss_tg_d_vss_tg_fbm_vss_tg_fbs_vss_tg_s_vss_vss_vss_link_vss_link_bridge_vss_link_dip_vss_link_m1_vss_x1_vss_x2_vss_x3_t100 vss__t100 vss 26.8364045034
* device instance g_vss_m1_inv_clk_vss_inv_mc_vss_inv_q_vss_mph_g_nand_m_vss_nand_s2_vss_s1_vss_m1_s2_vss_m1_s3_vss_m1_s4_vss_m1_sb_vss_sr1_vss_sr2_vss_sr3_vss_sr4_vss_sv_vss_tg_d_vss_tg_fbm_vss_tg_fbs_vss_tg_s_vss_vss_vss_link_vss_link_bridge_vss_link_dip_vss_link_m1_vss_x1_vss_x2_vss_x3_t101 r0 *1 0,0
Rg_vss_m1_inv_clk_vss_inv_mc_vss_inv_q_vss_mph_g_nand_m_vss_nand_s2_vss_s1_vss_m1_s2_vss_m1_s3_vss_m1_s4_vss_m1_sb_vss_sr1_vss_sr2_vss_sr3_vss_sr4_vss_sv_vss_tg_d_vss_tg_fbm_vss_tg_fbs_vss_tg_s_vss_vss_vss_link_vss_link_bridge_vss_link_dip_vss_link_m1_vss_x1_vss_x2_vss_x3_t101 vss__t101 vss 139.094428713
* device instance g_vss_m1_inv_clk_vss_inv_mc_vss_inv_q_vss_mph_g_nand_m_vss_nand_s2_vss_s1_vss_m1_s2_vss_m1_s3_vss_m1_s4_vss_m1_sb_vss_sr1_vss_sr2_vss_sr3_vss_sr4_vss_sv_vss_tg_d_vss_tg_fbm_vss_tg_fbs_vss_tg_s_vss_vss_vss_link_vss_link_bridge_vss_link_dip_vss_link_m1_vss_x1_vss_x2_vss_x3_t102 r0 *1 0,0
Rg_vss_m1_inv_clk_vss_inv_mc_vss_inv_q_vss_mph_g_nand_m_vss_nand_s2_vss_s1_vss_m1_s2_vss_m1_s3_vss_m1_s4_vss_m1_sb_vss_sr1_vss_sr2_vss_sr3_vss_sr4_vss_sv_vss_tg_d_vss_tg_fbm_vss_tg_fbs_vss_tg_s_vss_vss_vss_link_vss_link_bridge_vss_link_dip_vss_link_m1_vss_x1_vss_x2_vss_x3_t102 vss__t102 vss 324.294272449
* device instance g_vss_m1_inv_clk_vss_inv_mc_vss_inv_q_vss_mph_g_nand_m_vss_nand_s2_vss_s1_vss_m1_s2_vss_m1_s3_vss_m1_s4_vss_m1_sb_vss_sr1_vss_sr2_vss_sr3_vss_sr4_vss_sv_vss_tg_d_vss_tg_fbm_vss_tg_fbs_vss_tg_s_vss_vss_vss_link_vss_link_bridge_vss_link_dip_vss_link_m1_vss_x1_vss_x2_vss_x3_t103 r0 *1 0,0
Rg_vss_m1_inv_clk_vss_inv_mc_vss_inv_q_vss_mph_g_nand_m_vss_nand_s2_vss_s1_vss_m1_s2_vss_m1_s3_vss_m1_s4_vss_m1_sb_vss_sr1_vss_sr2_vss_sr3_vss_sr4_vss_sv_vss_tg_d_vss_tg_fbm_vss_tg_fbs_vss_tg_s_vss_vss_vss_link_vss_link_bridge_vss_link_dip_vss_link_m1_vss_x1_vss_x2_vss_x3_t103 vss__t103 vss 305.312664918
* device instance g_vss_m1_inv_clk_vss_inv_mc_vss_inv_q_vss_mph_g_nand_m_vss_nand_s2_vss_s1_vss_m1_s2_vss_m1_s3_vss_m1_s4_vss_m1_sb_vss_sr1_vss_sr2_vss_sr3_vss_sr4_vss_sv_vss_tg_d_vss_tg_fbm_vss_tg_fbs_vss_tg_s_vss_vss_vss_link_vss_link_bridge_vss_link_dip_vss_link_m1_vss_x1_vss_x2_vss_x3_t104 r0 *1 0,0
Rg_vss_m1_inv_clk_vss_inv_mc_vss_inv_q_vss_mph_g_nand_m_vss_nand_s2_vss_s1_vss_m1_s2_vss_m1_s3_vss_m1_s4_vss_m1_sb_vss_sr1_vss_sr2_vss_sr3_vss_sr4_vss_sv_vss_tg_d_vss_tg_fbm_vss_tg_fbs_vss_tg_s_vss_vss_vss_link_vss_link_bridge_vss_link_dip_vss_link_m1_vss_x1_vss_x2_vss_x3_t104 vss__t104 vss 246.15198492
* device instance g_vss_m1_inv_clk_vss_inv_mc_vss_inv_q_vss_mph_g_nand_m_vss_nand_s2_vss_s1_vss_m1_s2_vss_m1_s3_vss_m1_s4_vss_m1_sb_vss_sr1_vss_sr2_vss_sr3_vss_sr4_vss_sv_vss_tg_d_vss_tg_fbm_vss_tg_fbs_vss_tg_s_vss_vss_vss_link_vss_link_bridge_vss_link_dip_vss_link_m1_vss_x1_vss_x2_vss_x3_t105 r0 *1 0,0
Rg_vss_m1_inv_clk_vss_inv_mc_vss_inv_q_vss_mph_g_nand_m_vss_nand_s2_vss_s1_vss_m1_s2_vss_m1_s3_vss_m1_s4_vss_m1_sb_vss_sr1_vss_sr2_vss_sr3_vss_sr4_vss_sv_vss_tg_d_vss_tg_fbm_vss_tg_fbs_vss_tg_s_vss_vss_vss_link_vss_link_bridge_vss_link_dip_vss_link_m1_vss_x1_vss_x2_vss_x3_t105 vss__t105 vss 227.490709984
* device instance g_vss_m1_inv_clk_vss_inv_mc_vss_inv_q_vss_mph_g_nand_m_vss_nand_s2_vss_s1_vss_m1_s2_vss_m1_s3_vss_m1_s4_vss_m1_sb_vss_sr1_vss_sr2_vss_sr3_vss_sr4_vss_sv_vss_tg_d_vss_tg_fbm_vss_tg_fbs_vss_tg_s_vss_vss_vss_link_vss_link_bridge_vss_link_dip_vss_link_m1_vss_x1_vss_x2_vss_x3_t106 r0 *1 0,0
Rg_vss_m1_inv_clk_vss_inv_mc_vss_inv_q_vss_mph_g_nand_m_vss_nand_s2_vss_s1_vss_m1_s2_vss_m1_s3_vss_m1_s4_vss_m1_sb_vss_sr1_vss_sr2_vss_sr3_vss_sr4_vss_sv_vss_tg_d_vss_tg_fbm_vss_tg_fbs_vss_tg_s_vss_vss_vss_link_vss_link_bridge_vss_link_dip_vss_link_m1_vss_x1_vss_x2_vss_x3_t106 vss__t106 vss 169.9846573
* device instance g_vss_m1_inv_clk_vss_inv_mc_vss_inv_q_vss_mph_g_nand_m_vss_nand_s2_vss_s1_vss_m1_s2_vss_m1_s3_vss_m1_s4_vss_m1_sb_vss_sr1_vss_sr2_vss_sr3_vss_sr4_vss_sv_vss_tg_d_vss_tg_fbm_vss_tg_fbs_vss_tg_s_vss_vss_vss_link_vss_link_bridge_vss_link_dip_vss_link_m1_vss_x1_vss_x2_vss_x3_t107 r0 *1 0,0
Rg_vss_m1_inv_clk_vss_inv_mc_vss_inv_q_vss_mph_g_nand_m_vss_nand_s2_vss_s1_vss_m1_s2_vss_m1_s3_vss_m1_s4_vss_m1_sb_vss_sr1_vss_sr2_vss_sr3_vss_sr4_vss_sv_vss_tg_d_vss_tg_fbm_vss_tg_fbs_vss_tg_s_vss_vss_vss_link_vss_link_bridge_vss_link_dip_vss_link_m1_vss_x1_vss_x2_vss_x3_t107 vss__t107 vss 152.210979892
* device instance g_vss_m1_inv_clk_vss_inv_mc_vss_inv_q_vss_mph_g_nand_m_vss_nand_s2_vss_s1_vss_m1_s2_vss_m1_s3_vss_m1_s4_vss_m1_sb_vss_sr1_vss_sr2_vss_sr3_vss_sr4_vss_sv_vss_tg_d_vss_tg_fbm_vss_tg_fbs_vss_tg_s_vss_vss_vss_link_vss_link_bridge_vss_link_dip_vss_link_m1_vss_x1_vss_x2_vss_x3_t108 r0 *1 0,0
Rg_vss_m1_inv_clk_vss_inv_mc_vss_inv_q_vss_mph_g_nand_m_vss_nand_s2_vss_s1_vss_m1_s2_vss_m1_s3_vss_m1_s4_vss_m1_sb_vss_sr1_vss_sr2_vss_sr3_vss_sr4_vss_sv_vss_tg_d_vss_tg_fbm_vss_tg_fbs_vss_tg_s_vss_vss_vss_link_vss_link_bridge_vss_link_dip_vss_link_m1_vss_x1_vss_x2_vss_x3_t108 vss__t108 vss 305.895951366
* device instance g_vss_m1_inv_clk_vss_inv_mc_vss_inv_q_vss_mph_g_nand_m_vss_nand_s2_vss_s1_vss_m1_s2_vss_m1_s3_vss_m1_s4_vss_m1_sb_vss_sr1_vss_sr2_vss_sr3_vss_sr4_vss_sv_vss_tg_d_vss_tg_fbm_vss_tg_fbs_vss_tg_s_vss_vss_vss_link_vss_link_bridge_vss_link_dip_vss_link_m1_vss_x1_vss_x2_vss_x3_t109 r0 *1 0,0
Rg_vss_m1_inv_clk_vss_inv_mc_vss_inv_q_vss_mph_g_nand_m_vss_nand_s2_vss_s1_vss_m1_s2_vss_m1_s3_vss_m1_s4_vss_m1_sb_vss_sr1_vss_sr2_vss_sr3_vss_sr4_vss_sv_vss_tg_d_vss_tg_fbm_vss_tg_fbs_vss_tg_s_vss_vss_vss_link_vss_link_bridge_vss_link_dip_vss_link_m1_vss_x1_vss_x2_vss_x3_t109 vss__t109 vss 221.628692586
* device instance g_vss_m1_inv_clk_vss_inv_mc_vss_inv_q_vss_mph_g_nand_m_vss_nand_s2_vss_s1_vss_m1_s2_vss_m1_s3_vss_m1_s4_vss_m1_sb_vss_sr1_vss_sr2_vss_sr3_vss_sr4_vss_sv_vss_tg_d_vss_tg_fbm_vss_tg_fbs_vss_tg_s_vss_vss_vss_link_vss_link_bridge_vss_link_dip_vss_link_m1_vss_x1_vss_x2_vss_x3_t110 r0 *1 0,0
Rg_vss_m1_inv_clk_vss_inv_mc_vss_inv_q_vss_mph_g_nand_m_vss_nand_s2_vss_s1_vss_m1_s2_vss_m1_s3_vss_m1_s4_vss_m1_sb_vss_sr1_vss_sr2_vss_sr3_vss_sr4_vss_sv_vss_tg_d_vss_tg_fbm_vss_tg_fbs_vss_tg_s_vss_vss_vss_link_vss_link_bridge_vss_link_dip_vss_link_m1_vss_x1_vss_x2_vss_x3_t110 vss__t110 vss 154.879332032
* device instance g_vss_m1_inv_clk_vss_inv_mc_vss_inv_q_vss_mph_g_nand_m_vss_nand_s2_vss_s1_vss_m1_s2_vss_m1_s3_vss_m1_s4_vss_m1_sb_vss_sr1_vss_sr2_vss_sr3_vss_sr4_vss_sv_vss_tg_d_vss_tg_fbm_vss_tg_fbs_vss_tg_s_vss_vss_vss_link_vss_link_bridge_vss_link_dip_vss_link_m1_vss_x1_vss_x2_vss_x3_t111 r0 *1 0,0
Rg_vss_m1_inv_clk_vss_inv_mc_vss_inv_q_vss_mph_g_nand_m_vss_nand_s2_vss_s1_vss_m1_s2_vss_m1_s3_vss_m1_s4_vss_m1_sb_vss_sr1_vss_sr2_vss_sr3_vss_sr4_vss_sv_vss_tg_d_vss_tg_fbm_vss_tg_fbs_vss_tg_s_vss_vss_vss_link_vss_link_bridge_vss_link_dip_vss_link_m1_vss_x1_vss_x2_vss_x3_t111 vss__t111 vss 76.7804214546
* device instance g_vss_m1_inv_clk_vss_inv_mc_vss_inv_q_vss_mph_g_nand_m_vss_nand_s2_vss_s1_vss_m1_s2_vss_m1_s3_vss_m1_s4_vss_m1_sb_vss_sr1_vss_sr2_vss_sr3_vss_sr4_vss_sv_vss_tg_d_vss_tg_fbm_vss_tg_fbs_vss_tg_s_vss_vss_vss_link_vss_link_bridge_vss_link_dip_vss_link_m1_vss_x1_vss_x2_vss_x3_t112 r0 *1 0,0
Rg_vss_m1_inv_clk_vss_inv_mc_vss_inv_q_vss_mph_g_nand_m_vss_nand_s2_vss_s1_vss_m1_s2_vss_m1_s3_vss_m1_s4_vss_m1_sb_vss_sr1_vss_sr2_vss_sr3_vss_sr4_vss_sv_vss_tg_d_vss_tg_fbm_vss_tg_fbs_vss_tg_s_vss_vss_vss_link_vss_link_bridge_vss_link_dip_vss_link_m1_vss_x1_vss_x2_vss_x3_t112 vss__t112 vss 44.1336485437
* device instance g_vss_m1_inv_clk_vss_inv_mc_vss_inv_q_vss_mph_g_nand_m_vss_nand_s2_vss_s1_vss_m1_s2_vss_m1_s3_vss_m1_s4_vss_m1_sb_vss_sr1_vss_sr2_vss_sr3_vss_sr4_vss_sv_vss_tg_d_vss_tg_fbm_vss_tg_fbs_vss_tg_s_vss_vss_vss_link_vss_link_bridge_vss_link_dip_vss_link_m1_vss_x1_vss_x2_vss_x3_t113 r0 *1 0,0
Rg_vss_m1_inv_clk_vss_inv_mc_vss_inv_q_vss_mph_g_nand_m_vss_nand_s2_vss_s1_vss_m1_s2_vss_m1_s3_vss_m1_s4_vss_m1_sb_vss_sr1_vss_sr2_vss_sr3_vss_sr4_vss_sv_vss_tg_d_vss_tg_fbm_vss_tg_fbs_vss_tg_s_vss_vss_vss_link_vss_link_bridge_vss_link_dip_vss_link_m1_vss_x1_vss_x2_vss_x3_t113 vss__t113 vss 101.074654956
* device instance g_vss_m1_inv_clk_vss_inv_mc_vss_inv_q_vss_mph_g_nand_m_vss_nand_s2_vss_s1_vss_m1_s2_vss_m1_s3_vss_m1_s4_vss_m1_sb_vss_sr1_vss_sr2_vss_sr3_vss_sr4_vss_sv_vss_tg_d_vss_tg_fbm_vss_tg_fbs_vss_tg_s_vss_vss_vss_link_vss_link_bridge_vss_link_dip_vss_link_m1_vss_x1_vss_x2_vss_x3_t114 r0 *1 0,0
Rg_vss_m1_inv_clk_vss_inv_mc_vss_inv_q_vss_mph_g_nand_m_vss_nand_s2_vss_s1_vss_m1_s2_vss_m1_s3_vss_m1_s4_vss_m1_sb_vss_sr1_vss_sr2_vss_sr3_vss_sr4_vss_sv_vss_tg_d_vss_tg_fbm_vss_tg_fbs_vss_tg_s_vss_vss_vss_link_vss_link_bridge_vss_link_dip_vss_link_m1_vss_x1_vss_x2_vss_x3_t114 vss__t114 vss 165.689008058
* device instance g_vss_m1_inv_clk_vss_inv_mc_vss_inv_q_vss_mph_g_nand_m_vss_nand_s2_vss_s1_vss_m1_s2_vss_m1_s3_vss_m1_s4_vss_m1_sb_vss_sr1_vss_sr2_vss_sr3_vss_sr4_vss_sv_vss_tg_d_vss_tg_fbm_vss_tg_fbs_vss_tg_s_vss_vss_vss_link_vss_link_bridge_vss_link_dip_vss_link_m1_vss_x1_vss_x2_vss_x3_t115 r0 *1 0,0
Rg_vss_m1_inv_clk_vss_inv_mc_vss_inv_q_vss_mph_g_nand_m_vss_nand_s2_vss_s1_vss_m1_s2_vss_m1_s3_vss_m1_s4_vss_m1_sb_vss_sr1_vss_sr2_vss_sr3_vss_sr4_vss_sv_vss_tg_d_vss_tg_fbm_vss_tg_fbs_vss_tg_s_vss_vss_vss_link_vss_link_bridge_vss_link_dip_vss_link_m1_vss_x1_vss_x2_vss_x3_t115 vss__t115 vss 249.162267698
* device instance g_vss_m1_inv_clk_vss_inv_mc_vss_inv_q_vss_mph_g_nand_m_vss_nand_s2_vss_s1_vss_m1_s2_vss_m1_s3_vss_m1_s4_vss_m1_sb_vss_sr1_vss_sr2_vss_sr3_vss_sr4_vss_sv_vss_tg_d_vss_tg_fbm_vss_tg_fbs_vss_tg_s_vss_vss_vss_link_vss_link_bridge_vss_link_dip_vss_link_m1_vss_x1_vss_x2_vss_x3_t116 r0 *1 0,0
Rg_vss_m1_inv_clk_vss_inv_mc_vss_inv_q_vss_mph_g_nand_m_vss_nand_s2_vss_s1_vss_m1_s2_vss_m1_s3_vss_m1_s4_vss_m1_sb_vss_sr1_vss_sr2_vss_sr3_vss_sr4_vss_sv_vss_tg_d_vss_tg_fbm_vss_tg_fbs_vss_tg_s_vss_vss_vss_link_vss_link_bridge_vss_link_dip_vss_link_m1_vss_x1_vss_x2_vss_x3_t116 vss__t116 vss 317.021786101
* device instance g_vss_m1_inv_clk_vss_inv_mc_vss_inv_q_vss_mph_g_nand_m_vss_nand_s2_vss_s1_vss_m1_s2_vss_m1_s3_vss_m1_s4_vss_m1_sb_vss_sr1_vss_sr2_vss_sr3_vss_sr4_vss_sv_vss_tg_d_vss_tg_fbm_vss_tg_fbs_vss_tg_s_vss_vss_vss_link_vss_link_bridge_vss_link_dip_vss_link_m1_vss_x1_vss_x2_vss_x3_t117 r0 *1 0,0
Rg_vss_m1_inv_clk_vss_inv_mc_vss_inv_q_vss_mph_g_nand_m_vss_nand_s2_vss_s1_vss_m1_s2_vss_m1_s3_vss_m1_s4_vss_m1_sb_vss_sr1_vss_sr2_vss_sr3_vss_sr4_vss_sv_vss_tg_d_vss_tg_fbm_vss_tg_fbs_vss_tg_s_vss_vss_vss_link_vss_link_bridge_vss_link_dip_vss_link_m1_vss_x1_vss_x2_vss_x3_t117 vss__t117 vss 401.861272617
* device instance g_vss_m1_inv_clk_vss_inv_mc_vss_inv_q_vss_mph_g_nand_m_vss_nand_s2_vss_s1_vss_m1_s2_vss_m1_s3_vss_m1_s4_vss_m1_sb_vss_sr1_vss_sr2_vss_sr3_vss_sr4_vss_sv_vss_tg_d_vss_tg_fbm_vss_tg_fbs_vss_tg_s_vss_vss_vss_link_vss_link_bridge_vss_link_dip_vss_link_m1_vss_x1_vss_x2_vss_x3_t118 r0 *1 0,0
Rg_vss_m1_inv_clk_vss_inv_mc_vss_inv_q_vss_mph_g_nand_m_vss_nand_s2_vss_s1_vss_m1_s2_vss_m1_s3_vss_m1_s4_vss_m1_sb_vss_sr1_vss_sr2_vss_sr3_vss_sr4_vss_sv_vss_tg_d_vss_tg_fbm_vss_tg_fbs_vss_tg_s_vss_vss_vss_link_vss_link_bridge_vss_link_dip_vss_link_m1_vss_x1_vss_x2_vss_x3_t118 vss__t118 vss 470.2102459
* device instance g_vss_m1_inv_clk_vss_inv_mc_vss_inv_q_vss_mph_g_nand_m_vss_nand_s2_vss_s1_vss_m1_s2_vss_m1_s3_vss_m1_s4_vss_m1_sb_vss_sr1_vss_sr2_vss_sr3_vss_sr4_vss_sv_vss_tg_d_vss_tg_fbm_vss_tg_fbs_vss_tg_s_vss_vss_vss_link_vss_link_bridge_vss_link_dip_vss_link_m1_vss_x1_vss_x2_vss_x3_t119 r0 *1 0,0
Rg_vss_m1_inv_clk_vss_inv_mc_vss_inv_q_vss_mph_g_nand_m_vss_nand_s2_vss_s1_vss_m1_s2_vss_m1_s3_vss_m1_s4_vss_m1_sb_vss_sr1_vss_sr2_vss_sr3_vss_sr4_vss_sv_vss_tg_d_vss_tg_fbm_vss_tg_fbs_vss_tg_s_vss_vss_vss_link_vss_link_bridge_vss_link_dip_vss_link_m1_vss_x1_vss_x2_vss_x3_t119 vss__t119 vss 555.380973952
* device instance g_vss_m1_inv_clk_vss_inv_mc_vss_inv_q_vss_mph_g_nand_m_vss_nand_s2_vss_s1_vss_m1_s2_vss_m1_s3_vss_m1_s4_vss_m1_sb_vss_sr1_vss_sr2_vss_sr3_vss_sr4_vss_sv_vss_tg_d_vss_tg_fbm_vss_tg_fbs_vss_tg_s_vss_vss_vss_link_vss_link_bridge_vss_link_dip_vss_link_m1_vss_x1_vss_x2_vss_x3_t120 r0 *1 0,0
Rg_vss_m1_inv_clk_vss_inv_mc_vss_inv_q_vss_mph_g_nand_m_vss_nand_s2_vss_s1_vss_m1_s2_vss_m1_s3_vss_m1_s4_vss_m1_sb_vss_sr1_vss_sr2_vss_sr3_vss_sr4_vss_sv_vss_tg_d_vss_tg_fbm_vss_tg_fbs_vss_tg_s_vss_vss_vss_link_vss_link_bridge_vss_link_dip_vss_link_m1_vss_x1_vss_x2_vss_x3_t120 vss__t120 vss 321.043967623
* device instance g_vss_m1_inv_clk_vss_inv_mc_vss_inv_q_vss_mph_g_nand_m_vss_nand_s2_vss_s1_vss_m1_s2_vss_m1_s3_vss_m1_s4_vss_m1_sb_vss_sr1_vss_sr2_vss_sr3_vss_sr4_vss_sv_vss_tg_d_vss_tg_fbm_vss_tg_fbs_vss_tg_s_vss_vss_vss_link_vss_link_bridge_vss_link_dip_vss_link_m1_vss_x1_vss_x2_vss_x3_t121 r0 *1 0,0
Rg_vss_m1_inv_clk_vss_inv_mc_vss_inv_q_vss_mph_g_nand_m_vss_nand_s2_vss_s1_vss_m1_s2_vss_m1_s3_vss_m1_s4_vss_m1_sb_vss_sr1_vss_sr2_vss_sr3_vss_sr4_vss_sv_vss_tg_d_vss_tg_fbm_vss_tg_fbs_vss_tg_s_vss_vss_vss_link_vss_link_bridge_vss_link_dip_vss_link_m1_vss_x1_vss_x2_vss_x3_t121 vss__t121 vss 168.52652556
* device instance g_vss_m1_inv_clk_vss_inv_mc_vss_inv_q_vss_mph_g_nand_m_vss_nand_s2_vss_s1_vss_m1_s2_vss_m1_s3_vss_m1_s4_vss_m1_sb_vss_sr1_vss_sr2_vss_sr3_vss_sr4_vss_sv_vss_tg_d_vss_tg_fbm_vss_tg_fbs_vss_tg_s_vss_vss_vss_link_vss_link_bridge_vss_link_dip_vss_link_m1_vss_x1_vss_x2_vss_x3_t122 r0 *1 0,0
Rg_vss_m1_inv_clk_vss_inv_mc_vss_inv_q_vss_mph_g_nand_m_vss_nand_s2_vss_s1_vss_m1_s2_vss_m1_s3_vss_m1_s4_vss_m1_sb_vss_sr1_vss_sr2_vss_sr3_vss_sr4_vss_sv_vss_tg_d_vss_tg_fbm_vss_tg_fbs_vss_tg_s_vss_vss_vss_link_vss_link_bridge_vss_link_dip_vss_link_m1_vss_x1_vss_x2_vss_x3_t122 vss__t122 vss 25.7878038647
* device instance g_vss_m1_inv_clk_vss_inv_mc_vss_inv_q_vss_mph_g_nand_m_vss_nand_s2_vss_s1_vss_m1_s2_vss_m1_s3_vss_m1_s4_vss_m1_sb_vss_sr1_vss_sr2_vss_sr3_vss_sr4_vss_sv_vss_tg_d_vss_tg_fbm_vss_tg_fbs_vss_tg_s_vss_vss_vss_link_vss_link_bridge_vss_link_dip_vss_link_m1_vss_x1_vss_x2_vss_x3_t123 r0 *1 0,0
Rg_vss_m1_inv_clk_vss_inv_mc_vss_inv_q_vss_mph_g_nand_m_vss_nand_s2_vss_s1_vss_m1_s2_vss_m1_s3_vss_m1_s4_vss_m1_sb_vss_sr1_vss_sr2_vss_sr3_vss_sr4_vss_sv_vss_tg_d_vss_tg_fbm_vss_tg_fbs_vss_tg_s_vss_vss_vss_link_vss_link_bridge_vss_link_dip_vss_link_m1_vss_x1_vss_x2_vss_x3_t123 vss__t123 vss 140.927968055
* device instance g_vss_m1_inv_clk_vss_inv_mc_vss_inv_q_vss_mph_g_nand_m_vss_nand_s2_vss_s1_vss_m1_s2_vss_m1_s3_vss_m1_s4_vss_m1_sb_vss_sr1_vss_sr2_vss_sr3_vss_sr4_vss_sv_vss_tg_d_vss_tg_fbm_vss_tg_fbs_vss_tg_s_vss_vss_vss_link_vss_link_bridge_vss_link_dip_vss_link_m1_vss_x1_vss_x2_vss_x3_t124 r0 *1 0,0
Rg_vss_m1_inv_clk_vss_inv_mc_vss_inv_q_vss_mph_g_nand_m_vss_nand_s2_vss_s1_vss_m1_s2_vss_m1_s3_vss_m1_s4_vss_m1_sb_vss_sr1_vss_sr2_vss_sr3_vss_sr4_vss_sv_vss_tg_d_vss_tg_fbm_vss_tg_fbs_vss_tg_s_vss_vss_vss_link_vss_link_bridge_vss_link_dip_vss_link_m1_vss_x1_vss_x2_vss_x3_t124 vss__t124 vss 322.475355178
* device instance g_vss_m1_inv_clk_vss_inv_mc_vss_inv_q_vss_mph_g_nand_m_vss_nand_s2_vss_s1_vss_m1_s2_vss_m1_s3_vss_m1_s4_vss_m1_sb_vss_sr1_vss_sr2_vss_sr3_vss_sr4_vss_sv_vss_tg_d_vss_tg_fbm_vss_tg_fbs_vss_tg_s_vss_vss_vss_link_vss_link_bridge_vss_link_dip_vss_link_m1_vss_x1_vss_x2_vss_x3_t125 r0 *1 0,0
Rg_vss_m1_inv_clk_vss_inv_mc_vss_inv_q_vss_mph_g_nand_m_vss_nand_s2_vss_s1_vss_m1_s2_vss_m1_s3_vss_m1_s4_vss_m1_sb_vss_sr1_vss_sr2_vss_sr3_vss_sr4_vss_sv_vss_tg_d_vss_tg_fbm_vss_tg_fbs_vss_tg_s_vss_vss_vss_link_vss_link_bridge_vss_link_dip_vss_link_m1_vss_x1_vss_x2_vss_x3_t125 vss__t125 vss 303.498565649
* device instance g_vss_m1_inv_clk_vss_inv_mc_vss_inv_q_vss_mph_g_nand_m_vss_nand_s2_vss_s1_vss_m1_s2_vss_m1_s3_vss_m1_s4_vss_m1_sb_vss_sr1_vss_sr2_vss_sr3_vss_sr4_vss_sv_vss_tg_d_vss_tg_fbm_vss_tg_fbs_vss_tg_s_vss_vss_vss_link_vss_link_bridge_vss_link_dip_vss_link_m1_vss_x1_vss_x2_vss_x3_t126 r0 *1 0,0
Rg_vss_m1_inv_clk_vss_inv_mc_vss_inv_q_vss_mph_g_nand_m_vss_nand_s2_vss_s1_vss_m1_s2_vss_m1_s3_vss_m1_s4_vss_m1_sb_vss_sr1_vss_sr2_vss_sr3_vss_sr4_vss_sv_vss_tg_d_vss_tg_fbm_vss_tg_fbs_vss_tg_s_vss_vss_vss_link_vss_link_bridge_vss_link_dip_vss_link_m1_vss_x1_vss_x2_vss_x3_t126 vss__t126 vss 244.360919264
* device instance g_vss_m1_inv_clk_vss_inv_mc_vss_inv_q_vss_mph_g_nand_m_vss_nand_s2_vss_s1_vss_m1_s2_vss_m1_s3_vss_m1_s4_vss_m1_sb_vss_sr1_vss_sr2_vss_sr3_vss_sr4_vss_sv_vss_tg_d_vss_tg_fbm_vss_tg_fbs_vss_tg_s_vss_vss_vss_link_vss_link_bridge_vss_link_dip_vss_link_m1_vss_x1_vss_x2_vss_x3_t127 r0 *1 0,0
Rg_vss_m1_inv_clk_vss_inv_mc_vss_inv_q_vss_mph_g_nand_m_vss_nand_s2_vss_s1_vss_m1_s2_vss_m1_s3_vss_m1_s4_vss_m1_sb_vss_sr1_vss_sr2_vss_sr3_vss_sr4_vss_sv_vss_tg_d_vss_tg_fbm_vss_tg_fbs_vss_tg_s_vss_vss_vss_link_vss_link_bridge_vss_link_dip_vss_link_m1_vss_x1_vss_x2_vss_x3_t127 vss__t127 vss 225.711007155
* device instance g_vss_m1_inv_clk_vss_inv_mc_vss_inv_q_vss_mph_g_nand_m_vss_nand_s2_vss_s1_vss_m1_s2_vss_m1_s3_vss_m1_s4_vss_m1_sb_vss_sr1_vss_sr2_vss_sr3_vss_sr4_vss_sv_vss_tg_d_vss_tg_fbm_vss_tg_fbs_vss_tg_s_vss_vss_vss_link_vss_link_bridge_vss_link_dip_vss_link_m1_vss_x1_vss_x2_vss_x3_t128 r0 *1 0,0
Rg_vss_m1_inv_clk_vss_inv_mc_vss_inv_q_vss_mph_g_nand_m_vss_nand_s2_vss_s1_vss_m1_s2_vss_m1_s3_vss_m1_s4_vss_m1_sb_vss_sr1_vss_sr2_vss_sr3_vss_sr4_vss_sv_vss_tg_d_vss_tg_fbm_vss_tg_fbs_vss_tg_s_vss_vss_vss_link_vss_link_bridge_vss_link_dip_vss_link_m1_vss_x1_vss_x2_vss_x3_t128 vss__t128 vss 168.268008042
* device instance g_vss_m1_inv_clk_vss_inv_mc_vss_inv_q_vss_mph_g_nand_m_vss_nand_s2_vss_s1_vss_m1_s2_vss_m1_s3_vss_m1_s4_vss_m1_sb_vss_sr1_vss_sr2_vss_sr3_vss_sr4_vss_sv_vss_tg_d_vss_tg_fbm_vss_tg_fbs_vss_tg_s_vss_vss_vss_link_vss_link_bridge_vss_link_dip_vss_link_m1_vss_x1_vss_x2_vss_x3_t129 r0 *1 0,0
Rg_vss_m1_inv_clk_vss_inv_mc_vss_inv_q_vss_mph_g_nand_m_vss_nand_s2_vss_s1_vss_m1_s2_vss_m1_s3_vss_m1_s4_vss_m1_sb_vss_sr1_vss_sr2_vss_sr3_vss_sr4_vss_sv_vss_tg_d_vss_tg_fbm_vss_tg_fbs_vss_tg_s_vss_vss_vss_link_vss_link_bridge_vss_link_dip_vss_link_m1_vss_x1_vss_x2_vss_x3_t129 vss__t129 vss 150.530719956
* device instance g_vss_m1_inv_clk_vss_inv_mc_vss_inv_q_vss_mph_g_nand_m_vss_nand_s2_vss_s1_vss_m1_s2_vss_m1_s3_vss_m1_s4_vss_m1_sb_vss_sr1_vss_sr2_vss_sr3_vss_sr4_vss_sv_vss_tg_d_vss_tg_fbm_vss_tg_fbs_vss_tg_s_vss_vss_vss_link_vss_link_bridge_vss_link_dip_vss_link_m1_vss_x1_vss_x2_vss_x3_t130 r0 *1 0,0
Rg_vss_m1_inv_clk_vss_inv_mc_vss_inv_q_vss_mph_g_nand_m_vss_nand_s2_vss_s1_vss_m1_s2_vss_m1_s3_vss_m1_s4_vss_m1_sb_vss_sr1_vss_sr2_vss_sr3_vss_sr4_vss_sv_vss_tg_d_vss_tg_fbm_vss_tg_fbs_vss_tg_s_vss_vss_vss_link_vss_link_bridge_vss_link_dip_vss_link_m1_vss_x1_vss_x2_vss_x3_t130 vss__t130 vss 340.723725532
* device instance g_vss_m1_inv_clk_vss_inv_mc_vss_inv_q_vss_mph_g_nand_m_vss_nand_s2_vss_s1_vss_m1_s2_vss_m1_s3_vss_m1_s4_vss_m1_sb_vss_sr1_vss_sr2_vss_sr3_vss_sr4_vss_sv_vss_tg_d_vss_tg_fbm_vss_tg_fbs_vss_tg_s_vss_vss_vss_link_vss_link_bridge_vss_link_dip_vss_link_m1_vss_x1_vss_x2_vss_x3_t131 r0 *1 0,0
Rg_vss_m1_inv_clk_vss_inv_mc_vss_inv_q_vss_mph_g_nand_m_vss_nand_s2_vss_s1_vss_m1_s2_vss_m1_s3_vss_m1_s4_vss_m1_sb_vss_sr1_vss_sr2_vss_sr3_vss_sr4_vss_sv_vss_tg_d_vss_tg_fbm_vss_tg_fbs_vss_tg_s_vss_vss_vss_link_vss_link_bridge_vss_link_dip_vss_link_m1_vss_x1_vss_x2_vss_x3_t131 vss__t131 vss 327.638026688
* device instance g_vss_m1_inv_clk_vss_inv_mc_vss_inv_q_vss_mph_g_nand_m_vss_nand_s2_vss_s1_vss_m1_s2_vss_m1_s3_vss_m1_s4_vss_m1_sb_vss_sr1_vss_sr2_vss_sr3_vss_sr4_vss_sv_vss_tg_d_vss_tg_fbm_vss_tg_fbs_vss_tg_s_vss_vss_vss_link_vss_link_bridge_vss_link_dip_vss_link_m1_vss_x1_vss_x2_vss_x3_t132 r0 *1 0,0
Rg_vss_m1_inv_clk_vss_inv_mc_vss_inv_q_vss_mph_g_nand_m_vss_nand_s2_vss_s1_vss_m1_s2_vss_m1_s3_vss_m1_s4_vss_m1_sb_vss_sr1_vss_sr2_vss_sr3_vss_sr4_vss_sv_vss_tg_d_vss_tg_fbm_vss_tg_fbs_vss_tg_s_vss_vss_vss_link_vss_link_bridge_vss_link_dip_vss_link_m1_vss_x1_vss_x2_vss_x3_t132 vss__t132 vss 287.813421287
* device instance g_vss_m1_inv_clk_vss_inv_mc_vss_inv_q_vss_mph_g_nand_m_vss_nand_s2_vss_s1_vss_m1_s2_vss_m1_s3_vss_m1_s4_vss_m1_sb_vss_sr1_vss_sr2_vss_sr3_vss_sr4_vss_sv_vss_tg_d_vss_tg_fbm_vss_tg_fbs_vss_tg_s_vss_vss_vss_link_vss_link_bridge_vss_link_dip_vss_link_m1_vss_x1_vss_x2_vss_x3_t133 r0 *1 0,0
Rg_vss_m1_inv_clk_vss_inv_mc_vss_inv_q_vss_mph_g_nand_m_vss_nand_s2_vss_s1_vss_m1_s2_vss_m1_s3_vss_m1_s4_vss_m1_sb_vss_sr1_vss_sr2_vss_sr3_vss_sr4_vss_sv_vss_tg_d_vss_tg_fbm_vss_tg_fbs_vss_tg_s_vss_vss_vss_link_vss_link_bridge_vss_link_dip_vss_link_m1_vss_x1_vss_x2_vss_x3_t133 vss__t133 vss 274.77484113
* device instance g_vss_m1_inv_clk_vss_inv_mc_vss_inv_q_vss_mph_g_nand_m_vss_nand_s2_vss_s1_vss_m1_s2_vss_m1_s3_vss_m1_s4_vss_m1_sb_vss_sr1_vss_sr2_vss_sr3_vss_sr4_vss_sv_vss_tg_d_vss_tg_fbm_vss_tg_fbs_vss_tg_s_vss_vss_vss_link_vss_link_bridge_vss_link_dip_vss_link_m1_vss_x1_vss_x2_vss_x3_t134 r0 *1 0,0
Rg_vss_m1_inv_clk_vss_inv_mc_vss_inv_q_vss_mph_g_nand_m_vss_nand_s2_vss_s1_vss_m1_s2_vss_m1_s3_vss_m1_s4_vss_m1_sb_vss_sr1_vss_sr2_vss_sr3_vss_sr4_vss_sv_vss_tg_d_vss_tg_fbm_vss_tg_fbs_vss_tg_s_vss_vss_vss_link_vss_link_bridge_vss_link_dip_vss_link_m1_vss_x1_vss_x2_vss_x3_t134 vss__t134 vss 260.728293364
* device instance g_vss_m1_inv_clk_vss_inv_mc_vss_inv_q_vss_mph_g_nand_m_vss_nand_s2_vss_s1_vss_m1_s2_vss_m1_s3_vss_m1_s4_vss_m1_sb_vss_sr1_vss_sr2_vss_sr3_vss_sr4_vss_sv_vss_tg_d_vss_tg_fbm_vss_tg_fbs_vss_tg_s_vss_vss_vss_link_vss_link_bridge_vss_link_dip_vss_link_m1_vss_x1_vss_x2_vss_x3_t135 r0 *1 0,0
Rg_vss_m1_inv_clk_vss_inv_mc_vss_inv_q_vss_mph_g_nand_m_vss_nand_s2_vss_s1_vss_m1_s2_vss_m1_s3_vss_m1_s4_vss_m1_sb_vss_sr1_vss_sr2_vss_sr3_vss_sr4_vss_sv_vss_tg_d_vss_tg_fbm_vss_tg_fbs_vss_tg_s_vss_vss_vss_link_vss_link_bridge_vss_link_dip_vss_link_m1_vss_x1_vss_x2_vss_x3_t135 vss__t135 vss 242.166096824
* device instance g_vss_m1_inv_clk_vss_inv_mc_vss_inv_q_vss_mph_g_nand_m_vss_nand_s2_vss_s1_vss_m1_s2_vss_m1_s3_vss_m1_s4_vss_m1_sb_vss_sr1_vss_sr2_vss_sr3_vss_sr4_vss_sv_vss_tg_d_vss_tg_fbm_vss_tg_fbs_vss_tg_s_vss_vss_vss_link_vss_link_bridge_vss_link_dip_vss_link_m1_vss_x1_vss_x2_vss_x3_t136 r0 *1 0,0
Rg_vss_m1_inv_clk_vss_inv_mc_vss_inv_q_vss_mph_g_nand_m_vss_nand_s2_vss_s1_vss_m1_s2_vss_m1_s3_vss_m1_s4_vss_m1_sb_vss_sr1_vss_sr2_vss_sr3_vss_sr4_vss_sv_vss_tg_d_vss_tg_fbm_vss_tg_fbs_vss_tg_s_vss_vss_vss_link_vss_link_bridge_vss_link_dip_vss_link_m1_vss_x1_vss_x2_vss_x3_t136 vss__t136 vss 208.245110245
* device instance g_vss_m1_inv_clk_vss_inv_mc_vss_inv_q_vss_mph_g_nand_m_vss_nand_s2_vss_s1_vss_m1_s2_vss_m1_s3_vss_m1_s4_vss_m1_sb_vss_sr1_vss_sr2_vss_sr3_vss_sr4_vss_sv_vss_tg_d_vss_tg_fbm_vss_tg_fbs_vss_tg_s_vss_vss_vss_link_vss_link_bridge_vss_link_dip_vss_link_m1_vss_x1_vss_x2_vss_x3_t137 r0 *1 0,0
Rg_vss_m1_inv_clk_vss_inv_mc_vss_inv_q_vss_mph_g_nand_m_vss_nand_s2_vss_s1_vss_m1_s2_vss_m1_s3_vss_m1_s4_vss_m1_sb_vss_sr1_vss_sr2_vss_sr3_vss_sr4_vss_sv_vss_tg_d_vss_tg_fbm_vss_tg_fbs_vss_tg_s_vss_vss_vss_link_vss_link_bridge_vss_link_dip_vss_link_m1_vss_x1_vss_x2_vss_x3_t137 vss__t137 vss 188.860014474
* device instance g_vss_m1_inv_clk_vss_inv_mc_vss_inv_q_vss_mph_g_nand_m_vss_nand_s2_vss_s1_vss_m1_s2_vss_m1_s3_vss_m1_s4_vss_m1_sb_vss_sr1_vss_sr2_vss_sr3_vss_sr4_vss_sv_vss_tg_d_vss_tg_fbm_vss_tg_fbs_vss_tg_s_vss_vss_vss_link_vss_link_bridge_vss_link_dip_vss_link_m1_vss_x1_vss_x2_vss_x3_t138 r0 *1 0,0
Rg_vss_m1_inv_clk_vss_inv_mc_vss_inv_q_vss_mph_g_nand_m_vss_nand_s2_vss_s1_vss_m1_s2_vss_m1_s3_vss_m1_s4_vss_m1_sb_vss_sr1_vss_sr2_vss_sr3_vss_sr4_vss_sv_vss_tg_d_vss_tg_fbm_vss_tg_fbs_vss_tg_s_vss_vss_vss_link_vss_link_bridge_vss_link_dip_vss_link_m1_vss_x1_vss_x2_vss_x3_t138 vss__t138 vss 176.046579521
* device instance g_vss_m1_inv_clk_vss_inv_mc_vss_inv_q_vss_mph_g_nand_m_vss_nand_s2_vss_s1_vss_m1_s2_vss_m1_s3_vss_m1_s4_vss_m1_sb_vss_sr1_vss_sr2_vss_sr3_vss_sr4_vss_sv_vss_tg_d_vss_tg_fbm_vss_tg_fbs_vss_tg_s_vss_vss_vss_link_vss_link_bridge_vss_link_dip_vss_link_m1_vss_x1_vss_x2_vss_x3_t139 r0 *1 0,0
Rg_vss_m1_inv_clk_vss_inv_mc_vss_inv_q_vss_mph_g_nand_m_vss_nand_s2_vss_s1_vss_m1_s2_vss_m1_s3_vss_m1_s4_vss_m1_sb_vss_sr1_vss_sr2_vss_sr3_vss_sr4_vss_sv_vss_tg_d_vss_tg_fbm_vss_tg_fbs_vss_tg_s_vss_vss_vss_link_vss_link_bridge_vss_link_dip_vss_link_m1_vss_x1_vss_x2_vss_x3_t139 vss__t139 vss 137.439349262
* device instance g_vss_m1_inv_clk_vss_inv_mc_vss_inv_q_vss_mph_g_nand_m_vss_nand_s2_vss_s1_vss_m1_s2_vss_m1_s3_vss_m1_s4_vss_m1_sb_vss_sr1_vss_sr2_vss_sr3_vss_sr4_vss_sv_vss_tg_d_vss_tg_fbm_vss_tg_fbs_vss_tg_s_vss_vss_vss_link_vss_link_bridge_vss_link_dip_vss_link_m1_vss_x1_vss_x2_vss_x3_t140 r0 *1 0,0
Rg_vss_m1_inv_clk_vss_inv_mc_vss_inv_q_vss_mph_g_nand_m_vss_nand_s2_vss_s1_vss_m1_s2_vss_m1_s3_vss_m1_s4_vss_m1_sb_vss_sr1_vss_sr2_vss_sr3_vss_sr4_vss_sv_vss_tg_d_vss_tg_fbm_vss_tg_fbs_vss_tg_s_vss_vss_vss_link_vss_link_bridge_vss_link_dip_vss_link_m1_vss_x1_vss_x2_vss_x3_t140 vss__t140 vss 124.997985075
* device instance g_vss_m1_inv_clk_vss_inv_mc_vss_inv_q_vss_mph_g_nand_m_vss_nand_s2_vss_s1_vss_m1_s2_vss_m1_s3_vss_m1_s4_vss_m1_sb_vss_sr1_vss_sr2_vss_sr3_vss_sr4_vss_sv_vss_tg_d_vss_tg_fbm_vss_tg_fbs_vss_tg_s_vss_vss_vss_link_vss_link_bridge_vss_link_dip_vss_link_m1_vss_x1_vss_x2_vss_x3_t141 r0 *1 0,0
Rg_vss_m1_inv_clk_vss_inv_mc_vss_inv_q_vss_mph_g_nand_m_vss_nand_s2_vss_s1_vss_m1_s2_vss_m1_s3_vss_m1_s4_vss_m1_sb_vss_sr1_vss_sr2_vss_sr3_vss_sr4_vss_sv_vss_tg_d_vss_tg_fbm_vss_tg_fbs_vss_tg_s_vss_vss_vss_link_vss_link_bridge_vss_link_dip_vss_link_m1_vss_x1_vss_x2_vss_x3_t141 vss__t141 vss 111.772650769
* device instance g_vss_m1_inv_clk_vss_inv_mc_vss_inv_q_vss_mph_g_nand_m_vss_nand_s2_vss_s1_vss_m1_s2_vss_m1_s3_vss_m1_s4_vss_m1_sb_vss_sr1_vss_sr2_vss_sr3_vss_sr4_vss_sv_vss_tg_d_vss_tg_fbm_vss_tg_fbs_vss_tg_s_vss_vss_vss_link_vss_link_bridge_vss_link_dip_vss_link_m1_vss_x1_vss_x2_vss_x3_t142 r0 *1 0,0
Rg_vss_m1_inv_clk_vss_inv_mc_vss_inv_q_vss_mph_g_nand_m_vss_nand_s2_vss_s1_vss_m1_s2_vss_m1_s3_vss_m1_s4_vss_m1_sb_vss_sr1_vss_sr2_vss_sr3_vss_sr4_vss_sv_vss_tg_d_vss_tg_fbm_vss_tg_fbs_vss_tg_s_vss_vss_vss_link_vss_link_bridge_vss_link_dip_vss_link_m1_vss_x1_vss_x2_vss_x3_t142 vss__t142 vss 94.7161403067
* device instance g_vss_m1_inv_clk_vss_inv_mc_vss_inv_q_vss_mph_g_nand_m_vss_nand_s2_vss_s1_vss_m1_s2_vss_m1_s3_vss_m1_s4_vss_m1_sb_vss_sr1_vss_sr2_vss_sr3_vss_sr4_vss_sv_vss_tg_d_vss_tg_fbm_vss_tg_fbs_vss_tg_s_vss_vss_vss_link_vss_link_bridge_vss_link_dip_vss_link_m1_vss_x1_vss_x2_vss_x3_t143 r0 *1 0,0
Rg_vss_m1_inv_clk_vss_inv_mc_vss_inv_q_vss_mph_g_nand_m_vss_nand_s2_vss_s1_vss_m1_s2_vss_m1_s3_vss_m1_s4_vss_m1_sb_vss_sr1_vss_sr2_vss_sr3_vss_sr4_vss_sv_vss_tg_d_vss_tg_fbm_vss_tg_fbs_vss_tg_s_vss_vss_vss_link_vss_link_bridge_vss_link_dip_vss_link_m1_vss_x1_vss_x2_vss_x3_t143 vss__t143 vss 66.0111336556
* device instance g_vss_m1_inv_clk_vss_inv_mc_vss_inv_q_vss_mph_g_nand_m_vss_nand_s2_vss_s1_vss_m1_s2_vss_m1_s3_vss_m1_s4_vss_m1_sb_vss_sr1_vss_sr2_vss_sr3_vss_sr4_vss_sv_vss_tg_d_vss_tg_fbm_vss_tg_fbs_vss_tg_s_vss_vss_vss_link_vss_link_bridge_vss_link_dip_vss_link_m1_vss_x1_vss_x2_vss_x3_t144 r0 *1 0,0
Rg_vss_m1_inv_clk_vss_inv_mc_vss_inv_q_vss_mph_g_nand_m_vss_nand_s2_vss_s1_vss_m1_s2_vss_m1_s3_vss_m1_s4_vss_m1_sb_vss_sr1_vss_sr2_vss_sr3_vss_sr4_vss_sv_vss_tg_d_vss_tg_fbm_vss_tg_fbs_vss_tg_s_vss_vss_vss_link_vss_link_bridge_vss_link_dip_vss_link_m1_vss_x1_vss_x2_vss_x3_t144 vss__t144 vss 52.8057762744
* device instance g_vss_m1_inv_clk_vss_inv_mc_vss_inv_q_vss_mph_g_nand_m_vss_nand_s2_vss_s1_vss_m1_s2_vss_m1_s3_vss_m1_s4_vss_m1_sb_vss_sr1_vss_sr2_vss_sr3_vss_sr4_vss_sv_vss_tg_d_vss_tg_fbm_vss_tg_fbs_vss_tg_s_vss_vss_vss_link_vss_link_bridge_vss_link_dip_vss_link_m1_vss_x1_vss_x2_vss_x3_t145 r0 *1 0,0
Rg_vss_m1_inv_clk_vss_inv_mc_vss_inv_q_vss_mph_g_nand_m_vss_nand_s2_vss_s1_vss_m1_s2_vss_m1_s3_vss_m1_s4_vss_m1_sb_vss_sr1_vss_sr2_vss_sr3_vss_sr4_vss_sv_vss_tg_d_vss_tg_fbm_vss_tg_fbs_vss_tg_s_vss_vss_vss_link_vss_link_bridge_vss_link_dip_vss_link_m1_vss_x1_vss_x2_vss_x3_t145 vss__t145 vss 46.7227653733
* device instance g_vss_m1_inv_clk_vss_inv_mc_vss_inv_q_vss_mph_g_nand_m_vss_nand_s2_vss_s1_vss_m1_s2_vss_m1_s3_vss_m1_s4_vss_m1_sb_vss_sr1_vss_sr2_vss_sr3_vss_sr4_vss_sv_vss_tg_d_vss_tg_fbm_vss_tg_fbs_vss_tg_s_vss_vss_vss_link_vss_link_bridge_vss_link_dip_vss_link_m1_vss_x1_vss_x2_vss_x3_t146 r0 *1 0,0
Rg_vss_m1_inv_clk_vss_inv_mc_vss_inv_q_vss_mph_g_nand_m_vss_nand_s2_vss_s1_vss_m1_s2_vss_m1_s3_vss_m1_s4_vss_m1_sb_vss_sr1_vss_sr2_vss_sr3_vss_sr4_vss_sv_vss_tg_d_vss_tg_fbm_vss_tg_fbs_vss_tg_s_vss_vss_vss_link_vss_link_bridge_vss_link_dip_vss_link_m1_vss_x1_vss_x2_vss_x3_t146 vss__t146 vss 49.8746528061
* device instance g_vss_m1_inv_clk_vss_inv_mc_vss_inv_q_vss_mph_g_nand_m_vss_nand_s2_vss_s1_vss_m1_s2_vss_m1_s3_vss_m1_s4_vss_m1_sb_vss_sr1_vss_sr2_vss_sr3_vss_sr4_vss_sv_vss_tg_d_vss_tg_fbm_vss_tg_fbs_vss_tg_s_vss_vss_vss_link_vss_link_bridge_vss_link_dip_vss_link_m1_vss_x1_vss_x2_vss_x3_t147 r0 *1 0,0
Rg_vss_m1_inv_clk_vss_inv_mc_vss_inv_q_vss_mph_g_nand_m_vss_nand_s2_vss_s1_vss_m1_s2_vss_m1_s3_vss_m1_s4_vss_m1_sb_vss_sr1_vss_sr2_vss_sr3_vss_sr4_vss_sv_vss_tg_d_vss_tg_fbm_vss_tg_fbs_vss_tg_s_vss_vss_vss_link_vss_link_bridge_vss_link_dip_vss_link_m1_vss_x1_vss_x2_vss_x3_t147 vss__t147 vss 57.3818459285
* device instance g_vss_m1_inv_clk_vss_inv_mc_vss_inv_q_vss_mph_g_nand_m_vss_nand_s2_vss_s1_vss_m1_s2_vss_m1_s3_vss_m1_s4_vss_m1_sb_vss_sr1_vss_sr2_vss_sr3_vss_sr4_vss_sv_vss_tg_d_vss_tg_fbm_vss_tg_fbs_vss_tg_s_vss_vss_vss_link_vss_link_bridge_vss_link_dip_vss_link_m1_vss_x1_vss_x2_vss_x3_t148 r0 *1 0,0
Rg_vss_m1_inv_clk_vss_inv_mc_vss_inv_q_vss_mph_g_nand_m_vss_nand_s2_vss_s1_vss_m1_s2_vss_m1_s3_vss_m1_s4_vss_m1_sb_vss_sr1_vss_sr2_vss_sr3_vss_sr4_vss_sv_vss_tg_d_vss_tg_fbm_vss_tg_fbs_vss_tg_s_vss_vss_vss_link_vss_link_bridge_vss_link_dip_vss_link_m1_vss_x1_vss_x2_vss_x3_t148 vss__t148 vss 67.4678069432
* device instance g_vss_m1_inv_clk_vss_inv_mc_vss_inv_q_vss_mph_g_nand_m_vss_nand_s2_vss_s1_vss_m1_s2_vss_m1_s3_vss_m1_s4_vss_m1_sb_vss_sr1_vss_sr2_vss_sr3_vss_sr4_vss_sv_vss_tg_d_vss_tg_fbm_vss_tg_fbs_vss_tg_s_vss_vss_vss_link_vss_link_bridge_vss_link_dip_vss_link_m1_vss_x1_vss_x2_vss_x3_t149 r0 *1 0,0
Rg_vss_m1_inv_clk_vss_inv_mc_vss_inv_q_vss_mph_g_nand_m_vss_nand_s2_vss_s1_vss_m1_s2_vss_m1_s3_vss_m1_s4_vss_m1_sb_vss_sr1_vss_sr2_vss_sr3_vss_sr4_vss_sv_vss_tg_d_vss_tg_fbm_vss_tg_fbs_vss_tg_s_vss_vss_vss_link_vss_link_bridge_vss_link_dip_vss_link_m1_vss_x1_vss_x2_vss_x3_t149 vss__t149 vss 82.7210555587
* device instance g_vss_m1_inv_clk_vss_inv_mc_vss_inv_q_vss_mph_g_nand_m_vss_nand_s2_vss_s1_vss_m1_s2_vss_m1_s3_vss_m1_s4_vss_m1_sb_vss_sr1_vss_sr2_vss_sr3_vss_sr4_vss_sv_vss_tg_d_vss_tg_fbm_vss_tg_fbs_vss_tg_s_vss_vss_vss_link_vss_link_bridge_vss_link_dip_vss_link_m1_vss_x1_vss_x2_vss_x3_t150 r0 *1 0,0
Rg_vss_m1_inv_clk_vss_inv_mc_vss_inv_q_vss_mph_g_nand_m_vss_nand_s2_vss_s1_vss_m1_s2_vss_m1_s3_vss_m1_s4_vss_m1_sb_vss_sr1_vss_sr2_vss_sr3_vss_sr4_vss_sv_vss_tg_d_vss_tg_fbm_vss_tg_fbs_vss_tg_s_vss_vss_vss_link_vss_link_bridge_vss_link_dip_vss_link_m1_vss_x1_vss_x2_vss_x3_t150 vss__t150 vss 113.550916361
* device instance g_vss_m1_inv_clk_vss_inv_mc_vss_inv_q_vss_mph_g_nand_m_vss_nand_s2_vss_s1_vss_m1_s2_vss_m1_s3_vss_m1_s4_vss_m1_sb_vss_sr1_vss_sr2_vss_sr3_vss_sr4_vss_sv_vss_tg_d_vss_tg_fbm_vss_tg_fbs_vss_tg_s_vss_vss_vss_link_vss_link_bridge_vss_link_dip_vss_link_m1_vss_x1_vss_x2_vss_x3_t151 r0 *1 0,0
Rg_vss_m1_inv_clk_vss_inv_mc_vss_inv_q_vss_mph_g_nand_m_vss_nand_s2_vss_s1_vss_m1_s2_vss_m1_s3_vss_m1_s4_vss_m1_sb_vss_sr1_vss_sr2_vss_sr3_vss_sr4_vss_sv_vss_tg_d_vss_tg_fbm_vss_tg_fbs_vss_tg_s_vss_vss_vss_link_vss_link_bridge_vss_link_dip_vss_link_m1_vss_x1_vss_x2_vss_x3_t151 vss__t151 vss 132.112421684
* device instance g_vss_m1_inv_clk_vss_inv_mc_vss_inv_q_vss_mph_g_nand_m_vss_nand_s2_vss_s1_vss_m1_s2_vss_m1_s3_vss_m1_s4_vss_m1_sb_vss_sr1_vss_sr2_vss_sr3_vss_sr4_vss_sv_vss_tg_d_vss_tg_fbm_vss_tg_fbs_vss_tg_s_vss_vss_vss_link_vss_link_bridge_vss_link_dip_vss_link_m1_vss_x1_vss_x2_vss_x3_t152 r0 *1 0,0
Rg_vss_m1_inv_clk_vss_inv_mc_vss_inv_q_vss_mph_g_nand_m_vss_nand_s2_vss_s1_vss_m1_s2_vss_m1_s3_vss_m1_s4_vss_m1_sb_vss_sr1_vss_sr2_vss_sr3_vss_sr4_vss_sv_vss_tg_d_vss_tg_fbm_vss_tg_fbs_vss_tg_s_vss_vss_vss_link_vss_link_bridge_vss_link_dip_vss_link_m1_vss_x1_vss_x2_vss_x3_t152 vss__t152 vss 144.632404605
* device instance g_vss_m1_inv_clk_vss_inv_mc_vss_inv_q_vss_mph_g_nand_m_vss_nand_s2_vss_s1_vss_m1_s2_vss_m1_s3_vss_m1_s4_vss_m1_sb_vss_sr1_vss_sr2_vss_sr3_vss_sr4_vss_sv_vss_tg_d_vss_tg_fbm_vss_tg_fbs_vss_tg_s_vss_vss_vss_link_vss_link_bridge_vss_link_dip_vss_link_m1_vss_x1_vss_x2_vss_x3_t153 r0 *1 0,0
Rg_vss_m1_inv_clk_vss_inv_mc_vss_inv_q_vss_mph_g_nand_m_vss_nand_s2_vss_s1_vss_m1_s2_vss_m1_s3_vss_m1_s4_vss_m1_sb_vss_sr1_vss_sr2_vss_sr3_vss_sr4_vss_sv_vss_tg_d_vss_tg_fbm_vss_tg_fbs_vss_tg_s_vss_vss_vss_link_vss_link_bridge_vss_link_dip_vss_link_m1_vss_x1_vss_x2_vss_x3_t153 vss__t153 vss 183.385616322
* device instance g_vss_m1_inv_clk_vss_inv_mc_vss_inv_q_vss_mph_g_nand_m_vss_nand_s2_vss_s1_vss_m1_s2_vss_m1_s3_vss_m1_s4_vss_m1_sb_vss_sr1_vss_sr2_vss_sr3_vss_sr4_vss_sv_vss_tg_d_vss_tg_fbm_vss_tg_fbs_vss_tg_s_vss_vss_vss_link_vss_link_bridge_vss_link_dip_vss_link_m1_vss_x1_vss_x2_vss_x3_t154 r0 *1 0,0
Rg_vss_m1_inv_clk_vss_inv_mc_vss_inv_q_vss_mph_g_nand_m_vss_nand_s2_vss_s1_vss_m1_s2_vss_m1_s3_vss_m1_s4_vss_m1_sb_vss_sr1_vss_sr2_vss_sr3_vss_sr4_vss_sv_vss_tg_d_vss_tg_fbm_vss_tg_fbs_vss_tg_s_vss_vss_vss_link_vss_link_bridge_vss_link_dip_vss_link_m1_vss_x1_vss_x2_vss_x3_t154 vss__t154 vss 196.228828733
* device instance g_vss_m1_inv_clk_vss_inv_mc_vss_inv_q_vss_mph_g_nand_m_vss_nand_s2_vss_s1_vss_m1_s2_vss_m1_s3_vss_m1_s4_vss_m1_sb_vss_sr1_vss_sr2_vss_sr3_vss_sr4_vss_sv_vss_tg_d_vss_tg_fbm_vss_tg_fbs_vss_tg_s_vss_vss_vss_link_vss_link_bridge_vss_link_dip_vss_link_m1_vss_x1_vss_x2_vss_x3_t155 r0 *1 0,0
Rg_vss_m1_inv_clk_vss_inv_mc_vss_inv_q_vss_mph_g_nand_m_vss_nand_s2_vss_s1_vss_m1_s2_vss_m1_s3_vss_m1_s4_vss_m1_sb_vss_sr1_vss_sr2_vss_sr3_vss_sr4_vss_sv_vss_tg_d_vss_tg_fbm_vss_tg_fbs_vss_tg_s_vss_vss_vss_link_vss_link_bridge_vss_link_dip_vss_link_m1_vss_x1_vss_x2_vss_x3_t155 vss__t155 vss 210.132295238
* device instance g_vss_m1_inv_clk_vss_inv_mc_vss_inv_q_vss_mph_g_nand_m_vss_nand_s2_vss_s1_vss_m1_s2_vss_m1_s3_vss_m1_s4_vss_m1_sb_vss_sr1_vss_sr2_vss_sr3_vss_sr4_vss_sv_vss_tg_d_vss_tg_fbm_vss_tg_fbs_vss_tg_s_vss_vss_vss_link_vss_link_bridge_vss_link_dip_vss_link_m1_vss_x1_vss_x2_vss_x3_t156 r0 *1 0,0
Rg_vss_m1_inv_clk_vss_inv_mc_vss_inv_q_vss_mph_g_nand_m_vss_nand_s2_vss_s1_vss_m1_s2_vss_m1_s3_vss_m1_s4_vss_m1_sb_vss_sr1_vss_sr2_vss_sr3_vss_sr4_vss_sv_vss_tg_d_vss_tg_fbm_vss_tg_fbs_vss_tg_s_vss_vss_vss_link_vss_link_bridge_vss_link_dip_vss_link_m1_vss_x1_vss_x2_vss_x3_t156 vss__t156 vss 228.602921778
* device instance g_vss_m1_inv_clk_vss_inv_mc_vss_inv_q_vss_mph_g_nand_m_vss_nand_s2_vss_s1_vss_m1_s2_vss_m1_s3_vss_m1_s4_vss_m1_sb_vss_sr1_vss_sr2_vss_sr3_vss_sr4_vss_sv_vss_tg_d_vss_tg_fbm_vss_tg_fbs_vss_tg_s_vss_vss_vss_link_vss_link_bridge_vss_link_dip_vss_link_m1_vss_x1_vss_x2_vss_x3_t157 r0 *1 0,0
Rg_vss_m1_inv_clk_vss_inv_mc_vss_inv_q_vss_mph_g_nand_m_vss_nand_s2_vss_s1_vss_m1_s2_vss_m1_s3_vss_m1_s4_vss_m1_sb_vss_sr1_vss_sr2_vss_sr3_vss_sr4_vss_sv_vss_tg_d_vss_tg_fbm_vss_tg_fbs_vss_tg_s_vss_vss_vss_link_vss_link_bridge_vss_link_dip_vss_link_m1_vss_x1_vss_x2_vss_x3_t157 vss__t157 vss 262.631011993
* device instance g_vss_m1_inv_clk_vss_inv_mc_vss_inv_q_vss_mph_g_nand_m_vss_nand_s2_vss_s1_vss_m1_s2_vss_m1_s3_vss_m1_s4_vss_m1_sb_vss_sr1_vss_sr2_vss_sr3_vss_sr4_vss_sv_vss_tg_d_vss_tg_fbm_vss_tg_fbs_vss_tg_s_vss_vss_vss_link_vss_link_bridge_vss_link_dip_vss_link_m1_vss_x1_vss_x2_vss_x3_t158 r0 *1 0,0
Rg_vss_m1_inv_clk_vss_inv_mc_vss_inv_q_vss_mph_g_nand_m_vss_nand_s2_vss_s1_vss_m1_s2_vss_m1_s3_vss_m1_s4_vss_m1_sb_vss_sr1_vss_sr2_vss_sr3_vss_sr4_vss_sv_vss_tg_d_vss_tg_fbm_vss_tg_fbs_vss_tg_s_vss_vss_vss_link_vss_link_bridge_vss_link_dip_vss_link_m1_vss_x1_vss_x2_vss_x3_t158 vss__t158 vss 282.247818296
* device instance g_vss_m1_inv_clk_vss_inv_mc_vss_inv_q_vss_mph_g_nand_m_vss_nand_s2_vss_s1_vss_m1_s2_vss_m1_s3_vss_m1_s4_vss_m1_sb_vss_sr1_vss_sr2_vss_sr3_vss_sr4_vss_sv_vss_tg_d_vss_tg_fbm_vss_tg_fbs_vss_tg_s_vss_vss_vss_link_vss_link_bridge_vss_link_dip_vss_link_m1_vss_x1_vss_x2_vss_x3_t159 r0 *1 0,0
Rg_vss_m1_inv_clk_vss_inv_mc_vss_inv_q_vss_mph_g_nand_m_vss_nand_s2_vss_s1_vss_m1_s2_vss_m1_s3_vss_m1_s4_vss_m1_sb_vss_sr1_vss_sr2_vss_sr3_vss_sr4_vss_sv_vss_tg_d_vss_tg_fbm_vss_tg_fbs_vss_tg_s_vss_vss_vss_link_vss_link_bridge_vss_link_dip_vss_link_m1_vss_x1_vss_x2_vss_x3_t159 vss__t159 vss 295.294675085
* device instance g_vss_m1_inv_clk_vss_inv_mc_vss_inv_q_vss_mph_g_nand_m_vss_nand_s2_vss_s1_vss_m1_s2_vss_m1_s3_vss_m1_s4_vss_m1_sb_vss_sr1_vss_sr2_vss_sr3_vss_sr4_vss_sv_vss_tg_d_vss_tg_fbm_vss_tg_fbs_vss_tg_s_vss_vss_vss_link_vss_link_bridge_vss_link_dip_vss_link_m1_vss_x1_vss_x2_vss_x3_t160 r0 *1 0,0
Rg_vss_m1_inv_clk_vss_inv_mc_vss_inv_q_vss_mph_g_nand_m_vss_nand_s2_vss_s1_vss_m1_s2_vss_m1_s3_vss_m1_s4_vss_m1_sb_vss_sr1_vss_sr2_vss_sr3_vss_sr4_vss_sv_vss_tg_d_vss_tg_fbm_vss_tg_fbs_vss_tg_s_vss_vss_vss_link_vss_link_bridge_vss_link_dip_vss_link_m1_vss_x1_vss_x2_vss_x3_t160 vss__t160 vss 335.138754204
* device instance g_vss_m1_inv_clk_vss_inv_mc_vss_inv_q_vss_mph_g_nand_m_vss_nand_s2_vss_s1_vss_m1_s2_vss_m1_s3_vss_m1_s4_vss_m1_sb_vss_sr1_vss_sr2_vss_sr3_vss_sr4_vss_sv_vss_tg_d_vss_tg_fbm_vss_tg_fbs_vss_tg_s_vss_vss_vss_link_vss_link_bridge_vss_link_dip_vss_link_m1_vss_x1_vss_x2_vss_x3_t161 r0 *1 0,0
Rg_vss_m1_inv_clk_vss_inv_mc_vss_inv_q_vss_mph_g_nand_m_vss_nand_s2_vss_s1_vss_m1_s2_vss_m1_s3_vss_m1_s4_vss_m1_sb_vss_sr1_vss_sr2_vss_sr3_vss_sr4_vss_sv_vss_tg_d_vss_tg_fbm_vss_tg_fbs_vss_tg_s_vss_vss_vss_link_vss_link_bridge_vss_link_dip_vss_link_m1_vss_x1_vss_x2_vss_x3_t161 vss__t161 vss 348.229417516
* device instance g_vss_m1_inv_clk_vss_inv_mc_vss_inv_q_vss_mph_g_nand_m_vss_nand_s2_vss_s1_vss_m1_s2_vss_m1_s3_vss_m1_s4_vss_m1_sb_vss_sr1_vss_sr2_vss_sr3_vss_sr4_vss_sv_vss_tg_d_vss_tg_fbm_vss_tg_fbs_vss_tg_s_vss_vss_vss_link_vss_link_bridge_vss_link_dip_vss_link_m1_vss_x1_vss_x2_vss_x3_t162 r0 *1 0,0
Rg_vss_m1_inv_clk_vss_inv_mc_vss_inv_q_vss_mph_g_nand_m_vss_nand_s2_vss_s1_vss_m1_s2_vss_m1_s3_vss_m1_s4_vss_m1_sb_vss_sr1_vss_sr2_vss_sr3_vss_sr4_vss_sv_vss_tg_d_vss_tg_fbm_vss_tg_fbs_vss_tg_s_vss_vss_vss_link_vss_link_bridge_vss_link_dip_vss_link_m1_vss_x1_vss_x2_vss_x3_t162 vss__t162 vss 362.359152009
* device instance g_vss_m1_inv_clk_vss_inv_mc_vss_inv_q_vss_mph_g_nand_m_vss_nand_s2_vss_s1_vss_m1_s2_vss_m1_s3_vss_m1_s4_vss_m1_sb_vss_sr1_vss_sr2_vss_sr3_vss_sr4_vss_sv_vss_tg_d_vss_tg_fbm_vss_tg_fbs_vss_tg_s_vss_vss_vss_link_vss_link_bridge_vss_link_dip_vss_link_m1_vss_x1_vss_x2_vss_x3_t163 r0 *1 0,0
Rg_vss_m1_inv_clk_vss_inv_mc_vss_inv_q_vss_mph_g_nand_m_vss_nand_s2_vss_s1_vss_m1_s2_vss_m1_s3_vss_m1_s4_vss_m1_sb_vss_sr1_vss_sr2_vss_sr3_vss_sr4_vss_sv_vss_tg_d_vss_tg_fbm_vss_tg_fbs_vss_tg_s_vss_vss_vss_link_vss_link_bridge_vss_link_dip_vss_link_m1_vss_x1_vss_x2_vss_x3_t163 vss__t163 vss 381.078358966
* device instance g_vss_m1_inv_clk_vss_inv_mc_vss_inv_q_vss_mph_g_nand_m_vss_nand_s2_vss_s1_vss_m1_s2_vss_m1_s3_vss_m1_s4_vss_m1_sb_vss_sr1_vss_sr2_vss_sr3_vss_sr4_vss_sv_vss_tg_d_vss_tg_fbm_vss_tg_fbs_vss_tg_s_vss_vss_vss_link_vss_link_bridge_vss_link_dip_vss_link_m1_vss_x1_vss_x2_vss_x3_t164 r0 *1 0,0
Rg_vss_m1_inv_clk_vss_inv_mc_vss_inv_q_vss_mph_g_nand_m_vss_nand_s2_vss_s1_vss_m1_s2_vss_m1_s3_vss_m1_s4_vss_m1_sb_vss_sr1_vss_sr2_vss_sr3_vss_sr4_vss_sv_vss_tg_d_vss_tg_fbm_vss_tg_fbs_vss_tg_s_vss_vss_vss_link_vss_link_bridge_vss_link_dip_vss_link_m1_vss_x1_vss_x2_vss_x3_t164 vss__t164 vss 415.452985703
* device instance g_vss_m1_inv_clk_vss_inv_mc_vss_inv_q_vss_mph_g_nand_m_vss_nand_s2_vss_s1_vss_m1_s2_vss_m1_s3_vss_m1_s4_vss_m1_sb_vss_sr1_vss_sr2_vss_sr3_vss_sr4_vss_sv_vss_tg_d_vss_tg_fbm_vss_tg_fbs_vss_tg_s_vss_vss_vss_link_vss_link_bridge_vss_link_dip_vss_link_m1_vss_x1_vss_x2_vss_x3_t165 r0 *1 0,0
Rg_vss_m1_inv_clk_vss_inv_mc_vss_inv_q_vss_mph_g_nand_m_vss_nand_s2_vss_s1_vss_m1_s2_vss_m1_s3_vss_m1_s4_vss_m1_sb_vss_sr1_vss_sr2_vss_sr3_vss_sr4_vss_sv_vss_tg_d_vss_tg_fbm_vss_tg_fbs_vss_tg_s_vss_vss_vss_link_vss_link_bridge_vss_link_dip_vss_link_m1_vss_x1_vss_x2_vss_x3_t165 vss__t165 vss 435.22277849
* device instance g_vss_m1_inv_clk_vss_inv_mc_vss_inv_q_vss_mph_g_nand_m_vss_nand_s2_vss_s1_vss_m1_s2_vss_m1_s3_vss_m1_s4_vss_m1_sb_vss_sr1_vss_sr2_vss_sr3_vss_sr4_vss_sv_vss_tg_d_vss_tg_fbm_vss_tg_fbs_vss_tg_s_vss_vss_vss_link_vss_link_bridge_vss_link_dip_vss_link_m1_vss_x1_vss_x2_vss_x3_t166 r0 *1 0,0
Rg_vss_m1_inv_clk_vss_inv_mc_vss_inv_q_vss_mph_g_nand_m_vss_nand_s2_vss_s1_vss_m1_s2_vss_m1_s3_vss_m1_s4_vss_m1_sb_vss_sr1_vss_sr2_vss_sr3_vss_sr4_vss_sv_vss_tg_d_vss_tg_fbm_vss_tg_fbs_vss_tg_s_vss_vss_vss_link_vss_link_bridge_vss_link_dip_vss_link_m1_vss_x1_vss_x2_vss_x3_t166 vss__t166 vss 448.357284785
* device instance g_vss_m1_inv_clk_vss_inv_mc_vss_inv_q_vss_mph_g_nand_m_vss_nand_s2_vss_s1_vss_m1_s2_vss_m1_s3_vss_m1_s4_vss_m1_sb_vss_sr1_vss_sr2_vss_sr3_vss_sr4_vss_sv_vss_tg_d_vss_tg_fbm_vss_tg_fbs_vss_tg_s_vss_vss_vss_link_vss_link_bridge_vss_link_dip_vss_link_m1_vss_x1_vss_x2_vss_x3_t167 r0 *1 0,0
Rg_vss_m1_inv_clk_vss_inv_mc_vss_inv_q_vss_mph_g_nand_m_vss_nand_s2_vss_s1_vss_m1_s2_vss_m1_s3_vss_m1_s4_vss_m1_sb_vss_sr1_vss_sr2_vss_sr3_vss_sr4_vss_sv_vss_tg_d_vss_tg_fbm_vss_tg_fbs_vss_tg_s_vss_vss_vss_link_vss_link_bridge_vss_link_dip_vss_link_m1_vss_x1_vss_x2_vss_x3_t167 vss__t167 vss 488.41640214
* device instance g_vss_m1_inv_clk_vss_inv_mc_vss_inv_q_vss_mph_g_nand_m_vss_nand_s2_vss_s1_vss_m1_s2_vss_m1_s3_vss_m1_s4_vss_m1_sb_vss_sr1_vss_sr2_vss_sr3_vss_sr4_vss_sv_vss_tg_d_vss_tg_fbm_vss_tg_fbs_vss_tg_s_vss_vss_vss_link_vss_link_bridge_vss_link_dip_vss_link_m1_vss_x1_vss_x2_vss_x3_t168 r0 *1 0,0
Rg_vss_m1_inv_clk_vss_inv_mc_vss_inv_q_vss_mph_g_nand_m_vss_nand_s2_vss_s1_vss_m1_s2_vss_m1_s3_vss_m1_s4_vss_m1_sb_vss_sr1_vss_sr2_vss_sr3_vss_sr4_vss_sv_vss_tg_d_vss_tg_fbm_vss_tg_fbs_vss_tg_s_vss_vss_vss_link_vss_link_bridge_vss_link_dip_vss_link_m1_vss_x1_vss_x2_vss_x3_t168 vss__t168 vss 501.564151666
* device instance g_vss_m1_inv_clk_vss_inv_mc_vss_inv_q_vss_mph_g_nand_m_vss_nand_s2_vss_s1_vss_m1_s2_vss_m1_s3_vss_m1_s4_vss_m1_sb_vss_sr1_vss_sr2_vss_sr3_vss_sr4_vss_sv_vss_tg_d_vss_tg_fbm_vss_tg_fbs_vss_tg_s_vss_vss_vss_link_vss_link_bridge_vss_link_dip_vss_link_m1_vss_x1_vss_x2_vss_x3_t169 r0 *1 0,0
Rg_vss_m1_inv_clk_vss_inv_mc_vss_inv_q_vss_mph_g_nand_m_vss_nand_s2_vss_s1_vss_m1_s2_vss_m1_s3_vss_m1_s4_vss_m1_sb_vss_sr1_vss_sr2_vss_sr3_vss_sr4_vss_sv_vss_tg_d_vss_tg_fbm_vss_tg_fbs_vss_tg_s_vss_vss_vss_link_vss_link_bridge_vss_link_dip_vss_link_m1_vss_x1_vss_x2_vss_x3_t169 vss__t169 vss 515.749576443
* device instance g_vss_m1_inv_clk_vss_inv_mc_vss_inv_q_vss_mph_g_nand_m_vss_nand_s2_vss_s1_vss_m1_s2_vss_m1_s3_vss_m1_s4_vss_m1_sb_vss_sr1_vss_sr2_vss_sr3_vss_sr4_vss_sv_vss_tg_d_vss_tg_fbm_vss_tg_fbs_vss_tg_s_vss_vss_vss_link_vss_link_bridge_vss_link_dip_vss_link_m1_vss_x1_vss_x2_vss_x3_t170 r0 *1 0,0
Rg_vss_m1_inv_clk_vss_inv_mc_vss_inv_q_vss_mph_g_nand_m_vss_nand_s2_vss_s1_vss_m1_s2_vss_m1_s3_vss_m1_s4_vss_m1_sb_vss_sr1_vss_sr2_vss_sr3_vss_sr4_vss_sv_vss_tg_d_vss_tg_fbm_vss_tg_fbs_vss_tg_s_vss_vss_vss_link_vss_link_bridge_vss_link_dip_vss_link_m1_vss_x1_vss_x2_vss_x3_t170 vss__t170 vss 534.534407231
* device instance g_vss_m1_inv_clk_vss_inv_mc_vss_inv_q_vss_mph_g_nand_m_vss_nand_s2_vss_s1_vss_m1_s2_vss_m1_s3_vss_m1_s4_vss_m1_sb_vss_sr1_vss_sr2_vss_sr3_vss_sr4_vss_sv_vss_tg_d_vss_tg_fbm_vss_tg_fbs_vss_tg_s_vss_vss_vss_link_vss_link_bridge_vss_link_dip_vss_link_m1_vss_x1_vss_x2_vss_x3_t171 r0 *1 0,0
Rg_vss_m1_inv_clk_vss_inv_mc_vss_inv_q_vss_mph_g_nand_m_vss_nand_s2_vss_s1_vss_m1_s2_vss_m1_s3_vss_m1_s4_vss_m1_sb_vss_sr1_vss_sr2_vss_sr3_vss_sr4_vss_sv_vss_tg_d_vss_tg_fbm_vss_tg_fbs_vss_tg_s_vss_vss_vss_link_vss_link_bridge_vss_link_dip_vss_link_m1_vss_x1_vss_x2_vss_x3_t171 vss__t171 vss 569.00985511
* device instance g_vss_m1_inv_clk_vss_inv_mc_vss_inv_q_vss_mph_g_nand_m_vss_nand_s2_vss_s1_vss_m1_s2_vss_m1_s3_vss_m1_s4_vss_m1_sb_vss_sr1_vss_sr2_vss_sr3_vss_sr4_vss_sv_vss_tg_d_vss_tg_fbm_vss_tg_fbs_vss_tg_s_vss_vss_vss_link_vss_link_bridge_vss_link_dip_vss_link_m1_vss_x1_vss_x2_vss_x3_t172 r0 *1 0,0
Rg_vss_m1_inv_clk_vss_inv_mc_vss_inv_q_vss_mph_g_nand_m_vss_nand_s2_vss_s1_vss_m1_s2_vss_m1_s3_vss_m1_s4_vss_m1_sb_vss_sr1_vss_sr2_vss_sr3_vss_sr4_vss_sv_vss_tg_d_vss_tg_fbm_vss_tg_fbs_vss_tg_s_vss_vss_vss_link_vss_link_bridge_vss_link_dip_vss_link_m1_vss_x1_vss_x2_vss_x3_t172 vss__t172 vss 297.224770109
* device instance g_vss_m1_inv_clk_vss_inv_mc_vss_inv_q_vss_mph_g_nand_m_vss_nand_s2_vss_s1_vss_m1_s2_vss_m1_s3_vss_m1_s4_vss_m1_sb_vss_sr1_vss_sr2_vss_sr3_vss_sr4_vss_sv_vss_tg_d_vss_tg_fbm_vss_tg_fbs_vss_tg_s_vss_vss_vss_link_vss_link_bridge_vss_link_dip_vss_link_m1_vss_x1_vss_x2_vss_x3_t173 r0 *1 0,0
Rg_vss_m1_inv_clk_vss_inv_mc_vss_inv_q_vss_mph_g_nand_m_vss_nand_s2_vss_s1_vss_m1_s2_vss_m1_s3_vss_m1_s4_vss_m1_sb_vss_sr1_vss_sr2_vss_sr3_vss_sr4_vss_sv_vss_tg_d_vss_tg_fbm_vss_tg_fbs_vss_tg_s_vss_vss_vss_link_vss_link_bridge_vss_link_dip_vss_link_m1_vss_x1_vss_x2_vss_x3_t173 vss__t173 vss 274.644680225
* device instance g_vss_m1_inv_clk_vss_inv_mc_vss_inv_q_vss_mph_g_nand_m_vss_nand_s2_vss_s1_vss_m1_s2_vss_m1_s3_vss_m1_s4_vss_m1_sb_vss_sr1_vss_sr2_vss_sr3_vss_sr4_vss_sv_vss_tg_d_vss_tg_fbm_vss_tg_fbs_vss_tg_s_vss_vss_vss_link_vss_link_bridge_vss_link_dip_vss_link_m1_vss_x1_vss_x2_vss_x3_t174 r0 *1 0,0
Rg_vss_m1_inv_clk_vss_inv_mc_vss_inv_q_vss_mph_g_nand_m_vss_nand_s2_vss_s1_vss_m1_s2_vss_m1_s3_vss_m1_s4_vss_m1_sb_vss_sr1_vss_sr2_vss_sr3_vss_sr4_vss_sv_vss_tg_d_vss_tg_fbm_vss_tg_fbs_vss_tg_s_vss_vss_vss_link_vss_link_bridge_vss_link_dip_vss_link_m1_vss_x1_vss_x2_vss_x3_t174 vss__t174 vss 252.076322273
* device instance g_vss_m1_inv_clk_vss_inv_mc_vss_inv_q_vss_mph_g_nand_m_vss_nand_s2_vss_s1_vss_m1_s2_vss_m1_s3_vss_m1_s4_vss_m1_sb_vss_sr1_vss_sr2_vss_sr3_vss_sr4_vss_sv_vss_tg_d_vss_tg_fbm_vss_tg_fbs_vss_tg_s_vss_vss_vss_link_vss_link_bridge_vss_link_dip_vss_link_m1_vss_x1_vss_x2_vss_x3_t175 r0 *1 0,0
Rg_vss_m1_inv_clk_vss_inv_mc_vss_inv_q_vss_mph_g_nand_m_vss_nand_s2_vss_s1_vss_m1_s2_vss_m1_s3_vss_m1_s4_vss_m1_sb_vss_sr1_vss_sr2_vss_sr3_vss_sr4_vss_sv_vss_tg_d_vss_tg_fbm_vss_tg_fbs_vss_tg_s_vss_vss_vss_link_vss_link_bridge_vss_link_dip_vss_link_m1_vss_x1_vss_x2_vss_x3_t175 vss__t175 vss 229.52315698
* device instance g_vss_m1_inv_clk_vss_inv_mc_vss_inv_q_vss_mph_g_nand_m_vss_nand_s2_vss_s1_vss_m1_s2_vss_m1_s3_vss_m1_s4_vss_m1_sb_vss_sr1_vss_sr2_vss_sr3_vss_sr4_vss_sv_vss_tg_d_vss_tg_fbm_vss_tg_fbs_vss_tg_s_vss_vss_vss_link_vss_link_bridge_vss_link_dip_vss_link_m1_vss_x1_vss_x2_vss_x3_t176 r0 *1 0,0
Rg_vss_m1_inv_clk_vss_inv_mc_vss_inv_q_vss_mph_g_nand_m_vss_nand_s2_vss_s1_vss_m1_s2_vss_m1_s3_vss_m1_s4_vss_m1_sb_vss_sr1_vss_sr2_vss_sr3_vss_sr4_vss_sv_vss_tg_d_vss_tg_fbm_vss_tg_fbs_vss_tg_s_vss_vss_vss_link_vss_link_bridge_vss_link_dip_vss_link_m1_vss_x1_vss_x2_vss_x3_t176 vss__t176 vss 205.213370832
* device instance g_vss_m1_inv_clk_vss_inv_mc_vss_inv_q_vss_mph_g_nand_m_vss_nand_s2_vss_s1_vss_m1_s2_vss_m1_s3_vss_m1_s4_vss_m1_sb_vss_sr1_vss_sr2_vss_sr3_vss_sr4_vss_sv_vss_tg_d_vss_tg_fbm_vss_tg_fbs_vss_tg_s_vss_vss_vss_link_vss_link_bridge_vss_link_dip_vss_link_m1_vss_x1_vss_x2_vss_x3_t177 r0 *1 0,0
Rg_vss_m1_inv_clk_vss_inv_mc_vss_inv_q_vss_mph_g_nand_m_vss_nand_s2_vss_s1_vss_m1_s2_vss_m1_s3_vss_m1_s4_vss_m1_sb_vss_sr1_vss_sr2_vss_sr3_vss_sr4_vss_sv_vss_tg_d_vss_tg_fbm_vss_tg_fbs_vss_tg_s_vss_vss_vss_link_vss_link_bridge_vss_link_dip_vss_link_m1_vss_x1_vss_x2_vss_x3_t177 vss__t177 vss 144.879687476
* device instance g_vss_m1_inv_clk_vss_inv_mc_vss_inv_q_vss_mph_g_nand_m_vss_nand_s2_vss_s1_vss_m1_s2_vss_m1_s3_vss_m1_s4_vss_m1_sb_vss_sr1_vss_sr2_vss_sr3_vss_sr4_vss_sv_vss_tg_d_vss_tg_fbm_vss_tg_fbs_vss_tg_s_vss_vss_vss_link_vss_link_bridge_vss_link_dip_vss_link_m1_vss_x1_vss_x2_vss_x3_t178 r0 *1 0,0
Rg_vss_m1_inv_clk_vss_inv_mc_vss_inv_q_vss_mph_g_nand_m_vss_nand_s2_vss_s1_vss_m1_s2_vss_m1_s3_vss_m1_s4_vss_m1_sb_vss_sr1_vss_sr2_vss_sr3_vss_sr4_vss_sv_vss_tg_d_vss_tg_fbm_vss_tg_fbs_vss_tg_s_vss_vss_vss_link_vss_link_bridge_vss_link_dip_vss_link_m1_vss_x1_vss_x2_vss_x3_t178 vss__t178 vss 122.53651707
* device instance g_vss_m1_inv_clk_vss_inv_mc_vss_inv_q_vss_mph_g_nand_m_vss_nand_s2_vss_s1_vss_m1_s2_vss_m1_s3_vss_m1_s4_vss_m1_sb_vss_sr1_vss_sr2_vss_sr3_vss_sr4_vss_sv_vss_tg_d_vss_tg_fbm_vss_tg_fbs_vss_tg_s_vss_vss_vss_link_vss_link_bridge_vss_link_dip_vss_link_m1_vss_x1_vss_x2_vss_x3_t179 r0 *1 0,0
Rg_vss_m1_inv_clk_vss_inv_mc_vss_inv_q_vss_mph_g_nand_m_vss_nand_s2_vss_s1_vss_m1_s2_vss_m1_s3_vss_m1_s4_vss_m1_sb_vss_sr1_vss_sr2_vss_sr3_vss_sr4_vss_sv_vss_tg_d_vss_tg_fbm_vss_tg_fbs_vss_tg_s_vss_vss_vss_link_vss_link_bridge_vss_link_dip_vss_link_m1_vss_x1_vss_x2_vss_x3_t179 vss__t179 vss 100.32899707
* device instance g_vss_m1_inv_clk_vss_inv_mc_vss_inv_q_vss_mph_g_nand_m_vss_nand_s2_vss_s1_vss_m1_s2_vss_m1_s3_vss_m1_s4_vss_m1_sb_vss_sr1_vss_sr2_vss_sr3_vss_sr4_vss_sv_vss_tg_d_vss_tg_fbm_vss_tg_fbs_vss_tg_s_vss_vss_vss_link_vss_link_bridge_vss_link_dip_vss_link_m1_vss_x1_vss_x2_vss_x3_t180 r0 *1 0,0
Rg_vss_m1_inv_clk_vss_inv_mc_vss_inv_q_vss_mph_g_nand_m_vss_nand_s2_vss_s1_vss_m1_s2_vss_m1_s3_vss_m1_s4_vss_m1_sb_vss_sr1_vss_sr2_vss_sr3_vss_sr4_vss_sv_vss_tg_d_vss_tg_fbm_vss_tg_fbs_vss_tg_s_vss_vss_vss_link_vss_link_bridge_vss_link_dip_vss_link_m1_vss_x1_vss_x2_vss_x3_t180 vss__t180 vss 78.3725255147
* device instance g_vss_m1_inv_clk_vss_inv_mc_vss_inv_q_vss_mph_g_nand_m_vss_nand_s2_vss_s1_vss_m1_s2_vss_m1_s3_vss_m1_s4_vss_m1_sb_vss_sr1_vss_sr2_vss_sr3_vss_sr4_vss_sv_vss_tg_d_vss_tg_fbm_vss_tg_fbs_vss_tg_s_vss_vss_vss_link_vss_link_bridge_vss_link_dip_vss_link_m1_vss_x1_vss_x2_vss_x3_t181 r0 *1 0,0
Rg_vss_m1_inv_clk_vss_inv_mc_vss_inv_q_vss_mph_g_nand_m_vss_nand_s2_vss_s1_vss_m1_s2_vss_m1_s3_vss_m1_s4_vss_m1_sb_vss_sr1_vss_sr2_vss_sr3_vss_sr4_vss_sv_vss_tg_d_vss_tg_fbm_vss_tg_fbs_vss_tg_s_vss_vss_vss_link_vss_link_bridge_vss_link_dip_vss_link_m1_vss_x1_vss_x2_vss_x3_t181 vss__t181 vss 55.3103554581
* device instance g_vss_m1_inv_clk_vss_inv_mc_vss_inv_q_vss_mph_g_nand_m_vss_nand_s2_vss_s1_vss_m1_s2_vss_m1_s3_vss_m1_s4_vss_m1_sb_vss_sr1_vss_sr2_vss_sr3_vss_sr4_vss_sv_vss_tg_d_vss_tg_fbm_vss_tg_fbs_vss_tg_s_vss_vss_vss_link_vss_link_bridge_vss_link_dip_vss_link_m1_vss_x1_vss_x2_vss_x3_t182 r0 *1 0,0
Rg_vss_m1_inv_clk_vss_inv_mc_vss_inv_q_vss_mph_g_nand_m_vss_nand_s2_vss_s1_vss_m1_s2_vss_m1_s3_vss_m1_s4_vss_m1_sb_vss_sr1_vss_sr2_vss_sr3_vss_sr4_vss_sv_vss_tg_d_vss_tg_fbm_vss_tg_fbs_vss_tg_s_vss_vss_vss_link_vss_link_bridge_vss_link_dip_vss_link_m1_vss_x1_vss_x2_vss_x3_t182 vss__t182 vss 23.8651222667
* device instance g_vss_m1_inv_clk_vss_inv_mc_vss_inv_q_vss_mph_g_nand_m_vss_nand_s2_vss_s1_vss_m1_s2_vss_m1_s3_vss_m1_s4_vss_m1_sb_vss_sr1_vss_sr2_vss_sr3_vss_sr4_vss_sv_vss_tg_d_vss_tg_fbm_vss_tg_fbs_vss_tg_s_vss_vss_vss_link_vss_link_bridge_vss_link_dip_vss_link_m1_vss_x1_vss_x2_vss_x3_t183 r0 *1 0,0
Rg_vss_m1_inv_clk_vss_inv_mc_vss_inv_q_vss_mph_g_nand_m_vss_nand_s2_vss_s1_vss_m1_s2_vss_m1_s3_vss_m1_s4_vss_m1_sb_vss_sr1_vss_sr2_vss_sr3_vss_sr4_vss_sv_vss_tg_d_vss_tg_fbm_vss_tg_fbs_vss_tg_s_vss_vss_vss_link_vss_link_bridge_vss_link_dip_vss_link_m1_vss_x1_vss_x2_vss_x3_t183 vss__t183 vss 39.1478734575
* device instance g_vss_m1_inv_clk_vss_inv_mc_vss_inv_q_vss_mph_g_nand_m_vss_nand_s2_vss_s1_vss_m1_s2_vss_m1_s3_vss_m1_s4_vss_m1_sb_vss_sr1_vss_sr2_vss_sr3_vss_sr4_vss_sv_vss_tg_d_vss_tg_fbm_vss_tg_fbs_vss_tg_s_vss_vss_vss_link_vss_link_bridge_vss_link_dip_vss_link_m1_vss_x1_vss_x2_vss_x3_t184 r0 *1 0,0
Rg_vss_m1_inv_clk_vss_inv_mc_vss_inv_q_vss_mph_g_nand_m_vss_nand_s2_vss_s1_vss_m1_s2_vss_m1_s3_vss_m1_s4_vss_m1_sb_vss_sr1_vss_sr2_vss_sr3_vss_sr4_vss_sv_vss_tg_d_vss_tg_fbm_vss_tg_fbs_vss_tg_s_vss_vss_vss_link_vss_link_bridge_vss_link_dip_vss_link_m1_vss_x1_vss_x2_vss_x3_t184 vss__t184 vss 59.3397286531
* device instance g_vss_m1_inv_clk_vss_inv_mc_vss_inv_q_vss_mph_g_nand_m_vss_nand_s2_vss_s1_vss_m1_s2_vss_m1_s3_vss_m1_s4_vss_m1_sb_vss_sr1_vss_sr2_vss_sr3_vss_sr4_vss_sv_vss_tg_d_vss_tg_fbm_vss_tg_fbs_vss_tg_s_vss_vss_vss_link_vss_link_bridge_vss_link_dip_vss_link_m1_vss_x1_vss_x2_vss_x3_t185 r0 *1 0,0
Rg_vss_m1_inv_clk_vss_inv_mc_vss_inv_q_vss_mph_g_nand_m_vss_nand_s2_vss_s1_vss_m1_s2_vss_m1_s3_vss_m1_s4_vss_m1_sb_vss_sr1_vss_sr2_vss_sr3_vss_sr4_vss_sv_vss_tg_d_vss_tg_fbm_vss_tg_fbs_vss_tg_s_vss_vss_vss_link_vss_link_bridge_vss_link_dip_vss_link_m1_vss_x1_vss_x2_vss_x3_t185 vss__t185 vss 80.8423543816
* device instance g_vss_m1_inv_clk_vss_inv_mc_vss_inv_q_vss_mph_g_nand_m_vss_nand_s2_vss_s1_vss_m1_s2_vss_m1_s3_vss_m1_s4_vss_m1_sb_vss_sr1_vss_sr2_vss_sr3_vss_sr4_vss_sv_vss_tg_d_vss_tg_fbm_vss_tg_fbs_vss_tg_s_vss_vss_vss_link_vss_link_bridge_vss_link_dip_vss_link_m1_vss_x1_vss_x2_vss_x3_t186 r0 *1 0,0
Rg_vss_m1_inv_clk_vss_inv_mc_vss_inv_q_vss_mph_g_nand_m_vss_nand_s2_vss_s1_vss_m1_s2_vss_m1_s3_vss_m1_s4_vss_m1_sb_vss_sr1_vss_sr2_vss_sr3_vss_sr4_vss_sv_vss_tg_d_vss_tg_fbm_vss_tg_fbs_vss_tg_s_vss_vss_vss_link_vss_link_bridge_vss_link_dip_vss_link_m1_vss_x1_vss_x2_vss_x3_t186 vss__t186 vss 104.583954862
* device instance g_vss_m1_inv_clk_vss_inv_mc_vss_inv_q_vss_mph_g_nand_m_vss_nand_s2_vss_s1_vss_m1_s2_vss_m1_s3_vss_m1_s4_vss_m1_sb_vss_sr1_vss_sr2_vss_sr3_vss_sr4_vss_sv_vss_tg_d_vss_tg_fbm_vss_tg_fbs_vss_tg_s_vss_vss_vss_link_vss_link_bridge_vss_link_dip_vss_link_m1_vss_x1_vss_x2_vss_x3_t187 r0 *1 0,0
Rg_vss_m1_inv_clk_vss_inv_mc_vss_inv_q_vss_mph_g_nand_m_vss_nand_s2_vss_s1_vss_m1_s2_vss_m1_s3_vss_m1_s4_vss_m1_sb_vss_sr1_vss_sr2_vss_sr3_vss_sr4_vss_sv_vss_tg_d_vss_tg_fbm_vss_tg_fbs_vss_tg_s_vss_vss_vss_link_vss_link_bridge_vss_link_dip_vss_link_m1_vss_x1_vss_x2_vss_x3_t187 vss__t187 vss 164.562524955
* device instance g_vss_m1_inv_clk_vss_inv_mc_vss_inv_q_vss_mph_g_nand_m_vss_nand_s2_vss_s1_vss_m1_s2_vss_m1_s3_vss_m1_s4_vss_m1_sb_vss_sr1_vss_sr2_vss_sr3_vss_sr4_vss_sv_vss_tg_d_vss_tg_fbm_vss_tg_fbs_vss_tg_s_vss_vss_vss_link_vss_link_bridge_vss_link_dip_vss_link_m1_vss_x1_vss_x2_vss_x3_t188 r0 *1 0,0
Rg_vss_m1_inv_clk_vss_inv_mc_vss_inv_q_vss_mph_g_nand_m_vss_nand_s2_vss_s1_vss_m1_s2_vss_m1_s3_vss_m1_s4_vss_m1_sb_vss_sr1_vss_sr2_vss_sr3_vss_sr4_vss_sv_vss_tg_d_vss_tg_fbm_vss_tg_fbs_vss_tg_s_vss_vss_vss_link_vss_link_bridge_vss_link_dip_vss_link_m1_vss_x1_vss_x2_vss_x3_t188 vss__t188 vss 187.034152811
* device instance g_vss_m1_inv_clk_vss_inv_mc_vss_inv_q_vss_mph_g_nand_m_vss_nand_s2_vss_s1_vss_m1_s2_vss_m1_s3_vss_m1_s4_vss_m1_sb_vss_sr1_vss_sr2_vss_sr3_vss_sr4_vss_sv_vss_tg_d_vss_tg_fbm_vss_tg_fbs_vss_tg_s_vss_vss_vss_link_vss_link_bridge_vss_link_dip_vss_link_m1_vss_x1_vss_x2_vss_x3_t189 r0 *1 0,0
Rg_vss_m1_inv_clk_vss_inv_mc_vss_inv_q_vss_mph_g_nand_m_vss_nand_s2_vss_s1_vss_m1_s2_vss_m1_s3_vss_m1_s4_vss_m1_sb_vss_sr1_vss_sr2_vss_sr3_vss_sr4_vss_sv_vss_tg_d_vss_tg_fbm_vss_tg_fbs_vss_tg_s_vss_vss_vss_link_vss_link_bridge_vss_link_dip_vss_link_m1_vss_x1_vss_x2_vss_x3_t189 vss__t189 vss 209.543216261
* device instance g_vss_m1_inv_clk_vss_inv_mc_vss_inv_q_vss_mph_g_nand_m_vss_nand_s2_vss_s1_vss_m1_s2_vss_m1_s3_vss_m1_s4_vss_m1_sb_vss_sr1_vss_sr2_vss_sr3_vss_sr4_vss_sv_vss_tg_d_vss_tg_fbm_vss_tg_fbs_vss_tg_s_vss_vss_vss_link_vss_link_bridge_vss_link_dip_vss_link_m1_vss_x1_vss_x2_vss_x3_t190 r0 *1 0,0
Rg_vss_m1_inv_clk_vss_inv_mc_vss_inv_q_vss_mph_g_nand_m_vss_nand_s2_vss_s1_vss_m1_s2_vss_m1_s3_vss_m1_s4_vss_m1_sb_vss_sr1_vss_sr2_vss_sr3_vss_sr4_vss_sv_vss_tg_d_vss_tg_fbm_vss_tg_fbs_vss_tg_s_vss_vss_vss_link_vss_link_bridge_vss_link_dip_vss_link_m1_vss_x1_vss_x2_vss_x3_t190 vss__t190 vss 232.078823052
* device instance g_vss_m1_inv_clk_vss_inv_mc_vss_inv_q_vss_mph_g_nand_m_vss_nand_s2_vss_s1_vss_m1_s2_vss_m1_s3_vss_m1_s4_vss_m1_sb_vss_sr1_vss_sr2_vss_sr3_vss_sr4_vss_sv_vss_tg_d_vss_tg_fbm_vss_tg_fbs_vss_tg_s_vss_vss_vss_link_vss_link_bridge_vss_link_dip_vss_link_m1_vss_x1_vss_x2_vss_x3_t191 r0 *1 0,0
Rg_vss_m1_inv_clk_vss_inv_mc_vss_inv_q_vss_mph_g_nand_m_vss_nand_s2_vss_s1_vss_m1_s2_vss_m1_s3_vss_m1_s4_vss_m1_sb_vss_sr1_vss_sr2_vss_sr3_vss_sr4_vss_sv_vss_tg_d_vss_tg_fbm_vss_tg_fbs_vss_tg_s_vss_vss_vss_link_vss_link_bridge_vss_link_dip_vss_link_m1_vss_x1_vss_x2_vss_x3_t191 vss__t191 vss 256.414180866
* device instance g_vss_m1_inv_clk_vss_inv_mc_vss_inv_q_vss_mph_g_nand_m_vss_nand_s2_vss_s1_vss_m1_s2_vss_m1_s3_vss_m1_s4_vss_m1_sb_vss_sr1_vss_sr2_vss_sr3_vss_sr4_vss_sv_vss_tg_d_vss_tg_fbm_vss_tg_fbs_vss_tg_s_vss_vss_vss_link_vss_link_bridge_vss_link_dip_vss_link_m1_vss_x1_vss_x2_vss_x3_t192 r0 *1 0,0
Rg_vss_m1_inv_clk_vss_inv_mc_vss_inv_q_vss_mph_g_nand_m_vss_nand_s2_vss_s1_vss_m1_s2_vss_m1_s3_vss_m1_s4_vss_m1_sb_vss_sr1_vss_sr2_vss_sr3_vss_sr4_vss_sv_vss_tg_d_vss_tg_fbm_vss_tg_fbs_vss_tg_s_vss_vss_vss_link_vss_link_bridge_vss_link_dip_vss_link_m1_vss_x1_vss_x2_vss_x3_t192 vss__t192 vss 337.361037403
* device instance g_vss_m1_inv_clk_vss_inv_mc_vss_inv_q_vss_mph_g_nand_m_vss_nand_s2_vss_s1_vss_m1_s2_vss_m1_s3_vss_m1_s4_vss_m1_sb_vss_sr1_vss_sr2_vss_sr3_vss_sr4_vss_sv_vss_tg_d_vss_tg_fbm_vss_tg_fbs_vss_tg_s_vss_vss_vss_link_vss_link_bridge_vss_link_dip_vss_link_m1_vss_x1_vss_x2_vss_x3_t193 r0 *1 0,0
Rg_vss_m1_inv_clk_vss_inv_mc_vss_inv_q_vss_mph_g_nand_m_vss_nand_s2_vss_s1_vss_m1_s2_vss_m1_s3_vss_m1_s4_vss_m1_sb_vss_sr1_vss_sr2_vss_sr3_vss_sr4_vss_sv_vss_tg_d_vss_tg_fbm_vss_tg_fbs_vss_tg_s_vss_vss_vss_link_vss_link_bridge_vss_link_dip_vss_link_m1_vss_x1_vss_x2_vss_x3_t193 vss__t193 vss 288.326263217
* device instance g_vss_m1_inv_clk_vss_inv_mc_vss_inv_q_vss_mph_g_nand_m_vss_nand_s2_vss_s1_vss_m1_s2_vss_m1_s3_vss_m1_s4_vss_m1_sb_vss_sr1_vss_sr2_vss_sr3_vss_sr4_vss_sv_vss_tg_d_vss_tg_fbm_vss_tg_fbs_vss_tg_s_vss_vss_vss_link_vss_link_bridge_vss_link_dip_vss_link_m1_vss_x1_vss_x2_vss_x3_t194 r0 *1 0,0
Rg_vss_m1_inv_clk_vss_inv_mc_vss_inv_q_vss_mph_g_nand_m_vss_nand_s2_vss_s1_vss_m1_s2_vss_m1_s3_vss_m1_s4_vss_m1_sb_vss_sr1_vss_sr2_vss_sr3_vss_sr4_vss_sv_vss_tg_d_vss_tg_fbm_vss_tg_fbs_vss_tg_s_vss_vss_vss_link_vss_link_bridge_vss_link_dip_vss_link_m1_vss_x1_vss_x2_vss_x3_t194 vss__t194 vss 259.440105674
* device instance g_vss_m1_inv_clk_vss_inv_mc_vss_inv_q_vss_mph_g_nand_m_vss_nand_s2_vss_s1_vss_m1_s2_vss_m1_s3_vss_m1_s4_vss_m1_sb_vss_sr1_vss_sr2_vss_sr3_vss_sr4_vss_sv_vss_tg_d_vss_tg_fbm_vss_tg_fbs_vss_tg_s_vss_vss_vss_link_vss_link_bridge_vss_link_dip_vss_link_m1_vss_x1_vss_x2_vss_x3_t195 r0 *1 0,0
Rg_vss_m1_inv_clk_vss_inv_mc_vss_inv_q_vss_mph_g_nand_m_vss_nand_s2_vss_s1_vss_m1_s2_vss_m1_s3_vss_m1_s4_vss_m1_sb_vss_sr1_vss_sr2_vss_sr3_vss_sr4_vss_sv_vss_tg_d_vss_tg_fbm_vss_tg_fbs_vss_tg_s_vss_vss_vss_link_vss_link_bridge_vss_link_dip_vss_link_m1_vss_x1_vss_x2_vss_x3_t195 vss__t195 vss 211.445675363
* device instance g_vss_m1_inv_clk_vss_inv_mc_vss_inv_q_vss_mph_g_nand_m_vss_nand_s2_vss_s1_vss_m1_s2_vss_m1_s3_vss_m1_s4_vss_m1_sb_vss_sr1_vss_sr2_vss_sr3_vss_sr4_vss_sv_vss_tg_d_vss_tg_fbm_vss_tg_fbs_vss_tg_s_vss_vss_vss_link_vss_link_bridge_vss_link_dip_vss_link_m1_vss_x1_vss_x2_vss_x3_t196 r0 *1 0,0
Rg_vss_m1_inv_clk_vss_inv_mc_vss_inv_q_vss_mph_g_nand_m_vss_nand_s2_vss_s1_vss_m1_s2_vss_m1_s3_vss_m1_s4_vss_m1_sb_vss_sr1_vss_sr2_vss_sr3_vss_sr4_vss_sv_vss_tg_d_vss_tg_fbm_vss_tg_fbs_vss_tg_s_vss_vss_vss_link_vss_link_bridge_vss_link_dip_vss_link_m1_vss_x1_vss_x2_vss_x3_t196 vss__t196 vss 183.536990297
* device instance g_vss_m1_inv_clk_vss_inv_mc_vss_inv_q_vss_mph_g_nand_m_vss_nand_s2_vss_s1_vss_m1_s2_vss_m1_s3_vss_m1_s4_vss_m1_sb_vss_sr1_vss_sr2_vss_sr3_vss_sr4_vss_sv_vss_tg_d_vss_tg_fbm_vss_tg_fbs_vss_tg_s_vss_vss_vss_link_vss_link_bridge_vss_link_dip_vss_link_m1_vss_x1_vss_x2_vss_x3_t197 r0 *1 0,0
Rg_vss_m1_inv_clk_vss_inv_mc_vss_inv_q_vss_mph_g_nand_m_vss_nand_s2_vss_s1_vss_m1_s2_vss_m1_s3_vss_m1_s4_vss_m1_sb_vss_sr1_vss_sr2_vss_sr3_vss_sr4_vss_sv_vss_tg_d_vss_tg_fbm_vss_tg_fbs_vss_tg_s_vss_vss_vss_link_vss_link_bridge_vss_link_dip_vss_link_m1_vss_x1_vss_x2_vss_x3_t197 vss__t197 vss 138.443030519
* device instance g_vss_m1_inv_clk_vss_inv_mc_vss_inv_q_vss_mph_g_nand_m_vss_nand_s2_vss_s1_vss_m1_s2_vss_m1_s3_vss_m1_s4_vss_m1_sb_vss_sr1_vss_sr2_vss_sr3_vss_sr4_vss_sv_vss_tg_d_vss_tg_fbm_vss_tg_fbs_vss_tg_s_vss_vss_vss_link_vss_link_bridge_vss_link_dip_vss_link_m1_vss_x1_vss_x2_vss_x3_t198 r0 *1 0,0
Rg_vss_m1_inv_clk_vss_inv_mc_vss_inv_q_vss_mph_g_nand_m_vss_nand_s2_vss_s1_vss_m1_s2_vss_m1_s3_vss_m1_s4_vss_m1_sb_vss_sr1_vss_sr2_vss_sr3_vss_sr4_vss_sv_vss_tg_d_vss_tg_fbm_vss_tg_fbs_vss_tg_s_vss_vss_vss_link_vss_link_bridge_vss_link_dip_vss_link_m1_vss_x1_vss_x2_vss_x3_t198 vss__t198 vss 330.123479448
* device instance g_vss_m1_inv_clk_vss_inv_mc_vss_inv_q_vss_mph_g_nand_m_vss_nand_s2_vss_s1_vss_m1_s2_vss_m1_s3_vss_m1_s4_vss_m1_sb_vss_sr1_vss_sr2_vss_sr3_vss_sr4_vss_sv_vss_tg_d_vss_tg_fbm_vss_tg_fbs_vss_tg_s_vss_vss_vss_link_vss_link_bridge_vss_link_dip_vss_link_m1_vss_x1_vss_x2_vss_x3_t199 r0 *1 0,0
Rg_vss_m1_inv_clk_vss_inv_mc_vss_inv_q_vss_mph_g_nand_m_vss_nand_s2_vss_s1_vss_m1_s2_vss_m1_s3_vss_m1_s4_vss_m1_sb_vss_sr1_vss_sr2_vss_sr3_vss_sr4_vss_sv_vss_tg_d_vss_tg_fbm_vss_tg_fbs_vss_tg_s_vss_vss_vss_link_vss_link_bridge_vss_link_dip_vss_link_m1_vss_x1_vss_x2_vss_x3_t199 vss__t199 vss 304.422056852
* device instance g_vss_m1_inv_clk_vss_inv_mc_vss_inv_q_vss_mph_g_nand_m_vss_nand_s2_vss_s1_vss_m1_s2_vss_m1_s3_vss_m1_s4_vss_m1_sb_vss_sr1_vss_sr2_vss_sr3_vss_sr4_vss_sv_vss_tg_d_vss_tg_fbm_vss_tg_fbs_vss_tg_s_vss_vss_vss_link_vss_link_bridge_vss_link_dip_vss_link_m1_vss_x1_vss_x2_vss_x3_t200 r0 *1 0,0
Rg_vss_m1_inv_clk_vss_inv_mc_vss_inv_q_vss_mph_g_nand_m_vss_nand_s2_vss_s1_vss_m1_s2_vss_m1_s3_vss_m1_s4_vss_m1_sb_vss_sr1_vss_sr2_vss_sr3_vss_sr4_vss_sv_vss_tg_d_vss_tg_fbm_vss_tg_fbs_vss_tg_s_vss_vss_vss_link_vss_link_bridge_vss_link_dip_vss_link_m1_vss_x1_vss_x2_vss_x3_t200 vss__t200 vss 281.838786931
* device instance g_vss_m1_inv_clk_vss_inv_mc_vss_inv_q_vss_mph_g_nand_m_vss_nand_s2_vss_s1_vss_m1_s2_vss_m1_s3_vss_m1_s4_vss_m1_sb_vss_sr1_vss_sr2_vss_sr3_vss_sr4_vss_sv_vss_tg_d_vss_tg_fbm_vss_tg_fbs_vss_tg_s_vss_vss_vss_link_vss_link_bridge_vss_link_dip_vss_link_m1_vss_x1_vss_x2_vss_x3_t201 r0 *1 0,0
Rg_vss_m1_inv_clk_vss_inv_mc_vss_inv_q_vss_mph_g_nand_m_vss_nand_s2_vss_s1_vss_m1_s2_vss_m1_s3_vss_m1_s4_vss_m1_sb_vss_sr1_vss_sr2_vss_sr3_vss_sr4_vss_sv_vss_tg_d_vss_tg_fbm_vss_tg_fbs_vss_tg_s_vss_vss_vss_link_vss_link_bridge_vss_link_dip_vss_link_m1_vss_x1_vss_x2_vss_x3_t201 vss__t201 vss 259.266369598
* device instance g_vss_m1_inv_clk_vss_inv_mc_vss_inv_q_vss_mph_g_nand_m_vss_nand_s2_vss_s1_vss_m1_s2_vss_m1_s3_vss_m1_s4_vss_m1_sb_vss_sr1_vss_sr2_vss_sr3_vss_sr4_vss_sv_vss_tg_d_vss_tg_fbm_vss_tg_fbs_vss_tg_s_vss_vss_vss_link_vss_link_bridge_vss_link_dip_vss_link_m1_vss_x1_vss_x2_vss_x3_t202 r0 *1 0,0
Rg_vss_m1_inv_clk_vss_inv_mc_vss_inv_q_vss_mph_g_nand_m_vss_nand_s2_vss_s1_vss_m1_s2_vss_m1_s3_vss_m1_s4_vss_m1_sb_vss_sr1_vss_sr2_vss_sr3_vss_sr4_vss_sv_vss_tg_d_vss_tg_fbm_vss_tg_fbs_vss_tg_s_vss_vss_vss_link_vss_link_bridge_vss_link_dip_vss_link_m1_vss_x1_vss_x2_vss_x3_t202 vss__t202 vss 236.707909574
* device instance g_vss_m1_inv_clk_vss_inv_mc_vss_inv_q_vss_mph_g_nand_m_vss_nand_s2_vss_s1_vss_m1_s2_vss_m1_s3_vss_m1_s4_vss_m1_sb_vss_sr1_vss_sr2_vss_sr3_vss_sr4_vss_sv_vss_tg_d_vss_tg_fbm_vss_tg_fbs_vss_tg_s_vss_vss_vss_link_vss_link_bridge_vss_link_dip_vss_link_m1_vss_x1_vss_x2_vss_x3_t203 r0 *1 0,0
Rg_vss_m1_inv_clk_vss_inv_mc_vss_inv_q_vss_mph_g_nand_m_vss_nand_s2_vss_s1_vss_m1_s2_vss_m1_s3_vss_m1_s4_vss_m1_sb_vss_sr1_vss_sr2_vss_sr3_vss_sr4_vss_sv_vss_tg_d_vss_tg_fbm_vss_tg_fbs_vss_tg_s_vss_vss_vss_link_vss_link_bridge_vss_link_dip_vss_link_m1_vss_x1_vss_x2_vss_x3_t203 vss__t203 vss 177.55440599
* device instance g_vss_m1_inv_clk_vss_inv_mc_vss_inv_q_vss_mph_g_nand_m_vss_nand_s2_vss_s1_vss_m1_s2_vss_m1_s3_vss_m1_s4_vss_m1_sb_vss_sr1_vss_sr2_vss_sr3_vss_sr4_vss_sv_vss_tg_d_vss_tg_fbm_vss_tg_fbs_vss_tg_s_vss_vss_vss_link_vss_link_bridge_vss_link_dip_vss_link_m1_vss_x1_vss_x2_vss_x3_t204 r0 *1 0,0
Rg_vss_m1_inv_clk_vss_inv_mc_vss_inv_q_vss_mph_g_nand_m_vss_nand_s2_vss_s1_vss_m1_s2_vss_m1_s3_vss_m1_s4_vss_m1_sb_vss_sr1_vss_sr2_vss_sr3_vss_sr4_vss_sv_vss_tg_d_vss_tg_fbm_vss_tg_fbs_vss_tg_s_vss_vss_vss_link_vss_link_bridge_vss_link_dip_vss_link_m1_vss_x1_vss_x2_vss_x3_t204 vss__t204 vss 152.018235557
* device instance g_vss_m1_inv_clk_vss_inv_mc_vss_inv_q_vss_mph_g_nand_m_vss_nand_s2_vss_s1_vss_m1_s2_vss_m1_s3_vss_m1_s4_vss_m1_sb_vss_sr1_vss_sr2_vss_sr3_vss_sr4_vss_sv_vss_tg_d_vss_tg_fbm_vss_tg_fbs_vss_tg_s_vss_vss_vss_link_vss_link_bridge_vss_link_dip_vss_link_m1_vss_x1_vss_x2_vss_x3_t205 r0 *1 0,0
Rg_vss_m1_inv_clk_vss_inv_mc_vss_inv_q_vss_mph_g_nand_m_vss_nand_s2_vss_s1_vss_m1_s2_vss_m1_s3_vss_m1_s4_vss_m1_sb_vss_sr1_vss_sr2_vss_sr3_vss_sr4_vss_sv_vss_tg_d_vss_tg_fbm_vss_tg_fbs_vss_tg_s_vss_vss_vss_link_vss_link_bridge_vss_link_dip_vss_link_m1_vss_x1_vss_x2_vss_x3_t205 vss__t205 vss 129.644879673
* device instance g_vss_m1_inv_clk_vss_inv_mc_vss_inv_q_vss_mph_g_nand_m_vss_nand_s2_vss_s1_vss_m1_s2_vss_m1_s3_vss_m1_s4_vss_m1_sb_vss_sr1_vss_sr2_vss_sr3_vss_sr4_vss_sv_vss_tg_d_vss_tg_fbm_vss_tg_fbs_vss_tg_s_vss_vss_vss_link_vss_link_bridge_vss_link_dip_vss_link_m1_vss_x1_vss_x2_vss_x3_t206 r0 *1 0,0
Rg_vss_m1_inv_clk_vss_inv_mc_vss_inv_q_vss_mph_g_nand_m_vss_nand_s2_vss_s1_vss_m1_s2_vss_m1_s3_vss_m1_s4_vss_m1_sb_vss_sr1_vss_sr2_vss_sr3_vss_sr4_vss_sv_vss_tg_d_vss_tg_fbm_vss_tg_fbs_vss_tg_s_vss_vss_vss_link_vss_link_bridge_vss_link_dip_vss_link_m1_vss_x1_vss_x2_vss_x3_t206 vss__t206 vss 107.38566559
* device instance g_vss_m1_inv_clk_vss_inv_mc_vss_inv_q_vss_mph_g_nand_m_vss_nand_s2_vss_s1_vss_m1_s2_vss_m1_s3_vss_m1_s4_vss_m1_sb_vss_sr1_vss_sr2_vss_sr3_vss_sr4_vss_sv_vss_tg_d_vss_tg_fbm_vss_tg_fbs_vss_tg_s_vss_vss_vss_link_vss_link_bridge_vss_link_dip_vss_link_m1_vss_x1_vss_x2_vss_x3_t207 r0 *1 0,0
Rg_vss_m1_inv_clk_vss_inv_mc_vss_inv_q_vss_mph_g_nand_m_vss_nand_s2_vss_s1_vss_m1_s2_vss_m1_s3_vss_m1_s4_vss_m1_sb_vss_sr1_vss_sr2_vss_sr3_vss_sr4_vss_sv_vss_tg_d_vss_tg_fbm_vss_tg_fbs_vss_tg_s_vss_vss_vss_link_vss_link_bridge_vss_link_dip_vss_link_m1_vss_x1_vss_x2_vss_x3_t207 vss__t207 vss 85.329965357
* device instance g_vss_m1_inv_clk_vss_inv_mc_vss_inv_q_vss_mph_g_nand_m_vss_nand_s2_vss_s1_vss_m1_s2_vss_m1_s3_vss_m1_s4_vss_m1_sb_vss_sr1_vss_sr2_vss_sr3_vss_sr4_vss_sv_vss_tg_d_vss_tg_fbm_vss_tg_fbs_vss_tg_s_vss_vss_vss_link_vss_link_bridge_vss_link_dip_vss_link_m1_vss_x1_vss_x2_vss_x3_t208 r0 *1 0,0
Rg_vss_m1_inv_clk_vss_inv_mc_vss_inv_q_vss_mph_g_nand_m_vss_nand_s2_vss_s1_vss_m1_s2_vss_m1_s3_vss_m1_s4_vss_m1_sb_vss_sr1_vss_sr2_vss_sr3_vss_sr4_vss_sv_vss_tg_d_vss_tg_fbm_vss_tg_fbs_vss_tg_s_vss_vss_vss_link_vss_link_bridge_vss_link_dip_vss_link_m1_vss_x1_vss_x2_vss_x3_t208 vss__t208 vss 31.6462135368
* device instance g_vss_m1_inv_clk_vss_inv_mc_vss_inv_q_vss_mph_g_nand_m_vss_nand_s2_vss_s1_vss_m1_s2_vss_m1_s3_vss_m1_s4_vss_m1_sb_vss_sr1_vss_sr2_vss_sr3_vss_sr4_vss_sv_vss_tg_d_vss_tg_fbm_vss_tg_fbs_vss_tg_s_vss_vss_vss_link_vss_link_bridge_vss_link_dip_vss_link_m1_vss_x1_vss_x2_vss_x3_t209 r0 *1 0,0
Rg_vss_m1_inv_clk_vss_inv_mc_vss_inv_q_vss_mph_g_nand_m_vss_nand_s2_vss_s1_vss_m1_s2_vss_m1_s3_vss_m1_s4_vss_m1_sb_vss_sr1_vss_sr2_vss_sr3_vss_sr4_vss_sv_vss_tg_d_vss_tg_fbm_vss_tg_fbs_vss_tg_s_vss_vss_vss_link_vss_link_bridge_vss_link_dip_vss_link_m1_vss_x1_vss_x2_vss_x3_t209 vss__t209 vss 21.866859099
* device instance g_vss_m1_inv_clk_vss_inv_mc_vss_inv_q_vss_mph_g_nand_m_vss_nand_s2_vss_s1_vss_m1_s2_vss_m1_s3_vss_m1_s4_vss_m1_sb_vss_sr1_vss_sr2_vss_sr3_vss_sr4_vss_sv_vss_tg_d_vss_tg_fbm_vss_tg_fbs_vss_tg_s_vss_vss_vss_link_vss_link_bridge_vss_link_dip_vss_link_m1_vss_x1_vss_x2_vss_x3_t210 r0 *1 0,0
Rg_vss_m1_inv_clk_vss_inv_mc_vss_inv_q_vss_mph_g_nand_m_vss_nand_s2_vss_s1_vss_m1_s2_vss_m1_s3_vss_m1_s4_vss_m1_sb_vss_sr1_vss_sr2_vss_sr3_vss_sr4_vss_sv_vss_tg_d_vss_tg_fbm_vss_tg_fbs_vss_tg_s_vss_vss_vss_link_vss_link_bridge_vss_link_dip_vss_link_m1_vss_x1_vss_x2_vss_x3_t210 vss__t210 vss 33.3818539549
* device instance g_vss_m1_inv_clk_vss_inv_mc_vss_inv_q_vss_mph_g_nand_m_vss_nand_s2_vss_s1_vss_m1_s2_vss_m1_s3_vss_m1_s4_vss_m1_sb_vss_sr1_vss_sr2_vss_sr3_vss_sr4_vss_sv_vss_tg_d_vss_tg_fbm_vss_tg_fbs_vss_tg_s_vss_vss_vss_link_vss_link_bridge_vss_link_dip_vss_link_m1_vss_x1_vss_x2_vss_x3_t211 r0 *1 0,0
Rg_vss_m1_inv_clk_vss_inv_mc_vss_inv_q_vss_mph_g_nand_m_vss_nand_s2_vss_s1_vss_m1_s2_vss_m1_s3_vss_m1_s4_vss_m1_sb_vss_sr1_vss_sr2_vss_sr3_vss_sr4_vss_sv_vss_tg_d_vss_tg_fbm_vss_tg_fbs_vss_tg_s_vss_vss_vss_link_vss_link_bridge_vss_link_dip_vss_link_m1_vss_x1_vss_x2_vss_x3_t211 vss__t211 vss 52.6893944264
* device instance g_vss_m1_inv_clk_vss_inv_mc_vss_inv_q_vss_mph_g_nand_m_vss_nand_s2_vss_s1_vss_m1_s2_vss_m1_s3_vss_m1_s4_vss_m1_sb_vss_sr1_vss_sr2_vss_sr3_vss_sr4_vss_sv_vss_tg_d_vss_tg_fbm_vss_tg_fbs_vss_tg_s_vss_vss_vss_link_vss_link_bridge_vss_link_dip_vss_link_m1_vss_x1_vss_x2_vss_x3_t212 r0 *1 0,0
Rg_vss_m1_inv_clk_vss_inv_mc_vss_inv_q_vss_mph_g_nand_m_vss_nand_s2_vss_s1_vss_m1_s2_vss_m1_s3_vss_m1_s4_vss_m1_sb_vss_sr1_vss_sr2_vss_sr3_vss_sr4_vss_sv_vss_tg_d_vss_tg_fbm_vss_tg_fbs_vss_tg_s_vss_vss_vss_link_vss_link_bridge_vss_link_dip_vss_link_m1_vss_x1_vss_x2_vss_x3_t212 vss__t212 vss 73.9163842563
* device instance g_vss_m1_inv_clk_vss_inv_mc_vss_inv_q_vss_mph_g_nand_m_vss_nand_s2_vss_s1_vss_m1_s2_vss_m1_s3_vss_m1_s4_vss_m1_sb_vss_sr1_vss_sr2_vss_sr3_vss_sr4_vss_sv_vss_tg_d_vss_tg_fbm_vss_tg_fbs_vss_tg_s_vss_vss_vss_link_vss_link_bridge_vss_link_dip_vss_link_m1_vss_x1_vss_x2_vss_x3_t213 r0 *1 0,0
Rg_vss_m1_inv_clk_vss_inv_mc_vss_inv_q_vss_mph_g_nand_m_vss_nand_s2_vss_s1_vss_m1_s2_vss_m1_s3_vss_m1_s4_vss_m1_sb_vss_sr1_vss_sr2_vss_sr3_vss_sr4_vss_sv_vss_tg_d_vss_tg_fbm_vss_tg_fbs_vss_tg_s_vss_vss_vss_link_vss_link_bridge_vss_link_dip_vss_link_m1_vss_x1_vss_x2_vss_x3_t213 vss__t213 vss 131.944150749
* device instance g_vss_m1_inv_clk_vss_inv_mc_vss_inv_q_vss_mph_g_nand_m_vss_nand_s2_vss_s1_vss_m1_s2_vss_m1_s3_vss_m1_s4_vss_m1_sb_vss_sr1_vss_sr2_vss_sr3_vss_sr4_vss_sv_vss_tg_d_vss_tg_fbm_vss_tg_fbs_vss_tg_s_vss_vss_vss_link_vss_link_bridge_vss_link_dip_vss_link_m1_vss_x1_vss_x2_vss_x3_t214 r0 *1 0,0
Rg_vss_m1_inv_clk_vss_inv_mc_vss_inv_q_vss_mph_g_nand_m_vss_nand_s2_vss_s1_vss_m1_s2_vss_m1_s3_vss_m1_s4_vss_m1_sb_vss_sr1_vss_sr2_vss_sr3_vss_sr4_vss_sv_vss_tg_d_vss_tg_fbm_vss_tg_fbs_vss_tg_s_vss_vss_vss_link_vss_link_bridge_vss_link_dip_vss_link_m1_vss_x1_vss_x2_vss_x3_t214 vss__t214 vss 157.41231036
* device instance g_vss_m1_inv_clk_vss_inv_mc_vss_inv_q_vss_mph_g_nand_m_vss_nand_s2_vss_s1_vss_m1_s2_vss_m1_s3_vss_m1_s4_vss_m1_sb_vss_sr1_vss_sr2_vss_sr3_vss_sr4_vss_sv_vss_tg_d_vss_tg_fbm_vss_tg_fbs_vss_tg_s_vss_vss_vss_link_vss_link_bridge_vss_link_dip_vss_link_m1_vss_x1_vss_x2_vss_x3_t215 r0 *1 0,0
Rg_vss_m1_inv_clk_vss_inv_mc_vss_inv_q_vss_mph_g_nand_m_vss_nand_s2_vss_s1_vss_m1_s2_vss_m1_s3_vss_m1_s4_vss_m1_sb_vss_sr1_vss_sr2_vss_sr3_vss_sr4_vss_sv_vss_tg_d_vss_tg_fbm_vss_tg_fbs_vss_tg_s_vss_vss_vss_link_vss_link_bridge_vss_link_dip_vss_link_m1_vss_x1_vss_x2_vss_x3_t215 vss__t215 vss 179.868735089
* device instance g_vss_m1_inv_clk_vss_inv_mc_vss_inv_q_vss_mph_g_nand_m_vss_nand_s2_vss_s1_vss_m1_s2_vss_m1_s3_vss_m1_s4_vss_m1_sb_vss_sr1_vss_sr2_vss_sr3_vss_sr4_vss_sv_vss_tg_d_vss_tg_fbm_vss_tg_fbs_vss_tg_s_vss_vss_vss_link_vss_link_bridge_vss_link_dip_vss_link_m1_vss_x1_vss_x2_vss_x3_t216 r0 *1 0,0
Rg_vss_m1_inv_clk_vss_inv_mc_vss_inv_q_vss_mph_g_nand_m_vss_nand_s2_vss_s1_vss_m1_s2_vss_m1_s3_vss_m1_s4_vss_m1_sb_vss_sr1_vss_sr2_vss_sr3_vss_sr4_vss_sv_vss_tg_d_vss_tg_fbm_vss_tg_fbs_vss_tg_s_vss_vss_vss_link_vss_link_bridge_vss_link_dip_vss_link_m1_vss_x1_vss_x2_vss_x3_t216 vss__t216 vss 202.36729908
* device instance g_vss_m1_inv_clk_vss_inv_mc_vss_inv_q_vss_mph_g_nand_m_vss_nand_s2_vss_s1_vss_m1_s2_vss_m1_s3_vss_m1_s4_vss_m1_sb_vss_sr1_vss_sr2_vss_sr3_vss_sr4_vss_sv_vss_tg_d_vss_tg_fbm_vss_tg_fbs_vss_tg_s_vss_vss_vss_link_vss_link_bridge_vss_link_dip_vss_link_m1_vss_x1_vss_x2_vss_x3_t217 r0 *1 0,0
Rg_vss_m1_inv_clk_vss_inv_mc_vss_inv_q_vss_mph_g_nand_m_vss_nand_s2_vss_s1_vss_m1_s2_vss_m1_s3_vss_m1_s4_vss_m1_sb_vss_sr1_vss_sr2_vss_sr3_vss_sr4_vss_sv_vss_tg_d_vss_tg_fbm_vss_tg_fbs_vss_tg_s_vss_vss_vss_link_vss_link_bridge_vss_link_dip_vss_link_m1_vss_x1_vss_x2_vss_x3_t217 vss__t217 vss 224.895355835
* device instance g_vss_m1_inv_clk_vss_inv_mc_vss_inv_q_vss_mph_g_nand_m_vss_nand_s2_vss_s1_vss_m1_s2_vss_m1_s3_vss_m1_s4_vss_m1_sb_vss_sr1_vss_sr2_vss_sr3_vss_sr4_vss_sv_vss_tg_d_vss_tg_fbm_vss_tg_fbs_vss_tg_s_vss_vss_vss_link_vss_link_bridge_vss_link_dip_vss_link_m1_vss_x1_vss_x2_vss_x3 r0 *1 0,0
Cg_vss_m1_inv_clk_vss_inv_mc_vss_inv_q_vss_mph_g_nand_m_vss_nand_s2_vss_s1_vss_m1_s2_vss_m1_s3_vss_m1_s4_vss_m1_sb_vss_sr1_vss_sr2_vss_sr3_vss_sr4_vss_sv_vss_tg_d_vss_tg_fbm_vss_tg_fbs_vss_tg_s_vss_vss_vss_link_vss_link_bridge_vss_link_dip_vss_link_m1_vss_x1_vss_x2_vss_x3 vss vsubs 1.89378194e-13
* device instance mid_t0 r0 *1 0,0
Rmid_t0 mid__t0 mid 149.893184895
* device instance mid_t1 r0 *1 0,0
Rmid_t1 mid__t1 mid 180.889615105
* device instance mid_t2 r0 *1 0,0
Rmid_t2 mid__t2 mid 149.893184895
* device instance mid_t3 r0 *1 0,0
Rmid_t3 mid__t3 mid 180.889615105
* device instance mid r0 *1 0,0
Cmid mid vsubs 1.103314e-15
* device instance mid_dup1_t0 r0 *1 0,0
Rmid_dup1_t0 mid__t02 midn1 149.893184895
* device instance mid_dup1_t1 r0 *1 0,0
Rmid_dup1_t1 mid__t12 midn1 180.889615105
* device instance mid_dup1_t2 r0 *1 0,0
Rmid_dup1_t2 mid__t22 midn1 180.889615105
* device instance mid_dup1_t3 r0 *1 0,0
Rmid_dup1_t3 mid__t32 midn1 149.893184895
* device instance mid_dup1 r0 *1 0,0
Cmid_dup1 midn1 vsubs 1.101742e-15
* device instance mid_dup2_t0 r0 *1 0,0
Rmid_dup2_t0 mid__t03 midn2 149.893184895
* device instance mid_dup2_t1 r0 *1 0,0
Rmid_dup2_t1 mid__t13 midn2 180.889615105
* device instance mid_dup2_t2 r0 *1 0,0
Rmid_dup2_t2 mid__t23 midn2 180.889615105
* device instance mid_dup2_t3 r0 *1 0,0
Rmid_dup2_t3 mid__t33 midn2 149.893184895
* device instance mid_dup2 r0 *1 0,0
Cmid_dup2 midn2 vsubs 1.101742e-15
* device instance mpa_py_mpb_py_mph_py_py_t0 r0 *1 0,0
Rmpa_py_mpb_py_mph_py_py_t0 py_g__t0 py_g 33.64835
* device instance mpa_py_mpb_py_mph_py_py_t1 r0 *1 0,0
Rmpa_py_mpb_py_mph_py_py_t1 py_g__t1 py_g 28.4095054715
* device instance mpa_py_mpb_py_mph_py_py_t2 r0 *1 0,0
Rmpa_py_mpb_py_mph_py_py_t2 py_g__t2 py_g 5.23884452847
* device instance mpa_py_mpb_py_mph_py_py r0 *1 0,0
Cmpa_py_mpb_py_mph_py_py py_g vsubs 7.94002e-16
* device instance mpa_py_mpb_py_mph_py_py_dup1_t0 r0 *1 0,0
Rmpa_py_mpb_py_mph_py_py_dup1_t0 py_g__t02 py_gn1 33.9531
* device instance mpa_py_mpb_py_mph_py_py_dup1_t1 r0 *1 0,0
Rmpa_py_mpb_py_mph_py_py_dup1_t1 py_g__t12 py_gn1 28.6668077402
* device instance mpa_py_mpb_py_mph_py_py_dup1_t2 r0 *1 0,0
Rmpa_py_mpb_py_mph_py_py_dup1_t2 py_g__t22 py_gn1 5.28629225979
* device instance mpa_py_mpb_py_mph_py_py_dup1 r0 *1 0,0
Cmpa_py_mpb_py_mph_py_py_dup1 py_gn1 vsubs 7.95941e-16
* device instance mpa_py_mpb_py_mph_py_py_dup2_t0 r0 *1 0,0
Rmpa_py_mpb_py_mph_py_py_dup2_t0 py_g__t03 py_gn2 34.25785
* device instance mpa_py_mpb_py_mph_py_py_dup2_t1 r0 *1 0,0
Rmpa_py_mpb_py_mph_py_py_dup2_t1 py_g__t13 py_gn2 28.9241100089
* device instance mpa_py_mpb_py_mph_py_py_dup2_t2 r0 *1 0,0
Rmpa_py_mpb_py_mph_py_py_dup2_t2 py_g__t23 py_gn2 5.3337399911
* device instance mpa_py_mpb_py_mph_py_py_dup2 r0 *1 0,0
Cmpa_py_mpb_py_mph_py_py_dup2 py_gn2 vsubs 7.9788e-16
* device instance mpa_py_mpb_py_mph_py_py_dup3_t0 r0 *1 0,0
Rmpa_py_mpb_py_mph_py_py_dup3_t0 py_g__t04 py_gn3 34.5626
* device instance mpa_py_mpb_py_mph_py_py_dup3_t1 r0 *1 0,0
Rmpa_py_mpb_py_mph_py_py_dup3_t1 py_g__t14 py_gn3 29.1814122776
* device instance mpa_py_mpb_py_mph_py_py_dup3_t2 r0 *1 0,0
Rmpa_py_mpb_py_mph_py_py_dup3_t2 py_g__t24 py_gn3 5.38118772242
* device instance mpa_py_mpb_py_mph_py_py_dup3 r0 *1 0,0
Cmpa_py_mpb_py_mph_py_py_dup3 py_gn3 vsubs 7.99818e-16
* device instance ny_t0 r0 *1 0,0
Rny_t0 ny__t0 ny 53.0227
* device instance ny_t1 r0 *1 0,0
Rny_t1 ny__t1 ny 53.0227
* device instance ny r0 *1 0,0
Cny ny vsubs 2.33681e-16
* device instance ny_dup1_t0 r0 *1 0,0
Rny_dup1_t0 ny__t02 nyn1 50.4787
* device instance ny_dup1_t1 r0 *1 0,0
Rny_dup1_t1 ny__t12 nyn1 50.4787
* device instance ny_dup1 r0 *1 0,0
Cny_dup1 nyn1 vsubs 1.89586e-16
* device instance ny_dup2_t0 r0 *1 0,0
Rny_dup2_t0 ny__t03 nyn2 50.4787
* device instance ny_dup2_t1 r0 *1 0,0
Rny_dup2_t1 ny__t13 nyn2 50.4787
* device instance ny_dup2 r0 *1 0,0
Cny_dup2 nyn2 vsubs 1.89586e-16
* device instance ny_dup3_t0 r0 *1 0,0
Rny_dup3_t0 ny__t04 nyn3 50.4787
* device instance ny_dup3_t1 r0 *1 0,0
Rny_dup3_t1 ny__t14 nyn3 50.4787
* device instance ny_dup3 r0 *1 0,0
Cny_dup3 nyn3 vsubs 1.89586e-16
* device instance ny_dup4_t0 r0 *1 0,0
Rny_dup4_t0 ny__t05 nyn4 50.4787
* device instance ny_dup4_t1 r0 *1 0,0
Rny_dup4_t1 ny__t15 nyn4 50.4787
* device instance ny_dup4 r0 *1 0,0
Cny_dup4 nyn4 vsubs 1.89586e-16
* device instance ny_dup5_t0 r0 *1 0,0
Rny_dup5_t0 ny__t06 nyn5 53.185
* device instance ny_dup5_t1 r0 *1 0,0
Rny_dup5_t1 ny__t16 nyn5 53.185
* device instance ny_dup5 r0 *1 0,0
Cny_dup5 nyn5 vsubs 2.3562e-16
* device instance ny_dup6_t0 r0 *1 0,0
Rny_dup6_t0 ny__t07 nyn6 50.51025
* device instance ny_dup6_t1 r0 *1 0,0
Rny_dup6_t1 ny__t17 nyn6 50.51025
* device instance ny_dup6 r0 *1 0,0
Cny_dup6 nyn6 vsubs 1.91525e-16
* device instance ny_dup7_t0 r0 *1 0,0
Rny_dup7_t0 ny__t08 nyn7 50.51025
* device instance ny_dup7_t1 r0 *1 0,0
Rny_dup7_t1 ny__t18 nyn7 50.51025
* device instance ny_dup7 r0 *1 0,0
Cny_dup7 nyn7 vsubs 1.91525e-16
* device instance ny_dup8_t0 r0 *1 0,0
Rny_dup8_t0 ny__t09 nyn8 50.51025
* device instance ny_dup8_t1 r0 *1 0,0
Rny_dup8_t1 ny__t19 nyn8 50.51025
* device instance ny_dup8 r0 *1 0,0
Cny_dup8 nyn8 vsubs 1.91525e-16
* device instance ny_dup9_t0 r0 *1 0,0
Rny_dup9_t0 ny__t010 nyn9 50.51025
* device instance ny_dup9_t1 r0 *1 0,0
Rny_dup9_t1 ny__t110 nyn9 50.51025
* device instance ny_dup9 r0 *1 0,0
Cny_dup9 nyn9 vsubs 1.91525e-16
* device instance ny_dup10_t0 r0 *1 0,0
Rny_dup10_t0 ny__t011 nyn10 53.351
* device instance ny_dup10_t1 r0 *1 0,0
Rny_dup10_t1 ny__t111 nyn10 53.351
* device instance ny_dup10 r0 *1 0,0
Cny_dup10 nyn10 vsubs 2.37559e-16
* device instance ny_dup11_t0 r0 *1 0,0
Rny_dup11_t0 ny__t012 nyn11 50.5516
* device instance ny_dup11_t1 r0 *1 0,0
Rny_dup11_t1 ny__t112 nyn11 50.5516
* device instance ny_dup11 r0 *1 0,0
Cny_dup11 nyn11 vsubs 1.93464e-16
* device instance ny_dup12_t0 r0 *1 0,0
Rny_dup12_t0 ny__t013 nyn12 50.5516
* device instance ny_dup12_t1 r0 *1 0,0
Rny_dup12_t1 ny__t113 nyn12 50.5516
* device instance ny_dup12 r0 *1 0,0
Cny_dup12 nyn12 vsubs 1.93464e-16
* device instance ny_dup13_t0 r0 *1 0,0
Rny_dup13_t0 ny__t014 nyn13 50.5516
* device instance ny_dup13_t1 r0 *1 0,0
Rny_dup13_t1 ny__t114 nyn13 50.5516
* device instance ny_dup13 r0 *1 0,0
Cny_dup13 nyn13 vsubs 1.93464e-16
* device instance ny_dup14_t0 r0 *1 0,0
Rny_dup14_t0 ny__t015 nyn14 50.5516
* device instance ny_dup14_t1 r0 *1 0,0
Rny_dup14_t1 ny__t115 nyn14 50.5516
* device instance ny_dup14 r0 *1 0,0
Cny_dup14 nyn14 vsubs 1.93464e-16
* device instance ny_dup15_t0 r0 *1 0,0
Rny_dup15_t0 ny__t016 nyn15 53.52065
* device instance ny_dup15_t1 r0 *1 0,0
Rny_dup15_t1 ny__t116 nyn15 53.52065
* device instance ny_dup15 r0 *1 0,0
Cny_dup15 nyn15 vsubs 2.39497e-16
* device instance ny_dup16_t0 r0 *1 0,0
Rny_dup16_t0 ny__t017 nyn16 50.6022
* device instance ny_dup16_t1 r0 *1 0,0
Rny_dup16_t1 ny__t117 nyn16 50.6022
* device instance ny_dup16 r0 *1 0,0
Cny_dup16 nyn16 vsubs 1.95403e-16
* device instance ny_dup17_t0 r0 *1 0,0
Rny_dup17_t0 ny__t018 nyn17 50.6022
* device instance ny_dup17_t1 r0 *1 0,0
Rny_dup17_t1 ny__t118 nyn17 50.6022
* device instance ny_dup17 r0 *1 0,0
Cny_dup17 nyn17 vsubs 1.95403e-16
* device instance ny_dup18_t0 r0 *1 0,0
Rny_dup18_t0 ny__t019 nyn18 50.6022
* device instance ny_dup18_t1 r0 *1 0,0
Rny_dup18_t1 ny__t119 nyn18 50.6022
* device instance ny_dup18 r0 *1 0,0
Cny_dup18 nyn18 vsubs 1.95403e-16
* device instance ny_dup19_t0 r0 *1 0,0
Rny_dup19_t0 ny__t020 nyn19 50.6022
* device instance ny_dup19_t1 r0 *1 0,0
Rny_dup19_t1 ny__t120 nyn19 50.6022
* device instance ny_dup19 r0 *1 0,0
Cny_dup19 nyn19 vsubs 1.95403e-16
* device instance py_t0 r0 *1 0,0
Rpy_t0 py__t0 py 37.6683
* device instance py_t1 r0 *1 0,0
Rpy_t1 py__t1 py 37.6683
* device instance py r0 *1 0,0
Cpy py vsubs 1.9321e-16
* device instance py_dup1_t0 r0 *1 0,0
Rpy_dup1_t0 py__t02 pyn1 37.6683
* device instance py_dup1_t1 r0 *1 0,0
Rpy_dup1_t1 py__t12 pyn1 37.6683
* device instance py_dup1 r0 *1 0,0
Cpy_dup1 pyn1 vsubs 1.9321e-16
* device instance py_dup2_t0 r0 *1 0,0
Rpy_dup2_t0 py__t03 pyn2 37.6683
* device instance py_dup2_t1 r0 *1 0,0
Rpy_dup2_t1 py__t13 pyn2 37.6683
* device instance py_dup2 r0 *1 0,0
Cpy_dup2 pyn2 vsubs 1.9321e-16
* device instance py_dup3_t0 r0 *1 0,0
Rpy_dup3_t0 py__t04 pyn3 37.6683
* device instance py_dup3_t1 r0 *1 0,0
Rpy_dup3_t1 py__t14 pyn3 37.6683
* device instance py_dup3 r0 *1 0,0
Cpy_dup3 pyn3 vsubs 1.9321e-16
* device instance py_dup4_t0 r0 *1 0,0
Rpy_dup4_t0 py__t05 pyn4 37.875
* device instance py_dup4_t1 r0 *1 0,0
Rpy_dup4_t1 py__t15 pyn4 37.875
* device instance py_dup4 r0 *1 0,0
Cpy_dup4 pyn4 vsubs 1.95101e-16
* device instance py_dup5_t0 r0 *1 0,0
Rpy_dup5_t0 py__t06 pyn5 37.875
* device instance py_dup5_t1 r0 *1 0,0
Rpy_dup5_t1 py__t16 pyn5 37.875
* device instance py_dup5 r0 *1 0,0
Cpy_dup5 pyn5 vsubs 1.95101e-16
* device instance py_dup6_t0 r0 *1 0,0
Rpy_dup6_t0 py__t07 pyn6 37.875
* device instance py_dup6_t1 r0 *1 0,0
Rpy_dup6_t1 py__t17 pyn6 37.875
* device instance py_dup6 r0 *1 0,0
Cpy_dup6 pyn6 vsubs 1.95101e-16
* device instance py_dup7_t0 r0 *1 0,0
Rpy_dup7_t0 py__t08 pyn7 37.875
* device instance py_dup7_t1 r0 *1 0,0
Rpy_dup7_t1 py__t18 pyn7 37.875
* device instance py_dup7 r0 *1 0,0
Cpy_dup7 pyn7 vsubs 1.95101e-16
* device instance py_dup8_t0 r0 *1 0,0
Rpy_dup8_t0 py__t09 pyn8 38.0848
* device instance py_dup8_t1 r0 *1 0,0
Rpy_dup8_t1 py__t19 pyn8 38.0848
* device instance py_dup8 r0 *1 0,0
Cpy_dup8 pyn8 vsubs 1.96992e-16
* device instance py_dup9_t0 r0 *1 0,0
Rpy_dup9_t0 py__t010 pyn9 38.0848
* device instance py_dup9_t1 r0 *1 0,0
Rpy_dup9_t1 py__t110 pyn9 38.0848
* device instance py_dup9 r0 *1 0,0
Cpy_dup9 pyn9 vsubs 1.96992e-16
* device instance py_dup10_t0 r0 *1 0,0
Rpy_dup10_t0 py__t011 pyn10 38.0848
* device instance py_dup10_t1 r0 *1 0,0
Rpy_dup10_t1 py__t111 pyn10 38.0848
* device instance py_dup10 r0 *1 0,0
Cpy_dup10 pyn10 vsubs 1.96992e-16
* device instance py_dup11_t0 r0 *1 0,0
Rpy_dup11_t0 py__t012 pyn11 38.0848
* device instance py_dup11_t1 r0 *1 0,0
Rpy_dup11_t1 py__t112 pyn11 38.0848
* device instance py_dup11 r0 *1 0,0
Cpy_dup11 pyn11 vsubs 1.96992e-16
* device instance py_dup12_t0 r0 *1 0,0
Rpy_dup12_t0 py__t013 pyn12 38.29745
* device instance py_dup12_t1 r0 *1 0,0
Rpy_dup12_t1 py__t113 pyn12 38.29745
* device instance py_dup12 r0 *1 0,0
Cpy_dup12 pyn12 vsubs 1.98882e-16
* device instance py_dup13_t0 r0 *1 0,0
Rpy_dup13_t0 py__t014 pyn13 38.29745
* device instance py_dup13_t1 r0 *1 0,0
Rpy_dup13_t1 py__t114 pyn13 38.29745
* device instance py_dup13 r0 *1 0,0
Cpy_dup13 pyn13 vsubs 1.98882e-16
* device instance py_dup14_t0 r0 *1 0,0
Rpy_dup14_t0 py__t015 pyn14 38.29745
* device instance py_dup14_t1 r0 *1 0,0
Rpy_dup14_t1 py__t115 pyn14 38.29745
* device instance py_dup14 r0 *1 0,0
Cpy_dup14 pyn14 vsubs 1.98882e-16
* device instance py_dup15_t0 r0 *1 0,0
Rpy_dup15_t0 py__t016 pyn15 38.29745
* device instance py_dup15_t1 r0 *1 0,0
Rpy_dup15_t1 py__t116 pyn15 38.29745
* device instance py_dup15 r0 *1 0,0
Cpy_dup15 pyn15 vsubs 1.98882e-16
* device instance cc_a_b_b3_invb_a_mn12_g1_mp24_g0_t2_y_a_d_inva_a_mn12_g0_mp13_g0_ro3_ro3_esc_e_ro3_esc_w_ro3_hop_sr3_d_stub_tg_d_a_y r0 *1 0,0
Ccc_a_b_b3_invb_a_mn12_g1_mp24_g0_t2_y_a_d_inva_a_mn12_g0_mp13_g0_ro3_ro3_esc_e_ro3_esc_w_ro3_hop_sr3_d_stub_tg_d_a_y t2 ro3 3.3e-18
* device instance cc_a_b_b3_invb_a_mn12_g1_mp24_g0_t2_y_a_d_sb_d_stub_tg_d_a_xo_xo_dip_xo_hop_xo_stub_y r0 *1 0,0
Ccc_a_b_b3_invb_a_mn12_g1_mp24_g0_t2_y_a_d_sb_d_stub_tg_d_a_xo_xo_dip_xo_hop_xo_stub_y t2 xo 3.869e-18
* device instance cc_a_b_b3_invb_a_mn12_g1_mp24_g0_t2_y_a_inva_a_mn12_g0_mp13_g0_t1_y r0 *1 0,0
Ccc_a_b_b3_invb_a_mn12_g1_mp24_g0_t2_y_a_inva_a_mn12_g0_mp13_g0_t1_y t2 t1 3.869e-18
* device instance cc_a_b_b3_invb_a_mn12_g1_mp24_g0_t2_y_an_inva_y_mn34_g0_mp13_g1_y r0 *1 0,0
Ccc_a_b_b3_invb_a_mn12_g1_mp24_g0_t2_y_an_inva_y_mn34_g0_mp13_g1_y t2 xor_ann2 3.3e-18
* device instance cc_a_b_b3_invb_a_mn12_g1_mp24_g0_t2_y_bn_invb_y_mn34_g1_mp24_g1_y r0 *1 0,0
Ccc_a_b_b3_invb_a_mn12_g1_mp24_g0_t2_y_bn_invb_y_mn34_g1_mp24_g1_y t2 xor_bnn2 1.377e-17
* device instance cc_a_b_b3_invb_a_mn12_g1_mp24_g0_t2_y_g_vss_m1_inv_clk_vss_inv_mc_vss_inv_q_vss_mph_g_nand_m_vss_nand_s2_vss_s1_vss_m1_s2_vss_m1_s3_vss_m1_s4_vss_m1_sb_vss_sr1_vss_sr2_vss_sr3_vss_sr4_vss_sv_vss_tg_d_vss_tg_fbm_vss_tg_fbs_vss_tg_s_vss_vss_vss_link_vss_link_bridge_vss_link_dip_vss_link_m1_vss_x1_vss_x2_vss_x3 r0 *1 0,0
Ccc_a_b_b3_invb_a_mn12_g1_mp24_g0_t2_y_g_vss_m1_inv_clk_vss_inv_mc_vss_inv_q_vss_mph_g_nand_m_vss_nand_s2_vss_s1_vss_m1_s2_vss_m1_s3_vss_m1_s4_vss_m1_sb_vss_sr1_vss_sr2_vss_sr3_vss_sr4_vss_sv_vss_tg_d_vss_tg_fbm_vss_tg_fbs_vss_tg_s_vss_vss_vss_link_vss_link_bridge_vss_link_dip_vss_link_m1_vss_x1_vss_x2_vss_x3 t2 vss 7.354e-18
* device instance cc_a_b_b3_invb_a_mn12_g1_mp24_g0_t2_y_mid r0 *1 0,0
Ccc_a_b_b3_invb_a_mn12_g1_mp24_g0_t2_y_mid t2 midn2 8.154e-18
* device instance cc_a_b_d_invb_a_mn12_g1_mp24_g0_ro2_ro2_esc_sr2_d_stub_tg_d_a_y_a_b_m_east_m_west_nand_m_a_nand_m_a_ext_via_nand_m_a_ext_via2_nand_m_a_stub_tg_d_b_tg_d_b_via_tg_d_b_via2_tg_fbm_b_tg_fbm_b_alt_via_tg_fbm_b_alt_via2 r0 *1 0,0
Ccc_a_b_d_invb_a_mn12_g1_mp24_g0_ro2_ro2_esc_sr2_d_stub_tg_d_a_y_a_b_m_east_m_west_nand_m_a_nand_m_a_ext_via_nand_m_a_ext_via2_nand_m_a_stub_tg_d_b_tg_d_b_via_tg_d_b_via2_tg_fbm_b_tg_fbm_b_alt_via_tg_fbm_b_alt_via2 ro2 mn5 3.869e-18
* device instance cc_a_b_d_invb_a_mn12_g1_mp24_g0_ro2_ro2_esc_sr2_d_stub_tg_d_a_y_a_d_inv_clk_vdd_inv_mc_vdd_inv_q_vdd_mpa_py_mpb_py_nand_m_vdd_nand_s2_vdd_nwell_vdd_sb_vdd_sr1_vdd_sr2_vdd_sr3_vdd_sr4_vdd_sv_d_vdd_tie_sv_vdd_tg_d_a_tg_d_vdd_tg_fbm_vdd_tg_fbs_vdd_tg_s_vdd_vdd_vdd_b1_vdd_b2_vdd_b3_vdd_b4_vdd_link_vdd_link_dip_vdd_x1_vdd_x2_vdd_x3 r0 *1 0,0
Ccc_a_b_d_invb_a_mn12_g1_mp24_g0_ro2_ro2_esc_sr2_d_stub_tg_d_a_y_a_d_inv_clk_vdd_inv_mc_vdd_inv_q_vdd_mpa_py_mpb_py_nand_m_vdd_nand_s2_vdd_nwell_vdd_sb_vdd_sr1_vdd_sr2_vdd_sr3_vdd_sr4_vdd_sv_d_vdd_tie_sv_vdd_tg_d_a_tg_d_vdd_tg_fbm_vdd_tg_fbs_vdd_tg_s_vdd_vdd_vdd_b1_vdd_b2_vdd_b3_vdd_b4_vdd_link_vdd_link_dip_vdd_x1_vdd_x2_vdd_x3 ro2 vdd 2.2984e-17
* device instance cc_a_b_d_invb_a_mn12_g1_mp24_g0_ro2_ro2_esc_sr2_d_stub_tg_d_a_y_a_d_inva_a_mn12_g0_mp13_g0_ro1_ro1_esc_sr1_d_stub_tg_d_a_y r0 *1 0,0
Ccc_a_b_d_invb_a_mn12_g1_mp24_g0_ro2_ro2_esc_sr2_d_stub_tg_d_a_y_a_d_inva_a_mn12_g0_mp13_g0_ro1_ro1_esc_sr1_d_stub_tg_d_a_y ro2 ro1 3.869e-18
* device instance cc_a_b_d_invb_a_mn12_g1_mp24_g0_ro2_ro2_esc_sr2_d_stub_tg_d_a_y_a_d_inva_a_mn12_g0_mp13_g0_ro3_ro3_esc_e_ro3_esc_w_ro3_hop_sr3_d_stub_tg_d_a_y r0 *1 0,0
Ccc_a_b_d_invb_a_mn12_g1_mp24_g0_ro2_ro2_esc_sr2_d_stub_tg_d_a_y_a_d_inva_a_mn12_g0_mp13_g0_ro3_ro3_esc_e_ro3_esc_w_ro3_hop_sr3_d_stub_tg_d_a_y ro2 ro3 7.737e-18
* device instance cc_a_b_d_invb_a_mn12_g1_mp24_g0_ro2_ro2_esc_sr2_d_stub_tg_d_a_y_clkb_clkb_bridge1_clkb_bridge2_clkb_mid_clkb_w_ctrl_ctrlb_inv_clk_y_tg_d_ctrlb_tg_fbm_ctrl_tg_fbs_ctrlb_tg_s_ctrl_y r0 *1 0,0
Ccc_a_b_d_invb_a_mn12_g1_mp24_g0_ro2_ro2_esc_sr2_d_stub_tg_d_a_y_clkb_clkb_bridge1_clkb_bridge2_clkb_mid_clkb_w_ctrl_ctrlb_inv_clk_y_tg_d_ctrlb_tg_fbm_ctrl_tg_fbs_ctrlb_tg_s_ctrl_y ro2 clkbn5 8.337e-18
* device instance cc_a_b_d_invb_a_mn12_g1_mp24_g0_ro2_ro2_esc_sr2_d_stub_tg_d_a_y_en_nand_m_en_nand_m_en_via_nand_s2_en_nand_s2_en_via_rst_n r0 *1 0,0
Ccc_a_b_d_invb_a_mn12_g1_mp24_g0_ro2_ro2_esc_sr2_d_stub_tg_d_a_y_en_nand_m_en_nand_m_en_via_nand_s2_en_nand_s2_en_via_rst_n ro2 rst_n 3.869e-18
* device instance cc_a_b_d_invb_a_mn12_g1_mp24_g0_ro2_ro2_esc_sr2_d_stub_tg_d_a_y_g_vddr_m1_mnt_g_s1_vddr_m1_s2_vddr_m1_s3_vddr_m1_s4_vddr_m1_vddr_vddr1 r0 *1 0,0
Ccc_a_b_d_invb_a_mn12_g1_mp24_g0_ro2_ro2_esc_sr2_d_stub_tg_d_a_y_g_vddr_m1_mnt_g_s1_vddr_m1_s2_vddr_m1_s3_vddr_m1_s4_vddr_m1_vddr_vddr1 ro2 vddr1 1.6358e-17
* device instance cc_a_b_d_invb_a_mn12_g1_mp24_g0_ro2_ro2_esc_sr2_d_stub_tg_d_a_y_g_vss_m1_inv_clk_vss_inv_mc_vss_inv_q_vss_mph_g_nand_m_vss_nand_s2_vss_s1_vss_m1_s2_vss_m1_s3_vss_m1_s4_vss_m1_sb_vss_sr1_vss_sr2_vss_sr3_vss_sr4_vss_sv_vss_tg_d_vss_tg_fbm_vss_tg_fbs_vss_tg_s_vss_vss_vss_link_vss_link_bridge_vss_link_dip_vss_link_m1_vss_x1_vss_x2_vss_x3 r0 *1 0,0
Ccc_a_b_d_invb_a_mn12_g1_mp24_g0_ro2_ro2_esc_sr2_d_stub_tg_d_a_y_g_vss_m1_inv_clk_vss_inv_mc_vss_inv_q_vss_mph_g_nand_m_vss_nand_s2_vss_s1_vss_m1_s2_vss_m1_s3_vss_m1_s4_vss_m1_sb_vss_sr1_vss_sr2_vss_sr3_vss_sr4_vss_sv_vss_tg_d_vss_tg_fbm_vss_tg_fbs_vss_tg_s_vss_vss_vss_link_vss_link_bridge_vss_link_dip_vss_link_m1_vss_x1_vss_x2_vss_x3 ro2 vss 5.1954e-17
* device instance cc_a_b_d_invb_a_mn12_g1_mp24_g0_ro4_ro4_esc_sr4_d_stub_tg_d_a_y_a_b_m_east_m_west_nand_m_a_nand_m_a_ext_via_nand_m_a_ext_via2_nand_m_a_stub_tg_d_b_tg_d_b_via_tg_d_b_via2_tg_fbm_b_tg_fbm_b_alt_via_tg_fbm_b_alt_via2 r0 *1 0,0
Ccc_a_b_d_invb_a_mn12_g1_mp24_g0_ro4_ro4_esc_sr4_d_stub_tg_d_a_y_a_b_m_east_m_west_nand_m_a_nand_m_a_ext_via_nand_m_a_ext_via2_nand_m_a_stub_tg_d_b_tg_d_b_via_tg_d_b_via2_tg_fbm_b_tg_fbm_b_alt_via_tg_fbm_b_alt_via2 ro4 mn5 3.869e-18
* device instance cc_a_b_d_invb_a_mn12_g1_mp24_g0_ro4_ro4_esc_sr4_d_stub_tg_d_a_y_a_d_inv_clk_vdd_inv_mc_vdd_inv_q_vdd_mpa_py_mpb_py_nand_m_vdd_nand_s2_vdd_nwell_vdd_sb_vdd_sr1_vdd_sr2_vdd_sr3_vdd_sr4_vdd_sv_d_vdd_tie_sv_vdd_tg_d_a_tg_d_vdd_tg_fbm_vdd_tg_fbs_vdd_tg_s_vdd_vdd_vdd_b1_vdd_b2_vdd_b3_vdd_b4_vdd_link_vdd_link_dip_vdd_x1_vdd_x2_vdd_x3 r0 *1 0,0
Ccc_a_b_d_invb_a_mn12_g1_mp24_g0_ro4_ro4_esc_sr4_d_stub_tg_d_a_y_a_d_inv_clk_vdd_inv_mc_vdd_inv_q_vdd_mpa_py_mpb_py_nand_m_vdd_nand_s2_vdd_nwell_vdd_sb_vdd_sr1_vdd_sr2_vdd_sr3_vdd_sr4_vdd_sv_d_vdd_tie_sv_vdd_tg_d_a_tg_d_vdd_tg_fbm_vdd_tg_fbs_vdd_tg_s_vdd_vdd_vdd_b1_vdd_b2_vdd_b3_vdd_b4_vdd_link_vdd_link_dip_vdd_x1_vdd_x2_vdd_x3 ro4 vdd 1.3426e-17
* device instance cc_a_b_d_invb_a_mn12_g1_mp24_g0_ro4_ro4_esc_sr4_d_stub_tg_d_a_y_clkb_clkb_bridge1_clkb_bridge2_clkb_mid_clkb_w_ctrl_ctrlb_inv_clk_y_tg_d_ctrlb_tg_fbm_ctrl_tg_fbs_ctrlb_tg_s_ctrl_y r0 *1 0,0
Ccc_a_b_d_invb_a_mn12_g1_mp24_g0_ro4_ro4_esc_sr4_d_stub_tg_d_a_y_clkb_clkb_bridge1_clkb_bridge2_clkb_mid_clkb_w_ctrl_ctrlb_inv_clk_y_tg_d_ctrlb_tg_fbm_ctrl_tg_fbs_ctrlb_tg_s_ctrl_y ro4 clkbn5 8.337e-18
* device instance cc_a_b_d_invb_a_mn12_g1_mp24_g0_ro4_ro4_esc_sr4_d_stub_tg_d_a_y_en_nand_m_en_nand_m_en_via_nand_s2_en_nand_s2_en_via_rst_n r0 *1 0,0
Ccc_a_b_d_invb_a_mn12_g1_mp24_g0_ro4_ro4_esc_sr4_d_stub_tg_d_a_y_en_nand_m_en_nand_m_en_via_nand_s2_en_nand_s2_en_via_rst_n ro4 rst_n 3.869e-18
* device instance cc_a_b_d_invb_a_mn12_g1_mp24_g0_ro4_ro4_esc_sr4_d_stub_tg_d_a_y_g_vss_m1_inv_clk_vss_inv_mc_vss_inv_q_vss_mph_g_nand_m_vss_nand_s2_vss_s1_vss_m1_s2_vss_m1_s3_vss_m1_s4_vss_m1_sb_vss_sr1_vss_sr2_vss_sr3_vss_sr4_vss_sv_vss_tg_d_vss_tg_fbm_vss_tg_fbs_vss_tg_s_vss_vss_vss_link_vss_link_bridge_vss_link_dip_vss_link_m1_vss_x1_vss_x2_vss_x3 r0 *1 0,0
Ccc_a_b_d_invb_a_mn12_g1_mp24_g0_ro4_ro4_esc_sr4_d_stub_tg_d_a_y_g_vss_m1_inv_clk_vss_inv_mc_vss_inv_q_vss_mph_g_nand_m_vss_nand_s2_vss_s1_vss_m1_s2_vss_m1_s3_vss_m1_s4_vss_m1_sb_vss_sr1_vss_sr2_vss_sr3_vss_sr4_vss_sv_vss_tg_d_vss_tg_fbm_vss_tg_fbs_vss_tg_s_vss_vss_vss_link_vss_link_bridge_vss_link_dip_vss_link_m1_vss_x1_vss_x2_vss_x3 ro4 vss 8.0252e-17
* device instance cc_a_b_inv_q_a_inv_q_a_via_s_tg_fbs_b_tg_fbs_b_via_tg_s_b_tg_s_b_via_a_inv_mc_a_mb_mnab_y_mpa_y_mpb_y_nand_m_y_tg_s_a_y r0 *1 0,0
Ccc_a_b_inv_q_a_inv_q_a_via_s_tg_fbs_b_tg_fbs_b_via_tg_s_b_tg_s_b_via_a_inv_mc_a_mb_mnab_y_mpa_y_mpb_y_nand_m_y_tg_s_a_y sn5 mbn5 9.1937e-17
* device instance cc_a_b_inv_q_a_inv_q_a_via_s_tg_fbs_b_tg_fbs_b_via_tg_s_b_tg_s_b_via_a_mnab_y_mpa_y_mpb_y_nand_s2_y_qb_tg_fbs_a_y r0 *1 0,0
Ccc_a_b_inv_q_a_inv_q_a_via_s_tg_fbs_b_tg_fbs_b_via_tg_s_b_tg_s_b_via_a_mnab_y_mpa_y_mpb_y_nand_s2_y_qb_tg_fbs_a_y sn5 qbn5 2.15613e-16
* device instance cc_a_b_inv_q_a_inv_q_a_via_s_tg_fbs_b_tg_fbs_b_via_tg_s_b_tg_s_b_via_clkb_clkb_bridge1_clkb_bridge2_clkb_mid_clkb_w_ctrl_ctrlb_inv_clk_y_tg_d_ctrlb_tg_fbm_ctrl_tg_fbs_ctrlb_tg_s_ctrl_y r0 *1 0,0
Ccc_a_b_inv_q_a_inv_q_a_via_s_tg_fbs_b_tg_fbs_b_via_tg_s_b_tg_s_b_via_clkb_clkb_bridge1_clkb_bridge2_clkb_mid_clkb_w_ctrl_ctrlb_inv_clk_y_tg_d_ctrlb_tg_fbm_ctrl_tg_fbs_ctrlb_tg_s_ctrl_y sn5 clkbn5 9.3033e-17
* device instance cc_a_b_m_east_m_west_nand_m_a_nand_m_a_ext_via_nand_m_a_ext_via2_nand_m_a_stub_tg_d_b_tg_d_b_via_tg_d_b_via2_tg_fbm_b_tg_fbm_b_alt_via_tg_fbm_b_alt_via2_a_d_inv_clk_vdd_inv_mc_vdd_inv_q_vdd_mpa_py_mpb_py_nand_m_vdd_nand_s2_vdd_nwell_vdd_sb_vdd_sr1_vdd_sr2_vdd_sr3_vdd_sr4_vdd_sv_d_vdd_tie_sv_vdd_tg_d_a_tg_d_vdd_tg_fbm_vdd_tg_fbs_vdd_tg_s_vdd_vdd_vdd_b1_vdd_b2_vdd_b3_vdd_b4_vdd_link_vdd_link_dip_vdd_x1_vdd_x2_vdd_x3 r0 *1 0,0
Ccc_a_b_m_east_m_west_nand_m_a_nand_m_a_ext_via_nand_m_a_ext_via2_nand_m_a_stub_tg_d_b_tg_d_b_via_tg_d_b_via2_tg_fbm_b_tg_fbm_b_alt_via_tg_fbm_b_alt_via2_a_d_inv_clk_vdd_inv_mc_vdd_inv_q_vdd_mpa_py_mpb_py_nand_m_vdd_nand_s2_vdd_nwell_vdd_sb_vdd_sr1_vdd_sr2_vdd_sr3_vdd_sr4_vdd_sv_d_vdd_tie_sv_vdd_tg_d_a_tg_d_vdd_tg_fbm_vdd_tg_fbs_vdd_tg_s_vdd_vdd_vdd_b1_vdd_b2_vdd_b3_vdd_b4_vdd_link_vdd_link_dip_vdd_x1_vdd_x2_vdd_x3 mn5 vdd 3.869e-18
* device instance cc_a_b_m_east_m_west_nand_m_a_nand_m_a_ext_via_nand_m_a_ext_via2_nand_m_a_stub_tg_d_b_tg_d_b_via_tg_d_b_via2_tg_fbm_b_tg_fbm_b_alt_via_tg_fbm_b_alt_via2_a_d_inva_a_mn12_g0_mp13_g0_ro1_ro1_esc_sr1_d_stub_tg_d_a_y r0 *1 0,0
Ccc_a_b_m_east_m_west_nand_m_a_nand_m_a_ext_via_nand_m_a_ext_via2_nand_m_a_stub_tg_d_b_tg_d_b_via_tg_d_b_via2_tg_fbm_b_tg_fbm_b_alt_via_tg_fbm_b_alt_via2_a_d_inva_a_mn12_g0_mp13_g0_ro1_ro1_esc_sr1_d_stub_tg_d_a_y mn5 ro1 3.869e-18
* device instance cc_a_b_m_east_m_west_nand_m_a_nand_m_a_ext_via_nand_m_a_ext_via2_nand_m_a_stub_tg_d_b_tg_d_b_via_tg_d_b_via2_tg_fbm_b_tg_fbm_b_alt_via_tg_fbm_b_alt_via2_a_d_inva_a_mn12_g0_mp13_g0_ro3_ro3_esc_e_ro3_esc_w_ro3_hop_sr3_d_stub_tg_d_a_y r0 *1 0,0
Ccc_a_b_m_east_m_west_nand_m_a_nand_m_a_ext_via_nand_m_a_ext_via2_nand_m_a_stub_tg_d_b_tg_d_b_via_tg_d_b_via2_tg_fbm_b_tg_fbm_b_alt_via_tg_fbm_b_alt_via2_a_d_inva_a_mn12_g0_mp13_g0_ro3_ro3_esc_e_ro3_esc_w_ro3_hop_sr3_d_stub_tg_d_a_y mn5 ro3 3.869e-18
* device instance cc_a_b_m_east_m_west_nand_m_a_nand_m_a_ext_via_nand_m_a_ext_via2_nand_m_a_stub_tg_d_b_tg_d_b_via_tg_d_b_via2_tg_fbm_b_tg_fbm_b_alt_via_tg_fbm_b_alt_via2_a_d_sb_d_stub_tg_d_a_xo_xo_dip_xo_hop_xo_stub_y r0 *1 0,0
Ccc_a_b_m_east_m_west_nand_m_a_nand_m_a_ext_via_nand_m_a_ext_via2_nand_m_a_stub_tg_d_b_tg_d_b_via_tg_d_b_via2_tg_fbm_b_tg_fbm_b_alt_via_tg_fbm_b_alt_via2_a_d_sb_d_stub_tg_d_a_xo_xo_dip_xo_hop_xo_stub_y mn5 xo 3.869e-18
* device instance cc_a_b_m_east_m_west_nand_m_a_nand_m_a_ext_via_nand_m_a_ext_via2_nand_m_a_stub_tg_d_b_tg_d_b_via_tg_d_b_via2_tg_fbm_b_tg_fbm_b_alt_via_tg_fbm_b_alt_via2_a_inv_mc_a_mb_mnab_y_mpa_y_mpb_y_nand_m_y_tg_s_a_y r0 *1 0,0
Ccc_a_b_m_east_m_west_nand_m_a_nand_m_a_ext_via_nand_m_a_ext_via2_nand_m_a_stub_tg_d_b_tg_d_b_via_tg_d_b_via2_tg_fbm_b_tg_fbm_b_alt_via_tg_fbm_b_alt_via2_a_inv_mc_a_mb_mnab_y_mpa_y_mpb_y_nand_m_y_tg_s_a_y mn5 mbn5 1.54907e-16
* device instance cc_a_b_m_east_m_west_nand_m_a_nand_m_a_ext_via_nand_m_a_ext_via2_nand_m_a_stub_tg_d_b_tg_d_b_via_tg_d_b_via2_tg_fbm_b_tg_fbm_b_alt_via_tg_fbm_b_alt_via2_clkb_clkb_bridge1_clkb_bridge2_clkb_mid_clkb_w_ctrl_ctrlb_inv_clk_y_tg_d_ctrlb_tg_fbm_ctrl_tg_fbs_ctrlb_tg_s_ctrl_y r0 *1 0,0
Ccc_a_b_m_east_m_west_nand_m_a_nand_m_a_ext_via_nand_m_a_ext_via2_nand_m_a_stub_tg_d_b_tg_d_b_via_tg_d_b_via2_tg_fbm_b_tg_fbm_b_alt_via_tg_fbm_b_alt_via2_clkb_clkb_bridge1_clkb_bridge2_clkb_mid_clkb_w_ctrl_ctrlb_inv_clk_y_tg_d_ctrlb_tg_fbm_ctrl_tg_fbs_ctrlb_tg_s_ctrl_y mn5 clkbn5 1.00039e-16
* device instance cc_a_clk_ctrl_ctrlb_inv_clk_a_inv_clk_clk_via_tg_d_ctrl_tg_d_ctrl_via_tg_fbm_ctrlb_tg_fbm_ctrlb_via_tg_fbs_ctrl_tg_fbs_ctrl_via_tg_s_ctrlb_tg_s_ctrlb_via_a_mnab_y_mpa_y_mpb_y_nand_s2_y_qb_tg_fbs_a_y r0 *1 0,0
Ccc_a_clk_ctrl_ctrlb_inv_clk_a_inv_clk_clk_via_tg_d_ctrl_tg_d_ctrl_via_tg_fbm_ctrlb_tg_fbm_ctrlb_via_tg_fbs_ctrl_tg_fbs_ctrl_via_tg_s_ctrlb_tg_s_ctrlb_via_a_mnab_y_mpa_y_mpb_y_nand_s2_y_qb_tg_fbs_a_y clk qbn5 2.3211e-17
* device instance cc_a_clk_ctrl_ctrlb_inv_clk_a_inv_clk_clk_via_tg_d_ctrl_tg_d_ctrl_via_tg_fbm_ctrlb_tg_fbm_ctrlb_via_tg_fbs_ctrl_tg_fbs_ctrl_via_tg_s_ctrlb_tg_s_ctrlb_via_clkb_clkb_bridge1_clkb_bridge2_clkb_mid_clkb_w_ctrl_ctrlb_inv_clk_y_tg_d_ctrlb_tg_fbm_ctrl_tg_fbs_ctrlb_tg_s_ctrl_y r0 *1 0,0
Ccc_a_clk_ctrl_ctrlb_inv_clk_a_inv_clk_clk_via_tg_d_ctrl_tg_d_ctrl_via_tg_fbm_ctrlb_tg_fbm_ctrlb_via_tg_fbs_ctrl_tg_fbs_ctrl_via_tg_s_ctrlb_tg_s_ctrlb_via_clkb_clkb_bridge1_clkb_bridge2_clkb_mid_clkb_w_ctrl_ctrlb_inv_clk_y_tg_d_ctrlb_tg_fbm_ctrl_tg_fbs_ctrlb_tg_s_ctrl_y clk clkbn5 3.16766e-16
* device instance cc_a_clk_ctrl_ctrlb_inv_clk_a_inv_clk_clk_via_tg_d_ctrl_tg_d_ctrl_via_tg_fbm_ctrlb_tg_fbm_ctrlb_via_tg_fbs_ctrl_tg_fbs_ctrl_via_tg_s_ctrlb_tg_s_ctrlb_via_g_vss_m1_inv_clk_vss_inv_mc_vss_inv_q_vss_mph_g_nand_m_vss_nand_s2_vss_s1_vss_m1_s2_vss_m1_s3_vss_m1_s4_vss_m1_sb_vss_sr1_vss_sr2_vss_sr3_vss_sr4_vss_sv_vss_tg_d_vss_tg_fbm_vss_tg_fbs_vss_tg_s_vss_vss_vss_link_vss_link_bridge_vss_link_dip_vss_link_m1_vss_x1_vss_x2_vss_x3 r0 *1 0,0
Ccc_a_clk_ctrl_ctrlb_inv_clk_a_inv_clk_clk_via_tg_d_ctrl_tg_d_ctrl_via_tg_fbm_ctrlb_tg_fbm_ctrlb_via_tg_fbs_ctrl_tg_fbs_ctrl_via_tg_s_ctrlb_tg_s_ctrlb_via_g_vss_m1_inv_clk_vss_inv_mc_vss_inv_q_vss_mph_g_nand_m_vss_nand_s2_vss_s1_vss_m1_s2_vss_m1_s3_vss_m1_s4_vss_m1_sb_vss_sr1_vss_sr2_vss_sr3_vss_sr4_vss_sv_vss_tg_d_vss_tg_fbm_vss_tg_fbs_vss_tg_s_vss_vss_vss_link_vss_link_bridge_vss_link_dip_vss_link_m1_vss_x1_vss_x2_vss_x3 clk vss 1.16057e-16
* device instance cc_a_d_inv_clk_vdd_inv_mc_vdd_inv_q_vdd_mpa_py_mpb_py_nand_m_vdd_nand_s2_vdd_nwell_vdd_sb_vdd_sr1_vdd_sr2_vdd_sr3_vdd_sr4_vdd_sv_d_vdd_tie_sv_vdd_tg_d_a_tg_d_vdd_tg_fbm_vdd_tg_fbs_vdd_tg_s_vdd_vdd_vdd_b1_vdd_b2_vdd_b3_vdd_b4_vdd_link_vdd_link_dip_vdd_x1_vdd_x2_vdd_x3_a_d_inva_a_mn12_g0_mp13_g0_ro1_ro1_esc_sr1_d_stub_tg_d_a_y r0 *1 0,0
Ccc_a_d_inv_clk_vdd_inv_mc_vdd_inv_q_vdd_mpa_py_mpb_py_nand_m_vdd_nand_s2_vdd_nwell_vdd_sb_vdd_sr1_vdd_sr2_vdd_sr3_vdd_sr4_vdd_sv_d_vdd_tie_sv_vdd_tg_d_a_tg_d_vdd_tg_fbm_vdd_tg_fbs_vdd_tg_s_vdd_vdd_vdd_b1_vdd_b2_vdd_b3_vdd_b4_vdd_link_vdd_link_dip_vdd_x1_vdd_x2_vdd_x3_a_d_inva_a_mn12_g0_mp13_g0_ro1_ro1_esc_sr1_d_stub_tg_d_a_y vdd ro1 4.5399e-17
* device instance cc_a_d_inv_clk_vdd_inv_mc_vdd_inv_q_vdd_mpa_py_mpb_py_nand_m_vdd_nand_s2_vdd_nwell_vdd_sb_vdd_sr1_vdd_sr2_vdd_sr3_vdd_sr4_vdd_sv_d_vdd_tie_sv_vdd_tg_d_a_tg_d_vdd_tg_fbm_vdd_tg_fbs_vdd_tg_s_vdd_vdd_vdd_b1_vdd_b2_vdd_b3_vdd_b4_vdd_link_vdd_link_dip_vdd_x1_vdd_x2_vdd_x3_a_d_inva_a_mn12_g0_mp13_g0_ro3_ro3_esc_e_ro3_esc_w_ro3_hop_sr3_d_stub_tg_d_a_y r0 *1 0,0
Ccc_a_d_inv_clk_vdd_inv_mc_vdd_inv_q_vdd_mpa_py_mpb_py_nand_m_vdd_nand_s2_vdd_nwell_vdd_sb_vdd_sr1_vdd_sr2_vdd_sr3_vdd_sr4_vdd_sv_d_vdd_tie_sv_vdd_tg_d_a_tg_d_vdd_tg_fbm_vdd_tg_fbs_vdd_tg_s_vdd_vdd_vdd_b1_vdd_b2_vdd_b3_vdd_b4_vdd_link_vdd_link_dip_vdd_x1_vdd_x2_vdd_x3_a_d_inva_a_mn12_g0_mp13_g0_ro3_ro3_esc_e_ro3_esc_w_ro3_hop_sr3_d_stub_tg_d_a_y vdd ro3 4.9268e-17
* device instance cc_a_d_inv_clk_vdd_inv_mc_vdd_inv_q_vdd_mpa_py_mpb_py_nand_m_vdd_nand_s2_vdd_nwell_vdd_sb_vdd_sr1_vdd_sr2_vdd_sr3_vdd_sr4_vdd_sv_d_vdd_tie_sv_vdd_tg_d_a_tg_d_vdd_tg_fbm_vdd_tg_fbs_vdd_tg_s_vdd_vdd_vdd_b1_vdd_b2_vdd_b3_vdd_b4_vdd_link_vdd_link_dip_vdd_x1_vdd_x2_vdd_x3_a_d_sb_d_stub_tg_d_a_xo_xo_dip_xo_hop_xo_stub_y r0 *1 0,0
Ccc_a_d_inv_clk_vdd_inv_mc_vdd_inv_q_vdd_mpa_py_mpb_py_nand_m_vdd_nand_s2_vdd_nwell_vdd_sb_vdd_sr1_vdd_sr2_vdd_sr3_vdd_sr4_vdd_sv_d_vdd_tie_sv_vdd_tg_d_a_tg_d_vdd_tg_fbm_vdd_tg_fbs_vdd_tg_s_vdd_vdd_vdd_b1_vdd_b2_vdd_b3_vdd_b4_vdd_link_vdd_link_dip_vdd_x1_vdd_x2_vdd_x3_a_d_sb_d_stub_tg_d_a_xo_xo_dip_xo_hop_xo_stub_y vdd xo 3.869e-18
* device instance cc_a_d_inv_clk_vdd_inv_mc_vdd_inv_q_vdd_mpa_py_mpb_py_nand_m_vdd_nand_s2_vdd_nwell_vdd_sb_vdd_sr1_vdd_sr2_vdd_sr3_vdd_sr4_vdd_sv_d_vdd_tie_sv_vdd_tg_d_a_tg_d_vdd_tg_fbm_vdd_tg_fbs_vdd_tg_s_vdd_vdd_vdd_b1_vdd_b2_vdd_b3_vdd_b4_vdd_link_vdd_link_dip_vdd_x1_vdd_x2_vdd_x3_a_g_a_rn4_ro_s4_y_y r0 *1 0,0
Ccc_a_d_inv_clk_vdd_inv_mc_vdd_inv_q_vdd_mpa_py_mpb_py_nand_m_vdd_nand_s2_vdd_nwell_vdd_sb_vdd_sr1_vdd_sr2_vdd_sr3_vdd_sr4_vdd_sv_d_vdd_tie_sv_vdd_tg_d_a_tg_d_vdd_tg_fbm_vdd_tg_fbs_vdd_tg_s_vdd_vdd_vdd_b1_vdd_b2_vdd_b3_vdd_b4_vdd_link_vdd_link_dip_vdd_x1_vdd_x2_vdd_x3_a_g_a_rn4_ro_s4_y_y vdd rn4 3.869e-18
* device instance cc_a_d_inv_clk_vdd_inv_mc_vdd_inv_q_vdd_mpa_py_mpb_py_nand_m_vdd_nand_s2_vdd_nwell_vdd_sb_vdd_sr1_vdd_sr2_vdd_sr3_vdd_sr4_vdd_sv_d_vdd_tie_sv_vdd_tg_d_a_tg_d_vdd_tg_fbm_vdd_tg_fbs_vdd_tg_s_vdd_vdd_vdd_b1_vdd_b2_vdd_b3_vdd_b4_vdd_link_vdd_link_dip_vdd_x1_vdd_x2_vdd_x3_a_inva_a_mn12_g0_mp13_g0_t1_y r0 *1 0,0
Ccc_a_d_inv_clk_vdd_inv_mc_vdd_inv_q_vdd_mpa_py_mpb_py_nand_m_vdd_nand_s2_vdd_nwell_vdd_sb_vdd_sr1_vdd_sr2_vdd_sr3_vdd_sr4_vdd_sv_d_vdd_tie_sv_vdd_tg_d_a_tg_d_vdd_tg_fbm_vdd_tg_fbs_vdd_tg_s_vdd_vdd_vdd_b1_vdd_b2_vdd_b3_vdd_b4_vdd_link_vdd_link_dip_vdd_x1_vdd_x2_vdd_x3_a_inva_a_mn12_g0_mp13_g0_t1_y vdd t1 3.5274e-17
* device instance cc_a_d_inv_clk_vdd_inv_mc_vdd_inv_q_vdd_mpa_py_mpb_py_nand_m_vdd_nand_s2_vdd_nwell_vdd_sb_vdd_sr1_vdd_sr2_vdd_sr3_vdd_sr4_vdd_sv_d_vdd_tie_sv_vdd_tg_d_a_tg_d_vdd_tg_fbm_vdd_tg_fbs_vdd_tg_s_vdd_vdd_vdd_b1_vdd_b2_vdd_b3_vdd_b4_vdd_link_vdd_link_dip_vdd_x1_vdd_x2_vdd_x3_an_inva_y_mn34_g0_mp13_g1_y r0 *1 0,0
Ccc_a_d_inv_clk_vdd_inv_mc_vdd_inv_q_vdd_mpa_py_mpb_py_nand_m_vdd_nand_s2_vdd_nwell_vdd_sb_vdd_sr1_vdd_sr2_vdd_sr3_vdd_sr4_vdd_sv_d_vdd_tie_sv_vdd_tg_d_a_tg_d_vdd_tg_fbm_vdd_tg_fbs_vdd_tg_s_vdd_vdd_vdd_b1_vdd_b2_vdd_b3_vdd_b4_vdd_link_vdd_link_dip_vdd_x1_vdd_x2_vdd_x3_an_inva_y_mn34_g0_mp13_g1_y vdd xor_ann2 2.8673e-17
* device instance cc_a_d_inv_clk_vdd_inv_mc_vdd_inv_q_vdd_mpa_py_mpb_py_nand_m_vdd_nand_s2_vdd_nwell_vdd_sb_vdd_sr1_vdd_sr2_vdd_sr3_vdd_sr4_vdd_sv_d_vdd_tie_sv_vdd_tg_d_a_tg_d_vdd_tg_fbm_vdd_tg_fbs_vdd_tg_s_vdd_vdd_vdd_b1_vdd_b2_vdd_b3_vdd_b4_vdd_link_vdd_link_dip_vdd_x1_vdd_x2_vdd_x3_bn_invb_y_mn34_g1_mp24_g1_y r0 *1 0,0
Ccc_a_d_inv_clk_vdd_inv_mc_vdd_inv_q_vdd_mpa_py_mpb_py_nand_m_vdd_nand_s2_vdd_nwell_vdd_sb_vdd_sr1_vdd_sr2_vdd_sr3_vdd_sr4_vdd_sv_d_vdd_tie_sv_vdd_tg_d_a_tg_d_vdd_tg_fbm_vdd_tg_fbs_vdd_tg_s_vdd_vdd_vdd_b1_vdd_b2_vdd_b3_vdd_b4_vdd_link_vdd_link_dip_vdd_x1_vdd_x2_vdd_x3_bn_invb_y_mn34_g1_mp24_g1_y vdd xor_bnn2 9.901e-18
* device instance cc_a_d_inv_clk_vdd_inv_mc_vdd_inv_q_vdd_mpa_py_mpb_py_nand_m_vdd_nand_s2_vdd_nwell_vdd_sb_vdd_sr1_vdd_sr2_vdd_sr3_vdd_sr4_vdd_sv_d_vdd_tie_sv_vdd_tg_d_a_tg_d_vdd_tg_fbm_vdd_tg_fbs_vdd_tg_s_vdd_vdd_vdd_b1_vdd_b2_vdd_b3_vdd_b4_vdd_link_vdd_link_dip_vdd_x1_vdd_x2_vdd_x3_clkb_clkb_bridge1_clkb_bridge2_clkb_mid_clkb_w_ctrl_ctrlb_inv_clk_y_tg_d_ctrlb_tg_fbm_ctrl_tg_fbs_ctrlb_tg_s_ctrl_y r0 *1 0,0
Ccc_a_d_inv_clk_vdd_inv_mc_vdd_inv_q_vdd_mpa_py_mpb_py_nand_m_vdd_nand_s2_vdd_nwell_vdd_sb_vdd_sr1_vdd_sr2_vdd_sr3_vdd_sr4_vdd_sv_d_vdd_tie_sv_vdd_tg_d_a_tg_d_vdd_tg_fbm_vdd_tg_fbs_vdd_tg_s_vdd_vdd_vdd_b1_vdd_b2_vdd_b3_vdd_b4_vdd_link_vdd_link_dip_vdd_x1_vdd_x2_vdd_x3_clkb_clkb_bridge1_clkb_bridge2_clkb_mid_clkb_w_ctrl_ctrlb_inv_clk_y_tg_d_ctrlb_tg_fbm_ctrl_tg_fbs_ctrlb_tg_s_ctrl_y vdd clkbn5 8.337e-18
* device instance cc_a_d_inv_clk_vdd_inv_mc_vdd_inv_q_vdd_mpa_py_mpb_py_nand_m_vdd_nand_s2_vdd_nwell_vdd_sb_vdd_sr1_vdd_sr2_vdd_sr3_vdd_sr4_vdd_sv_d_vdd_tie_sv_vdd_tg_d_a_tg_d_vdd_tg_fbm_vdd_tg_fbs_vdd_tg_s_vdd_vdd_vdd_b1_vdd_b2_vdd_b3_vdd_b4_vdd_link_vdd_link_dip_vdd_x1_vdd_x2_vdd_x3_en_nand_m_en_nand_m_en_via_nand_s2_en_nand_s2_en_via_rst_n r0 *1 0,0
Ccc_a_d_inv_clk_vdd_inv_mc_vdd_inv_q_vdd_mpa_py_mpb_py_nand_m_vdd_nand_s2_vdd_nwell_vdd_sb_vdd_sr1_vdd_sr2_vdd_sr3_vdd_sr4_vdd_sv_d_vdd_tie_sv_vdd_tg_d_a_tg_d_vdd_tg_fbm_vdd_tg_fbs_vdd_tg_s_vdd_vdd_vdd_b1_vdd_b2_vdd_b3_vdd_b4_vdd_link_vdd_link_dip_vdd_x1_vdd_x2_vdd_x3_en_nand_m_en_nand_m_en_via_nand_s2_en_nand_s2_en_via_rst_n vdd rst_n 5.26927e-16
* device instance cc_a_d_inv_clk_vdd_inv_mc_vdd_inv_q_vdd_mpa_py_mpb_py_nand_m_vdd_nand_s2_vdd_nwell_vdd_sb_vdd_sr1_vdd_sr2_vdd_sr3_vdd_sr4_vdd_sv_d_vdd_tie_sv_vdd_tg_d_a_tg_d_vdd_tg_fbm_vdd_tg_fbs_vdd_tg_s_vdd_vdd_vdd_b1_vdd_b2_vdd_b3_vdd_b4_vdd_link_vdd_link_dip_vdd_x1_vdd_x2_vdd_x3_g_vss_m1_inv_clk_vss_inv_mc_vss_inv_q_vss_mph_g_nand_m_vss_nand_s2_vss_s1_vss_m1_s2_vss_m1_s3_vss_m1_s4_vss_m1_sb_vss_sr1_vss_sr2_vss_sr3_vss_sr4_vss_sv_vss_tg_d_vss_tg_fbm_vss_tg_fbs_vss_tg_s_vss_vss_vss_link_vss_link_bridge_vss_link_dip_vss_link_m1_vss_x1_vss_x2_vss_x3 r0 *1 0,0
Ccc_a_d_inv_clk_vdd_inv_mc_vdd_inv_q_vdd_mpa_py_mpb_py_nand_m_vdd_nand_s2_vdd_nwell_vdd_sb_vdd_sr1_vdd_sr2_vdd_sr3_vdd_sr4_vdd_sv_d_vdd_tie_sv_vdd_tg_d_a_tg_d_vdd_tg_fbm_vdd_tg_fbs_vdd_tg_s_vdd_vdd_vdd_b1_vdd_b2_vdd_b3_vdd_b4_vdd_link_vdd_link_dip_vdd_x1_vdd_x2_vdd_x3_g_vss_m1_inv_clk_vss_inv_mc_vss_inv_q_vss_mph_g_nand_m_vss_nand_s2_vss_s1_vss_m1_s2_vss_m1_s3_vss_m1_s4_vss_m1_sb_vss_sr1_vss_sr2_vss_sr3_vss_sr4_vss_sv_vss_tg_d_vss_tg_fbm_vss_tg_fbs_vss_tg_s_vss_vss_vss_link_vss_link_bridge_vss_link_dip_vss_link_m1_vss_x1_vss_x2_vss_x3 vdd vss 7.7757e-17
* device instance cc_a_d_inva_a_mn12_g0_mp13_g0_ro1_ro1_esc_sr1_d_stub_tg_d_a_y_a_d_inva_a_mn12_g0_mp13_g0_ro3_ro3_esc_e_ro3_esc_w_ro3_hop_sr3_d_stub_tg_d_a_y r0 *1 0,0
Ccc_a_d_inva_a_mn12_g0_mp13_g0_ro1_ro1_esc_sr1_d_stub_tg_d_a_y_a_d_inva_a_mn12_g0_mp13_g0_ro3_ro3_esc_e_ro3_esc_w_ro3_hop_sr3_d_stub_tg_d_a_y ro1 ro3 3.869e-18
* device instance cc_a_d_inva_a_mn12_g0_mp13_g0_ro1_ro1_esc_sr1_d_stub_tg_d_a_y_a_inva_a_mn12_g0_mp13_g0_t1_y r0 *1 0,0
Ccc_a_d_inva_a_mn12_g0_mp13_g0_ro1_ro1_esc_sr1_d_stub_tg_d_a_y_a_inva_a_mn12_g0_mp13_g0_t1_y ro1 t1 3.3e-18
* device instance cc_a_d_inva_a_mn12_g0_mp13_g0_ro1_ro1_esc_sr1_d_stub_tg_d_a_y_clkb_clkb_bridge1_clkb_bridge2_clkb_mid_clkb_w_ctrl_ctrlb_inv_clk_y_tg_d_ctrlb_tg_fbm_ctrl_tg_fbs_ctrlb_tg_s_ctrl_y r0 *1 0,0
Ccc_a_d_inva_a_mn12_g0_mp13_g0_ro1_ro1_esc_sr1_d_stub_tg_d_a_y_clkb_clkb_bridge1_clkb_bridge2_clkb_mid_clkb_w_ctrl_ctrlb_inv_clk_y_tg_d_ctrlb_tg_fbm_ctrl_tg_fbs_ctrlb_tg_s_ctrl_y ro1 clkbn5 8.337e-18
* device instance cc_a_d_inva_a_mn12_g0_mp13_g0_ro1_ro1_esc_sr1_d_stub_tg_d_a_y_en_nand_m_en_nand_m_en_via_nand_s2_en_nand_s2_en_via_rst_n r0 *1 0,0
Ccc_a_d_inva_a_mn12_g0_mp13_g0_ro1_ro1_esc_sr1_d_stub_tg_d_a_y_en_nand_m_en_nand_m_en_via_nand_s2_en_nand_s2_en_via_rst_n ro1 rst_n 3.869e-18
* device instance cc_a_d_inva_a_mn12_g0_mp13_g0_ro1_ro1_esc_sr1_d_stub_tg_d_a_y_g_vss_m1_inv_clk_vss_inv_mc_vss_inv_q_vss_mph_g_nand_m_vss_nand_s2_vss_s1_vss_m1_s2_vss_m1_s3_vss_m1_s4_vss_m1_sb_vss_sr1_vss_sr2_vss_sr3_vss_sr4_vss_sv_vss_tg_d_vss_tg_fbm_vss_tg_fbs_vss_tg_s_vss_vss_vss_link_vss_link_bridge_vss_link_dip_vss_link_m1_vss_x1_vss_x2_vss_x3 r0 *1 0,0
Ccc_a_d_inva_a_mn12_g0_mp13_g0_ro1_ro1_esc_sr1_d_stub_tg_d_a_y_g_vss_m1_inv_clk_vss_inv_mc_vss_inv_q_vss_mph_g_nand_m_vss_nand_s2_vss_s1_vss_m1_s2_vss_m1_s3_vss_m1_s4_vss_m1_sb_vss_sr1_vss_sr2_vss_sr3_vss_sr4_vss_sv_vss_tg_d_vss_tg_fbm_vss_tg_fbs_vss_tg_s_vss_vss_vss_link_vss_link_bridge_vss_link_dip_vss_link_m1_vss_x1_vss_x2_vss_x3 ro1 vss 1.3955e-17
* device instance cc_a_d_inva_a_mn12_g0_mp13_g0_ro3_ro3_esc_e_ro3_esc_w_ro3_hop_sr3_d_stub_tg_d_a_y_clkb_clkb_bridge1_clkb_bridge2_clkb_mid_clkb_w_ctrl_ctrlb_inv_clk_y_tg_d_ctrlb_tg_fbm_ctrl_tg_fbs_ctrlb_tg_s_ctrl_y r0 *1 0,0
Ccc_a_d_inva_a_mn12_g0_mp13_g0_ro3_ro3_esc_e_ro3_esc_w_ro3_hop_sr3_d_stub_tg_d_a_y_clkb_clkb_bridge1_clkb_bridge2_clkb_mid_clkb_w_ctrl_ctrlb_inv_clk_y_tg_d_ctrlb_tg_fbm_ctrl_tg_fbs_ctrlb_tg_s_ctrl_y ro3 clkbn5 8.337e-18
* device instance cc_a_d_inva_a_mn12_g0_mp13_g0_ro3_ro3_esc_e_ro3_esc_w_ro3_hop_sr3_d_stub_tg_d_a_y_en_nand_m_en_nand_m_en_via_nand_s2_en_nand_s2_en_via_rst_n r0 *1 0,0
Ccc_a_d_inva_a_mn12_g0_mp13_g0_ro3_ro3_esc_e_ro3_esc_w_ro3_hop_sr3_d_stub_tg_d_a_y_en_nand_m_en_nand_m_en_via_nand_s2_en_nand_s2_en_via_rst_n ro3 rst_n 3.869e-18
* device instance cc_a_d_inva_a_mn12_g0_mp13_g0_ro3_ro3_esc_e_ro3_esc_w_ro3_hop_sr3_d_stub_tg_d_a_y_g_vddr_m1_mnt_g_s1_vddr_m1_s2_vddr_m1_s3_vddr_m1_s4_vddr_m1_vddr_vddr1 r0 *1 0,0
Ccc_a_d_inva_a_mn12_g0_mp13_g0_ro3_ro3_esc_e_ro3_esc_w_ro3_hop_sr3_d_stub_tg_d_a_y_g_vddr_m1_mnt_g_s1_vddr_m1_s2_vddr_m1_s3_vddr_m1_s4_vddr_m1_vddr_vddr1 ro3 vddr1 3.869e-18
* device instance cc_a_d_inva_a_mn12_g0_mp13_g0_ro3_ro3_esc_e_ro3_esc_w_ro3_hop_sr3_d_stub_tg_d_a_y_g_vss_m1_inv_clk_vss_inv_mc_vss_inv_q_vss_mph_g_nand_m_vss_nand_s2_vss_s1_vss_m1_s2_vss_m1_s3_vss_m1_s4_vss_m1_sb_vss_sr1_vss_sr2_vss_sr3_vss_sr4_vss_sv_vss_tg_d_vss_tg_fbm_vss_tg_fbs_vss_tg_s_vss_vss_vss_link_vss_link_bridge_vss_link_dip_vss_link_m1_vss_x1_vss_x2_vss_x3 r0 *1 0,0
Ccc_a_d_inva_a_mn12_g0_mp13_g0_ro3_ro3_esc_e_ro3_esc_w_ro3_hop_sr3_d_stub_tg_d_a_y_g_vss_m1_inv_clk_vss_inv_mc_vss_inv_q_vss_mph_g_nand_m_vss_nand_s2_vss_s1_vss_m1_s2_vss_m1_s3_vss_m1_s4_vss_m1_sb_vss_sr1_vss_sr2_vss_sr3_vss_sr4_vss_sv_vss_tg_d_vss_tg_fbm_vss_tg_fbs_vss_tg_s_vss_vss_vss_link_vss_link_bridge_vss_link_dip_vss_link_m1_vss_x1_vss_x2_vss_x3 ro3 vss 3.125e-17
* device instance cc_a_d_sb_d_stub_tg_d_a_xo_xo_dip_xo_hop_xo_stub_y_a_inva_a_mn12_g0_mp13_g0_t1_y r0 *1 0,0
Ccc_a_d_sb_d_stub_tg_d_a_xo_xo_dip_xo_hop_xo_stub_y_a_inva_a_mn12_g0_mp13_g0_t1_y xo t1 1.1037e-17
* device instance cc_a_d_sb_d_stub_tg_d_a_xo_xo_dip_xo_hop_xo_stub_y_an_inva_y_mn34_g0_mp13_g1_y r0 *1 0,0
Ccc_a_d_sb_d_stub_tg_d_a_xo_xo_dip_xo_hop_xo_stub_y_an_inva_y_mn34_g0_mp13_g1_y xo xor_ann2 3.3e-18
* device instance cc_a_d_sb_d_stub_tg_d_a_xo_xo_dip_xo_hop_xo_stub_y_bn_invb_y_mn34_g1_mp24_g1_y r0 *1 0,0
Ccc_a_d_sb_d_stub_tg_d_a_xo_xo_dip_xo_hop_xo_stub_y_bn_invb_y_mn34_g1_mp24_g1_y xo xor_bnn2 9.901e-18
* device instance cc_a_d_sb_d_stub_tg_d_a_xo_xo_dip_xo_hop_xo_stub_y_clkb_clkb_bridge1_clkb_bridge2_clkb_mid_clkb_w_ctrl_ctrlb_inv_clk_y_tg_d_ctrlb_tg_fbm_ctrl_tg_fbs_ctrlb_tg_s_ctrl_y r0 *1 0,0
Ccc_a_d_sb_d_stub_tg_d_a_xo_xo_dip_xo_hop_xo_stub_y_clkb_clkb_bridge1_clkb_bridge2_clkb_mid_clkb_w_ctrl_ctrlb_inv_clk_y_tg_d_ctrlb_tg_fbm_ctrl_tg_fbs_ctrlb_tg_s_ctrl_y xo clkbn5 8.337e-18
* device instance cc_a_d_sb_d_stub_tg_d_a_xo_xo_dip_xo_hop_xo_stub_y_mid r0 *1 0,0
Ccc_a_d_sb_d_stub_tg_d_a_xo_xo_dip_xo_hop_xo_stub_y_mid xo midn2 8.154e-18
* device instance cc_a_g_a_rn1_ro_s4_y_y_a_g_y_mnab_y_mpa_y_mpb_y_n1_s1_a_y r0 *1 0,0
Ccc_a_g_a_rn1_ro_s4_y_y_a_g_y_mnab_y_mpa_y_mpb_y_n1_s1_a_y rn1 sig_n1n3 6.626e-18
* device instance cc_a_g_a_rn1_ro_s4_y_y_g_vddr_m1_mnt_g_s1_vddr_m1_s2_vddr_m1_s3_vddr_m1_s4_vddr_m1_vddr_vddr1 r0 *1 0,0
Ccc_a_g_a_rn1_ro_s4_y_y_g_vddr_m1_mnt_g_s1_vddr_m1_s2_vddr_m1_s3_vddr_m1_s4_vddr_m1_vddr_vddr1 rn1 vddr1 1.5474e-17
* device instance cc_a_g_a_rn2_ro_s4_y_y_a_g_y_mnab_y_mpa_y_mpb_y_n1_s1_a_y r0 *1 0,0
Ccc_a_g_a_rn2_ro_s4_y_y_a_g_y_mnab_y_mpa_y_mpb_y_n1_s1_a_y rn2 sig_n1n3 6.626e-18
* device instance cc_a_g_a_rn2_ro_s4_y_y_g_vddr_m1_mnt_g_s1_vddr_m1_s2_vddr_m1_s3_vddr_m1_s4_vddr_m1_vddr_vddr2 r0 *1 0,0
Ccc_a_g_a_rn2_ro_s4_y_y_g_vddr_m1_mnt_g_s1_vddr_m1_s2_vddr_m1_s3_vddr_m1_s4_vddr_m1_vddr_vddr2 rn2 vddr2 1.5474e-17
* device instance cc_a_g_a_rn3_ro_s4_y_y_a_g_y_mnab_y_mpa_y_mpb_y_n1_s1_a_y r0 *1 0,0
Ccc_a_g_a_rn3_ro_s4_y_y_a_g_y_mnab_y_mpa_y_mpb_y_n1_s1_a_y rn3 sig_n1n3 6.626e-18
* device instance cc_a_g_a_rn3_ro_s4_y_y_g_vddr_m1_mnt_g_s1_vddr_m1_s2_vddr_m1_s3_vddr_m1_s4_vddr_m1_vddr_vddr3 r0 *1 0,0
Ccc_a_g_a_rn3_ro_s4_y_y_g_vddr_m1_mnt_g_s1_vddr_m1_s2_vddr_m1_s3_vddr_m1_s4_vddr_m1_vddr_vddr3 rn3 vddr3 1.5474e-17
* device instance cc_a_g_a_rn4_ro_s4_y_y_a_g_y_mnab_y_mpa_y_mpb_y_n1_s1_a_y r0 *1 0,0
Ccc_a_g_a_rn4_ro_s4_y_y_a_g_y_mnab_y_mpa_y_mpb_y_n1_s1_a_y rn4 sig_n1n3 6.626e-18
* device instance cc_a_g_a_rn4_ro_s4_y_y_g_vddr_m1_mnt_g_s1_vddr_m1_s2_vddr_m1_s3_vddr_m1_s4_vddr_m1_vddr_vddr4 r0 *1 0,0
Ccc_a_g_a_rn4_ro_s4_y_y_g_vddr_m1_mnt_g_s1_vddr_m1_s2_vddr_m1_s3_vddr_m1_s4_vddr_m1_vddr_vddr4 rn4 vddr4 1.5474e-17
* device instance cc_a_g_a_rn4_ro_s4_y_y_g_vss_m1_inv_clk_vss_inv_mc_vss_inv_q_vss_mph_g_nand_m_vss_nand_s2_vss_s1_vss_m1_s2_vss_m1_s3_vss_m1_s4_vss_m1_sb_vss_sr1_vss_sr2_vss_sr3_vss_sr4_vss_sv_vss_tg_d_vss_tg_fbm_vss_tg_fbs_vss_tg_s_vss_vss_vss_link_vss_link_bridge_vss_link_dip_vss_link_m1_vss_x1_vss_x2_vss_x3 r0 *1 0,0
Ccc_a_g_a_rn4_ro_s4_y_y_g_vss_m1_inv_clk_vss_inv_mc_vss_inv_q_vss_mph_g_nand_m_vss_nand_s2_vss_s1_vss_m1_s2_vss_m1_s3_vss_m1_s4_vss_m1_sb_vss_sr1_vss_sr2_vss_sr3_vss_sr4_vss_sv_vss_tg_d_vss_tg_fbm_vss_tg_fbs_vss_tg_s_vss_vss_vss_link_vss_link_bridge_vss_link_dip_vss_link_m1_vss_x1_vss_x2_vss_x3 rn4 vss 2.7612e-17
* device instance cc_a_g_y_mnab_y_mpa_y_mpb_y_n1_s1_a_y_g_vss_m1_inv_clk_vss_inv_mc_vss_inv_q_vss_mph_g_nand_m_vss_nand_s2_vss_s1_vss_m1_s2_vss_m1_s3_vss_m1_s4_vss_m1_sb_vss_sr1_vss_sr2_vss_sr3_vss_sr4_vss_sv_vss_tg_d_vss_tg_fbm_vss_tg_fbs_vss_tg_s_vss_vss_vss_link_vss_link_bridge_vss_link_dip_vss_link_m1_vss_x1_vss_x2_vss_x3 r0 *1 0,0
Ccc_a_g_y_mnab_y_mpa_y_mpb_y_n1_s1_a_y_g_vss_m1_inv_clk_vss_inv_mc_vss_inv_q_vss_mph_g_nand_m_vss_nand_s2_vss_s1_vss_m1_s2_vss_m1_s3_vss_m1_s4_vss_m1_sb_vss_sr1_vss_sr2_vss_sr3_vss_sr4_vss_sv_vss_tg_d_vss_tg_fbm_vss_tg_fbs_vss_tg_s_vss_vss_vss_link_vss_link_bridge_vss_link_dip_vss_link_m1_vss_x1_vss_x2_vss_x3 sig_n1n3 vss 1.5474e-17
* device instance cc_a_g_y_mnab_y_mpa_y_mpb_y_n1_s1_a_y_ny r0 *1 0,0
Ccc_a_g_y_mnab_y_mpa_y_mpb_y_n1_s1_a_y_ny sig_n1n3 nyn19 3.0903e-17
* device instance cc_a_inv_mc_a_mb_mnab_y_mpa_y_mpb_y_nand_m_y_tg_s_a_y_a_inv_mc_y_inv_mc_y_via_mc_tg_fbm_a_tg_fbm_a_via_y r0 *1 0,0
Ccc_a_inv_mc_a_mb_mnab_y_mpa_y_mpb_y_nand_m_y_tg_s_a_y_a_inv_mc_y_inv_mc_y_via_mc_tg_fbm_a_tg_fbm_a_via_y mbn5 mcn5 1.37451e-16
* device instance cc_a_inv_mc_a_mb_mnab_y_mpa_y_mpb_y_nand_m_y_tg_s_a_y_clkb_clkb_bridge1_clkb_bridge2_clkb_mid_clkb_w_ctrl_ctrlb_inv_clk_y_tg_d_ctrlb_tg_fbm_ctrl_tg_fbs_ctrlb_tg_s_ctrl_y r0 *1 0,0
Ccc_a_inv_mc_a_mb_mnab_y_mpa_y_mpb_y_nand_m_y_tg_s_a_y_clkb_clkb_bridge1_clkb_bridge2_clkb_mid_clkb_w_ctrl_ctrlb_inv_clk_y_tg_d_ctrlb_tg_fbm_ctrl_tg_fbs_ctrlb_tg_s_ctrl_y mbn5 clkbn5 7.8925e-17
* device instance cc_a_inv_mc_a_mb_mnab_y_mpa_y_mpb_y_nand_m_y_tg_s_a_y_en_nand_m_en_nand_m_en_via_nand_s2_en_nand_s2_en_via_rst_n r0 *1 0,0
Ccc_a_inv_mc_a_mb_mnab_y_mpa_y_mpb_y_nand_m_y_tg_s_a_y_en_nand_m_en_nand_m_en_via_nand_s2_en_nand_s2_en_via_rst_n mbn5 rst_n 9.2845e-17
* device instance cc_a_inv_mc_y_inv_mc_y_via_mc_tg_fbm_a_tg_fbm_a_via_y_clkb_clkb_bridge1_clkb_bridge2_clkb_mid_clkb_w_ctrl_ctrlb_inv_clk_y_tg_d_ctrlb_tg_fbm_ctrl_tg_fbs_ctrlb_tg_s_ctrl_y r0 *1 0,0
Ccc_a_inv_mc_y_inv_mc_y_via_mc_tg_fbm_a_tg_fbm_a_via_y_clkb_clkb_bridge1_clkb_bridge2_clkb_mid_clkb_w_ctrl_ctrlb_inv_clk_y_tg_d_ctrlb_tg_fbm_ctrl_tg_fbs_ctrlb_tg_s_ctrl_y mcn5 clkbn5 1.23251e-16
* device instance cc_a_inv_q_y_inv_q_y_via_inv_q_y_via2_nand_s2_a_nand_s2_a_stub_nand_s2_a_via_nand_s2_a_via2_q_y_a_mnab_y_mpa_y_mpb_y_nand_s2_y_qb_tg_fbs_a_y r0 *1 0,0
Ccc_a_inv_q_y_inv_q_y_via_inv_q_y_via2_nand_s2_a_nand_s2_a_stub_nand_s2_a_via_nand_s2_a_via2_q_y_a_mnab_y_mpa_y_mpb_y_nand_s2_y_qb_tg_fbs_a_y ring_bit4 qbn5 1.09393e-16
* device instance cc_a_inv_q_y_inv_q_y_via_inv_q_y_via2_nand_s2_a_nand_s2_a_stub_nand_s2_a_via_nand_s2_a_via2_q_y_clkb_clkb_bridge1_clkb_bridge2_clkb_mid_clkb_w_ctrl_ctrlb_inv_clk_y_tg_d_ctrlb_tg_fbm_ctrl_tg_fbs_ctrlb_tg_s_ctrl_y r0 *1 0,0
Ccc_a_inv_q_y_inv_q_y_via_inv_q_y_via2_nand_s2_a_nand_s2_a_stub_nand_s2_a_via_nand_s2_a_via2_q_y_clkb_clkb_bridge1_clkb_bridge2_clkb_mid_clkb_w_ctrl_ctrlb_inv_clk_y_tg_d_ctrlb_tg_fbm_ctrl_tg_fbs_ctrlb_tg_s_ctrl_y ring_bit4 clkbn5 5.002e-17
* device instance cc_a_inva_a_mn12_g0_mp13_g0_t1_y_an_inva_y_mn34_g0_mp13_g1_y r0 *1 0,0
Ccc_a_inva_a_mn12_g0_mp13_g0_t1_y_an_inva_y_mn34_g0_mp13_g1_y t1 xor_ann2 3.3e-18
* device instance cc_a_inva_a_mn12_g0_mp13_g0_t1_y_bn_invb_y_mn34_g1_mp24_g1_y r0 *1 0,0
Ccc_a_inva_a_mn12_g0_mp13_g0_t1_y_bn_invb_y_mn34_g1_mp24_g1_y t1 xor_bnn2 9.901e-18
* device instance cc_a_inva_a_mn12_g0_mp13_g0_t1_y_g_vss_m1_inv_clk_vss_inv_mc_vss_inv_q_vss_mph_g_nand_m_vss_nand_s2_vss_s1_vss_m1_s2_vss_m1_s3_vss_m1_s4_vss_m1_sb_vss_sr1_vss_sr2_vss_sr3_vss_sr4_vss_sv_vss_tg_d_vss_tg_fbm_vss_tg_fbs_vss_tg_s_vss_vss_vss_link_vss_link_bridge_vss_link_dip_vss_link_m1_vss_x1_vss_x2_vss_x3 r0 *1 0,0
Ccc_a_inva_a_mn12_g0_mp13_g0_t1_y_g_vss_m1_inv_clk_vss_inv_mc_vss_inv_q_vss_mph_g_nand_m_vss_nand_s2_vss_s1_vss_m1_s2_vss_m1_s3_vss_m1_s4_vss_m1_sb_vss_sr1_vss_sr2_vss_sr3_vss_sr4_vss_sv_vss_tg_d_vss_tg_fbm_vss_tg_fbs_vss_tg_s_vss_vss_vss_link_vss_link_bridge_vss_link_dip_vss_link_m1_vss_x1_vss_x2_vss_x3 t1 vss 1.3955e-17
* device instance cc_a_inva_a_mn12_g0_mp13_g0_t1_y_mid r0 *1 0,0
Ccc_a_inva_a_mn12_g0_mp13_g0_t1_y_mid t1 midn2 3.3e-18
* device instance cc_a_mnab_y_mpa_y_mpb_y_nand_s2_y_qb_tg_fbs_a_y_clkb_clkb_bridge1_clkb_bridge2_clkb_mid_clkb_w_ctrl_ctrlb_inv_clk_y_tg_d_ctrlb_tg_fbm_ctrl_tg_fbs_ctrlb_tg_s_ctrl_y r0 *1 0,0
Ccc_a_mnab_y_mpa_y_mpb_y_nand_s2_y_qb_tg_fbs_a_y_clkb_clkb_bridge1_clkb_bridge2_clkb_mid_clkb_w_ctrl_ctrlb_inv_clk_y_tg_d_ctrlb_tg_fbm_ctrl_tg_fbs_ctrlb_tg_s_ctrl_y qbn5 clkbn5 5.6964e-17
* device instance cc_a_n2_s1_y_s2_a_y_g_vss_m1_inv_clk_vss_inv_mc_vss_inv_q_vss_mph_g_nand_m_vss_nand_s2_vss_s1_vss_m1_s2_vss_m1_s3_vss_m1_s4_vss_m1_sb_vss_sr1_vss_sr2_vss_sr3_vss_sr4_vss_sv_vss_tg_d_vss_tg_fbm_vss_tg_fbs_vss_tg_s_vss_vss_vss_link_vss_link_bridge_vss_link_dip_vss_link_m1_vss_x1_vss_x2_vss_x3 r0 *1 0,0
Ccc_a_n2_s1_y_s2_a_y_g_vss_m1_inv_clk_vss_inv_mc_vss_inv_q_vss_mph_g_nand_m_vss_nand_s2_vss_s1_vss_m1_s2_vss_m1_s3_vss_m1_s4_vss_m1_sb_vss_sr1_vss_sr2_vss_sr3_vss_sr4_vss_sv_vss_tg_d_vss_tg_fbm_vss_tg_fbs_vss_tg_s_vss_vss_vss_link_vss_link_bridge_vss_link_dip_vss_link_m1_vss_x1_vss_x2_vss_x3 sig_n2n3 vss 1.5474e-17
* device instance cc_a_n2_s1_y_s2_a_y_ny r0 *1 0,0
Ccc_a_n2_s1_y_s2_a_y_ny sig_n2n3 nyn19 3.0903e-17
* device instance cc_a_n3_s2_y_s3_a_y_g_vss_m1_inv_clk_vss_inv_mc_vss_inv_q_vss_mph_g_nand_m_vss_nand_s2_vss_s1_vss_m1_s2_vss_m1_s3_vss_m1_s4_vss_m1_sb_vss_sr1_vss_sr2_vss_sr3_vss_sr4_vss_sv_vss_tg_d_vss_tg_fbm_vss_tg_fbs_vss_tg_s_vss_vss_vss_link_vss_link_bridge_vss_link_dip_vss_link_m1_vss_x1_vss_x2_vss_x3 r0 *1 0,0
Ccc_a_n3_s2_y_s3_a_y_g_vss_m1_inv_clk_vss_inv_mc_vss_inv_q_vss_mph_g_nand_m_vss_nand_s2_vss_s1_vss_m1_s2_vss_m1_s3_vss_m1_s4_vss_m1_sb_vss_sr1_vss_sr2_vss_sr3_vss_sr4_vss_sv_vss_tg_d_vss_tg_fbm_vss_tg_fbs_vss_tg_s_vss_vss_vss_link_vss_link_bridge_vss_link_dip_vss_link_m1_vss_x1_vss_x2_vss_x3 sig_n3n3 vss 1.5474e-17
* device instance cc_a_n3_s2_y_s3_a_y_ny r0 *1 0,0
Ccc_a_n3_s2_y_s3_a_y_ny sig_n3n3 nyn19 3.0903e-17
* device instance cc_a_n4_s3_y_s4_a_y_g_vss_m1_inv_clk_vss_inv_mc_vss_inv_q_vss_mph_g_nand_m_vss_nand_s2_vss_s1_vss_m1_s2_vss_m1_s3_vss_m1_s4_vss_m1_sb_vss_sr1_vss_sr2_vss_sr3_vss_sr4_vss_sv_vss_tg_d_vss_tg_fbm_vss_tg_fbs_vss_tg_s_vss_vss_vss_link_vss_link_bridge_vss_link_dip_vss_link_m1_vss_x1_vss_x2_vss_x3 r0 *1 0,0
Ccc_a_n4_s3_y_s4_a_y_g_vss_m1_inv_clk_vss_inv_mc_vss_inv_q_vss_mph_g_nand_m_vss_nand_s2_vss_s1_vss_m1_s2_vss_m1_s3_vss_m1_s4_vss_m1_sb_vss_sr1_vss_sr2_vss_sr3_vss_sr4_vss_sv_vss_tg_d_vss_tg_fbm_vss_tg_fbs_vss_tg_s_vss_vss_vss_link_vss_link_bridge_vss_link_dip_vss_link_m1_vss_x1_vss_x2_vss_x3 sig_n4n3 vss 1.5474e-17
* device instance cc_a_n4_s3_y_s4_a_y_ny r0 *1 0,0
Ccc_a_n4_s3_y_s4_a_y_ny sig_n4n3 nyn19 3.0903e-17
* device instance cc_bn_invb_y_mn34_g1_mp24_g1_y_mid r0 *1 0,0
Ccc_bn_invb_y_mn34_g1_mp24_g1_y_mid xor_bnn2 midn2 9.901e-18
* device instance cc_clkb_clkb_bridge1_clkb_bridge2_clkb_mid_clkb_w_ctrl_ctrlb_inv_clk_y_tg_d_ctrlb_tg_fbm_ctrl_tg_fbs_ctrlb_tg_s_ctrl_y_en_nand_m_en_nand_m_en_via_nand_s2_en_nand_s2_en_via_rst_n r0 *1 0,0
Ccc_clkb_clkb_bridge1_clkb_bridge2_clkb_mid_clkb_w_ctrl_ctrlb_inv_clk_y_tg_d_ctrlb_tg_fbm_ctrl_tg_fbs_ctrlb_tg_s_ctrl_y_en_nand_m_en_nand_m_en_via_nand_s2_en_nand_s2_en_via_rst_n clkbn5 rst_n 5.11091e-16
* device instance cc_clkb_clkb_bridge1_clkb_bridge2_clkb_mid_clkb_w_ctrl_ctrlb_inv_clk_y_tg_d_ctrlb_tg_fbm_ctrl_tg_fbs_ctrlb_tg_s_ctrl_y_g_vss_m1_inv_clk_vss_inv_mc_vss_inv_q_vss_mph_g_nand_m_vss_nand_s2_vss_s1_vss_m1_s2_vss_m1_s3_vss_m1_s4_vss_m1_sb_vss_sr1_vss_sr2_vss_sr3_vss_sr4_vss_sv_vss_tg_d_vss_tg_fbm_vss_tg_fbs_vss_tg_s_vss_vss_vss_link_vss_link_bridge_vss_link_dip_vss_link_m1_vss_x1_vss_x2_vss_x3 r0 *1 0,0
Ccc_clkb_clkb_bridge1_clkb_bridge2_clkb_mid_clkb_w_ctrl_ctrlb_inv_clk_y_tg_d_ctrlb_tg_fbm_ctrl_tg_fbs_ctrlb_tg_s_ctrl_y_g_vss_m1_inv_clk_vss_inv_mc_vss_inv_q_vss_mph_g_nand_m_vss_nand_s2_vss_s1_vss_m1_s2_vss_m1_s3_vss_m1_s4_vss_m1_sb_vss_sr1_vss_sr2_vss_sr3_vss_sr4_vss_sv_vss_tg_d_vss_tg_fbm_vss_tg_fbs_vss_tg_s_vss_vss_vss_link_vss_link_bridge_vss_link_dip_vss_link_m1_vss_x1_vss_x2_vss_x3 clkbn5 vss 5.12256e-16
* device instance cc_en_nand_m_en_nand_m_en_via_nand_s2_en_nand_s2_en_via_rst_n_g_vss_m1_inv_clk_vss_inv_mc_vss_inv_q_vss_mph_g_nand_m_vss_nand_s2_vss_s1_vss_m1_s2_vss_m1_s3_vss_m1_s4_vss_m1_sb_vss_sr1_vss_sr2_vss_sr3_vss_sr4_vss_sv_vss_tg_d_vss_tg_fbm_vss_tg_fbs_vss_tg_s_vss_vss_vss_link_vss_link_bridge_vss_link_dip_vss_link_m1_vss_x1_vss_x2_vss_x3 r0 *1 0,0
Ccc_en_nand_m_en_nand_m_en_via_nand_s2_en_nand_s2_en_via_rst_n_g_vss_m1_inv_clk_vss_inv_mc_vss_inv_q_vss_mph_g_nand_m_vss_nand_s2_vss_s1_vss_m1_s2_vss_m1_s3_vss_m1_s4_vss_m1_sb_vss_sr1_vss_sr2_vss_sr3_vss_sr4_vss_sv_vss_tg_d_vss_tg_fbm_vss_tg_fbs_vss_tg_s_vss_vss_vss_link_vss_link_bridge_vss_link_dip_vss_link_m1_vss_x1_vss_x2_vss_x3 rst_n vss 3.869e-18
* device instance cc_g_vddr_m1_mnt_g_s1_vddr_m1_s2_vddr_m1_s3_vddr_m1_s4_vddr_m1_vddr_vddr1_py r0 *1 0,0
Ccc_g_vddr_m1_mnt_g_s1_vddr_m1_s2_vddr_m1_s3_vddr_m1_s4_vddr_m1_vddr_vddr1_py vddr1 pyn15 1.2471e-17
* device instance cc_g_vddr_m1_mnt_g_s1_vddr_m1_s2_vddr_m1_s3_vddr_m1_s4_vddr_m1_vddr_vddr2_py r0 *1 0,0
Ccc_g_vddr_m1_mnt_g_s1_vddr_m1_s2_vddr_m1_s3_vddr_m1_s4_vddr_m1_vddr_vddr2_py vddr2 pyn15 1.3064e-17
* device instance cc_g_vddr_m1_mnt_g_s1_vddr_m1_s2_vddr_m1_s3_vddr_m1_s4_vddr_m1_vddr_vddr3_py r0 *1 0,0
Ccc_g_vddr_m1_mnt_g_s1_vddr_m1_s2_vddr_m1_s3_vddr_m1_s4_vddr_m1_vddr_vddr3_py vddr3 pyn15 1.3658e-17
* device instance cc_g_vddr_m1_mnt_g_s1_vddr_m1_s2_vddr_m1_s3_vddr_m1_s4_vddr_m1_vddr_vddr4_py r0 *1 0,0
Ccc_g_vddr_m1_mnt_g_s1_vddr_m1_s2_vddr_m1_s3_vddr_m1_s4_vddr_m1_vddr_vddr4_py vddr4 pyn15 1.4252e-17
* device instance vsubs_dctie r0 *1 0,0
Rvsubs_dctie vsubs 0 1e+12
.ends sampler_core_pex__core

* sampler_core_pex -- design-port-order wrapper over sampler_core_pex__core.
* Promoted-internal layout pins kept local here: t2, ro2, ro4, s, sn1, sn2, sn3, sn4, sn5, m, mn1, mn2, mn3, mn4, mn5, ro1, ro3, xo, rn1, rn2, rn3, rn4, sig_n1, sig_n1n1, sig_n1n2, sig_n1n3, mb, mbn1, mbn2, mbn3, mbn4, mbn5, mc, mcn1, mcn2, mcn3, mcn4, mcn5, t1, qb, qbn1, qbn2, qbn3, qbn4, qbn5, sig_n2, sig_n2n1, sig_n2n2, sig_n2n3, sig_n3, sig_n3n1, sig_n3n2, sig_n3n3, sig_n4, sig_n4n1, sig_n4n2, sig_n4n3, xor_an, xor_ann1, xor_ann2, xor_bn, xor_bnn1, xor_bnn2, clkb, clkbn1, clkbn2, clkbn3, clkbn4, clkbn5, mid, midn1, midn2, py_g, py_gn1, py_gn2, py_gn3, ny, nyn1, nyn2, nyn3, nyn4, nyn5, nyn6, nyn7, nyn8, nyn9, nyn10, nyn11, nyn12, nyn13, nyn14, nyn15, nyn16, nyn17, nyn18, nyn19, py, pyn1, pyn2, pyn3, pyn4, pyn5, pyn6, pyn7, pyn8, pyn9, pyn10, pyn11, pyn12, pyn13, pyn14, pyn15
.subckt sampler_core_pex en1 en2 en3 en4 vddr1 vddr2 vddr3 vddr4 vdd vss clk rst_n raw_bit raw_valid ring_bit1 ring_bit2 ring_bit3 ring_bit4
xpex t2 ro2 ro4 s sn1 sn2 sn3 sn4 sn5 m mn1 mn2 mn3 mn4 mn5 clk vdd ro1 ro3 xo rn1 rn2 rn3 rn4 sig_n1 sig_n1n1 sig_n1n2 sig_n1n3 mb mbn1 mbn2 mbn3 mbn4 mbn5 mc mcn1 mcn2 mcn3 mcn4 mcn5 raw_bit raw_valid ring_bit1 ring_bit2 ring_bit3 ring_bit4 t1 qb qbn1 qbn2 qbn3 qbn4 qbn5 sig_n2 sig_n2n1 sig_n2n2 sig_n2n3 sig_n3 sig_n3n1 sig_n3n2 sig_n3n3 sig_n4 sig_n4n1 sig_n4n2 sig_n4n3 xor_an xor_ann1 xor_ann2 xor_bn xor_bnn1 xor_bnn2 clkb clkbn1 clkbn2 clkbn3 clkbn4 clkbn5 en1 en2 en3 en4 rst_n vddr1 vddr2 vddr3 vddr4 vss mid midn1 midn2 py_g py_gn1 py_gn2 py_gn3 ny nyn1 nyn2 nyn3 nyn4 nyn5 nyn6 nyn7 nyn8 nyn9 nyn10 nyn11 nyn12 nyn13 nyn14 nyn15 nyn16 nyn17 nyn18 nyn19 py pyn1 pyn2 pyn3 pyn4 pyn5 pyn6 pyn7 pyn8 pyn9 pyn10 pyn11 pyn12 pyn13 pyn14 pyn15 sampler_core_pex__core
.ends sampler_core_pex
