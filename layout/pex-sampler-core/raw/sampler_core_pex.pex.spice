* extracted by klt extract --deck sky130
* parasitic model (--parasitics):
* - capacitance: net-to-ground for every net's own (non-coupled) area/perimeter, plus net-to-net for the vertical-overlap coupling `coupling` describes below -- a coupled net pair gets a direct capacitor between their two hub nodes, not just capacitors to the deck's ground/substrate net
* - coupling: vertical overlap (crossover) unconditionally -- where one net's conductor on an adjacent metal level sits directly over another *distinct* net's conductor, that overlap area is charged between the two nets instead of to ground (issue #760) -- plus lateral (same-layer, sidewall) coupling, but only for a net pair naming one of the caller's declared `--critical-net` nets (issue #976): facing-edge length within that layer's own minimum-spacing lookback is charged between the two nets, *additively* (not deducted from either net's substrate fringe term, unlike the vertical case -- a known simplification). Any same-layer pair with neither side named `--critical-net`, and fringe shielding in general, are still not modelled
* - resistance: single lumped series resistance per net, distributed as a star across that net's device terminals (issue #592) -- not a per-segment, distributed RC ladder, *unless* `--distributed-rc` names this net via `--critical-net` (issue #977, Epic #709 Phase 2b): then the net's terminals are ordered along their approximate physical spread and its total R/C is broken into a chain of per-segment resistors (segment length proportional to inter-terminal distance) with a ground capacitor at each terminal node (proportional to its adjacent segment length/2), instead of one star hub -- still an approximation (terminal position is a device-placement proxy, not true per-segment routing geometry), but a strictly finer-grained one than the single-hub star
* - frequency: quasi-static -- one frequency-independent R and C per net; no skin effect, no distributed transmission-line behavior

* cell sampler_core
* pin a,b,b3,invb_a,mn12_g1,mp24_g0,t2,y
* pin a,b,d,invb_a,mn12_g1,mp24_g0,ro2,ro2_esc,sr2_d_stub,tg_d_a,y
* pin a,b,d,invb_a,mn12_g1,mp24_g0,ro4,ro4_esc,sr4_d_stub,tg_d_a,y
* pin a,b,inv_q_a,inv_q_a_via,s,tg_fbs_b,tg_fbs_b_via,tg_s_b,tg_s_b_via
* pin a,b,inv_q_a,inv_q_a_via,s,tg_fbs_b,tg_fbs_b_via,tg_s_b,tg_s_b_via
* pin a,b,inv_q_a,inv_q_a_via,s,tg_fbs_b,tg_fbs_b_via,tg_s_b,tg_s_b_via
* pin a,b,inv_q_a,inv_q_a_via,s,tg_fbs_b,tg_fbs_b_via,tg_s_b,tg_s_b_via
* pin a,b,inv_q_a,inv_q_a_via,s,tg_fbs_b,tg_fbs_b_via,tg_s_b,tg_s_b_via
* pin a,b,inv_q_a,inv_q_a_via,s,tg_fbs_b,tg_fbs_b_via,tg_s_b,tg_s_b_via
* pin a,b,m_east,m_west,nand_m_a,nand_m_a_ext_via,nand_m_a_ext_via2,nand_m_a_stub,tg_d_b,tg_d_b_via,tg_d_b_via2,tg_fbm_b,tg_fbm_b_alt_via,tg_fbm_b_alt_via2
* pin a,b,m_east,m_west,nand_m_a,nand_m_a_ext_via,nand_m_a_ext_via2,nand_m_a_stub,tg_d_b,tg_d_b_via,tg_d_b_via2,tg_fbm_b,tg_fbm_b_alt_via,tg_fbm_b_alt_via2
* pin a,b,m_east,m_west,nand_m_a,nand_m_a_ext_via,nand_m_a_ext_via2,nand_m_a_stub,tg_d_b,tg_d_b_via,tg_d_b_via2,tg_fbm_b,tg_fbm_b_alt_via,tg_fbm_b_alt_via2
* pin a,b,m_east,m_west,nand_m_a,nand_m_a_ext_via,nand_m_a_ext_via2,nand_m_a_stub,tg_d_b,tg_d_b_via,tg_d_b_via2,tg_fbm_b,tg_fbm_b_alt_via,tg_fbm_b_alt_via2
* pin a,b,m_east,m_west,nand_m_a,nand_m_a_ext_via,nand_m_a_ext_via2,nand_m_a_stub,tg_d_b,tg_d_b_via,tg_d_b_via2,tg_fbm_b,tg_fbm_b_alt_via,tg_fbm_b_alt_via2
* pin a,b,m_east,m_west,nand_m_a,nand_m_a_ext_via,nand_m_a_ext_via2,nand_m_a_stub,tg_d_b,tg_d_b_via,tg_d_b_via2,tg_fbm_b,tg_fbm_b_alt_via,tg_fbm_b_alt_via2
* pin a,clk,ctrl,ctrlb,inv_clk_a,inv_clk_clk_via,tg_d_ctrl,tg_d_ctrl_via,tg_fbm_ctrlb,tg_fbm_ctrlb_via,tg_fbs_ctrl,tg_fbs_ctrl_via,tg_s_ctrlb,tg_s_ctrlb_via
* pin a,d,inv_clk_vdd,inv_mc_vdd,inv_q_vdd,mpa_py,mpb_py,nand_m_vdd,nand_s2_vdd,nwell_vdd,sb_vdd,sr1_vdd,sr2_vdd,sr3_vdd,sr4_vdd,sv_d_vdd_tie,sv_vdd,tg_d_a,tg_d_vdd,tg_fbm_vdd,tg_fbs_vdd,tg_s_vdd,vdd,vdd_b1,vdd_b2,vdd_b3,vdd_b4,vdd_link,vdd_link_dip,vdd_x1,vdd_x2,vdd_x3
* pin a,d,inva_a,mn12_g0,mp13_g0,ro1,ro1_esc,sr1_d_stub,tg_d_a,y
* pin a,d,inva_a,mn12_g0,mp13_g0,ro3,ro3_esc_e,ro3_esc_w,ro3_hop,sr3_d_stub,tg_d_a,y
* pin a,d,sb_d_stub,tg_d_a,xo,xo_dip,xo_hop,xo_stub,y
* pin a,g_a,rn1,ro,s4_y,y
* pin a,g_a,rn2,ro,s4_y,y
* pin a,g_a,rn3,ro,s4_y,y
* pin a,g_a,rn4,ro,s4_y,y
* pin a,g_y,mnab_y,mpa_y,mpb_y,n1,s1_a,y
* pin a,g_y,mnab_y,mpa_y,mpb_y,n1,s1_a,y
* pin a,g_y,mnab_y,mpa_y,mpb_y,n1,s1_a,y
* pin a,g_y,mnab_y,mpa_y,mpb_y,n1,s1_a,y
* pin a,inv_mc_a,mb,mnab_y,mpa_y,mpb_y,nand_m_y,tg_s_a,y
* pin a,inv_mc_a,mb,mnab_y,mpa_y,mpb_y,nand_m_y,tg_s_a,y
* pin a,inv_mc_a,mb,mnab_y,mpa_y,mpb_y,nand_m_y,tg_s_a,y
* pin a,inv_mc_a,mb,mnab_y,mpa_y,mpb_y,nand_m_y,tg_s_a,y
* pin a,inv_mc_a,mb,mnab_y,mpa_y,mpb_y,nand_m_y,tg_s_a,y
* pin a,inv_mc_a,mb,mnab_y,mpa_y,mpb_y,nand_m_y,tg_s_a,y
* pin a,inv_mc_y,inv_mc_y_via,mc,tg_fbm_a,tg_fbm_a_via,y
* pin a,inv_mc_y,inv_mc_y_via,mc,tg_fbm_a,tg_fbm_a_via,y
* pin a,inv_mc_y,inv_mc_y_via,mc,tg_fbm_a,tg_fbm_a_via,y
* pin a,inv_mc_y,inv_mc_y_via,mc,tg_fbm_a,tg_fbm_a_via,y
* pin a,inv_mc_y,inv_mc_y_via,mc,tg_fbm_a,tg_fbm_a_via,y
* pin a,inv_mc_y,inv_mc_y_via,mc,tg_fbm_a,tg_fbm_a_via,y
* pin a,inv_q_y,inv_q_y_via,inv_q_y_via2,nand_s2_a,nand_s2_a_stub,nand_s2_a_via,nand_s2_a_via2,q,y
* pin a,inv_q_y,inv_q_y_via,inv_q_y_via2,nand_s2_a,nand_s2_a_stub,nand_s2_a_via,nand_s2_a_via2,q,y
* pin a,inv_q_y,inv_q_y_via,inv_q_y_via2,nand_s2_a,nand_s2_a_stub,nand_s2_a_via,nand_s2_a_via2,q,y
* pin a,inv_q_y,inv_q_y_via,inv_q_y_via2,nand_s2_a,nand_s2_a_stub,nand_s2_a_via,nand_s2_a_via2,q,y
* pin a,inv_q_y,inv_q_y_via,inv_q_y_via2,nand_s2_a,nand_s2_a_stub,nand_s2_a_via,nand_s2_a_via2,q,y
* pin a,inv_q_y,inv_q_y_via,inv_q_y_via2,nand_s2_a,nand_s2_a_stub,nand_s2_a_via,nand_s2_a_via2,q,y
* pin a,inva_a,mn12_g0,mp13_g0,t1,y
* pin a,mnab_y,mpa_y,mpb_y,nand_s2_y,qb,tg_fbs_a,y
* pin a,mnab_y,mpa_y,mpb_y,nand_s2_y,qb,tg_fbs_a,y
* pin a,mnab_y,mpa_y,mpb_y,nand_s2_y,qb,tg_fbs_a,y
* pin a,mnab_y,mpa_y,mpb_y,nand_s2_y,qb,tg_fbs_a,y
* pin a,mnab_y,mpa_y,mpb_y,nand_s2_y,qb,tg_fbs_a,y
* pin a,mnab_y,mpa_y,mpb_y,nand_s2_y,qb,tg_fbs_a,y
* pin a,n2,s1_y,s2_a,y
* pin a,n2,s1_y,s2_a,y
* pin a,n2,s1_y,s2_a,y
* pin a,n2,s1_y,s2_a,y
* pin a,n3,s2_y,s3_a,y
* pin a,n3,s2_y,s3_a,y
* pin a,n3,s2_y,s3_a,y
* pin a,n3,s2_y,s3_a,y
* pin a,n4,s3_y,s4_a,y
* pin a,n4,s3_y,s4_a,y
* pin a,n4,s3_y,s4_a,y
* pin a,n4,s3_y,s4_a,y
* pin an,inva_y,mn34_g0,mp13_g1,y
* pin an,inva_y,mn34_g0,mp13_g1,y
* pin an,inva_y,mn34_g0,mp13_g1,y
* pin bn,invb_y,mn34_g1,mp24_g1,y
* pin bn,invb_y,mn34_g1,mp24_g1,y
* pin bn,invb_y,mn34_g1,mp24_g1,y
* pin clkb,clkb_bridge1,clkb_bridge2,clkb_mid,clkb_w,ctrl,ctrlb,inv_clk_y,tg_d_ctrlb,tg_fbm_ctrl,tg_fbs_ctrlb,tg_s_ctrl,y
* pin clkb,clkb_bridge1,clkb_bridge2,clkb_mid,clkb_w,ctrl,ctrlb,inv_clk_y,tg_d_ctrlb,tg_fbm_ctrl,tg_fbs_ctrlb,tg_s_ctrl,y
* pin clkb,clkb_bridge1,clkb_bridge2,clkb_mid,clkb_w,ctrl,ctrlb,inv_clk_y,tg_d_ctrlb,tg_fbm_ctrl,tg_fbs_ctrlb,tg_s_ctrl,y
* pin clkb,clkb_bridge1,clkb_bridge2,clkb_mid,clkb_w,ctrl,ctrlb,inv_clk_y,tg_d_ctrlb,tg_fbm_ctrl,tg_fbs_ctrlb,tg_s_ctrl,y
* pin clkb,clkb_bridge1,clkb_bridge2,clkb_mid,clkb_w,ctrl,ctrlb,inv_clk_y,tg_d_ctrlb,tg_fbm_ctrl,tg_fbs_ctrlb,tg_s_ctrl,y
* pin clkb,clkb_bridge1,clkb_bridge2,clkb_mid,clkb_w,ctrl,ctrlb,inv_clk_y,tg_d_ctrlb,tg_fbm_ctrl,tg_fbs_ctrlb,tg_s_ctrl,y
* pin en,en1,g_en
* pin en,en2,g_en
* pin en,en3,g_en
* pin en,en4,g_en
* pin en,nand_m_en,nand_m_en_via,nand_s2_en,nand_s2_en_via,rst_n
* pin g_vddr_m1,mnt_g,s1_vddr_m1,s2_vddr_m1,s3_vddr_m1,s4_vddr_m1,vddr,vddr1
* pin g_vddr_m1,mnt_g,s1_vddr_m1,s2_vddr_m1,s3_vddr_m1,s4_vddr_m1,vddr,vddr2
* pin g_vddr_m1,mnt_g,s1_vddr_m1,s2_vddr_m1,s3_vddr_m1,s4_vddr_m1,vddr,vddr3
* pin g_vddr_m1,mnt_g,s1_vddr_m1,s2_vddr_m1,s3_vddr_m1,s4_vddr_m1,vddr,vddr4
* pin g_vss_m1,inv_clk_vss,inv_mc_vss,inv_q_vss,mph_g,nand_m_vss,nand_s2_vss,s1_vss_m1,s2_vss_m1,s3_vss_m1,s4_vss_m1,sb_vss,sr1_vss,sr2_vss,sr3_vss,sr4_vss,sv_vss,tg_d_vss,tg_fbm_vss,tg_fbs_vss,tg_s_vss,vss,vss_link,vss_link_bridge,vss_link_dip,vss_link_m1,vss_x1,vss_x2,vss_x3
* pin mid
* pin mid
* pin mid
* pin mpa_py,mpb_py,mph_py,py
* pin mpa_py,mpb_py,mph_py,py
* pin mpa_py,mpb_py,mph_py,py
* pin mpa_py,mpb_py,mph_py,py
* pin ny
* pin ny
* pin ny
* pin ny
* pin ny
* pin ny
* pin ny
* pin ny
* pin ny
* pin ny
* pin ny
* pin ny
* pin ny
* pin ny
* pin ny
* pin ny
* pin ny
* pin ny
* pin ny
* pin ny
* pin py
* pin py
* pin py
* pin py
* pin py
* pin py
* pin py
* pin py
* pin py
* pin py
* pin py
* pin py
* pin py
* pin py
* pin py
* pin py
.SUBCKT sampler_core a|b|b3|invb_a|mn12_g1|mp24_g0|t2|y
+ a|b|d|invb_a|mn12_g1|mp24_g0|ro2|ro2_esc|sr2_d_stub|tg_d_a|y
+ a|b|d|invb_a|mn12_g1|mp24_g0|ro4|ro4_esc|sr4_d_stub|tg_d_a|y
+ a|b|inv_q_a|inv_q_a_via|s|tg_fbs_b|tg_fbs_b_via|tg_s_b|tg_s_b_via
+ a|b|inv_q_a|inv_q_a_via|s|tg_fbs_b|tg_fbs_b_via|tg_s_b|tg_s_b_via$1
+ a|b|inv_q_a|inv_q_a_via|s|tg_fbs_b|tg_fbs_b_via|tg_s_b|tg_s_b_via$2
+ a|b|inv_q_a|inv_q_a_via|s|tg_fbs_b|tg_fbs_b_via|tg_s_b|tg_s_b_via$3
+ a|b|inv_q_a|inv_q_a_via|s|tg_fbs_b|tg_fbs_b_via|tg_s_b|tg_s_b_via$4
+ a|b|inv_q_a|inv_q_a_via|s|tg_fbs_b|tg_fbs_b_via|tg_s_b|tg_s_b_via$5
+ a|b|m_east|m_west|nand_m_a|nand_m_a_ext_via|nand_m_a_ext_via2|nand_m_a_stub|tg_d_b|tg_d_b_via|tg_d_b_via2|tg_fbm_b|tg_fbm_b_alt_via|tg_fbm_b_alt_via2
+ a|b|m_east|m_west|nand_m_a|nand_m_a_ext_via|nand_m_a_ext_via2|nand_m_a_stub|tg_d_b|tg_d_b_via|tg_d_b_via2|tg_fbm_b|tg_fbm_b_alt_via|tg_fbm_b_alt_via2$1
+ a|b|m_east|m_west|nand_m_a|nand_m_a_ext_via|nand_m_a_ext_via2|nand_m_a_stub|tg_d_b|tg_d_b_via|tg_d_b_via2|tg_fbm_b|tg_fbm_b_alt_via|tg_fbm_b_alt_via2$2
+ a|b|m_east|m_west|nand_m_a|nand_m_a_ext_via|nand_m_a_ext_via2|nand_m_a_stub|tg_d_b|tg_d_b_via|tg_d_b_via2|tg_fbm_b|tg_fbm_b_alt_via|tg_fbm_b_alt_via2$3
+ a|b|m_east|m_west|nand_m_a|nand_m_a_ext_via|nand_m_a_ext_via2|nand_m_a_stub|tg_d_b|tg_d_b_via|tg_d_b_via2|tg_fbm_b|tg_fbm_b_alt_via|tg_fbm_b_alt_via2$4
+ a|b|m_east|m_west|nand_m_a|nand_m_a_ext_via|nand_m_a_ext_via2|nand_m_a_stub|tg_d_b|tg_d_b_via|tg_d_b_via2|tg_fbm_b|tg_fbm_b_alt_via|tg_fbm_b_alt_via2$5
+ a|clk|ctrl|ctrlb|inv_clk_a|inv_clk_clk_via|tg_d_ctrl|tg_d_ctrl_via|tg_fbm_ctrlb|tg_fbm_ctrlb_via|tg_fbs_ctrl|tg_fbs_ctrl_via|tg_s_ctrlb|tg_s_ctrlb_via
+ a|d|inv_clk_vdd|inv_mc_vdd|inv_q_vdd|mpa_py|mpb_py|nand_m_vdd|nand_s2_vdd|nwell_vdd|sb_vdd|sr1_vdd|sr2_vdd|sr3_vdd|sr4_vdd|sv_d_vdd_tie|sv_vdd|tg_d_a|tg_d_vdd|tg_fbm_vdd|tg_fbs_vdd|tg_s_vdd|vdd|vdd_b1|vdd_b2|vdd_b3|vdd_b4|vdd_link|vdd_link_dip|vdd_x1|vdd_x2|vdd_x3
+ a|d|inva_a|mn12_g0|mp13_g0|ro1|ro1_esc|sr1_d_stub|tg_d_a|y
+ a|d|inva_a|mn12_g0|mp13_g0|ro3|ro3_esc_e|ro3_esc_w|ro3_hop|sr3_d_stub|tg_d_a|y
+ a|d|sb_d_stub|tg_d_a|xo|xo_dip|xo_hop|xo_stub|y a|g_a|rn1|ro|s4_y|y
+ a|g_a|rn2|ro|s4_y|y a|g_a|rn3|ro|s4_y|y a|g_a|rn4|ro|s4_y|y
+ a|g_y|mnab_y|mpa_y|mpb_y|n1|s1_a|y a|g_y|mnab_y|mpa_y|mpb_y|n1|s1_a|y$1
+ a|g_y|mnab_y|mpa_y|mpb_y|n1|s1_a|y$2 a|g_y|mnab_y|mpa_y|mpb_y|n1|s1_a|y$3
+ a|inv_mc_a|mb|mnab_y|mpa_y|mpb_y|nand_m_y|tg_s_a|y
+ a|inv_mc_a|mb|mnab_y|mpa_y|mpb_y|nand_m_y|tg_s_a|y$1
+ a|inv_mc_a|mb|mnab_y|mpa_y|mpb_y|nand_m_y|tg_s_a|y$2
+ a|inv_mc_a|mb|mnab_y|mpa_y|mpb_y|nand_m_y|tg_s_a|y$3
+ a|inv_mc_a|mb|mnab_y|mpa_y|mpb_y|nand_m_y|tg_s_a|y$4
+ a|inv_mc_a|mb|mnab_y|mpa_y|mpb_y|nand_m_y|tg_s_a|y$5
+ a|inv_mc_y|inv_mc_y_via|mc|tg_fbm_a|tg_fbm_a_via|y
+ a|inv_mc_y|inv_mc_y_via|mc|tg_fbm_a|tg_fbm_a_via|y$1
+ a|inv_mc_y|inv_mc_y_via|mc|tg_fbm_a|tg_fbm_a_via|y$2
+ a|inv_mc_y|inv_mc_y_via|mc|tg_fbm_a|tg_fbm_a_via|y$3
+ a|inv_mc_y|inv_mc_y_via|mc|tg_fbm_a|tg_fbm_a_via|y$4
+ a|inv_mc_y|inv_mc_y_via|mc|tg_fbm_a|tg_fbm_a_via|y$5
+ a|inv_q_y|inv_q_y_via|inv_q_y_via2|nand_s2_a|nand_s2_a_stub|nand_s2_a_via|nand_s2_a_via2|q|y
+ a|inv_q_y|inv_q_y_via|inv_q_y_via2|nand_s2_a|nand_s2_a_stub|nand_s2_a_via|nand_s2_a_via2|q|y$1
+ a|inv_q_y|inv_q_y_via|inv_q_y_via2|nand_s2_a|nand_s2_a_stub|nand_s2_a_via|nand_s2_a_via2|q|y$2
+ a|inv_q_y|inv_q_y_via|inv_q_y_via2|nand_s2_a|nand_s2_a_stub|nand_s2_a_via|nand_s2_a_via2|q|y$3
+ a|inv_q_y|inv_q_y_via|inv_q_y_via2|nand_s2_a|nand_s2_a_stub|nand_s2_a_via|nand_s2_a_via2|q|y$4
+ a|inv_q_y|inv_q_y_via|inv_q_y_via2|nand_s2_a|nand_s2_a_stub|nand_s2_a_via|nand_s2_a_via2|q|y$5
+ a|inva_a|mn12_g0|mp13_g0|t1|y a|mnab_y|mpa_y|mpb_y|nand_s2_y|qb|tg_fbs_a|y
+ a|mnab_y|mpa_y|mpb_y|nand_s2_y|qb|tg_fbs_a|y$1
+ a|mnab_y|mpa_y|mpb_y|nand_s2_y|qb|tg_fbs_a|y$2
+ a|mnab_y|mpa_y|mpb_y|nand_s2_y|qb|tg_fbs_a|y$3
+ a|mnab_y|mpa_y|mpb_y|nand_s2_y|qb|tg_fbs_a|y$4
+ a|mnab_y|mpa_y|mpb_y|nand_s2_y|qb|tg_fbs_a|y$5 a|n2|s1_y|s2_a|y
+ a|n2|s1_y|s2_a|y$1 a|n2|s1_y|s2_a|y$2 a|n2|s1_y|s2_a|y$3 a|n3|s2_y|s3_a|y
+ a|n3|s2_y|s3_a|y$1 a|n3|s2_y|s3_a|y$2 a|n3|s2_y|s3_a|y$3 a|n4|s3_y|s4_a|y
+ a|n4|s3_y|s4_a|y$1 a|n4|s3_y|s4_a|y$2 a|n4|s3_y|s4_a|y$3
+ an|inva_y|mn34_g0|mp13_g1|y an|inva_y|mn34_g0|mp13_g1|y$1
+ an|inva_y|mn34_g0|mp13_g1|y$2 bn|invb_y|mn34_g1|mp24_g1|y
+ bn|invb_y|mn34_g1|mp24_g1|y$1 bn|invb_y|mn34_g1|mp24_g1|y$2
+ clkb|clkb_bridge1|clkb_bridge2|clkb_mid|clkb_w|ctrl|ctrlb|inv_clk_y|tg_d_ctrlb|tg_fbm_ctrl|tg_fbs_ctrlb|tg_s_ctrl|y
+ clkb|clkb_bridge1|clkb_bridge2|clkb_mid|clkb_w|ctrl|ctrlb|inv_clk_y|tg_d_ctrlb|tg_fbm_ctrl|tg_fbs_ctrlb|tg_s_ctrl|y$1
+ clkb|clkb_bridge1|clkb_bridge2|clkb_mid|clkb_w|ctrl|ctrlb|inv_clk_y|tg_d_ctrlb|tg_fbm_ctrl|tg_fbs_ctrlb|tg_s_ctrl|y$2
+ clkb|clkb_bridge1|clkb_bridge2|clkb_mid|clkb_w|ctrl|ctrlb|inv_clk_y|tg_d_ctrlb|tg_fbm_ctrl|tg_fbs_ctrlb|tg_s_ctrl|y$3
+ clkb|clkb_bridge1|clkb_bridge2|clkb_mid|clkb_w|ctrl|ctrlb|inv_clk_y|tg_d_ctrlb|tg_fbm_ctrl|tg_fbs_ctrlb|tg_s_ctrl|y$4
+ clkb|clkb_bridge1|clkb_bridge2|clkb_mid|clkb_w|ctrl|ctrlb|inv_clk_y|tg_d_ctrlb|tg_fbm_ctrl|tg_fbs_ctrlb|tg_s_ctrl|y$5
+ en|en1|g_en en|en2|g_en en|en3|g_en en|en4|g_en
+ en|nand_m_en|nand_m_en_via|nand_s2_en|nand_s2_en_via|rst_n
+ g_vddr_m1|mnt_g|s1_vddr_m1|s2_vddr_m1|s3_vddr_m1|s4_vddr_m1|vddr|vddr1
+ g_vddr_m1|mnt_g|s1_vddr_m1|s2_vddr_m1|s3_vddr_m1|s4_vddr_m1|vddr|vddr2
+ g_vddr_m1|mnt_g|s1_vddr_m1|s2_vddr_m1|s3_vddr_m1|s4_vddr_m1|vddr|vddr3
+ g_vddr_m1|mnt_g|s1_vddr_m1|s2_vddr_m1|s3_vddr_m1|s4_vddr_m1|vddr|vddr4
+ g_vss_m1|inv_clk_vss|inv_mc_vss|inv_q_vss|mph_g|nand_m_vss|nand_s2_vss|s1_vss_m1|s2_vss_m1|s3_vss_m1|s4_vss_m1|sb_vss|sr1_vss|sr2_vss|sr3_vss|sr4_vss|sv_vss|tg_d_vss|tg_fbm_vss|tg_fbs_vss|tg_s_vss|vss|vss_link|vss_link_bridge|vss_link_dip|vss_link_m1|vss_x1|vss_x2|vss_x3
+ mid mid$1 mid$2 mpa_py|mpb_py|mph_py|py mpa_py|mpb_py|mph_py|py$1
+ mpa_py|mpb_py|mph_py|py$2 mpa_py|mpb_py|mph_py|py$3 ny ny$1 ny$2 ny$3 ny$4
+ ny$5 ny$6 ny$7 ny$8 ny$9 ny$10 ny$11 ny$12 ny$13 ny$14 ny$15 ny$16 ny$17
+ ny$18 ny$19 py py$1 py$2 py$3 py$4 py$5 py$6 py$7 py$8 py$9 py$10 py$11 py$12
+ py$13 py$14 py$15
* device instance $1 r0 *1 12.315,0.21 nfet
X$1 \$17__t1
+ en\x7cnand_m_en\x7cnand_m_en_via\x7cnand_s2_en\x7cnand_s2_en_via\x7crst_n__t0
+ g_vss_m1\x7cinv_clk_vss\x7cinv_mc_vss\x7cinv_q_vss\x7cmph_g\x7cnand_m_vss\x7cnand_s2_vss\x7cs1_vss_m1\x7cs2_vss_m1\x7cs3_vss_m1\x7cs4_vss_m1\x7csb_vss\x7csr1_vss\x7csr2_vss\x7csr3_vss\x7csr4_vss\x7csv_vss\x7ctg_d_vss\x7ctg_fbm_vss\x7ctg_fbs_vss\x7ctg_s_vss\x7cvss\x7cvss_link\x7cvss_link_bridge\x7cvss_link_dip\x7cvss_link_m1\x7cvss_x1\x7cvss_x2\x7cvss_x3__t0
+ g_vss_m1\x7cinv_clk_vss\x7cinv_mc_vss\x7cinv_q_vss\x7cmph_g\x7cnand_m_vss\x7cnand_s2_vss\x7cs1_vss_m1\x7cs2_vss_m1\x7cs3_vss_m1\x7cs4_vss_m1\x7csb_vss\x7csr1_vss\x7csr2_vss\x7csr3_vss\x7csr4_vss\x7csv_vss\x7ctg_d_vss\x7ctg_fbm_vss\x7ctg_fbs_vss\x7ctg_s_vss\x7cvss\x7cvss_link\x7cvss_link_bridge\x7cvss_link_dip\x7cvss_link_m1\x7cvss_x1\x7cvss_x2\x7cvss_x3__t86
+ sky130_fd_pr__nfet_01v8 L=0.15 W=0.84 AS=0.3948 AD=0.2184 PS=2.62 PD=1.36
* device instance $2 r0 *1 12.985,0.21 nfet
X$2
+ a\x7cinv_mc_a\x7cmb\x7cmnab_y\x7cmpa_y\x7cmpb_y\x7cnand_m_y\x7ctg_s_a\x7cy__t0
+ a\x7cb\x7cm_east\x7cm_west\x7cnand_m_a\x7cnand_m_a_ext_via\x7cnand_m_a_ext_via2\x7cnand_m_a_stub\x7ctg_d_b\x7ctg_d_b_via\x7ctg_d_b_via2\x7ctg_fbm_b\x7ctg_fbm_b_alt_via\x7ctg_fbm_b_alt_via2__t0
+ \$17__t0
+ g_vss_m1\x7cinv_clk_vss\x7cinv_mc_vss\x7cinv_q_vss\x7cmph_g\x7cnand_m_vss\x7cnand_s2_vss\x7cs1_vss_m1\x7cs2_vss_m1\x7cs3_vss_m1\x7cs4_vss_m1\x7csb_vss\x7csr1_vss\x7csr2_vss\x7csr3_vss\x7csr4_vss\x7csv_vss\x7ctg_d_vss\x7ctg_fbm_vss\x7ctg_fbs_vss\x7ctg_s_vss\x7cvss\x7cvss_link\x7cvss_link_bridge\x7cvss_link_dip\x7cvss_link_m1\x7cvss_x1\x7cvss_x2\x7cvss_x3__t108
+ sky130_fd_pr__nfet_01v8 L=0.15 W=0.84 AS=0.2184 AD=0.3948 PS=1.36 PD=2.62
* device instance $3 r0 *1 43.175,0.21 nfet
X$3 \$18__t0
+ en\x7cnand_m_en\x7cnand_m_en_via\x7cnand_s2_en\x7cnand_s2_en_via\x7crst_n__t22
+ g_vss_m1\x7cinv_clk_vss\x7cinv_mc_vss\x7cinv_q_vss\x7cmph_g\x7cnand_m_vss\x7cnand_s2_vss\x7cs1_vss_m1\x7cs2_vss_m1\x7cs3_vss_m1\x7cs4_vss_m1\x7csb_vss\x7csr1_vss\x7csr2_vss\x7csr3_vss\x7csr4_vss\x7csv_vss\x7ctg_d_vss\x7ctg_fbm_vss\x7ctg_fbs_vss\x7ctg_s_vss\x7cvss\x7cvss_link\x7cvss_link_bridge\x7cvss_link_dip\x7cvss_link_m1\x7cvss_x1\x7cvss_x2\x7cvss_x3__t84
+ g_vss_m1\x7cinv_clk_vss\x7cinv_mc_vss\x7cinv_q_vss\x7cmph_g\x7cnand_m_vss\x7cnand_s2_vss\x7cs1_vss_m1\x7cs2_vss_m1\x7cs3_vss_m1\x7cs4_vss_m1\x7csb_vss\x7csr1_vss\x7csr2_vss\x7csr3_vss\x7csr4_vss\x7csv_vss\x7ctg_d_vss\x7ctg_fbm_vss\x7ctg_fbs_vss\x7ctg_s_vss\x7cvss\x7cvss_link\x7cvss_link_bridge\x7cvss_link_dip\x7cvss_link_m1\x7cvss_x1\x7cvss_x2\x7cvss_x3__t87
+ sky130_fd_pr__nfet_01v8 L=0.15 W=0.84 AS=0.3948 AD=0.2184 PS=2.62 PD=1.36
* device instance $4 r0 *1 43.845,0.21 nfet
X$4 a\x7cmnab_y\x7cmpa_y\x7cmpb_y\x7cnand_s2_y\x7cqb\x7ctg_fbs_a\x7cy__t4
+ a\x7cinv_q_y\x7cinv_q_y_via\x7cinv_q_y_via2\x7cnand_s2_a\x7cnand_s2_a_stub\x7cnand_s2_a_via\x7cnand_s2_a_via2\x7cq\x7cy__t3
+ \$18__t1
+ g_vss_m1\x7cinv_clk_vss\x7cinv_mc_vss\x7cinv_q_vss\x7cmph_g\x7cnand_m_vss\x7cnand_s2_vss\x7cs1_vss_m1\x7cs2_vss_m1\x7cs3_vss_m1\x7cs4_vss_m1\x7csb_vss\x7csr1_vss\x7csr2_vss\x7csr3_vss\x7csr4_vss\x7csv_vss\x7ctg_d_vss\x7ctg_fbm_vss\x7ctg_fbs_vss\x7ctg_s_vss\x7cvss\x7cvss_link\x7cvss_link_bridge\x7cvss_link_dip\x7cvss_link_m1\x7cvss_x1\x7cvss_x2\x7cvss_x3__t109
+ sky130_fd_pr__nfet_01v8 L=0.15 W=0.84 AS=0.2184 AD=0.3948 PS=1.36 PD=2.62
* device instance $5 r0 *1 67.975,0.21 nfet
X$5 \$20__t0
+ en\x7cnand_m_en\x7cnand_m_en_via\x7cnand_s2_en\x7cnand_s2_en_via\x7crst_n__t23
+ g_vss_m1\x7cinv_clk_vss\x7cinv_mc_vss\x7cinv_q_vss\x7cmph_g\x7cnand_m_vss\x7cnand_s2_vss\x7cs1_vss_m1\x7cs2_vss_m1\x7cs3_vss_m1\x7cs4_vss_m1\x7csb_vss\x7csr1_vss\x7csr2_vss\x7csr3_vss\x7csr4_vss\x7csv_vss\x7ctg_d_vss\x7ctg_fbm_vss\x7ctg_fbs_vss\x7ctg_s_vss\x7cvss\x7cvss_link\x7cvss_link_bridge\x7cvss_link_dip\x7cvss_link_m1\x7cvss_x1\x7cvss_x2\x7cvss_x3__t85
+ g_vss_m1\x7cinv_clk_vss\x7cinv_mc_vss\x7cinv_q_vss\x7cmph_g\x7cnand_m_vss\x7cnand_s2_vss\x7cs1_vss_m1\x7cs2_vss_m1\x7cs3_vss_m1\x7cs4_vss_m1\x7csb_vss\x7csr1_vss\x7csr2_vss\x7csr3_vss\x7csr4_vss\x7csv_vss\x7ctg_d_vss\x7ctg_fbm_vss\x7ctg_fbs_vss\x7ctg_s_vss\x7cvss\x7cvss_link\x7cvss_link_bridge\x7cvss_link_dip\x7cvss_link_m1\x7cvss_x1\x7cvss_x2\x7cvss_x3__t88
+ sky130_fd_pr__nfet_01v8 L=0.15 W=0.84 AS=0.3948 AD=0.2184 PS=2.62 PD=1.36
* device instance $6 r0 *1 68.645,0.21 nfet
X$6
+ a\x7cinv_mc_a\x7cmb\x7cmnab_y\x7cmpa_y\x7cmpb_y\x7cnand_m_y\x7ctg_s_a\x7cy__t62
+ a\x7cb\x7cm_east\x7cm_west\x7cnand_m_a\x7cnand_m_a_ext_via\x7cnand_m_a_ext_via2\x7cnand_m_a_stub\x7ctg_d_b\x7ctg_d_b_via\x7ctg_d_b_via2\x7ctg_fbm_b\x7ctg_fbm_b_alt_via\x7ctg_fbm_b_alt_via2__t52
+ \$20__t1
+ g_vss_m1\x7cinv_clk_vss\x7cinv_mc_vss\x7cinv_q_vss\x7cmph_g\x7cnand_m_vss\x7cnand_s2_vss\x7cs1_vss_m1\x7cs2_vss_m1\x7cs3_vss_m1\x7cs4_vss_m1\x7csb_vss\x7csr1_vss\x7csr2_vss\x7csr3_vss\x7csr4_vss\x7csv_vss\x7ctg_d_vss\x7ctg_fbm_vss\x7ctg_fbs_vss\x7ctg_s_vss\x7cvss\x7cvss_link\x7cvss_link_bridge\x7cvss_link_dip\x7cvss_link_m1\x7cvss_x1\x7cvss_x2\x7cvss_x3__t110
+ sky130_fd_pr__nfet_01v8 L=0.15 W=0.84 AS=0.2184 AD=0.3948 PS=1.36 PD=2.62
* device instance $7 r0 *1 98.835,0.21 nfet
X$7 \$21__t0
+ en\x7cnand_m_en\x7cnand_m_en_via\x7cnand_s2_en\x7cnand_s2_en_via\x7crst_n__t21
+ g_vss_m1\x7cinv_clk_vss\x7cinv_mc_vss\x7cinv_q_vss\x7cmph_g\x7cnand_m_vss\x7cnand_s2_vss\x7cs1_vss_m1\x7cs2_vss_m1\x7cs3_vss_m1\x7cs4_vss_m1\x7csb_vss\x7csr1_vss\x7csr2_vss\x7csr3_vss\x7csr4_vss\x7csv_vss\x7ctg_d_vss\x7ctg_fbm_vss\x7ctg_fbs_vss\x7ctg_s_vss\x7cvss\x7cvss_link\x7cvss_link_bridge\x7cvss_link_dip\x7cvss_link_m1\x7cvss_x1\x7cvss_x2\x7cvss_x3__t83
+ g_vss_m1\x7cinv_clk_vss\x7cinv_mc_vss\x7cinv_q_vss\x7cmph_g\x7cnand_m_vss\x7cnand_s2_vss\x7cs1_vss_m1\x7cs2_vss_m1\x7cs3_vss_m1\x7cs4_vss_m1\x7csb_vss\x7csr1_vss\x7csr2_vss\x7csr3_vss\x7csr4_vss\x7csv_vss\x7ctg_d_vss\x7ctg_fbm_vss\x7ctg_fbs_vss\x7ctg_s_vss\x7cvss\x7cvss_link\x7cvss_link_bridge\x7cvss_link_dip\x7cvss_link_m1\x7cvss_x1\x7cvss_x2\x7cvss_x3__t89
+ sky130_fd_pr__nfet_01v8 L=0.15 W=0.84 AS=0.3948 AD=0.2184 PS=2.62 PD=1.36
* device instance $8 r0 *1 99.505,0.21 nfet
X$8 a\x7cmnab_y\x7cmpa_y\x7cmpb_y\x7cnand_s2_y\x7cqb\x7ctg_fbs_a\x7cy__t42
+ a\x7cinv_q_y\x7cinv_q_y_via\x7cinv_q_y_via2\x7cnand_s2_a\x7cnand_s2_a_stub\x7cnand_s2_a_via\x7cnand_s2_a_via2\x7cq\x7cy__t32
+ \$21__t1
+ g_vss_m1\x7cinv_clk_vss\x7cinv_mc_vss\x7cinv_q_vss\x7cmph_g\x7cnand_m_vss\x7cnand_s2_vss\x7cs1_vss_m1\x7cs2_vss_m1\x7cs3_vss_m1\x7cs4_vss_m1\x7csb_vss\x7csr1_vss\x7csr2_vss\x7csr3_vss\x7csr4_vss\x7csv_vss\x7ctg_d_vss\x7ctg_fbm_vss\x7ctg_fbs_vss\x7ctg_s_vss\x7cvss\x7cvss_link\x7cvss_link_bridge\x7cvss_link_dip\x7cvss_link_m1\x7cvss_x1\x7cvss_x2\x7cvss_x3__t111
+ sky130_fd_pr__nfet_01v8 L=0.15 W=0.84 AS=0.2184 AD=0.3948 PS=1.36 PD=2.62
* device instance $9 r0 *1 123.635,0.21 nfet
X$9 \$24__t0
+ en\x7cnand_m_en\x7cnand_m_en_via\x7cnand_s2_en\x7cnand_s2_en_via\x7crst_n__t20
+ g_vss_m1\x7cinv_clk_vss\x7cinv_mc_vss\x7cinv_q_vss\x7cmph_g\x7cnand_m_vss\x7cnand_s2_vss\x7cs1_vss_m1\x7cs2_vss_m1\x7cs3_vss_m1\x7cs4_vss_m1\x7csb_vss\x7csr1_vss\x7csr2_vss\x7csr3_vss\x7csr4_vss\x7csv_vss\x7ctg_d_vss\x7ctg_fbm_vss\x7ctg_fbs_vss\x7ctg_s_vss\x7cvss\x7cvss_link\x7cvss_link_bridge\x7cvss_link_dip\x7cvss_link_m1\x7cvss_x1\x7cvss_x2\x7cvss_x3__t82
+ g_vss_m1\x7cinv_clk_vss\x7cinv_mc_vss\x7cinv_q_vss\x7cmph_g\x7cnand_m_vss\x7cnand_s2_vss\x7cs1_vss_m1\x7cs2_vss_m1\x7cs3_vss_m1\x7cs4_vss_m1\x7csb_vss\x7csr1_vss\x7csr2_vss\x7csr3_vss\x7csr4_vss\x7csv_vss\x7ctg_d_vss\x7ctg_fbm_vss\x7ctg_fbs_vss\x7ctg_s_vss\x7cvss\x7cvss_link\x7cvss_link_bridge\x7cvss_link_dip\x7cvss_link_m1\x7cvss_x1\x7cvss_x2\x7cvss_x3__t90
+ sky130_fd_pr__nfet_01v8 L=0.15 W=0.84 AS=0.3948 AD=0.2184 PS=2.62 PD=1.36
* device instance $10 r0 *1 124.305,0.21 nfet
X$10
+ a\x7cinv_mc_a\x7cmb\x7cmnab_y\x7cmpa_y\x7cmpb_y\x7cnand_m_y\x7ctg_s_a\x7cy__t63
+ a\x7cb\x7cm_east\x7cm_west\x7cnand_m_a\x7cnand_m_a_ext_via\x7cnand_m_a_ext_via2\x7cnand_m_a_stub\x7ctg_d_b\x7ctg_d_b_via\x7ctg_d_b_via2\x7ctg_fbm_b\x7ctg_fbm_b_alt_via\x7ctg_fbm_b_alt_via2__t53
+ \$24__t1
+ g_vss_m1\x7cinv_clk_vss\x7cinv_mc_vss\x7cinv_q_vss\x7cmph_g\x7cnand_m_vss\x7cnand_s2_vss\x7cs1_vss_m1\x7cs2_vss_m1\x7cs3_vss_m1\x7cs4_vss_m1\x7csb_vss\x7csr1_vss\x7csr2_vss\x7csr3_vss\x7csr4_vss\x7csv_vss\x7ctg_d_vss\x7ctg_fbm_vss\x7ctg_fbs_vss\x7ctg_s_vss\x7cvss\x7cvss_link\x7cvss_link_bridge\x7cvss_link_dip\x7cvss_link_m1\x7cvss_x1\x7cvss_x2\x7cvss_x3__t112
+ sky130_fd_pr__nfet_01v8 L=0.15 W=0.84 AS=0.2184 AD=0.3948 PS=1.36 PD=2.62
* device instance $11 r0 *1 154.495,0.21 nfet
X$11 \$25__t0
+ en\x7cnand_m_en\x7cnand_m_en_via\x7cnand_s2_en\x7cnand_s2_en_via\x7crst_n__t19
+ g_vss_m1\x7cinv_clk_vss\x7cinv_mc_vss\x7cinv_q_vss\x7cmph_g\x7cnand_m_vss\x7cnand_s2_vss\x7cs1_vss_m1\x7cs2_vss_m1\x7cs3_vss_m1\x7cs4_vss_m1\x7csb_vss\x7csr1_vss\x7csr2_vss\x7csr3_vss\x7csr4_vss\x7csv_vss\x7ctg_d_vss\x7ctg_fbm_vss\x7ctg_fbs_vss\x7ctg_s_vss\x7cvss\x7cvss_link\x7cvss_link_bridge\x7cvss_link_dip\x7cvss_link_m1\x7cvss_x1\x7cvss_x2\x7cvss_x3__t81
+ g_vss_m1\x7cinv_clk_vss\x7cinv_mc_vss\x7cinv_q_vss\x7cmph_g\x7cnand_m_vss\x7cnand_s2_vss\x7cs1_vss_m1\x7cs2_vss_m1\x7cs3_vss_m1\x7cs4_vss_m1\x7csb_vss\x7csr1_vss\x7csr2_vss\x7csr3_vss\x7csr4_vss\x7csv_vss\x7ctg_d_vss\x7ctg_fbm_vss\x7ctg_fbs_vss\x7ctg_s_vss\x7cvss\x7cvss_link\x7cvss_link_bridge\x7cvss_link_dip\x7cvss_link_m1\x7cvss_x1\x7cvss_x2\x7cvss_x3__t91
+ sky130_fd_pr__nfet_01v8 L=0.15 W=0.84 AS=0.3948 AD=0.2184 PS=2.62 PD=1.36
* device instance $12 r0 *1 155.165,0.21 nfet
X$12 a\x7cmnab_y\x7cmpa_y\x7cmpb_y\x7cnand_s2_y\x7cqb\x7ctg_fbs_a\x7cy__t43
+ a\x7cinv_q_y\x7cinv_q_y_via\x7cinv_q_y_via2\x7cnand_s2_a\x7cnand_s2_a_stub\x7cnand_s2_a_via\x7cnand_s2_a_via2\x7cq\x7cy__t33
+ \$25__t1
+ g_vss_m1\x7cinv_clk_vss\x7cinv_mc_vss\x7cinv_q_vss\x7cmph_g\x7cnand_m_vss\x7cnand_s2_vss\x7cs1_vss_m1\x7cs2_vss_m1\x7cs3_vss_m1\x7cs4_vss_m1\x7csb_vss\x7csr1_vss\x7csr2_vss\x7csr3_vss\x7csr4_vss\x7csv_vss\x7ctg_d_vss\x7ctg_fbm_vss\x7ctg_fbs_vss\x7ctg_s_vss\x7cvss\x7cvss_link\x7cvss_link_bridge\x7cvss_link_dip\x7cvss_link_m1\x7cvss_x1\x7cvss_x2\x7cvss_x3__t113
+ sky130_fd_pr__nfet_01v8 L=0.15 W=0.84 AS=0.2184 AD=0.3948 PS=1.36 PD=2.62
* device instance $13 r0 *1 179.295,0.21 nfet
X$13 \$28__t0
+ en\x7cnand_m_en\x7cnand_m_en_via\x7cnand_s2_en\x7cnand_s2_en_via\x7crst_n__t15
+ g_vss_m1\x7cinv_clk_vss\x7cinv_mc_vss\x7cinv_q_vss\x7cmph_g\x7cnand_m_vss\x7cnand_s2_vss\x7cs1_vss_m1\x7cs2_vss_m1\x7cs3_vss_m1\x7cs4_vss_m1\x7csb_vss\x7csr1_vss\x7csr2_vss\x7csr3_vss\x7csr4_vss\x7csv_vss\x7ctg_d_vss\x7ctg_fbm_vss\x7ctg_fbs_vss\x7ctg_s_vss\x7cvss\x7cvss_link\x7cvss_link_bridge\x7cvss_link_dip\x7cvss_link_m1\x7cvss_x1\x7cvss_x2\x7cvss_x3__t77
+ g_vss_m1\x7cinv_clk_vss\x7cinv_mc_vss\x7cinv_q_vss\x7cmph_g\x7cnand_m_vss\x7cnand_s2_vss\x7cs1_vss_m1\x7cs2_vss_m1\x7cs3_vss_m1\x7cs4_vss_m1\x7csb_vss\x7csr1_vss\x7csr2_vss\x7csr3_vss\x7csr4_vss\x7csv_vss\x7ctg_d_vss\x7ctg_fbm_vss\x7ctg_fbs_vss\x7ctg_s_vss\x7cvss\x7cvss_link\x7cvss_link_bridge\x7cvss_link_dip\x7cvss_link_m1\x7cvss_x1\x7cvss_x2\x7cvss_x3__t92
+ sky130_fd_pr__nfet_01v8 L=0.15 W=0.84 AS=0.3948 AD=0.2184 PS=2.62 PD=1.36
* device instance $14 r0 *1 179.965,0.21 nfet
X$14
+ a\x7cinv_mc_a\x7cmb\x7cmnab_y\x7cmpa_y\x7cmpb_y\x7cnand_m_y\x7ctg_s_a\x7cy__t64
+ a\x7cb\x7cm_east\x7cm_west\x7cnand_m_a\x7cnand_m_a_ext_via\x7cnand_m_a_ext_via2\x7cnand_m_a_stub\x7ctg_d_b\x7ctg_d_b_via\x7ctg_d_b_via2\x7ctg_fbm_b\x7ctg_fbm_b_alt_via\x7ctg_fbm_b_alt_via2__t54
+ \$28__t1
+ g_vss_m1\x7cinv_clk_vss\x7cinv_mc_vss\x7cinv_q_vss\x7cmph_g\x7cnand_m_vss\x7cnand_s2_vss\x7cs1_vss_m1\x7cs2_vss_m1\x7cs3_vss_m1\x7cs4_vss_m1\x7csb_vss\x7csr1_vss\x7csr2_vss\x7csr3_vss\x7csr4_vss\x7csv_vss\x7ctg_d_vss\x7ctg_fbm_vss\x7ctg_fbs_vss\x7ctg_s_vss\x7cvss\x7cvss_link\x7cvss_link_bridge\x7cvss_link_dip\x7cvss_link_m1\x7cvss_x1\x7cvss_x2\x7cvss_x3__t114
+ sky130_fd_pr__nfet_01v8 L=0.15 W=0.84 AS=0.2184 AD=0.3948 PS=1.36 PD=2.62
* device instance $15 r0 *1 210.155,0.21 nfet
X$15 \$29__t0
+ en\x7cnand_m_en\x7cnand_m_en_via\x7cnand_s2_en\x7cnand_s2_en_via\x7crst_n__t17
+ g_vss_m1\x7cinv_clk_vss\x7cinv_mc_vss\x7cinv_q_vss\x7cmph_g\x7cnand_m_vss\x7cnand_s2_vss\x7cs1_vss_m1\x7cs2_vss_m1\x7cs3_vss_m1\x7cs4_vss_m1\x7csb_vss\x7csr1_vss\x7csr2_vss\x7csr3_vss\x7csr4_vss\x7csv_vss\x7ctg_d_vss\x7ctg_fbm_vss\x7ctg_fbs_vss\x7ctg_s_vss\x7cvss\x7cvss_link\x7cvss_link_bridge\x7cvss_link_dip\x7cvss_link_m1\x7cvss_x1\x7cvss_x2\x7cvss_x3__t79
+ g_vss_m1\x7cinv_clk_vss\x7cinv_mc_vss\x7cinv_q_vss\x7cmph_g\x7cnand_m_vss\x7cnand_s2_vss\x7cs1_vss_m1\x7cs2_vss_m1\x7cs3_vss_m1\x7cs4_vss_m1\x7csb_vss\x7csr1_vss\x7csr2_vss\x7csr3_vss\x7csr4_vss\x7csv_vss\x7ctg_d_vss\x7ctg_fbm_vss\x7ctg_fbs_vss\x7ctg_s_vss\x7cvss\x7cvss_link\x7cvss_link_bridge\x7cvss_link_dip\x7cvss_link_m1\x7cvss_x1\x7cvss_x2\x7cvss_x3__t93
+ sky130_fd_pr__nfet_01v8 L=0.15 W=0.84 AS=0.3948 AD=0.2184 PS=2.62 PD=1.36
* device instance $16 r0 *1 210.825,0.21 nfet
X$16 a\x7cmnab_y\x7cmpa_y\x7cmpb_y\x7cnand_s2_y\x7cqb\x7ctg_fbs_a\x7cy__t44
+ a\x7cinv_q_y\x7cinv_q_y_via\x7cinv_q_y_via2\x7cnand_s2_a\x7cnand_s2_a_stub\x7cnand_s2_a_via\x7cnand_s2_a_via2\x7cq\x7cy__t34
+ \$29__t1
+ g_vss_m1\x7cinv_clk_vss\x7cinv_mc_vss\x7cinv_q_vss\x7cmph_g\x7cnand_m_vss\x7cnand_s2_vss\x7cs1_vss_m1\x7cs2_vss_m1\x7cs3_vss_m1\x7cs4_vss_m1\x7csb_vss\x7csr1_vss\x7csr2_vss\x7csr3_vss\x7csr4_vss\x7csv_vss\x7ctg_d_vss\x7ctg_fbm_vss\x7ctg_fbs_vss\x7ctg_s_vss\x7cvss\x7cvss_link\x7cvss_link_bridge\x7cvss_link_dip\x7cvss_link_m1\x7cvss_x1\x7cvss_x2\x7cvss_x3__t115
+ sky130_fd_pr__nfet_01v8 L=0.15 W=0.84 AS=0.2184 AD=0.3948 PS=1.36 PD=2.62
* device instance $17 r0 *1 234.955,0.21 nfet
X$17 \$32__t0
+ en\x7cnand_m_en\x7cnand_m_en_via\x7cnand_s2_en\x7cnand_s2_en_via\x7crst_n__t16
+ g_vss_m1\x7cinv_clk_vss\x7cinv_mc_vss\x7cinv_q_vss\x7cmph_g\x7cnand_m_vss\x7cnand_s2_vss\x7cs1_vss_m1\x7cs2_vss_m1\x7cs3_vss_m1\x7cs4_vss_m1\x7csb_vss\x7csr1_vss\x7csr2_vss\x7csr3_vss\x7csr4_vss\x7csv_vss\x7ctg_d_vss\x7ctg_fbm_vss\x7ctg_fbs_vss\x7ctg_s_vss\x7cvss\x7cvss_link\x7cvss_link_bridge\x7cvss_link_dip\x7cvss_link_m1\x7cvss_x1\x7cvss_x2\x7cvss_x3__t78
+ g_vss_m1\x7cinv_clk_vss\x7cinv_mc_vss\x7cinv_q_vss\x7cmph_g\x7cnand_m_vss\x7cnand_s2_vss\x7cs1_vss_m1\x7cs2_vss_m1\x7cs3_vss_m1\x7cs4_vss_m1\x7csb_vss\x7csr1_vss\x7csr2_vss\x7csr3_vss\x7csr4_vss\x7csv_vss\x7ctg_d_vss\x7ctg_fbm_vss\x7ctg_fbs_vss\x7ctg_s_vss\x7cvss\x7cvss_link\x7cvss_link_bridge\x7cvss_link_dip\x7cvss_link_m1\x7cvss_x1\x7cvss_x2\x7cvss_x3__t94
+ sky130_fd_pr__nfet_01v8 L=0.15 W=0.84 AS=0.3948 AD=0.2184 PS=2.62 PD=1.36
* device instance $18 r0 *1 235.625,0.21 nfet
X$18
+ a\x7cinv_mc_a\x7cmb\x7cmnab_y\x7cmpa_y\x7cmpb_y\x7cnand_m_y\x7ctg_s_a\x7cy__t65
+ a\x7cb\x7cm_east\x7cm_west\x7cnand_m_a\x7cnand_m_a_ext_via\x7cnand_m_a_ext_via2\x7cnand_m_a_stub\x7ctg_d_b\x7ctg_d_b_via\x7ctg_d_b_via2\x7ctg_fbm_b\x7ctg_fbm_b_alt_via\x7ctg_fbm_b_alt_via2__t55
+ \$32__t1
+ g_vss_m1\x7cinv_clk_vss\x7cinv_mc_vss\x7cinv_q_vss\x7cmph_g\x7cnand_m_vss\x7cnand_s2_vss\x7cs1_vss_m1\x7cs2_vss_m1\x7cs3_vss_m1\x7cs4_vss_m1\x7csb_vss\x7csr1_vss\x7csr2_vss\x7csr3_vss\x7csr4_vss\x7csv_vss\x7ctg_d_vss\x7ctg_fbm_vss\x7ctg_fbs_vss\x7ctg_s_vss\x7cvss\x7cvss_link\x7cvss_link_bridge\x7cvss_link_dip\x7cvss_link_m1\x7cvss_x1\x7cvss_x2\x7cvss_x3__t116
+ sky130_fd_pr__nfet_01v8 L=0.15 W=0.84 AS=0.2184 AD=0.3948 PS=1.36 PD=2.62
* device instance $19 r0 *1 265.815,0.21 nfet
X$19 \$33__t0
+ en\x7cnand_m_en\x7cnand_m_en_via\x7cnand_s2_en\x7cnand_s2_en_via\x7crst_n__t18
+ g_vss_m1\x7cinv_clk_vss\x7cinv_mc_vss\x7cinv_q_vss\x7cmph_g\x7cnand_m_vss\x7cnand_s2_vss\x7cs1_vss_m1\x7cs2_vss_m1\x7cs3_vss_m1\x7cs4_vss_m1\x7csb_vss\x7csr1_vss\x7csr2_vss\x7csr3_vss\x7csr4_vss\x7csv_vss\x7ctg_d_vss\x7ctg_fbm_vss\x7ctg_fbs_vss\x7ctg_s_vss\x7cvss\x7cvss_link\x7cvss_link_bridge\x7cvss_link_dip\x7cvss_link_m1\x7cvss_x1\x7cvss_x2\x7cvss_x3__t80
+ g_vss_m1\x7cinv_clk_vss\x7cinv_mc_vss\x7cinv_q_vss\x7cmph_g\x7cnand_m_vss\x7cnand_s2_vss\x7cs1_vss_m1\x7cs2_vss_m1\x7cs3_vss_m1\x7cs4_vss_m1\x7csb_vss\x7csr1_vss\x7csr2_vss\x7csr3_vss\x7csr4_vss\x7csv_vss\x7ctg_d_vss\x7ctg_fbm_vss\x7ctg_fbs_vss\x7ctg_s_vss\x7cvss\x7cvss_link\x7cvss_link_bridge\x7cvss_link_dip\x7cvss_link_m1\x7cvss_x1\x7cvss_x2\x7cvss_x3__t95
+ sky130_fd_pr__nfet_01v8 L=0.15 W=0.84 AS=0.3948 AD=0.2184 PS=2.62 PD=1.36
* device instance $20 r0 *1 266.485,0.21 nfet
X$20 a\x7cmnab_y\x7cmpa_y\x7cmpb_y\x7cnand_s2_y\x7cqb\x7ctg_fbs_a\x7cy__t45
+ a\x7cinv_q_y\x7cinv_q_y_via\x7cinv_q_y_via2\x7cnand_s2_a\x7cnand_s2_a_stub\x7cnand_s2_a_via\x7cnand_s2_a_via2\x7cq\x7cy__t35
+ \$33__t1
+ g_vss_m1\x7cinv_clk_vss\x7cinv_mc_vss\x7cinv_q_vss\x7cmph_g\x7cnand_m_vss\x7cnand_s2_vss\x7cs1_vss_m1\x7cs2_vss_m1\x7cs3_vss_m1\x7cs4_vss_m1\x7csb_vss\x7csr1_vss\x7csr2_vss\x7csr3_vss\x7csr4_vss\x7csv_vss\x7ctg_d_vss\x7ctg_fbm_vss\x7ctg_fbs_vss\x7ctg_s_vss\x7cvss\x7cvss_link\x7cvss_link_bridge\x7cvss_link_dip\x7cvss_link_m1\x7cvss_x1\x7cvss_x2\x7cvss_x3__t117
+ sky130_fd_pr__nfet_01v8 L=0.15 W=0.84 AS=0.2184 AD=0.3948 PS=1.36 PD=2.62
* device instance $21 r0 *1 290.615,0.21 nfet
X$21 \$36__t0
+ en\x7cnand_m_en\x7cnand_m_en_via\x7cnand_s2_en\x7cnand_s2_en_via\x7crst_n__t14
+ g_vss_m1\x7cinv_clk_vss\x7cinv_mc_vss\x7cinv_q_vss\x7cmph_g\x7cnand_m_vss\x7cnand_s2_vss\x7cs1_vss_m1\x7cs2_vss_m1\x7cs3_vss_m1\x7cs4_vss_m1\x7csb_vss\x7csr1_vss\x7csr2_vss\x7csr3_vss\x7csr4_vss\x7csv_vss\x7ctg_d_vss\x7ctg_fbm_vss\x7ctg_fbs_vss\x7ctg_s_vss\x7cvss\x7cvss_link\x7cvss_link_bridge\x7cvss_link_dip\x7cvss_link_m1\x7cvss_x1\x7cvss_x2\x7cvss_x3__t76
+ g_vss_m1\x7cinv_clk_vss\x7cinv_mc_vss\x7cinv_q_vss\x7cmph_g\x7cnand_m_vss\x7cnand_s2_vss\x7cs1_vss_m1\x7cs2_vss_m1\x7cs3_vss_m1\x7cs4_vss_m1\x7csb_vss\x7csr1_vss\x7csr2_vss\x7csr3_vss\x7csr4_vss\x7csv_vss\x7ctg_d_vss\x7ctg_fbm_vss\x7ctg_fbs_vss\x7ctg_s_vss\x7cvss\x7cvss_link\x7cvss_link_bridge\x7cvss_link_dip\x7cvss_link_m1\x7cvss_x1\x7cvss_x2\x7cvss_x3__t96
+ sky130_fd_pr__nfet_01v8 L=0.15 W=0.84 AS=0.3948 AD=0.2184 PS=2.62 PD=1.36
* device instance $22 r0 *1 291.285,0.21 nfet
X$22
+ a\x7cinv_mc_a\x7cmb\x7cmnab_y\x7cmpa_y\x7cmpb_y\x7cnand_m_y\x7ctg_s_a\x7cy__t66
+ a\x7cb\x7cm_east\x7cm_west\x7cnand_m_a\x7cnand_m_a_ext_via\x7cnand_m_a_ext_via2\x7cnand_m_a_stub\x7ctg_d_b\x7ctg_d_b_via\x7ctg_d_b_via2\x7ctg_fbm_b\x7ctg_fbm_b_alt_via\x7ctg_fbm_b_alt_via2__t56
+ \$36__t1
+ g_vss_m1\x7cinv_clk_vss\x7cinv_mc_vss\x7cinv_q_vss\x7cmph_g\x7cnand_m_vss\x7cnand_s2_vss\x7cs1_vss_m1\x7cs2_vss_m1\x7cs3_vss_m1\x7cs4_vss_m1\x7csb_vss\x7csr1_vss\x7csr2_vss\x7csr3_vss\x7csr4_vss\x7csv_vss\x7ctg_d_vss\x7ctg_fbm_vss\x7ctg_fbs_vss\x7ctg_s_vss\x7cvss\x7cvss_link\x7cvss_link_bridge\x7cvss_link_dip\x7cvss_link_m1\x7cvss_x1\x7cvss_x2\x7cvss_x3__t118
+ sky130_fd_pr__nfet_01v8 L=0.15 W=0.84 AS=0.2184 AD=0.3948 PS=1.36 PD=2.62
* device instance $23 r0 *1 321.475,0.21 nfet
X$23 \$37__t0
+ en\x7cnand_m_en\x7cnand_m_en_via\x7cnand_s2_en\x7cnand_s2_en_via\x7crst_n__t13
+ g_vss_m1\x7cinv_clk_vss\x7cinv_mc_vss\x7cinv_q_vss\x7cmph_g\x7cnand_m_vss\x7cnand_s2_vss\x7cs1_vss_m1\x7cs2_vss_m1\x7cs3_vss_m1\x7cs4_vss_m1\x7csb_vss\x7csr1_vss\x7csr2_vss\x7csr3_vss\x7csr4_vss\x7csv_vss\x7ctg_d_vss\x7ctg_fbm_vss\x7ctg_fbs_vss\x7ctg_s_vss\x7cvss\x7cvss_link\x7cvss_link_bridge\x7cvss_link_dip\x7cvss_link_m1\x7cvss_x1\x7cvss_x2\x7cvss_x3__t75
+ g_vss_m1\x7cinv_clk_vss\x7cinv_mc_vss\x7cinv_q_vss\x7cmph_g\x7cnand_m_vss\x7cnand_s2_vss\x7cs1_vss_m1\x7cs2_vss_m1\x7cs3_vss_m1\x7cs4_vss_m1\x7csb_vss\x7csr1_vss\x7csr2_vss\x7csr3_vss\x7csr4_vss\x7csv_vss\x7ctg_d_vss\x7ctg_fbm_vss\x7ctg_fbs_vss\x7ctg_s_vss\x7cvss\x7cvss_link\x7cvss_link_bridge\x7cvss_link_dip\x7cvss_link_m1\x7cvss_x1\x7cvss_x2\x7cvss_x3__t97
+ sky130_fd_pr__nfet_01v8 L=0.15 W=0.84 AS=0.3948 AD=0.2184 PS=2.62 PD=1.36
* device instance $24 r0 *1 322.145,0.21 nfet
X$24 a\x7cmnab_y\x7cmpa_y\x7cmpb_y\x7cnand_s2_y\x7cqb\x7ctg_fbs_a\x7cy__t46
+ a\x7cinv_q_y\x7cinv_q_y_via\x7cinv_q_y_via2\x7cnand_s2_a\x7cnand_s2_a_stub\x7cnand_s2_a_via\x7cnand_s2_a_via2\x7cq\x7cy__t36
+ \$37__t1
+ g_vss_m1\x7cinv_clk_vss\x7cinv_mc_vss\x7cinv_q_vss\x7cmph_g\x7cnand_m_vss\x7cnand_s2_vss\x7cs1_vss_m1\x7cs2_vss_m1\x7cs3_vss_m1\x7cs4_vss_m1\x7csb_vss\x7csr1_vss\x7csr2_vss\x7csr3_vss\x7csr4_vss\x7csv_vss\x7ctg_d_vss\x7ctg_fbm_vss\x7ctg_fbs_vss\x7ctg_s_vss\x7cvss\x7cvss_link\x7cvss_link_bridge\x7cvss_link_dip\x7cvss_link_m1\x7cvss_x1\x7cvss_x2\x7cvss_x3__t119
+ sky130_fd_pr__nfet_01v8 L=0.15 W=0.84 AS=0.2184 AD=0.3948 PS=1.36 PD=2.62
* device instance $25 r0 *1 0.545,0.21 nfet
X$25
+ clkb\x7cclkb_bridge1\x7cclkb_bridge2\x7cclkb_mid\x7cclkb_w\x7cctrl\x7cctrlb\x7cinv_clk_y\x7ctg_d_ctrlb\x7ctg_fbm_ctrl\x7ctg_fbs_ctrlb\x7ctg_s_ctrl\x7cy__t1
+ a\x7cclk\x7cctrl\x7cctrlb\x7cinv_clk_a\x7cinv_clk_clk_via\x7ctg_d_ctrl\x7ctg_d_ctrl_via\x7ctg_fbm_ctrlb\x7ctg_fbm_ctrlb_via\x7ctg_fbs_ctrl\x7ctg_fbs_ctrl_via\x7ctg_s_ctrlb\x7ctg_s_ctrlb_via__t1
+ g_vss_m1\x7cinv_clk_vss\x7cinv_mc_vss\x7cinv_q_vss\x7cmph_g\x7cnand_m_vss\x7cnand_s2_vss\x7cs1_vss_m1\x7cs2_vss_m1\x7cs3_vss_m1\x7cs4_vss_m1\x7csb_vss\x7csr1_vss\x7csr2_vss\x7csr3_vss\x7csr4_vss\x7csv_vss\x7ctg_d_vss\x7ctg_fbm_vss\x7ctg_fbs_vss\x7ctg_s_vss\x7cvss\x7cvss_link\x7cvss_link_bridge\x7cvss_link_dip\x7cvss_link_m1\x7cvss_x1\x7cvss_x2\x7cvss_x3__t1
+ g_vss_m1\x7cinv_clk_vss\x7cinv_mc_vss\x7cinv_q_vss\x7cmph_g\x7cnand_m_vss\x7cnand_s2_vss\x7cs1_vss_m1\x7cs2_vss_m1\x7cs3_vss_m1\x7cs4_vss_m1\x7csb_vss\x7csr1_vss\x7csr2_vss\x7csr3_vss\x7csr4_vss\x7csv_vss\x7ctg_d_vss\x7ctg_fbm_vss\x7ctg_fbs_vss\x7ctg_s_vss\x7cvss\x7cvss_link\x7cvss_link_bridge\x7cvss_link_dip\x7cvss_link_m1\x7cvss_x1\x7cvss_x2\x7cvss_x3__t130
+ sky130_fd_pr__nfet_01v8 L=0.15 W=0.42 AS=0.1974 AD=0.1974 PS=1.78 PD=1.78
* device instance $26 r0 *1 5.31,0.21 nfet
X$26
+ a\x7cd\x7csb_d_stub\x7ctg_d_a\x7cxo\x7cxo_dip\x7cxo_hop\x7cxo_stub\x7cy__t2
+ clkb\x7cclkb_bridge1\x7cclkb_bridge2\x7cclkb_mid\x7cclkb_w\x7cctrl\x7cctrlb\x7cinv_clk_y\x7ctg_d_ctrlb\x7ctg_fbm_ctrl\x7ctg_fbs_ctrlb\x7ctg_s_ctrl\x7cy__t2
+ a\x7cb\x7cm_east\x7cm_west\x7cnand_m_a\x7cnand_m_a_ext_via\x7cnand_m_a_ext_via2\x7cnand_m_a_stub\x7ctg_d_b\x7ctg_d_b_via\x7ctg_d_b_via2\x7ctg_fbm_b\x7ctg_fbm_b_alt_via\x7ctg_fbm_b_alt_via2__t2
+ g_vss_m1\x7cinv_clk_vss\x7cinv_mc_vss\x7cinv_q_vss\x7cmph_g\x7cnand_m_vss\x7cnand_s2_vss\x7cs1_vss_m1\x7cs2_vss_m1\x7cs3_vss_m1\x7cs4_vss_m1\x7csb_vss\x7csr1_vss\x7csr2_vss\x7csr3_vss\x7csr4_vss\x7csv_vss\x7ctg_d_vss\x7ctg_fbm_vss\x7ctg_fbs_vss\x7ctg_s_vss\x7cvss\x7cvss_link\x7cvss_link_bridge\x7cvss_link_dip\x7cvss_link_m1\x7cvss_x1\x7cvss_x2\x7cvss_x3__t131
+ sky130_fd_pr__nfet_01v8 L=0.15 W=0.42 AS=0.1974 AD=0.1974 PS=1.78 PD=1.78
* device instance $27 r0 *1 19.835,0.21 nfet
X$27 a\x7cinv_mc_y\x7cinv_mc_y_via\x7cmc\x7ctg_fbm_a\x7ctg_fbm_a_via\x7cy__t0
+ a\x7cinv_mc_a\x7cmb\x7cmnab_y\x7cmpa_y\x7cmpb_y\x7cnand_m_y\x7ctg_s_a\x7cy__t4
+ g_vss_m1\x7cinv_clk_vss\x7cinv_mc_vss\x7cinv_q_vss\x7cmph_g\x7cnand_m_vss\x7cnand_s2_vss\x7cs1_vss_m1\x7cs2_vss_m1\x7cs3_vss_m1\x7cs4_vss_m1\x7csb_vss\x7csr1_vss\x7csr2_vss\x7csr3_vss\x7csr4_vss\x7csv_vss\x7ctg_d_vss\x7ctg_fbm_vss\x7ctg_fbs_vss\x7ctg_s_vss\x7cvss\x7cvss_link\x7cvss_link_bridge\x7cvss_link_dip\x7cvss_link_m1\x7cvss_x1\x7cvss_x2\x7cvss_x3__t52
+ g_vss_m1\x7cinv_clk_vss\x7cinv_mc_vss\x7cinv_q_vss\x7cmph_g\x7cnand_m_vss\x7cnand_s2_vss\x7cs1_vss_m1\x7cs2_vss_m1\x7cs3_vss_m1\x7cs4_vss_m1\x7csb_vss\x7csr1_vss\x7csr2_vss\x7csr3_vss\x7csr4_vss\x7csv_vss\x7ctg_d_vss\x7ctg_fbm_vss\x7ctg_fbs_vss\x7ctg_s_vss\x7cvss\x7cvss_link\x7cvss_link_bridge\x7cvss_link_dip\x7cvss_link_m1\x7cvss_x1\x7cvss_x2\x7cvss_x3__t132
+ sky130_fd_pr__nfet_01v8 L=0.15 W=0.42 AS=0.1974 AD=0.1974 PS=1.78 PD=1.78
* device instance $28 r0 *1 24.6,0.21 nfet
X$28 a\x7cinv_mc_y\x7cinv_mc_y_via\x7cmc\x7ctg_fbm_a\x7ctg_fbm_a_via\x7cy__t1
+ a\x7cclk\x7cctrl\x7cctrlb\x7cinv_clk_a\x7cinv_clk_clk_via\x7ctg_d_ctrl\x7ctg_d_ctrl_via\x7ctg_fbm_ctrlb\x7ctg_fbm_ctrlb_via\x7ctg_fbs_ctrl\x7ctg_fbs_ctrl_via\x7ctg_s_ctrlb\x7ctg_s_ctrlb_via__t11
+ a\x7cb\x7cm_east\x7cm_west\x7cnand_m_a\x7cnand_m_a_ext_via\x7cnand_m_a_ext_via2\x7cnand_m_a_stub\x7ctg_d_b\x7ctg_d_b_via\x7ctg_d_b_via2\x7ctg_fbm_b\x7ctg_fbm_b_alt_via\x7ctg_fbm_b_alt_via2__t3
+ g_vss_m1\x7cinv_clk_vss\x7cinv_mc_vss\x7cinv_q_vss\x7cmph_g\x7cnand_m_vss\x7cnand_s2_vss\x7cs1_vss_m1\x7cs2_vss_m1\x7cs3_vss_m1\x7cs4_vss_m1\x7csb_vss\x7csr1_vss\x7csr2_vss\x7csr3_vss\x7csr4_vss\x7csv_vss\x7ctg_d_vss\x7ctg_fbm_vss\x7ctg_fbs_vss\x7ctg_s_vss\x7cvss\x7cvss_link\x7cvss_link_bridge\x7cvss_link_dip\x7cvss_link_m1\x7cvss_x1\x7cvss_x2\x7cvss_x3__t133
+ sky130_fd_pr__nfet_01v8 L=0.15 W=0.42 AS=0.1974 AD=0.1974 PS=1.78 PD=1.78
* device instance $29 r0 *1 29.74,0.21 nfet
X$29
+ a\x7cinv_mc_a\x7cmb\x7cmnab_y\x7cmpa_y\x7cmpb_y\x7cnand_m_y\x7ctg_s_a\x7cy__t1
+ a\x7cclk\x7cctrl\x7cctrlb\x7cinv_clk_a\x7cinv_clk_clk_via\x7ctg_d_ctrl\x7ctg_d_ctrl_via\x7ctg_fbm_ctrlb\x7ctg_fbm_ctrlb_via\x7ctg_fbs_ctrl\x7ctg_fbs_ctrl_via\x7ctg_s_ctrlb\x7ctg_s_ctrlb_via__t12
+ a\x7cb\x7cinv_q_a\x7cinv_q_a_via\x7cs\x7ctg_fbs_b\x7ctg_fbs_b_via\x7ctg_s_b\x7ctg_s_b_via__t2
+ g_vss_m1\x7cinv_clk_vss\x7cinv_mc_vss\x7cinv_q_vss\x7cmph_g\x7cnand_m_vss\x7cnand_s2_vss\x7cs1_vss_m1\x7cs2_vss_m1\x7cs3_vss_m1\x7cs4_vss_m1\x7csb_vss\x7csr1_vss\x7csr2_vss\x7csr3_vss\x7csr4_vss\x7csv_vss\x7ctg_d_vss\x7ctg_fbm_vss\x7ctg_fbs_vss\x7ctg_s_vss\x7cvss\x7cvss_link\x7cvss_link_bridge\x7cvss_link_dip\x7cvss_link_m1\x7cvss_x1\x7cvss_x2\x7cvss_x3__t134
+ sky130_fd_pr__nfet_01v8 L=0.15 W=0.42 AS=0.1974 AD=0.1974 PS=1.78 PD=1.78
* device instance $30 r0 *1 36.545,0.21 nfet
X$30
+ a\x7cinv_q_y\x7cinv_q_y_via\x7cinv_q_y_via2\x7cnand_s2_a\x7cnand_s2_a_stub\x7cnand_s2_a_via\x7cnand_s2_a_via2\x7cq\x7cy__t0
+ a\x7cb\x7cinv_q_a\x7cinv_q_a_via\x7cs\x7ctg_fbs_b\x7ctg_fbs_b_via\x7ctg_s_b\x7ctg_s_b_via__t0
+ g_vss_m1\x7cinv_clk_vss\x7cinv_mc_vss\x7cinv_q_vss\x7cmph_g\x7cnand_m_vss\x7cnand_s2_vss\x7cs1_vss_m1\x7cs2_vss_m1\x7cs3_vss_m1\x7cs4_vss_m1\x7csb_vss\x7csr1_vss\x7csr2_vss\x7csr3_vss\x7csr4_vss\x7csv_vss\x7ctg_d_vss\x7ctg_fbm_vss\x7ctg_fbs_vss\x7ctg_s_vss\x7cvss\x7cvss_link\x7cvss_link_bridge\x7cvss_link_dip\x7cvss_link_m1\x7cvss_x1\x7cvss_x2\x7cvss_x3__t53
+ g_vss_m1\x7cinv_clk_vss\x7cinv_mc_vss\x7cinv_q_vss\x7cmph_g\x7cnand_m_vss\x7cnand_s2_vss\x7cs1_vss_m1\x7cs2_vss_m1\x7cs3_vss_m1\x7cs4_vss_m1\x7csb_vss\x7csr1_vss\x7csr2_vss\x7csr3_vss\x7csr4_vss\x7csv_vss\x7ctg_d_vss\x7ctg_fbm_vss\x7ctg_fbs_vss\x7ctg_s_vss\x7cvss\x7cvss_link\x7cvss_link_bridge\x7cvss_link_dip\x7cvss_link_m1\x7cvss_x1\x7cvss_x2\x7cvss_x3__t135
+ sky130_fd_pr__nfet_01v8 L=0.15 W=0.42 AS=0.1974 AD=0.1974 PS=1.78 PD=1.78
* device instance $31 r0 *1 49.03,0.21 nfet
X$31 a\x7cmnab_y\x7cmpa_y\x7cmpb_y\x7cnand_s2_y\x7cqb\x7ctg_fbs_a\x7cy__t0
+ clkb\x7cclkb_bridge1\x7cclkb_bridge2\x7cclkb_mid\x7cclkb_w\x7cctrl\x7cctrlb\x7cinv_clk_y\x7ctg_d_ctrlb\x7ctg_fbm_ctrl\x7ctg_fbs_ctrlb\x7ctg_s_ctrl\x7cy__t3
+ a\x7cb\x7cinv_q_a\x7cinv_q_a_via\x7cs\x7ctg_fbs_b\x7ctg_fbs_b_via\x7ctg_s_b\x7ctg_s_b_via__t3
+ g_vss_m1\x7cinv_clk_vss\x7cinv_mc_vss\x7cinv_q_vss\x7cmph_g\x7cnand_m_vss\x7cnand_s2_vss\x7cs1_vss_m1\x7cs2_vss_m1\x7cs3_vss_m1\x7cs4_vss_m1\x7csb_vss\x7csr1_vss\x7csr2_vss\x7csr3_vss\x7csr4_vss\x7csv_vss\x7ctg_d_vss\x7ctg_fbm_vss\x7ctg_fbs_vss\x7ctg_s_vss\x7cvss\x7cvss_link\x7cvss_link_bridge\x7cvss_link_dip\x7cvss_link_m1\x7cvss_x1\x7cvss_x2\x7cvss_x3__t136
+ sky130_fd_pr__nfet_01v8 L=0.15 W=0.42 AS=0.1974 AD=0.1974 PS=1.78 PD=1.78
* device instance $32 r0 *1 56.205,0.21 nfet
X$32
+ clkb\x7cclkb_bridge1\x7cclkb_bridge2\x7cclkb_mid\x7cclkb_w\x7cctrl\x7cctrlb\x7cinv_clk_y\x7ctg_d_ctrlb\x7ctg_fbm_ctrl\x7ctg_fbs_ctrlb\x7ctg_s_ctrl\x7cy__t02
+ a\x7cclk\x7cctrl\x7cctrlb\x7cinv_clk_a\x7cinv_clk_clk_via\x7ctg_d_ctrl\x7ctg_d_ctrl_via\x7ctg_fbm_ctrlb\x7ctg_fbm_ctrlb_via\x7ctg_fbs_ctrl\x7ctg_fbs_ctrl_via\x7ctg_s_ctrlb\x7ctg_s_ctrlb_via__t13
+ g_vss_m1\x7cinv_clk_vss\x7cinv_mc_vss\x7cinv_q_vss\x7cmph_g\x7cnand_m_vss\x7cnand_s2_vss\x7cs1_vss_m1\x7cs2_vss_m1\x7cs3_vss_m1\x7cs4_vss_m1\x7csb_vss\x7csr1_vss\x7csr2_vss\x7csr3_vss\x7csr4_vss\x7csv_vss\x7ctg_d_vss\x7ctg_fbm_vss\x7ctg_fbs_vss\x7ctg_s_vss\x7cvss\x7cvss_link\x7cvss_link_bridge\x7cvss_link_dip\x7cvss_link_m1\x7cvss_x1\x7cvss_x2\x7cvss_x3__t54
+ g_vss_m1\x7cinv_clk_vss\x7cinv_mc_vss\x7cinv_q_vss\x7cmph_g\x7cnand_m_vss\x7cnand_s2_vss\x7cs1_vss_m1\x7cs2_vss_m1\x7cs3_vss_m1\x7cs4_vss_m1\x7csb_vss\x7csr1_vss\x7csr2_vss\x7csr3_vss\x7csr4_vss\x7csv_vss\x7ctg_d_vss\x7ctg_fbm_vss\x7ctg_fbs_vss\x7ctg_s_vss\x7cvss\x7cvss_link\x7cvss_link_bridge\x7cvss_link_dip\x7cvss_link_m1\x7cvss_x1\x7cvss_x2\x7cvss_x3__t137
+ sky130_fd_pr__nfet_01v8 L=0.15 W=0.42 AS=0.1974 AD=0.1974 PS=1.78 PD=1.78
* device instance $33 r0 *1 60.97,0.21 nfet
X$33
+ a\x7cd\x7cinv_clk_vdd\x7cinv_mc_vdd\x7cinv_q_vdd\x7cmpa_py\x7cmpb_py\x7cnand_m_vdd\x7cnand_s2_vdd\x7cnwell_vdd\x7csb_vdd\x7csr1_vdd\x7csr2_vdd\x7csr3_vdd\x7csr4_vdd\x7csv_d_vdd_tie\x7csv_vdd\x7ctg_d_a\x7ctg_d_vdd\x7ctg_fbm_vdd\x7ctg_fbs_vdd\x7ctg_s_vdd\x7cvdd\x7cvdd_b1\x7cvdd_b2\x7cvdd_b3\x7cvdd_b4\x7cvdd_link\x7cvdd_link_dip\x7cvdd_x1\x7cvdd_x2\x7cvdd_x3__t20
+ clkb\x7cclkb_bridge1\x7cclkb_bridge2\x7cclkb_mid\x7cclkb_w\x7cctrl\x7cctrlb\x7cinv_clk_y\x7ctg_d_ctrlb\x7ctg_fbm_ctrl\x7ctg_fbs_ctrlb\x7ctg_s_ctrl\x7cy__t22
+ a\x7cb\x7cm_east\x7cm_west\x7cnand_m_a\x7cnand_m_a_ext_via\x7cnand_m_a_ext_via2\x7cnand_m_a_stub\x7ctg_d_b\x7ctg_d_b_via\x7ctg_d_b_via2\x7ctg_fbm_b\x7ctg_fbm_b_alt_via\x7ctg_fbm_b_alt_via2__t12
+ g_vss_m1\x7cinv_clk_vss\x7cinv_mc_vss\x7cinv_q_vss\x7cmph_g\x7cnand_m_vss\x7cnand_s2_vss\x7cs1_vss_m1\x7cs2_vss_m1\x7cs3_vss_m1\x7cs4_vss_m1\x7csb_vss\x7csr1_vss\x7csr2_vss\x7csr3_vss\x7csr4_vss\x7csv_vss\x7ctg_d_vss\x7ctg_fbm_vss\x7ctg_fbs_vss\x7ctg_s_vss\x7cvss\x7cvss_link\x7cvss_link_bridge\x7cvss_link_dip\x7cvss_link_m1\x7cvss_x1\x7cvss_x2\x7cvss_x3__t138
+ sky130_fd_pr__nfet_01v8 L=0.15 W=0.42 AS=0.1974 AD=0.1974 PS=1.78 PD=1.78
* device instance $34 r0 *1 75.495,0.21 nfet
X$34 a\x7cinv_mc_y\x7cinv_mc_y_via\x7cmc\x7ctg_fbm_a\x7ctg_fbm_a_via\x7cy__t02
+ a\x7cinv_mc_a\x7cmb\x7cmnab_y\x7cmpa_y\x7cmpb_y\x7cnand_m_y\x7ctg_s_a\x7cy__t32
+ g_vss_m1\x7cinv_clk_vss\x7cinv_mc_vss\x7cinv_q_vss\x7cmph_g\x7cnand_m_vss\x7cnand_s2_vss\x7cs1_vss_m1\x7cs2_vss_m1\x7cs3_vss_m1\x7cs4_vss_m1\x7csb_vss\x7csr1_vss\x7csr2_vss\x7csr3_vss\x7csr4_vss\x7csv_vss\x7ctg_d_vss\x7ctg_fbm_vss\x7ctg_fbs_vss\x7ctg_s_vss\x7cvss\x7cvss_link\x7cvss_link_bridge\x7cvss_link_dip\x7cvss_link_m1\x7cvss_x1\x7cvss_x2\x7cvss_x3__t57
+ g_vss_m1\x7cinv_clk_vss\x7cinv_mc_vss\x7cinv_q_vss\x7cmph_g\x7cnand_m_vss\x7cnand_s2_vss\x7cs1_vss_m1\x7cs2_vss_m1\x7cs3_vss_m1\x7cs4_vss_m1\x7csb_vss\x7csr1_vss\x7csr2_vss\x7csr3_vss\x7csr4_vss\x7csv_vss\x7ctg_d_vss\x7ctg_fbm_vss\x7ctg_fbs_vss\x7ctg_s_vss\x7cvss\x7cvss_link\x7cvss_link_bridge\x7cvss_link_dip\x7cvss_link_m1\x7cvss_x1\x7cvss_x2\x7cvss_x3__t139
+ sky130_fd_pr__nfet_01v8 L=0.15 W=0.42 AS=0.1974 AD=0.1974 PS=1.78 PD=1.78
* device instance $35 r0 *1 80.26,0.21 nfet
X$35 a\x7cinv_mc_y\x7cinv_mc_y_via\x7cmc\x7ctg_fbm_a\x7ctg_fbm_a_via\x7cy__t12
+ a\x7cclk\x7cctrl\x7cctrlb\x7cinv_clk_a\x7cinv_clk_clk_via\x7ctg_d_ctrl\x7ctg_d_ctrl_via\x7ctg_fbm_ctrlb\x7ctg_fbm_ctrlb_via\x7ctg_fbs_ctrl\x7ctg_fbs_ctrl_via\x7ctg_s_ctrlb\x7ctg_s_ctrlb_via__t14
+ a\x7cb\x7cm_east\x7cm_west\x7cnand_m_a\x7cnand_m_a_ext_via\x7cnand_m_a_ext_via2\x7cnand_m_a_stub\x7ctg_d_b\x7ctg_d_b_via\x7ctg_d_b_via2\x7ctg_fbm_b\x7ctg_fbm_b_alt_via\x7ctg_fbm_b_alt_via2__t22
+ g_vss_m1\x7cinv_clk_vss\x7cinv_mc_vss\x7cinv_q_vss\x7cmph_g\x7cnand_m_vss\x7cnand_s2_vss\x7cs1_vss_m1\x7cs2_vss_m1\x7cs3_vss_m1\x7cs4_vss_m1\x7csb_vss\x7csr1_vss\x7csr2_vss\x7csr3_vss\x7csr4_vss\x7csv_vss\x7ctg_d_vss\x7ctg_fbm_vss\x7ctg_fbs_vss\x7ctg_s_vss\x7cvss\x7cvss_link\x7cvss_link_bridge\x7cvss_link_dip\x7cvss_link_m1\x7cvss_x1\x7cvss_x2\x7cvss_x3__t140
+ sky130_fd_pr__nfet_01v8 L=0.15 W=0.42 AS=0.1974 AD=0.1974 PS=1.78 PD=1.78
* device instance $36 r0 *1 85.4,0.21 nfet
X$36
+ a\x7cinv_mc_a\x7cmb\x7cmnab_y\x7cmpa_y\x7cmpb_y\x7cnand_m_y\x7ctg_s_a\x7cy__t02
+ a\x7cclk\x7cctrl\x7cctrlb\x7cinv_clk_a\x7cinv_clk_clk_via\x7ctg_d_ctrl\x7ctg_d_ctrl_via\x7ctg_fbm_ctrlb\x7ctg_fbm_ctrlb_via\x7ctg_fbs_ctrl\x7ctg_fbs_ctrl_via\x7ctg_s_ctrlb\x7ctg_s_ctrlb_via__t18
+ a\x7cb\x7cinv_q_a\x7cinv_q_a_via\x7cs\x7ctg_fbs_b\x7ctg_fbs_b_via\x7ctg_s_b\x7ctg_s_b_via__t32
+ g_vss_m1\x7cinv_clk_vss\x7cinv_mc_vss\x7cinv_q_vss\x7cmph_g\x7cnand_m_vss\x7cnand_s2_vss\x7cs1_vss_m1\x7cs2_vss_m1\x7cs3_vss_m1\x7cs4_vss_m1\x7csb_vss\x7csr1_vss\x7csr2_vss\x7csr3_vss\x7csr4_vss\x7csv_vss\x7ctg_d_vss\x7ctg_fbm_vss\x7ctg_fbs_vss\x7ctg_s_vss\x7cvss\x7cvss_link\x7cvss_link_bridge\x7cvss_link_dip\x7cvss_link_m1\x7cvss_x1\x7cvss_x2\x7cvss_x3__t141
+ sky130_fd_pr__nfet_01v8 L=0.15 W=0.42 AS=0.1974 AD=0.1974 PS=1.78 PD=1.78
* device instance $37 r0 *1 92.205,0.21 nfet
X$37
+ a\x7cinv_q_y\x7cinv_q_y_via\x7cinv_q_y_via2\x7cnand_s2_a\x7cnand_s2_a_stub\x7cnand_s2_a_via\x7cnand_s2_a_via2\x7cq\x7cy__t02
+ a\x7cb\x7cinv_q_a\x7cinv_q_a_via\x7cs\x7ctg_fbs_b\x7ctg_fbs_b_via\x7ctg_s_b\x7ctg_s_b_via__t02
+ g_vss_m1\x7cinv_clk_vss\x7cinv_mc_vss\x7cinv_q_vss\x7cmph_g\x7cnand_m_vss\x7cnand_s2_vss\x7cs1_vss_m1\x7cs2_vss_m1\x7cs3_vss_m1\x7cs4_vss_m1\x7csb_vss\x7csr1_vss\x7csr2_vss\x7csr3_vss\x7csr4_vss\x7csv_vss\x7ctg_d_vss\x7ctg_fbm_vss\x7ctg_fbs_vss\x7ctg_s_vss\x7cvss\x7cvss_link\x7cvss_link_bridge\x7cvss_link_dip\x7cvss_link_m1\x7cvss_x1\x7cvss_x2\x7cvss_x3__t60
+ g_vss_m1\x7cinv_clk_vss\x7cinv_mc_vss\x7cinv_q_vss\x7cmph_g\x7cnand_m_vss\x7cnand_s2_vss\x7cs1_vss_m1\x7cs2_vss_m1\x7cs3_vss_m1\x7cs4_vss_m1\x7csb_vss\x7csr1_vss\x7csr2_vss\x7csr3_vss\x7csr4_vss\x7csv_vss\x7ctg_d_vss\x7ctg_fbm_vss\x7ctg_fbs_vss\x7ctg_s_vss\x7cvss\x7cvss_link\x7cvss_link_bridge\x7cvss_link_dip\x7cvss_link_m1\x7cvss_x1\x7cvss_x2\x7cvss_x3__t142
+ sky130_fd_pr__nfet_01v8 L=0.15 W=0.42 AS=0.1974 AD=0.1974 PS=1.78 PD=1.78
* device instance $38 r0 *1 104.69,0.21 nfet
X$38 a\x7cmnab_y\x7cmpa_y\x7cmpb_y\x7cnand_s2_y\x7cqb\x7ctg_fbs_a\x7cy__t02
+ clkb\x7cclkb_bridge1\x7cclkb_bridge2\x7cclkb_mid\x7cclkb_w\x7cctrl\x7cctrlb\x7cinv_clk_y\x7ctg_d_ctrlb\x7ctg_fbm_ctrl\x7ctg_fbs_ctrlb\x7ctg_s_ctrl\x7cy__t32
+ a\x7cb\x7cinv_q_a\x7cinv_q_a_via\x7cs\x7ctg_fbs_b\x7ctg_fbs_b_via\x7ctg_s_b\x7ctg_s_b_via__t22
+ g_vss_m1\x7cinv_clk_vss\x7cinv_mc_vss\x7cinv_q_vss\x7cmph_g\x7cnand_m_vss\x7cnand_s2_vss\x7cs1_vss_m1\x7cs2_vss_m1\x7cs3_vss_m1\x7cs4_vss_m1\x7csb_vss\x7csr1_vss\x7csr2_vss\x7csr3_vss\x7csr4_vss\x7csv_vss\x7ctg_d_vss\x7ctg_fbm_vss\x7ctg_fbs_vss\x7ctg_s_vss\x7cvss\x7cvss_link\x7cvss_link_bridge\x7cvss_link_dip\x7cvss_link_m1\x7cvss_x1\x7cvss_x2\x7cvss_x3__t143
+ sky130_fd_pr__nfet_01v8 L=0.15 W=0.42 AS=0.1974 AD=0.1974 PS=1.78 PD=1.78
* device instance $39 r0 *1 111.865,0.21 nfet
X$39
+ clkb\x7cclkb_bridge1\x7cclkb_bridge2\x7cclkb_mid\x7cclkb_w\x7cctrl\x7cctrlb\x7cinv_clk_y\x7ctg_d_ctrlb\x7ctg_fbm_ctrl\x7ctg_fbs_ctrlb\x7ctg_s_ctrl\x7cy__t03
+ a\x7cclk\x7cctrl\x7cctrlb\x7cinv_clk_a\x7cinv_clk_clk_via\x7ctg_d_ctrl\x7ctg_d_ctrl_via\x7ctg_fbm_ctrlb\x7ctg_fbm_ctrlb_via\x7ctg_fbs_ctrl\x7ctg_fbs_ctrl_via\x7ctg_s_ctrlb\x7ctg_s_ctrlb_via__t17
+ g_vss_m1\x7cinv_clk_vss\x7cinv_mc_vss\x7cinv_q_vss\x7cmph_g\x7cnand_m_vss\x7cnand_s2_vss\x7cs1_vss_m1\x7cs2_vss_m1\x7cs3_vss_m1\x7cs4_vss_m1\x7csb_vss\x7csr1_vss\x7csr2_vss\x7csr3_vss\x7csr4_vss\x7csv_vss\x7ctg_d_vss\x7ctg_fbm_vss\x7ctg_fbs_vss\x7ctg_s_vss\x7cvss\x7cvss_link\x7cvss_link_bridge\x7cvss_link_dip\x7cvss_link_m1\x7cvss_x1\x7cvss_x2\x7cvss_x3__t61
+ g_vss_m1\x7cinv_clk_vss\x7cinv_mc_vss\x7cinv_q_vss\x7cmph_g\x7cnand_m_vss\x7cnand_s2_vss\x7cs1_vss_m1\x7cs2_vss_m1\x7cs3_vss_m1\x7cs4_vss_m1\x7csb_vss\x7csr1_vss\x7csr2_vss\x7csr3_vss\x7csr4_vss\x7csv_vss\x7ctg_d_vss\x7ctg_fbm_vss\x7ctg_fbs_vss\x7ctg_s_vss\x7cvss\x7cvss_link\x7cvss_link_bridge\x7cvss_link_dip\x7cvss_link_m1\x7cvss_x1\x7cvss_x2\x7cvss_x3__t144
+ sky130_fd_pr__nfet_01v8 L=0.15 W=0.42 AS=0.1974 AD=0.1974 PS=1.78 PD=1.78
* device instance $40 r0 *1 116.63,0.21 nfet
X$40
+ a\x7cd\x7cinva_a\x7cmn12_g0\x7cmp13_g0\x7cro1\x7cro1_esc\x7csr1_d_stub\x7ctg_d_a\x7cy__t2
+ clkb\x7cclkb_bridge1\x7cclkb_bridge2\x7cclkb_mid\x7cclkb_w\x7cctrl\x7cctrlb\x7cinv_clk_y\x7ctg_d_ctrlb\x7ctg_fbm_ctrl\x7ctg_fbs_ctrlb\x7ctg_s_ctrl\x7cy__t33
+ a\x7cb\x7cm_east\x7cm_west\x7cnand_m_a\x7cnand_m_a_ext_via\x7cnand_m_a_ext_via2\x7cnand_m_a_stub\x7ctg_d_b\x7ctg_d_b_via\x7ctg_d_b_via2\x7ctg_fbm_b\x7ctg_fbm_b_alt_via\x7ctg_fbm_b_alt_via2__t23
+ g_vss_m1\x7cinv_clk_vss\x7cinv_mc_vss\x7cinv_q_vss\x7cmph_g\x7cnand_m_vss\x7cnand_s2_vss\x7cs1_vss_m1\x7cs2_vss_m1\x7cs3_vss_m1\x7cs4_vss_m1\x7csb_vss\x7csr1_vss\x7csr2_vss\x7csr3_vss\x7csr4_vss\x7csv_vss\x7ctg_d_vss\x7ctg_fbm_vss\x7ctg_fbs_vss\x7ctg_s_vss\x7cvss\x7cvss_link\x7cvss_link_bridge\x7cvss_link_dip\x7cvss_link_m1\x7cvss_x1\x7cvss_x2\x7cvss_x3__t145
+ sky130_fd_pr__nfet_01v8 L=0.15 W=0.42 AS=0.1974 AD=0.1974 PS=1.78 PD=1.78
* device instance $41 r0 *1 131.155,0.21 nfet
X$41 a\x7cinv_mc_y\x7cinv_mc_y_via\x7cmc\x7ctg_fbm_a\x7ctg_fbm_a_via\x7cy__t03
+ a\x7cinv_mc_a\x7cmb\x7cmnab_y\x7cmpa_y\x7cmpb_y\x7cnand_m_y\x7ctg_s_a\x7cy__t33
+ g_vss_m1\x7cinv_clk_vss\x7cinv_mc_vss\x7cinv_q_vss\x7cmph_g\x7cnand_m_vss\x7cnand_s2_vss\x7cs1_vss_m1\x7cs2_vss_m1\x7cs3_vss_m1\x7cs4_vss_m1\x7csb_vss\x7csr1_vss\x7csr2_vss\x7csr3_vss\x7csr4_vss\x7csv_vss\x7ctg_d_vss\x7ctg_fbm_vss\x7ctg_fbs_vss\x7ctg_s_vss\x7cvss\x7cvss_link\x7cvss_link_bridge\x7cvss_link_dip\x7cvss_link_m1\x7cvss_x1\x7cvss_x2\x7cvss_x3__t56
+ g_vss_m1\x7cinv_clk_vss\x7cinv_mc_vss\x7cinv_q_vss\x7cmph_g\x7cnand_m_vss\x7cnand_s2_vss\x7cs1_vss_m1\x7cs2_vss_m1\x7cs3_vss_m1\x7cs4_vss_m1\x7csb_vss\x7csr1_vss\x7csr2_vss\x7csr3_vss\x7csr4_vss\x7csv_vss\x7ctg_d_vss\x7ctg_fbm_vss\x7ctg_fbs_vss\x7ctg_s_vss\x7cvss\x7cvss_link\x7cvss_link_bridge\x7cvss_link_dip\x7cvss_link_m1\x7cvss_x1\x7cvss_x2\x7cvss_x3__t146
+ sky130_fd_pr__nfet_01v8 L=0.15 W=0.42 AS=0.1974 AD=0.1974 PS=1.78 PD=1.78
* device instance $42 r0 *1 135.92,0.21 nfet
X$42 a\x7cinv_mc_y\x7cinv_mc_y_via\x7cmc\x7ctg_fbm_a\x7ctg_fbm_a_via\x7cy__t13
+ a\x7cclk\x7cctrl\x7cctrlb\x7cinv_clk_a\x7cinv_clk_clk_via\x7ctg_d_ctrl\x7ctg_d_ctrl_via\x7ctg_fbm_ctrlb\x7ctg_fbm_ctrlb_via\x7ctg_fbs_ctrl\x7ctg_fbs_ctrl_via\x7ctg_s_ctrlb\x7ctg_s_ctrlb_via__t16
+ a\x7cb\x7cm_east\x7cm_west\x7cnand_m_a\x7cnand_m_a_ext_via\x7cnand_m_a_ext_via2\x7cnand_m_a_stub\x7ctg_d_b\x7ctg_d_b_via\x7ctg_d_b_via2\x7ctg_fbm_b\x7ctg_fbm_b_alt_via\x7ctg_fbm_b_alt_via2__t13
+ g_vss_m1\x7cinv_clk_vss\x7cinv_mc_vss\x7cinv_q_vss\x7cmph_g\x7cnand_m_vss\x7cnand_s2_vss\x7cs1_vss_m1\x7cs2_vss_m1\x7cs3_vss_m1\x7cs4_vss_m1\x7csb_vss\x7csr1_vss\x7csr2_vss\x7csr3_vss\x7csr4_vss\x7csv_vss\x7ctg_d_vss\x7ctg_fbm_vss\x7ctg_fbs_vss\x7ctg_s_vss\x7cvss\x7cvss_link\x7cvss_link_bridge\x7cvss_link_dip\x7cvss_link_m1\x7cvss_x1\x7cvss_x2\x7cvss_x3__t147
+ sky130_fd_pr__nfet_01v8 L=0.15 W=0.42 AS=0.1974 AD=0.1974 PS=1.78 PD=1.78
* device instance $43 r0 *1 141.06,0.21 nfet
X$43
+ a\x7cinv_mc_a\x7cmb\x7cmnab_y\x7cmpa_y\x7cmpb_y\x7cnand_m_y\x7ctg_s_a\x7cy__t03
+ a\x7cclk\x7cctrl\x7cctrlb\x7cinv_clk_a\x7cinv_clk_clk_via\x7ctg_d_ctrl\x7ctg_d_ctrl_via\x7ctg_fbm_ctrlb\x7ctg_fbm_ctrlb_via\x7ctg_fbs_ctrl\x7ctg_fbs_ctrl_via\x7ctg_s_ctrlb\x7ctg_s_ctrlb_via__t15
+ a\x7cb\x7cinv_q_a\x7cinv_q_a_via\x7cs\x7ctg_fbs_b\x7ctg_fbs_b_via\x7ctg_s_b\x7ctg_s_b_via__t33
+ g_vss_m1\x7cinv_clk_vss\x7cinv_mc_vss\x7cinv_q_vss\x7cmph_g\x7cnand_m_vss\x7cnand_s2_vss\x7cs1_vss_m1\x7cs2_vss_m1\x7cs3_vss_m1\x7cs4_vss_m1\x7csb_vss\x7csr1_vss\x7csr2_vss\x7csr3_vss\x7csr4_vss\x7csv_vss\x7ctg_d_vss\x7ctg_fbm_vss\x7ctg_fbs_vss\x7ctg_s_vss\x7cvss\x7cvss_link\x7cvss_link_bridge\x7cvss_link_dip\x7cvss_link_m1\x7cvss_x1\x7cvss_x2\x7cvss_x3__t148
+ sky130_fd_pr__nfet_01v8 L=0.15 W=0.42 AS=0.1974 AD=0.1974 PS=1.78 PD=1.78
* device instance $44 r0 *1 147.865,0.21 nfet
X$44
+ a\x7cinv_q_y\x7cinv_q_y_via\x7cinv_q_y_via2\x7cnand_s2_a\x7cnand_s2_a_stub\x7cnand_s2_a_via\x7cnand_s2_a_via2\x7cq\x7cy__t03
+ a\x7cb\x7cinv_q_a\x7cinv_q_a_via\x7cs\x7ctg_fbs_b\x7ctg_fbs_b_via\x7ctg_s_b\x7ctg_s_b_via__t03
+ g_vss_m1\x7cinv_clk_vss\x7cinv_mc_vss\x7cinv_q_vss\x7cmph_g\x7cnand_m_vss\x7cnand_s2_vss\x7cs1_vss_m1\x7cs2_vss_m1\x7cs3_vss_m1\x7cs4_vss_m1\x7csb_vss\x7csr1_vss\x7csr2_vss\x7csr3_vss\x7csr4_vss\x7csv_vss\x7ctg_d_vss\x7ctg_fbm_vss\x7ctg_fbs_vss\x7ctg_s_vss\x7cvss\x7cvss_link\x7cvss_link_bridge\x7cvss_link_dip\x7cvss_link_m1\x7cvss_x1\x7cvss_x2\x7cvss_x3__t58
+ g_vss_m1\x7cinv_clk_vss\x7cinv_mc_vss\x7cinv_q_vss\x7cmph_g\x7cnand_m_vss\x7cnand_s2_vss\x7cs1_vss_m1\x7cs2_vss_m1\x7cs3_vss_m1\x7cs4_vss_m1\x7csb_vss\x7csr1_vss\x7csr2_vss\x7csr3_vss\x7csr4_vss\x7csv_vss\x7ctg_d_vss\x7ctg_fbm_vss\x7ctg_fbs_vss\x7ctg_s_vss\x7cvss\x7cvss_link\x7cvss_link_bridge\x7cvss_link_dip\x7cvss_link_m1\x7cvss_x1\x7cvss_x2\x7cvss_x3__t149
+ sky130_fd_pr__nfet_01v8 L=0.15 W=0.42 AS=0.1974 AD=0.1974 PS=1.78 PD=1.78
* device instance $45 r0 *1 160.35,0.21 nfet
X$45 a\x7cmnab_y\x7cmpa_y\x7cmpb_y\x7cnand_s2_y\x7cqb\x7ctg_fbs_a\x7cy__t03
+ clkb\x7cclkb_bridge1\x7cclkb_bridge2\x7cclkb_mid\x7cclkb_w\x7cctrl\x7cctrlb\x7cinv_clk_y\x7ctg_d_ctrlb\x7ctg_fbm_ctrl\x7ctg_fbs_ctrlb\x7ctg_s_ctrl\x7cy__t23
+ a\x7cb\x7cinv_q_a\x7cinv_q_a_via\x7cs\x7ctg_fbs_b\x7ctg_fbs_b_via\x7ctg_s_b\x7ctg_s_b_via__t23
+ g_vss_m1\x7cinv_clk_vss\x7cinv_mc_vss\x7cinv_q_vss\x7cmph_g\x7cnand_m_vss\x7cnand_s2_vss\x7cs1_vss_m1\x7cs2_vss_m1\x7cs3_vss_m1\x7cs4_vss_m1\x7csb_vss\x7csr1_vss\x7csr2_vss\x7csr3_vss\x7csr4_vss\x7csv_vss\x7ctg_d_vss\x7ctg_fbm_vss\x7ctg_fbs_vss\x7ctg_s_vss\x7cvss\x7cvss_link\x7cvss_link_bridge\x7cvss_link_dip\x7cvss_link_m1\x7cvss_x1\x7cvss_x2\x7cvss_x3__t150
+ sky130_fd_pr__nfet_01v8 L=0.15 W=0.42 AS=0.1974 AD=0.1974 PS=1.78 PD=1.78
* device instance $46 r0 *1 167.525,0.21 nfet
X$46
+ clkb\x7cclkb_bridge1\x7cclkb_bridge2\x7cclkb_mid\x7cclkb_w\x7cctrl\x7cctrlb\x7cinv_clk_y\x7ctg_d_ctrlb\x7ctg_fbm_ctrl\x7ctg_fbs_ctrlb\x7ctg_s_ctrl\x7cy__t04
+ a\x7cclk\x7cctrl\x7cctrlb\x7cinv_clk_a\x7cinv_clk_clk_via\x7ctg_d_ctrl\x7ctg_d_ctrl_via\x7ctg_fbm_ctrlb\x7ctg_fbm_ctrlb_via\x7ctg_fbs_ctrl\x7ctg_fbs_ctrl_via\x7ctg_s_ctrlb\x7ctg_s_ctrlb_via__t10
+ g_vss_m1\x7cinv_clk_vss\x7cinv_mc_vss\x7cinv_q_vss\x7cmph_g\x7cnand_m_vss\x7cnand_s2_vss\x7cs1_vss_m1\x7cs2_vss_m1\x7cs3_vss_m1\x7cs4_vss_m1\x7csb_vss\x7csr1_vss\x7csr2_vss\x7csr3_vss\x7csr4_vss\x7csv_vss\x7ctg_d_vss\x7ctg_fbm_vss\x7ctg_fbs_vss\x7ctg_s_vss\x7cvss\x7cvss_link\x7cvss_link_bridge\x7cvss_link_dip\x7cvss_link_m1\x7cvss_x1\x7cvss_x2\x7cvss_x3__t51
+ g_vss_m1\x7cinv_clk_vss\x7cinv_mc_vss\x7cinv_q_vss\x7cmph_g\x7cnand_m_vss\x7cnand_s2_vss\x7cs1_vss_m1\x7cs2_vss_m1\x7cs3_vss_m1\x7cs4_vss_m1\x7csb_vss\x7csr1_vss\x7csr2_vss\x7csr3_vss\x7csr4_vss\x7csv_vss\x7ctg_d_vss\x7ctg_fbm_vss\x7ctg_fbs_vss\x7ctg_s_vss\x7cvss\x7cvss_link\x7cvss_link_bridge\x7cvss_link_dip\x7cvss_link_m1\x7cvss_x1\x7cvss_x2\x7cvss_x3__t151
+ sky130_fd_pr__nfet_01v8 L=0.15 W=0.42 AS=0.1974 AD=0.1974 PS=1.78 PD=1.78
* device instance $47 r0 *1 172.29,0.21 nfet
X$47
+ a\x7cb\x7cd\x7cinvb_a\x7cmn12_g1\x7cmp24_g0\x7cro2\x7cro2_esc\x7csr2_d_stub\x7ctg_d_a\x7cy__t1
+ clkb\x7cclkb_bridge1\x7cclkb_bridge2\x7cclkb_mid\x7cclkb_w\x7cctrl\x7cctrlb\x7cinv_clk_y\x7ctg_d_ctrlb\x7ctg_fbm_ctrl\x7ctg_fbs_ctrlb\x7ctg_s_ctrl\x7cy__t34
+ a\x7cb\x7cm_east\x7cm_west\x7cnand_m_a\x7cnand_m_a_ext_via\x7cnand_m_a_ext_via2\x7cnand_m_a_stub\x7ctg_d_b\x7ctg_d_b_via\x7ctg_d_b_via2\x7ctg_fbm_b\x7ctg_fbm_b_alt_via\x7ctg_fbm_b_alt_via2__t24
+ g_vss_m1\x7cinv_clk_vss\x7cinv_mc_vss\x7cinv_q_vss\x7cmph_g\x7cnand_m_vss\x7cnand_s2_vss\x7cs1_vss_m1\x7cs2_vss_m1\x7cs3_vss_m1\x7cs4_vss_m1\x7csb_vss\x7csr1_vss\x7csr2_vss\x7csr3_vss\x7csr4_vss\x7csv_vss\x7ctg_d_vss\x7ctg_fbm_vss\x7ctg_fbs_vss\x7ctg_s_vss\x7cvss\x7cvss_link\x7cvss_link_bridge\x7cvss_link_dip\x7cvss_link_m1\x7cvss_x1\x7cvss_x2\x7cvss_x3__t152
+ sky130_fd_pr__nfet_01v8 L=0.15 W=0.42 AS=0.1974 AD=0.1974 PS=1.78 PD=1.78
* device instance $48 r0 *1 186.815,0.21 nfet
X$48 a\x7cinv_mc_y\x7cinv_mc_y_via\x7cmc\x7ctg_fbm_a\x7ctg_fbm_a_via\x7cy__t14
+ a\x7cinv_mc_a\x7cmb\x7cmnab_y\x7cmpa_y\x7cmpb_y\x7cnand_m_y\x7ctg_s_a\x7cy__t34
+ g_vss_m1\x7cinv_clk_vss\x7cinv_mc_vss\x7cinv_q_vss\x7cmph_g\x7cnand_m_vss\x7cnand_s2_vss\x7cs1_vss_m1\x7cs2_vss_m1\x7cs3_vss_m1\x7cs4_vss_m1\x7csb_vss\x7csr1_vss\x7csr2_vss\x7csr3_vss\x7csr4_vss\x7csv_vss\x7ctg_d_vss\x7ctg_fbm_vss\x7ctg_fbs_vss\x7ctg_s_vss\x7cvss\x7cvss_link\x7cvss_link_bridge\x7cvss_link_dip\x7cvss_link_m1\x7cvss_x1\x7cvss_x2\x7cvss_x3__t45
+ g_vss_m1\x7cinv_clk_vss\x7cinv_mc_vss\x7cinv_q_vss\x7cmph_g\x7cnand_m_vss\x7cnand_s2_vss\x7cs1_vss_m1\x7cs2_vss_m1\x7cs3_vss_m1\x7cs4_vss_m1\x7csb_vss\x7csr1_vss\x7csr2_vss\x7csr3_vss\x7csr4_vss\x7csv_vss\x7ctg_d_vss\x7ctg_fbm_vss\x7ctg_fbs_vss\x7ctg_s_vss\x7cvss\x7cvss_link\x7cvss_link_bridge\x7cvss_link_dip\x7cvss_link_m1\x7cvss_x1\x7cvss_x2\x7cvss_x3__t153
+ sky130_fd_pr__nfet_01v8 L=0.15 W=0.42 AS=0.1974 AD=0.1974 PS=1.78 PD=1.78
* device instance $49 r0 *1 191.58,0.21 nfet
X$49 a\x7cinv_mc_y\x7cinv_mc_y_via\x7cmc\x7ctg_fbm_a\x7ctg_fbm_a_via\x7cy__t04
+ a\x7cclk\x7cctrl\x7cctrlb\x7cinv_clk_a\x7cinv_clk_clk_via\x7ctg_d_ctrl\x7ctg_d_ctrl_via\x7ctg_fbm_ctrlb\x7ctg_fbm_ctrlb_via\x7ctg_fbs_ctrl\x7ctg_fbs_ctrl_via\x7ctg_s_ctrlb\x7ctg_s_ctrlb_via__t5
+ a\x7cb\x7cm_east\x7cm_west\x7cnand_m_a\x7cnand_m_a_ext_via\x7cnand_m_a_ext_via2\x7cnand_m_a_stub\x7ctg_d_b\x7ctg_d_b_via\x7ctg_d_b_via2\x7ctg_fbm_b\x7ctg_fbm_b_alt_via\x7ctg_fbm_b_alt_via2__t14
+ g_vss_m1\x7cinv_clk_vss\x7cinv_mc_vss\x7cinv_q_vss\x7cmph_g\x7cnand_m_vss\x7cnand_s2_vss\x7cs1_vss_m1\x7cs2_vss_m1\x7cs3_vss_m1\x7cs4_vss_m1\x7csb_vss\x7csr1_vss\x7csr2_vss\x7csr3_vss\x7csr4_vss\x7csv_vss\x7ctg_d_vss\x7ctg_fbm_vss\x7ctg_fbs_vss\x7ctg_s_vss\x7cvss\x7cvss_link\x7cvss_link_bridge\x7cvss_link_dip\x7cvss_link_m1\x7cvss_x1\x7cvss_x2\x7cvss_x3__t154
+ sky130_fd_pr__nfet_01v8 L=0.15 W=0.42 AS=0.1974 AD=0.1974 PS=1.78 PD=1.78
* device instance $50 r0 *1 196.72,0.21 nfet
X$50
+ a\x7cinv_mc_a\x7cmb\x7cmnab_y\x7cmpa_y\x7cmpb_y\x7cnand_m_y\x7ctg_s_a\x7cy__t04
+ a\x7cclk\x7cctrl\x7cctrlb\x7cinv_clk_a\x7cinv_clk_clk_via\x7ctg_d_ctrl\x7ctg_d_ctrl_via\x7ctg_fbm_ctrlb\x7ctg_fbm_ctrlb_via\x7ctg_fbs_ctrl\x7ctg_fbs_ctrl_via\x7ctg_s_ctrlb\x7ctg_s_ctrlb_via__t4
+ a\x7cb\x7cinv_q_a\x7cinv_q_a_via\x7cs\x7ctg_fbs_b\x7ctg_fbs_b_via\x7ctg_s_b\x7ctg_s_b_via__t34
+ g_vss_m1\x7cinv_clk_vss\x7cinv_mc_vss\x7cinv_q_vss\x7cmph_g\x7cnand_m_vss\x7cnand_s2_vss\x7cs1_vss_m1\x7cs2_vss_m1\x7cs3_vss_m1\x7cs4_vss_m1\x7csb_vss\x7csr1_vss\x7csr2_vss\x7csr3_vss\x7csr4_vss\x7csv_vss\x7ctg_d_vss\x7ctg_fbm_vss\x7ctg_fbs_vss\x7ctg_s_vss\x7cvss\x7cvss_link\x7cvss_link_bridge\x7cvss_link_dip\x7cvss_link_m1\x7cvss_x1\x7cvss_x2\x7cvss_x3__t155
+ sky130_fd_pr__nfet_01v8 L=0.15 W=0.42 AS=0.1974 AD=0.1974 PS=1.78 PD=1.78
* device instance $51 r0 *1 203.525,0.21 nfet
X$51
+ a\x7cinv_q_y\x7cinv_q_y_via\x7cinv_q_y_via2\x7cnand_s2_a\x7cnand_s2_a_stub\x7cnand_s2_a_via\x7cnand_s2_a_via2\x7cq\x7cy__t04
+ a\x7cb\x7cinv_q_a\x7cinv_q_a_via\x7cs\x7ctg_fbs_b\x7ctg_fbs_b_via\x7ctg_s_b\x7ctg_s_b_via__t04
+ g_vss_m1\x7cinv_clk_vss\x7cinv_mc_vss\x7cinv_q_vss\x7cmph_g\x7cnand_m_vss\x7cnand_s2_vss\x7cs1_vss_m1\x7cs2_vss_m1\x7cs3_vss_m1\x7cs4_vss_m1\x7csb_vss\x7csr1_vss\x7csr2_vss\x7csr3_vss\x7csr4_vss\x7csv_vss\x7ctg_d_vss\x7ctg_fbm_vss\x7ctg_fbs_vss\x7ctg_s_vss\x7cvss\x7cvss_link\x7cvss_link_bridge\x7cvss_link_dip\x7cvss_link_m1\x7cvss_x1\x7cvss_x2\x7cvss_x3__t44
+ g_vss_m1\x7cinv_clk_vss\x7cinv_mc_vss\x7cinv_q_vss\x7cmph_g\x7cnand_m_vss\x7cnand_s2_vss\x7cs1_vss_m1\x7cs2_vss_m1\x7cs3_vss_m1\x7cs4_vss_m1\x7csb_vss\x7csr1_vss\x7csr2_vss\x7csr3_vss\x7csr4_vss\x7csv_vss\x7ctg_d_vss\x7ctg_fbm_vss\x7ctg_fbs_vss\x7ctg_s_vss\x7cvss\x7cvss_link\x7cvss_link_bridge\x7cvss_link_dip\x7cvss_link_m1\x7cvss_x1\x7cvss_x2\x7cvss_x3__t156
+ sky130_fd_pr__nfet_01v8 L=0.15 W=0.42 AS=0.1974 AD=0.1974 PS=1.78 PD=1.78
* device instance $52 r0 *1 216.01,0.21 nfet
X$52 a\x7cmnab_y\x7cmpa_y\x7cmpb_y\x7cnand_s2_y\x7cqb\x7ctg_fbs_a\x7cy__t04
+ clkb\x7cclkb_bridge1\x7cclkb_bridge2\x7cclkb_mid\x7cclkb_w\x7cctrl\x7cctrlb\x7cinv_clk_y\x7ctg_d_ctrlb\x7ctg_fbm_ctrl\x7ctg_fbs_ctrlb\x7ctg_s_ctrl\x7cy__t24
+ a\x7cb\x7cinv_q_a\x7cinv_q_a_via\x7cs\x7ctg_fbs_b\x7ctg_fbs_b_via\x7ctg_s_b\x7ctg_s_b_via__t24
+ g_vss_m1\x7cinv_clk_vss\x7cinv_mc_vss\x7cinv_q_vss\x7cmph_g\x7cnand_m_vss\x7cnand_s2_vss\x7cs1_vss_m1\x7cs2_vss_m1\x7cs3_vss_m1\x7cs4_vss_m1\x7csb_vss\x7csr1_vss\x7csr2_vss\x7csr3_vss\x7csr4_vss\x7csv_vss\x7ctg_d_vss\x7ctg_fbm_vss\x7ctg_fbs_vss\x7ctg_s_vss\x7cvss\x7cvss_link\x7cvss_link_bridge\x7cvss_link_dip\x7cvss_link_m1\x7cvss_x1\x7cvss_x2\x7cvss_x3__t157
+ sky130_fd_pr__nfet_01v8 L=0.15 W=0.42 AS=0.1974 AD=0.1974 PS=1.78 PD=1.78
* device instance $53 r0 *1 223.185,0.21 nfet
X$53
+ clkb\x7cclkb_bridge1\x7cclkb_bridge2\x7cclkb_mid\x7cclkb_w\x7cctrl\x7cctrlb\x7cinv_clk_y\x7ctg_d_ctrlb\x7ctg_fbm_ctrl\x7ctg_fbs_ctrlb\x7ctg_s_ctrl\x7cy__t05
+ a\x7cclk\x7cctrl\x7cctrlb\x7cinv_clk_a\x7cinv_clk_clk_via\x7ctg_d_ctrl\x7ctg_d_ctrl_via\x7ctg_fbm_ctrlb\x7ctg_fbm_ctrlb_via\x7ctg_fbs_ctrl\x7ctg_fbs_ctrl_via\x7ctg_s_ctrlb\x7ctg_s_ctrlb_via__t2
+ g_vss_m1\x7cinv_clk_vss\x7cinv_mc_vss\x7cinv_q_vss\x7cmph_g\x7cnand_m_vss\x7cnand_s2_vss\x7cs1_vss_m1\x7cs2_vss_m1\x7cs3_vss_m1\x7cs4_vss_m1\x7csb_vss\x7csr1_vss\x7csr2_vss\x7csr3_vss\x7csr4_vss\x7csv_vss\x7ctg_d_vss\x7ctg_fbm_vss\x7ctg_fbs_vss\x7ctg_s_vss\x7cvss\x7cvss_link\x7cvss_link_bridge\x7cvss_link_dip\x7cvss_link_m1\x7cvss_x1\x7cvss_x2\x7cvss_x3__t43
+ g_vss_m1\x7cinv_clk_vss\x7cinv_mc_vss\x7cinv_q_vss\x7cmph_g\x7cnand_m_vss\x7cnand_s2_vss\x7cs1_vss_m1\x7cs2_vss_m1\x7cs3_vss_m1\x7cs4_vss_m1\x7csb_vss\x7csr1_vss\x7csr2_vss\x7csr3_vss\x7csr4_vss\x7csv_vss\x7ctg_d_vss\x7ctg_fbm_vss\x7ctg_fbs_vss\x7ctg_s_vss\x7cvss\x7cvss_link\x7cvss_link_bridge\x7cvss_link_dip\x7cvss_link_m1\x7cvss_x1\x7cvss_x2\x7cvss_x3__t158
+ sky130_fd_pr__nfet_01v8 L=0.15 W=0.42 AS=0.1974 AD=0.1974 PS=1.78 PD=1.78
* device instance $54 r0 *1 227.95,0.21 nfet
X$54
+ a\x7cd\x7cinva_a\x7cmn12_g0\x7cmp13_g0\x7cro3\x7cro3_esc_e\x7cro3_esc_w\x7cro3_hop\x7csr3_d_stub\x7ctg_d_a\x7cy__t1
+ clkb\x7cclkb_bridge1\x7cclkb_bridge2\x7cclkb_mid\x7cclkb_w\x7cctrl\x7cctrlb\x7cinv_clk_y\x7ctg_d_ctrlb\x7ctg_fbm_ctrl\x7ctg_fbs_ctrlb\x7ctg_s_ctrl\x7cy__t25
+ a\x7cb\x7cm_east\x7cm_west\x7cnand_m_a\x7cnand_m_a_ext_via\x7cnand_m_a_ext_via2\x7cnand_m_a_stub\x7ctg_d_b\x7ctg_d_b_via\x7ctg_d_b_via2\x7ctg_fbm_b\x7ctg_fbm_b_alt_via\x7ctg_fbm_b_alt_via2__t15
+ g_vss_m1\x7cinv_clk_vss\x7cinv_mc_vss\x7cinv_q_vss\x7cmph_g\x7cnand_m_vss\x7cnand_s2_vss\x7cs1_vss_m1\x7cs2_vss_m1\x7cs3_vss_m1\x7cs4_vss_m1\x7csb_vss\x7csr1_vss\x7csr2_vss\x7csr3_vss\x7csr4_vss\x7csv_vss\x7ctg_d_vss\x7ctg_fbm_vss\x7ctg_fbs_vss\x7ctg_s_vss\x7cvss\x7cvss_link\x7cvss_link_bridge\x7cvss_link_dip\x7cvss_link_m1\x7cvss_x1\x7cvss_x2\x7cvss_x3__t159
+ sky130_fd_pr__nfet_01v8 L=0.15 W=0.42 AS=0.1974 AD=0.1974 PS=1.78 PD=1.78
* device instance $55 r0 *1 242.475,0.21 nfet
X$55 a\x7cinv_mc_y\x7cinv_mc_y_via\x7cmc\x7ctg_fbm_a\x7ctg_fbm_a_via\x7cy__t05
+ a\x7cinv_mc_a\x7cmb\x7cmnab_y\x7cmpa_y\x7cmpb_y\x7cnand_m_y\x7ctg_s_a\x7cy__t35
+ g_vss_m1\x7cinv_clk_vss\x7cinv_mc_vss\x7cinv_q_vss\x7cmph_g\x7cnand_m_vss\x7cnand_s2_vss\x7cs1_vss_m1\x7cs2_vss_m1\x7cs3_vss_m1\x7cs4_vss_m1\x7csb_vss\x7csr1_vss\x7csr2_vss\x7csr3_vss\x7csr4_vss\x7csv_vss\x7ctg_d_vss\x7ctg_fbm_vss\x7ctg_fbs_vss\x7ctg_s_vss\x7cvss\x7cvss_link\x7cvss_link_bridge\x7cvss_link_dip\x7cvss_link_m1\x7cvss_x1\x7cvss_x2\x7cvss_x3__t42
+ g_vss_m1\x7cinv_clk_vss\x7cinv_mc_vss\x7cinv_q_vss\x7cmph_g\x7cnand_m_vss\x7cnand_s2_vss\x7cs1_vss_m1\x7cs2_vss_m1\x7cs3_vss_m1\x7cs4_vss_m1\x7csb_vss\x7csr1_vss\x7csr2_vss\x7csr3_vss\x7csr4_vss\x7csv_vss\x7ctg_d_vss\x7ctg_fbm_vss\x7ctg_fbs_vss\x7ctg_s_vss\x7cvss\x7cvss_link\x7cvss_link_bridge\x7cvss_link_dip\x7cvss_link_m1\x7cvss_x1\x7cvss_x2\x7cvss_x3__t160
+ sky130_fd_pr__nfet_01v8 L=0.15 W=0.42 AS=0.1974 AD=0.1974 PS=1.78 PD=1.78
* device instance $56 r0 *1 247.24,0.21 nfet
X$56 a\x7cinv_mc_y\x7cinv_mc_y_via\x7cmc\x7ctg_fbm_a\x7ctg_fbm_a_via\x7cy__t15
+ a\x7cclk\x7cctrl\x7cctrlb\x7cinv_clk_a\x7cinv_clk_clk_via\x7ctg_d_ctrl\x7ctg_d_ctrl_via\x7ctg_fbm_ctrlb\x7ctg_fbm_ctrlb_via\x7ctg_fbs_ctrl\x7ctg_fbs_ctrl_via\x7ctg_s_ctrlb\x7ctg_s_ctrlb_via__t3
+ a\x7cb\x7cm_east\x7cm_west\x7cnand_m_a\x7cnand_m_a_ext_via\x7cnand_m_a_ext_via2\x7cnand_m_a_stub\x7ctg_d_b\x7ctg_d_b_via\x7ctg_d_b_via2\x7ctg_fbm_b\x7ctg_fbm_b_alt_via\x7ctg_fbm_b_alt_via2__t25
+ g_vss_m1\x7cinv_clk_vss\x7cinv_mc_vss\x7cinv_q_vss\x7cmph_g\x7cnand_m_vss\x7cnand_s2_vss\x7cs1_vss_m1\x7cs2_vss_m1\x7cs3_vss_m1\x7cs4_vss_m1\x7csb_vss\x7csr1_vss\x7csr2_vss\x7csr3_vss\x7csr4_vss\x7csv_vss\x7ctg_d_vss\x7ctg_fbm_vss\x7ctg_fbs_vss\x7ctg_s_vss\x7cvss\x7cvss_link\x7cvss_link_bridge\x7cvss_link_dip\x7cvss_link_m1\x7cvss_x1\x7cvss_x2\x7cvss_x3__t161
+ sky130_fd_pr__nfet_01v8 L=0.15 W=0.42 AS=0.1974 AD=0.1974 PS=1.78 PD=1.78
* device instance $57 r0 *1 252.38,0.21 nfet
X$57
+ a\x7cinv_mc_a\x7cmb\x7cmnab_y\x7cmpa_y\x7cmpb_y\x7cnand_m_y\x7ctg_s_a\x7cy__t05
+ a\x7cclk\x7cctrl\x7cctrlb\x7cinv_clk_a\x7cinv_clk_clk_via\x7ctg_d_ctrl\x7ctg_d_ctrl_via\x7ctg_fbm_ctrlb\x7ctg_fbm_ctrlb_via\x7ctg_fbs_ctrl\x7ctg_fbs_ctrl_via\x7ctg_s_ctrlb\x7ctg_s_ctrlb_via__t6
+ a\x7cb\x7cinv_q_a\x7cinv_q_a_via\x7cs\x7ctg_fbs_b\x7ctg_fbs_b_via\x7ctg_s_b\x7ctg_s_b_via__t25
+ g_vss_m1\x7cinv_clk_vss\x7cinv_mc_vss\x7cinv_q_vss\x7cmph_g\x7cnand_m_vss\x7cnand_s2_vss\x7cs1_vss_m1\x7cs2_vss_m1\x7cs3_vss_m1\x7cs4_vss_m1\x7csb_vss\x7csr1_vss\x7csr2_vss\x7csr3_vss\x7csr4_vss\x7csv_vss\x7ctg_d_vss\x7ctg_fbm_vss\x7ctg_fbs_vss\x7ctg_s_vss\x7cvss\x7cvss_link\x7cvss_link_bridge\x7cvss_link_dip\x7cvss_link_m1\x7cvss_x1\x7cvss_x2\x7cvss_x3__t162
+ sky130_fd_pr__nfet_01v8 L=0.15 W=0.42 AS=0.1974 AD=0.1974 PS=1.78 PD=1.78
* device instance $58 r0 *1 259.185,0.21 nfet
X$58
+ a\x7cinv_q_y\x7cinv_q_y_via\x7cinv_q_y_via2\x7cnand_s2_a\x7cnand_s2_a_stub\x7cnand_s2_a_via\x7cnand_s2_a_via2\x7cq\x7cy__t05
+ a\x7cb\x7cinv_q_a\x7cinv_q_a_via\x7cs\x7ctg_fbs_b\x7ctg_fbs_b_via\x7ctg_s_b\x7ctg_s_b_via__t05
+ g_vss_m1\x7cinv_clk_vss\x7cinv_mc_vss\x7cinv_q_vss\x7cmph_g\x7cnand_m_vss\x7cnand_s2_vss\x7cs1_vss_m1\x7cs2_vss_m1\x7cs3_vss_m1\x7cs4_vss_m1\x7csb_vss\x7csr1_vss\x7csr2_vss\x7csr3_vss\x7csr4_vss\x7csv_vss\x7ctg_d_vss\x7ctg_fbm_vss\x7ctg_fbs_vss\x7ctg_s_vss\x7cvss\x7cvss_link\x7cvss_link_bridge\x7cvss_link_dip\x7cvss_link_m1\x7cvss_x1\x7cvss_x2\x7cvss_x3__t47
+ g_vss_m1\x7cinv_clk_vss\x7cinv_mc_vss\x7cinv_q_vss\x7cmph_g\x7cnand_m_vss\x7cnand_s2_vss\x7cs1_vss_m1\x7cs2_vss_m1\x7cs3_vss_m1\x7cs4_vss_m1\x7csb_vss\x7csr1_vss\x7csr2_vss\x7csr3_vss\x7csr4_vss\x7csv_vss\x7ctg_d_vss\x7ctg_fbm_vss\x7ctg_fbs_vss\x7ctg_s_vss\x7cvss\x7cvss_link\x7cvss_link_bridge\x7cvss_link_dip\x7cvss_link_m1\x7cvss_x1\x7cvss_x2\x7cvss_x3__t163
+ sky130_fd_pr__nfet_01v8 L=0.15 W=0.42 AS=0.1974 AD=0.1974 PS=1.78 PD=1.78
* device instance $59 r0 *1 271.67,0.21 nfet
X$59 a\x7cmnab_y\x7cmpa_y\x7cmpb_y\x7cnand_s2_y\x7cqb\x7ctg_fbs_a\x7cy__t05
+ clkb\x7cclkb_bridge1\x7cclkb_bridge2\x7cclkb_mid\x7cclkb_w\x7cctrl\x7cctrlb\x7cinv_clk_y\x7ctg_d_ctrlb\x7ctg_fbm_ctrl\x7ctg_fbs_ctrlb\x7ctg_s_ctrl\x7cy__t35
+ a\x7cb\x7cinv_q_a\x7cinv_q_a_via\x7cs\x7ctg_fbs_b\x7ctg_fbs_b_via\x7ctg_s_b\x7ctg_s_b_via__t35
+ g_vss_m1\x7cinv_clk_vss\x7cinv_mc_vss\x7cinv_q_vss\x7cmph_g\x7cnand_m_vss\x7cnand_s2_vss\x7cs1_vss_m1\x7cs2_vss_m1\x7cs3_vss_m1\x7cs4_vss_m1\x7csb_vss\x7csr1_vss\x7csr2_vss\x7csr3_vss\x7csr4_vss\x7csv_vss\x7ctg_d_vss\x7ctg_fbm_vss\x7ctg_fbs_vss\x7ctg_s_vss\x7cvss\x7cvss_link\x7cvss_link_bridge\x7cvss_link_dip\x7cvss_link_m1\x7cvss_x1\x7cvss_x2\x7cvss_x3__t164
+ sky130_fd_pr__nfet_01v8 L=0.15 W=0.42 AS=0.1974 AD=0.1974 PS=1.78 PD=1.78
* device instance $60 r0 *1 278.845,0.21 nfet
X$60
+ clkb\x7cclkb_bridge1\x7cclkb_bridge2\x7cclkb_mid\x7cclkb_w\x7cctrl\x7cctrlb\x7cinv_clk_y\x7ctg_d_ctrlb\x7ctg_fbm_ctrl\x7ctg_fbs_ctrlb\x7ctg_s_ctrl\x7cy__t06
+ a\x7cclk\x7cctrl\x7cctrlb\x7cinv_clk_a\x7cinv_clk_clk_via\x7ctg_d_ctrl\x7ctg_d_ctrl_via\x7ctg_fbm_ctrlb\x7ctg_fbm_ctrlb_via\x7ctg_fbs_ctrl\x7ctg_fbs_ctrl_via\x7ctg_s_ctrlb\x7ctg_s_ctrlb_via__t7
+ g_vss_m1\x7cinv_clk_vss\x7cinv_mc_vss\x7cinv_q_vss\x7cmph_g\x7cnand_m_vss\x7cnand_s2_vss\x7cs1_vss_m1\x7cs2_vss_m1\x7cs3_vss_m1\x7cs4_vss_m1\x7csb_vss\x7csr1_vss\x7csr2_vss\x7csr3_vss\x7csr4_vss\x7csv_vss\x7ctg_d_vss\x7ctg_fbm_vss\x7ctg_fbs_vss\x7ctg_s_vss\x7cvss\x7cvss_link\x7cvss_link_bridge\x7cvss_link_dip\x7cvss_link_m1\x7cvss_x1\x7cvss_x2\x7cvss_x3__t48
+ g_vss_m1\x7cinv_clk_vss\x7cinv_mc_vss\x7cinv_q_vss\x7cmph_g\x7cnand_m_vss\x7cnand_s2_vss\x7cs1_vss_m1\x7cs2_vss_m1\x7cs3_vss_m1\x7cs4_vss_m1\x7csb_vss\x7csr1_vss\x7csr2_vss\x7csr3_vss\x7csr4_vss\x7csv_vss\x7ctg_d_vss\x7ctg_fbm_vss\x7ctg_fbs_vss\x7ctg_s_vss\x7cvss\x7cvss_link\x7cvss_link_bridge\x7cvss_link_dip\x7cvss_link_m1\x7cvss_x1\x7cvss_x2\x7cvss_x3__t165
+ sky130_fd_pr__nfet_01v8 L=0.15 W=0.42 AS=0.1974 AD=0.1974 PS=1.78 PD=1.78
* device instance $61 r0 *1 283.61,0.21 nfet
X$61
+ a\x7cb\x7cd\x7cinvb_a\x7cmn12_g1\x7cmp24_g0\x7cro4\x7cro4_esc\x7csr4_d_stub\x7ctg_d_a\x7cy__t2
+ clkb\x7cclkb_bridge1\x7cclkb_bridge2\x7cclkb_mid\x7cclkb_w\x7cctrl\x7cctrlb\x7cinv_clk_y\x7ctg_d_ctrlb\x7ctg_fbm_ctrl\x7ctg_fbs_ctrlb\x7ctg_s_ctrl\x7cy__t26
+ a\x7cb\x7cm_east\x7cm_west\x7cnand_m_a\x7cnand_m_a_ext_via\x7cnand_m_a_ext_via2\x7cnand_m_a_stub\x7ctg_d_b\x7ctg_d_b_via\x7ctg_d_b_via2\x7ctg_fbm_b\x7ctg_fbm_b_alt_via\x7ctg_fbm_b_alt_via2__t16
+ g_vss_m1\x7cinv_clk_vss\x7cinv_mc_vss\x7cinv_q_vss\x7cmph_g\x7cnand_m_vss\x7cnand_s2_vss\x7cs1_vss_m1\x7cs2_vss_m1\x7cs3_vss_m1\x7cs4_vss_m1\x7csb_vss\x7csr1_vss\x7csr2_vss\x7csr3_vss\x7csr4_vss\x7csv_vss\x7ctg_d_vss\x7ctg_fbm_vss\x7ctg_fbs_vss\x7ctg_s_vss\x7cvss\x7cvss_link\x7cvss_link_bridge\x7cvss_link_dip\x7cvss_link_m1\x7cvss_x1\x7cvss_x2\x7cvss_x3__t166
+ sky130_fd_pr__nfet_01v8 L=0.15 W=0.42 AS=0.1974 AD=0.1974 PS=1.78 PD=1.78
* device instance $62 r0 *1 298.135,0.21 nfet
X$62 a\x7cinv_mc_y\x7cinv_mc_y_via\x7cmc\x7ctg_fbm_a\x7ctg_fbm_a_via\x7cy__t06
+ a\x7cinv_mc_a\x7cmb\x7cmnab_y\x7cmpa_y\x7cmpb_y\x7cnand_m_y\x7ctg_s_a\x7cy__t36
+ g_vss_m1\x7cinv_clk_vss\x7cinv_mc_vss\x7cinv_q_vss\x7cmph_g\x7cnand_m_vss\x7cnand_s2_vss\x7cs1_vss_m1\x7cs2_vss_m1\x7cs3_vss_m1\x7cs4_vss_m1\x7csb_vss\x7csr1_vss\x7csr2_vss\x7csr3_vss\x7csr4_vss\x7csv_vss\x7ctg_d_vss\x7ctg_fbm_vss\x7ctg_fbs_vss\x7ctg_s_vss\x7cvss\x7cvss_link\x7cvss_link_bridge\x7cvss_link_dip\x7cvss_link_m1\x7cvss_x1\x7cvss_x2\x7cvss_x3__t49
+ g_vss_m1\x7cinv_clk_vss\x7cinv_mc_vss\x7cinv_q_vss\x7cmph_g\x7cnand_m_vss\x7cnand_s2_vss\x7cs1_vss_m1\x7cs2_vss_m1\x7cs3_vss_m1\x7cs4_vss_m1\x7csb_vss\x7csr1_vss\x7csr2_vss\x7csr3_vss\x7csr4_vss\x7csv_vss\x7ctg_d_vss\x7ctg_fbm_vss\x7ctg_fbs_vss\x7ctg_s_vss\x7cvss\x7cvss_link\x7cvss_link_bridge\x7cvss_link_dip\x7cvss_link_m1\x7cvss_x1\x7cvss_x2\x7cvss_x3__t167
+ sky130_fd_pr__nfet_01v8 L=0.15 W=0.42 AS=0.1974 AD=0.1974 PS=1.78 PD=1.78
* device instance $63 r0 *1 302.9,0.21 nfet
X$63 a\x7cinv_mc_y\x7cinv_mc_y_via\x7cmc\x7ctg_fbm_a\x7ctg_fbm_a_via\x7cy__t16
+ a\x7cclk\x7cctrl\x7cctrlb\x7cinv_clk_a\x7cinv_clk_clk_via\x7ctg_d_ctrl\x7ctg_d_ctrl_via\x7ctg_fbm_ctrlb\x7ctg_fbm_ctrlb_via\x7ctg_fbs_ctrl\x7ctg_fbs_ctrl_via\x7ctg_s_ctrlb\x7ctg_s_ctrlb_via__t8
+ a\x7cb\x7cm_east\x7cm_west\x7cnand_m_a\x7cnand_m_a_ext_via\x7cnand_m_a_ext_via2\x7cnand_m_a_stub\x7ctg_d_b\x7ctg_d_b_via\x7ctg_d_b_via2\x7ctg_fbm_b\x7ctg_fbm_b_alt_via\x7ctg_fbm_b_alt_via2__t26
+ g_vss_m1\x7cinv_clk_vss\x7cinv_mc_vss\x7cinv_q_vss\x7cmph_g\x7cnand_m_vss\x7cnand_s2_vss\x7cs1_vss_m1\x7cs2_vss_m1\x7cs3_vss_m1\x7cs4_vss_m1\x7csb_vss\x7csr1_vss\x7csr2_vss\x7csr3_vss\x7csr4_vss\x7csv_vss\x7ctg_d_vss\x7ctg_fbm_vss\x7ctg_fbs_vss\x7ctg_s_vss\x7cvss\x7cvss_link\x7cvss_link_bridge\x7cvss_link_dip\x7cvss_link_m1\x7cvss_x1\x7cvss_x2\x7cvss_x3__t168
+ sky130_fd_pr__nfet_01v8 L=0.15 W=0.42 AS=0.1974 AD=0.1974 PS=1.78 PD=1.78
* device instance $64 r0 *1 308.04,0.21 nfet
X$64
+ a\x7cinv_mc_a\x7cmb\x7cmnab_y\x7cmpa_y\x7cmpb_y\x7cnand_m_y\x7ctg_s_a\x7cy__t06
+ a\x7cclk\x7cctrl\x7cctrlb\x7cinv_clk_a\x7cinv_clk_clk_via\x7ctg_d_ctrl\x7ctg_d_ctrl_via\x7ctg_fbm_ctrlb\x7ctg_fbm_ctrlb_via\x7ctg_fbs_ctrl\x7ctg_fbs_ctrl_via\x7ctg_s_ctrlb\x7ctg_s_ctrlb_via__t9
+ a\x7cb\x7cinv_q_a\x7cinv_q_a_via\x7cs\x7ctg_fbs_b\x7ctg_fbs_b_via\x7ctg_s_b\x7ctg_s_b_via__t26
+ g_vss_m1\x7cinv_clk_vss\x7cinv_mc_vss\x7cinv_q_vss\x7cmph_g\x7cnand_m_vss\x7cnand_s2_vss\x7cs1_vss_m1\x7cs2_vss_m1\x7cs3_vss_m1\x7cs4_vss_m1\x7csb_vss\x7csr1_vss\x7csr2_vss\x7csr3_vss\x7csr4_vss\x7csv_vss\x7ctg_d_vss\x7ctg_fbm_vss\x7ctg_fbs_vss\x7ctg_s_vss\x7cvss\x7cvss_link\x7cvss_link_bridge\x7cvss_link_dip\x7cvss_link_m1\x7cvss_x1\x7cvss_x2\x7cvss_x3__t169
+ sky130_fd_pr__nfet_01v8 L=0.15 W=0.42 AS=0.1974 AD=0.1974 PS=1.78 PD=1.78
* device instance $65 r0 *1 314.845,0.21 nfet
X$65
+ a\x7cinv_q_y\x7cinv_q_y_via\x7cinv_q_y_via2\x7cnand_s2_a\x7cnand_s2_a_stub\x7cnand_s2_a_via\x7cnand_s2_a_via2\x7cq\x7cy__t06
+ a\x7cb\x7cinv_q_a\x7cinv_q_a_via\x7cs\x7ctg_fbs_b\x7ctg_fbs_b_via\x7ctg_s_b\x7ctg_s_b_via__t06
+ g_vss_m1\x7cinv_clk_vss\x7cinv_mc_vss\x7cinv_q_vss\x7cmph_g\x7cnand_m_vss\x7cnand_s2_vss\x7cs1_vss_m1\x7cs2_vss_m1\x7cs3_vss_m1\x7cs4_vss_m1\x7csb_vss\x7csr1_vss\x7csr2_vss\x7csr3_vss\x7csr4_vss\x7csv_vss\x7ctg_d_vss\x7ctg_fbm_vss\x7ctg_fbs_vss\x7ctg_s_vss\x7cvss\x7cvss_link\x7cvss_link_bridge\x7cvss_link_dip\x7cvss_link_m1\x7cvss_x1\x7cvss_x2\x7cvss_x3__t50
+ g_vss_m1\x7cinv_clk_vss\x7cinv_mc_vss\x7cinv_q_vss\x7cmph_g\x7cnand_m_vss\x7cnand_s2_vss\x7cs1_vss_m1\x7cs2_vss_m1\x7cs3_vss_m1\x7cs4_vss_m1\x7csb_vss\x7csr1_vss\x7csr2_vss\x7csr3_vss\x7csr4_vss\x7csv_vss\x7ctg_d_vss\x7ctg_fbm_vss\x7ctg_fbs_vss\x7ctg_s_vss\x7cvss\x7cvss_link\x7cvss_link_bridge\x7cvss_link_dip\x7cvss_link_m1\x7cvss_x1\x7cvss_x2\x7cvss_x3__t170
+ sky130_fd_pr__nfet_01v8 L=0.15 W=0.42 AS=0.1974 AD=0.1974 PS=1.78 PD=1.78
* device instance $66 r0 *1 327.33,0.21 nfet
X$66 a\x7cmnab_y\x7cmpa_y\x7cmpb_y\x7cnand_s2_y\x7cqb\x7ctg_fbs_a\x7cy__t06
+ clkb\x7cclkb_bridge1\x7cclkb_bridge2\x7cclkb_mid\x7cclkb_w\x7cctrl\x7cctrlb\x7cinv_clk_y\x7ctg_d_ctrlb\x7ctg_fbm_ctrl\x7ctg_fbs_ctrlb\x7ctg_s_ctrl\x7cy__t36
+ a\x7cb\x7cinv_q_a\x7cinv_q_a_via\x7cs\x7ctg_fbs_b\x7ctg_fbs_b_via\x7ctg_s_b\x7ctg_s_b_via__t36
+ g_vss_m1\x7cinv_clk_vss\x7cinv_mc_vss\x7cinv_q_vss\x7cmph_g\x7cnand_m_vss\x7cnand_s2_vss\x7cs1_vss_m1\x7cs2_vss_m1\x7cs3_vss_m1\x7cs4_vss_m1\x7csb_vss\x7csr1_vss\x7csr2_vss\x7csr3_vss\x7csr4_vss\x7csv_vss\x7ctg_d_vss\x7ctg_fbm_vss\x7ctg_fbs_vss\x7ctg_s_vss\x7cvss\x7cvss_link\x7cvss_link_bridge\x7cvss_link_dip\x7cvss_link_m1\x7cvss_x1\x7cvss_x2\x7cvss_x3__t171
+ sky130_fd_pr__nfet_01v8 L=0.15 W=0.42 AS=0.1974 AD=0.1974 PS=1.78 PD=1.78
* device instance $67 r0 *1 3.61,23.845 nfet
X$67 ny__t0
+ g_vddr_m1\x7cmnt_g\x7cs1_vddr_m1\x7cs2_vddr_m1\x7cs3_vddr_m1\x7cs4_vddr_m1\x7cvddr\x7cvddr1__t0
+ g_vss_m1\x7cinv_clk_vss\x7cinv_mc_vss\x7cinv_q_vss\x7cmph_g\x7cnand_m_vss\x7cnand_s2_vss\x7cs1_vss_m1\x7cs2_vss_m1\x7cs3_vss_m1\x7cs4_vss_m1\x7csb_vss\x7csr1_vss\x7csr2_vss\x7csr3_vss\x7csr4_vss\x7csv_vss\x7ctg_d_vss\x7ctg_fbm_vss\x7ctg_fbs_vss\x7ctg_s_vss\x7cvss\x7cvss_link\x7cvss_link_bridge\x7cvss_link_dip\x7cvss_link_m1\x7cvss_x1\x7cvss_x2\x7cvss_x3__t2
+ g_vss_m1\x7cinv_clk_vss\x7cinv_mc_vss\x7cinv_q_vss\x7cmph_g\x7cnand_m_vss\x7cnand_s2_vss\x7cs1_vss_m1\x7cs2_vss_m1\x7cs3_vss_m1\x7cs4_vss_m1\x7csb_vss\x7csr1_vss\x7csr2_vss\x7csr3_vss\x7csr4_vss\x7csv_vss\x7ctg_d_vss\x7ctg_fbm_vss\x7ctg_fbs_vss\x7ctg_s_vss\x7cvss\x7cvss_link\x7cvss_link_bridge\x7cvss_link_dip\x7cvss_link_m1\x7cvss_x1\x7cvss_x2\x7cvss_x3__t198
+ sky130_fd_pr__nfet_01v8 L=2 W=0.42 AS=0.1764 AD=0.1764 PS=1.68 PD=1.68
* device instance $68 r0 *1 3.445,41.54 nfet
X$68 an\x7cinva_y\x7cmn34_g0\x7cmp13_g1\x7cy__t1
+ a\x7cd\x7cinva_a\x7cmn12_g0\x7cmp13_g0\x7cro1\x7cro1_esc\x7csr1_d_stub\x7ctg_d_a\x7cy__t5
+ g_vss_m1\x7cinv_clk_vss\x7cinv_mc_vss\x7cinv_q_vss\x7cmph_g\x7cnand_m_vss\x7cnand_s2_vss\x7cs1_vss_m1\x7cs2_vss_m1\x7cs3_vss_m1\x7cs4_vss_m1\x7csb_vss\x7csr1_vss\x7csr2_vss\x7csr3_vss\x7csr4_vss\x7csv_vss\x7ctg_d_vss\x7ctg_fbm_vss\x7ctg_fbs_vss\x7ctg_s_vss\x7cvss\x7cvss_link\x7cvss_link_bridge\x7cvss_link_dip\x7cvss_link_m1\x7cvss_x1\x7cvss_x2\x7cvss_x3__t64
+ g_vss_m1\x7cinv_clk_vss\x7cinv_mc_vss\x7cinv_q_vss\x7cmph_g\x7cnand_m_vss\x7cnand_s2_vss\x7cs1_vss_m1\x7cs2_vss_m1\x7cs3_vss_m1\x7cs4_vss_m1\x7csb_vss\x7csr1_vss\x7csr2_vss\x7csr3_vss\x7csr4_vss\x7csv_vss\x7ctg_d_vss\x7ctg_fbm_vss\x7ctg_fbs_vss\x7ctg_s_vss\x7cvss\x7cvss_link\x7cvss_link_bridge\x7cvss_link_dip\x7cvss_link_m1\x7cvss_x1\x7cvss_x2\x7cvss_x3__t192
+ sky130_fd_pr__nfet_01v8 L=0.15 W=0.42 AS=0.1974 AD=0.1974 PS=1.78 PD=1.78
* device instance $69 r0 *1 5.975,23.845 nfet
X$69 \$70__t0 en\x7cen1\x7cg_en__t1 ny__t1
+ g_vss_m1\x7cinv_clk_vss\x7cinv_mc_vss\x7cinv_q_vss\x7cmph_g\x7cnand_m_vss\x7cnand_s2_vss\x7cs1_vss_m1\x7cs2_vss_m1\x7cs3_vss_m1\x7cs4_vss_m1\x7csb_vss\x7csr1_vss\x7csr2_vss\x7csr3_vss\x7csr4_vss\x7csv_vss\x7ctg_d_vss\x7ctg_fbm_vss\x7ctg_fbs_vss\x7ctg_s_vss\x7cvss\x7cvss_link\x7cvss_link_bridge\x7cvss_link_dip\x7cvss_link_m1\x7cvss_x1\x7cvss_x2\x7cvss_x3__t98
+ sky130_fd_pr__nfet_01v8 L=0.15 W=0.84 AS=0.3948 AD=0.2184 PS=2.62 PD=1.36
* device instance $70 r0 *1 6.645,23.845 nfet
X$70 a\x7cg_y\x7cmnab_y\x7cmpa_y\x7cmpb_y\x7cn1\x7cs1_a\x7cy__t4
+ a\x7cg_a\x7crn1\x7cro\x7cs4_y\x7cy__t5 \$70__t1
+ g_vss_m1\x7cinv_clk_vss\x7cinv_mc_vss\x7cinv_q_vss\x7cmph_g\x7cnand_m_vss\x7cnand_s2_vss\x7cs1_vss_m1\x7cs2_vss_m1\x7cs3_vss_m1\x7cs4_vss_m1\x7csb_vss\x7csr1_vss\x7csr2_vss\x7csr3_vss\x7csr4_vss\x7csv_vss\x7ctg_d_vss\x7ctg_fbm_vss\x7ctg_fbs_vss\x7ctg_s_vss\x7cvss\x7cvss_link\x7cvss_link_bridge\x7cvss_link_dip\x7cvss_link_m1\x7cvss_x1\x7cvss_x2\x7cvss_x3__t120
+ sky130_fd_pr__nfet_01v8 L=0.15 W=0.84 AS=0.2184 AD=0.3948 PS=1.36 PD=2.62
* device instance $71 r0 *1 7.78,39.22 nfet
X$71 \$136__t0 an\x7cinva_y\x7cmn34_g0\x7cmp13_g1\x7cy__t3
+ a\x7cinva_a\x7cmn12_g0\x7cmp13_g0\x7ct1\x7cy__t6
+ g_vss_m1\x7cinv_clk_vss\x7cinv_mc_vss\x7cinv_q_vss\x7cmph_g\x7cnand_m_vss\x7cnand_s2_vss\x7cs1_vss_m1\x7cs2_vss_m1\x7cs3_vss_m1\x7cs4_vss_m1\x7csb_vss\x7csr1_vss\x7csr2_vss\x7csr3_vss\x7csr4_vss\x7csv_vss\x7ctg_d_vss\x7ctg_fbm_vss\x7ctg_fbs_vss\x7ctg_s_vss\x7cvss\x7cvss_link\x7cvss_link_bridge\x7cvss_link_dip\x7cvss_link_m1\x7cvss_x1\x7cvss_x2\x7cvss_x3__t102
+ sky130_fd_pr__nfet_01v8 L=0.15 W=0.84 AS=0.3948 AD=0.2184 PS=2.62 PD=1.36
* device instance $72 r0 *1 8.45,39.22 nfet
X$72
+ g_vss_m1\x7cinv_clk_vss\x7cinv_mc_vss\x7cinv_q_vss\x7cmph_g\x7cnand_m_vss\x7cnand_s2_vss\x7cs1_vss_m1\x7cs2_vss_m1\x7cs3_vss_m1\x7cs4_vss_m1\x7csb_vss\x7csr1_vss\x7csr2_vss\x7csr3_vss\x7csr4_vss\x7csv_vss\x7ctg_d_vss\x7ctg_fbm_vss\x7ctg_fbs_vss\x7ctg_s_vss\x7cvss\x7cvss_link\x7cvss_link_bridge\x7cvss_link_dip\x7cvss_link_m1\x7cvss_x1\x7cvss_x2\x7cvss_x3__t69
+ bn\x7cinvb_y\x7cmn34_g1\x7cmp24_g1\x7cy__t3 \$136__t1
+ g_vss_m1\x7cinv_clk_vss\x7cinv_mc_vss\x7cinv_q_vss\x7cmph_g\x7cnand_m_vss\x7cnand_s2_vss\x7cs1_vss_m1\x7cs2_vss_m1\x7cs3_vss_m1\x7cs4_vss_m1\x7csb_vss\x7csr1_vss\x7csr2_vss\x7csr3_vss\x7csr4_vss\x7csv_vss\x7ctg_d_vss\x7ctg_fbm_vss\x7ctg_fbs_vss\x7ctg_s_vss\x7cvss\x7cvss_link\x7cvss_link_bridge\x7cvss_link_dip\x7cvss_link_m1\x7cvss_x1\x7cvss_x2\x7cvss_x3__t124
+ sky130_fd_pr__nfet_01v8 L=0.15 W=0.84 AS=0.2184 AD=0.3948 PS=1.36 PD=2.62
* device instance $73 r0 *1 12.91,23.845 nfet
X$73 ny__t02
+ g_vddr_m1\x7cmnt_g\x7cs1_vddr_m1\x7cs2_vddr_m1\x7cs3_vddr_m1\x7cs4_vddr_m1\x7cvddr\x7cvddr1__t11
+ g_vss_m1\x7cinv_clk_vss\x7cinv_mc_vss\x7cinv_q_vss\x7cmph_g\x7cnand_m_vss\x7cnand_s2_vss\x7cs1_vss_m1\x7cs2_vss_m1\x7cs3_vss_m1\x7cs4_vss_m1\x7csb_vss\x7csr1_vss\x7csr2_vss\x7csr3_vss\x7csr4_vss\x7csv_vss\x7ctg_d_vss\x7ctg_fbm_vss\x7ctg_fbs_vss\x7ctg_s_vss\x7cvss\x7cvss_link\x7cvss_link_bridge\x7cvss_link_dip\x7cvss_link_m1\x7cvss_x1\x7cvss_x2\x7cvss_x3__t38
+ g_vss_m1\x7cinv_clk_vss\x7cinv_mc_vss\x7cinv_q_vss\x7cmph_g\x7cnand_m_vss\x7cnand_s2_vss\x7cs1_vss_m1\x7cs2_vss_m1\x7cs3_vss_m1\x7cs4_vss_m1\x7csb_vss\x7csr1_vss\x7csr2_vss\x7csr3_vss\x7csr4_vss\x7csv_vss\x7ctg_d_vss\x7ctg_fbm_vss\x7ctg_fbs_vss\x7ctg_s_vss\x7cvss\x7cvss_link\x7cvss_link_bridge\x7cvss_link_dip\x7cvss_link_m1\x7cvss_x1\x7cvss_x2\x7cvss_x3__t199
+ sky130_fd_pr__nfet_01v8 L=2 W=0.42 AS=0.1764 AD=0.1764 PS=1.68 PD=1.68
* device instance $74 r0 *1 14.78,39.22 nfet
X$74 \$138__t0
+ a\x7cd\x7cinva_a\x7cmn12_g0\x7cmp13_g0\x7cro1\x7cro1_esc\x7csr1_d_stub\x7ctg_d_a\x7cy__t7
+ a\x7cinva_a\x7cmn12_g0\x7cmp13_g0\x7ct1\x7cy__t7
+ g_vss_m1\x7cinv_clk_vss\x7cinv_mc_vss\x7cinv_q_vss\x7cmph_g\x7cnand_m_vss\x7cnand_s2_vss\x7cs1_vss_m1\x7cs2_vss_m1\x7cs3_vss_m1\x7cs4_vss_m1\x7csb_vss\x7csr1_vss\x7csr2_vss\x7csr3_vss\x7csr4_vss\x7csv_vss\x7ctg_d_vss\x7ctg_fbm_vss\x7ctg_fbs_vss\x7ctg_s_vss\x7cvss\x7cvss_link\x7cvss_link_bridge\x7cvss_link_dip\x7cvss_link_m1\x7cvss_x1\x7cvss_x2\x7cvss_x3__t103
+ sky130_fd_pr__nfet_01v8 L=0.15 W=0.84 AS=0.3948 AD=0.2184 PS=2.62 PD=1.36
* device instance $75 r0 *1 15.45,39.22 nfet
X$75
+ g_vss_m1\x7cinv_clk_vss\x7cinv_mc_vss\x7cinv_q_vss\x7cmph_g\x7cnand_m_vss\x7cnand_s2_vss\x7cs1_vss_m1\x7cs2_vss_m1\x7cs3_vss_m1\x7cs4_vss_m1\x7csb_vss\x7csr1_vss\x7csr2_vss\x7csr3_vss\x7csr4_vss\x7csv_vss\x7ctg_d_vss\x7ctg_fbm_vss\x7ctg_fbs_vss\x7ctg_s_vss\x7cvss\x7cvss_link\x7cvss_link_bridge\x7cvss_link_dip\x7cvss_link_m1\x7cvss_x1\x7cvss_x2\x7cvss_x3__t70
+ a\x7cb\x7cd\x7cinvb_a\x7cmn12_g1\x7cmp24_g0\x7cro2\x7cro2_esc\x7csr2_d_stub\x7ctg_d_a\x7cy__t7
+ \$138__t1
+ g_vss_m1\x7cinv_clk_vss\x7cinv_mc_vss\x7cinv_q_vss\x7cmph_g\x7cnand_m_vss\x7cnand_s2_vss\x7cs1_vss_m1\x7cs2_vss_m1\x7cs3_vss_m1\x7cs4_vss_m1\x7csb_vss\x7csr1_vss\x7csr2_vss\x7csr3_vss\x7csr4_vss\x7csv_vss\x7ctg_d_vss\x7ctg_fbm_vss\x7ctg_fbs_vss\x7ctg_s_vss\x7cvss\x7cvss_link\x7cvss_link_bridge\x7cvss_link_dip\x7cvss_link_m1\x7cvss_x1\x7cvss_x2\x7cvss_x3__t125
+ sky130_fd_pr__nfet_01v8 L=0.15 W=0.84 AS=0.2184 AD=0.3948 PS=1.36 PD=2.62
* device instance $76 r0 *1 15.275,23.845 nfet
X$76 a\x7cn2\x7cs1_y\x7cs2_a\x7cy__t0
+ a\x7cg_y\x7cmnab_y\x7cmpa_y\x7cmpb_y\x7cn1\x7cs1_a\x7cy__t1 ny__t12
+ g_vss_m1\x7cinv_clk_vss\x7cinv_mc_vss\x7cinv_q_vss\x7cmph_g\x7cnand_m_vss\x7cnand_s2_vss\x7cs1_vss_m1\x7cs2_vss_m1\x7cs3_vss_m1\x7cs4_vss_m1\x7csb_vss\x7csr1_vss\x7csr2_vss\x7csr3_vss\x7csr4_vss\x7csv_vss\x7ctg_d_vss\x7ctg_fbm_vss\x7ctg_fbs_vss\x7ctg_s_vss\x7cvss\x7cvss_link\x7cvss_link_bridge\x7cvss_link_dip\x7cvss_link_m1\x7cvss_x1\x7cvss_x2\x7cvss_x3__t172
+ sky130_fd_pr__nfet_01v8 L=0.15 W=0.42 AS=0.1974 AD=0.1974 PS=1.78 PD=1.78
* device instance $77 r0 *1 21.085,23.845 nfet
X$77 ny__t03
+ g_vddr_m1\x7cmnt_g\x7cs1_vddr_m1\x7cs2_vddr_m1\x7cs3_vddr_m1\x7cs4_vddr_m1\x7cvddr\x7cvddr1__t14
+ g_vss_m1\x7cinv_clk_vss\x7cinv_mc_vss\x7cinv_q_vss\x7cmph_g\x7cnand_m_vss\x7cnand_s2_vss\x7cs1_vss_m1\x7cs2_vss_m1\x7cs3_vss_m1\x7cs4_vss_m1\x7csb_vss\x7csr1_vss\x7csr2_vss\x7csr3_vss\x7csr4_vss\x7csv_vss\x7ctg_d_vss\x7ctg_fbm_vss\x7ctg_fbs_vss\x7ctg_s_vss\x7cvss\x7cvss_link\x7cvss_link_bridge\x7cvss_link_dip\x7cvss_link_m1\x7cvss_x1\x7cvss_x2\x7cvss_x3__t41
+ g_vss_m1\x7cinv_clk_vss\x7cinv_mc_vss\x7cinv_q_vss\x7cmph_g\x7cnand_m_vss\x7cnand_s2_vss\x7cs1_vss_m1\x7cs2_vss_m1\x7cs3_vss_m1\x7cs4_vss_m1\x7csb_vss\x7csr1_vss\x7csr2_vss\x7csr3_vss\x7csr4_vss\x7csv_vss\x7ctg_d_vss\x7ctg_fbm_vss\x7ctg_fbs_vss\x7ctg_s_vss\x7cvss\x7cvss_link\x7cvss_link_bridge\x7cvss_link_dip\x7cvss_link_m1\x7cvss_x1\x7cvss_x2\x7cvss_x3__t200
+ sky130_fd_pr__nfet_01v8 L=2 W=0.42 AS=0.1764 AD=0.1764 PS=1.68 PD=1.68
* device instance $78 r0 *1 21.62,41.54 nfet
X$78 bn\x7cinvb_y\x7cmn34_g1\x7cmp24_g1\x7cy__t1
+ a\x7cb\x7cd\x7cinvb_a\x7cmn12_g1\x7cmp24_g0\x7cro2\x7cro2_esc\x7csr2_d_stub\x7ctg_d_a\x7cy__t5
+ g_vss_m1\x7cinv_clk_vss\x7cinv_mc_vss\x7cinv_q_vss\x7cmph_g\x7cnand_m_vss\x7cnand_s2_vss\x7cs1_vss_m1\x7cs2_vss_m1\x7cs3_vss_m1\x7cs4_vss_m1\x7csb_vss\x7csr1_vss\x7csr2_vss\x7csr3_vss\x7csr4_vss\x7csv_vss\x7ctg_d_vss\x7ctg_fbm_vss\x7ctg_fbs_vss\x7ctg_s_vss\x7cvss\x7cvss_link\x7cvss_link_bridge\x7cvss_link_dip\x7cvss_link_m1\x7cvss_x1\x7cvss_x2\x7cvss_x3__t65
+ g_vss_m1\x7cinv_clk_vss\x7cinv_mc_vss\x7cinv_q_vss\x7cmph_g\x7cnand_m_vss\x7cnand_s2_vss\x7cs1_vss_m1\x7cs2_vss_m1\x7cs3_vss_m1\x7cs4_vss_m1\x7csb_vss\x7csr1_vss\x7csr2_vss\x7csr3_vss\x7csr4_vss\x7csv_vss\x7ctg_d_vss\x7ctg_fbm_vss\x7ctg_fbs_vss\x7ctg_s_vss\x7cvss\x7cvss_link\x7cvss_link_bridge\x7cvss_link_dip\x7cvss_link_m1\x7cvss_x1\x7cvss_x2\x7cvss_x3__t193
+ sky130_fd_pr__nfet_01v8 L=0.15 W=0.42 AS=0.1974 AD=0.1974 PS=1.78 PD=1.78
* device instance $79 r0 *1 23.45,23.845 nfet
X$79 a\x7cn3\x7cs2_y\x7cs3_a\x7cy__t0 a\x7cn2\x7cs1_y\x7cs2_a\x7cy__t2 ny__t13
+ g_vss_m1\x7cinv_clk_vss\x7cinv_mc_vss\x7cinv_q_vss\x7cmph_g\x7cnand_m_vss\x7cnand_s2_vss\x7cs1_vss_m1\x7cs2_vss_m1\x7cs3_vss_m1\x7cs4_vss_m1\x7csb_vss\x7csr1_vss\x7csr2_vss\x7csr3_vss\x7csr4_vss\x7csv_vss\x7ctg_d_vss\x7ctg_fbm_vss\x7ctg_fbs_vss\x7ctg_s_vss\x7cvss\x7cvss_link\x7cvss_link_bridge\x7cvss_link_dip\x7cvss_link_m1\x7cvss_x1\x7cvss_x2\x7cvss_x3__t173
+ sky130_fd_pr__nfet_01v8 L=0.15 W=0.42 AS=0.1974 AD=0.1974 PS=1.78 PD=1.78
* device instance $80 r0 *1 29.26,23.845 nfet
X$80 ny__t04
+ g_vddr_m1\x7cmnt_g\x7cs1_vddr_m1\x7cs2_vddr_m1\x7cs3_vddr_m1\x7cs4_vddr_m1\x7cvddr\x7cvddr1__t12
+ g_vss_m1\x7cinv_clk_vss\x7cinv_mc_vss\x7cinv_q_vss\x7cmph_g\x7cnand_m_vss\x7cnand_s2_vss\x7cs1_vss_m1\x7cs2_vss_m1\x7cs3_vss_m1\x7cs4_vss_m1\x7csb_vss\x7csr1_vss\x7csr2_vss\x7csr3_vss\x7csr4_vss\x7csv_vss\x7ctg_d_vss\x7ctg_fbm_vss\x7ctg_fbs_vss\x7ctg_s_vss\x7cvss\x7cvss_link\x7cvss_link_bridge\x7cvss_link_dip\x7cvss_link_m1\x7cvss_x1\x7cvss_x2\x7cvss_x3__t39
+ g_vss_m1\x7cinv_clk_vss\x7cinv_mc_vss\x7cinv_q_vss\x7cmph_g\x7cnand_m_vss\x7cnand_s2_vss\x7cs1_vss_m1\x7cs2_vss_m1\x7cs3_vss_m1\x7cs4_vss_m1\x7csb_vss\x7csr1_vss\x7csr2_vss\x7csr3_vss\x7csr4_vss\x7csv_vss\x7ctg_d_vss\x7ctg_fbm_vss\x7ctg_fbs_vss\x7ctg_s_vss\x7cvss\x7cvss_link\x7cvss_link_bridge\x7cvss_link_dip\x7cvss_link_m1\x7cvss_x1\x7cvss_x2\x7cvss_x3__t201
+ sky130_fd_pr__nfet_01v8 L=2 W=0.42 AS=0.1764 AD=0.1764 PS=1.68 PD=1.68
* device instance $81 r0 *1 31.625,23.845 nfet
X$81 a\x7cn4\x7cs3_y\x7cs4_a\x7cy__t0 a\x7cn3\x7cs2_y\x7cs3_a\x7cy__t2 ny__t14
+ g_vss_m1\x7cinv_clk_vss\x7cinv_mc_vss\x7cinv_q_vss\x7cmph_g\x7cnand_m_vss\x7cnand_s2_vss\x7cs1_vss_m1\x7cs2_vss_m1\x7cs3_vss_m1\x7cs4_vss_m1\x7csb_vss\x7csr1_vss\x7csr2_vss\x7csr3_vss\x7csr4_vss\x7csv_vss\x7ctg_d_vss\x7ctg_fbm_vss\x7ctg_fbs_vss\x7ctg_s_vss\x7cvss\x7cvss_link\x7cvss_link_bridge\x7cvss_link_dip\x7cvss_link_m1\x7cvss_x1\x7cvss_x2\x7cvss_x3__t174
+ sky130_fd_pr__nfet_01v8 L=0.15 W=0.42 AS=0.1974 AD=0.1974 PS=1.78 PD=1.78
* device instance $82 r0 *1 32.415,41.54 nfet
X$82 an\x7cinva_y\x7cmn34_g0\x7cmp13_g1\x7cy__t12
+ a\x7cd\x7cinva_a\x7cmn12_g0\x7cmp13_g0\x7cro3\x7cro3_esc_e\x7cro3_esc_w\x7cro3_hop\x7csr3_d_stub\x7ctg_d_a\x7cy__t5
+ g_vss_m1\x7cinv_clk_vss\x7cinv_mc_vss\x7cinv_q_vss\x7cmph_g\x7cnand_m_vss\x7cnand_s2_vss\x7cs1_vss_m1\x7cs2_vss_m1\x7cs3_vss_m1\x7cs4_vss_m1\x7csb_vss\x7csr1_vss\x7csr2_vss\x7csr3_vss\x7csr4_vss\x7csv_vss\x7ctg_d_vss\x7ctg_fbm_vss\x7ctg_fbs_vss\x7ctg_s_vss\x7cvss\x7cvss_link\x7cvss_link_bridge\x7cvss_link_dip\x7cvss_link_m1\x7cvss_x1\x7cvss_x2\x7cvss_x3__t67
+ g_vss_m1\x7cinv_clk_vss\x7cinv_mc_vss\x7cinv_q_vss\x7cmph_g\x7cnand_m_vss\x7cnand_s2_vss\x7cs1_vss_m1\x7cs2_vss_m1\x7cs3_vss_m1\x7cs4_vss_m1\x7csb_vss\x7csr1_vss\x7csr2_vss\x7csr3_vss\x7csr4_vss\x7csv_vss\x7ctg_d_vss\x7ctg_fbm_vss\x7ctg_fbs_vss\x7ctg_s_vss\x7cvss\x7cvss_link\x7cvss_link_bridge\x7cvss_link_dip\x7cvss_link_m1\x7cvss_x1\x7cvss_x2\x7cvss_x3__t194
+ sky130_fd_pr__nfet_01v8 L=0.15 W=0.42 AS=0.1974 AD=0.1974 PS=1.78 PD=1.78
* device instance $83 r0 *1 37.435,23.845 nfet
X$83 ny__t05
+ g_vddr_m1\x7cmnt_g\x7cs1_vddr_m1\x7cs2_vddr_m1\x7cs3_vddr_m1\x7cs4_vddr_m1\x7cvddr\x7cvddr1__t13
+ g_vss_m1\x7cinv_clk_vss\x7cinv_mc_vss\x7cinv_q_vss\x7cmph_g\x7cnand_m_vss\x7cnand_s2_vss\x7cs1_vss_m1\x7cs2_vss_m1\x7cs3_vss_m1\x7cs4_vss_m1\x7csb_vss\x7csr1_vss\x7csr2_vss\x7csr3_vss\x7csr4_vss\x7csv_vss\x7ctg_d_vss\x7ctg_fbm_vss\x7ctg_fbs_vss\x7ctg_s_vss\x7cvss\x7cvss_link\x7cvss_link_bridge\x7cvss_link_dip\x7cvss_link_m1\x7cvss_x1\x7cvss_x2\x7cvss_x3__t40
+ g_vss_m1\x7cinv_clk_vss\x7cinv_mc_vss\x7cinv_q_vss\x7cmph_g\x7cnand_m_vss\x7cnand_s2_vss\x7cs1_vss_m1\x7cs2_vss_m1\x7cs3_vss_m1\x7cs4_vss_m1\x7csb_vss\x7csr1_vss\x7csr2_vss\x7csr3_vss\x7csr4_vss\x7csv_vss\x7ctg_d_vss\x7ctg_fbm_vss\x7ctg_fbs_vss\x7ctg_s_vss\x7cvss\x7cvss_link\x7cvss_link_bridge\x7cvss_link_dip\x7cvss_link_m1\x7cvss_x1\x7cvss_x2\x7cvss_x3__t202
+ sky130_fd_pr__nfet_01v8 L=2 W=0.42 AS=0.1764 AD=0.1764 PS=1.68 PD=1.68
* device instance $84 r0 *1 36.75,39.22 nfet
X$84 \$139__t0 an\x7cinva_y\x7cmn34_g0\x7cmp13_g1\x7cy__t32
+ a\x7cb\x7cb3\x7cinvb_a\x7cmn12_g1\x7cmp24_g0\x7ct2\x7cy__t7
+ g_vss_m1\x7cinv_clk_vss\x7cinv_mc_vss\x7cinv_q_vss\x7cmph_g\x7cnand_m_vss\x7cnand_s2_vss\x7cs1_vss_m1\x7cs2_vss_m1\x7cs3_vss_m1\x7cs4_vss_m1\x7csb_vss\x7csr1_vss\x7csr2_vss\x7csr3_vss\x7csr4_vss\x7csv_vss\x7ctg_d_vss\x7ctg_fbm_vss\x7ctg_fbs_vss\x7ctg_s_vss\x7cvss\x7cvss_link\x7cvss_link_bridge\x7cvss_link_dip\x7cvss_link_m1\x7cvss_x1\x7cvss_x2\x7cvss_x3__t104
+ sky130_fd_pr__nfet_01v8 L=0.15 W=0.84 AS=0.3948 AD=0.2184 PS=2.62 PD=1.36
* device instance $85 r0 *1 37.42,39.22 nfet
X$85
+ g_vss_m1\x7cinv_clk_vss\x7cinv_mc_vss\x7cinv_q_vss\x7cmph_g\x7cnand_m_vss\x7cnand_s2_vss\x7cs1_vss_m1\x7cs2_vss_m1\x7cs3_vss_m1\x7cs4_vss_m1\x7csb_vss\x7csr1_vss\x7csr2_vss\x7csr3_vss\x7csr4_vss\x7csv_vss\x7ctg_d_vss\x7ctg_fbm_vss\x7ctg_fbs_vss\x7ctg_s_vss\x7cvss\x7cvss_link\x7cvss_link_bridge\x7cvss_link_dip\x7cvss_link_m1\x7cvss_x1\x7cvss_x2\x7cvss_x3__t74
+ bn\x7cinvb_y\x7cmn34_g1\x7cmp24_g1\x7cy__t32 \$139__t1
+ g_vss_m1\x7cinv_clk_vss\x7cinv_mc_vss\x7cinv_q_vss\x7cmph_g\x7cnand_m_vss\x7cnand_s2_vss\x7cs1_vss_m1\x7cs2_vss_m1\x7cs3_vss_m1\x7cs4_vss_m1\x7csb_vss\x7csr1_vss\x7csr2_vss\x7csr3_vss\x7csr4_vss\x7csv_vss\x7ctg_d_vss\x7ctg_fbm_vss\x7ctg_fbs_vss\x7ctg_s_vss\x7cvss\x7cvss_link\x7cvss_link_bridge\x7cvss_link_dip\x7cvss_link_m1\x7cvss_x1\x7cvss_x2\x7cvss_x3__t126
+ sky130_fd_pr__nfet_01v8 L=0.15 W=0.84 AS=0.2184 AD=0.3948 PS=1.36 PD=2.62
* device instance $86 r0 *1 39.8,23.845 nfet
X$86 a\x7cg_a\x7crn1\x7cro\x7cs4_y\x7cy__t0 a\x7cn4\x7cs3_y\x7cs4_a\x7cy__t2
+ ny__t15
+ g_vss_m1\x7cinv_clk_vss\x7cinv_mc_vss\x7cinv_q_vss\x7cmph_g\x7cnand_m_vss\x7cnand_s2_vss\x7cs1_vss_m1\x7cs2_vss_m1\x7cs3_vss_m1\x7cs4_vss_m1\x7csb_vss\x7csr1_vss\x7csr2_vss\x7csr3_vss\x7csr4_vss\x7csv_vss\x7ctg_d_vss\x7ctg_fbm_vss\x7ctg_fbs_vss\x7ctg_s_vss\x7cvss\x7cvss_link\x7cvss_link_bridge\x7cvss_link_dip\x7cvss_link_m1\x7cvss_x1\x7cvss_x2\x7cvss_x3__t175
+ sky130_fd_pr__nfet_01v8 L=0.15 W=0.42 AS=0.1974 AD=0.1974 PS=1.78 PD=1.78
* device instance $87 r0 *1 43.75,39.22 nfet
X$87 \$141__t0
+ a\x7cd\x7cinva_a\x7cmn12_g0\x7cmp13_g0\x7cro3\x7cro3_esc_e\x7cro3_esc_w\x7cro3_hop\x7csr3_d_stub\x7ctg_d_a\x7cy__t7
+ a\x7cb\x7cb3\x7cinvb_a\x7cmn12_g1\x7cmp24_g0\x7ct2\x7cy__t6
+ g_vss_m1\x7cinv_clk_vss\x7cinv_mc_vss\x7cinv_q_vss\x7cmph_g\x7cnand_m_vss\x7cnand_s2_vss\x7cs1_vss_m1\x7cs2_vss_m1\x7cs3_vss_m1\x7cs4_vss_m1\x7csb_vss\x7csr1_vss\x7csr2_vss\x7csr3_vss\x7csr4_vss\x7csv_vss\x7ctg_d_vss\x7ctg_fbm_vss\x7ctg_fbs_vss\x7ctg_s_vss\x7cvss\x7cvss_link\x7cvss_link_bridge\x7cvss_link_dip\x7cvss_link_m1\x7cvss_x1\x7cvss_x2\x7cvss_x3__t105
+ sky130_fd_pr__nfet_01v8 L=0.15 W=0.84 AS=0.3948 AD=0.2184 PS=2.62 PD=1.36
* device instance $88 r0 *1 44.42,39.22 nfet
X$88
+ g_vss_m1\x7cinv_clk_vss\x7cinv_mc_vss\x7cinv_q_vss\x7cmph_g\x7cnand_m_vss\x7cnand_s2_vss\x7cs1_vss_m1\x7cs2_vss_m1\x7cs3_vss_m1\x7cs4_vss_m1\x7csb_vss\x7csr1_vss\x7csr2_vss\x7csr3_vss\x7csr4_vss\x7csv_vss\x7ctg_d_vss\x7ctg_fbm_vss\x7ctg_fbs_vss\x7ctg_s_vss\x7cvss\x7cvss_link\x7cvss_link_bridge\x7cvss_link_dip\x7cvss_link_m1\x7cvss_x1\x7cvss_x2\x7cvss_x3__t73
+ a\x7cb\x7cd\x7cinvb_a\x7cmn12_g1\x7cmp24_g0\x7cro4\x7cro4_esc\x7csr4_d_stub\x7ctg_d_a\x7cy__t7
+ \$141__t1
+ g_vss_m1\x7cinv_clk_vss\x7cinv_mc_vss\x7cinv_q_vss\x7cmph_g\x7cnand_m_vss\x7cnand_s2_vss\x7cs1_vss_m1\x7cs2_vss_m1\x7cs3_vss_m1\x7cs4_vss_m1\x7csb_vss\x7csr1_vss\x7csr2_vss\x7csr3_vss\x7csr4_vss\x7csv_vss\x7ctg_d_vss\x7ctg_fbm_vss\x7ctg_fbs_vss\x7ctg_s_vss\x7cvss\x7cvss_link\x7cvss_link_bridge\x7cvss_link_dip\x7cvss_link_m1\x7cvss_x1\x7cvss_x2\x7cvss_x3__t127
+ sky130_fd_pr__nfet_01v8 L=0.15 W=0.84 AS=0.2184 AD=0.3948 PS=1.36 PD=2.62
* device instance $89 r0 *1 48.86,23.845 nfet
X$89
+ a\x7cd\x7cinva_a\x7cmn12_g0\x7cmp13_g0\x7cro1\x7cro1_esc\x7csr1_d_stub\x7ctg_d_a\x7cy__t1
+ a\x7cg_a\x7crn1\x7cro\x7cs4_y\x7cy__t2
+ g_vss_m1\x7cinv_clk_vss\x7cinv_mc_vss\x7cinv_q_vss\x7cmph_g\x7cnand_m_vss\x7cnand_s2_vss\x7cs1_vss_m1\x7cs2_vss_m1\x7cs3_vss_m1\x7cs4_vss_m1\x7csb_vss\x7csr1_vss\x7csr2_vss\x7csr3_vss\x7csr4_vss\x7csv_vss\x7ctg_d_vss\x7ctg_fbm_vss\x7ctg_fbs_vss\x7ctg_s_vss\x7cvss\x7cvss_link\x7cvss_link_bridge\x7cvss_link_dip\x7cvss_link_m1\x7cvss_x1\x7cvss_x2\x7cvss_x3__t59
+ g_vss_m1\x7cinv_clk_vss\x7cinv_mc_vss\x7cinv_q_vss\x7cmph_g\x7cnand_m_vss\x7cnand_s2_vss\x7cs1_vss_m1\x7cs2_vss_m1\x7cs3_vss_m1\x7cs4_vss_m1\x7csb_vss\x7csr1_vss\x7csr2_vss\x7csr3_vss\x7csr4_vss\x7csv_vss\x7ctg_d_vss\x7ctg_fbm_vss\x7ctg_fbs_vss\x7ctg_s_vss\x7cvss\x7cvss_link\x7cvss_link_bridge\x7cvss_link_dip\x7cvss_link_m1\x7cvss_x1\x7cvss_x2\x7cvss_x3__t176
+ sky130_fd_pr__nfet_01v8 L=0.15 W=0.42 AS=0.1974 AD=0.1974 PS=1.78 PD=1.78
* device instance $90 r0 *1 50.59,41.54 nfet
X$90 bn\x7cinvb_y\x7cmn34_g1\x7cmp24_g1\x7cy__t12
+ a\x7cb\x7cd\x7cinvb_a\x7cmn12_g1\x7cmp24_g0\x7cro4\x7cro4_esc\x7csr4_d_stub\x7ctg_d_a\x7cy__t5
+ g_vss_m1\x7cinv_clk_vss\x7cinv_mc_vss\x7cinv_q_vss\x7cmph_g\x7cnand_m_vss\x7cnand_s2_vss\x7cs1_vss_m1\x7cs2_vss_m1\x7cs3_vss_m1\x7cs4_vss_m1\x7csb_vss\x7csr1_vss\x7csr2_vss\x7csr3_vss\x7csr4_vss\x7csv_vss\x7ctg_d_vss\x7ctg_fbm_vss\x7ctg_fbs_vss\x7ctg_s_vss\x7cvss\x7cvss_link\x7cvss_link_bridge\x7cvss_link_dip\x7cvss_link_m1\x7cvss_x1\x7cvss_x2\x7cvss_x3__t68
+ g_vss_m1\x7cinv_clk_vss\x7cinv_mc_vss\x7cinv_q_vss\x7cmph_g\x7cnand_m_vss\x7cnand_s2_vss\x7cs1_vss_m1\x7cs2_vss_m1\x7cs3_vss_m1\x7cs4_vss_m1\x7csb_vss\x7csr1_vss\x7csr2_vss\x7csr3_vss\x7csr4_vss\x7csv_vss\x7ctg_d_vss\x7ctg_fbm_vss\x7ctg_fbs_vss\x7ctg_s_vss\x7cvss\x7cvss_link\x7cvss_link_bridge\x7cvss_link_dip\x7cvss_link_m1\x7cvss_x1\x7cvss_x2\x7cvss_x3__t195
+ sky130_fd_pr__nfet_01v8 L=0.15 W=0.42 AS=0.1974 AD=0.1974 PS=1.78 PD=1.78
* device instance $91 r0 *1 58.91,23.845 nfet
X$91 ny__t06
+ g_vddr_m1\x7cmnt_g\x7cs1_vddr_m1\x7cs2_vddr_m1\x7cs3_vddr_m1\x7cs4_vddr_m1\x7cvddr\x7cvddr2__t0
+ g_vss_m1\x7cinv_clk_vss\x7cinv_mc_vss\x7cinv_q_vss\x7cmph_g\x7cnand_m_vss\x7cnand_s2_vss\x7cs1_vss_m1\x7cs2_vss_m1\x7cs3_vss_m1\x7cs4_vss_m1\x7csb_vss\x7csr1_vss\x7csr2_vss\x7csr3_vss\x7csr4_vss\x7csv_vss\x7ctg_d_vss\x7ctg_fbm_vss\x7ctg_fbs_vss\x7ctg_s_vss\x7cvss\x7cvss_link\x7cvss_link_bridge\x7cvss_link_dip\x7cvss_link_m1\x7cvss_x1\x7cvss_x2\x7cvss_x3__t3
+ g_vss_m1\x7cinv_clk_vss\x7cinv_mc_vss\x7cinv_q_vss\x7cmph_g\x7cnand_m_vss\x7cnand_s2_vss\x7cs1_vss_m1\x7cs2_vss_m1\x7cs3_vss_m1\x7cs4_vss_m1\x7csb_vss\x7csr1_vss\x7csr2_vss\x7csr3_vss\x7csr4_vss\x7csv_vss\x7ctg_d_vss\x7ctg_fbm_vss\x7ctg_fbs_vss\x7ctg_s_vss\x7cvss\x7cvss_link\x7cvss_link_bridge\x7cvss_link_dip\x7cvss_link_m1\x7cvss_x1\x7cvss_x2\x7cvss_x3__t203
+ sky130_fd_pr__nfet_01v8 L=2 W=0.44 AS=0.1848 AD=0.1848 PS=1.72 PD=1.72
* device instance $92 r0 *1 61.275,23.845 nfet
X$92 \$78__t0 en\x7cen2\x7cg_en__t1 ny__t16
+ g_vss_m1\x7cinv_clk_vss\x7cinv_mc_vss\x7cinv_q_vss\x7cmph_g\x7cnand_m_vss\x7cnand_s2_vss\x7cs1_vss_m1\x7cs2_vss_m1\x7cs3_vss_m1\x7cs4_vss_m1\x7csb_vss\x7csr1_vss\x7csr2_vss\x7csr3_vss\x7csr4_vss\x7csv_vss\x7ctg_d_vss\x7ctg_fbm_vss\x7ctg_fbs_vss\x7ctg_s_vss\x7cvss\x7cvss_link\x7cvss_link_bridge\x7cvss_link_dip\x7cvss_link_m1\x7cvss_x1\x7cvss_x2\x7cvss_x3__t99
+ sky130_fd_pr__nfet_01v8 L=0.15 W=0.84 AS=0.3948 AD=0.2184 PS=2.62 PD=1.36
* device instance $93 r0 *1 61.945,23.845 nfet
X$93 a\x7cg_y\x7cmnab_y\x7cmpa_y\x7cmpb_y\x7cn1\x7cs1_a\x7cy__t42
+ a\x7cg_a\x7crn2\x7cro\x7cs4_y\x7cy__t5 \$78__t1
+ g_vss_m1\x7cinv_clk_vss\x7cinv_mc_vss\x7cinv_q_vss\x7cmph_g\x7cnand_m_vss\x7cnand_s2_vss\x7cs1_vss_m1\x7cs2_vss_m1\x7cs3_vss_m1\x7cs4_vss_m1\x7csb_vss\x7csr1_vss\x7csr2_vss\x7csr3_vss\x7csr4_vss\x7csv_vss\x7ctg_d_vss\x7ctg_fbm_vss\x7ctg_fbs_vss\x7ctg_s_vss\x7cvss\x7cvss_link\x7cvss_link_bridge\x7cvss_link_dip\x7cvss_link_m1\x7cvss_x1\x7cvss_x2\x7cvss_x3__t121
+ sky130_fd_pr__nfet_01v8 L=0.15 W=0.84 AS=0.2184 AD=0.3948 PS=1.36 PD=2.62
* device instance $94 r0 *1 61.385,41.54 nfet
X$94 an\x7cinva_y\x7cmn34_g0\x7cmp13_g1\x7cy__t13
+ a\x7cinva_a\x7cmn12_g0\x7cmp13_g0\x7ct1\x7cy__t3
+ g_vss_m1\x7cinv_clk_vss\x7cinv_mc_vss\x7cinv_q_vss\x7cmph_g\x7cnand_m_vss\x7cnand_s2_vss\x7cs1_vss_m1\x7cs2_vss_m1\x7cs3_vss_m1\x7cs4_vss_m1\x7csb_vss\x7csr1_vss\x7csr2_vss\x7csr3_vss\x7csr4_vss\x7csv_vss\x7ctg_d_vss\x7ctg_fbm_vss\x7ctg_fbs_vss\x7ctg_s_vss\x7cvss\x7cvss_link\x7cvss_link_bridge\x7cvss_link_dip\x7cvss_link_m1\x7cvss_x1\x7cvss_x2\x7cvss_x3__t62
+ g_vss_m1\x7cinv_clk_vss\x7cinv_mc_vss\x7cinv_q_vss\x7cmph_g\x7cnand_m_vss\x7cnand_s2_vss\x7cs1_vss_m1\x7cs2_vss_m1\x7cs3_vss_m1\x7cs4_vss_m1\x7csb_vss\x7csr1_vss\x7csr2_vss\x7csr3_vss\x7csr4_vss\x7csv_vss\x7ctg_d_vss\x7ctg_fbm_vss\x7ctg_fbs_vss\x7ctg_s_vss\x7cvss\x7cvss_link\x7cvss_link_bridge\x7cvss_link_dip\x7cvss_link_m1\x7cvss_x1\x7cvss_x2\x7cvss_x3__t196
+ sky130_fd_pr__nfet_01v8 L=0.15 W=0.42 AS=0.1974 AD=0.1974 PS=1.78 PD=1.78
* device instance $95 r0 *1 65.72,39.22 nfet
X$95 \$143__t0 an\x7cinva_y\x7cmn34_g0\x7cmp13_g1\x7cy__t33
+ a\x7cd\x7csb_d_stub\x7ctg_d_a\x7cxo\x7cxo_dip\x7cxo_hop\x7cxo_stub\x7cy__t5
+ g_vss_m1\x7cinv_clk_vss\x7cinv_mc_vss\x7cinv_q_vss\x7cmph_g\x7cnand_m_vss\x7cnand_s2_vss\x7cs1_vss_m1\x7cs2_vss_m1\x7cs3_vss_m1\x7cs4_vss_m1\x7csb_vss\x7csr1_vss\x7csr2_vss\x7csr3_vss\x7csr4_vss\x7csv_vss\x7ctg_d_vss\x7ctg_fbm_vss\x7ctg_fbs_vss\x7ctg_s_vss\x7cvss\x7cvss_link\x7cvss_link_bridge\x7cvss_link_dip\x7cvss_link_m1\x7cvss_x1\x7cvss_x2\x7cvss_x3__t106
+ sky130_fd_pr__nfet_01v8 L=0.15 W=0.84 AS=0.3948 AD=0.2184 PS=2.62 PD=1.36
* device instance $96 r0 *1 66.39,39.22 nfet
X$96
+ g_vss_m1\x7cinv_clk_vss\x7cinv_mc_vss\x7cinv_q_vss\x7cmph_g\x7cnand_m_vss\x7cnand_s2_vss\x7cs1_vss_m1\x7cs2_vss_m1\x7cs3_vss_m1\x7cs4_vss_m1\x7csb_vss\x7csr1_vss\x7csr2_vss\x7csr3_vss\x7csr4_vss\x7csv_vss\x7ctg_d_vss\x7ctg_fbm_vss\x7ctg_fbs_vss\x7ctg_s_vss\x7cvss\x7cvss_link\x7cvss_link_bridge\x7cvss_link_dip\x7cvss_link_m1\x7cvss_x1\x7cvss_x2\x7cvss_x3__t71
+ bn\x7cinvb_y\x7cmn34_g1\x7cmp24_g1\x7cy__t33 \$143__t1
+ g_vss_m1\x7cinv_clk_vss\x7cinv_mc_vss\x7cinv_q_vss\x7cmph_g\x7cnand_m_vss\x7cnand_s2_vss\x7cs1_vss_m1\x7cs2_vss_m1\x7cs3_vss_m1\x7cs4_vss_m1\x7csb_vss\x7csr1_vss\x7csr2_vss\x7csr3_vss\x7csr4_vss\x7csv_vss\x7ctg_d_vss\x7ctg_fbm_vss\x7ctg_fbs_vss\x7ctg_s_vss\x7cvss\x7cvss_link\x7cvss_link_bridge\x7cvss_link_dip\x7cvss_link_m1\x7cvss_x1\x7cvss_x2\x7cvss_x3__t128
+ sky130_fd_pr__nfet_01v8 L=0.15 W=0.84 AS=0.2184 AD=0.3948 PS=1.36 PD=2.62
* device instance $97 r0 *1 68.21,23.845 nfet
X$97 ny__t07
+ g_vddr_m1\x7cmnt_g\x7cs1_vddr_m1\x7cs2_vddr_m1\x7cs3_vddr_m1\x7cs4_vddr_m1\x7cvddr\x7cvddr2__t14
+ g_vss_m1\x7cinv_clk_vss\x7cinv_mc_vss\x7cinv_q_vss\x7cmph_g\x7cnand_m_vss\x7cnand_s2_vss\x7cs1_vss_m1\x7cs2_vss_m1\x7cs3_vss_m1\x7cs4_vss_m1\x7csb_vss\x7csr1_vss\x7csr2_vss\x7csr3_vss\x7csr4_vss\x7csv_vss\x7ctg_d_vss\x7ctg_fbm_vss\x7ctg_fbs_vss\x7ctg_s_vss\x7cvss\x7cvss_link\x7cvss_link_bridge\x7cvss_link_dip\x7cvss_link_m1\x7cvss_x1\x7cvss_x2\x7cvss_x3__t37
+ g_vss_m1\x7cinv_clk_vss\x7cinv_mc_vss\x7cinv_q_vss\x7cmph_g\x7cnand_m_vss\x7cnand_s2_vss\x7cs1_vss_m1\x7cs2_vss_m1\x7cs3_vss_m1\x7cs4_vss_m1\x7csb_vss\x7csr1_vss\x7csr2_vss\x7csr3_vss\x7csr4_vss\x7csv_vss\x7ctg_d_vss\x7ctg_fbm_vss\x7ctg_fbs_vss\x7ctg_s_vss\x7cvss\x7cvss_link\x7cvss_link_bridge\x7cvss_link_dip\x7cvss_link_m1\x7cvss_x1\x7cvss_x2\x7cvss_x3__t204
+ sky130_fd_pr__nfet_01v8 L=2 W=0.44 AS=0.1848 AD=0.1848 PS=1.72 PD=1.72
* device instance $98 r0 *1 70.575,23.845 nfet
X$98 a\x7cn2\x7cs1_y\x7cs2_a\x7cy__t02
+ a\x7cg_y\x7cmnab_y\x7cmpa_y\x7cmpb_y\x7cn1\x7cs1_a\x7cy__t12 ny__t17
+ g_vss_m1\x7cinv_clk_vss\x7cinv_mc_vss\x7cinv_q_vss\x7cmph_g\x7cnand_m_vss\x7cnand_s2_vss\x7cs1_vss_m1\x7cs2_vss_m1\x7cs3_vss_m1\x7cs4_vss_m1\x7csb_vss\x7csr1_vss\x7csr2_vss\x7csr3_vss\x7csr4_vss\x7csv_vss\x7ctg_d_vss\x7ctg_fbm_vss\x7ctg_fbs_vss\x7ctg_s_vss\x7cvss\x7cvss_link\x7cvss_link_bridge\x7cvss_link_dip\x7cvss_link_m1\x7cvss_x1\x7cvss_x2\x7cvss_x3__t177
+ sky130_fd_pr__nfet_01v8 L=0.15 W=0.42 AS=0.1974 AD=0.1974 PS=1.78 PD=1.78
* device instance $99 r0 *1 72.72,39.22 nfet
X$99 \$145__t0 a\x7cinva_a\x7cmn12_g0\x7cmp13_g0\x7ct1\x7cy__t5
+ a\x7cd\x7csb_d_stub\x7ctg_d_a\x7cxo\x7cxo_dip\x7cxo_hop\x7cxo_stub\x7cy__t4
+ g_vss_m1\x7cinv_clk_vss\x7cinv_mc_vss\x7cinv_q_vss\x7cmph_g\x7cnand_m_vss\x7cnand_s2_vss\x7cs1_vss_m1\x7cs2_vss_m1\x7cs3_vss_m1\x7cs4_vss_m1\x7csb_vss\x7csr1_vss\x7csr2_vss\x7csr3_vss\x7csr4_vss\x7csv_vss\x7ctg_d_vss\x7ctg_fbm_vss\x7ctg_fbs_vss\x7ctg_s_vss\x7cvss\x7cvss_link\x7cvss_link_bridge\x7cvss_link_dip\x7cvss_link_m1\x7cvss_x1\x7cvss_x2\x7cvss_x3__t107
+ sky130_fd_pr__nfet_01v8 L=0.15 W=0.84 AS=0.3948 AD=0.2184 PS=2.62 PD=1.36
* device instance $100 r0 *1 73.39,39.22 nfet
X$100
+ g_vss_m1\x7cinv_clk_vss\x7cinv_mc_vss\x7cinv_q_vss\x7cmph_g\x7cnand_m_vss\x7cnand_s2_vss\x7cs1_vss_m1\x7cs2_vss_m1\x7cs3_vss_m1\x7cs4_vss_m1\x7csb_vss\x7csr1_vss\x7csr2_vss\x7csr3_vss\x7csr4_vss\x7csv_vss\x7ctg_d_vss\x7ctg_fbm_vss\x7ctg_fbs_vss\x7ctg_s_vss\x7cvss\x7cvss_link\x7cvss_link_bridge\x7cvss_link_dip\x7cvss_link_m1\x7cvss_x1\x7cvss_x2\x7cvss_x3__t72
+ a\x7cb\x7cb3\x7cinvb_a\x7cmn12_g1\x7cmp24_g0\x7ct2\x7cy__t5 \$145__t1
+ g_vss_m1\x7cinv_clk_vss\x7cinv_mc_vss\x7cinv_q_vss\x7cmph_g\x7cnand_m_vss\x7cnand_s2_vss\x7cs1_vss_m1\x7cs2_vss_m1\x7cs3_vss_m1\x7cs4_vss_m1\x7csb_vss\x7csr1_vss\x7csr2_vss\x7csr3_vss\x7csr4_vss\x7csv_vss\x7ctg_d_vss\x7ctg_fbm_vss\x7ctg_fbs_vss\x7ctg_s_vss\x7cvss\x7cvss_link\x7cvss_link_bridge\x7cvss_link_dip\x7cvss_link_m1\x7cvss_x1\x7cvss_x2\x7cvss_x3__t129
+ sky130_fd_pr__nfet_01v8 L=0.15 W=0.84 AS=0.2184 AD=0.3948 PS=1.36 PD=2.62
* device instance $101 r0 *1 76.385,23.845 nfet
X$101 ny__t08
+ g_vddr_m1\x7cmnt_g\x7cs1_vddr_m1\x7cs2_vddr_m1\x7cs3_vddr_m1\x7cs4_vddr_m1\x7cvddr\x7cvddr2__t11
+ g_vss_m1\x7cinv_clk_vss\x7cinv_mc_vss\x7cinv_q_vss\x7cmph_g\x7cnand_m_vss\x7cnand_s2_vss\x7cs1_vss_m1\x7cs2_vss_m1\x7cs3_vss_m1\x7cs4_vss_m1\x7csb_vss\x7csr1_vss\x7csr2_vss\x7csr3_vss\x7csr4_vss\x7csv_vss\x7ctg_d_vss\x7ctg_fbm_vss\x7ctg_fbs_vss\x7ctg_s_vss\x7cvss\x7cvss_link\x7cvss_link_bridge\x7cvss_link_dip\x7cvss_link_m1\x7cvss_x1\x7cvss_x2\x7cvss_x3__t34
+ g_vss_m1\x7cinv_clk_vss\x7cinv_mc_vss\x7cinv_q_vss\x7cmph_g\x7cnand_m_vss\x7cnand_s2_vss\x7cs1_vss_m1\x7cs2_vss_m1\x7cs3_vss_m1\x7cs4_vss_m1\x7csb_vss\x7csr1_vss\x7csr2_vss\x7csr3_vss\x7csr4_vss\x7csv_vss\x7ctg_d_vss\x7ctg_fbm_vss\x7ctg_fbs_vss\x7ctg_s_vss\x7cvss\x7cvss_link\x7cvss_link_bridge\x7cvss_link_dip\x7cvss_link_m1\x7cvss_x1\x7cvss_x2\x7cvss_x3__t205
+ sky130_fd_pr__nfet_01v8 L=2 W=0.44 AS=0.1848 AD=0.1848 PS=1.72 PD=1.72
* device instance $102 r0 *1 78.75,23.845 nfet
X$102 a\x7cn3\x7cs2_y\x7cs3_a\x7cy__t02 a\x7cn2\x7cs1_y\x7cs2_a\x7cy__t22
+ ny__t18
+ g_vss_m1\x7cinv_clk_vss\x7cinv_mc_vss\x7cinv_q_vss\x7cmph_g\x7cnand_m_vss\x7cnand_s2_vss\x7cs1_vss_m1\x7cs2_vss_m1\x7cs3_vss_m1\x7cs4_vss_m1\x7csb_vss\x7csr1_vss\x7csr2_vss\x7csr3_vss\x7csr4_vss\x7csv_vss\x7ctg_d_vss\x7ctg_fbm_vss\x7ctg_fbs_vss\x7ctg_s_vss\x7cvss\x7cvss_link\x7cvss_link_bridge\x7cvss_link_dip\x7cvss_link_m1\x7cvss_x1\x7cvss_x2\x7cvss_x3__t178
+ sky130_fd_pr__nfet_01v8 L=0.15 W=0.42 AS=0.1974 AD=0.1974 PS=1.78 PD=1.78
* device instance $103 r0 *1 79.56,41.54 nfet
X$103 bn\x7cinvb_y\x7cmn34_g1\x7cmp24_g1\x7cy__t13
+ a\x7cb\x7cb3\x7cinvb_a\x7cmn12_g1\x7cmp24_g0\x7ct2\x7cy__t3
+ g_vss_m1\x7cinv_clk_vss\x7cinv_mc_vss\x7cinv_q_vss\x7cmph_g\x7cnand_m_vss\x7cnand_s2_vss\x7cs1_vss_m1\x7cs2_vss_m1\x7cs3_vss_m1\x7cs4_vss_m1\x7csb_vss\x7csr1_vss\x7csr2_vss\x7csr3_vss\x7csr4_vss\x7csv_vss\x7ctg_d_vss\x7ctg_fbm_vss\x7ctg_fbs_vss\x7ctg_s_vss\x7cvss\x7cvss_link\x7cvss_link_bridge\x7cvss_link_dip\x7cvss_link_m1\x7cvss_x1\x7cvss_x2\x7cvss_x3__t63
+ g_vss_m1\x7cinv_clk_vss\x7cinv_mc_vss\x7cinv_q_vss\x7cmph_g\x7cnand_m_vss\x7cnand_s2_vss\x7cs1_vss_m1\x7cs2_vss_m1\x7cs3_vss_m1\x7cs4_vss_m1\x7csb_vss\x7csr1_vss\x7csr2_vss\x7csr3_vss\x7csr4_vss\x7csv_vss\x7ctg_d_vss\x7ctg_fbm_vss\x7ctg_fbs_vss\x7ctg_s_vss\x7cvss\x7cvss_link\x7cvss_link_bridge\x7cvss_link_dip\x7cvss_link_m1\x7cvss_x1\x7cvss_x2\x7cvss_x3__t197
+ sky130_fd_pr__nfet_01v8 L=0.15 W=0.42 AS=0.1974 AD=0.1974 PS=1.78 PD=1.78
* device instance $104 r0 *1 84.56,23.845 nfet
X$104 ny__t09
+ g_vddr_m1\x7cmnt_g\x7cs1_vddr_m1\x7cs2_vddr_m1\x7cs3_vddr_m1\x7cs4_vddr_m1\x7cvddr\x7cvddr2__t13
+ g_vss_m1\x7cinv_clk_vss\x7cinv_mc_vss\x7cinv_q_vss\x7cmph_g\x7cnand_m_vss\x7cnand_s2_vss\x7cs1_vss_m1\x7cs2_vss_m1\x7cs3_vss_m1\x7cs4_vss_m1\x7csb_vss\x7csr1_vss\x7csr2_vss\x7csr3_vss\x7csr4_vss\x7csv_vss\x7ctg_d_vss\x7ctg_fbm_vss\x7ctg_fbs_vss\x7ctg_s_vss\x7cvss\x7cvss_link\x7cvss_link_bridge\x7cvss_link_dip\x7cvss_link_m1\x7cvss_x1\x7cvss_x2\x7cvss_x3__t36
+ g_vss_m1\x7cinv_clk_vss\x7cinv_mc_vss\x7cinv_q_vss\x7cmph_g\x7cnand_m_vss\x7cnand_s2_vss\x7cs1_vss_m1\x7cs2_vss_m1\x7cs3_vss_m1\x7cs4_vss_m1\x7csb_vss\x7csr1_vss\x7csr2_vss\x7csr3_vss\x7csr4_vss\x7csv_vss\x7ctg_d_vss\x7ctg_fbm_vss\x7ctg_fbs_vss\x7ctg_s_vss\x7cvss\x7cvss_link\x7cvss_link_bridge\x7cvss_link_dip\x7cvss_link_m1\x7cvss_x1\x7cvss_x2\x7cvss_x3__t206
+ sky130_fd_pr__nfet_01v8 L=2 W=0.44 AS=0.1848 AD=0.1848 PS=1.72 PD=1.72
* device instance $105 r0 *1 86.925,23.845 nfet
X$105 a\x7cn4\x7cs3_y\x7cs4_a\x7cy__t03 a\x7cn3\x7cs2_y\x7cs3_a\x7cy__t22
+ ny__t19
+ g_vss_m1\x7cinv_clk_vss\x7cinv_mc_vss\x7cinv_q_vss\x7cmph_g\x7cnand_m_vss\x7cnand_s2_vss\x7cs1_vss_m1\x7cs2_vss_m1\x7cs3_vss_m1\x7cs4_vss_m1\x7csb_vss\x7csr1_vss\x7csr2_vss\x7csr3_vss\x7csr4_vss\x7csv_vss\x7ctg_d_vss\x7ctg_fbm_vss\x7ctg_fbs_vss\x7ctg_s_vss\x7cvss\x7cvss_link\x7cvss_link_bridge\x7cvss_link_dip\x7cvss_link_m1\x7cvss_x1\x7cvss_x2\x7cvss_x3__t179
+ sky130_fd_pr__nfet_01v8 L=0.15 W=0.42 AS=0.1974 AD=0.1974 PS=1.78 PD=1.78
* device instance $106 r0 *1 92.735,23.845 nfet
X$106 ny__t010
+ g_vddr_m1\x7cmnt_g\x7cs1_vddr_m1\x7cs2_vddr_m1\x7cs3_vddr_m1\x7cs4_vddr_m1\x7cvddr\x7cvddr2__t12
+ g_vss_m1\x7cinv_clk_vss\x7cinv_mc_vss\x7cinv_q_vss\x7cmph_g\x7cnand_m_vss\x7cnand_s2_vss\x7cs1_vss_m1\x7cs2_vss_m1\x7cs3_vss_m1\x7cs4_vss_m1\x7csb_vss\x7csr1_vss\x7csr2_vss\x7csr3_vss\x7csr4_vss\x7csv_vss\x7ctg_d_vss\x7ctg_fbm_vss\x7ctg_fbs_vss\x7ctg_s_vss\x7cvss\x7cvss_link\x7cvss_link_bridge\x7cvss_link_dip\x7cvss_link_m1\x7cvss_x1\x7cvss_x2\x7cvss_x3__t35
+ g_vss_m1\x7cinv_clk_vss\x7cinv_mc_vss\x7cinv_q_vss\x7cmph_g\x7cnand_m_vss\x7cnand_s2_vss\x7cs1_vss_m1\x7cs2_vss_m1\x7cs3_vss_m1\x7cs4_vss_m1\x7csb_vss\x7csr1_vss\x7csr2_vss\x7csr3_vss\x7csr4_vss\x7csv_vss\x7ctg_d_vss\x7ctg_fbm_vss\x7ctg_fbs_vss\x7ctg_s_vss\x7cvss\x7cvss_link\x7cvss_link_bridge\x7cvss_link_dip\x7cvss_link_m1\x7cvss_x1\x7cvss_x2\x7cvss_x3__t207
+ sky130_fd_pr__nfet_01v8 L=2 W=0.44 AS=0.1848 AD=0.1848 PS=1.72 PD=1.72
* device instance $107 r0 *1 95.1,23.845 nfet
X$107 a\x7cg_a\x7crn2\x7cro\x7cs4_y\x7cy__t0 a\x7cn4\x7cs3_y\x7cs4_a\x7cy__t23
+ ny__t110
+ g_vss_m1\x7cinv_clk_vss\x7cinv_mc_vss\x7cinv_q_vss\x7cmph_g\x7cnand_m_vss\x7cnand_s2_vss\x7cs1_vss_m1\x7cs2_vss_m1\x7cs3_vss_m1\x7cs4_vss_m1\x7csb_vss\x7csr1_vss\x7csr2_vss\x7csr3_vss\x7csr4_vss\x7csv_vss\x7ctg_d_vss\x7ctg_fbm_vss\x7ctg_fbs_vss\x7ctg_s_vss\x7cvss\x7cvss_link\x7cvss_link_bridge\x7cvss_link_dip\x7cvss_link_m1\x7cvss_x1\x7cvss_x2\x7cvss_x3__t180
+ sky130_fd_pr__nfet_01v8 L=0.15 W=0.42 AS=0.1974 AD=0.1974 PS=1.78 PD=1.78
* device instance $108 r0 *1 104.16,23.845 nfet
X$108
+ a\x7cb\x7cd\x7cinvb_a\x7cmn12_g1\x7cmp24_g0\x7cro2\x7cro2_esc\x7csr2_d_stub\x7ctg_d_a\x7cy__t2
+ a\x7cg_a\x7crn2\x7cro\x7cs4_y\x7cy__t2
+ g_vss_m1\x7cinv_clk_vss\x7cinv_mc_vss\x7cinv_q_vss\x7cmph_g\x7cnand_m_vss\x7cnand_s2_vss\x7cs1_vss_m1\x7cs2_vss_m1\x7cs3_vss_m1\x7cs4_vss_m1\x7csb_vss\x7csr1_vss\x7csr2_vss\x7csr3_vss\x7csr4_vss\x7csv_vss\x7ctg_d_vss\x7ctg_fbm_vss\x7ctg_fbs_vss\x7ctg_s_vss\x7cvss\x7cvss_link\x7cvss_link_bridge\x7cvss_link_dip\x7cvss_link_m1\x7cvss_x1\x7cvss_x2\x7cvss_x3__t55
+ g_vss_m1\x7cinv_clk_vss\x7cinv_mc_vss\x7cinv_q_vss\x7cmph_g\x7cnand_m_vss\x7cnand_s2_vss\x7cs1_vss_m1\x7cs2_vss_m1\x7cs3_vss_m1\x7cs4_vss_m1\x7csb_vss\x7csr1_vss\x7csr2_vss\x7csr3_vss\x7csr4_vss\x7csv_vss\x7ctg_d_vss\x7ctg_fbm_vss\x7ctg_fbs_vss\x7ctg_s_vss\x7cvss\x7cvss_link\x7cvss_link_bridge\x7cvss_link_dip\x7cvss_link_m1\x7cvss_x1\x7cvss_x2\x7cvss_x3__t181
+ sky130_fd_pr__nfet_01v8 L=0.15 W=0.42 AS=0.1974 AD=0.1974 PS=1.78 PD=1.78
* device instance $109 r0 *1 114.21,23.845 nfet
X$109 ny__t011
+ g_vddr_m1\x7cmnt_g\x7cs1_vddr_m1\x7cs2_vddr_m1\x7cs3_vddr_m1\x7cs4_vddr_m1\x7cvddr\x7cvddr3__t0
+ g_vss_m1\x7cinv_clk_vss\x7cinv_mc_vss\x7cinv_q_vss\x7cmph_g\x7cnand_m_vss\x7cnand_s2_vss\x7cs1_vss_m1\x7cs2_vss_m1\x7cs3_vss_m1\x7cs4_vss_m1\x7csb_vss\x7csr1_vss\x7csr2_vss\x7csr3_vss\x7csr4_vss\x7csv_vss\x7ctg_d_vss\x7ctg_fbm_vss\x7ctg_fbs_vss\x7ctg_s_vss\x7cvss\x7cvss_link\x7cvss_link_bridge\x7cvss_link_dip\x7cvss_link_m1\x7cvss_x1\x7cvss_x2\x7cvss_x3__t4
+ g_vss_m1\x7cinv_clk_vss\x7cinv_mc_vss\x7cinv_q_vss\x7cmph_g\x7cnand_m_vss\x7cnand_s2_vss\x7cs1_vss_m1\x7cs2_vss_m1\x7cs3_vss_m1\x7cs4_vss_m1\x7csb_vss\x7csr1_vss\x7csr2_vss\x7csr3_vss\x7csr4_vss\x7csv_vss\x7ctg_d_vss\x7ctg_fbm_vss\x7ctg_fbs_vss\x7ctg_s_vss\x7cvss\x7cvss_link\x7cvss_link_bridge\x7cvss_link_dip\x7cvss_link_m1\x7cvss_x1\x7cvss_x2\x7cvss_x3__t208
+ sky130_fd_pr__nfet_01v8 L=2 W=0.46 AS=0.1932 AD=0.1932 PS=1.76 PD=1.76
* device instance $110 r0 *1 116.575,23.845 nfet
X$110 \$87__t0 en\x7cen3\x7cg_en__t1 ny__t111
+ g_vss_m1\x7cinv_clk_vss\x7cinv_mc_vss\x7cinv_q_vss\x7cmph_g\x7cnand_m_vss\x7cnand_s2_vss\x7cs1_vss_m1\x7cs2_vss_m1\x7cs3_vss_m1\x7cs4_vss_m1\x7csb_vss\x7csr1_vss\x7csr2_vss\x7csr3_vss\x7csr4_vss\x7csv_vss\x7ctg_d_vss\x7ctg_fbm_vss\x7ctg_fbs_vss\x7ctg_s_vss\x7cvss\x7cvss_link\x7cvss_link_bridge\x7cvss_link_dip\x7cvss_link_m1\x7cvss_x1\x7cvss_x2\x7cvss_x3__t100
+ sky130_fd_pr__nfet_01v8 L=0.15 W=0.84 AS=0.3948 AD=0.2184 PS=2.62 PD=1.36
* device instance $111 r0 *1 117.245,23.845 nfet
X$111 a\x7cg_y\x7cmnab_y\x7cmpa_y\x7cmpb_y\x7cn1\x7cs1_a\x7cy__t43
+ a\x7cg_a\x7crn3\x7cro\x7cs4_y\x7cy__t5 \$87__t1
+ g_vss_m1\x7cinv_clk_vss\x7cinv_mc_vss\x7cinv_q_vss\x7cmph_g\x7cnand_m_vss\x7cnand_s2_vss\x7cs1_vss_m1\x7cs2_vss_m1\x7cs3_vss_m1\x7cs4_vss_m1\x7csb_vss\x7csr1_vss\x7csr2_vss\x7csr3_vss\x7csr4_vss\x7csv_vss\x7ctg_d_vss\x7ctg_fbm_vss\x7ctg_fbs_vss\x7ctg_s_vss\x7cvss\x7cvss_link\x7cvss_link_bridge\x7cvss_link_dip\x7cvss_link_m1\x7cvss_x1\x7cvss_x2\x7cvss_x3__t122
+ sky130_fd_pr__nfet_01v8 L=0.15 W=0.84 AS=0.2184 AD=0.3948 PS=1.36 PD=2.62
* device instance $112 r0 *1 123.51,23.845 nfet
X$112 ny__t012
+ g_vddr_m1\x7cmnt_g\x7cs1_vddr_m1\x7cs2_vddr_m1\x7cs3_vddr_m1\x7cs4_vddr_m1\x7cvddr\x7cvddr3__t12
+ g_vss_m1\x7cinv_clk_vss\x7cinv_mc_vss\x7cinv_q_vss\x7cmph_g\x7cnand_m_vss\x7cnand_s2_vss\x7cs1_vss_m1\x7cs2_vss_m1\x7cs3_vss_m1\x7cs4_vss_m1\x7csb_vss\x7csr1_vss\x7csr2_vss\x7csr3_vss\x7csr4_vss\x7csv_vss\x7ctg_d_vss\x7ctg_fbm_vss\x7ctg_fbs_vss\x7ctg_s_vss\x7cvss\x7cvss_link\x7cvss_link_bridge\x7cvss_link_dip\x7cvss_link_m1\x7cvss_x1\x7cvss_x2\x7cvss_x3__t31
+ g_vss_m1\x7cinv_clk_vss\x7cinv_mc_vss\x7cinv_q_vss\x7cmph_g\x7cnand_m_vss\x7cnand_s2_vss\x7cs1_vss_m1\x7cs2_vss_m1\x7cs3_vss_m1\x7cs4_vss_m1\x7csb_vss\x7csr1_vss\x7csr2_vss\x7csr3_vss\x7csr4_vss\x7csv_vss\x7ctg_d_vss\x7ctg_fbm_vss\x7ctg_fbs_vss\x7ctg_s_vss\x7cvss\x7cvss_link\x7cvss_link_bridge\x7cvss_link_dip\x7cvss_link_m1\x7cvss_x1\x7cvss_x2\x7cvss_x3__t209
+ sky130_fd_pr__nfet_01v8 L=2 W=0.46 AS=0.1932 AD=0.1932 PS=1.76 PD=1.76
* device instance $113 r0 *1 125.875,23.845 nfet
X$113 a\x7cn2\x7cs1_y\x7cs2_a\x7cy__t03
+ a\x7cg_y\x7cmnab_y\x7cmpa_y\x7cmpb_y\x7cn1\x7cs1_a\x7cy__t13 ny__t112
+ g_vss_m1\x7cinv_clk_vss\x7cinv_mc_vss\x7cinv_q_vss\x7cmph_g\x7cnand_m_vss\x7cnand_s2_vss\x7cs1_vss_m1\x7cs2_vss_m1\x7cs3_vss_m1\x7cs4_vss_m1\x7csb_vss\x7csr1_vss\x7csr2_vss\x7csr3_vss\x7csr4_vss\x7csv_vss\x7ctg_d_vss\x7ctg_fbm_vss\x7ctg_fbs_vss\x7ctg_s_vss\x7cvss\x7cvss_link\x7cvss_link_bridge\x7cvss_link_dip\x7cvss_link_m1\x7cvss_x1\x7cvss_x2\x7cvss_x3__t182
+ sky130_fd_pr__nfet_01v8 L=0.15 W=0.42 AS=0.1974 AD=0.1974 PS=1.78 PD=1.78
* device instance $114 r0 *1 131.685,23.845 nfet
X$114 ny__t013
+ g_vddr_m1\x7cmnt_g\x7cs1_vddr_m1\x7cs2_vddr_m1\x7cs3_vddr_m1\x7cs4_vddr_m1\x7cvddr\x7cvddr3__t11
+ g_vss_m1\x7cinv_clk_vss\x7cinv_mc_vss\x7cinv_q_vss\x7cmph_g\x7cnand_m_vss\x7cnand_s2_vss\x7cs1_vss_m1\x7cs2_vss_m1\x7cs3_vss_m1\x7cs4_vss_m1\x7csb_vss\x7csr1_vss\x7csr2_vss\x7csr3_vss\x7csr4_vss\x7csv_vss\x7ctg_d_vss\x7ctg_fbm_vss\x7ctg_fbs_vss\x7ctg_s_vss\x7cvss\x7cvss_link\x7cvss_link_bridge\x7cvss_link_dip\x7cvss_link_m1\x7cvss_x1\x7cvss_x2\x7cvss_x3__t30
+ g_vss_m1\x7cinv_clk_vss\x7cinv_mc_vss\x7cinv_q_vss\x7cmph_g\x7cnand_m_vss\x7cnand_s2_vss\x7cs1_vss_m1\x7cs2_vss_m1\x7cs3_vss_m1\x7cs4_vss_m1\x7csb_vss\x7csr1_vss\x7csr2_vss\x7csr3_vss\x7csr4_vss\x7csv_vss\x7ctg_d_vss\x7ctg_fbm_vss\x7ctg_fbs_vss\x7ctg_s_vss\x7cvss\x7cvss_link\x7cvss_link_bridge\x7cvss_link_dip\x7cvss_link_m1\x7cvss_x1\x7cvss_x2\x7cvss_x3__t210
+ sky130_fd_pr__nfet_01v8 L=2 W=0.46 AS=0.1932 AD=0.1932 PS=1.76 PD=1.76
* device instance $115 r0 *1 134.05,23.845 nfet
X$115 a\x7cn3\x7cs2_y\x7cs3_a\x7cy__t03 a\x7cn2\x7cs1_y\x7cs2_a\x7cy__t23
+ ny__t113
+ g_vss_m1\x7cinv_clk_vss\x7cinv_mc_vss\x7cinv_q_vss\x7cmph_g\x7cnand_m_vss\x7cnand_s2_vss\x7cs1_vss_m1\x7cs2_vss_m1\x7cs3_vss_m1\x7cs4_vss_m1\x7csb_vss\x7csr1_vss\x7csr2_vss\x7csr3_vss\x7csr4_vss\x7csv_vss\x7ctg_d_vss\x7ctg_fbm_vss\x7ctg_fbs_vss\x7ctg_s_vss\x7cvss\x7cvss_link\x7cvss_link_bridge\x7cvss_link_dip\x7cvss_link_m1\x7cvss_x1\x7cvss_x2\x7cvss_x3__t183
+ sky130_fd_pr__nfet_01v8 L=0.15 W=0.42 AS=0.1974 AD=0.1974 PS=1.78 PD=1.78
* device instance $116 r0 *1 139.86,23.845 nfet
X$116 ny__t014
+ g_vddr_m1\x7cmnt_g\x7cs1_vddr_m1\x7cs2_vddr_m1\x7cs3_vddr_m1\x7cs4_vddr_m1\x7cvddr\x7cvddr3__t14
+ g_vss_m1\x7cinv_clk_vss\x7cinv_mc_vss\x7cinv_q_vss\x7cmph_g\x7cnand_m_vss\x7cnand_s2_vss\x7cs1_vss_m1\x7cs2_vss_m1\x7cs3_vss_m1\x7cs4_vss_m1\x7csb_vss\x7csr1_vss\x7csr2_vss\x7csr3_vss\x7csr4_vss\x7csv_vss\x7ctg_d_vss\x7ctg_fbm_vss\x7ctg_fbs_vss\x7ctg_s_vss\x7cvss\x7cvss_link\x7cvss_link_bridge\x7cvss_link_dip\x7cvss_link_m1\x7cvss_x1\x7cvss_x2\x7cvss_x3__t33
+ g_vss_m1\x7cinv_clk_vss\x7cinv_mc_vss\x7cinv_q_vss\x7cmph_g\x7cnand_m_vss\x7cnand_s2_vss\x7cs1_vss_m1\x7cs2_vss_m1\x7cs3_vss_m1\x7cs4_vss_m1\x7csb_vss\x7csr1_vss\x7csr2_vss\x7csr3_vss\x7csr4_vss\x7csv_vss\x7ctg_d_vss\x7ctg_fbm_vss\x7ctg_fbs_vss\x7ctg_s_vss\x7cvss\x7cvss_link\x7cvss_link_bridge\x7cvss_link_dip\x7cvss_link_m1\x7cvss_x1\x7cvss_x2\x7cvss_x3__t211
+ sky130_fd_pr__nfet_01v8 L=2 W=0.46 AS=0.1932 AD=0.1932 PS=1.76 PD=1.76
* device instance $117 r0 *1 142.225,23.845 nfet
X$117 a\x7cn4\x7cs3_y\x7cs4_a\x7cy__t04 a\x7cn3\x7cs2_y\x7cs3_a\x7cy__t23
+ ny__t114
+ g_vss_m1\x7cinv_clk_vss\x7cinv_mc_vss\x7cinv_q_vss\x7cmph_g\x7cnand_m_vss\x7cnand_s2_vss\x7cs1_vss_m1\x7cs2_vss_m1\x7cs3_vss_m1\x7cs4_vss_m1\x7csb_vss\x7csr1_vss\x7csr2_vss\x7csr3_vss\x7csr4_vss\x7csv_vss\x7ctg_d_vss\x7ctg_fbm_vss\x7ctg_fbs_vss\x7ctg_s_vss\x7cvss\x7cvss_link\x7cvss_link_bridge\x7cvss_link_dip\x7cvss_link_m1\x7cvss_x1\x7cvss_x2\x7cvss_x3__t184
+ sky130_fd_pr__nfet_01v8 L=0.15 W=0.42 AS=0.1974 AD=0.1974 PS=1.78 PD=1.78
* device instance $118 r0 *1 148.035,23.845 nfet
X$118 ny__t015
+ g_vddr_m1\x7cmnt_g\x7cs1_vddr_m1\x7cs2_vddr_m1\x7cs3_vddr_m1\x7cs4_vddr_m1\x7cvddr\x7cvddr3__t13
+ g_vss_m1\x7cinv_clk_vss\x7cinv_mc_vss\x7cinv_q_vss\x7cmph_g\x7cnand_m_vss\x7cnand_s2_vss\x7cs1_vss_m1\x7cs2_vss_m1\x7cs3_vss_m1\x7cs4_vss_m1\x7csb_vss\x7csr1_vss\x7csr2_vss\x7csr3_vss\x7csr4_vss\x7csv_vss\x7ctg_d_vss\x7ctg_fbm_vss\x7ctg_fbs_vss\x7ctg_s_vss\x7cvss\x7cvss_link\x7cvss_link_bridge\x7cvss_link_dip\x7cvss_link_m1\x7cvss_x1\x7cvss_x2\x7cvss_x3__t32
+ g_vss_m1\x7cinv_clk_vss\x7cinv_mc_vss\x7cinv_q_vss\x7cmph_g\x7cnand_m_vss\x7cnand_s2_vss\x7cs1_vss_m1\x7cs2_vss_m1\x7cs3_vss_m1\x7cs4_vss_m1\x7csb_vss\x7csr1_vss\x7csr2_vss\x7csr3_vss\x7csr4_vss\x7csv_vss\x7ctg_d_vss\x7ctg_fbm_vss\x7ctg_fbs_vss\x7ctg_s_vss\x7cvss\x7cvss_link\x7cvss_link_bridge\x7cvss_link_dip\x7cvss_link_m1\x7cvss_x1\x7cvss_x2\x7cvss_x3__t212
+ sky130_fd_pr__nfet_01v8 L=2 W=0.46 AS=0.1932 AD=0.1932 PS=1.76 PD=1.76
* device instance $119 r0 *1 150.4,23.845 nfet
X$119 a\x7cg_a\x7crn3\x7cro\x7cs4_y\x7cy__t0 a\x7cn4\x7cs3_y\x7cs4_a\x7cy__t24
+ ny__t115
+ g_vss_m1\x7cinv_clk_vss\x7cinv_mc_vss\x7cinv_q_vss\x7cmph_g\x7cnand_m_vss\x7cnand_s2_vss\x7cs1_vss_m1\x7cs2_vss_m1\x7cs3_vss_m1\x7cs4_vss_m1\x7csb_vss\x7csr1_vss\x7csr2_vss\x7csr3_vss\x7csr4_vss\x7csv_vss\x7ctg_d_vss\x7ctg_fbm_vss\x7ctg_fbs_vss\x7ctg_s_vss\x7cvss\x7cvss_link\x7cvss_link_bridge\x7cvss_link_dip\x7cvss_link_m1\x7cvss_x1\x7cvss_x2\x7cvss_x3__t185
+ sky130_fd_pr__nfet_01v8 L=0.15 W=0.42 AS=0.1974 AD=0.1974 PS=1.78 PD=1.78
* device instance $120 r0 *1 159.46,23.845 nfet
X$120
+ a\x7cd\x7cinva_a\x7cmn12_g0\x7cmp13_g0\x7cro3\x7cro3_esc_e\x7cro3_esc_w\x7cro3_hop\x7csr3_d_stub\x7ctg_d_a\x7cy__t2
+ a\x7cg_a\x7crn3\x7cro\x7cs4_y\x7cy__t2
+ g_vss_m1\x7cinv_clk_vss\x7cinv_mc_vss\x7cinv_q_vss\x7cmph_g\x7cnand_m_vss\x7cnand_s2_vss\x7cs1_vss_m1\x7cs2_vss_m1\x7cs3_vss_m1\x7cs4_vss_m1\x7csb_vss\x7csr1_vss\x7csr2_vss\x7csr3_vss\x7csr4_vss\x7csv_vss\x7ctg_d_vss\x7ctg_fbm_vss\x7ctg_fbs_vss\x7ctg_s_vss\x7cvss\x7cvss_link\x7cvss_link_bridge\x7cvss_link_dip\x7cvss_link_m1\x7cvss_x1\x7cvss_x2\x7cvss_x3__t66
+ g_vss_m1\x7cinv_clk_vss\x7cinv_mc_vss\x7cinv_q_vss\x7cmph_g\x7cnand_m_vss\x7cnand_s2_vss\x7cs1_vss_m1\x7cs2_vss_m1\x7cs3_vss_m1\x7cs4_vss_m1\x7csb_vss\x7csr1_vss\x7csr2_vss\x7csr3_vss\x7csr4_vss\x7csv_vss\x7ctg_d_vss\x7ctg_fbm_vss\x7ctg_fbs_vss\x7ctg_s_vss\x7cvss\x7cvss_link\x7cvss_link_bridge\x7cvss_link_dip\x7cvss_link_m1\x7cvss_x1\x7cvss_x2\x7cvss_x3__t186
+ sky130_fd_pr__nfet_01v8 L=0.15 W=0.42 AS=0.1974 AD=0.1974 PS=1.78 PD=1.78
* device instance $121 r0 *1 169.51,23.845 nfet
X$121 ny__t016
+ g_vddr_m1\x7cmnt_g\x7cs1_vddr_m1\x7cs2_vddr_m1\x7cs3_vddr_m1\x7cs4_vddr_m1\x7cvddr\x7cvddr4__t0
+ g_vss_m1\x7cinv_clk_vss\x7cinv_mc_vss\x7cinv_q_vss\x7cmph_g\x7cnand_m_vss\x7cnand_s2_vss\x7cs1_vss_m1\x7cs2_vss_m1\x7cs3_vss_m1\x7cs4_vss_m1\x7csb_vss\x7csr1_vss\x7csr2_vss\x7csr3_vss\x7csr4_vss\x7csv_vss\x7ctg_d_vss\x7ctg_fbm_vss\x7ctg_fbs_vss\x7ctg_s_vss\x7cvss\x7cvss_link\x7cvss_link_bridge\x7cvss_link_dip\x7cvss_link_m1\x7cvss_x1\x7cvss_x2\x7cvss_x3__t5
+ g_vss_m1\x7cinv_clk_vss\x7cinv_mc_vss\x7cinv_q_vss\x7cmph_g\x7cnand_m_vss\x7cnand_s2_vss\x7cs1_vss_m1\x7cs2_vss_m1\x7cs3_vss_m1\x7cs4_vss_m1\x7csb_vss\x7csr1_vss\x7csr2_vss\x7csr3_vss\x7csr4_vss\x7csv_vss\x7ctg_d_vss\x7ctg_fbm_vss\x7ctg_fbs_vss\x7ctg_s_vss\x7cvss\x7cvss_link\x7cvss_link_bridge\x7cvss_link_dip\x7cvss_link_m1\x7cvss_x1\x7cvss_x2\x7cvss_x3__t213
+ sky130_fd_pr__nfet_01v8 L=2 W=0.48 AS=0.2016 AD=0.2016 PS=1.8 PD=1.8
* device instance $122 r0 *1 171.875,23.845 nfet
X$122 \$96__t0 en\x7cen4\x7cg_en__t1 ny__t116
+ g_vss_m1\x7cinv_clk_vss\x7cinv_mc_vss\x7cinv_q_vss\x7cmph_g\x7cnand_m_vss\x7cnand_s2_vss\x7cs1_vss_m1\x7cs2_vss_m1\x7cs3_vss_m1\x7cs4_vss_m1\x7csb_vss\x7csr1_vss\x7csr2_vss\x7csr3_vss\x7csr4_vss\x7csv_vss\x7ctg_d_vss\x7ctg_fbm_vss\x7ctg_fbs_vss\x7ctg_s_vss\x7cvss\x7cvss_link\x7cvss_link_bridge\x7cvss_link_dip\x7cvss_link_m1\x7cvss_x1\x7cvss_x2\x7cvss_x3__t101
+ sky130_fd_pr__nfet_01v8 L=0.15 W=0.84 AS=0.3948 AD=0.2184 PS=2.62 PD=1.36
* device instance $123 r0 *1 172.545,23.845 nfet
X$123 a\x7cg_y\x7cmnab_y\x7cmpa_y\x7cmpb_y\x7cn1\x7cs1_a\x7cy__t44
+ a\x7cg_a\x7crn4\x7cro\x7cs4_y\x7cy__t5 \$96__t1
+ g_vss_m1\x7cinv_clk_vss\x7cinv_mc_vss\x7cinv_q_vss\x7cmph_g\x7cnand_m_vss\x7cnand_s2_vss\x7cs1_vss_m1\x7cs2_vss_m1\x7cs3_vss_m1\x7cs4_vss_m1\x7csb_vss\x7csr1_vss\x7csr2_vss\x7csr3_vss\x7csr4_vss\x7csv_vss\x7ctg_d_vss\x7ctg_fbm_vss\x7ctg_fbs_vss\x7ctg_s_vss\x7cvss\x7cvss_link\x7cvss_link_bridge\x7cvss_link_dip\x7cvss_link_m1\x7cvss_x1\x7cvss_x2\x7cvss_x3__t123
+ sky130_fd_pr__nfet_01v8 L=0.15 W=0.84 AS=0.2184 AD=0.3948 PS=1.36 PD=2.62
* device instance $124 r0 *1 178.81,23.845 nfet
X$124 ny__t017
+ g_vddr_m1\x7cmnt_g\x7cs1_vddr_m1\x7cs2_vddr_m1\x7cs3_vddr_m1\x7cs4_vddr_m1\x7cvddr\x7cvddr4__t11
+ g_vss_m1\x7cinv_clk_vss\x7cinv_mc_vss\x7cinv_q_vss\x7cmph_g\x7cnand_m_vss\x7cnand_s2_vss\x7cs1_vss_m1\x7cs2_vss_m1\x7cs3_vss_m1\x7cs4_vss_m1\x7csb_vss\x7csr1_vss\x7csr2_vss\x7csr3_vss\x7csr4_vss\x7csv_vss\x7ctg_d_vss\x7ctg_fbm_vss\x7ctg_fbs_vss\x7ctg_s_vss\x7cvss\x7cvss_link\x7cvss_link_bridge\x7cvss_link_dip\x7cvss_link_m1\x7cvss_x1\x7cvss_x2\x7cvss_x3__t26
+ g_vss_m1\x7cinv_clk_vss\x7cinv_mc_vss\x7cinv_q_vss\x7cmph_g\x7cnand_m_vss\x7cnand_s2_vss\x7cs1_vss_m1\x7cs2_vss_m1\x7cs3_vss_m1\x7cs4_vss_m1\x7csb_vss\x7csr1_vss\x7csr2_vss\x7csr3_vss\x7csr4_vss\x7csv_vss\x7ctg_d_vss\x7ctg_fbm_vss\x7ctg_fbs_vss\x7ctg_s_vss\x7cvss\x7cvss_link\x7cvss_link_bridge\x7cvss_link_dip\x7cvss_link_m1\x7cvss_x1\x7cvss_x2\x7cvss_x3__t214
+ sky130_fd_pr__nfet_01v8 L=2 W=0.48 AS=0.2016 AD=0.2016 PS=1.8 PD=1.8
* device instance $125 r0 *1 181.175,23.845 nfet
X$125 a\x7cn2\x7cs1_y\x7cs2_a\x7cy__t04
+ a\x7cg_y\x7cmnab_y\x7cmpa_y\x7cmpb_y\x7cn1\x7cs1_a\x7cy__t14 ny__t117
+ g_vss_m1\x7cinv_clk_vss\x7cinv_mc_vss\x7cinv_q_vss\x7cmph_g\x7cnand_m_vss\x7cnand_s2_vss\x7cs1_vss_m1\x7cs2_vss_m1\x7cs3_vss_m1\x7cs4_vss_m1\x7csb_vss\x7csr1_vss\x7csr2_vss\x7csr3_vss\x7csr4_vss\x7csv_vss\x7ctg_d_vss\x7ctg_fbm_vss\x7ctg_fbs_vss\x7ctg_s_vss\x7cvss\x7cvss_link\x7cvss_link_bridge\x7cvss_link_dip\x7cvss_link_m1\x7cvss_x1\x7cvss_x2\x7cvss_x3__t187
+ sky130_fd_pr__nfet_01v8 L=0.15 W=0.42 AS=0.1974 AD=0.1974 PS=1.78 PD=1.78
* device instance $126 r0 *1 186.985,23.845 nfet
X$126 ny__t018
+ g_vddr_m1\x7cmnt_g\x7cs1_vddr_m1\x7cs2_vddr_m1\x7cs3_vddr_m1\x7cs4_vddr_m1\x7cvddr\x7cvddr4__t12
+ g_vss_m1\x7cinv_clk_vss\x7cinv_mc_vss\x7cinv_q_vss\x7cmph_g\x7cnand_m_vss\x7cnand_s2_vss\x7cs1_vss_m1\x7cs2_vss_m1\x7cs3_vss_m1\x7cs4_vss_m1\x7csb_vss\x7csr1_vss\x7csr2_vss\x7csr3_vss\x7csr4_vss\x7csv_vss\x7ctg_d_vss\x7ctg_fbm_vss\x7ctg_fbs_vss\x7ctg_s_vss\x7cvss\x7cvss_link\x7cvss_link_bridge\x7cvss_link_dip\x7cvss_link_m1\x7cvss_x1\x7cvss_x2\x7cvss_x3__t27
+ g_vss_m1\x7cinv_clk_vss\x7cinv_mc_vss\x7cinv_q_vss\x7cmph_g\x7cnand_m_vss\x7cnand_s2_vss\x7cs1_vss_m1\x7cs2_vss_m1\x7cs3_vss_m1\x7cs4_vss_m1\x7csb_vss\x7csr1_vss\x7csr2_vss\x7csr3_vss\x7csr4_vss\x7csv_vss\x7ctg_d_vss\x7ctg_fbm_vss\x7ctg_fbs_vss\x7ctg_s_vss\x7cvss\x7cvss_link\x7cvss_link_bridge\x7cvss_link_dip\x7cvss_link_m1\x7cvss_x1\x7cvss_x2\x7cvss_x3__t215
+ sky130_fd_pr__nfet_01v8 L=2 W=0.48 AS=0.2016 AD=0.2016 PS=1.8 PD=1.8
* device instance $127 r0 *1 189.35,23.845 nfet
X$127 a\x7cn3\x7cs2_y\x7cs3_a\x7cy__t04 a\x7cn2\x7cs1_y\x7cs2_a\x7cy__t24
+ ny__t118
+ g_vss_m1\x7cinv_clk_vss\x7cinv_mc_vss\x7cinv_q_vss\x7cmph_g\x7cnand_m_vss\x7cnand_s2_vss\x7cs1_vss_m1\x7cs2_vss_m1\x7cs3_vss_m1\x7cs4_vss_m1\x7csb_vss\x7csr1_vss\x7csr2_vss\x7csr3_vss\x7csr4_vss\x7csv_vss\x7ctg_d_vss\x7ctg_fbm_vss\x7ctg_fbs_vss\x7ctg_s_vss\x7cvss\x7cvss_link\x7cvss_link_bridge\x7cvss_link_dip\x7cvss_link_m1\x7cvss_x1\x7cvss_x2\x7cvss_x3__t188
+ sky130_fd_pr__nfet_01v8 L=0.15 W=0.42 AS=0.1974 AD=0.1974 PS=1.78 PD=1.78
* device instance $128 r0 *1 195.16,23.845 nfet
X$128 ny__t019
+ g_vddr_m1\x7cmnt_g\x7cs1_vddr_m1\x7cs2_vddr_m1\x7cs3_vddr_m1\x7cs4_vddr_m1\x7cvddr\x7cvddr4__t13
+ g_vss_m1\x7cinv_clk_vss\x7cinv_mc_vss\x7cinv_q_vss\x7cmph_g\x7cnand_m_vss\x7cnand_s2_vss\x7cs1_vss_m1\x7cs2_vss_m1\x7cs3_vss_m1\x7cs4_vss_m1\x7csb_vss\x7csr1_vss\x7csr2_vss\x7csr3_vss\x7csr4_vss\x7csv_vss\x7ctg_d_vss\x7ctg_fbm_vss\x7ctg_fbs_vss\x7ctg_s_vss\x7cvss\x7cvss_link\x7cvss_link_bridge\x7cvss_link_dip\x7cvss_link_m1\x7cvss_x1\x7cvss_x2\x7cvss_x3__t28
+ g_vss_m1\x7cinv_clk_vss\x7cinv_mc_vss\x7cinv_q_vss\x7cmph_g\x7cnand_m_vss\x7cnand_s2_vss\x7cs1_vss_m1\x7cs2_vss_m1\x7cs3_vss_m1\x7cs4_vss_m1\x7csb_vss\x7csr1_vss\x7csr2_vss\x7csr3_vss\x7csr4_vss\x7csv_vss\x7ctg_d_vss\x7ctg_fbm_vss\x7ctg_fbs_vss\x7ctg_s_vss\x7cvss\x7cvss_link\x7cvss_link_bridge\x7cvss_link_dip\x7cvss_link_m1\x7cvss_x1\x7cvss_x2\x7cvss_x3__t216
+ sky130_fd_pr__nfet_01v8 L=2 W=0.48 AS=0.2016 AD=0.2016 PS=1.8 PD=1.8
* device instance $129 r0 *1 197.525,23.845 nfet
X$129 a\x7cn4\x7cs3_y\x7cs4_a\x7cy__t02 a\x7cn3\x7cs2_y\x7cs3_a\x7cy__t24
+ ny__t119
+ g_vss_m1\x7cinv_clk_vss\x7cinv_mc_vss\x7cinv_q_vss\x7cmph_g\x7cnand_m_vss\x7cnand_s2_vss\x7cs1_vss_m1\x7cs2_vss_m1\x7cs3_vss_m1\x7cs4_vss_m1\x7csb_vss\x7csr1_vss\x7csr2_vss\x7csr3_vss\x7csr4_vss\x7csv_vss\x7ctg_d_vss\x7ctg_fbm_vss\x7ctg_fbs_vss\x7ctg_s_vss\x7cvss\x7cvss_link\x7cvss_link_bridge\x7cvss_link_dip\x7cvss_link_m1\x7cvss_x1\x7cvss_x2\x7cvss_x3__t189
+ sky130_fd_pr__nfet_01v8 L=0.15 W=0.42 AS=0.1974 AD=0.1974 PS=1.78 PD=1.78
* device instance $130 r0 *1 203.335,23.845 nfet
X$130 ny__t020
+ g_vddr_m1\x7cmnt_g\x7cs1_vddr_m1\x7cs2_vddr_m1\x7cs3_vddr_m1\x7cs4_vddr_m1\x7cvddr\x7cvddr4__t14
+ g_vss_m1\x7cinv_clk_vss\x7cinv_mc_vss\x7cinv_q_vss\x7cmph_g\x7cnand_m_vss\x7cnand_s2_vss\x7cs1_vss_m1\x7cs2_vss_m1\x7cs3_vss_m1\x7cs4_vss_m1\x7csb_vss\x7csr1_vss\x7csr2_vss\x7csr3_vss\x7csr4_vss\x7csv_vss\x7ctg_d_vss\x7ctg_fbm_vss\x7ctg_fbs_vss\x7ctg_s_vss\x7cvss\x7cvss_link\x7cvss_link_bridge\x7cvss_link_dip\x7cvss_link_m1\x7cvss_x1\x7cvss_x2\x7cvss_x3__t29
+ g_vss_m1\x7cinv_clk_vss\x7cinv_mc_vss\x7cinv_q_vss\x7cmph_g\x7cnand_m_vss\x7cnand_s2_vss\x7cs1_vss_m1\x7cs2_vss_m1\x7cs3_vss_m1\x7cs4_vss_m1\x7csb_vss\x7csr1_vss\x7csr2_vss\x7csr3_vss\x7csr4_vss\x7csv_vss\x7ctg_d_vss\x7ctg_fbm_vss\x7ctg_fbs_vss\x7ctg_s_vss\x7cvss\x7cvss_link\x7cvss_link_bridge\x7cvss_link_dip\x7cvss_link_m1\x7cvss_x1\x7cvss_x2\x7cvss_x3__t217
+ sky130_fd_pr__nfet_01v8 L=2 W=0.48 AS=0.2016 AD=0.2016 PS=1.8 PD=1.8
* device instance $131 r0 *1 205.7,23.845 nfet
X$131 a\x7cg_a\x7crn4\x7cro\x7cs4_y\x7cy__t0 a\x7cn4\x7cs3_y\x7cs4_a\x7cy__t22
+ ny__t120
+ g_vss_m1\x7cinv_clk_vss\x7cinv_mc_vss\x7cinv_q_vss\x7cmph_g\x7cnand_m_vss\x7cnand_s2_vss\x7cs1_vss_m1\x7cs2_vss_m1\x7cs3_vss_m1\x7cs4_vss_m1\x7csb_vss\x7csr1_vss\x7csr2_vss\x7csr3_vss\x7csr4_vss\x7csv_vss\x7ctg_d_vss\x7ctg_fbm_vss\x7ctg_fbs_vss\x7ctg_s_vss\x7cvss\x7cvss_link\x7cvss_link_bridge\x7cvss_link_dip\x7cvss_link_m1\x7cvss_x1\x7cvss_x2\x7cvss_x3__t190
+ sky130_fd_pr__nfet_01v8 L=0.15 W=0.42 AS=0.1974 AD=0.1974 PS=1.78 PD=1.78
* device instance $132 r0 *1 214.76,23.845 nfet
X$132
+ a\x7cb\x7cd\x7cinvb_a\x7cmn12_g1\x7cmp24_g0\x7cro4\x7cro4_esc\x7csr4_d_stub\x7ctg_d_a\x7cy__t1
+ a\x7cg_a\x7crn4\x7cro\x7cs4_y\x7cy__t2
+ g_vss_m1\x7cinv_clk_vss\x7cinv_mc_vss\x7cinv_q_vss\x7cmph_g\x7cnand_m_vss\x7cnand_s2_vss\x7cs1_vss_m1\x7cs2_vss_m1\x7cs3_vss_m1\x7cs4_vss_m1\x7csb_vss\x7csr1_vss\x7csr2_vss\x7csr3_vss\x7csr4_vss\x7csv_vss\x7ctg_d_vss\x7ctg_fbm_vss\x7ctg_fbs_vss\x7ctg_s_vss\x7cvss\x7cvss_link\x7cvss_link_bridge\x7cvss_link_dip\x7cvss_link_m1\x7cvss_x1\x7cvss_x2\x7cvss_x3__t46
+ g_vss_m1\x7cinv_clk_vss\x7cinv_mc_vss\x7cinv_q_vss\x7cmph_g\x7cnand_m_vss\x7cnand_s2_vss\x7cs1_vss_m1\x7cs2_vss_m1\x7cs3_vss_m1\x7cs4_vss_m1\x7csb_vss\x7csr1_vss\x7csr2_vss\x7csr3_vss\x7csr4_vss\x7csv_vss\x7ctg_d_vss\x7ctg_fbm_vss\x7ctg_fbs_vss\x7ctg_s_vss\x7cvss\x7cvss_link\x7cvss_link_bridge\x7cvss_link_dip\x7cvss_link_m1\x7cvss_x1\x7cvss_x2\x7cvss_x3__t191
+ sky130_fd_pr__nfet_01v8 L=0.15 W=0.42 AS=0.1974 AD=0.1974 PS=1.78 PD=1.78
* device instance $133 r0 *1 0.545,3.53 pfet
X$133
+ clkb\x7cclkb_bridge1\x7cclkb_bridge2\x7cclkb_mid\x7cclkb_w\x7cctrl\x7cctrlb\x7cinv_clk_y\x7ctg_d_ctrlb\x7ctg_fbm_ctrl\x7ctg_fbs_ctrlb\x7ctg_s_ctrl\x7cy__t0
+ a\x7cclk\x7cctrl\x7cctrlb\x7cinv_clk_a\x7cinv_clk_clk_via\x7ctg_d_ctrl\x7ctg_d_ctrl_via\x7ctg_fbm_ctrlb\x7ctg_fbm_ctrlb_via\x7ctg_fbs_ctrl\x7ctg_fbs_ctrl_via\x7ctg_s_ctrlb\x7ctg_s_ctrlb_via__t0
+ a\x7cd\x7cinv_clk_vdd\x7cinv_mc_vdd\x7cinv_q_vdd\x7cmpa_py\x7cmpb_py\x7cnand_m_vdd\x7cnand_s2_vdd\x7cnwell_vdd\x7csb_vdd\x7csr1_vdd\x7csr2_vdd\x7csr3_vdd\x7csr4_vdd\x7csv_d_vdd_tie\x7csv_vdd\x7ctg_d_a\x7ctg_d_vdd\x7ctg_fbm_vdd\x7ctg_fbs_vdd\x7ctg_s_vdd\x7cvdd\x7cvdd_b1\x7cvdd_b2\x7cvdd_b3\x7cvdd_b4\x7cvdd_link\x7cvdd_link_dip\x7cvdd_x1\x7cvdd_x2\x7cvdd_x3__t0
+ a\x7cd\x7cinv_clk_vdd\x7cinv_mc_vdd\x7cinv_q_vdd\x7cmpa_py\x7cmpb_py\x7cnand_m_vdd\x7cnand_s2_vdd\x7cnwell_vdd\x7csb_vdd\x7csr1_vdd\x7csr2_vdd\x7csr3_vdd\x7csr4_vdd\x7csv_d_vdd_tie\x7csv_vdd\x7ctg_d_a\x7ctg_d_vdd\x7ctg_fbm_vdd\x7ctg_fbs_vdd\x7ctg_s_vdd\x7cvdd\x7cvdd_b1\x7cvdd_b2\x7cvdd_b3\x7cvdd_b4\x7cvdd_link\x7cvdd_link_dip\x7cvdd_x1\x7cvdd_x2\x7cvdd_x3__t1
+ sky130_fd_pr__pfet_01v8 L=0.15 W=0.84 AS=0.3948 AD=0.3948 PS=2.62 PD=2.62
* device instance $134 r0 *1 5.31,3.53 pfet
X$134
+ a\x7cd\x7csb_d_stub\x7ctg_d_a\x7cxo\x7cxo_dip\x7cxo_hop\x7cxo_stub\x7cy__t3
+ a\x7cclk\x7cctrl\x7cctrlb\x7cinv_clk_a\x7cinv_clk_clk_via\x7ctg_d_ctrl\x7ctg_d_ctrl_via\x7ctg_fbm_ctrlb\x7ctg_fbm_ctrlb_via\x7ctg_fbs_ctrl\x7ctg_fbs_ctrl_via\x7ctg_s_ctrlb\x7ctg_s_ctrlb_via__t22
+ a\x7cb\x7cm_east\x7cm_west\x7cnand_m_a\x7cnand_m_a_ext_via\x7cnand_m_a_ext_via2\x7cnand_m_a_stub\x7ctg_d_b\x7ctg_d_b_via\x7ctg_d_b_via2\x7ctg_fbm_b\x7ctg_fbm_b_alt_via\x7ctg_fbm_b_alt_via2__t4
+ a\x7cd\x7cinv_clk_vdd\x7cinv_mc_vdd\x7cinv_q_vdd\x7cmpa_py\x7cmpb_py\x7cnand_m_vdd\x7cnand_s2_vdd\x7cnwell_vdd\x7csb_vdd\x7csr1_vdd\x7csr2_vdd\x7csr3_vdd\x7csr4_vdd\x7csv_d_vdd_tie\x7csv_vdd\x7ctg_d_a\x7ctg_d_vdd\x7ctg_fbm_vdd\x7ctg_fbs_vdd\x7ctg_s_vdd\x7cvdd\x7cvdd_b1\x7cvdd_b2\x7cvdd_b3\x7cvdd_b4\x7cvdd_link\x7cvdd_link_dip\x7cvdd_x1\x7cvdd_x2\x7cvdd_x3__t65
+ sky130_fd_pr__pfet_01v8 L=0.15 W=0.84 AS=0.3948 AD=0.3948 PS=2.62 PD=2.62
* device instance $135 r0 *1 19.835,3.53 pfet
X$135 a\x7cinv_mc_y\x7cinv_mc_y_via\x7cmc\x7ctg_fbm_a\x7ctg_fbm_a_via\x7cy__t2
+ a\x7cinv_mc_a\x7cmb\x7cmnab_y\x7cmpa_y\x7cmpb_y\x7cnand_m_y\x7ctg_s_a\x7cy__t5
+ a\x7cd\x7cinv_clk_vdd\x7cinv_mc_vdd\x7cinv_q_vdd\x7cmpa_py\x7cmpb_py\x7cnand_m_vdd\x7cnand_s2_vdd\x7cnwell_vdd\x7csb_vdd\x7csr1_vdd\x7csr2_vdd\x7csr3_vdd\x7csr4_vdd\x7csv_d_vdd_tie\x7csv_vdd\x7ctg_d_a\x7ctg_d_vdd\x7ctg_fbm_vdd\x7ctg_fbs_vdd\x7ctg_s_vdd\x7cvdd\x7cvdd_b1\x7cvdd_b2\x7cvdd_b3\x7cvdd_b4\x7cvdd_link\x7cvdd_link_dip\x7cvdd_x1\x7cvdd_x2\x7cvdd_x3__t129
+ a\x7cd\x7cinv_clk_vdd\x7cinv_mc_vdd\x7cinv_q_vdd\x7cmpa_py\x7cmpb_py\x7cnand_m_vdd\x7cnand_s2_vdd\x7cnwell_vdd\x7csb_vdd\x7csr1_vdd\x7csr2_vdd\x7csr3_vdd\x7csr4_vdd\x7csv_d_vdd_tie\x7csv_vdd\x7ctg_d_a\x7ctg_d_vdd\x7ctg_fbm_vdd\x7ctg_fbs_vdd\x7ctg_s_vdd\x7cvdd\x7cvdd_b1\x7cvdd_b2\x7cvdd_b3\x7cvdd_b4\x7cvdd_link\x7cvdd_link_dip\x7cvdd_x1\x7cvdd_x2\x7cvdd_x3__t66
+ sky130_fd_pr__pfet_01v8 L=0.15 W=0.84 AS=0.3948 AD=0.3948 PS=2.62 PD=2.62
* device instance $136 r0 *1 24.6,3.53 pfet
X$136 a\x7cinv_mc_y\x7cinv_mc_y_via\x7cmc\x7ctg_fbm_a\x7ctg_fbm_a_via\x7cy__t3
+ clkb\x7cclkb_bridge1\x7cclkb_bridge2\x7cclkb_mid\x7cclkb_w\x7cctrl\x7cctrlb\x7cinv_clk_y\x7ctg_d_ctrlb\x7ctg_fbm_ctrl\x7ctg_fbs_ctrlb\x7ctg_s_ctrl\x7cy__t4
+ a\x7cb\x7cm_east\x7cm_west\x7cnand_m_a\x7cnand_m_a_ext_via\x7cnand_m_a_ext_via2\x7cnand_m_a_stub\x7ctg_d_b\x7ctg_d_b_via\x7ctg_d_b_via2\x7ctg_fbm_b\x7ctg_fbm_b_alt_via\x7ctg_fbm_b_alt_via2__t5
+ a\x7cd\x7cinv_clk_vdd\x7cinv_mc_vdd\x7cinv_q_vdd\x7cmpa_py\x7cmpb_py\x7cnand_m_vdd\x7cnand_s2_vdd\x7cnwell_vdd\x7csb_vdd\x7csr1_vdd\x7csr2_vdd\x7csr3_vdd\x7csr4_vdd\x7csv_d_vdd_tie\x7csv_vdd\x7ctg_d_a\x7ctg_d_vdd\x7ctg_fbm_vdd\x7ctg_fbs_vdd\x7ctg_s_vdd\x7cvdd\x7cvdd_b1\x7cvdd_b2\x7cvdd_b3\x7cvdd_b4\x7cvdd_link\x7cvdd_link_dip\x7cvdd_x1\x7cvdd_x2\x7cvdd_x3__t67
+ sky130_fd_pr__pfet_01v8 L=0.15 W=0.84 AS=0.3948 AD=0.3948 PS=2.62 PD=2.62
* device instance $137 r0 *1 29.74,3.53 pfet
X$137
+ a\x7cinv_mc_a\x7cmb\x7cmnab_y\x7cmpa_y\x7cmpb_y\x7cnand_m_y\x7ctg_s_a\x7cy__t2
+ clkb\x7cclkb_bridge1\x7cclkb_bridge2\x7cclkb_mid\x7cclkb_w\x7cctrl\x7cctrlb\x7cinv_clk_y\x7ctg_d_ctrlb\x7ctg_fbm_ctrl\x7ctg_fbs_ctrlb\x7ctg_s_ctrl\x7cy__t5
+ a\x7cb\x7cinv_q_a\x7cinv_q_a_via\x7cs\x7ctg_fbs_b\x7ctg_fbs_b_via\x7ctg_s_b\x7ctg_s_b_via__t4
+ a\x7cd\x7cinv_clk_vdd\x7cinv_mc_vdd\x7cinv_q_vdd\x7cmpa_py\x7cmpb_py\x7cnand_m_vdd\x7cnand_s2_vdd\x7cnwell_vdd\x7csb_vdd\x7csr1_vdd\x7csr2_vdd\x7csr3_vdd\x7csr4_vdd\x7csv_d_vdd_tie\x7csv_vdd\x7ctg_d_a\x7ctg_d_vdd\x7ctg_fbm_vdd\x7ctg_fbs_vdd\x7ctg_s_vdd\x7cvdd\x7cvdd_b1\x7cvdd_b2\x7cvdd_b3\x7cvdd_b4\x7cvdd_link\x7cvdd_link_dip\x7cvdd_x1\x7cvdd_x2\x7cvdd_x3__t68
+ sky130_fd_pr__pfet_01v8 L=0.15 W=0.84 AS=0.3948 AD=0.3948 PS=2.62 PD=2.62
* device instance $138 r0 *1 36.545,3.53 pfet
X$138
+ a\x7cinv_q_y\x7cinv_q_y_via\x7cinv_q_y_via2\x7cnand_s2_a\x7cnand_s2_a_stub\x7cnand_s2_a_via\x7cnand_s2_a_via2\x7cq\x7cy__t1
+ a\x7cb\x7cinv_q_a\x7cinv_q_a_via\x7cs\x7ctg_fbs_b\x7ctg_fbs_b_via\x7ctg_s_b\x7ctg_s_b_via__t1
+ a\x7cd\x7cinv_clk_vdd\x7cinv_mc_vdd\x7cinv_q_vdd\x7cmpa_py\x7cmpb_py\x7cnand_m_vdd\x7cnand_s2_vdd\x7cnwell_vdd\x7csb_vdd\x7csr1_vdd\x7csr2_vdd\x7csr3_vdd\x7csr4_vdd\x7csv_d_vdd_tie\x7csv_vdd\x7ctg_d_a\x7ctg_d_vdd\x7ctg_fbm_vdd\x7ctg_fbs_vdd\x7ctg_s_vdd\x7cvdd\x7cvdd_b1\x7cvdd_b2\x7cvdd_b3\x7cvdd_b4\x7cvdd_link\x7cvdd_link_dip\x7cvdd_x1\x7cvdd_x2\x7cvdd_x3__t130
+ a\x7cd\x7cinv_clk_vdd\x7cinv_mc_vdd\x7cinv_q_vdd\x7cmpa_py\x7cmpb_py\x7cnand_m_vdd\x7cnand_s2_vdd\x7cnwell_vdd\x7csb_vdd\x7csr1_vdd\x7csr2_vdd\x7csr3_vdd\x7csr4_vdd\x7csv_d_vdd_tie\x7csv_vdd\x7ctg_d_a\x7ctg_d_vdd\x7ctg_fbm_vdd\x7ctg_fbs_vdd\x7ctg_s_vdd\x7cvdd\x7cvdd_b1\x7cvdd_b2\x7cvdd_b3\x7cvdd_b4\x7cvdd_link\x7cvdd_link_dip\x7cvdd_x1\x7cvdd_x2\x7cvdd_x3__t69
+ sky130_fd_pr__pfet_01v8 L=0.15 W=0.84 AS=0.3948 AD=0.3948 PS=2.62 PD=2.62
* device instance $139 r0 *1 49.03,3.53 pfet
X$139 a\x7cmnab_y\x7cmpa_y\x7cmpb_y\x7cnand_s2_y\x7cqb\x7ctg_fbs_a\x7cy__t1
+ a\x7cclk\x7cctrl\x7cctrlb\x7cinv_clk_a\x7cinv_clk_clk_via\x7ctg_d_ctrl\x7ctg_d_ctrl_via\x7ctg_fbm_ctrlb\x7ctg_fbm_ctrlb_via\x7ctg_fbs_ctrl\x7ctg_fbs_ctrl_via\x7ctg_s_ctrlb\x7ctg_s_ctrlb_via__t23
+ a\x7cb\x7cinv_q_a\x7cinv_q_a_via\x7cs\x7ctg_fbs_b\x7ctg_fbs_b_via\x7ctg_s_b\x7ctg_s_b_via__t5
+ a\x7cd\x7cinv_clk_vdd\x7cinv_mc_vdd\x7cinv_q_vdd\x7cmpa_py\x7cmpb_py\x7cnand_m_vdd\x7cnand_s2_vdd\x7cnwell_vdd\x7csb_vdd\x7csr1_vdd\x7csr2_vdd\x7csr3_vdd\x7csr4_vdd\x7csv_d_vdd_tie\x7csv_vdd\x7ctg_d_a\x7ctg_d_vdd\x7ctg_fbm_vdd\x7ctg_fbs_vdd\x7ctg_s_vdd\x7cvdd\x7cvdd_b1\x7cvdd_b2\x7cvdd_b3\x7cvdd_b4\x7cvdd_link\x7cvdd_link_dip\x7cvdd_x1\x7cvdd_x2\x7cvdd_x3__t70
+ sky130_fd_pr__pfet_01v8 L=0.15 W=0.84 AS=0.3948 AD=0.3948 PS=2.62 PD=2.62
* device instance $140 r0 *1 56.205,3.53 pfet
X$140
+ clkb\x7cclkb_bridge1\x7cclkb_bridge2\x7cclkb_mid\x7cclkb_w\x7cctrl\x7cctrlb\x7cinv_clk_y\x7ctg_d_ctrlb\x7ctg_fbm_ctrl\x7ctg_fbs_ctrlb\x7ctg_s_ctrl\x7cy__t12
+ a\x7cclk\x7cctrl\x7cctrlb\x7cinv_clk_a\x7cinv_clk_clk_via\x7ctg_d_ctrl\x7ctg_d_ctrl_via\x7ctg_fbm_ctrlb\x7ctg_fbm_ctrlb_via\x7ctg_fbs_ctrl\x7ctg_fbs_ctrl_via\x7ctg_s_ctrlb\x7ctg_s_ctrlb_via__t24
+ a\x7cd\x7cinv_clk_vdd\x7cinv_mc_vdd\x7cinv_q_vdd\x7cmpa_py\x7cmpb_py\x7cnand_m_vdd\x7cnand_s2_vdd\x7cnwell_vdd\x7csb_vdd\x7csr1_vdd\x7csr2_vdd\x7csr3_vdd\x7csr4_vdd\x7csv_d_vdd_tie\x7csv_vdd\x7ctg_d_a\x7ctg_d_vdd\x7ctg_fbm_vdd\x7ctg_fbs_vdd\x7ctg_s_vdd\x7cvdd\x7cvdd_b1\x7cvdd_b2\x7cvdd_b3\x7cvdd_b4\x7cvdd_link\x7cvdd_link_dip\x7cvdd_x1\x7cvdd_x2\x7cvdd_x3__t131
+ a\x7cd\x7cinv_clk_vdd\x7cinv_mc_vdd\x7cinv_q_vdd\x7cmpa_py\x7cmpb_py\x7cnand_m_vdd\x7cnand_s2_vdd\x7cnwell_vdd\x7csb_vdd\x7csr1_vdd\x7csr2_vdd\x7csr3_vdd\x7csr4_vdd\x7csv_d_vdd_tie\x7csv_vdd\x7ctg_d_a\x7ctg_d_vdd\x7ctg_fbm_vdd\x7ctg_fbs_vdd\x7ctg_s_vdd\x7cvdd\x7cvdd_b1\x7cvdd_b2\x7cvdd_b3\x7cvdd_b4\x7cvdd_link\x7cvdd_link_dip\x7cvdd_x1\x7cvdd_x2\x7cvdd_x3__t71
+ sky130_fd_pr__pfet_01v8 L=0.15 W=0.84 AS=0.3948 AD=0.3948 PS=2.62 PD=2.62
* device instance $141 r0 *1 60.97,3.53 pfet
X$141
+ a\x7cd\x7cinv_clk_vdd\x7cinv_mc_vdd\x7cinv_q_vdd\x7cmpa_py\x7cmpb_py\x7cnand_m_vdd\x7cnand_s2_vdd\x7cnwell_vdd\x7csb_vdd\x7csr1_vdd\x7csr2_vdd\x7csr3_vdd\x7csr4_vdd\x7csv_d_vdd_tie\x7csv_vdd\x7ctg_d_a\x7ctg_d_vdd\x7ctg_fbm_vdd\x7ctg_fbs_vdd\x7ctg_s_vdd\x7cvdd\x7cvdd_b1\x7cvdd_b2\x7cvdd_b3\x7cvdd_b4\x7cvdd_link\x7cvdd_link_dip\x7cvdd_x1\x7cvdd_x2\x7cvdd_x3__t27
+ a\x7cclk\x7cctrl\x7cctrlb\x7cinv_clk_a\x7cinv_clk_clk_via\x7ctg_d_ctrl\x7ctg_d_ctrl_via\x7ctg_fbm_ctrlb\x7ctg_fbm_ctrlb_via\x7ctg_fbs_ctrl\x7ctg_fbs_ctrl_via\x7ctg_s_ctrlb\x7ctg_s_ctrlb_via__t25
+ a\x7cb\x7cm_east\x7cm_west\x7cnand_m_a\x7cnand_m_a_ext_via\x7cnand_m_a_ext_via2\x7cnand_m_a_stub\x7ctg_d_b\x7ctg_d_b_via\x7ctg_d_b_via2\x7ctg_fbm_b\x7ctg_fbm_b_alt_via\x7ctg_fbm_b_alt_via2__t32
+ a\x7cd\x7cinv_clk_vdd\x7cinv_mc_vdd\x7cinv_q_vdd\x7cmpa_py\x7cmpb_py\x7cnand_m_vdd\x7cnand_s2_vdd\x7cnwell_vdd\x7csb_vdd\x7csr1_vdd\x7csr2_vdd\x7csr3_vdd\x7csr4_vdd\x7csv_d_vdd_tie\x7csv_vdd\x7ctg_d_a\x7ctg_d_vdd\x7ctg_fbm_vdd\x7ctg_fbs_vdd\x7ctg_s_vdd\x7cvdd\x7cvdd_b1\x7cvdd_b2\x7cvdd_b3\x7cvdd_b4\x7cvdd_link\x7cvdd_link_dip\x7cvdd_x1\x7cvdd_x2\x7cvdd_x3__t72
+ sky130_fd_pr__pfet_01v8 L=0.15 W=0.84 AS=0.3948 AD=0.3948 PS=2.62 PD=2.62
* device instance $142 r0 *1 75.495,3.53 pfet
X$142 a\x7cinv_mc_y\x7cinv_mc_y_via\x7cmc\x7ctg_fbm_a\x7ctg_fbm_a_via\x7cy__t22
+ a\x7cinv_mc_a\x7cmb\x7cmnab_y\x7cmpa_y\x7cmpb_y\x7cnand_m_y\x7ctg_s_a\x7cy__t42
+ a\x7cd\x7cinv_clk_vdd\x7cinv_mc_vdd\x7cinv_q_vdd\x7cmpa_py\x7cmpb_py\x7cnand_m_vdd\x7cnand_s2_vdd\x7cnwell_vdd\x7csb_vdd\x7csr1_vdd\x7csr2_vdd\x7csr3_vdd\x7csr4_vdd\x7csv_d_vdd_tie\x7csv_vdd\x7ctg_d_a\x7ctg_d_vdd\x7ctg_fbm_vdd\x7ctg_fbs_vdd\x7ctg_s_vdd\x7cvdd\x7cvdd_b1\x7cvdd_b2\x7cvdd_b3\x7cvdd_b4\x7cvdd_link\x7cvdd_link_dip\x7cvdd_x1\x7cvdd_x2\x7cvdd_x3__t132
+ a\x7cd\x7cinv_clk_vdd\x7cinv_mc_vdd\x7cinv_q_vdd\x7cmpa_py\x7cmpb_py\x7cnand_m_vdd\x7cnand_s2_vdd\x7cnwell_vdd\x7csb_vdd\x7csr1_vdd\x7csr2_vdd\x7csr3_vdd\x7csr4_vdd\x7csv_d_vdd_tie\x7csv_vdd\x7ctg_d_a\x7ctg_d_vdd\x7ctg_fbm_vdd\x7ctg_fbs_vdd\x7ctg_s_vdd\x7cvdd\x7cvdd_b1\x7cvdd_b2\x7cvdd_b3\x7cvdd_b4\x7cvdd_link\x7cvdd_link_dip\x7cvdd_x1\x7cvdd_x2\x7cvdd_x3__t73
+ sky130_fd_pr__pfet_01v8 L=0.15 W=0.84 AS=0.3948 AD=0.3948 PS=2.62 PD=2.62
* device instance $143 r0 *1 80.26,3.53 pfet
X$143 a\x7cinv_mc_y\x7cinv_mc_y_via\x7cmc\x7ctg_fbm_a\x7ctg_fbm_a_via\x7cy__t32
+ clkb\x7cclkb_bridge1\x7cclkb_bridge2\x7cclkb_mid\x7cclkb_w\x7cctrl\x7cctrlb\x7cinv_clk_y\x7ctg_d_ctrlb\x7ctg_fbm_ctrl\x7ctg_fbs_ctrlb\x7ctg_s_ctrl\x7cy__t52
+ a\x7cb\x7cm_east\x7cm_west\x7cnand_m_a\x7cnand_m_a_ext_via\x7cnand_m_a_ext_via2\x7cnand_m_a_stub\x7ctg_d_b\x7ctg_d_b_via\x7ctg_d_b_via2\x7ctg_fbm_b\x7ctg_fbm_b_alt_via\x7ctg_fbm_b_alt_via2__t42
+ a\x7cd\x7cinv_clk_vdd\x7cinv_mc_vdd\x7cinv_q_vdd\x7cmpa_py\x7cmpb_py\x7cnand_m_vdd\x7cnand_s2_vdd\x7cnwell_vdd\x7csb_vdd\x7csr1_vdd\x7csr2_vdd\x7csr3_vdd\x7csr4_vdd\x7csv_d_vdd_tie\x7csv_vdd\x7ctg_d_a\x7ctg_d_vdd\x7ctg_fbm_vdd\x7ctg_fbs_vdd\x7ctg_s_vdd\x7cvdd\x7cvdd_b1\x7cvdd_b2\x7cvdd_b3\x7cvdd_b4\x7cvdd_link\x7cvdd_link_dip\x7cvdd_x1\x7cvdd_x2\x7cvdd_x3__t85
+ sky130_fd_pr__pfet_01v8 L=0.15 W=0.84 AS=0.3948 AD=0.3948 PS=2.62 PD=2.62
* device instance $144 r0 *1 85.4,3.53 pfet
X$144
+ a\x7cinv_mc_a\x7cmb\x7cmnab_y\x7cmpa_y\x7cmpb_y\x7cnand_m_y\x7ctg_s_a\x7cy__t12
+ clkb\x7cclkb_bridge1\x7cclkb_bridge2\x7cclkb_mid\x7cclkb_w\x7cctrl\x7cctrlb\x7cinv_clk_y\x7ctg_d_ctrlb\x7ctg_fbm_ctrl\x7ctg_fbs_ctrlb\x7ctg_s_ctrl\x7cy__t42
+ a\x7cb\x7cinv_q_a\x7cinv_q_a_via\x7cs\x7ctg_fbs_b\x7ctg_fbs_b_via\x7ctg_s_b\x7ctg_s_b_via__t52
+ a\x7cd\x7cinv_clk_vdd\x7cinv_mc_vdd\x7cinv_q_vdd\x7cmpa_py\x7cmpb_py\x7cnand_m_vdd\x7cnand_s2_vdd\x7cnwell_vdd\x7csb_vdd\x7csr1_vdd\x7csr2_vdd\x7csr3_vdd\x7csr4_vdd\x7csv_d_vdd_tie\x7csv_vdd\x7ctg_d_a\x7ctg_d_vdd\x7ctg_fbm_vdd\x7ctg_fbs_vdd\x7ctg_s_vdd\x7cvdd\x7cvdd_b1\x7cvdd_b2\x7cvdd_b3\x7cvdd_b4\x7cvdd_link\x7cvdd_link_dip\x7cvdd_x1\x7cvdd_x2\x7cvdd_x3__t84
+ sky130_fd_pr__pfet_01v8 L=0.15 W=0.84 AS=0.3948 AD=0.3948 PS=2.62 PD=2.62
* device instance $145 r0 *1 92.205,3.53 pfet
X$145
+ a\x7cinv_q_y\x7cinv_q_y_via\x7cinv_q_y_via2\x7cnand_s2_a\x7cnand_s2_a_stub\x7cnand_s2_a_via\x7cnand_s2_a_via2\x7cq\x7cy__t12
+ a\x7cb\x7cinv_q_a\x7cinv_q_a_via\x7cs\x7ctg_fbs_b\x7ctg_fbs_b_via\x7ctg_s_b\x7ctg_s_b_via__t12
+ a\x7cd\x7cinv_clk_vdd\x7cinv_mc_vdd\x7cinv_q_vdd\x7cmpa_py\x7cmpb_py\x7cnand_m_vdd\x7cnand_s2_vdd\x7cnwell_vdd\x7csb_vdd\x7csr1_vdd\x7csr2_vdd\x7csr3_vdd\x7csr4_vdd\x7csv_d_vdd_tie\x7csv_vdd\x7ctg_d_a\x7ctg_d_vdd\x7ctg_fbm_vdd\x7ctg_fbs_vdd\x7ctg_s_vdd\x7cvdd\x7cvdd_b1\x7cvdd_b2\x7cvdd_b3\x7cvdd_b4\x7cvdd_link\x7cvdd_link_dip\x7cvdd_x1\x7cvdd_x2\x7cvdd_x3__t137
+ a\x7cd\x7cinv_clk_vdd\x7cinv_mc_vdd\x7cinv_q_vdd\x7cmpa_py\x7cmpb_py\x7cnand_m_vdd\x7cnand_s2_vdd\x7cnwell_vdd\x7csb_vdd\x7csr1_vdd\x7csr2_vdd\x7csr3_vdd\x7csr4_vdd\x7csv_d_vdd_tie\x7csv_vdd\x7ctg_d_a\x7ctg_d_vdd\x7ctg_fbm_vdd\x7ctg_fbs_vdd\x7ctg_s_vdd\x7cvdd\x7cvdd_b1\x7cvdd_b2\x7cvdd_b3\x7cvdd_b4\x7cvdd_link\x7cvdd_link_dip\x7cvdd_x1\x7cvdd_x2\x7cvdd_x3__t83
+ sky130_fd_pr__pfet_01v8 L=0.15 W=0.84 AS=0.3948 AD=0.3948 PS=2.62 PD=2.62
* device instance $146 r0 *1 104.69,3.53 pfet
X$146 a\x7cmnab_y\x7cmpa_y\x7cmpb_y\x7cnand_s2_y\x7cqb\x7ctg_fbs_a\x7cy__t22
+ a\x7cclk\x7cctrl\x7cctrlb\x7cinv_clk_a\x7cinv_clk_clk_via\x7ctg_d_ctrl\x7ctg_d_ctrl_via\x7ctg_fbm_ctrlb\x7ctg_fbm_ctrlb_via\x7ctg_fbs_ctrl\x7ctg_fbs_ctrl_via\x7ctg_s_ctrlb\x7ctg_s_ctrlb_via__t30
+ a\x7cb\x7cinv_q_a\x7cinv_q_a_via\x7cs\x7ctg_fbs_b\x7ctg_fbs_b_via\x7ctg_s_b\x7ctg_s_b_via__t42
+ a\x7cd\x7cinv_clk_vdd\x7cinv_mc_vdd\x7cinv_q_vdd\x7cmpa_py\x7cmpb_py\x7cnand_m_vdd\x7cnand_s2_vdd\x7cnwell_vdd\x7csb_vdd\x7csr1_vdd\x7csr2_vdd\x7csr3_vdd\x7csr4_vdd\x7csv_d_vdd_tie\x7csv_vdd\x7ctg_d_a\x7ctg_d_vdd\x7ctg_fbm_vdd\x7ctg_fbs_vdd\x7ctg_s_vdd\x7cvdd\x7cvdd_b1\x7cvdd_b2\x7cvdd_b3\x7cvdd_b4\x7cvdd_link\x7cvdd_link_dip\x7cvdd_x1\x7cvdd_x2\x7cvdd_x3__t82
+ sky130_fd_pr__pfet_01v8 L=0.15 W=0.84 AS=0.3948 AD=0.3948 PS=2.62 PD=2.62
* device instance $147 r0 *1 111.865,3.53 pfet
X$147
+ clkb\x7cclkb_bridge1\x7cclkb_bridge2\x7cclkb_mid\x7cclkb_w\x7cctrl\x7cctrlb\x7cinv_clk_y\x7ctg_d_ctrlb\x7ctg_fbm_ctrl\x7ctg_fbs_ctrlb\x7ctg_s_ctrl\x7cy__t13
+ a\x7cclk\x7cctrl\x7cctrlb\x7cinv_clk_a\x7cinv_clk_clk_via\x7ctg_d_ctrl\x7ctg_d_ctrl_via\x7ctg_fbm_ctrlb\x7ctg_fbm_ctrlb_via\x7ctg_fbs_ctrl\x7ctg_fbs_ctrl_via\x7ctg_s_ctrlb\x7ctg_s_ctrlb_via__t29
+ a\x7cd\x7cinv_clk_vdd\x7cinv_mc_vdd\x7cinv_q_vdd\x7cmpa_py\x7cmpb_py\x7cnand_m_vdd\x7cnand_s2_vdd\x7cnwell_vdd\x7csb_vdd\x7csr1_vdd\x7csr2_vdd\x7csr3_vdd\x7csr4_vdd\x7csv_d_vdd_tie\x7csv_vdd\x7ctg_d_a\x7ctg_d_vdd\x7ctg_fbm_vdd\x7ctg_fbs_vdd\x7ctg_s_vdd\x7cvdd\x7cvdd_b1\x7cvdd_b2\x7cvdd_b3\x7cvdd_b4\x7cvdd_link\x7cvdd_link_dip\x7cvdd_x1\x7cvdd_x2\x7cvdd_x3__t136
+ a\x7cd\x7cinv_clk_vdd\x7cinv_mc_vdd\x7cinv_q_vdd\x7cmpa_py\x7cmpb_py\x7cnand_m_vdd\x7cnand_s2_vdd\x7cnwell_vdd\x7csb_vdd\x7csr1_vdd\x7csr2_vdd\x7csr3_vdd\x7csr4_vdd\x7csv_d_vdd_tie\x7csv_vdd\x7ctg_d_a\x7ctg_d_vdd\x7ctg_fbm_vdd\x7ctg_fbs_vdd\x7ctg_s_vdd\x7cvdd\x7cvdd_b1\x7cvdd_b2\x7cvdd_b3\x7cvdd_b4\x7cvdd_link\x7cvdd_link_dip\x7cvdd_x1\x7cvdd_x2\x7cvdd_x3__t81
+ sky130_fd_pr__pfet_01v8 L=0.15 W=0.84 AS=0.3948 AD=0.3948 PS=2.62 PD=2.62
* device instance $148 r0 *1 116.63,3.53 pfet
X$148
+ a\x7cd\x7cinva_a\x7cmn12_g0\x7cmp13_g0\x7cro1\x7cro1_esc\x7csr1_d_stub\x7ctg_d_a\x7cy__t4
+ a\x7cclk\x7cctrl\x7cctrlb\x7cinv_clk_a\x7cinv_clk_clk_via\x7ctg_d_ctrl\x7ctg_d_ctrl_via\x7ctg_fbm_ctrlb\x7ctg_fbm_ctrlb_via\x7ctg_fbs_ctrl\x7ctg_fbs_ctrl_via\x7ctg_s_ctrlb\x7ctg_s_ctrlb_via__t28
+ a\x7cb\x7cm_east\x7cm_west\x7cnand_m_a\x7cnand_m_a_ext_via\x7cnand_m_a_ext_via2\x7cnand_m_a_stub\x7ctg_d_b\x7ctg_d_b_via\x7ctg_d_b_via2\x7ctg_fbm_b\x7ctg_fbm_b_alt_via\x7ctg_fbm_b_alt_via2__t43
+ a\x7cd\x7cinv_clk_vdd\x7cinv_mc_vdd\x7cinv_q_vdd\x7cmpa_py\x7cmpb_py\x7cnand_m_vdd\x7cnand_s2_vdd\x7cnwell_vdd\x7csb_vdd\x7csr1_vdd\x7csr2_vdd\x7csr3_vdd\x7csr4_vdd\x7csv_d_vdd_tie\x7csv_vdd\x7ctg_d_a\x7ctg_d_vdd\x7ctg_fbm_vdd\x7ctg_fbs_vdd\x7ctg_s_vdd\x7cvdd\x7cvdd_b1\x7cvdd_b2\x7cvdd_b3\x7cvdd_b4\x7cvdd_link\x7cvdd_link_dip\x7cvdd_x1\x7cvdd_x2\x7cvdd_x3__t80
+ sky130_fd_pr__pfet_01v8 L=0.15 W=0.84 AS=0.3948 AD=0.3948 PS=2.62 PD=2.62
* device instance $149 r0 *1 131.155,3.53 pfet
X$149 a\x7cinv_mc_y\x7cinv_mc_y_via\x7cmc\x7ctg_fbm_a\x7ctg_fbm_a_via\x7cy__t33
+ a\x7cinv_mc_a\x7cmb\x7cmnab_y\x7cmpa_y\x7cmpb_y\x7cnand_m_y\x7ctg_s_a\x7cy__t43
+ a\x7cd\x7cinv_clk_vdd\x7cinv_mc_vdd\x7cinv_q_vdd\x7cmpa_py\x7cmpb_py\x7cnand_m_vdd\x7cnand_s2_vdd\x7cnwell_vdd\x7csb_vdd\x7csr1_vdd\x7csr2_vdd\x7csr3_vdd\x7csr4_vdd\x7csv_d_vdd_tie\x7csv_vdd\x7ctg_d_a\x7ctg_d_vdd\x7ctg_fbm_vdd\x7ctg_fbs_vdd\x7ctg_s_vdd\x7cvdd\x7cvdd_b1\x7cvdd_b2\x7cvdd_b3\x7cvdd_b4\x7cvdd_link\x7cvdd_link_dip\x7cvdd_x1\x7cvdd_x2\x7cvdd_x3__t135
+ a\x7cd\x7cinv_clk_vdd\x7cinv_mc_vdd\x7cinv_q_vdd\x7cmpa_py\x7cmpb_py\x7cnand_m_vdd\x7cnand_s2_vdd\x7cnwell_vdd\x7csb_vdd\x7csr1_vdd\x7csr2_vdd\x7csr3_vdd\x7csr4_vdd\x7csv_d_vdd_tie\x7csv_vdd\x7ctg_d_a\x7ctg_d_vdd\x7ctg_fbm_vdd\x7ctg_fbs_vdd\x7ctg_s_vdd\x7cvdd\x7cvdd_b1\x7cvdd_b2\x7cvdd_b3\x7cvdd_b4\x7cvdd_link\x7cvdd_link_dip\x7cvdd_x1\x7cvdd_x2\x7cvdd_x3__t79
+ sky130_fd_pr__pfet_01v8 L=0.15 W=0.84 AS=0.3948 AD=0.3948 PS=2.62 PD=2.62
* device instance $150 r0 *1 135.92,3.53 pfet
X$150 a\x7cinv_mc_y\x7cinv_mc_y_via\x7cmc\x7ctg_fbm_a\x7ctg_fbm_a_via\x7cy__t23
+ clkb\x7cclkb_bridge1\x7cclkb_bridge2\x7cclkb_mid\x7cclkb_w\x7cctrl\x7cctrlb\x7cinv_clk_y\x7ctg_d_ctrlb\x7ctg_fbm_ctrl\x7ctg_fbs_ctrlb\x7ctg_s_ctrl\x7cy__t43
+ a\x7cb\x7cm_east\x7cm_west\x7cnand_m_a\x7cnand_m_a_ext_via\x7cnand_m_a_ext_via2\x7cnand_m_a_stub\x7ctg_d_b\x7ctg_d_b_via\x7ctg_d_b_via2\x7ctg_fbm_b\x7ctg_fbm_b_alt_via\x7ctg_fbm_b_alt_via2__t33
+ a\x7cd\x7cinv_clk_vdd\x7cinv_mc_vdd\x7cinv_q_vdd\x7cmpa_py\x7cmpb_py\x7cnand_m_vdd\x7cnand_s2_vdd\x7cnwell_vdd\x7csb_vdd\x7csr1_vdd\x7csr2_vdd\x7csr3_vdd\x7csr4_vdd\x7csv_d_vdd_tie\x7csv_vdd\x7ctg_d_a\x7ctg_d_vdd\x7ctg_fbm_vdd\x7ctg_fbs_vdd\x7ctg_s_vdd\x7cvdd\x7cvdd_b1\x7cvdd_b2\x7cvdd_b3\x7cvdd_b4\x7cvdd_link\x7cvdd_link_dip\x7cvdd_x1\x7cvdd_x2\x7cvdd_x3__t78
+ sky130_fd_pr__pfet_01v8 L=0.15 W=0.84 AS=0.3948 AD=0.3948 PS=2.62 PD=2.62
* device instance $151 r0 *1 141.06,3.53 pfet
X$151
+ a\x7cinv_mc_a\x7cmb\x7cmnab_y\x7cmpa_y\x7cmpb_y\x7cnand_m_y\x7ctg_s_a\x7cy__t23
+ clkb\x7cclkb_bridge1\x7cclkb_bridge2\x7cclkb_mid\x7cclkb_w\x7cctrl\x7cctrlb\x7cinv_clk_y\x7ctg_d_ctrlb\x7ctg_fbm_ctrl\x7ctg_fbs_ctrlb\x7ctg_s_ctrl\x7cy__t53
+ a\x7cb\x7cinv_q_a\x7cinv_q_a_via\x7cs\x7ctg_fbs_b\x7ctg_fbs_b_via\x7ctg_s_b\x7ctg_s_b_via__t53
+ a\x7cd\x7cinv_clk_vdd\x7cinv_mc_vdd\x7cinv_q_vdd\x7cmpa_py\x7cmpb_py\x7cnand_m_vdd\x7cnand_s2_vdd\x7cnwell_vdd\x7csb_vdd\x7csr1_vdd\x7csr2_vdd\x7csr3_vdd\x7csr4_vdd\x7csv_d_vdd_tie\x7csv_vdd\x7ctg_d_a\x7ctg_d_vdd\x7ctg_fbm_vdd\x7ctg_fbs_vdd\x7ctg_s_vdd\x7cvdd\x7cvdd_b1\x7cvdd_b2\x7cvdd_b3\x7cvdd_b4\x7cvdd_link\x7cvdd_link_dip\x7cvdd_x1\x7cvdd_x2\x7cvdd_x3__t100
+ sky130_fd_pr__pfet_01v8 L=0.15 W=0.84 AS=0.3948 AD=0.3948 PS=2.62 PD=2.62
* device instance $152 r0 *1 147.865,3.53 pfet
X$152
+ a\x7cinv_q_y\x7cinv_q_y_via\x7cinv_q_y_via2\x7cnand_s2_a\x7cnand_s2_a_stub\x7cnand_s2_a_via\x7cnand_s2_a_via2\x7cq\x7cy__t13
+ a\x7cb\x7cinv_q_a\x7cinv_q_a_via\x7cs\x7ctg_fbs_b\x7ctg_fbs_b_via\x7ctg_s_b\x7ctg_s_b_via__t13
+ a\x7cd\x7cinv_clk_vdd\x7cinv_mc_vdd\x7cinv_q_vdd\x7cmpa_py\x7cmpb_py\x7cnand_m_vdd\x7cnand_s2_vdd\x7cnwell_vdd\x7csb_vdd\x7csr1_vdd\x7csr2_vdd\x7csr3_vdd\x7csr4_vdd\x7csv_d_vdd_tie\x7csv_vdd\x7ctg_d_a\x7ctg_d_vdd\x7ctg_fbm_vdd\x7ctg_fbs_vdd\x7ctg_s_vdd\x7cvdd\x7cvdd_b1\x7cvdd_b2\x7cvdd_b3\x7cvdd_b4\x7cvdd_link\x7cvdd_link_dip\x7cvdd_x1\x7cvdd_x2\x7cvdd_x3__t143
+ a\x7cd\x7cinv_clk_vdd\x7cinv_mc_vdd\x7cinv_q_vdd\x7cmpa_py\x7cmpb_py\x7cnand_m_vdd\x7cnand_s2_vdd\x7cnwell_vdd\x7csb_vdd\x7csr1_vdd\x7csr2_vdd\x7csr3_vdd\x7csr4_vdd\x7csv_d_vdd_tie\x7csv_vdd\x7ctg_d_a\x7ctg_d_vdd\x7ctg_fbm_vdd\x7ctg_fbs_vdd\x7ctg_s_vdd\x7cvdd\x7cvdd_b1\x7cvdd_b2\x7cvdd_b3\x7cvdd_b4\x7cvdd_link\x7cvdd_link_dip\x7cvdd_x1\x7cvdd_x2\x7cvdd_x3__t98
+ sky130_fd_pr__pfet_01v8 L=0.15 W=0.84 AS=0.3948 AD=0.3948 PS=2.62 PD=2.62
* device instance $153 r0 *1 160.35,3.53 pfet
X$153 a\x7cmnab_y\x7cmpa_y\x7cmpb_y\x7cnand_s2_y\x7cqb\x7ctg_fbs_a\x7cy__t23
+ a\x7cclk\x7cctrl\x7cctrlb\x7cinv_clk_a\x7cinv_clk_clk_via\x7ctg_d_ctrl\x7ctg_d_ctrl_via\x7ctg_fbm_ctrlb\x7ctg_fbm_ctrlb_via\x7ctg_fbs_ctrl\x7ctg_fbs_ctrl_via\x7ctg_s_ctrlb\x7ctg_s_ctrlb_via__t34
+ a\x7cb\x7cinv_q_a\x7cinv_q_a_via\x7cs\x7ctg_fbs_b\x7ctg_fbs_b_via\x7ctg_s_b\x7ctg_s_b_via__t43
+ a\x7cd\x7cinv_clk_vdd\x7cinv_mc_vdd\x7cinv_q_vdd\x7cmpa_py\x7cmpb_py\x7cnand_m_vdd\x7cnand_s2_vdd\x7cnwell_vdd\x7csb_vdd\x7csr1_vdd\x7csr2_vdd\x7csr3_vdd\x7csr4_vdd\x7csv_d_vdd_tie\x7csv_vdd\x7ctg_d_a\x7ctg_d_vdd\x7ctg_fbm_vdd\x7ctg_fbs_vdd\x7ctg_s_vdd\x7cvdd\x7cvdd_b1\x7cvdd_b2\x7cvdd_b3\x7cvdd_b4\x7cvdd_link\x7cvdd_link_dip\x7cvdd_x1\x7cvdd_x2\x7cvdd_x3__t97
+ sky130_fd_pr__pfet_01v8 L=0.15 W=0.84 AS=0.3948 AD=0.3948 PS=2.62 PD=2.62
* device instance $154 r0 *1 167.525,3.53 pfet
X$154
+ clkb\x7cclkb_bridge1\x7cclkb_bridge2\x7cclkb_mid\x7cclkb_w\x7cctrl\x7cctrlb\x7cinv_clk_y\x7ctg_d_ctrlb\x7ctg_fbm_ctrl\x7ctg_fbs_ctrlb\x7ctg_s_ctrl\x7cy__t14
+ a\x7cclk\x7cctrl\x7cctrlb\x7cinv_clk_a\x7cinv_clk_clk_via\x7ctg_d_ctrl\x7ctg_d_ctrl_via\x7ctg_fbm_ctrlb\x7ctg_fbm_ctrlb_via\x7ctg_fbs_ctrl\x7ctg_fbs_ctrl_via\x7ctg_s_ctrlb\x7ctg_s_ctrlb_via__t27
+ a\x7cd\x7cinv_clk_vdd\x7cinv_mc_vdd\x7cinv_q_vdd\x7cmpa_py\x7cmpb_py\x7cnand_m_vdd\x7cnand_s2_vdd\x7cnwell_vdd\x7csb_vdd\x7csr1_vdd\x7csr2_vdd\x7csr3_vdd\x7csr4_vdd\x7csv_d_vdd_tie\x7csv_vdd\x7ctg_d_a\x7ctg_d_vdd\x7ctg_fbm_vdd\x7ctg_fbs_vdd\x7ctg_s_vdd\x7cvdd\x7cvdd_b1\x7cvdd_b2\x7cvdd_b3\x7cvdd_b4\x7cvdd_link\x7cvdd_link_dip\x7cvdd_x1\x7cvdd_x2\x7cvdd_x3__t133
+ a\x7cd\x7cinv_clk_vdd\x7cinv_mc_vdd\x7cinv_q_vdd\x7cmpa_py\x7cmpb_py\x7cnand_m_vdd\x7cnand_s2_vdd\x7cnwell_vdd\x7csb_vdd\x7csr1_vdd\x7csr2_vdd\x7csr3_vdd\x7csr4_vdd\x7csv_d_vdd_tie\x7csv_vdd\x7ctg_d_a\x7ctg_d_vdd\x7ctg_fbm_vdd\x7ctg_fbs_vdd\x7ctg_s_vdd\x7cvdd\x7cvdd_b1\x7cvdd_b2\x7cvdd_b3\x7cvdd_b4\x7cvdd_link\x7cvdd_link_dip\x7cvdd_x1\x7cvdd_x2\x7cvdd_x3__t75
+ sky130_fd_pr__pfet_01v8 L=0.15 W=0.84 AS=0.3948 AD=0.3948 PS=2.62 PD=2.62
* device instance $155 r0 *1 172.29,3.53 pfet
X$155
+ a\x7cb\x7cd\x7cinvb_a\x7cmn12_g1\x7cmp24_g0\x7cro2\x7cro2_esc\x7csr2_d_stub\x7ctg_d_a\x7cy__t4
+ a\x7cclk\x7cctrl\x7cctrlb\x7cinv_clk_a\x7cinv_clk_clk_via\x7ctg_d_ctrl\x7ctg_d_ctrl_via\x7ctg_fbm_ctrlb\x7ctg_fbm_ctrlb_via\x7ctg_fbs_ctrl\x7ctg_fbs_ctrl_via\x7ctg_s_ctrlb\x7ctg_s_ctrlb_via__t35
+ a\x7cb\x7cm_east\x7cm_west\x7cnand_m_a\x7cnand_m_a_ext_via\x7cnand_m_a_ext_via2\x7cnand_m_a_stub\x7ctg_d_b\x7ctg_d_b_via\x7ctg_d_b_via2\x7ctg_fbm_b\x7ctg_fbm_b_alt_via\x7ctg_fbm_b_alt_via2__t44
+ a\x7cd\x7cinv_clk_vdd\x7cinv_mc_vdd\x7cinv_q_vdd\x7cmpa_py\x7cmpb_py\x7cnand_m_vdd\x7cnand_s2_vdd\x7cnwell_vdd\x7csb_vdd\x7csr1_vdd\x7csr2_vdd\x7csr3_vdd\x7csr4_vdd\x7csv_d_vdd_tie\x7csv_vdd\x7ctg_d_a\x7ctg_d_vdd\x7ctg_fbm_vdd\x7ctg_fbs_vdd\x7ctg_s_vdd\x7cvdd\x7cvdd_b1\x7cvdd_b2\x7cvdd_b3\x7cvdd_b4\x7cvdd_link\x7cvdd_link_dip\x7cvdd_x1\x7cvdd_x2\x7cvdd_x3__t106
+ sky130_fd_pr__pfet_01v8 L=0.15 W=0.84 AS=0.3948 AD=0.3948 PS=2.62 PD=2.62
* device instance $156 r0 *1 186.815,3.53 pfet
X$156 a\x7cinv_mc_y\x7cinv_mc_y_via\x7cmc\x7ctg_fbm_a\x7ctg_fbm_a_via\x7cy__t34
+ a\x7cinv_mc_a\x7cmb\x7cmnab_y\x7cmpa_y\x7cmpb_y\x7cnand_m_y\x7ctg_s_a\x7cy__t44
+ a\x7cd\x7cinv_clk_vdd\x7cinv_mc_vdd\x7cinv_q_vdd\x7cmpa_py\x7cmpb_py\x7cnand_m_vdd\x7cnand_s2_vdd\x7cnwell_vdd\x7csb_vdd\x7csr1_vdd\x7csr2_vdd\x7csr3_vdd\x7csr4_vdd\x7csv_d_vdd_tie\x7csv_vdd\x7ctg_d_a\x7ctg_d_vdd\x7ctg_fbm_vdd\x7ctg_fbs_vdd\x7ctg_s_vdd\x7cvdd\x7cvdd_b1\x7cvdd_b2\x7cvdd_b3\x7cvdd_b4\x7cvdd_link\x7cvdd_link_dip\x7cvdd_x1\x7cvdd_x2\x7cvdd_x3__t146
+ a\x7cd\x7cinv_clk_vdd\x7cinv_mc_vdd\x7cinv_q_vdd\x7cmpa_py\x7cmpb_py\x7cnand_m_vdd\x7cnand_s2_vdd\x7cnwell_vdd\x7csb_vdd\x7csr1_vdd\x7csr2_vdd\x7csr3_vdd\x7csr4_vdd\x7csv_d_vdd_tie\x7csv_vdd\x7ctg_d_a\x7ctg_d_vdd\x7ctg_fbm_vdd\x7ctg_fbs_vdd\x7ctg_s_vdd\x7cvdd\x7cvdd_b1\x7cvdd_b2\x7cvdd_b3\x7cvdd_b4\x7cvdd_link\x7cvdd_link_dip\x7cvdd_x1\x7cvdd_x2\x7cvdd_x3__t105
+ sky130_fd_pr__pfet_01v8 L=0.15 W=0.84 AS=0.3948 AD=0.3948 PS=2.62 PD=2.62
* device instance $157 r0 *1 191.58,3.53 pfet
X$157 a\x7cinv_mc_y\x7cinv_mc_y_via\x7cmc\x7ctg_fbm_a\x7ctg_fbm_a_via\x7cy__t24
+ clkb\x7cclkb_bridge1\x7cclkb_bridge2\x7cclkb_mid\x7cclkb_w\x7cctrl\x7cctrlb\x7cinv_clk_y\x7ctg_d_ctrlb\x7ctg_fbm_ctrl\x7ctg_fbs_ctrlb\x7ctg_s_ctrl\x7cy__t54
+ a\x7cb\x7cm_east\x7cm_west\x7cnand_m_a\x7cnand_m_a_ext_via\x7cnand_m_a_ext_via2\x7cnand_m_a_stub\x7ctg_d_b\x7ctg_d_b_via\x7ctg_d_b_via2\x7ctg_fbm_b\x7ctg_fbm_b_alt_via\x7ctg_fbm_b_alt_via2__t34
+ a\x7cd\x7cinv_clk_vdd\x7cinv_mc_vdd\x7cinv_q_vdd\x7cmpa_py\x7cmpb_py\x7cnand_m_vdd\x7cnand_s2_vdd\x7cnwell_vdd\x7csb_vdd\x7csr1_vdd\x7csr2_vdd\x7csr3_vdd\x7csr4_vdd\x7csv_d_vdd_tie\x7csv_vdd\x7ctg_d_a\x7ctg_d_vdd\x7ctg_fbm_vdd\x7ctg_fbs_vdd\x7ctg_s_vdd\x7cvdd\x7cvdd_b1\x7cvdd_b2\x7cvdd_b3\x7cvdd_b4\x7cvdd_link\x7cvdd_link_dip\x7cvdd_x1\x7cvdd_x2\x7cvdd_x3__t104
+ sky130_fd_pr__pfet_01v8 L=0.15 W=0.84 AS=0.3948 AD=0.3948 PS=2.62 PD=2.62
* device instance $158 r0 *1 196.72,3.53 pfet
X$158
+ a\x7cinv_mc_a\x7cmb\x7cmnab_y\x7cmpa_y\x7cmpb_y\x7cnand_m_y\x7ctg_s_a\x7cy__t24
+ clkb\x7cclkb_bridge1\x7cclkb_bridge2\x7cclkb_mid\x7cclkb_w\x7cctrl\x7cctrlb\x7cinv_clk_y\x7ctg_d_ctrlb\x7ctg_fbm_ctrl\x7ctg_fbs_ctrlb\x7ctg_s_ctrl\x7cy__t44
+ a\x7cb\x7cinv_q_a\x7cinv_q_a_via\x7cs\x7ctg_fbs_b\x7ctg_fbs_b_via\x7ctg_s_b\x7ctg_s_b_via__t54
+ a\x7cd\x7cinv_clk_vdd\x7cinv_mc_vdd\x7cinv_q_vdd\x7cmpa_py\x7cmpb_py\x7cnand_m_vdd\x7cnand_s2_vdd\x7cnwell_vdd\x7csb_vdd\x7csr1_vdd\x7csr2_vdd\x7csr3_vdd\x7csr4_vdd\x7csv_d_vdd_tie\x7csv_vdd\x7ctg_d_a\x7ctg_d_vdd\x7ctg_fbm_vdd\x7ctg_fbs_vdd\x7ctg_s_vdd\x7cvdd\x7cvdd_b1\x7cvdd_b2\x7cvdd_b3\x7cvdd_b4\x7cvdd_link\x7cvdd_link_dip\x7cvdd_x1\x7cvdd_x2\x7cvdd_x3__t101
+ sky130_fd_pr__pfet_01v8 L=0.15 W=0.84 AS=0.3948 AD=0.3948 PS=2.62 PD=2.62
* device instance $159 r0 *1 203.525,3.53 pfet
X$159
+ a\x7cinv_q_y\x7cinv_q_y_via\x7cinv_q_y_via2\x7cnand_s2_a\x7cnand_s2_a_stub\x7cnand_s2_a_via\x7cnand_s2_a_via2\x7cq\x7cy__t14
+ a\x7cb\x7cinv_q_a\x7cinv_q_a_via\x7cs\x7ctg_fbs_b\x7ctg_fbs_b_via\x7ctg_s_b\x7ctg_s_b_via__t14
+ a\x7cd\x7cinv_clk_vdd\x7cinv_mc_vdd\x7cinv_q_vdd\x7cmpa_py\x7cmpb_py\x7cnand_m_vdd\x7cnand_s2_vdd\x7cnwell_vdd\x7csb_vdd\x7csr1_vdd\x7csr2_vdd\x7csr3_vdd\x7csr4_vdd\x7csv_d_vdd_tie\x7csv_vdd\x7ctg_d_a\x7ctg_d_vdd\x7ctg_fbm_vdd\x7ctg_fbs_vdd\x7ctg_s_vdd\x7cvdd\x7cvdd_b1\x7cvdd_b2\x7cvdd_b3\x7cvdd_b4\x7cvdd_link\x7cvdd_link_dip\x7cvdd_x1\x7cvdd_x2\x7cvdd_x3__t144
+ a\x7cd\x7cinv_clk_vdd\x7cinv_mc_vdd\x7cinv_q_vdd\x7cmpa_py\x7cmpb_py\x7cnand_m_vdd\x7cnand_s2_vdd\x7cnwell_vdd\x7csb_vdd\x7csr1_vdd\x7csr2_vdd\x7csr3_vdd\x7csr4_vdd\x7csv_d_vdd_tie\x7csv_vdd\x7ctg_d_a\x7ctg_d_vdd\x7ctg_fbm_vdd\x7ctg_fbs_vdd\x7ctg_s_vdd\x7cvdd\x7cvdd_b1\x7cvdd_b2\x7cvdd_b3\x7cvdd_b4\x7cvdd_link\x7cvdd_link_dip\x7cvdd_x1\x7cvdd_x2\x7cvdd_x3__t99
+ sky130_fd_pr__pfet_01v8 L=0.15 W=0.84 AS=0.3948 AD=0.3948 PS=2.62 PD=2.62
* device instance $160 r0 *1 216.01,3.53 pfet
X$160 a\x7cmnab_y\x7cmpa_y\x7cmpb_y\x7cnand_s2_y\x7cqb\x7ctg_fbs_a\x7cy__t24
+ a\x7cclk\x7cctrl\x7cctrlb\x7cinv_clk_a\x7cinv_clk_clk_via\x7ctg_d_ctrl\x7ctg_d_ctrl_via\x7ctg_fbm_ctrlb\x7ctg_fbm_ctrlb_via\x7ctg_fbs_ctrl\x7ctg_fbs_ctrl_via\x7ctg_s_ctrlb\x7ctg_s_ctrlb_via__t33
+ a\x7cb\x7cinv_q_a\x7cinv_q_a_via\x7cs\x7ctg_fbs_b\x7ctg_fbs_b_via\x7ctg_s_b\x7ctg_s_b_via__t44
+ a\x7cd\x7cinv_clk_vdd\x7cinv_mc_vdd\x7cinv_q_vdd\x7cmpa_py\x7cmpb_py\x7cnand_m_vdd\x7cnand_s2_vdd\x7cnwell_vdd\x7csb_vdd\x7csr1_vdd\x7csr2_vdd\x7csr3_vdd\x7csr4_vdd\x7csv_d_vdd_tie\x7csv_vdd\x7ctg_d_a\x7ctg_d_vdd\x7ctg_fbm_vdd\x7ctg_fbs_vdd\x7ctg_s_vdd\x7cvdd\x7cvdd_b1\x7cvdd_b2\x7cvdd_b3\x7cvdd_b4\x7cvdd_link\x7cvdd_link_dip\x7cvdd_x1\x7cvdd_x2\x7cvdd_x3__t93
+ sky130_fd_pr__pfet_01v8 L=0.15 W=0.84 AS=0.3948 AD=0.3948 PS=2.62 PD=2.62
* device instance $161 r0 *1 223.185,3.53 pfet
X$161
+ clkb\x7cclkb_bridge1\x7cclkb_bridge2\x7cclkb_mid\x7cclkb_w\x7cctrl\x7cctrlb\x7cinv_clk_y\x7ctg_d_ctrlb\x7ctg_fbm_ctrl\x7ctg_fbs_ctrlb\x7ctg_s_ctrl\x7cy__t15
+ a\x7cclk\x7cctrl\x7cctrlb\x7cinv_clk_a\x7cinv_clk_clk_via\x7ctg_d_ctrl\x7ctg_d_ctrl_via\x7ctg_fbm_ctrlb\x7ctg_fbm_ctrlb_via\x7ctg_fbs_ctrl\x7ctg_fbs_ctrl_via\x7ctg_s_ctrlb\x7ctg_s_ctrlb_via__t32
+ a\x7cd\x7cinv_clk_vdd\x7cinv_mc_vdd\x7cinv_q_vdd\x7cmpa_py\x7cmpb_py\x7cnand_m_vdd\x7cnand_s2_vdd\x7cnwell_vdd\x7csb_vdd\x7csr1_vdd\x7csr2_vdd\x7csr3_vdd\x7csr4_vdd\x7csv_d_vdd_tie\x7csv_vdd\x7ctg_d_a\x7ctg_d_vdd\x7ctg_fbm_vdd\x7ctg_fbs_vdd\x7ctg_s_vdd\x7cvdd\x7cvdd_b1\x7cvdd_b2\x7cvdd_b3\x7cvdd_b4\x7cvdd_link\x7cvdd_link_dip\x7cvdd_x1\x7cvdd_x2\x7cvdd_x3__t139
+ a\x7cd\x7cinv_clk_vdd\x7cinv_mc_vdd\x7cinv_q_vdd\x7cmpa_py\x7cmpb_py\x7cnand_m_vdd\x7cnand_s2_vdd\x7cnwell_vdd\x7csb_vdd\x7csr1_vdd\x7csr2_vdd\x7csr3_vdd\x7csr4_vdd\x7csv_d_vdd_tie\x7csv_vdd\x7ctg_d_a\x7ctg_d_vdd\x7ctg_fbm_vdd\x7ctg_fbs_vdd\x7ctg_s_vdd\x7cvdd\x7cvdd_b1\x7cvdd_b2\x7cvdd_b3\x7cvdd_b4\x7cvdd_link\x7cvdd_link_dip\x7cvdd_x1\x7cvdd_x2\x7cvdd_x3__t90
+ sky130_fd_pr__pfet_01v8 L=0.15 W=0.84 AS=0.3948 AD=0.3948 PS=2.62 PD=2.62
* device instance $162 r0 *1 227.95,3.53 pfet
X$162
+ a\x7cd\x7cinva_a\x7cmn12_g0\x7cmp13_g0\x7cro3\x7cro3_esc_e\x7cro3_esc_w\x7cro3_hop\x7csr3_d_stub\x7ctg_d_a\x7cy__t4
+ a\x7cclk\x7cctrl\x7cctrlb\x7cinv_clk_a\x7cinv_clk_clk_via\x7ctg_d_ctrl\x7ctg_d_ctrl_via\x7ctg_fbm_ctrlb\x7ctg_fbm_ctrlb_via\x7ctg_fbs_ctrl\x7ctg_fbs_ctrl_via\x7ctg_s_ctrlb\x7ctg_s_ctrlb_via__t31
+ a\x7cb\x7cm_east\x7cm_west\x7cnand_m_a\x7cnand_m_a_ext_via\x7cnand_m_a_ext_via2\x7cnand_m_a_stub\x7ctg_d_b\x7ctg_d_b_via\x7ctg_d_b_via2\x7ctg_fbm_b\x7ctg_fbm_b_alt_via\x7ctg_fbm_b_alt_via2__t45
+ a\x7cd\x7cinv_clk_vdd\x7cinv_mc_vdd\x7cinv_q_vdd\x7cmpa_py\x7cmpb_py\x7cnand_m_vdd\x7cnand_s2_vdd\x7cnwell_vdd\x7csb_vdd\x7csr1_vdd\x7csr2_vdd\x7csr3_vdd\x7csr4_vdd\x7csv_d_vdd_tie\x7csv_vdd\x7ctg_d_a\x7ctg_d_vdd\x7ctg_fbm_vdd\x7ctg_fbs_vdd\x7ctg_s_vdd\x7cvdd\x7cvdd_b1\x7cvdd_b2\x7cvdd_b3\x7cvdd_b4\x7cvdd_link\x7cvdd_link_dip\x7cvdd_x1\x7cvdd_x2\x7cvdd_x3__t89
+ sky130_fd_pr__pfet_01v8 L=0.15 W=0.84 AS=0.3948 AD=0.3948 PS=2.62 PD=2.62
* device instance $163 r0 *1 242.475,3.53 pfet
X$163 a\x7cinv_mc_y\x7cinv_mc_y_via\x7cmc\x7ctg_fbm_a\x7ctg_fbm_a_via\x7cy__t35
+ a\x7cinv_mc_a\x7cmb\x7cmnab_y\x7cmpa_y\x7cmpb_y\x7cnand_m_y\x7ctg_s_a\x7cy__t45
+ a\x7cd\x7cinv_clk_vdd\x7cinv_mc_vdd\x7cinv_q_vdd\x7cmpa_py\x7cmpb_py\x7cnand_m_vdd\x7cnand_s2_vdd\x7cnwell_vdd\x7csb_vdd\x7csr1_vdd\x7csr2_vdd\x7csr3_vdd\x7csr4_vdd\x7csv_d_vdd_tie\x7csv_vdd\x7ctg_d_a\x7ctg_d_vdd\x7ctg_fbm_vdd\x7ctg_fbs_vdd\x7ctg_s_vdd\x7cvdd\x7cvdd_b1\x7cvdd_b2\x7cvdd_b3\x7cvdd_b4\x7cvdd_link\x7cvdd_link_dip\x7cvdd_x1\x7cvdd_x2\x7cvdd_x3__t138
+ a\x7cd\x7cinv_clk_vdd\x7cinv_mc_vdd\x7cinv_q_vdd\x7cmpa_py\x7cmpb_py\x7cnand_m_vdd\x7cnand_s2_vdd\x7cnwell_vdd\x7csb_vdd\x7csr1_vdd\x7csr2_vdd\x7csr3_vdd\x7csr4_vdd\x7csv_d_vdd_tie\x7csv_vdd\x7ctg_d_a\x7ctg_d_vdd\x7ctg_fbm_vdd\x7ctg_fbs_vdd\x7ctg_s_vdd\x7cvdd\x7cvdd_b1\x7cvdd_b2\x7cvdd_b3\x7cvdd_b4\x7cvdd_link\x7cvdd_link_dip\x7cvdd_x1\x7cvdd_x2\x7cvdd_x3__t87
+ sky130_fd_pr__pfet_01v8 L=0.15 W=0.84 AS=0.3948 AD=0.3948 PS=2.62 PD=2.62
* device instance $164 r0 *1 247.24,3.53 pfet
X$164 a\x7cinv_mc_y\x7cinv_mc_y_via\x7cmc\x7ctg_fbm_a\x7ctg_fbm_a_via\x7cy__t25
+ clkb\x7cclkb_bridge1\x7cclkb_bridge2\x7cclkb_mid\x7cclkb_w\x7cctrl\x7cctrlb\x7cinv_clk_y\x7ctg_d_ctrlb\x7ctg_fbm_ctrl\x7ctg_fbs_ctrlb\x7ctg_s_ctrl\x7cy__t55
+ a\x7cb\x7cm_east\x7cm_west\x7cnand_m_a\x7cnand_m_a_ext_via\x7cnand_m_a_ext_via2\x7cnand_m_a_stub\x7ctg_d_b\x7ctg_d_b_via\x7ctg_d_b_via2\x7ctg_fbm_b\x7ctg_fbm_b_alt_via\x7ctg_fbm_b_alt_via2__t35
+ a\x7cd\x7cinv_clk_vdd\x7cinv_mc_vdd\x7cinv_q_vdd\x7cmpa_py\x7cmpb_py\x7cnand_m_vdd\x7cnand_s2_vdd\x7cnwell_vdd\x7csb_vdd\x7csr1_vdd\x7csr2_vdd\x7csr3_vdd\x7csr4_vdd\x7csv_d_vdd_tie\x7csv_vdd\x7ctg_d_a\x7ctg_d_vdd\x7ctg_fbm_vdd\x7ctg_fbs_vdd\x7ctg_s_vdd\x7cvdd\x7cvdd_b1\x7cvdd_b2\x7cvdd_b3\x7cvdd_b4\x7cvdd_link\x7cvdd_link_dip\x7cvdd_x1\x7cvdd_x2\x7cvdd_x3__t86
+ sky130_fd_pr__pfet_01v8 L=0.15 W=0.84 AS=0.3948 AD=0.3948 PS=2.62 PD=2.62
* device instance $165 r0 *1 252.38,3.53 pfet
X$165
+ a\x7cinv_mc_a\x7cmb\x7cmnab_y\x7cmpa_y\x7cmpb_y\x7cnand_m_y\x7ctg_s_a\x7cy__t25
+ clkb\x7cclkb_bridge1\x7cclkb_bridge2\x7cclkb_mid\x7cclkb_w\x7cctrl\x7cctrlb\x7cinv_clk_y\x7ctg_d_ctrlb\x7ctg_fbm_ctrl\x7ctg_fbs_ctrlb\x7ctg_s_ctrl\x7cy__t45
+ a\x7cb\x7cinv_q_a\x7cinv_q_a_via\x7cs\x7ctg_fbs_b\x7ctg_fbs_b_via\x7ctg_s_b\x7ctg_s_b_via__t45
+ a\x7cd\x7cinv_clk_vdd\x7cinv_mc_vdd\x7cinv_q_vdd\x7cmpa_py\x7cmpb_py\x7cnand_m_vdd\x7cnand_s2_vdd\x7cnwell_vdd\x7csb_vdd\x7csr1_vdd\x7csr2_vdd\x7csr3_vdd\x7csr4_vdd\x7csv_d_vdd_tie\x7csv_vdd\x7ctg_d_a\x7ctg_d_vdd\x7ctg_fbm_vdd\x7ctg_fbs_vdd\x7ctg_s_vdd\x7cvdd\x7cvdd_b1\x7cvdd_b2\x7cvdd_b3\x7cvdd_b4\x7cvdd_link\x7cvdd_link_dip\x7cvdd_x1\x7cvdd_x2\x7cvdd_x3__t54
+ sky130_fd_pr__pfet_01v8 L=0.15 W=0.84 AS=0.3948 AD=0.3948 PS=2.62 PD=2.62
* device instance $166 r0 *1 259.185,3.53 pfet
X$166
+ a\x7cinv_q_y\x7cinv_q_y_via\x7cinv_q_y_via2\x7cnand_s2_a\x7cnand_s2_a_stub\x7cnand_s2_a_via\x7cnand_s2_a_via2\x7cq\x7cy__t15
+ a\x7cb\x7cinv_q_a\x7cinv_q_a_via\x7cs\x7ctg_fbs_b\x7ctg_fbs_b_via\x7ctg_s_b\x7ctg_s_b_via__t15
+ a\x7cd\x7cinv_clk_vdd\x7cinv_mc_vdd\x7cinv_q_vdd\x7cmpa_py\x7cmpb_py\x7cnand_m_vdd\x7cnand_s2_vdd\x7cnwell_vdd\x7csb_vdd\x7csr1_vdd\x7csr2_vdd\x7csr3_vdd\x7csr4_vdd\x7csv_d_vdd_tie\x7csv_vdd\x7ctg_d_a\x7ctg_d_vdd\x7ctg_fbm_vdd\x7ctg_fbs_vdd\x7ctg_s_vdd\x7cvdd\x7cvdd_b1\x7cvdd_b2\x7cvdd_b3\x7cvdd_b4\x7cvdd_link\x7cvdd_link_dip\x7cvdd_x1\x7cvdd_x2\x7cvdd_x3__t116
+ a\x7cd\x7cinv_clk_vdd\x7cinv_mc_vdd\x7cinv_q_vdd\x7cmpa_py\x7cmpb_py\x7cnand_m_vdd\x7cnand_s2_vdd\x7cnwell_vdd\x7csb_vdd\x7csr1_vdd\x7csr2_vdd\x7csr3_vdd\x7csr4_vdd\x7csv_d_vdd_tie\x7csv_vdd\x7ctg_d_a\x7ctg_d_vdd\x7ctg_fbm_vdd\x7ctg_fbs_vdd\x7ctg_s_vdd\x7cvdd\x7cvdd_b1\x7cvdd_b2\x7cvdd_b3\x7cvdd_b4\x7cvdd_link\x7cvdd_link_dip\x7cvdd_x1\x7cvdd_x2\x7cvdd_x3__t46
+ sky130_fd_pr__pfet_01v8 L=0.15 W=0.84 AS=0.3948 AD=0.3948 PS=2.62 PD=2.62
* device instance $167 r0 *1 271.67,3.53 pfet
X$167 a\x7cmnab_y\x7cmpa_y\x7cmpb_y\x7cnand_s2_y\x7cqb\x7ctg_fbs_a\x7cy__t25
+ a\x7cclk\x7cctrl\x7cctrlb\x7cinv_clk_a\x7cinv_clk_clk_via\x7ctg_d_ctrl\x7ctg_d_ctrl_via\x7ctg_fbm_ctrlb\x7ctg_fbm_ctrlb_via\x7ctg_fbs_ctrl\x7ctg_fbs_ctrl_via\x7ctg_s_ctrlb\x7ctg_s_ctrlb_via__t26
+ a\x7cb\x7cinv_q_a\x7cinv_q_a_via\x7cs\x7ctg_fbs_b\x7ctg_fbs_b_via\x7ctg_s_b\x7ctg_s_b_via__t55
+ a\x7cd\x7cinv_clk_vdd\x7cinv_mc_vdd\x7cinv_q_vdd\x7cmpa_py\x7cmpb_py\x7cnand_m_vdd\x7cnand_s2_vdd\x7cnwell_vdd\x7csb_vdd\x7csr1_vdd\x7csr2_vdd\x7csr3_vdd\x7csr4_vdd\x7csv_d_vdd_tie\x7csv_vdd\x7ctg_d_a\x7ctg_d_vdd\x7ctg_fbm_vdd\x7ctg_fbs_vdd\x7ctg_s_vdd\x7cvdd\x7cvdd_b1\x7cvdd_b2\x7cvdd_b3\x7cvdd_b4\x7cvdd_link\x7cvdd_link_dip\x7cvdd_x1\x7cvdd_x2\x7cvdd_x3__t74
+ sky130_fd_pr__pfet_01v8 L=0.15 W=0.84 AS=0.3948 AD=0.3948 PS=2.62 PD=2.62
* device instance $168 r0 *1 278.845,3.53 pfet
X$168
+ clkb\x7cclkb_bridge1\x7cclkb_bridge2\x7cclkb_mid\x7cclkb_w\x7cctrl\x7cctrlb\x7cinv_clk_y\x7ctg_d_ctrlb\x7ctg_fbm_ctrl\x7ctg_fbs_ctrlb\x7ctg_s_ctrl\x7cy__t16
+ a\x7cclk\x7cctrl\x7cctrlb\x7cinv_clk_a\x7cinv_clk_clk_via\x7ctg_d_ctrl\x7ctg_d_ctrl_via\x7ctg_fbm_ctrlb\x7ctg_fbm_ctrlb_via\x7ctg_fbs_ctrl\x7ctg_fbs_ctrl_via\x7ctg_s_ctrlb\x7ctg_s_ctrlb_via__t21
+ a\x7cd\x7cinv_clk_vdd\x7cinv_mc_vdd\x7cinv_q_vdd\x7cmpa_py\x7cmpb_py\x7cnand_m_vdd\x7cnand_s2_vdd\x7cnwell_vdd\x7csb_vdd\x7csr1_vdd\x7csr2_vdd\x7csr3_vdd\x7csr4_vdd\x7csv_d_vdd_tie\x7csv_vdd\x7ctg_d_a\x7ctg_d_vdd\x7ctg_fbm_vdd\x7ctg_fbs_vdd\x7ctg_s_vdd\x7cvdd\x7cvdd_b1\x7cvdd_b2\x7cvdd_b3\x7cvdd_b4\x7cvdd_link\x7cvdd_link_dip\x7cvdd_x1\x7cvdd_x2\x7cvdd_x3__t115
+ a\x7cd\x7cinv_clk_vdd\x7cinv_mc_vdd\x7cinv_q_vdd\x7cmpa_py\x7cmpb_py\x7cnand_m_vdd\x7cnand_s2_vdd\x7cnwell_vdd\x7csb_vdd\x7csr1_vdd\x7csr2_vdd\x7csr3_vdd\x7csr4_vdd\x7csv_d_vdd_tie\x7csv_vdd\x7ctg_d_a\x7ctg_d_vdd\x7ctg_fbm_vdd\x7ctg_fbs_vdd\x7ctg_s_vdd\x7cvdd\x7cvdd_b1\x7cvdd_b2\x7cvdd_b3\x7cvdd_b4\x7cvdd_link\x7cvdd_link_dip\x7cvdd_x1\x7cvdd_x2\x7cvdd_x3__t45
+ sky130_fd_pr__pfet_01v8 L=0.15 W=0.84 AS=0.3948 AD=0.3948 PS=2.62 PD=2.62
* device instance $169 r0 *1 283.61,3.53 pfet
X$169
+ a\x7cb\x7cd\x7cinvb_a\x7cmn12_g1\x7cmp24_g0\x7cro4\x7cro4_esc\x7csr4_d_stub\x7ctg_d_a\x7cy__t3
+ a\x7cclk\x7cctrl\x7cctrlb\x7cinv_clk_a\x7cinv_clk_clk_via\x7ctg_d_ctrl\x7ctg_d_ctrl_via\x7ctg_fbm_ctrlb\x7ctg_fbm_ctrlb_via\x7ctg_fbs_ctrl\x7ctg_fbs_ctrl_via\x7ctg_s_ctrlb\x7ctg_s_ctrlb_via__t20
+ a\x7cb\x7cm_east\x7cm_west\x7cnand_m_a\x7cnand_m_a_ext_via\x7cnand_m_a_ext_via2\x7cnand_m_a_stub\x7ctg_d_b\x7ctg_d_b_via\x7ctg_d_b_via2\x7ctg_fbm_b\x7ctg_fbm_b_alt_via\x7ctg_fbm_b_alt_via2__t46
+ a\x7cd\x7cinv_clk_vdd\x7cinv_mc_vdd\x7cinv_q_vdd\x7cmpa_py\x7cmpb_py\x7cnand_m_vdd\x7cnand_s2_vdd\x7cnwell_vdd\x7csb_vdd\x7csr1_vdd\x7csr2_vdd\x7csr3_vdd\x7csr4_vdd\x7csv_d_vdd_tie\x7csv_vdd\x7ctg_d_a\x7ctg_d_vdd\x7ctg_fbm_vdd\x7ctg_fbs_vdd\x7ctg_s_vdd\x7cvdd\x7cvdd_b1\x7cvdd_b2\x7cvdd_b3\x7cvdd_b4\x7cvdd_link\x7cvdd_link_dip\x7cvdd_x1\x7cvdd_x2\x7cvdd_x3__t44
+ sky130_fd_pr__pfet_01v8 L=0.15 W=0.84 AS=0.3948 AD=0.3948 PS=2.62 PD=2.62
* device instance $170 r0 *1 298.135,3.53 pfet
X$170 a\x7cinv_mc_y\x7cinv_mc_y_via\x7cmc\x7ctg_fbm_a\x7ctg_fbm_a_via\x7cy__t36
+ a\x7cinv_mc_a\x7cmb\x7cmnab_y\x7cmpa_y\x7cmpb_y\x7cnand_m_y\x7ctg_s_a\x7cy__t46
+ a\x7cd\x7cinv_clk_vdd\x7cinv_mc_vdd\x7cinv_q_vdd\x7cmpa_py\x7cmpb_py\x7cnand_m_vdd\x7cnand_s2_vdd\x7cnwell_vdd\x7csb_vdd\x7csr1_vdd\x7csr2_vdd\x7csr3_vdd\x7csr4_vdd\x7csv_d_vdd_tie\x7csv_vdd\x7ctg_d_a\x7ctg_d_vdd\x7ctg_fbm_vdd\x7ctg_fbs_vdd\x7ctg_s_vdd\x7cvdd\x7cvdd_b1\x7cvdd_b2\x7cvdd_b3\x7cvdd_b4\x7cvdd_link\x7cvdd_link_dip\x7cvdd_x1\x7cvdd_x2\x7cvdd_x3__t114
+ a\x7cd\x7cinv_clk_vdd\x7cinv_mc_vdd\x7cinv_q_vdd\x7cmpa_py\x7cmpb_py\x7cnand_m_vdd\x7cnand_s2_vdd\x7cnwell_vdd\x7csb_vdd\x7csr1_vdd\x7csr2_vdd\x7csr3_vdd\x7csr4_vdd\x7csv_d_vdd_tie\x7csv_vdd\x7ctg_d_a\x7ctg_d_vdd\x7ctg_fbm_vdd\x7ctg_fbs_vdd\x7ctg_s_vdd\x7cvdd\x7cvdd_b1\x7cvdd_b2\x7cvdd_b3\x7cvdd_b4\x7cvdd_link\x7cvdd_link_dip\x7cvdd_x1\x7cvdd_x2\x7cvdd_x3__t43
+ sky130_fd_pr__pfet_01v8 L=0.15 W=0.84 AS=0.3948 AD=0.3948 PS=2.62 PD=2.62
* device instance $171 r0 *1 302.9,3.53 pfet
X$171 a\x7cinv_mc_y\x7cinv_mc_y_via\x7cmc\x7ctg_fbm_a\x7ctg_fbm_a_via\x7cy__t26
+ clkb\x7cclkb_bridge1\x7cclkb_bridge2\x7cclkb_mid\x7cclkb_w\x7cctrl\x7cctrlb\x7cinv_clk_y\x7ctg_d_ctrlb\x7ctg_fbm_ctrl\x7ctg_fbs_ctrlb\x7ctg_s_ctrl\x7cy__t56
+ a\x7cb\x7cm_east\x7cm_west\x7cnand_m_a\x7cnand_m_a_ext_via\x7cnand_m_a_ext_via2\x7cnand_m_a_stub\x7ctg_d_b\x7ctg_d_b_via\x7ctg_d_b_via2\x7ctg_fbm_b\x7ctg_fbm_b_alt_via\x7ctg_fbm_b_alt_via2__t36
+ a\x7cd\x7cinv_clk_vdd\x7cinv_mc_vdd\x7cinv_q_vdd\x7cmpa_py\x7cmpb_py\x7cnand_m_vdd\x7cnand_s2_vdd\x7cnwell_vdd\x7csb_vdd\x7csr1_vdd\x7csr2_vdd\x7csr3_vdd\x7csr4_vdd\x7csv_d_vdd_tie\x7csv_vdd\x7ctg_d_a\x7ctg_d_vdd\x7ctg_fbm_vdd\x7ctg_fbs_vdd\x7ctg_s_vdd\x7cvdd\x7cvdd_b1\x7cvdd_b2\x7cvdd_b3\x7cvdd_b4\x7cvdd_link\x7cvdd_link_dip\x7cvdd_x1\x7cvdd_x2\x7cvdd_x3__t42
+ sky130_fd_pr__pfet_01v8 L=0.15 W=0.84 AS=0.3948 AD=0.3948 PS=2.62 PD=2.62
* device instance $172 r0 *1 308.04,3.53 pfet
X$172
+ a\x7cinv_mc_a\x7cmb\x7cmnab_y\x7cmpa_y\x7cmpb_y\x7cnand_m_y\x7ctg_s_a\x7cy__t16
+ clkb\x7cclkb_bridge1\x7cclkb_bridge2\x7cclkb_mid\x7cclkb_w\x7cctrl\x7cctrlb\x7cinv_clk_y\x7ctg_d_ctrlb\x7ctg_fbm_ctrl\x7ctg_fbs_ctrlb\x7ctg_s_ctrl\x7cy__t46
+ a\x7cb\x7cinv_q_a\x7cinv_q_a_via\x7cs\x7ctg_fbs_b\x7ctg_fbs_b_via\x7ctg_s_b\x7ctg_s_b_via__t56
+ a\x7cd\x7cinv_clk_vdd\x7cinv_mc_vdd\x7cinv_q_vdd\x7cmpa_py\x7cmpb_py\x7cnand_m_vdd\x7cnand_s2_vdd\x7cnwell_vdd\x7csb_vdd\x7csr1_vdd\x7csr2_vdd\x7csr3_vdd\x7csr4_vdd\x7csv_d_vdd_tie\x7csv_vdd\x7ctg_d_a\x7ctg_d_vdd\x7ctg_fbm_vdd\x7ctg_fbs_vdd\x7ctg_s_vdd\x7cvdd\x7cvdd_b1\x7cvdd_b2\x7cvdd_b3\x7cvdd_b4\x7cvdd_link\x7cvdd_link_dip\x7cvdd_x1\x7cvdd_x2\x7cvdd_x3__t41
+ sky130_fd_pr__pfet_01v8 L=0.15 W=0.84 AS=0.3948 AD=0.3948 PS=2.62 PD=2.62
* device instance $173 r0 *1 314.845,3.53 pfet
X$173
+ a\x7cinv_q_y\x7cinv_q_y_via\x7cinv_q_y_via2\x7cnand_s2_a\x7cnand_s2_a_stub\x7cnand_s2_a_via\x7cnand_s2_a_via2\x7cq\x7cy__t16
+ a\x7cb\x7cinv_q_a\x7cinv_q_a_via\x7cs\x7ctg_fbs_b\x7ctg_fbs_b_via\x7ctg_s_b\x7ctg_s_b_via__t16
+ a\x7cd\x7cinv_clk_vdd\x7cinv_mc_vdd\x7cinv_q_vdd\x7cmpa_py\x7cmpb_py\x7cnand_m_vdd\x7cnand_s2_vdd\x7cnwell_vdd\x7csb_vdd\x7csr1_vdd\x7csr2_vdd\x7csr3_vdd\x7csr4_vdd\x7csv_d_vdd_tie\x7csv_vdd\x7ctg_d_a\x7ctg_d_vdd\x7ctg_fbm_vdd\x7ctg_fbs_vdd\x7ctg_s_vdd\x7cvdd\x7cvdd_b1\x7cvdd_b2\x7cvdd_b3\x7cvdd_b4\x7cvdd_link\x7cvdd_link_dip\x7cvdd_x1\x7cvdd_x2\x7cvdd_x3__t113
+ a\x7cd\x7cinv_clk_vdd\x7cinv_mc_vdd\x7cinv_q_vdd\x7cmpa_py\x7cmpb_py\x7cnand_m_vdd\x7cnand_s2_vdd\x7cnwell_vdd\x7csb_vdd\x7csr1_vdd\x7csr2_vdd\x7csr3_vdd\x7csr4_vdd\x7csv_d_vdd_tie\x7csv_vdd\x7ctg_d_a\x7ctg_d_vdd\x7ctg_fbm_vdd\x7ctg_fbs_vdd\x7ctg_s_vdd\x7cvdd\x7cvdd_b1\x7cvdd_b2\x7cvdd_b3\x7cvdd_b4\x7cvdd_link\x7cvdd_link_dip\x7cvdd_x1\x7cvdd_x2\x7cvdd_x3__t40
+ sky130_fd_pr__pfet_01v8 L=0.15 W=0.84 AS=0.3948 AD=0.3948 PS=2.62 PD=2.62
* device instance $174 r0 *1 327.33,3.53 pfet
X$174 a\x7cmnab_y\x7cmpa_y\x7cmpb_y\x7cnand_s2_y\x7cqb\x7ctg_fbs_a\x7cy__t16
+ a\x7cclk\x7cctrl\x7cctrlb\x7cinv_clk_a\x7cinv_clk_clk_via\x7ctg_d_ctrl\x7ctg_d_ctrl_via\x7ctg_fbm_ctrlb\x7ctg_fbm_ctrlb_via\x7ctg_fbs_ctrl\x7ctg_fbs_ctrl_via\x7ctg_s_ctrlb\x7ctg_s_ctrlb_via__t19
+ a\x7cb\x7cinv_q_a\x7cinv_q_a_via\x7cs\x7ctg_fbs_b\x7ctg_fbs_b_via\x7ctg_s_b\x7ctg_s_b_via__t46
+ a\x7cd\x7cinv_clk_vdd\x7cinv_mc_vdd\x7cinv_q_vdd\x7cmpa_py\x7cmpb_py\x7cnand_m_vdd\x7cnand_s2_vdd\x7cnwell_vdd\x7csb_vdd\x7csr1_vdd\x7csr2_vdd\x7csr3_vdd\x7csr4_vdd\x7csv_d_vdd_tie\x7csv_vdd\x7ctg_d_a\x7ctg_d_vdd\x7ctg_fbm_vdd\x7ctg_fbs_vdd\x7ctg_s_vdd\x7cvdd\x7cvdd_b1\x7cvdd_b2\x7cvdd_b3\x7cvdd_b4\x7cvdd_link\x7cvdd_link_dip\x7cvdd_x1\x7cvdd_x2\x7cvdd_x3__t39
+ sky130_fd_pr__pfet_01v8 L=0.15 W=0.84 AS=0.3948 AD=0.3948 PS=2.62 PD=2.62
* device instance $175 r0 *1 5.775,27.375 pfet
X$175 a\x7cg_y\x7cmnab_y\x7cmpa_y\x7cmpb_y\x7cn1\x7cs1_a\x7cy__t0
+ en\x7cen1\x7cg_en__t0 mpa_py\x7cmpb_py\x7cmph_py\x7cpy__t2
+ g_vddr_m1\x7cmnt_g\x7cs1_vddr_m1\x7cs2_vddr_m1\x7cs3_vddr_m1\x7cs4_vddr_m1\x7cvddr\x7cvddr1__t19
+ sky130_fd_pr__pfet_01v8 L=0.15 W=0.84 AS=0.3948 AD=0.3948 PS=2.62 PD=2.62
* device instance $176 r0 *1 7.065,27.375 pfet
X$176 mpa_py\x7cmpb_py\x7cmph_py\x7cpy__t1
+ a\x7cg_a\x7crn1\x7cro\x7cs4_y\x7cy__t4
+ a\x7cg_y\x7cmnab_y\x7cmpa_y\x7cmpb_y\x7cn1\x7cs1_a\x7cy__t3
+ g_vddr_m1\x7cmnt_g\x7cs1_vddr_m1\x7cs2_vddr_m1\x7cs3_vddr_m1\x7cs4_vddr_m1\x7cvddr\x7cvddr1__t20
+ sky130_fd_pr__pfet_01v8 L=0.15 W=0.84 AS=0.3948 AD=0.3948 PS=2.62 PD=2.62
* device instance $177 r0 *1 12.115,3.74 pfet
X$177
+ a\x7cinv_mc_a\x7cmb\x7cmnab_y\x7cmpa_y\x7cmpb_y\x7cnand_m_y\x7ctg_s_a\x7cy__t3
+ en\x7cnand_m_en\x7cnand_m_en_via\x7cnand_s2_en\x7cnand_s2_en_via\x7crst_n__t10
+ a\x7cd\x7cinv_clk_vdd\x7cinv_mc_vdd\x7cinv_q_vdd\x7cmpa_py\x7cmpb_py\x7cnand_m_vdd\x7cnand_s2_vdd\x7cnwell_vdd\x7csb_vdd\x7csr1_vdd\x7csr2_vdd\x7csr3_vdd\x7csr4_vdd\x7csv_d_vdd_tie\x7csv_vdd\x7ctg_d_a\x7ctg_d_vdd\x7ctg_fbm_vdd\x7ctg_fbs_vdd\x7ctg_s_vdd\x7cvdd\x7cvdd_b1\x7cvdd_b2\x7cvdd_b3\x7cvdd_b4\x7cvdd_link\x7cvdd_link_dip\x7cvdd_x1\x7cvdd_x2\x7cvdd_x3__t142
+ a\x7cd\x7cinv_clk_vdd\x7cinv_mc_vdd\x7cinv_q_vdd\x7cmpa_py\x7cmpb_py\x7cnand_m_vdd\x7cnand_s2_vdd\x7cnwell_vdd\x7csb_vdd\x7csr1_vdd\x7csr2_vdd\x7csr3_vdd\x7csr4_vdd\x7csv_d_vdd_tie\x7csv_vdd\x7ctg_d_a\x7ctg_d_vdd\x7ctg_fbm_vdd\x7ctg_fbs_vdd\x7ctg_s_vdd\x7cvdd\x7cvdd_b1\x7cvdd_b2\x7cvdd_b3\x7cvdd_b4\x7cvdd_link\x7cvdd_link_dip\x7cvdd_x1\x7cvdd_x2\x7cvdd_x3__t95
+ sky130_fd_pr__pfet_01v8 L=0.15 W=0.84 AS=0.3948 AD=0.3948 PS=2.62 PD=2.62
* device instance $178 r0 *1 13.405,3.74 pfet
X$178
+ a\x7cd\x7cinv_clk_vdd\x7cinv_mc_vdd\x7cinv_q_vdd\x7cmpa_py\x7cmpb_py\x7cnand_m_vdd\x7cnand_s2_vdd\x7cnwell_vdd\x7csb_vdd\x7csr1_vdd\x7csr2_vdd\x7csr3_vdd\x7csr4_vdd\x7csv_d_vdd_tie\x7csv_vdd\x7ctg_d_a\x7ctg_d_vdd\x7ctg_fbm_vdd\x7ctg_fbs_vdd\x7ctg_s_vdd\x7cvdd\x7cvdd_b1\x7cvdd_b2\x7cvdd_b3\x7cvdd_b4\x7cvdd_link\x7cvdd_link_dip\x7cvdd_x1\x7cvdd_x2\x7cvdd_x3__t33
+ a\x7cb\x7cm_east\x7cm_west\x7cnand_m_a\x7cnand_m_a_ext_via\x7cnand_m_a_ext_via2\x7cnand_m_a_stub\x7ctg_d_b\x7ctg_d_b_via\x7ctg_d_b_via2\x7ctg_fbm_b\x7ctg_fbm_b_alt_via\x7ctg_fbm_b_alt_via2__t1
+ a\x7cinv_mc_a\x7cmb\x7cmnab_y\x7cmpa_y\x7cmpb_y\x7cnand_m_y\x7ctg_s_a\x7cy__t6
+ a\x7cd\x7cinv_clk_vdd\x7cinv_mc_vdd\x7cinv_q_vdd\x7cmpa_py\x7cmpb_py\x7cnand_m_vdd\x7cnand_s2_vdd\x7cnwell_vdd\x7csb_vdd\x7csr1_vdd\x7csr2_vdd\x7csr3_vdd\x7csr4_vdd\x7csv_d_vdd_tie\x7csv_vdd\x7ctg_d_a\x7ctg_d_vdd\x7ctg_fbm_vdd\x7ctg_fbs_vdd\x7ctg_s_vdd\x7cvdd\x7cvdd_b1\x7cvdd_b2\x7cvdd_b3\x7cvdd_b4\x7cvdd_link\x7cvdd_link_dip\x7cvdd_x1\x7cvdd_x2\x7cvdd_x3__t108
+ sky130_fd_pr__pfet_01v8 L=0.15 W=0.84 AS=0.3948 AD=0.3948 PS=2.62 PD=2.62
* device instance $179 r0 *1 15.075,27.375 pfet
X$179 a\x7cn2\x7cs1_y\x7cs2_a\x7cy__t1
+ a\x7cg_y\x7cmnab_y\x7cmpa_y\x7cmpb_y\x7cn1\x7cs1_a\x7cy__t2 py__t1
+ g_vddr_m1\x7cmnt_g\x7cs1_vddr_m1\x7cs2_vddr_m1\x7cs3_vddr_m1\x7cs4_vddr_m1\x7cvddr\x7cvddr1__t18
+ sky130_fd_pr__pfet_01v8 L=0.15 W=0.84 AS=0.3948 AD=0.3948 PS=2.62 PD=2.62
* device instance $180 r0 *1 23.25,27.375 pfet
X$180 a\x7cn3\x7cs2_y\x7cs3_a\x7cy__t1 a\x7cn2\x7cs1_y\x7cs2_a\x7cy__t3 py__t12
+ g_vddr_m1\x7cmnt_g\x7cs1_vddr_m1\x7cs2_vddr_m1\x7cs3_vddr_m1\x7cs4_vddr_m1\x7cvddr\x7cvddr1__t17
+ sky130_fd_pr__pfet_01v8 L=0.15 W=0.84 AS=0.3948 AD=0.3948 PS=2.62 PD=2.62
* device instance $181 r0 *1 31.425,27.375 pfet
X$181 a\x7cn4\x7cs3_y\x7cs4_a\x7cy__t1 a\x7cn3\x7cs2_y\x7cs3_a\x7cy__t3 py__t13
+ g_vddr_m1\x7cmnt_g\x7cs1_vddr_m1\x7cs2_vddr_m1\x7cs3_vddr_m1\x7cs4_vddr_m1\x7cvddr\x7cvddr1__t15
+ sky130_fd_pr__pfet_01v8 L=0.15 W=0.84 AS=0.3948 AD=0.3948 PS=2.62 PD=2.62
* device instance $182 r0 *1 39.6,27.375 pfet
X$182 a\x7cg_a\x7crn1\x7cro\x7cs4_y\x7cy__t1 a\x7cn4\x7cs3_y\x7cs4_a\x7cy__t3
+ py__t14
+ g_vddr_m1\x7cmnt_g\x7cs1_vddr_m1\x7cs2_vddr_m1\x7cs3_vddr_m1\x7cs4_vddr_m1\x7cvddr\x7cvddr1__t16
+ sky130_fd_pr__pfet_01v8 L=0.15 W=0.84 AS=0.3948 AD=0.3948 PS=2.62 PD=2.62
* device instance $183 r0 *1 42.975,3.74 pfet
X$183 a\x7cmnab_y\x7cmpa_y\x7cmpb_y\x7cnand_s2_y\x7cqb\x7ctg_fbs_a\x7cy__t2
+ en\x7cnand_m_en\x7cnand_m_en_via\x7cnand_s2_en\x7cnand_s2_en_via\x7crst_n__t11
+ a\x7cd\x7cinv_clk_vdd\x7cinv_mc_vdd\x7cinv_q_vdd\x7cmpa_py\x7cmpb_py\x7cnand_m_vdd\x7cnand_s2_vdd\x7cnwell_vdd\x7csb_vdd\x7csr1_vdd\x7csr2_vdd\x7csr3_vdd\x7csr4_vdd\x7csv_d_vdd_tie\x7csv_vdd\x7ctg_d_a\x7ctg_d_vdd\x7ctg_fbm_vdd\x7ctg_fbs_vdd\x7ctg_s_vdd\x7cvdd\x7cvdd_b1\x7cvdd_b2\x7cvdd_b3\x7cvdd_b4\x7cvdd_link\x7cvdd_link_dip\x7cvdd_x1\x7cvdd_x2\x7cvdd_x3__t145
+ a\x7cd\x7cinv_clk_vdd\x7cinv_mc_vdd\x7cinv_q_vdd\x7cmpa_py\x7cmpb_py\x7cnand_m_vdd\x7cnand_s2_vdd\x7cnwell_vdd\x7csb_vdd\x7csr1_vdd\x7csr2_vdd\x7csr3_vdd\x7csr4_vdd\x7csv_d_vdd_tie\x7csv_vdd\x7ctg_d_a\x7ctg_d_vdd\x7ctg_fbm_vdd\x7ctg_fbs_vdd\x7ctg_s_vdd\x7cvdd\x7cvdd_b1\x7cvdd_b2\x7cvdd_b3\x7cvdd_b4\x7cvdd_link\x7cvdd_link_dip\x7cvdd_x1\x7cvdd_x2\x7cvdd_x3__t102
+ sky130_fd_pr__pfet_01v8 L=0.15 W=0.84 AS=0.3948 AD=0.3948 PS=2.62 PD=2.62
* device instance $184 r0 *1 44.265,3.74 pfet
X$184
+ a\x7cd\x7cinv_clk_vdd\x7cinv_mc_vdd\x7cinv_q_vdd\x7cmpa_py\x7cmpb_py\x7cnand_m_vdd\x7cnand_s2_vdd\x7cnwell_vdd\x7csb_vdd\x7csr1_vdd\x7csr2_vdd\x7csr3_vdd\x7csr4_vdd\x7csv_d_vdd_tie\x7csv_vdd\x7ctg_d_a\x7ctg_d_vdd\x7ctg_fbm_vdd\x7ctg_fbs_vdd\x7ctg_s_vdd\x7cvdd\x7cvdd_b1\x7cvdd_b2\x7cvdd_b3\x7cvdd_b4\x7cvdd_link\x7cvdd_link_dip\x7cvdd_x1\x7cvdd_x2\x7cvdd_x3__t32
+ a\x7cinv_q_y\x7cinv_q_y_via\x7cinv_q_y_via2\x7cnand_s2_a\x7cnand_s2_a_stub\x7cnand_s2_a_via\x7cnand_s2_a_via2\x7cq\x7cy__t2
+ a\x7cmnab_y\x7cmpa_y\x7cmpb_y\x7cnand_s2_y\x7cqb\x7ctg_fbs_a\x7cy__t3
+ a\x7cd\x7cinv_clk_vdd\x7cinv_mc_vdd\x7cinv_q_vdd\x7cmpa_py\x7cmpb_py\x7cnand_m_vdd\x7cnand_s2_vdd\x7cnwell_vdd\x7csb_vdd\x7csr1_vdd\x7csr2_vdd\x7csr3_vdd\x7csr4_vdd\x7csv_d_vdd_tie\x7csv_vdd\x7ctg_d_a\x7ctg_d_vdd\x7ctg_fbm_vdd\x7ctg_fbs_vdd\x7ctg_s_vdd\x7cvdd\x7cvdd_b1\x7cvdd_b2\x7cvdd_b3\x7cvdd_b4\x7cvdd_link\x7cvdd_link_dip\x7cvdd_x1\x7cvdd_x2\x7cvdd_x3__t103
+ sky130_fd_pr__pfet_01v8 L=0.15 W=0.84 AS=0.3948 AD=0.3948 PS=2.62 PD=2.62
* device instance $185 r0 *1 48.86,27.165 pfet
X$185
+ a\x7cd\x7cinva_a\x7cmn12_g0\x7cmp13_g0\x7cro1\x7cro1_esc\x7csr1_d_stub\x7ctg_d_a\x7cy__t3
+ a\x7cg_a\x7crn1\x7cro\x7cs4_y\x7cy__t3
+ a\x7cd\x7cinv_clk_vdd\x7cinv_mc_vdd\x7cinv_q_vdd\x7cmpa_py\x7cmpb_py\x7cnand_m_vdd\x7cnand_s2_vdd\x7cnwell_vdd\x7csb_vdd\x7csr1_vdd\x7csr2_vdd\x7csr3_vdd\x7csr4_vdd\x7csv_d_vdd_tie\x7csv_vdd\x7ctg_d_a\x7ctg_d_vdd\x7ctg_fbm_vdd\x7ctg_fbs_vdd\x7ctg_s_vdd\x7cvdd\x7cvdd_b1\x7cvdd_b2\x7cvdd_b3\x7cvdd_b4\x7cvdd_link\x7cvdd_link_dip\x7cvdd_x1\x7cvdd_x2\x7cvdd_x3__t111
+ a\x7cd\x7cinv_clk_vdd\x7cinv_mc_vdd\x7cinv_q_vdd\x7cmpa_py\x7cmpb_py\x7cnand_m_vdd\x7cnand_s2_vdd\x7cnwell_vdd\x7csb_vdd\x7csr1_vdd\x7csr2_vdd\x7csr3_vdd\x7csr4_vdd\x7csv_d_vdd_tie\x7csv_vdd\x7ctg_d_a\x7ctg_d_vdd\x7ctg_fbm_vdd\x7ctg_fbs_vdd\x7ctg_s_vdd\x7cvdd\x7cvdd_b1\x7cvdd_b2\x7cvdd_b3\x7cvdd_b4\x7cvdd_link\x7cvdd_link_dip\x7cvdd_x1\x7cvdd_x2\x7cvdd_x3__t36
+ sky130_fd_pr__pfet_01v8 L=0.15 W=0.84 AS=0.3948 AD=0.3948 PS=2.62 PD=2.62
* device instance $186 r0 *1 61.075,27.375 pfet
X$186 a\x7cg_y\x7cmnab_y\x7cmpa_y\x7cmpb_y\x7cn1\x7cs1_a\x7cy__t02
+ en\x7cen2\x7cg_en__t0 mpa_py\x7cmpb_py\x7cmph_py\x7cpy__t22
+ g_vddr_m1\x7cmnt_g\x7cs1_vddr_m1\x7cs2_vddr_m1\x7cs3_vddr_m1\x7cs4_vddr_m1\x7cvddr\x7cvddr2__t16
+ sky130_fd_pr__pfet_01v8 L=0.15 W=0.84 AS=0.3948 AD=0.3948 PS=2.62 PD=2.62
* device instance $187 r0 *1 62.365,27.375 pfet
X$187 mpa_py\x7cmpb_py\x7cmph_py\x7cpy__t12
+ a\x7cg_a\x7crn2\x7cro\x7cs4_y\x7cy__t4
+ a\x7cg_y\x7cmnab_y\x7cmpa_y\x7cmpb_y\x7cn1\x7cs1_a\x7cy__t32
+ g_vddr_m1\x7cmnt_g\x7cs1_vddr_m1\x7cs2_vddr_m1\x7cs3_vddr_m1\x7cs4_vddr_m1\x7cvddr\x7cvddr2__t17
+ sky130_fd_pr__pfet_01v8 L=0.15 W=0.84 AS=0.3948 AD=0.3948 PS=2.62 PD=2.62
* device instance $188 r0 *1 67.775,3.74 pfet
X$188
+ a\x7cinv_mc_a\x7cmb\x7cmnab_y\x7cmpa_y\x7cmpb_y\x7cnand_m_y\x7ctg_s_a\x7cy__t22
+ en\x7cnand_m_en\x7cnand_m_en_via\x7cnand_s2_en\x7cnand_s2_en_via\x7crst_n__t12
+ a\x7cd\x7cinv_clk_vdd\x7cinv_mc_vdd\x7cinv_q_vdd\x7cmpa_py\x7cmpb_py\x7cnand_m_vdd\x7cnand_s2_vdd\x7cnwell_vdd\x7csb_vdd\x7csr1_vdd\x7csr2_vdd\x7csr3_vdd\x7csr4_vdd\x7csv_d_vdd_tie\x7csv_vdd\x7ctg_d_a\x7ctg_d_vdd\x7ctg_fbm_vdd\x7ctg_fbs_vdd\x7ctg_s_vdd\x7cvdd\x7cvdd_b1\x7cvdd_b2\x7cvdd_b3\x7cvdd_b4\x7cvdd_link\x7cvdd_link_dip\x7cvdd_x1\x7cvdd_x2\x7cvdd_x3__t147
+ a\x7cd\x7cinv_clk_vdd\x7cinv_mc_vdd\x7cinv_q_vdd\x7cmpa_py\x7cmpb_py\x7cnand_m_vdd\x7cnand_s2_vdd\x7cnwell_vdd\x7csb_vdd\x7csr1_vdd\x7csr2_vdd\x7csr3_vdd\x7csr4_vdd\x7csv_d_vdd_tie\x7csv_vdd\x7ctg_d_a\x7ctg_d_vdd\x7ctg_fbm_vdd\x7ctg_fbs_vdd\x7ctg_s_vdd\x7cvdd\x7cvdd_b1\x7cvdd_b2\x7cvdd_b3\x7cvdd_b4\x7cvdd_link\x7cvdd_link_dip\x7cvdd_x1\x7cvdd_x2\x7cvdd_x3__t107
+ sky130_fd_pr__pfet_01v8 L=0.15 W=0.84 AS=0.3948 AD=0.3948 PS=2.62 PD=2.62
* device instance $189 r0 *1 69.065,3.74 pfet
X$189
+ a\x7cd\x7cinv_clk_vdd\x7cinv_mc_vdd\x7cinv_q_vdd\x7cmpa_py\x7cmpb_py\x7cnand_m_vdd\x7cnand_s2_vdd\x7cnwell_vdd\x7csb_vdd\x7csr1_vdd\x7csr2_vdd\x7csr3_vdd\x7csr4_vdd\x7csv_d_vdd_tie\x7csv_vdd\x7ctg_d_a\x7ctg_d_vdd\x7ctg_fbm_vdd\x7ctg_fbs_vdd\x7ctg_s_vdd\x7cvdd\x7cvdd_b1\x7cvdd_b2\x7cvdd_b3\x7cvdd_b4\x7cvdd_link\x7cvdd_link_dip\x7cvdd_x1\x7cvdd_x2\x7cvdd_x3__t31
+ a\x7cb\x7cm_east\x7cm_west\x7cnand_m_a\x7cnand_m_a_ext_via\x7cnand_m_a_ext_via2\x7cnand_m_a_stub\x7ctg_d_b\x7ctg_d_b_via\x7ctg_d_b_via2\x7ctg_fbm_b\x7ctg_fbm_b_alt_via\x7ctg_fbm_b_alt_via2__t02
+ a\x7cinv_mc_a\x7cmb\x7cmnab_y\x7cmpa_y\x7cmpb_y\x7cnand_m_y\x7ctg_s_a\x7cy__t52
+ a\x7cd\x7cinv_clk_vdd\x7cinv_mc_vdd\x7cinv_q_vdd\x7cmpa_py\x7cmpb_py\x7cnand_m_vdd\x7cnand_s2_vdd\x7cnwell_vdd\x7csb_vdd\x7csr1_vdd\x7csr2_vdd\x7csr3_vdd\x7csr4_vdd\x7csv_d_vdd_tie\x7csv_vdd\x7ctg_d_a\x7ctg_d_vdd\x7ctg_fbm_vdd\x7ctg_fbs_vdd\x7ctg_s_vdd\x7cvdd\x7cvdd_b1\x7cvdd_b2\x7cvdd_b3\x7cvdd_b4\x7cvdd_link\x7cvdd_link_dip\x7cvdd_x1\x7cvdd_x2\x7cvdd_x3__t96
+ sky130_fd_pr__pfet_01v8 L=0.15 W=0.84 AS=0.3948 AD=0.3948 PS=2.62 PD=2.62
* device instance $190 r0 *1 70.375,27.375 pfet
X$190 a\x7cn2\x7cs1_y\x7cs2_a\x7cy__t12
+ a\x7cg_y\x7cmnab_y\x7cmpa_y\x7cmpb_y\x7cn1\x7cs1_a\x7cy__t22 py__t15
+ g_vddr_m1\x7cmnt_g\x7cs1_vddr_m1\x7cs2_vddr_m1\x7cs3_vddr_m1\x7cs4_vddr_m1\x7cvddr\x7cvddr2__t18
+ sky130_fd_pr__pfet_01v8 L=0.15 W=0.84 AS=0.3948 AD=0.3948 PS=2.62 PD=2.62
* device instance $191 r0 *1 78.55,27.375 pfet
X$191 a\x7cn3\x7cs2_y\x7cs3_a\x7cy__t12 a\x7cn2\x7cs1_y\x7cs2_a\x7cy__t32
+ py__t16
+ g_vddr_m1\x7cmnt_g\x7cs1_vddr_m1\x7cs2_vddr_m1\x7cs3_vddr_m1\x7cs4_vddr_m1\x7cvddr\x7cvddr2__t19
+ sky130_fd_pr__pfet_01v8 L=0.15 W=0.84 AS=0.3948 AD=0.3948 PS=2.62 PD=2.62
* device instance $192 r0 *1 86.725,27.375 pfet
X$192 a\x7cn4\x7cs3_y\x7cs4_a\x7cy__t13 a\x7cn3\x7cs2_y\x7cs3_a\x7cy__t32
+ py__t17
+ g_vddr_m1\x7cmnt_g\x7cs1_vddr_m1\x7cs2_vddr_m1\x7cs3_vddr_m1\x7cs4_vddr_m1\x7cvddr\x7cvddr2__t20
+ sky130_fd_pr__pfet_01v8 L=0.15 W=0.84 AS=0.3948 AD=0.3948 PS=2.62 PD=2.62
* device instance $193 r0 *1 94.9,27.375 pfet
X$193 a\x7cg_a\x7crn2\x7cro\x7cs4_y\x7cy__t1 a\x7cn4\x7cs3_y\x7cs4_a\x7cy__t33
+ py__t18
+ g_vddr_m1\x7cmnt_g\x7cs1_vddr_m1\x7cs2_vddr_m1\x7cs3_vddr_m1\x7cs4_vddr_m1\x7cvddr\x7cvddr2__t15
+ sky130_fd_pr__pfet_01v8 L=0.15 W=0.84 AS=0.3948 AD=0.3948 PS=2.62 PD=2.62
* device instance $194 r0 *1 98.635,3.74 pfet
X$194 a\x7cmnab_y\x7cmpa_y\x7cmpb_y\x7cnand_s2_y\x7cqb\x7ctg_fbs_a\x7cy__t12
+ en\x7cnand_m_en\x7cnand_m_en_via\x7cnand_s2_en\x7cnand_s2_en_via\x7crst_n__t7
+ a\x7cd\x7cinv_clk_vdd\x7cinv_mc_vdd\x7cinv_q_vdd\x7cmpa_py\x7cmpb_py\x7cnand_m_vdd\x7cnand_s2_vdd\x7cnwell_vdd\x7csb_vdd\x7csr1_vdd\x7csr2_vdd\x7csr3_vdd\x7csr4_vdd\x7csv_d_vdd_tie\x7csv_vdd\x7ctg_d_a\x7ctg_d_vdd\x7ctg_fbm_vdd\x7ctg_fbs_vdd\x7ctg_s_vdd\x7cvdd\x7cvdd_b1\x7cvdd_b2\x7cvdd_b3\x7cvdd_b4\x7cvdd_link\x7cvdd_link_dip\x7cvdd_x1\x7cvdd_x2\x7cvdd_x3__t134
+ a\x7cd\x7cinv_clk_vdd\x7cinv_mc_vdd\x7cinv_q_vdd\x7cmpa_py\x7cmpb_py\x7cnand_m_vdd\x7cnand_s2_vdd\x7cnwell_vdd\x7csb_vdd\x7csr1_vdd\x7csr2_vdd\x7csr3_vdd\x7csr4_vdd\x7csv_d_vdd_tie\x7csv_vdd\x7ctg_d_a\x7ctg_d_vdd\x7ctg_fbm_vdd\x7ctg_fbs_vdd\x7ctg_s_vdd\x7cvdd\x7cvdd_b1\x7cvdd_b2\x7cvdd_b3\x7cvdd_b4\x7cvdd_link\x7cvdd_link_dip\x7cvdd_x1\x7cvdd_x2\x7cvdd_x3__t77
+ sky130_fd_pr__pfet_01v8 L=0.15 W=0.84 AS=0.3948 AD=0.3948 PS=2.62 PD=2.62
* device instance $195 r0 *1 99.925,3.74 pfet
X$195
+ a\x7cd\x7cinv_clk_vdd\x7cinv_mc_vdd\x7cinv_q_vdd\x7cmpa_py\x7cmpb_py\x7cnand_m_vdd\x7cnand_s2_vdd\x7cnwell_vdd\x7csb_vdd\x7csr1_vdd\x7csr2_vdd\x7csr3_vdd\x7csr4_vdd\x7csv_d_vdd_tie\x7csv_vdd\x7ctg_d_a\x7ctg_d_vdd\x7ctg_fbm_vdd\x7ctg_fbs_vdd\x7ctg_s_vdd\x7cvdd\x7cvdd_b1\x7cvdd_b2\x7cvdd_b3\x7cvdd_b4\x7cvdd_link\x7cvdd_link_dip\x7cvdd_x1\x7cvdd_x2\x7cvdd_x3__t28
+ a\x7cinv_q_y\x7cinv_q_y_via\x7cinv_q_y_via2\x7cnand_s2_a\x7cnand_s2_a_stub\x7cnand_s2_a_via\x7cnand_s2_a_via2\x7cq\x7cy__t22
+ a\x7cmnab_y\x7cmpa_y\x7cmpb_y\x7cnand_s2_y\x7cqb\x7ctg_fbs_a\x7cy__t32
+ a\x7cd\x7cinv_clk_vdd\x7cinv_mc_vdd\x7cinv_q_vdd\x7cmpa_py\x7cmpb_py\x7cnand_m_vdd\x7cnand_s2_vdd\x7cnwell_vdd\x7csb_vdd\x7csr1_vdd\x7csr2_vdd\x7csr3_vdd\x7csr4_vdd\x7csv_d_vdd_tie\x7csv_vdd\x7ctg_d_a\x7ctg_d_vdd\x7ctg_fbm_vdd\x7ctg_fbs_vdd\x7ctg_s_vdd\x7cvdd\x7cvdd_b1\x7cvdd_b2\x7cvdd_b3\x7cvdd_b4\x7cvdd_link\x7cvdd_link_dip\x7cvdd_x1\x7cvdd_x2\x7cvdd_x3__t76
+ sky130_fd_pr__pfet_01v8 L=0.15 W=0.84 AS=0.3948 AD=0.3948 PS=2.62 PD=2.62
* device instance $196 r0 *1 104.16,27.165 pfet
X$196
+ a\x7cb\x7cd\x7cinvb_a\x7cmn12_g1\x7cmp24_g0\x7cro2\x7cro2_esc\x7csr2_d_stub\x7ctg_d_a\x7cy__t3
+ a\x7cg_a\x7crn2\x7cro\x7cs4_y\x7cy__t3
+ a\x7cd\x7cinv_clk_vdd\x7cinv_mc_vdd\x7cinv_q_vdd\x7cmpa_py\x7cmpb_py\x7cnand_m_vdd\x7cnand_s2_vdd\x7cnwell_vdd\x7csb_vdd\x7csr1_vdd\x7csr2_vdd\x7csr3_vdd\x7csr4_vdd\x7csv_d_vdd_tie\x7csv_vdd\x7ctg_d_a\x7ctg_d_vdd\x7ctg_fbm_vdd\x7ctg_fbs_vdd\x7ctg_s_vdd\x7cvdd\x7cvdd_b1\x7cvdd_b2\x7cvdd_b3\x7cvdd_b4\x7cvdd_link\x7cvdd_link_dip\x7cvdd_x1\x7cvdd_x2\x7cvdd_x3__t109
+ a\x7cd\x7cinv_clk_vdd\x7cinv_mc_vdd\x7cinv_q_vdd\x7cmpa_py\x7cmpb_py\x7cnand_m_vdd\x7cnand_s2_vdd\x7cnwell_vdd\x7csb_vdd\x7csr1_vdd\x7csr2_vdd\x7csr3_vdd\x7csr4_vdd\x7csv_d_vdd_tie\x7csv_vdd\x7ctg_d_a\x7ctg_d_vdd\x7ctg_fbm_vdd\x7ctg_fbs_vdd\x7ctg_s_vdd\x7cvdd\x7cvdd_b1\x7cvdd_b2\x7cvdd_b3\x7cvdd_b4\x7cvdd_link\x7cvdd_link_dip\x7cvdd_x1\x7cvdd_x2\x7cvdd_x3__t34
+ sky130_fd_pr__pfet_01v8 L=0.15 W=0.84 AS=0.3948 AD=0.3948 PS=2.62 PD=2.62
* device instance $197 r0 *1 116.375,27.375 pfet
X$197 a\x7cg_y\x7cmnab_y\x7cmpa_y\x7cmpb_y\x7cn1\x7cs1_a\x7cy__t03
+ en\x7cen3\x7cg_en__t0 mpa_py\x7cmpb_py\x7cmph_py\x7cpy__t23
+ g_vddr_m1\x7cmnt_g\x7cs1_vddr_m1\x7cs2_vddr_m1\x7cs3_vddr_m1\x7cs4_vddr_m1\x7cvddr\x7cvddr3__t17
+ sky130_fd_pr__pfet_01v8 L=0.15 W=0.84 AS=0.3948 AD=0.3948 PS=2.62 PD=2.62
* device instance $198 r0 *1 117.665,27.375 pfet
X$198 mpa_py\x7cmpb_py\x7cmph_py\x7cpy__t13
+ a\x7cg_a\x7crn3\x7cro\x7cs4_y\x7cy__t3
+ a\x7cg_y\x7cmnab_y\x7cmpa_y\x7cmpb_y\x7cn1\x7cs1_a\x7cy__t33
+ g_vddr_m1\x7cmnt_g\x7cs1_vddr_m1\x7cs2_vddr_m1\x7cs3_vddr_m1\x7cs4_vddr_m1\x7cvddr\x7cvddr3__t16
+ sky130_fd_pr__pfet_01v8 L=0.15 W=0.84 AS=0.3948 AD=0.3948 PS=2.62 PD=2.62
* device instance $199 r0 *1 123.435,3.74 pfet
X$199
+ a\x7cinv_mc_a\x7cmb\x7cmnab_y\x7cmpa_y\x7cmpb_y\x7cnand_m_y\x7ctg_s_a\x7cy__t13
+ en\x7cnand_m_en\x7cnand_m_en_via\x7cnand_s2_en\x7cnand_s2_en_via\x7crst_n__t9
+ a\x7cd\x7cinv_clk_vdd\x7cinv_mc_vdd\x7cinv_q_vdd\x7cmpa_py\x7cmpb_py\x7cnand_m_vdd\x7cnand_s2_vdd\x7cnwell_vdd\x7csb_vdd\x7csr1_vdd\x7csr2_vdd\x7csr3_vdd\x7csr4_vdd\x7csv_d_vdd_tie\x7csv_vdd\x7ctg_d_a\x7ctg_d_vdd\x7ctg_fbm_vdd\x7ctg_fbs_vdd\x7ctg_s_vdd\x7cvdd\x7cvdd_b1\x7cvdd_b2\x7cvdd_b3\x7cvdd_b4\x7cvdd_link\x7cvdd_link_dip\x7cvdd_x1\x7cvdd_x2\x7cvdd_x3__t141
+ a\x7cd\x7cinv_clk_vdd\x7cinv_mc_vdd\x7cinv_q_vdd\x7cmpa_py\x7cmpb_py\x7cnand_m_vdd\x7cnand_s2_vdd\x7cnwell_vdd\x7csb_vdd\x7csr1_vdd\x7csr2_vdd\x7csr3_vdd\x7csr4_vdd\x7csv_d_vdd_tie\x7csv_vdd\x7ctg_d_a\x7ctg_d_vdd\x7ctg_fbm_vdd\x7ctg_fbs_vdd\x7ctg_s_vdd\x7cvdd\x7cvdd_b1\x7cvdd_b2\x7cvdd_b3\x7cvdd_b4\x7cvdd_link\x7cvdd_link_dip\x7cvdd_x1\x7cvdd_x2\x7cvdd_x3__t94
+ sky130_fd_pr__pfet_01v8 L=0.15 W=0.84 AS=0.3948 AD=0.3948 PS=2.62 PD=2.62
* device instance $200 r0 *1 124.725,3.74 pfet
X$200
+ a\x7cd\x7cinv_clk_vdd\x7cinv_mc_vdd\x7cinv_q_vdd\x7cmpa_py\x7cmpb_py\x7cnand_m_vdd\x7cnand_s2_vdd\x7cnwell_vdd\x7csb_vdd\x7csr1_vdd\x7csr2_vdd\x7csr3_vdd\x7csr4_vdd\x7csv_d_vdd_tie\x7csv_vdd\x7ctg_d_a\x7ctg_d_vdd\x7ctg_fbm_vdd\x7ctg_fbs_vdd\x7ctg_s_vdd\x7cvdd\x7cvdd_b1\x7cvdd_b2\x7cvdd_b3\x7cvdd_b4\x7cvdd_link\x7cvdd_link_dip\x7cvdd_x1\x7cvdd_x2\x7cvdd_x3__t30
+ a\x7cb\x7cm_east\x7cm_west\x7cnand_m_a\x7cnand_m_a_ext_via\x7cnand_m_a_ext_via2\x7cnand_m_a_stub\x7ctg_d_b\x7ctg_d_b_via\x7ctg_d_b_via2\x7ctg_fbm_b\x7ctg_fbm_b_alt_via\x7ctg_fbm_b_alt_via2__t03
+ a\x7cinv_mc_a\x7cmb\x7cmnab_y\x7cmpa_y\x7cmpb_y\x7cnand_m_y\x7ctg_s_a\x7cy__t53
+ a\x7cd\x7cinv_clk_vdd\x7cinv_mc_vdd\x7cinv_q_vdd\x7cmpa_py\x7cmpb_py\x7cnand_m_vdd\x7cnand_s2_vdd\x7cnwell_vdd\x7csb_vdd\x7csr1_vdd\x7csr2_vdd\x7csr3_vdd\x7csr4_vdd\x7csv_d_vdd_tie\x7csv_vdd\x7ctg_d_a\x7ctg_d_vdd\x7ctg_fbm_vdd\x7ctg_fbs_vdd\x7ctg_s_vdd\x7cvdd\x7cvdd_b1\x7cvdd_b2\x7cvdd_b3\x7cvdd_b4\x7cvdd_link\x7cvdd_link_dip\x7cvdd_x1\x7cvdd_x2\x7cvdd_x3__t92
+ sky130_fd_pr__pfet_01v8 L=0.15 W=0.84 AS=0.3948 AD=0.3948 PS=2.62 PD=2.62
* device instance $201 r0 *1 125.675,27.375 pfet
X$201 a\x7cn2\x7cs1_y\x7cs2_a\x7cy__t13
+ a\x7cg_y\x7cmnab_y\x7cmpa_y\x7cmpb_y\x7cn1\x7cs1_a\x7cy__t23 py__t19
+ g_vddr_m1\x7cmnt_g\x7cs1_vddr_m1\x7cs2_vddr_m1\x7cs3_vddr_m1\x7cs4_vddr_m1\x7cvddr\x7cvddr3__t15
+ sky130_fd_pr__pfet_01v8 L=0.15 W=0.84 AS=0.3948 AD=0.3948 PS=2.62 PD=2.62
* device instance $202 r0 *1 133.85,27.375 pfet
X$202 a\x7cn3\x7cs2_y\x7cs3_a\x7cy__t13 a\x7cn2\x7cs1_y\x7cs2_a\x7cy__t33
+ py__t110
+ g_vddr_m1\x7cmnt_g\x7cs1_vddr_m1\x7cs2_vddr_m1\x7cs3_vddr_m1\x7cs4_vddr_m1\x7cvddr\x7cvddr3__t18
+ sky130_fd_pr__pfet_01v8 L=0.15 W=0.84 AS=0.3948 AD=0.3948 PS=2.62 PD=2.62
* device instance $203 r0 *1 142.025,27.375 pfet
X$203 a\x7cn4\x7cs3_y\x7cs4_a\x7cy__t14 a\x7cn3\x7cs2_y\x7cs3_a\x7cy__t33
+ py__t111
+ g_vddr_m1\x7cmnt_g\x7cs1_vddr_m1\x7cs2_vddr_m1\x7cs3_vddr_m1\x7cs4_vddr_m1\x7cvddr\x7cvddr3__t20
+ sky130_fd_pr__pfet_01v8 L=0.15 W=0.84 AS=0.3948 AD=0.3948 PS=2.62 PD=2.62
* device instance $204 r0 *1 150.2,27.375 pfet
X$204 a\x7cg_a\x7crn3\x7cro\x7cs4_y\x7cy__t1 a\x7cn4\x7cs3_y\x7cs4_a\x7cy__t34
+ py__t112
+ g_vddr_m1\x7cmnt_g\x7cs1_vddr_m1\x7cs2_vddr_m1\x7cs3_vddr_m1\x7cs4_vddr_m1\x7cvddr\x7cvddr3__t19
+ sky130_fd_pr__pfet_01v8 L=0.15 W=0.84 AS=0.3948 AD=0.3948 PS=2.62 PD=2.62
* device instance $205 r0 *1 154.295,3.74 pfet
X$205 a\x7cmnab_y\x7cmpa_y\x7cmpb_y\x7cnand_s2_y\x7cqb\x7ctg_fbs_a\x7cy__t13
+ en\x7cnand_m_en\x7cnand_m_en_via\x7cnand_s2_en\x7cnand_s2_en_via\x7crst_n__t8
+ a\x7cd\x7cinv_clk_vdd\x7cinv_mc_vdd\x7cinv_q_vdd\x7cmpa_py\x7cmpb_py\x7cnand_m_vdd\x7cnand_s2_vdd\x7cnwell_vdd\x7csb_vdd\x7csr1_vdd\x7csr2_vdd\x7csr3_vdd\x7csr4_vdd\x7csv_d_vdd_tie\x7csv_vdd\x7ctg_d_a\x7ctg_d_vdd\x7ctg_fbm_vdd\x7ctg_fbs_vdd\x7ctg_s_vdd\x7cvdd\x7cvdd_b1\x7cvdd_b2\x7cvdd_b3\x7cvdd_b4\x7cvdd_link\x7cvdd_link_dip\x7cvdd_x1\x7cvdd_x2\x7cvdd_x3__t140
+ a\x7cd\x7cinv_clk_vdd\x7cinv_mc_vdd\x7cinv_q_vdd\x7cmpa_py\x7cmpb_py\x7cnand_m_vdd\x7cnand_s2_vdd\x7cnwell_vdd\x7csb_vdd\x7csr1_vdd\x7csr2_vdd\x7csr3_vdd\x7csr4_vdd\x7csv_d_vdd_tie\x7csv_vdd\x7ctg_d_a\x7ctg_d_vdd\x7ctg_fbm_vdd\x7ctg_fbs_vdd\x7ctg_s_vdd\x7cvdd\x7cvdd_b1\x7cvdd_b2\x7cvdd_b3\x7cvdd_b4\x7cvdd_link\x7cvdd_link_dip\x7cvdd_x1\x7cvdd_x2\x7cvdd_x3__t91
+ sky130_fd_pr__pfet_01v8 L=0.15 W=0.84 AS=0.3948 AD=0.3948 PS=2.62 PD=2.62
* device instance $206 r0 *1 155.585,3.74 pfet
X$206
+ a\x7cd\x7cinv_clk_vdd\x7cinv_mc_vdd\x7cinv_q_vdd\x7cmpa_py\x7cmpb_py\x7cnand_m_vdd\x7cnand_s2_vdd\x7cnwell_vdd\x7csb_vdd\x7csr1_vdd\x7csr2_vdd\x7csr3_vdd\x7csr4_vdd\x7csv_d_vdd_tie\x7csv_vdd\x7ctg_d_a\x7ctg_d_vdd\x7ctg_fbm_vdd\x7ctg_fbs_vdd\x7ctg_s_vdd\x7cvdd\x7cvdd_b1\x7cvdd_b2\x7cvdd_b3\x7cvdd_b4\x7cvdd_link\x7cvdd_link_dip\x7cvdd_x1\x7cvdd_x2\x7cvdd_x3__t29
+ a\x7cinv_q_y\x7cinv_q_y_via\x7cinv_q_y_via2\x7cnand_s2_a\x7cnand_s2_a_stub\x7cnand_s2_a_via\x7cnand_s2_a_via2\x7cq\x7cy__t23
+ a\x7cmnab_y\x7cmpa_y\x7cmpb_y\x7cnand_s2_y\x7cqb\x7ctg_fbs_a\x7cy__t33
+ a\x7cd\x7cinv_clk_vdd\x7cinv_mc_vdd\x7cinv_q_vdd\x7cmpa_py\x7cmpb_py\x7cnand_m_vdd\x7cnand_s2_vdd\x7cnwell_vdd\x7csb_vdd\x7csr1_vdd\x7csr2_vdd\x7csr3_vdd\x7csr4_vdd\x7csv_d_vdd_tie\x7csv_vdd\x7ctg_d_a\x7ctg_d_vdd\x7ctg_fbm_vdd\x7ctg_fbs_vdd\x7ctg_s_vdd\x7cvdd\x7cvdd_b1\x7cvdd_b2\x7cvdd_b3\x7cvdd_b4\x7cvdd_link\x7cvdd_link_dip\x7cvdd_x1\x7cvdd_x2\x7cvdd_x3__t88
+ sky130_fd_pr__pfet_01v8 L=0.15 W=0.84 AS=0.3948 AD=0.3948 PS=2.62 PD=2.62
* device instance $207 r0 *1 159.46,27.165 pfet
X$207
+ a\x7cd\x7cinva_a\x7cmn12_g0\x7cmp13_g0\x7cro3\x7cro3_esc_e\x7cro3_esc_w\x7cro3_hop\x7csr3_d_stub\x7ctg_d_a\x7cy__t3
+ a\x7cg_a\x7crn3\x7cro\x7cs4_y\x7cy__t4
+ a\x7cd\x7cinv_clk_vdd\x7cinv_mc_vdd\x7cinv_q_vdd\x7cmpa_py\x7cmpb_py\x7cnand_m_vdd\x7cnand_s2_vdd\x7cnwell_vdd\x7csb_vdd\x7csr1_vdd\x7csr2_vdd\x7csr3_vdd\x7csr4_vdd\x7csv_d_vdd_tie\x7csv_vdd\x7ctg_d_a\x7ctg_d_vdd\x7ctg_fbm_vdd\x7ctg_fbs_vdd\x7ctg_s_vdd\x7cvdd\x7cvdd_b1\x7cvdd_b2\x7cvdd_b3\x7cvdd_b4\x7cvdd_link\x7cvdd_link_dip\x7cvdd_x1\x7cvdd_x2\x7cvdd_x3__t126
+ a\x7cd\x7cinv_clk_vdd\x7cinv_mc_vdd\x7cinv_q_vdd\x7cmpa_py\x7cmpb_py\x7cnand_m_vdd\x7cnand_s2_vdd\x7cnwell_vdd\x7csb_vdd\x7csr1_vdd\x7csr2_vdd\x7csr3_vdd\x7csr4_vdd\x7csv_d_vdd_tie\x7csv_vdd\x7ctg_d_a\x7ctg_d_vdd\x7ctg_fbm_vdd\x7ctg_fbs_vdd\x7ctg_s_vdd\x7cvdd\x7cvdd_b1\x7cvdd_b2\x7cvdd_b3\x7cvdd_b4\x7cvdd_link\x7cvdd_link_dip\x7cvdd_x1\x7cvdd_x2\x7cvdd_x3__t62
+ sky130_fd_pr__pfet_01v8 L=0.15 W=0.84 AS=0.3948 AD=0.3948 PS=2.62 PD=2.62
* device instance $208 r0 *1 171.675,27.375 pfet
X$208 a\x7cg_y\x7cmnab_y\x7cmpa_y\x7cmpb_y\x7cn1\x7cs1_a\x7cy__t04
+ en\x7cen4\x7cg_en__t0 mpa_py\x7cmpb_py\x7cmph_py\x7cpy__t24
+ g_vddr_m1\x7cmnt_g\x7cs1_vddr_m1\x7cs2_vddr_m1\x7cs3_vddr_m1\x7cs4_vddr_m1\x7cvddr\x7cvddr4__t16
+ sky130_fd_pr__pfet_01v8 L=0.15 W=0.84 AS=0.3948 AD=0.3948 PS=2.62 PD=2.62
* device instance $209 r0 *1 172.965,27.375 pfet
X$209 mpa_py\x7cmpb_py\x7cmph_py\x7cpy__t14
+ a\x7cg_a\x7crn4\x7cro\x7cs4_y\x7cy__t3
+ a\x7cg_y\x7cmnab_y\x7cmpa_y\x7cmpb_y\x7cn1\x7cs1_a\x7cy__t34
+ g_vddr_m1\x7cmnt_g\x7cs1_vddr_m1\x7cs2_vddr_m1\x7cs3_vddr_m1\x7cs4_vddr_m1\x7cvddr\x7cvddr4__t15
+ sky130_fd_pr__pfet_01v8 L=0.15 W=0.84 AS=0.3948 AD=0.3948 PS=2.62 PD=2.62
* device instance $210 r0 *1 179.095,3.74 pfet
X$210
+ a\x7cinv_mc_a\x7cmb\x7cmnab_y\x7cmpa_y\x7cmpb_y\x7cnand_m_y\x7ctg_s_a\x7cy__t14
+ en\x7cnand_m_en\x7cnand_m_en_via\x7cnand_s2_en\x7cnand_s2_en_via\x7crst_n__t1
+ a\x7cd\x7cinv_clk_vdd\x7cinv_mc_vdd\x7cinv_q_vdd\x7cmpa_py\x7cmpb_py\x7cnand_m_vdd\x7cnand_s2_vdd\x7cnwell_vdd\x7csb_vdd\x7csr1_vdd\x7csr2_vdd\x7csr3_vdd\x7csr4_vdd\x7csv_d_vdd_tie\x7csv_vdd\x7ctg_d_a\x7ctg_d_vdd\x7ctg_fbm_vdd\x7ctg_fbs_vdd\x7ctg_s_vdd\x7cvdd\x7cvdd_b1\x7cvdd_b2\x7cvdd_b3\x7cvdd_b4\x7cvdd_link\x7cvdd_link_dip\x7cvdd_x1\x7cvdd_x2\x7cvdd_x3__t112
+ a\x7cd\x7cinv_clk_vdd\x7cinv_mc_vdd\x7cinv_q_vdd\x7cmpa_py\x7cmpb_py\x7cnand_m_vdd\x7cnand_s2_vdd\x7cnwell_vdd\x7csb_vdd\x7csr1_vdd\x7csr2_vdd\x7csr3_vdd\x7csr4_vdd\x7csv_d_vdd_tie\x7csv_vdd\x7ctg_d_a\x7ctg_d_vdd\x7ctg_fbm_vdd\x7ctg_fbs_vdd\x7ctg_s_vdd\x7cvdd\x7cvdd_b1\x7cvdd_b2\x7cvdd_b3\x7cvdd_b4\x7cvdd_link\x7cvdd_link_dip\x7cvdd_x1\x7cvdd_x2\x7cvdd_x3__t38
+ sky130_fd_pr__pfet_01v8 L=0.15 W=0.84 AS=0.3948 AD=0.3948 PS=2.62 PD=2.62
* device instance $211 r0 *1 180.385,3.74 pfet
X$211
+ a\x7cd\x7cinv_clk_vdd\x7cinv_mc_vdd\x7cinv_q_vdd\x7cmpa_py\x7cmpb_py\x7cnand_m_vdd\x7cnand_s2_vdd\x7cnwell_vdd\x7csb_vdd\x7csr1_vdd\x7csr2_vdd\x7csr3_vdd\x7csr4_vdd\x7csv_d_vdd_tie\x7csv_vdd\x7ctg_d_a\x7ctg_d_vdd\x7ctg_fbm_vdd\x7ctg_fbs_vdd\x7ctg_s_vdd\x7cvdd\x7cvdd_b1\x7cvdd_b2\x7cvdd_b3\x7cvdd_b4\x7cvdd_link\x7cvdd_link_dip\x7cvdd_x1\x7cvdd_x2\x7cvdd_x3__t21
+ a\x7cb\x7cm_east\x7cm_west\x7cnand_m_a\x7cnand_m_a_ext_via\x7cnand_m_a_ext_via2\x7cnand_m_a_stub\x7ctg_d_b\x7ctg_d_b_via\x7ctg_d_b_via2\x7ctg_fbm_b\x7ctg_fbm_b_alt_via\x7ctg_fbm_b_alt_via2__t04
+ a\x7cinv_mc_a\x7cmb\x7cmnab_y\x7cmpa_y\x7cmpb_y\x7cnand_m_y\x7ctg_s_a\x7cy__t54
+ a\x7cd\x7cinv_clk_vdd\x7cinv_mc_vdd\x7cinv_q_vdd\x7cmpa_py\x7cmpb_py\x7cnand_m_vdd\x7cnand_s2_vdd\x7cnwell_vdd\x7csb_vdd\x7csr1_vdd\x7csr2_vdd\x7csr3_vdd\x7csr4_vdd\x7csv_d_vdd_tie\x7csv_vdd\x7ctg_d_a\x7ctg_d_vdd\x7ctg_fbm_vdd\x7ctg_fbs_vdd\x7ctg_s_vdd\x7cvdd\x7cvdd_b1\x7cvdd_b2\x7cvdd_b3\x7cvdd_b4\x7cvdd_link\x7cvdd_link_dip\x7cvdd_x1\x7cvdd_x2\x7cvdd_x3__t37
+ sky130_fd_pr__pfet_01v8 L=0.15 W=0.84 AS=0.3948 AD=0.3948 PS=2.62 PD=2.62
* device instance $212 r0 *1 180.975,27.375 pfet
X$212 a\x7cn2\x7cs1_y\x7cs2_a\x7cy__t14
+ a\x7cg_y\x7cmnab_y\x7cmpa_y\x7cmpb_y\x7cn1\x7cs1_a\x7cy__t24 py__t113
+ g_vddr_m1\x7cmnt_g\x7cs1_vddr_m1\x7cs2_vddr_m1\x7cs3_vddr_m1\x7cs4_vddr_m1\x7cvddr\x7cvddr4__t17
+ sky130_fd_pr__pfet_01v8 L=0.15 W=0.84 AS=0.3948 AD=0.3948 PS=2.62 PD=2.62
* device instance $213 r0 *1 189.15,27.375 pfet
X$213 a\x7cn3\x7cs2_y\x7cs3_a\x7cy__t14 a\x7cn2\x7cs1_y\x7cs2_a\x7cy__t34
+ py__t114
+ g_vddr_m1\x7cmnt_g\x7cs1_vddr_m1\x7cs2_vddr_m1\x7cs3_vddr_m1\x7cs4_vddr_m1\x7cvddr\x7cvddr4__t20
+ sky130_fd_pr__pfet_01v8 L=0.15 W=0.84 AS=0.3948 AD=0.3948 PS=2.62 PD=2.62
* device instance $214 r0 *1 197.325,27.375 pfet
X$214 a\x7cn4\x7cs3_y\x7cs4_a\x7cy__t12 a\x7cn3\x7cs2_y\x7cs3_a\x7cy__t34
+ py__t115
+ g_vddr_m1\x7cmnt_g\x7cs1_vddr_m1\x7cs2_vddr_m1\x7cs3_vddr_m1\x7cs4_vddr_m1\x7cvddr\x7cvddr4__t19
+ sky130_fd_pr__pfet_01v8 L=0.15 W=0.84 AS=0.3948 AD=0.3948 PS=2.62 PD=2.62
* device instance $215 r0 *1 205.5,27.375 pfet
X$215 a\x7cg_a\x7crn4\x7cro\x7cs4_y\x7cy__t1 a\x7cn4\x7cs3_y\x7cs4_a\x7cy__t32
+ py__t116
+ g_vddr_m1\x7cmnt_g\x7cs1_vddr_m1\x7cs2_vddr_m1\x7cs3_vddr_m1\x7cs4_vddr_m1\x7cvddr\x7cvddr4__t18
+ sky130_fd_pr__pfet_01v8 L=0.15 W=0.84 AS=0.3948 AD=0.3948 PS=2.62 PD=2.62
* device instance $216 r0 *1 209.955,3.74 pfet
X$216 a\x7cmnab_y\x7cmpa_y\x7cmpb_y\x7cnand_s2_y\x7cqb\x7ctg_fbs_a\x7cy__t14
+ en\x7cnand_m_en\x7cnand_m_en_via\x7cnand_s2_en\x7cnand_s2_en_via\x7crst_n__t3
+ a\x7cd\x7cinv_clk_vdd\x7cinv_mc_vdd\x7cinv_q_vdd\x7cmpa_py\x7cmpb_py\x7cnand_m_vdd\x7cnand_s2_vdd\x7cnwell_vdd\x7csb_vdd\x7csr1_vdd\x7csr2_vdd\x7csr3_vdd\x7csr4_vdd\x7csv_d_vdd_tie\x7csv_vdd\x7ctg_d_a\x7ctg_d_vdd\x7ctg_fbm_vdd\x7ctg_fbs_vdd\x7ctg_s_vdd\x7cvdd\x7cvdd_b1\x7cvdd_b2\x7cvdd_b3\x7cvdd_b4\x7cvdd_link\x7cvdd_link_dip\x7cvdd_x1\x7cvdd_x2\x7cvdd_x3__t119
+ a\x7cd\x7cinv_clk_vdd\x7cinv_mc_vdd\x7cinv_q_vdd\x7cmpa_py\x7cmpb_py\x7cnand_m_vdd\x7cnand_s2_vdd\x7cnwell_vdd\x7csb_vdd\x7csr1_vdd\x7csr2_vdd\x7csr3_vdd\x7csr4_vdd\x7csv_d_vdd_tie\x7csv_vdd\x7ctg_d_a\x7ctg_d_vdd\x7ctg_fbm_vdd\x7ctg_fbs_vdd\x7ctg_s_vdd\x7cvdd\x7cvdd_b1\x7cvdd_b2\x7cvdd_b3\x7cvdd_b4\x7cvdd_link\x7cvdd_link_dip\x7cvdd_x1\x7cvdd_x2\x7cvdd_x3__t51
+ sky130_fd_pr__pfet_01v8 L=0.15 W=0.84 AS=0.3948 AD=0.3948 PS=2.62 PD=2.62
* device instance $217 r0 *1 211.245,3.74 pfet
X$217
+ a\x7cd\x7cinv_clk_vdd\x7cinv_mc_vdd\x7cinv_q_vdd\x7cmpa_py\x7cmpb_py\x7cnand_m_vdd\x7cnand_s2_vdd\x7cnwell_vdd\x7csb_vdd\x7csr1_vdd\x7csr2_vdd\x7csr3_vdd\x7csr4_vdd\x7csv_d_vdd_tie\x7csv_vdd\x7ctg_d_a\x7ctg_d_vdd\x7ctg_fbm_vdd\x7ctg_fbs_vdd\x7ctg_s_vdd\x7cvdd\x7cvdd_b1\x7cvdd_b2\x7cvdd_b3\x7cvdd_b4\x7cvdd_link\x7cvdd_link_dip\x7cvdd_x1\x7cvdd_x2\x7cvdd_x3__t23
+ a\x7cinv_q_y\x7cinv_q_y_via\x7cinv_q_y_via2\x7cnand_s2_a\x7cnand_s2_a_stub\x7cnand_s2_a_via\x7cnand_s2_a_via2\x7cq\x7cy__t24
+ a\x7cmnab_y\x7cmpa_y\x7cmpb_y\x7cnand_s2_y\x7cqb\x7ctg_fbs_a\x7cy__t34
+ a\x7cd\x7cinv_clk_vdd\x7cinv_mc_vdd\x7cinv_q_vdd\x7cmpa_py\x7cmpb_py\x7cnand_m_vdd\x7cnand_s2_vdd\x7cnwell_vdd\x7csb_vdd\x7csr1_vdd\x7csr2_vdd\x7csr3_vdd\x7csr4_vdd\x7csv_d_vdd_tie\x7csv_vdd\x7ctg_d_a\x7ctg_d_vdd\x7ctg_fbm_vdd\x7ctg_fbs_vdd\x7ctg_s_vdd\x7cvdd\x7cvdd_b1\x7cvdd_b2\x7cvdd_b3\x7cvdd_b4\x7cvdd_link\x7cvdd_link_dip\x7cvdd_x1\x7cvdd_x2\x7cvdd_x3__t50
+ sky130_fd_pr__pfet_01v8 L=0.15 W=0.84 AS=0.3948 AD=0.3948 PS=2.62 PD=2.62
* device instance $218 r0 *1 214.76,27.165 pfet
X$218
+ a\x7cb\x7cd\x7cinvb_a\x7cmn12_g1\x7cmp24_g0\x7cro4\x7cro4_esc\x7csr4_d_stub\x7ctg_d_a\x7cy__t4
+ a\x7cg_a\x7crn4\x7cro\x7cs4_y\x7cy__t4
+ a\x7cd\x7cinv_clk_vdd\x7cinv_mc_vdd\x7cinv_q_vdd\x7cmpa_py\x7cmpb_py\x7cnand_m_vdd\x7cnand_s2_vdd\x7cnwell_vdd\x7csb_vdd\x7csr1_vdd\x7csr2_vdd\x7csr3_vdd\x7csr4_vdd\x7csv_d_vdd_tie\x7csv_vdd\x7ctg_d_a\x7ctg_d_vdd\x7ctg_fbm_vdd\x7ctg_fbs_vdd\x7ctg_s_vdd\x7cvdd\x7cvdd_b1\x7cvdd_b2\x7cvdd_b3\x7cvdd_b4\x7cvdd_link\x7cvdd_link_dip\x7cvdd_x1\x7cvdd_x2\x7cvdd_x3__t118
+ a\x7cd\x7cinv_clk_vdd\x7cinv_mc_vdd\x7cinv_q_vdd\x7cmpa_py\x7cmpb_py\x7cnand_m_vdd\x7cnand_s2_vdd\x7cnwell_vdd\x7csb_vdd\x7csr1_vdd\x7csr2_vdd\x7csr3_vdd\x7csr4_vdd\x7csv_d_vdd_tie\x7csv_vdd\x7ctg_d_a\x7ctg_d_vdd\x7ctg_fbm_vdd\x7ctg_fbs_vdd\x7ctg_s_vdd\x7cvdd\x7cvdd_b1\x7cvdd_b2\x7cvdd_b3\x7cvdd_b4\x7cvdd_link\x7cvdd_link_dip\x7cvdd_x1\x7cvdd_x2\x7cvdd_x3__t49
+ sky130_fd_pr__pfet_01v8 L=0.15 W=0.84 AS=0.3948 AD=0.3948 PS=2.62 PD=2.62
* device instance $219 r0 *1 234.755,3.74 pfet
X$219
+ a\x7cinv_mc_a\x7cmb\x7cmnab_y\x7cmpa_y\x7cmpb_y\x7cnand_m_y\x7ctg_s_a\x7cy__t15
+ en\x7cnand_m_en\x7cnand_m_en_via\x7cnand_s2_en\x7cnand_s2_en_via\x7crst_n__t2
+ a\x7cd\x7cinv_clk_vdd\x7cinv_mc_vdd\x7cinv_q_vdd\x7cmpa_py\x7cmpb_py\x7cnand_m_vdd\x7cnand_s2_vdd\x7cnwell_vdd\x7csb_vdd\x7csr1_vdd\x7csr2_vdd\x7csr3_vdd\x7csr4_vdd\x7csv_d_vdd_tie\x7csv_vdd\x7ctg_d_a\x7ctg_d_vdd\x7ctg_fbm_vdd\x7ctg_fbs_vdd\x7ctg_s_vdd\x7cvdd\x7cvdd_b1\x7cvdd_b2\x7cvdd_b3\x7cvdd_b4\x7cvdd_link\x7cvdd_link_dip\x7cvdd_x1\x7cvdd_x2\x7cvdd_x3__t117
+ a\x7cd\x7cinv_clk_vdd\x7cinv_mc_vdd\x7cinv_q_vdd\x7cmpa_py\x7cmpb_py\x7cnand_m_vdd\x7cnand_s2_vdd\x7cnwell_vdd\x7csb_vdd\x7csr1_vdd\x7csr2_vdd\x7csr3_vdd\x7csr4_vdd\x7csv_d_vdd_tie\x7csv_vdd\x7ctg_d_a\x7ctg_d_vdd\x7ctg_fbm_vdd\x7ctg_fbs_vdd\x7ctg_s_vdd\x7cvdd\x7cvdd_b1\x7cvdd_b2\x7cvdd_b3\x7cvdd_b4\x7cvdd_link\x7cvdd_link_dip\x7cvdd_x1\x7cvdd_x2\x7cvdd_x3__t48
+ sky130_fd_pr__pfet_01v8 L=0.15 W=0.84 AS=0.3948 AD=0.3948 PS=2.62 PD=2.62
* device instance $220 r0 *1 236.045,3.74 pfet
X$220
+ a\x7cd\x7cinv_clk_vdd\x7cinv_mc_vdd\x7cinv_q_vdd\x7cmpa_py\x7cmpb_py\x7cnand_m_vdd\x7cnand_s2_vdd\x7cnwell_vdd\x7csb_vdd\x7csr1_vdd\x7csr2_vdd\x7csr3_vdd\x7csr4_vdd\x7csv_d_vdd_tie\x7csv_vdd\x7ctg_d_a\x7ctg_d_vdd\x7ctg_fbm_vdd\x7ctg_fbs_vdd\x7ctg_s_vdd\x7cvdd\x7cvdd_b1\x7cvdd_b2\x7cvdd_b3\x7cvdd_b4\x7cvdd_link\x7cvdd_link_dip\x7cvdd_x1\x7cvdd_x2\x7cvdd_x3__t22
+ a\x7cb\x7cm_east\x7cm_west\x7cnand_m_a\x7cnand_m_a_ext_via\x7cnand_m_a_ext_via2\x7cnand_m_a_stub\x7ctg_d_b\x7ctg_d_b_via\x7ctg_d_b_via2\x7ctg_fbm_b\x7ctg_fbm_b_alt_via\x7ctg_fbm_b_alt_via2__t05
+ a\x7cinv_mc_a\x7cmb\x7cmnab_y\x7cmpa_y\x7cmpb_y\x7cnand_m_y\x7ctg_s_a\x7cy__t55
+ a\x7cd\x7cinv_clk_vdd\x7cinv_mc_vdd\x7cinv_q_vdd\x7cmpa_py\x7cmpb_py\x7cnand_m_vdd\x7cnand_s2_vdd\x7cnwell_vdd\x7csb_vdd\x7csr1_vdd\x7csr2_vdd\x7csr3_vdd\x7csr4_vdd\x7csv_d_vdd_tie\x7csv_vdd\x7ctg_d_a\x7ctg_d_vdd\x7ctg_fbm_vdd\x7ctg_fbs_vdd\x7ctg_s_vdd\x7cvdd\x7cvdd_b1\x7cvdd_b2\x7cvdd_b3\x7cvdd_b4\x7cvdd_link\x7cvdd_link_dip\x7cvdd_x1\x7cvdd_x2\x7cvdd_x3__t47
+ sky130_fd_pr__pfet_01v8 L=0.15 W=0.84 AS=0.3948 AD=0.3948 PS=2.62 PD=2.62
* device instance $221 r0 *1 265.615,3.74 pfet
X$221 a\x7cmnab_y\x7cmpa_y\x7cmpb_y\x7cnand_s2_y\x7cqb\x7ctg_fbs_a\x7cy__t15
+ en\x7cnand_m_en\x7cnand_m_en_via\x7cnand_s2_en\x7cnand_s2_en_via\x7crst_n__t4
+ a\x7cd\x7cinv_clk_vdd\x7cinv_mc_vdd\x7cinv_q_vdd\x7cmpa_py\x7cmpb_py\x7cnand_m_vdd\x7cnand_s2_vdd\x7cnwell_vdd\x7csb_vdd\x7csr1_vdd\x7csr2_vdd\x7csr3_vdd\x7csr4_vdd\x7csv_d_vdd_tie\x7csv_vdd\x7ctg_d_a\x7ctg_d_vdd\x7ctg_fbm_vdd\x7ctg_fbs_vdd\x7ctg_s_vdd\x7cvdd\x7cvdd_b1\x7cvdd_b2\x7cvdd_b3\x7cvdd_b4\x7cvdd_link\x7cvdd_link_dip\x7cvdd_x1\x7cvdd_x2\x7cvdd_x3__t120
+ a\x7cd\x7cinv_clk_vdd\x7cinv_mc_vdd\x7cinv_q_vdd\x7cmpa_py\x7cmpb_py\x7cnand_m_vdd\x7cnand_s2_vdd\x7cnwell_vdd\x7csb_vdd\x7csr1_vdd\x7csr2_vdd\x7csr3_vdd\x7csr4_vdd\x7csv_d_vdd_tie\x7csv_vdd\x7ctg_d_a\x7ctg_d_vdd\x7ctg_fbm_vdd\x7ctg_fbs_vdd\x7ctg_s_vdd\x7cvdd\x7cvdd_b1\x7cvdd_b2\x7cvdd_b3\x7cvdd_b4\x7cvdd_link\x7cvdd_link_dip\x7cvdd_x1\x7cvdd_x2\x7cvdd_x3__t52
+ sky130_fd_pr__pfet_01v8 L=0.15 W=0.84 AS=0.3948 AD=0.3948 PS=2.62 PD=2.62
* device instance $222 r0 *1 266.905,3.74 pfet
X$222
+ a\x7cd\x7cinv_clk_vdd\x7cinv_mc_vdd\x7cinv_q_vdd\x7cmpa_py\x7cmpb_py\x7cnand_m_vdd\x7cnand_s2_vdd\x7cnwell_vdd\x7csb_vdd\x7csr1_vdd\x7csr2_vdd\x7csr3_vdd\x7csr4_vdd\x7csv_d_vdd_tie\x7csv_vdd\x7ctg_d_a\x7ctg_d_vdd\x7ctg_fbm_vdd\x7ctg_fbs_vdd\x7ctg_s_vdd\x7cvdd\x7cvdd_b1\x7cvdd_b2\x7cvdd_b3\x7cvdd_b4\x7cvdd_link\x7cvdd_link_dip\x7cvdd_x1\x7cvdd_x2\x7cvdd_x3__t24
+ a\x7cinv_q_y\x7cinv_q_y_via\x7cinv_q_y_via2\x7cnand_s2_a\x7cnand_s2_a_stub\x7cnand_s2_a_via\x7cnand_s2_a_via2\x7cq\x7cy__t25
+ a\x7cmnab_y\x7cmpa_y\x7cmpb_y\x7cnand_s2_y\x7cqb\x7ctg_fbs_a\x7cy__t35
+ a\x7cd\x7cinv_clk_vdd\x7cinv_mc_vdd\x7cinv_q_vdd\x7cmpa_py\x7cmpb_py\x7cnand_m_vdd\x7cnand_s2_vdd\x7cnwell_vdd\x7csb_vdd\x7csr1_vdd\x7csr2_vdd\x7csr3_vdd\x7csr4_vdd\x7csv_d_vdd_tie\x7csv_vdd\x7ctg_d_a\x7ctg_d_vdd\x7ctg_fbm_vdd\x7ctg_fbs_vdd\x7ctg_s_vdd\x7cvdd\x7cvdd_b1\x7cvdd_b2\x7cvdd_b3\x7cvdd_b4\x7cvdd_link\x7cvdd_link_dip\x7cvdd_x1\x7cvdd_x2\x7cvdd_x3__t55
+ sky130_fd_pr__pfet_01v8 L=0.15 W=0.84 AS=0.3948 AD=0.3948 PS=2.62 PD=2.62
* device instance $223 r0 *1 290.415,3.74 pfet
X$223
+ a\x7cinv_mc_a\x7cmb\x7cmnab_y\x7cmpa_y\x7cmpb_y\x7cnand_m_y\x7ctg_s_a\x7cy__t26
+ en\x7cnand_m_en\x7cnand_m_en_via\x7cnand_s2_en\x7cnand_s2_en_via\x7crst_n__t5
+ a\x7cd\x7cinv_clk_vdd\x7cinv_mc_vdd\x7cinv_q_vdd\x7cmpa_py\x7cmpb_py\x7cnand_m_vdd\x7cnand_s2_vdd\x7cnwell_vdd\x7csb_vdd\x7csr1_vdd\x7csr2_vdd\x7csr3_vdd\x7csr4_vdd\x7csv_d_vdd_tie\x7csv_vdd\x7ctg_d_a\x7ctg_d_vdd\x7ctg_fbm_vdd\x7ctg_fbs_vdd\x7ctg_s_vdd\x7cvdd\x7cvdd_b1\x7cvdd_b2\x7cvdd_b3\x7cvdd_b4\x7cvdd_link\x7cvdd_link_dip\x7cvdd_x1\x7cvdd_x2\x7cvdd_x3__t123
+ a\x7cd\x7cinv_clk_vdd\x7cinv_mc_vdd\x7cinv_q_vdd\x7cmpa_py\x7cmpb_py\x7cnand_m_vdd\x7cnand_s2_vdd\x7cnwell_vdd\x7csb_vdd\x7csr1_vdd\x7csr2_vdd\x7csr3_vdd\x7csr4_vdd\x7csv_d_vdd_tie\x7csv_vdd\x7ctg_d_a\x7ctg_d_vdd\x7ctg_fbm_vdd\x7ctg_fbs_vdd\x7ctg_s_vdd\x7cvdd\x7cvdd_b1\x7cvdd_b2\x7cvdd_b3\x7cvdd_b4\x7cvdd_link\x7cvdd_link_dip\x7cvdd_x1\x7cvdd_x2\x7cvdd_x3__t57
+ sky130_fd_pr__pfet_01v8 L=0.15 W=0.84 AS=0.3948 AD=0.3948 PS=2.62 PD=2.62
* device instance $224 r0 *1 291.705,3.74 pfet
X$224
+ a\x7cd\x7cinv_clk_vdd\x7cinv_mc_vdd\x7cinv_q_vdd\x7cmpa_py\x7cmpb_py\x7cnand_m_vdd\x7cnand_s2_vdd\x7cnwell_vdd\x7csb_vdd\x7csr1_vdd\x7csr2_vdd\x7csr3_vdd\x7csr4_vdd\x7csv_d_vdd_tie\x7csv_vdd\x7ctg_d_a\x7ctg_d_vdd\x7ctg_fbm_vdd\x7ctg_fbs_vdd\x7ctg_s_vdd\x7cvdd\x7cvdd_b1\x7cvdd_b2\x7cvdd_b3\x7cvdd_b4\x7cvdd_link\x7cvdd_link_dip\x7cvdd_x1\x7cvdd_x2\x7cvdd_x3__t25
+ a\x7cb\x7cm_east\x7cm_west\x7cnand_m_a\x7cnand_m_a_ext_via\x7cnand_m_a_ext_via2\x7cnand_m_a_stub\x7ctg_d_b\x7ctg_d_b_via\x7ctg_d_b_via2\x7ctg_fbm_b\x7ctg_fbm_b_alt_via\x7ctg_fbm_b_alt_via2__t06
+ a\x7cinv_mc_a\x7cmb\x7cmnab_y\x7cmpa_y\x7cmpb_y\x7cnand_m_y\x7ctg_s_a\x7cy__t56
+ a\x7cd\x7cinv_clk_vdd\x7cinv_mc_vdd\x7cinv_q_vdd\x7cmpa_py\x7cmpb_py\x7cnand_m_vdd\x7cnand_s2_vdd\x7cnwell_vdd\x7csb_vdd\x7csr1_vdd\x7csr2_vdd\x7csr3_vdd\x7csr4_vdd\x7csv_d_vdd_tie\x7csv_vdd\x7ctg_d_a\x7ctg_d_vdd\x7ctg_fbm_vdd\x7ctg_fbs_vdd\x7ctg_s_vdd\x7cvdd\x7cvdd_b1\x7cvdd_b2\x7cvdd_b3\x7cvdd_b4\x7cvdd_link\x7cvdd_link_dip\x7cvdd_x1\x7cvdd_x2\x7cvdd_x3__t59
+ sky130_fd_pr__pfet_01v8 L=0.15 W=0.84 AS=0.3948 AD=0.3948 PS=2.62 PD=2.62
* device instance $225 r0 *1 321.275,3.74 pfet
X$225 a\x7cmnab_y\x7cmpa_y\x7cmpb_y\x7cnand_s2_y\x7cqb\x7ctg_fbs_a\x7cy__t26
+ en\x7cnand_m_en\x7cnand_m_en_via\x7cnand_s2_en\x7cnand_s2_en_via\x7crst_n__t6
+ a\x7cd\x7cinv_clk_vdd\x7cinv_mc_vdd\x7cinv_q_vdd\x7cmpa_py\x7cmpb_py\x7cnand_m_vdd\x7cnand_s2_vdd\x7cnwell_vdd\x7csb_vdd\x7csr1_vdd\x7csr2_vdd\x7csr3_vdd\x7csr4_vdd\x7csv_d_vdd_tie\x7csv_vdd\x7ctg_d_a\x7ctg_d_vdd\x7ctg_fbm_vdd\x7ctg_fbs_vdd\x7ctg_s_vdd\x7cvdd\x7cvdd_b1\x7cvdd_b2\x7cvdd_b3\x7cvdd_b4\x7cvdd_link\x7cvdd_link_dip\x7cvdd_x1\x7cvdd_x2\x7cvdd_x3__t125
+ a\x7cd\x7cinv_clk_vdd\x7cinv_mc_vdd\x7cinv_q_vdd\x7cmpa_py\x7cmpb_py\x7cnand_m_vdd\x7cnand_s2_vdd\x7cnwell_vdd\x7csb_vdd\x7csr1_vdd\x7csr2_vdd\x7csr3_vdd\x7csr4_vdd\x7csv_d_vdd_tie\x7csv_vdd\x7ctg_d_a\x7ctg_d_vdd\x7ctg_fbm_vdd\x7ctg_fbs_vdd\x7ctg_s_vdd\x7cvdd\x7cvdd_b1\x7cvdd_b2\x7cvdd_b3\x7cvdd_b4\x7cvdd_link\x7cvdd_link_dip\x7cvdd_x1\x7cvdd_x2\x7cvdd_x3__t60
+ sky130_fd_pr__pfet_01v8 L=0.15 W=0.84 AS=0.3948 AD=0.3948 PS=2.62 PD=2.62
* device instance $226 r0 *1 322.565,3.74 pfet
X$226
+ a\x7cd\x7cinv_clk_vdd\x7cinv_mc_vdd\x7cinv_q_vdd\x7cmpa_py\x7cmpb_py\x7cnand_m_vdd\x7cnand_s2_vdd\x7cnwell_vdd\x7csb_vdd\x7csr1_vdd\x7csr2_vdd\x7csr3_vdd\x7csr4_vdd\x7csv_d_vdd_tie\x7csv_vdd\x7ctg_d_a\x7ctg_d_vdd\x7ctg_fbm_vdd\x7ctg_fbs_vdd\x7ctg_s_vdd\x7cvdd\x7cvdd_b1\x7cvdd_b2\x7cvdd_b3\x7cvdd_b4\x7cvdd_link\x7cvdd_link_dip\x7cvdd_x1\x7cvdd_x2\x7cvdd_x3__t26
+ a\x7cinv_q_y\x7cinv_q_y_via\x7cinv_q_y_via2\x7cnand_s2_a\x7cnand_s2_a_stub\x7cnand_s2_a_via\x7cnand_s2_a_via2\x7cq\x7cy__t26
+ a\x7cmnab_y\x7cmpa_y\x7cmpb_y\x7cnand_s2_y\x7cqb\x7ctg_fbs_a\x7cy__t36
+ a\x7cd\x7cinv_clk_vdd\x7cinv_mc_vdd\x7cinv_q_vdd\x7cmpa_py\x7cmpb_py\x7cnand_m_vdd\x7cnand_s2_vdd\x7cnwell_vdd\x7csb_vdd\x7csr1_vdd\x7csr2_vdd\x7csr3_vdd\x7csr4_vdd\x7csv_d_vdd_tie\x7csv_vdd\x7ctg_d_a\x7ctg_d_vdd\x7ctg_fbm_vdd\x7ctg_fbs_vdd\x7ctg_s_vdd\x7cvdd\x7cvdd_b1\x7cvdd_b2\x7cvdd_b3\x7cvdd_b4\x7cvdd_link\x7cvdd_link_dip\x7cvdd_x1\x7cvdd_x2\x7cvdd_x3__t61
+ sky130_fd_pr__pfet_01v8 L=0.15 W=0.84 AS=0.3948 AD=0.3948 PS=2.62 PD=2.62
* device instance $227 r0 *1 3.61,27.375 pfet
X$227 mpa_py\x7cmpb_py\x7cmph_py\x7cpy__t0
+ g_vss_m1\x7cinv_clk_vss\x7cinv_mc_vss\x7cinv_q_vss\x7cmph_g\x7cnand_m_vss\x7cnand_s2_vss\x7cs1_vss_m1\x7cs2_vss_m1\x7cs3_vss_m1\x7cs4_vss_m1\x7csb_vss\x7csr1_vss\x7csr2_vss\x7csr3_vss\x7csr4_vss\x7csv_vss\x7ctg_d_vss\x7ctg_fbm_vss\x7ctg_fbs_vss\x7ctg_s_vss\x7cvss\x7cvss_link\x7cvss_link_bridge\x7cvss_link_dip\x7cvss_link_m1\x7cvss_x1\x7cvss_x2\x7cvss_x3__t6
+ g_vddr_m1\x7cmnt_g\x7cs1_vddr_m1\x7cs2_vddr_m1\x7cs3_vddr_m1\x7cs4_vddr_m1\x7cvddr\x7cvddr1__t1
+ g_vddr_m1\x7cmnt_g\x7cs1_vddr_m1\x7cs2_vddr_m1\x7cs3_vddr_m1\x7cs4_vddr_m1\x7cvddr\x7cvddr1__t2
+ sky130_fd_pr__pfet_01v8 L=2 W=0.42 AS=0.1764 AD=0.1764 PS=1.68 PD=1.68
* device instance $228 r0 *1 3.445,44.86 pfet
X$228 an\x7cinva_y\x7cmn34_g0\x7cmp13_g1\x7cy__t2
+ a\x7cd\x7cinva_a\x7cmn12_g0\x7cmp13_g0\x7cro1\x7cro1_esc\x7csr1_d_stub\x7ctg_d_a\x7cy__t6
+ a\x7cd\x7cinv_clk_vdd\x7cinv_mc_vdd\x7cinv_q_vdd\x7cmpa_py\x7cmpb_py\x7cnand_m_vdd\x7cnand_s2_vdd\x7cnwell_vdd\x7csb_vdd\x7csr1_vdd\x7csr2_vdd\x7csr3_vdd\x7csr4_vdd\x7csv_d_vdd_tie\x7csv_vdd\x7ctg_d_a\x7ctg_d_vdd\x7ctg_fbm_vdd\x7ctg_fbs_vdd\x7ctg_s_vdd\x7cvdd\x7cvdd_b1\x7cvdd_b2\x7cvdd_b3\x7cvdd_b4\x7cvdd_link\x7cvdd_link_dip\x7cvdd_x1\x7cvdd_x2\x7cvdd_x3__t121
+ a\x7cd\x7cinv_clk_vdd\x7cinv_mc_vdd\x7cinv_q_vdd\x7cmpa_py\x7cmpb_py\x7cnand_m_vdd\x7cnand_s2_vdd\x7cnwell_vdd\x7csb_vdd\x7csr1_vdd\x7csr2_vdd\x7csr3_vdd\x7csr4_vdd\x7csv_d_vdd_tie\x7csv_vdd\x7ctg_d_a\x7ctg_d_vdd\x7ctg_fbm_vdd\x7ctg_fbs_vdd\x7ctg_s_vdd\x7cvdd\x7cvdd_b1\x7cvdd_b2\x7cvdd_b3\x7cvdd_b4\x7cvdd_link\x7cvdd_link_dip\x7cvdd_x1\x7cvdd_x2\x7cvdd_x3__t53
+ sky130_fd_pr__pfet_01v8 L=0.15 W=0.84 AS=0.3948 AD=0.3948 PS=2.62 PD=2.62
* device instance $229 r0 *1 7.43,49.22 pfet
X$229 mid__t1
+ a\x7cd\x7cinva_a\x7cmn12_g0\x7cmp13_g0\x7cro1\x7cro1_esc\x7csr1_d_stub\x7ctg_d_a\x7cy__t0
+ a\x7cd\x7cinv_clk_vdd\x7cinv_mc_vdd\x7cinv_q_vdd\x7cmpa_py\x7cmpb_py\x7cnand_m_vdd\x7cnand_s2_vdd\x7cnwell_vdd\x7csb_vdd\x7csr1_vdd\x7csr2_vdd\x7csr3_vdd\x7csr4_vdd\x7csv_d_vdd_tie\x7csv_vdd\x7ctg_d_a\x7ctg_d_vdd\x7ctg_fbm_vdd\x7ctg_fbs_vdd\x7ctg_s_vdd\x7cvdd\x7cvdd_b1\x7cvdd_b2\x7cvdd_b3\x7cvdd_b4\x7cvdd_link\x7cvdd_link_dip\x7cvdd_x1\x7cvdd_x2\x7cvdd_x3__t2
+ a\x7cd\x7cinv_clk_vdd\x7cinv_mc_vdd\x7cinv_q_vdd\x7cmpa_py\x7cmpb_py\x7cnand_m_vdd\x7cnand_s2_vdd\x7cnwell_vdd\x7csb_vdd\x7csr1_vdd\x7csr2_vdd\x7csr3_vdd\x7csr4_vdd\x7csv_d_vdd_tie\x7csv_vdd\x7ctg_d_a\x7ctg_d_vdd\x7ctg_fbm_vdd\x7ctg_fbs_vdd\x7ctg_s_vdd\x7cvdd\x7cvdd_b1\x7cvdd_b2\x7cvdd_b3\x7cvdd_b4\x7cvdd_link\x7cvdd_link_dip\x7cvdd_x1\x7cvdd_x2\x7cvdd_x3__t3
+ sky130_fd_pr__pfet_01v8 L=0.15 W=1.68 AS=0.7896 AD=0.4368 PS=4.3 PD=2.2
* device instance $230 r0 *1 8.1,49.22 pfet
X$230 a\x7cinva_a\x7cmn12_g0\x7cmp13_g0\x7ct1\x7cy__t0
+ an\x7cinva_y\x7cmn34_g0\x7cmp13_g1\x7cy__t0 mid__t0
+ a\x7cd\x7cinv_clk_vdd\x7cinv_mc_vdd\x7cinv_q_vdd\x7cmpa_py\x7cmpb_py\x7cnand_m_vdd\x7cnand_s2_vdd\x7cnwell_vdd\x7csb_vdd\x7csr1_vdd\x7csr2_vdd\x7csr3_vdd\x7csr4_vdd\x7csv_d_vdd_tie\x7csv_vdd\x7ctg_d_a\x7ctg_d_vdd\x7ctg_fbm_vdd\x7ctg_fbs_vdd\x7ctg_s_vdd\x7cvdd\x7cvdd_b1\x7cvdd_b2\x7cvdd_b3\x7cvdd_b4\x7cvdd_link\x7cvdd_link_dip\x7cvdd_x1\x7cvdd_x2\x7cvdd_x3__t4
+ sky130_fd_pr__pfet_01v8 L=0.15 W=1.68 AS=0.4368 AD=0.7896 PS=2.2 PD=4.3
* device instance $231 r0 *1 12.91,27.375 pfet
X$231 py__t0
+ g_vss_m1\x7cinv_clk_vss\x7cinv_mc_vss\x7cinv_q_vss\x7cmph_g\x7cnand_m_vss\x7cnand_s2_vss\x7cs1_vss_m1\x7cs2_vss_m1\x7cs3_vss_m1\x7cs4_vss_m1\x7csb_vss\x7csr1_vss\x7csr2_vss\x7csr3_vss\x7csr4_vss\x7csv_vss\x7ctg_d_vss\x7ctg_fbm_vss\x7ctg_fbs_vss\x7ctg_s_vss\x7cvss\x7cvss_link\x7cvss_link_bridge\x7cvss_link_dip\x7cvss_link_m1\x7cvss_x1\x7cvss_x2\x7cvss_x3__t25
+ g_vddr_m1\x7cmnt_g\x7cs1_vddr_m1\x7cs2_vddr_m1\x7cs3_vddr_m1\x7cs4_vddr_m1\x7cvddr\x7cvddr1__t10
+ g_vddr_m1\x7cmnt_g\x7cs1_vddr_m1\x7cs2_vddr_m1\x7cs3_vddr_m1\x7cs4_vddr_m1\x7cvddr\x7cvddr1__t6
+ sky130_fd_pr__pfet_01v8 L=2 W=0.42 AS=0.1764 AD=0.1764 PS=1.68 PD=1.68
* device instance $232 r0 *1 14.58,49.22 pfet
X$232 mid__t2 bn\x7cinvb_y\x7cmn34_g1\x7cmp24_g1\x7cy__t0
+ a\x7cinva_a\x7cmn12_g0\x7cmp13_g0\x7ct1\x7cy__t2
+ a\x7cd\x7cinv_clk_vdd\x7cinv_mc_vdd\x7cinv_q_vdd\x7cmpa_py\x7cmpb_py\x7cnand_m_vdd\x7cnand_s2_vdd\x7cnwell_vdd\x7csb_vdd\x7csr1_vdd\x7csr2_vdd\x7csr3_vdd\x7csr4_vdd\x7csv_d_vdd_tie\x7csv_vdd\x7ctg_d_a\x7ctg_d_vdd\x7ctg_fbm_vdd\x7ctg_fbs_vdd\x7ctg_s_vdd\x7cvdd\x7cvdd_b1\x7cvdd_b2\x7cvdd_b3\x7cvdd_b4\x7cvdd_link\x7cvdd_link_dip\x7cvdd_x1\x7cvdd_x2\x7cvdd_x3__t13
+ sky130_fd_pr__pfet_01v8 L=0.15 W=1.68 AS=0.7896 AD=0.4368 PS=4.3 PD=2.2
* device instance $233 r0 *1 15.25,49.22 pfet
X$233
+ a\x7cd\x7cinv_clk_vdd\x7cinv_mc_vdd\x7cinv_q_vdd\x7cmpa_py\x7cmpb_py\x7cnand_m_vdd\x7cnand_s2_vdd\x7cnwell_vdd\x7csb_vdd\x7csr1_vdd\x7csr2_vdd\x7csr3_vdd\x7csr4_vdd\x7csv_d_vdd_tie\x7csv_vdd\x7ctg_d_a\x7ctg_d_vdd\x7ctg_fbm_vdd\x7ctg_fbs_vdd\x7ctg_s_vdd\x7cvdd\x7cvdd_b1\x7cvdd_b2\x7cvdd_b3\x7cvdd_b4\x7cvdd_link\x7cvdd_link_dip\x7cvdd_x1\x7cvdd_x2\x7cvdd_x3__t6
+ a\x7cb\x7cd\x7cinvb_a\x7cmn12_g1\x7cmp24_g0\x7cro2\x7cro2_esc\x7csr2_d_stub\x7ctg_d_a\x7cy__t0
+ mid__t3
+ a\x7cd\x7cinv_clk_vdd\x7cinv_mc_vdd\x7cinv_q_vdd\x7cmpa_py\x7cmpb_py\x7cnand_m_vdd\x7cnand_s2_vdd\x7cnwell_vdd\x7csb_vdd\x7csr1_vdd\x7csr2_vdd\x7csr3_vdd\x7csr4_vdd\x7csv_d_vdd_tie\x7csv_vdd\x7ctg_d_a\x7ctg_d_vdd\x7ctg_fbm_vdd\x7ctg_fbs_vdd\x7ctg_s_vdd\x7cvdd\x7cvdd_b1\x7cvdd_b2\x7cvdd_b3\x7cvdd_b4\x7cvdd_link\x7cvdd_link_dip\x7cvdd_x1\x7cvdd_x2\x7cvdd_x3__t10
+ sky130_fd_pr__pfet_01v8 L=0.15 W=1.68 AS=0.4368 AD=0.7896 PS=2.2 PD=4.3
* device instance $234 r0 *1 21.085,27.375 pfet
X$234 py__t02
+ g_vss_m1\x7cinv_clk_vss\x7cinv_mc_vss\x7cinv_q_vss\x7cmph_g\x7cnand_m_vss\x7cnand_s2_vss\x7cs1_vss_m1\x7cs2_vss_m1\x7cs3_vss_m1\x7cs4_vss_m1\x7csb_vss\x7csr1_vss\x7csr2_vss\x7csr3_vss\x7csr4_vss\x7csv_vss\x7ctg_d_vss\x7ctg_fbm_vss\x7ctg_fbs_vss\x7ctg_s_vss\x7cvss\x7cvss_link\x7cvss_link_bridge\x7cvss_link_dip\x7cvss_link_m1\x7cvss_x1\x7cvss_x2\x7cvss_x3__t24
+ g_vddr_m1\x7cmnt_g\x7cs1_vddr_m1\x7cs2_vddr_m1\x7cs3_vddr_m1\x7cs4_vddr_m1\x7cvddr\x7cvddr1__t9
+ g_vddr_m1\x7cmnt_g\x7cs1_vddr_m1\x7cs2_vddr_m1\x7cs3_vddr_m1\x7cs4_vddr_m1\x7cvddr\x7cvddr1__t5
+ sky130_fd_pr__pfet_01v8 L=2 W=0.42 AS=0.1764 AD=0.1764 PS=1.68 PD=1.68
* device instance $235 r0 *1 21.62,44.86 pfet
X$235 bn\x7cinvb_y\x7cmn34_g1\x7cmp24_g1\x7cy__t2
+ a\x7cb\x7cd\x7cinvb_a\x7cmn12_g1\x7cmp24_g0\x7cro2\x7cro2_esc\x7csr2_d_stub\x7ctg_d_a\x7cy__t6
+ a\x7cd\x7cinv_clk_vdd\x7cinv_mc_vdd\x7cinv_q_vdd\x7cmpa_py\x7cmpb_py\x7cnand_m_vdd\x7cnand_s2_vdd\x7cnwell_vdd\x7csb_vdd\x7csr1_vdd\x7csr2_vdd\x7csr3_vdd\x7csr4_vdd\x7csv_d_vdd_tie\x7csv_vdd\x7ctg_d_a\x7ctg_d_vdd\x7ctg_fbm_vdd\x7ctg_fbs_vdd\x7ctg_s_vdd\x7cvdd\x7cvdd_b1\x7cvdd_b2\x7cvdd_b3\x7cvdd_b4\x7cvdd_link\x7cvdd_link_dip\x7cvdd_x1\x7cvdd_x2\x7cvdd_x3__t122
+ a\x7cd\x7cinv_clk_vdd\x7cinv_mc_vdd\x7cinv_q_vdd\x7cmpa_py\x7cmpb_py\x7cnand_m_vdd\x7cnand_s2_vdd\x7cnwell_vdd\x7csb_vdd\x7csr1_vdd\x7csr2_vdd\x7csr3_vdd\x7csr4_vdd\x7csv_d_vdd_tie\x7csv_vdd\x7ctg_d_a\x7ctg_d_vdd\x7ctg_fbm_vdd\x7ctg_fbs_vdd\x7ctg_s_vdd\x7cvdd\x7cvdd_b1\x7cvdd_b2\x7cvdd_b3\x7cvdd_b4\x7cvdd_link\x7cvdd_link_dip\x7cvdd_x1\x7cvdd_x2\x7cvdd_x3__t56
+ sky130_fd_pr__pfet_01v8 L=0.15 W=0.84 AS=0.3948 AD=0.3948 PS=2.62 PD=2.62
* device instance $236 r0 *1 29.26,27.375 pfet
X$236 py__t03
+ g_vss_m1\x7cinv_clk_vss\x7cinv_mc_vss\x7cinv_q_vss\x7cmph_g\x7cnand_m_vss\x7cnand_s2_vss\x7cs1_vss_m1\x7cs2_vss_m1\x7cs3_vss_m1\x7cs4_vss_m1\x7csb_vss\x7csr1_vss\x7csr2_vss\x7csr3_vss\x7csr4_vss\x7csv_vss\x7ctg_d_vss\x7ctg_fbm_vss\x7ctg_fbs_vss\x7ctg_s_vss\x7cvss\x7cvss_link\x7cvss_link_bridge\x7cvss_link_dip\x7cvss_link_m1\x7cvss_x1\x7cvss_x2\x7cvss_x3__t23
+ g_vddr_m1\x7cmnt_g\x7cs1_vddr_m1\x7cs2_vddr_m1\x7cs3_vddr_m1\x7cs4_vddr_m1\x7cvddr\x7cvddr1__t8
+ g_vddr_m1\x7cmnt_g\x7cs1_vddr_m1\x7cs2_vddr_m1\x7cs3_vddr_m1\x7cs4_vddr_m1\x7cvddr\x7cvddr1__t4
+ sky130_fd_pr__pfet_01v8 L=2 W=0.42 AS=0.1764 AD=0.1764 PS=1.68 PD=1.68
* device instance $237 r0 *1 32.415,44.86 pfet
X$237 an\x7cinva_y\x7cmn34_g0\x7cmp13_g1\x7cy__t22
+ a\x7cd\x7cinva_a\x7cmn12_g0\x7cmp13_g0\x7cro3\x7cro3_esc_e\x7cro3_esc_w\x7cro3_hop\x7csr3_d_stub\x7ctg_d_a\x7cy__t6
+ a\x7cd\x7cinv_clk_vdd\x7cinv_mc_vdd\x7cinv_q_vdd\x7cmpa_py\x7cmpb_py\x7cnand_m_vdd\x7cnand_s2_vdd\x7cnwell_vdd\x7csb_vdd\x7csr1_vdd\x7csr2_vdd\x7csr3_vdd\x7csr4_vdd\x7csv_d_vdd_tie\x7csv_vdd\x7ctg_d_a\x7ctg_d_vdd\x7ctg_fbm_vdd\x7ctg_fbs_vdd\x7ctg_s_vdd\x7cvdd\x7cvdd_b1\x7cvdd_b2\x7cvdd_b3\x7cvdd_b4\x7cvdd_link\x7cvdd_link_dip\x7cvdd_x1\x7cvdd_x2\x7cvdd_x3__t124
+ a\x7cd\x7cinv_clk_vdd\x7cinv_mc_vdd\x7cinv_q_vdd\x7cmpa_py\x7cmpb_py\x7cnand_m_vdd\x7cnand_s2_vdd\x7cnwell_vdd\x7csb_vdd\x7csr1_vdd\x7csr2_vdd\x7csr3_vdd\x7csr4_vdd\x7csv_d_vdd_tie\x7csv_vdd\x7ctg_d_a\x7ctg_d_vdd\x7ctg_fbm_vdd\x7ctg_fbs_vdd\x7ctg_s_vdd\x7cvdd\x7cvdd_b1\x7cvdd_b2\x7cvdd_b3\x7cvdd_b4\x7cvdd_link\x7cvdd_link_dip\x7cvdd_x1\x7cvdd_x2\x7cvdd_x3__t58
+ sky130_fd_pr__pfet_01v8 L=0.15 W=0.84 AS=0.3948 AD=0.3948 PS=2.62 PD=2.62
* device instance $238 r0 *1 36.4,49.22 pfet
X$238 mid__t02
+ a\x7cd\x7cinva_a\x7cmn12_g0\x7cmp13_g0\x7cro3\x7cro3_esc_e\x7cro3_esc_w\x7cro3_hop\x7csr3_d_stub\x7ctg_d_a\x7cy__t0
+ a\x7cd\x7cinv_clk_vdd\x7cinv_mc_vdd\x7cinv_q_vdd\x7cmpa_py\x7cmpb_py\x7cnand_m_vdd\x7cnand_s2_vdd\x7cnwell_vdd\x7csb_vdd\x7csr1_vdd\x7csr2_vdd\x7csr3_vdd\x7csr4_vdd\x7csv_d_vdd_tie\x7csv_vdd\x7ctg_d_a\x7ctg_d_vdd\x7ctg_fbm_vdd\x7ctg_fbs_vdd\x7ctg_s_vdd\x7cvdd\x7cvdd_b1\x7cvdd_b2\x7cvdd_b3\x7cvdd_b4\x7cvdd_link\x7cvdd_link_dip\x7cvdd_x1\x7cvdd_x2\x7cvdd_x3__t18
+ a\x7cd\x7cinv_clk_vdd\x7cinv_mc_vdd\x7cinv_q_vdd\x7cmpa_py\x7cmpb_py\x7cnand_m_vdd\x7cnand_s2_vdd\x7cnwell_vdd\x7csb_vdd\x7csr1_vdd\x7csr2_vdd\x7csr3_vdd\x7csr4_vdd\x7csv_d_vdd_tie\x7csv_vdd\x7ctg_d_a\x7ctg_d_vdd\x7ctg_fbm_vdd\x7ctg_fbs_vdd\x7ctg_s_vdd\x7cvdd\x7cvdd_b1\x7cvdd_b2\x7cvdd_b3\x7cvdd_b4\x7cvdd_link\x7cvdd_link_dip\x7cvdd_x1\x7cvdd_x2\x7cvdd_x3__t14
+ sky130_fd_pr__pfet_01v8 L=0.15 W=1.68 AS=0.7896 AD=0.4368 PS=4.3 PD=2.2
* device instance $239 r0 *1 37.07,49.22 pfet
X$239 a\x7cb\x7cb3\x7cinvb_a\x7cmn12_g1\x7cmp24_g0\x7ct2\x7cy__t0
+ an\x7cinva_y\x7cmn34_g0\x7cmp13_g1\x7cy__t02 mid__t32
+ a\x7cd\x7cinv_clk_vdd\x7cinv_mc_vdd\x7cinv_q_vdd\x7cmpa_py\x7cmpb_py\x7cnand_m_vdd\x7cnand_s2_vdd\x7cnwell_vdd\x7csb_vdd\x7csr1_vdd\x7csr2_vdd\x7csr3_vdd\x7csr4_vdd\x7csv_d_vdd_tie\x7csv_vdd\x7ctg_d_a\x7ctg_d_vdd\x7ctg_fbm_vdd\x7ctg_fbs_vdd\x7ctg_s_vdd\x7cvdd\x7cvdd_b1\x7cvdd_b2\x7cvdd_b3\x7cvdd_b4\x7cvdd_link\x7cvdd_link_dip\x7cvdd_x1\x7cvdd_x2\x7cvdd_x3__t12
+ sky130_fd_pr__pfet_01v8 L=0.15 W=1.68 AS=0.4368 AD=0.7896 PS=2.2 PD=4.3
* device instance $240 r0 *1 37.435,27.375 pfet
X$240 py__t04
+ g_vss_m1\x7cinv_clk_vss\x7cinv_mc_vss\x7cinv_q_vss\x7cmph_g\x7cnand_m_vss\x7cnand_s2_vss\x7cs1_vss_m1\x7cs2_vss_m1\x7cs3_vss_m1\x7cs4_vss_m1\x7csb_vss\x7csr1_vss\x7csr2_vss\x7csr3_vss\x7csr4_vss\x7csv_vss\x7ctg_d_vss\x7ctg_fbm_vss\x7ctg_fbs_vss\x7ctg_s_vss\x7cvss\x7cvss_link\x7cvss_link_bridge\x7cvss_link_dip\x7cvss_link_m1\x7cvss_x1\x7cvss_x2\x7cvss_x3__t22
+ g_vddr_m1\x7cmnt_g\x7cs1_vddr_m1\x7cs2_vddr_m1\x7cs3_vddr_m1\x7cs4_vddr_m1\x7cvddr\x7cvddr1__t7
+ g_vddr_m1\x7cmnt_g\x7cs1_vddr_m1\x7cs2_vddr_m1\x7cs3_vddr_m1\x7cs4_vddr_m1\x7cvddr\x7cvddr1__t3
+ sky130_fd_pr__pfet_01v8 L=2 W=0.42 AS=0.1764 AD=0.1764 PS=1.68 PD=1.68
* device instance $241 r0 *1 43.55,49.22 pfet
X$241 mid__t12 bn\x7cinvb_y\x7cmn34_g1\x7cmp24_g1\x7cy__t02
+ a\x7cb\x7cb3\x7cinvb_a\x7cmn12_g1\x7cmp24_g0\x7ct2\x7cy__t2
+ a\x7cd\x7cinv_clk_vdd\x7cinv_mc_vdd\x7cinv_q_vdd\x7cmpa_py\x7cmpb_py\x7cnand_m_vdd\x7cnand_s2_vdd\x7cnwell_vdd\x7csb_vdd\x7csr1_vdd\x7csr2_vdd\x7csr3_vdd\x7csr4_vdd\x7csv_d_vdd_tie\x7csv_vdd\x7ctg_d_a\x7ctg_d_vdd\x7ctg_fbm_vdd\x7ctg_fbs_vdd\x7ctg_s_vdd\x7cvdd\x7cvdd_b1\x7cvdd_b2\x7cvdd_b3\x7cvdd_b4\x7cvdd_link\x7cvdd_link_dip\x7cvdd_x1\x7cvdd_x2\x7cvdd_x3__t16
+ sky130_fd_pr__pfet_01v8 L=0.15 W=1.68 AS=0.7896 AD=0.4368 PS=4.3 PD=2.2
* device instance $242 r0 *1 44.22,49.22 pfet
X$242
+ a\x7cd\x7cinv_clk_vdd\x7cinv_mc_vdd\x7cinv_q_vdd\x7cmpa_py\x7cmpb_py\x7cnand_m_vdd\x7cnand_s2_vdd\x7cnwell_vdd\x7csb_vdd\x7csr1_vdd\x7csr2_vdd\x7csr3_vdd\x7csr4_vdd\x7csv_d_vdd_tie\x7csv_vdd\x7ctg_d_a\x7ctg_d_vdd\x7ctg_fbm_vdd\x7ctg_fbs_vdd\x7ctg_s_vdd\x7cvdd\x7cvdd_b1\x7cvdd_b2\x7cvdd_b3\x7cvdd_b4\x7cvdd_link\x7cvdd_link_dip\x7cvdd_x1\x7cvdd_x2\x7cvdd_x3__t5
+ a\x7cb\x7cd\x7cinvb_a\x7cmn12_g1\x7cmp24_g0\x7cro4\x7cro4_esc\x7csr4_d_stub\x7ctg_d_a\x7cy__t0
+ mid__t22
+ a\x7cd\x7cinv_clk_vdd\x7cinv_mc_vdd\x7cinv_q_vdd\x7cmpa_py\x7cmpb_py\x7cnand_m_vdd\x7cnand_s2_vdd\x7cnwell_vdd\x7csb_vdd\x7csr1_vdd\x7csr2_vdd\x7csr3_vdd\x7csr4_vdd\x7csv_d_vdd_tie\x7csv_vdd\x7ctg_d_a\x7ctg_d_vdd\x7ctg_fbm_vdd\x7ctg_fbs_vdd\x7ctg_s_vdd\x7cvdd\x7cvdd_b1\x7cvdd_b2\x7cvdd_b3\x7cvdd_b4\x7cvdd_link\x7cvdd_link_dip\x7cvdd_x1\x7cvdd_x2\x7cvdd_x3__t8
+ sky130_fd_pr__pfet_01v8 L=0.15 W=1.68 AS=0.4368 AD=0.7896 PS=2.2 PD=4.3
* device instance $243 r0 *1 50.59,44.86 pfet
X$243 bn\x7cinvb_y\x7cmn34_g1\x7cmp24_g1\x7cy__t22
+ a\x7cb\x7cd\x7cinvb_a\x7cmn12_g1\x7cmp24_g0\x7cro4\x7cro4_esc\x7csr4_d_stub\x7ctg_d_a\x7cy__t6
+ a\x7cd\x7cinv_clk_vdd\x7cinv_mc_vdd\x7cinv_q_vdd\x7cmpa_py\x7cmpb_py\x7cnand_m_vdd\x7cnand_s2_vdd\x7cnwell_vdd\x7csb_vdd\x7csr1_vdd\x7csr2_vdd\x7csr3_vdd\x7csr4_vdd\x7csv_d_vdd_tie\x7csv_vdd\x7ctg_d_a\x7ctg_d_vdd\x7ctg_fbm_vdd\x7ctg_fbs_vdd\x7ctg_s_vdd\x7cvdd\x7cvdd_b1\x7cvdd_b2\x7cvdd_b3\x7cvdd_b4\x7cvdd_link\x7cvdd_link_dip\x7cvdd_x1\x7cvdd_x2\x7cvdd_x3__t127
+ a\x7cd\x7cinv_clk_vdd\x7cinv_mc_vdd\x7cinv_q_vdd\x7cmpa_py\x7cmpb_py\x7cnand_m_vdd\x7cnand_s2_vdd\x7cnwell_vdd\x7csb_vdd\x7csr1_vdd\x7csr2_vdd\x7csr3_vdd\x7csr4_vdd\x7csv_d_vdd_tie\x7csv_vdd\x7ctg_d_a\x7ctg_d_vdd\x7ctg_fbm_vdd\x7ctg_fbs_vdd\x7ctg_s_vdd\x7cvdd\x7cvdd_b1\x7cvdd_b2\x7cvdd_b3\x7cvdd_b4\x7cvdd_link\x7cvdd_link_dip\x7cvdd_x1\x7cvdd_x2\x7cvdd_x3__t63
+ sky130_fd_pr__pfet_01v8 L=0.15 W=0.84 AS=0.3948 AD=0.3948 PS=2.62 PD=2.62
* device instance $244 r0 *1 58.91,27.375 pfet
X$244 mpa_py\x7cmpb_py\x7cmph_py\x7cpy__t02
+ g_vss_m1\x7cinv_clk_vss\x7cinv_mc_vss\x7cinv_q_vss\x7cmph_g\x7cnand_m_vss\x7cnand_s2_vss\x7cs1_vss_m1\x7cs2_vss_m1\x7cs3_vss_m1\x7cs4_vss_m1\x7csb_vss\x7csr1_vss\x7csr2_vss\x7csr3_vss\x7csr4_vss\x7csv_vss\x7ctg_d_vss\x7ctg_fbm_vss\x7ctg_fbs_vss\x7ctg_s_vss\x7cvss\x7cvss_link\x7cvss_link_bridge\x7cvss_link_dip\x7cvss_link_m1\x7cvss_x1\x7cvss_x2\x7cvss_x3__t7
+ g_vddr_m1\x7cmnt_g\x7cs1_vddr_m1\x7cs2_vddr_m1\x7cs3_vddr_m1\x7cs4_vddr_m1\x7cvddr\x7cvddr2__t1
+ g_vddr_m1\x7cmnt_g\x7cs1_vddr_m1\x7cs2_vddr_m1\x7cs3_vddr_m1\x7cs4_vddr_m1\x7cvddr\x7cvddr2__t2
+ sky130_fd_pr__pfet_01v8 L=2 W=0.44 AS=0.1848 AD=0.1848 PS=1.72 PD=1.72
* device instance $245 r0 *1 61.385,44.86 pfet
X$245 an\x7cinva_y\x7cmn34_g0\x7cmp13_g1\x7cy__t23
+ a\x7cinva_a\x7cmn12_g0\x7cmp13_g0\x7ct1\x7cy__t4
+ a\x7cd\x7cinv_clk_vdd\x7cinv_mc_vdd\x7cinv_q_vdd\x7cmpa_py\x7cmpb_py\x7cnand_m_vdd\x7cnand_s2_vdd\x7cnwell_vdd\x7csb_vdd\x7csr1_vdd\x7csr2_vdd\x7csr3_vdd\x7csr4_vdd\x7csv_d_vdd_tie\x7csv_vdd\x7ctg_d_a\x7ctg_d_vdd\x7ctg_fbm_vdd\x7ctg_fbs_vdd\x7ctg_s_vdd\x7cvdd\x7cvdd_b1\x7cvdd_b2\x7cvdd_b3\x7cvdd_b4\x7cvdd_link\x7cvdd_link_dip\x7cvdd_x1\x7cvdd_x2\x7cvdd_x3__t128
+ a\x7cd\x7cinv_clk_vdd\x7cinv_mc_vdd\x7cinv_q_vdd\x7cmpa_py\x7cmpb_py\x7cnand_m_vdd\x7cnand_s2_vdd\x7cnwell_vdd\x7csb_vdd\x7csr1_vdd\x7csr2_vdd\x7csr3_vdd\x7csr4_vdd\x7csv_d_vdd_tie\x7csv_vdd\x7ctg_d_a\x7ctg_d_vdd\x7ctg_fbm_vdd\x7ctg_fbs_vdd\x7ctg_s_vdd\x7cvdd\x7cvdd_b1\x7cvdd_b2\x7cvdd_b3\x7cvdd_b4\x7cvdd_link\x7cvdd_link_dip\x7cvdd_x1\x7cvdd_x2\x7cvdd_x3__t64
+ sky130_fd_pr__pfet_01v8 L=0.15 W=0.84 AS=0.3948 AD=0.3948 PS=2.62 PD=2.62
* device instance $246 r0 *1 65.37,49.22 pfet
X$246 mid__t13 a\x7cinva_a\x7cmn12_g0\x7cmp13_g0\x7ct1\x7cy__t1
+ a\x7cd\x7cinv_clk_vdd\x7cinv_mc_vdd\x7cinv_q_vdd\x7cmpa_py\x7cmpb_py\x7cnand_m_vdd\x7cnand_s2_vdd\x7cnwell_vdd\x7csb_vdd\x7csr1_vdd\x7csr2_vdd\x7csr3_vdd\x7csr4_vdd\x7csv_d_vdd_tie\x7csv_vdd\x7ctg_d_a\x7ctg_d_vdd\x7ctg_fbm_vdd\x7ctg_fbs_vdd\x7ctg_s_vdd\x7cvdd\x7cvdd_b1\x7cvdd_b2\x7cvdd_b3\x7cvdd_b4\x7cvdd_link\x7cvdd_link_dip\x7cvdd_x1\x7cvdd_x2\x7cvdd_x3__t19
+ a\x7cd\x7cinv_clk_vdd\x7cinv_mc_vdd\x7cinv_q_vdd\x7cmpa_py\x7cmpb_py\x7cnand_m_vdd\x7cnand_s2_vdd\x7cnwell_vdd\x7csb_vdd\x7csr1_vdd\x7csr2_vdd\x7csr3_vdd\x7csr4_vdd\x7csv_d_vdd_tie\x7csv_vdd\x7ctg_d_a\x7ctg_d_vdd\x7ctg_fbm_vdd\x7ctg_fbs_vdd\x7ctg_s_vdd\x7cvdd\x7cvdd_b1\x7cvdd_b2\x7cvdd_b3\x7cvdd_b4\x7cvdd_link\x7cvdd_link_dip\x7cvdd_x1\x7cvdd_x2\x7cvdd_x3__t17
+ sky130_fd_pr__pfet_01v8 L=0.15 W=1.68 AS=0.7896 AD=0.4368 PS=4.3 PD=2.2
* device instance $247 r0 *1 66.04,49.22 pfet
X$247
+ a\x7cd\x7csb_d_stub\x7ctg_d_a\x7cxo\x7cxo_dip\x7cxo_hop\x7cxo_stub\x7cy__t0
+ an\x7cinva_y\x7cmn34_g0\x7cmp13_g1\x7cy__t03 mid__t23
+ a\x7cd\x7cinv_clk_vdd\x7cinv_mc_vdd\x7cinv_q_vdd\x7cmpa_py\x7cmpb_py\x7cnand_m_vdd\x7cnand_s2_vdd\x7cnwell_vdd\x7csb_vdd\x7csr1_vdd\x7csr2_vdd\x7csr3_vdd\x7csr4_vdd\x7csv_d_vdd_tie\x7csv_vdd\x7ctg_d_a\x7ctg_d_vdd\x7ctg_fbm_vdd\x7ctg_fbs_vdd\x7ctg_s_vdd\x7cvdd\x7cvdd_b1\x7cvdd_b2\x7cvdd_b3\x7cvdd_b4\x7cvdd_link\x7cvdd_link_dip\x7cvdd_x1\x7cvdd_x2\x7cvdd_x3__t9
+ sky130_fd_pr__pfet_01v8 L=0.15 W=1.68 AS=0.4368 AD=0.7896 PS=2.2 PD=4.3
* device instance $248 r0 *1 68.21,27.375 pfet
X$248 py__t05
+ g_vss_m1\x7cinv_clk_vss\x7cinv_mc_vss\x7cinv_q_vss\x7cmph_g\x7cnand_m_vss\x7cnand_s2_vss\x7cs1_vss_m1\x7cs2_vss_m1\x7cs3_vss_m1\x7cs4_vss_m1\x7csb_vss\x7csr1_vss\x7csr2_vss\x7csr3_vss\x7csr4_vss\x7csv_vss\x7ctg_d_vss\x7ctg_fbm_vss\x7ctg_fbs_vss\x7ctg_s_vss\x7cvss\x7cvss_link\x7cvss_link_bridge\x7cvss_link_dip\x7cvss_link_m1\x7cvss_x1\x7cvss_x2\x7cvss_x3__t20
+ g_vddr_m1\x7cmnt_g\x7cs1_vddr_m1\x7cs2_vddr_m1\x7cs3_vddr_m1\x7cs4_vddr_m1\x7cvddr\x7cvddr2__t9
+ g_vddr_m1\x7cmnt_g\x7cs1_vddr_m1\x7cs2_vddr_m1\x7cs3_vddr_m1\x7cs4_vddr_m1\x7cvddr\x7cvddr2__t5
+ sky130_fd_pr__pfet_01v8 L=2 W=0.44 AS=0.1848 AD=0.1848 PS=1.72 PD=1.72
* device instance $249 r0 *1 72.52,49.22 pfet
X$249 mid__t03 bn\x7cinvb_y\x7cmn34_g1\x7cmp24_g1\x7cy__t03
+ a\x7cd\x7csb_d_stub\x7ctg_d_a\x7cxo\x7cxo_dip\x7cxo_hop\x7cxo_stub\x7cy__t1
+ a\x7cd\x7cinv_clk_vdd\x7cinv_mc_vdd\x7cinv_q_vdd\x7cmpa_py\x7cmpb_py\x7cnand_m_vdd\x7cnand_s2_vdd\x7cnwell_vdd\x7csb_vdd\x7csr1_vdd\x7csr2_vdd\x7csr3_vdd\x7csr4_vdd\x7csv_d_vdd_tie\x7csv_vdd\x7ctg_d_a\x7ctg_d_vdd\x7ctg_fbm_vdd\x7ctg_fbs_vdd\x7ctg_s_vdd\x7cvdd\x7cvdd_b1\x7cvdd_b2\x7cvdd_b3\x7cvdd_b4\x7cvdd_link\x7cvdd_link_dip\x7cvdd_x1\x7cvdd_x2\x7cvdd_x3__t15
+ sky130_fd_pr__pfet_01v8 L=0.15 W=1.68 AS=0.7896 AD=0.4368 PS=4.3 PD=2.2
* device instance $250 r0 *1 73.19,49.22 pfet
X$250
+ a\x7cd\x7cinv_clk_vdd\x7cinv_mc_vdd\x7cinv_q_vdd\x7cmpa_py\x7cmpb_py\x7cnand_m_vdd\x7cnand_s2_vdd\x7cnwell_vdd\x7csb_vdd\x7csr1_vdd\x7csr2_vdd\x7csr3_vdd\x7csr4_vdd\x7csv_d_vdd_tie\x7csv_vdd\x7ctg_d_a\x7ctg_d_vdd\x7ctg_fbm_vdd\x7ctg_fbs_vdd\x7ctg_s_vdd\x7cvdd\x7cvdd_b1\x7cvdd_b2\x7cvdd_b3\x7cvdd_b4\x7cvdd_link\x7cvdd_link_dip\x7cvdd_x1\x7cvdd_x2\x7cvdd_x3__t7
+ a\x7cb\x7cb3\x7cinvb_a\x7cmn12_g1\x7cmp24_g0\x7ct2\x7cy__t1 mid__t33
+ a\x7cd\x7cinv_clk_vdd\x7cinv_mc_vdd\x7cinv_q_vdd\x7cmpa_py\x7cmpb_py\x7cnand_m_vdd\x7cnand_s2_vdd\x7cnwell_vdd\x7csb_vdd\x7csr1_vdd\x7csr2_vdd\x7csr3_vdd\x7csr4_vdd\x7csv_d_vdd_tie\x7csv_vdd\x7ctg_d_a\x7ctg_d_vdd\x7ctg_fbm_vdd\x7ctg_fbs_vdd\x7ctg_s_vdd\x7cvdd\x7cvdd_b1\x7cvdd_b2\x7cvdd_b3\x7cvdd_b4\x7cvdd_link\x7cvdd_link_dip\x7cvdd_x1\x7cvdd_x2\x7cvdd_x3__t11
+ sky130_fd_pr__pfet_01v8 L=0.15 W=1.68 AS=0.4368 AD=0.7896 PS=2.2 PD=4.3
* device instance $251 r0 *1 76.385,27.375 pfet
X$251 py__t06
+ g_vss_m1\x7cinv_clk_vss\x7cinv_mc_vss\x7cinv_q_vss\x7cmph_g\x7cnand_m_vss\x7cnand_s2_vss\x7cs1_vss_m1\x7cs2_vss_m1\x7cs3_vss_m1\x7cs4_vss_m1\x7csb_vss\x7csr1_vss\x7csr2_vss\x7csr3_vss\x7csr4_vss\x7csv_vss\x7ctg_d_vss\x7ctg_fbm_vss\x7ctg_fbs_vss\x7ctg_s_vss\x7cvss\x7cvss_link\x7cvss_link_bridge\x7cvss_link_dip\x7cvss_link_m1\x7cvss_x1\x7cvss_x2\x7cvss_x3__t21
+ g_vddr_m1\x7cmnt_g\x7cs1_vddr_m1\x7cs2_vddr_m1\x7cs3_vddr_m1\x7cs4_vddr_m1\x7cvddr\x7cvddr2__t10
+ g_vddr_m1\x7cmnt_g\x7cs1_vddr_m1\x7cs2_vddr_m1\x7cs3_vddr_m1\x7cs4_vddr_m1\x7cvddr\x7cvddr2__t6
+ sky130_fd_pr__pfet_01v8 L=2 W=0.44 AS=0.1848 AD=0.1848 PS=1.72 PD=1.72
* device instance $252 r0 *1 79.56,44.86 pfet
X$252 bn\x7cinvb_y\x7cmn34_g1\x7cmp24_g1\x7cy__t23
+ a\x7cb\x7cb3\x7cinvb_a\x7cmn12_g1\x7cmp24_g0\x7ct2\x7cy__t4
+ a\x7cd\x7cinv_clk_vdd\x7cinv_mc_vdd\x7cinv_q_vdd\x7cmpa_py\x7cmpb_py\x7cnand_m_vdd\x7cnand_s2_vdd\x7cnwell_vdd\x7csb_vdd\x7csr1_vdd\x7csr2_vdd\x7csr3_vdd\x7csr4_vdd\x7csv_d_vdd_tie\x7csv_vdd\x7ctg_d_a\x7ctg_d_vdd\x7ctg_fbm_vdd\x7ctg_fbs_vdd\x7ctg_s_vdd\x7cvdd\x7cvdd_b1\x7cvdd_b2\x7cvdd_b3\x7cvdd_b4\x7cvdd_link\x7cvdd_link_dip\x7cvdd_x1\x7cvdd_x2\x7cvdd_x3__t110
+ a\x7cd\x7cinv_clk_vdd\x7cinv_mc_vdd\x7cinv_q_vdd\x7cmpa_py\x7cmpb_py\x7cnand_m_vdd\x7cnand_s2_vdd\x7cnwell_vdd\x7csb_vdd\x7csr1_vdd\x7csr2_vdd\x7csr3_vdd\x7csr4_vdd\x7csv_d_vdd_tie\x7csv_vdd\x7ctg_d_a\x7ctg_d_vdd\x7ctg_fbm_vdd\x7ctg_fbs_vdd\x7ctg_s_vdd\x7cvdd\x7cvdd_b1\x7cvdd_b2\x7cvdd_b3\x7cvdd_b4\x7cvdd_link\x7cvdd_link_dip\x7cvdd_x1\x7cvdd_x2\x7cvdd_x3__t35
+ sky130_fd_pr__pfet_01v8 L=0.15 W=0.84 AS=0.3948 AD=0.3948 PS=2.62 PD=2.62
* device instance $253 r0 *1 84.56,27.375 pfet
X$253 py__t07
+ g_vss_m1\x7cinv_clk_vss\x7cinv_mc_vss\x7cinv_q_vss\x7cmph_g\x7cnand_m_vss\x7cnand_s2_vss\x7cs1_vss_m1\x7cs2_vss_m1\x7cs3_vss_m1\x7cs4_vss_m1\x7csb_vss\x7csr1_vss\x7csr2_vss\x7csr3_vss\x7csr4_vss\x7csv_vss\x7ctg_d_vss\x7ctg_fbm_vss\x7ctg_fbs_vss\x7ctg_s_vss\x7cvss\x7cvss_link\x7cvss_link_bridge\x7cvss_link_dip\x7cvss_link_m1\x7cvss_x1\x7cvss_x2\x7cvss_x3__t18
+ g_vddr_m1\x7cmnt_g\x7cs1_vddr_m1\x7cs2_vddr_m1\x7cs3_vddr_m1\x7cs4_vddr_m1\x7cvddr\x7cvddr2__t7
+ g_vddr_m1\x7cmnt_g\x7cs1_vddr_m1\x7cs2_vddr_m1\x7cs3_vddr_m1\x7cs4_vddr_m1\x7cvddr\x7cvddr2__t3
+ sky130_fd_pr__pfet_01v8 L=2 W=0.44 AS=0.1848 AD=0.1848 PS=1.72 PD=1.72
* device instance $254 r0 *1 92.735,27.375 pfet
X$254 py__t08
+ g_vss_m1\x7cinv_clk_vss\x7cinv_mc_vss\x7cinv_q_vss\x7cmph_g\x7cnand_m_vss\x7cnand_s2_vss\x7cs1_vss_m1\x7cs2_vss_m1\x7cs3_vss_m1\x7cs4_vss_m1\x7csb_vss\x7csr1_vss\x7csr2_vss\x7csr3_vss\x7csr4_vss\x7csv_vss\x7ctg_d_vss\x7ctg_fbm_vss\x7ctg_fbs_vss\x7ctg_s_vss\x7cvss\x7cvss_link\x7cvss_link_bridge\x7cvss_link_dip\x7cvss_link_m1\x7cvss_x1\x7cvss_x2\x7cvss_x3__t19
+ g_vddr_m1\x7cmnt_g\x7cs1_vddr_m1\x7cs2_vddr_m1\x7cs3_vddr_m1\x7cs4_vddr_m1\x7cvddr\x7cvddr2__t8
+ g_vddr_m1\x7cmnt_g\x7cs1_vddr_m1\x7cs2_vddr_m1\x7cs3_vddr_m1\x7cs4_vddr_m1\x7cvddr\x7cvddr2__t4
+ sky130_fd_pr__pfet_01v8 L=2 W=0.44 AS=0.1848 AD=0.1848 PS=1.72 PD=1.72
* device instance $255 r0 *1 114.21,27.375 pfet
X$255 mpa_py\x7cmpb_py\x7cmph_py\x7cpy__t03
+ g_vss_m1\x7cinv_clk_vss\x7cinv_mc_vss\x7cinv_q_vss\x7cmph_g\x7cnand_m_vss\x7cnand_s2_vss\x7cs1_vss_m1\x7cs2_vss_m1\x7cs3_vss_m1\x7cs4_vss_m1\x7csb_vss\x7csr1_vss\x7csr2_vss\x7csr3_vss\x7csr4_vss\x7csv_vss\x7ctg_d_vss\x7ctg_fbm_vss\x7ctg_fbs_vss\x7ctg_s_vss\x7cvss\x7cvss_link\x7cvss_link_bridge\x7cvss_link_dip\x7cvss_link_m1\x7cvss_x1\x7cvss_x2\x7cvss_x3__t8
+ g_vddr_m1\x7cmnt_g\x7cs1_vddr_m1\x7cs2_vddr_m1\x7cs3_vddr_m1\x7cs4_vddr_m1\x7cvddr\x7cvddr3__t1
+ g_vddr_m1\x7cmnt_g\x7cs1_vddr_m1\x7cs2_vddr_m1\x7cs3_vddr_m1\x7cs4_vddr_m1\x7cvddr\x7cvddr3__t2
+ sky130_fd_pr__pfet_01v8 L=2 W=0.46 AS=0.1932 AD=0.1932 PS=1.76 PD=1.76
* device instance $256 r0 *1 123.51,27.375 pfet
X$256 py__t09
+ g_vss_m1\x7cinv_clk_vss\x7cinv_mc_vss\x7cinv_q_vss\x7cmph_g\x7cnand_m_vss\x7cnand_s2_vss\x7cs1_vss_m1\x7cs2_vss_m1\x7cs3_vss_m1\x7cs4_vss_m1\x7csb_vss\x7csr1_vss\x7csr2_vss\x7csr3_vss\x7csr4_vss\x7csv_vss\x7ctg_d_vss\x7ctg_fbm_vss\x7ctg_fbs_vss\x7ctg_s_vss\x7cvss\x7cvss_link\x7cvss_link_bridge\x7cvss_link_dip\x7cvss_link_m1\x7cvss_x1\x7cvss_x2\x7cvss_x3__t17
+ g_vddr_m1\x7cmnt_g\x7cs1_vddr_m1\x7cs2_vddr_m1\x7cs3_vddr_m1\x7cs4_vddr_m1\x7cvddr\x7cvddr3__t10
+ g_vddr_m1\x7cmnt_g\x7cs1_vddr_m1\x7cs2_vddr_m1\x7cs3_vddr_m1\x7cs4_vddr_m1\x7cvddr\x7cvddr3__t6
+ sky130_fd_pr__pfet_01v8 L=2 W=0.46 AS=0.1932 AD=0.1932 PS=1.76 PD=1.76
* device instance $257 r0 *1 131.685,27.375 pfet
X$257 py__t010
+ g_vss_m1\x7cinv_clk_vss\x7cinv_mc_vss\x7cinv_q_vss\x7cmph_g\x7cnand_m_vss\x7cnand_s2_vss\x7cs1_vss_m1\x7cs2_vss_m1\x7cs3_vss_m1\x7cs4_vss_m1\x7csb_vss\x7csr1_vss\x7csr2_vss\x7csr3_vss\x7csr4_vss\x7csv_vss\x7ctg_d_vss\x7ctg_fbm_vss\x7ctg_fbs_vss\x7ctg_s_vss\x7cvss\x7cvss_link\x7cvss_link_bridge\x7cvss_link_dip\x7cvss_link_m1\x7cvss_x1\x7cvss_x2\x7cvss_x3__t16
+ g_vddr_m1\x7cmnt_g\x7cs1_vddr_m1\x7cs2_vddr_m1\x7cs3_vddr_m1\x7cs4_vddr_m1\x7cvddr\x7cvddr3__t9
+ g_vddr_m1\x7cmnt_g\x7cs1_vddr_m1\x7cs2_vddr_m1\x7cs3_vddr_m1\x7cs4_vddr_m1\x7cvddr\x7cvddr3__t5
+ sky130_fd_pr__pfet_01v8 L=2 W=0.46 AS=0.1932 AD=0.1932 PS=1.76 PD=1.76
* device instance $258 r0 *1 139.86,27.375 pfet
X$258 py__t011
+ g_vss_m1\x7cinv_clk_vss\x7cinv_mc_vss\x7cinv_q_vss\x7cmph_g\x7cnand_m_vss\x7cnand_s2_vss\x7cs1_vss_m1\x7cs2_vss_m1\x7cs3_vss_m1\x7cs4_vss_m1\x7csb_vss\x7csr1_vss\x7csr2_vss\x7csr3_vss\x7csr4_vss\x7csv_vss\x7ctg_d_vss\x7ctg_fbm_vss\x7ctg_fbs_vss\x7ctg_s_vss\x7cvss\x7cvss_link\x7cvss_link_bridge\x7cvss_link_dip\x7cvss_link_m1\x7cvss_x1\x7cvss_x2\x7cvss_x3__t15
+ g_vddr_m1\x7cmnt_g\x7cs1_vddr_m1\x7cs2_vddr_m1\x7cs3_vddr_m1\x7cs4_vddr_m1\x7cvddr\x7cvddr3__t8
+ g_vddr_m1\x7cmnt_g\x7cs1_vddr_m1\x7cs2_vddr_m1\x7cs3_vddr_m1\x7cs4_vddr_m1\x7cvddr\x7cvddr3__t4
+ sky130_fd_pr__pfet_01v8 L=2 W=0.46 AS=0.1932 AD=0.1932 PS=1.76 PD=1.76
* device instance $259 r0 *1 148.035,27.375 pfet
X$259 py__t012
+ g_vss_m1\x7cinv_clk_vss\x7cinv_mc_vss\x7cinv_q_vss\x7cmph_g\x7cnand_m_vss\x7cnand_s2_vss\x7cs1_vss_m1\x7cs2_vss_m1\x7cs3_vss_m1\x7cs4_vss_m1\x7csb_vss\x7csr1_vss\x7csr2_vss\x7csr3_vss\x7csr4_vss\x7csv_vss\x7ctg_d_vss\x7ctg_fbm_vss\x7ctg_fbs_vss\x7ctg_s_vss\x7cvss\x7cvss_link\x7cvss_link_bridge\x7cvss_link_dip\x7cvss_link_m1\x7cvss_x1\x7cvss_x2\x7cvss_x3__t14
+ g_vddr_m1\x7cmnt_g\x7cs1_vddr_m1\x7cs2_vddr_m1\x7cs3_vddr_m1\x7cs4_vddr_m1\x7cvddr\x7cvddr3__t7
+ g_vddr_m1\x7cmnt_g\x7cs1_vddr_m1\x7cs2_vddr_m1\x7cs3_vddr_m1\x7cs4_vddr_m1\x7cvddr\x7cvddr3__t3
+ sky130_fd_pr__pfet_01v8 L=2 W=0.46 AS=0.1932 AD=0.1932 PS=1.76 PD=1.76
* device instance $260 r0 *1 169.51,27.375 pfet
X$260 mpa_py\x7cmpb_py\x7cmph_py\x7cpy__t04
+ g_vss_m1\x7cinv_clk_vss\x7cinv_mc_vss\x7cinv_q_vss\x7cmph_g\x7cnand_m_vss\x7cnand_s2_vss\x7cs1_vss_m1\x7cs2_vss_m1\x7cs3_vss_m1\x7cs4_vss_m1\x7csb_vss\x7csr1_vss\x7csr2_vss\x7csr3_vss\x7csr4_vss\x7csv_vss\x7ctg_d_vss\x7ctg_fbm_vss\x7ctg_fbs_vss\x7ctg_s_vss\x7cvss\x7cvss_link\x7cvss_link_bridge\x7cvss_link_dip\x7cvss_link_m1\x7cvss_x1\x7cvss_x2\x7cvss_x3__t9
+ g_vddr_m1\x7cmnt_g\x7cs1_vddr_m1\x7cs2_vddr_m1\x7cs3_vddr_m1\x7cs4_vddr_m1\x7cvddr\x7cvddr4__t1
+ g_vddr_m1\x7cmnt_g\x7cs1_vddr_m1\x7cs2_vddr_m1\x7cs3_vddr_m1\x7cs4_vddr_m1\x7cvddr\x7cvddr4__t2
+ sky130_fd_pr__pfet_01v8 L=2 W=0.48 AS=0.2016 AD=0.2016 PS=1.8 PD=1.8
* device instance $261 r0 *1 178.81,27.375 pfet
X$261 py__t013
+ g_vss_m1\x7cinv_clk_vss\x7cinv_mc_vss\x7cinv_q_vss\x7cmph_g\x7cnand_m_vss\x7cnand_s2_vss\x7cs1_vss_m1\x7cs2_vss_m1\x7cs3_vss_m1\x7cs4_vss_m1\x7csb_vss\x7csr1_vss\x7csr2_vss\x7csr3_vss\x7csr4_vss\x7csv_vss\x7ctg_d_vss\x7ctg_fbm_vss\x7ctg_fbs_vss\x7ctg_s_vss\x7cvss\x7cvss_link\x7cvss_link_bridge\x7cvss_link_dip\x7cvss_link_m1\x7cvss_x1\x7cvss_x2\x7cvss_x3__t13
+ g_vddr_m1\x7cmnt_g\x7cs1_vddr_m1\x7cs2_vddr_m1\x7cs3_vddr_m1\x7cs4_vddr_m1\x7cvddr\x7cvddr4__t10
+ g_vddr_m1\x7cmnt_g\x7cs1_vddr_m1\x7cs2_vddr_m1\x7cs3_vddr_m1\x7cs4_vddr_m1\x7cvddr\x7cvddr4__t6
+ sky130_fd_pr__pfet_01v8 L=2 W=0.48 AS=0.2016 AD=0.2016 PS=1.8 PD=1.8
* device instance $262 r0 *1 186.985,27.375 pfet
X$262 py__t014
+ g_vss_m1\x7cinv_clk_vss\x7cinv_mc_vss\x7cinv_q_vss\x7cmph_g\x7cnand_m_vss\x7cnand_s2_vss\x7cs1_vss_m1\x7cs2_vss_m1\x7cs3_vss_m1\x7cs4_vss_m1\x7csb_vss\x7csr1_vss\x7csr2_vss\x7csr3_vss\x7csr4_vss\x7csv_vss\x7ctg_d_vss\x7ctg_fbm_vss\x7ctg_fbs_vss\x7ctg_s_vss\x7cvss\x7cvss_link\x7cvss_link_bridge\x7cvss_link_dip\x7cvss_link_m1\x7cvss_x1\x7cvss_x2\x7cvss_x3__t10
+ g_vddr_m1\x7cmnt_g\x7cs1_vddr_m1\x7cs2_vddr_m1\x7cs3_vddr_m1\x7cs4_vddr_m1\x7cvddr\x7cvddr4__t7
+ g_vddr_m1\x7cmnt_g\x7cs1_vddr_m1\x7cs2_vddr_m1\x7cs3_vddr_m1\x7cs4_vddr_m1\x7cvddr\x7cvddr4__t3
+ sky130_fd_pr__pfet_01v8 L=2 W=0.48 AS=0.2016 AD=0.2016 PS=1.8 PD=1.8
* device instance $263 r0 *1 195.16,27.375 pfet
X$263 py__t015
+ g_vss_m1\x7cinv_clk_vss\x7cinv_mc_vss\x7cinv_q_vss\x7cmph_g\x7cnand_m_vss\x7cnand_s2_vss\x7cs1_vss_m1\x7cs2_vss_m1\x7cs3_vss_m1\x7cs4_vss_m1\x7csb_vss\x7csr1_vss\x7csr2_vss\x7csr3_vss\x7csr4_vss\x7csv_vss\x7ctg_d_vss\x7ctg_fbm_vss\x7ctg_fbs_vss\x7ctg_s_vss\x7cvss\x7cvss_link\x7cvss_link_bridge\x7cvss_link_dip\x7cvss_link_m1\x7cvss_x1\x7cvss_x2\x7cvss_x3__t11
+ g_vddr_m1\x7cmnt_g\x7cs1_vddr_m1\x7cs2_vddr_m1\x7cs3_vddr_m1\x7cs4_vddr_m1\x7cvddr\x7cvddr4__t8
+ g_vddr_m1\x7cmnt_g\x7cs1_vddr_m1\x7cs2_vddr_m1\x7cs3_vddr_m1\x7cs4_vddr_m1\x7cvddr\x7cvddr4__t4
+ sky130_fd_pr__pfet_01v8 L=2 W=0.48 AS=0.2016 AD=0.2016 PS=1.8 PD=1.8
* device instance $264 r0 *1 203.335,27.375 pfet
X$264 py__t016
+ g_vss_m1\x7cinv_clk_vss\x7cinv_mc_vss\x7cinv_q_vss\x7cmph_g\x7cnand_m_vss\x7cnand_s2_vss\x7cs1_vss_m1\x7cs2_vss_m1\x7cs3_vss_m1\x7cs4_vss_m1\x7csb_vss\x7csr1_vss\x7csr2_vss\x7csr3_vss\x7csr4_vss\x7csv_vss\x7ctg_d_vss\x7ctg_fbm_vss\x7ctg_fbs_vss\x7ctg_s_vss\x7cvss\x7cvss_link\x7cvss_link_bridge\x7cvss_link_dip\x7cvss_link_m1\x7cvss_x1\x7cvss_x2\x7cvss_x3__t12
+ g_vddr_m1\x7cmnt_g\x7cs1_vddr_m1\x7cs2_vddr_m1\x7cs3_vddr_m1\x7cs4_vddr_m1\x7cvddr\x7cvddr4__t9
+ g_vddr_m1\x7cmnt_g\x7cs1_vddr_m1\x7cs2_vddr_m1\x7cs3_vddr_m1\x7cs4_vddr_m1\x7cvddr\x7cvddr4__t5
+ sky130_fd_pr__pfet_01v8 L=2 W=0.48 AS=0.2016 AD=0.2016 PS=1.8 PD=1.8
* device instance _136_t0 r0 *1 0,0
R_136_t0 \$136__t0 \$136 12.8
* device instance _136_t1 r0 *1 0,0
R_136_t1 \$136__t1 \$136 12.8
* device instance _136 r0 *1 0,0
C_136 \$136 vsubs 1.15618e-16
* device instance _138_t0 r0 *1 0,0
R_138_t0 \$138__t0 \$138 12.8
* device instance _138_t1 r0 *1 0,0
R_138_t1 \$138__t1 \$138 12.8
* device instance _138 r0 *1 0,0
C_138 \$138 vsubs 1.15618e-16
* device instance _139_t0 r0 *1 0,0
R_139_t0 \$139__t0 \$139 12.8
* device instance _139_t1 r0 *1 0,0
R_139_t1 \$139__t1 \$139 12.8
* device instance _139 r0 *1 0,0
C_139 \$139 vsubs 1.15618e-16
* device instance _141_t0 r0 *1 0,0
R_141_t0 \$141__t0 \$141 12.8
* device instance _141_t1 r0 *1 0,0
R_141_t1 \$141__t1 \$141 12.8
* device instance _141 r0 *1 0,0
C_141 \$141 vsubs 1.15618e-16
* device instance _143_t0 r0 *1 0,0
R_143_t0 \$143__t0 \$143 12.8
* device instance _143_t1 r0 *1 0,0
R_143_t1 \$143__t1 \$143 12.8
* device instance _143 r0 *1 0,0
C_143 \$143 vsubs 1.15618e-16
* device instance _145_t0 r0 *1 0,0
R_145_t0 \$145__t0 \$145 12.8
* device instance _145_t1 r0 *1 0,0
R_145_t1 \$145__t1 \$145 12.8
* device instance _145 r0 *1 0,0
C_145 \$145 vsubs 1.15618e-16
* device instance _17_t0 r0 *1 0,0
R_17_t0 \$17__t0 \$17 12.8
* device instance _17_t1 r0 *1 0,0
R_17_t1 \$17__t1 \$17 12.8
* device instance _17 r0 *1 0,0
C_17 \$17 vsubs 1.15618e-16
* device instance _18_t0 r0 *1 0,0
R_18_t0 \$18__t0 \$18 12.8
* device instance _18_t1 r0 *1 0,0
R_18_t1 \$18__t1 \$18 12.8
* device instance _18 r0 *1 0,0
C_18 \$18 vsubs 1.15618e-16
* device instance _20_t0 r0 *1 0,0
R_20_t0 \$20__t0 \$20 12.8
* device instance _20_t1 r0 *1 0,0
R_20_t1 \$20__t1 \$20 12.8
* device instance _20 r0 *1 0,0
C_20 \$20 vsubs 1.15618e-16
* device instance _21_t0 r0 *1 0,0
R_21_t0 \$21__t0 \$21 12.8
* device instance _21_t1 r0 *1 0,0
R_21_t1 \$21__t1 \$21 12.8
* device instance _21 r0 *1 0,0
C_21 \$21 vsubs 1.15618e-16
* device instance _24_t0 r0 *1 0,0
R_24_t0 \$24__t0 \$24 12.8
* device instance _24_t1 r0 *1 0,0
R_24_t1 \$24__t1 \$24 12.8
* device instance _24 r0 *1 0,0
C_24 \$24 vsubs 1.15618e-16
* device instance _25_t0 r0 *1 0,0
R_25_t0 \$25__t0 \$25 12.8
* device instance _25_t1 r0 *1 0,0
R_25_t1 \$25__t1 \$25 12.8
* device instance _25 r0 *1 0,0
C_25 \$25 vsubs 1.15618e-16
* device instance _28_t0 r0 *1 0,0
R_28_t0 \$28__t0 \$28 12.8
* device instance _28_t1 r0 *1 0,0
R_28_t1 \$28__t1 \$28 12.8
* device instance _28 r0 *1 0,0
C_28 \$28 vsubs 1.15618e-16
* device instance _29_t0 r0 *1 0,0
R_29_t0 \$29__t0 \$29 12.8
* device instance _29_t1 r0 *1 0,0
R_29_t1 \$29__t1 \$29 12.8
* device instance _29 r0 *1 0,0
C_29 \$29 vsubs 1.15618e-16
* device instance _32_t0 r0 *1 0,0
R_32_t0 \$32__t0 \$32 12.8
* device instance _32_t1 r0 *1 0,0
R_32_t1 \$32__t1 \$32 12.8
* device instance _32 r0 *1 0,0
C_32 \$32 vsubs 1.15618e-16
* device instance _33_t0 r0 *1 0,0
R_33_t0 \$33__t0 \$33 12.8
* device instance _33_t1 r0 *1 0,0
R_33_t1 \$33__t1 \$33 12.8
* device instance _33 r0 *1 0,0
C_33 \$33 vsubs 1.15618e-16
* device instance _36_t0 r0 *1 0,0
R_36_t0 \$36__t0 \$36 12.8
* device instance _36_t1 r0 *1 0,0
R_36_t1 \$36__t1 \$36 12.8
* device instance _36 r0 *1 0,0
C_36 \$36 vsubs 1.15618e-16
* device instance _37_t0 r0 *1 0,0
R_37_t0 \$37__t0 \$37 12.8
* device instance _37_t1 r0 *1 0,0
R_37_t1 \$37__t1 \$37 12.8
* device instance _37 r0 *1 0,0
C_37 \$37 vsubs 1.15618e-16
* device instance _70_t0 r0 *1 0,0
R_70_t0 \$70__t0 \$70 12.8
* device instance _70_t1 r0 *1 0,0
R_70_t1 \$70__t1 \$70 12.8
* device instance _70 r0 *1 0,0
C_70 \$70 vsubs 1.15618e-16
* device instance _78_t0 r0 *1 0,0
R_78_t0 \$78__t0 \$78 12.8
* device instance _78_t1 r0 *1 0,0
R_78_t1 \$78__t1 \$78 12.8
* device instance _78 r0 *1 0,0
C_78 \$78 vsubs 1.15618e-16
* device instance _87_t0 r0 *1 0,0
R_87_t0 \$87__t0 \$87 12.8
* device instance _87_t1 r0 *1 0,0
R_87_t1 \$87__t1 \$87 12.8
* device instance _87 r0 *1 0,0
C_87 \$87 vsubs 1.15618e-16
* device instance _96_t0 r0 *1 0,0
R_96_t0 \$96__t0 \$96 12.8
* device instance _96_t1 r0 *1 0,0
R_96_t1 \$96__t1 \$96 12.8
* device instance _96 r0 *1 0,0
C_96 \$96 vsubs 1.15618e-16
* device instance an_inva_y_mn34_g0_mp13_g1_y_t0 r0 *1 0,0
Ran_inva_y_mn34_g0_mp13_g1_y_t0 an\x7cinva_y\x7cmn34_g0\x7cmp13_g1\x7cy__t0
+ an|inva_y|mn34_g0|mp13_g1|y 308.267015586
* device instance an_inva_y_mn34_g0_mp13_g1_y_t1 r0 *1 0,0
Ran_inva_y_mn34_g0_mp13_g1_y_t1 an\x7cinva_y\x7cmn34_g0\x7cmp13_g1\x7cy__t1
+ an|inva_y|mn34_g0|mp13_g1|y 160.163782155
* device instance an_inva_y_mn34_g0_mp13_g1_y_t2 r0 *1 0,0
Ran_inva_y_mn34_g0_mp13_g1_y_t2 an\x7cinva_y\x7cmn34_g0\x7cmp13_g1\x7cy__t2
+ an|inva_y|mn34_g0|mp13_g1|y 129.429614029
* device instance an_inva_y_mn34_g0_mp13_g1_y_t3 r0 *1 0,0
Ran_inva_y_mn34_g0_mp13_g1_y_t3 an\x7cinva_y\x7cmn34_g0\x7cmp13_g1\x7cy__t3
+ an|inva_y|mn34_g0|mp13_g1|y 253.84948823
* device instance an_inva_y_mn34_g0_mp13_g1_y r0 *1 0,0
Can_inva_y_mn34_g0_mp13_g1_y an|inva_y|mn34_g0|mp13_g1|y vsubs 2.183901e-15
* device instance an_inva_y_mn34_g0_mp13_g1_y_dup1_t0 r0 *1 0,0
Ran_inva_y_mn34_g0_mp13_g1_y_dup1_t0
+ an\x7cinva_y\x7cmn34_g0\x7cmp13_g1\x7cy__t02 an|inva_y|mn34_g0|mp13_g1|y$1
+ 308.267015586
* device instance an_inva_y_mn34_g0_mp13_g1_y_dup1_t1 r0 *1 0,0
Ran_inva_y_mn34_g0_mp13_g1_y_dup1_t1
+ an\x7cinva_y\x7cmn34_g0\x7cmp13_g1\x7cy__t12 an|inva_y|mn34_g0|mp13_g1|y$1
+ 160.163782155
* device instance an_inva_y_mn34_g0_mp13_g1_y_dup1_t2 r0 *1 0,0
Ran_inva_y_mn34_g0_mp13_g1_y_dup1_t2
+ an\x7cinva_y\x7cmn34_g0\x7cmp13_g1\x7cy__t22 an|inva_y|mn34_g0|mp13_g1|y$1
+ 129.429614029
* device instance an_inva_y_mn34_g0_mp13_g1_y_dup1_t3 r0 *1 0,0
Ran_inva_y_mn34_g0_mp13_g1_y_dup1_t3
+ an\x7cinva_y\x7cmn34_g0\x7cmp13_g1\x7cy__t32 an|inva_y|mn34_g0|mp13_g1|y$1
+ 253.84948823
* device instance an_inva_y_mn34_g0_mp13_g1_y_dup1 r0 *1 0,0
Can_inva_y_mn34_g0_mp13_g1_y_dup1 an|inva_y|mn34_g0|mp13_g1|y$1 vsubs
+ 2.183901e-15
* device instance an_inva_y_mn34_g0_mp13_g1_y_dup2_t0 r0 *1 0,0
Ran_inva_y_mn34_g0_mp13_g1_y_dup2_t0
+ an\x7cinva_y\x7cmn34_g0\x7cmp13_g1\x7cy__t03 an|inva_y|mn34_g0|mp13_g1|y$2
+ 308.267015586
* device instance an_inva_y_mn34_g0_mp13_g1_y_dup2_t1 r0 *1 0,0
Ran_inva_y_mn34_g0_mp13_g1_y_dup2_t1
+ an\x7cinva_y\x7cmn34_g0\x7cmp13_g1\x7cy__t13 an|inva_y|mn34_g0|mp13_g1|y$2
+ 160.163782155
* device instance an_inva_y_mn34_g0_mp13_g1_y_dup2_t2 r0 *1 0,0
Ran_inva_y_mn34_g0_mp13_g1_y_dup2_t2
+ an\x7cinva_y\x7cmn34_g0\x7cmp13_g1\x7cy__t23 an|inva_y|mn34_g0|mp13_g1|y$2
+ 129.429614029
* device instance an_inva_y_mn34_g0_mp13_g1_y_dup2_t3 r0 *1 0,0
Ran_inva_y_mn34_g0_mp13_g1_y_dup2_t3
+ an\x7cinva_y\x7cmn34_g0\x7cmp13_g1\x7cy__t33 an|inva_y|mn34_g0|mp13_g1|y$2
+ 253.84948823
* device instance an_inva_y_mn34_g0_mp13_g1_y_dup2 r0 *1 0,0
Can_inva_y_mn34_g0_mp13_g1_y_dup2 an|inva_y|mn34_g0|mp13_g1|y$2 vsubs
+ 2.183901e-15
* device instance a_b_b3_invb_a_mn12_g1_mp24_g0_t2_y_t0 r0 *1 0,0
Ra_b_b3_invb_a_mn12_g1_mp24_g0_t2_y_t0
+ a\x7cb\x7cb3\x7cinvb_a\x7cmn12_g1\x7cmp24_g0\x7ct2\x7cy__t0
+ a|b|b3|invb_a|mn12_g1|mp24_g0|t2|y 436.725341736
* device instance a_b_b3_invb_a_mn12_g1_mp24_g0_t2_y_t1 r0 *1 0,0
Ra_b_b3_invb_a_mn12_g1_mp24_g0_t2_y_t1
+ a\x7cb\x7cb3\x7cinvb_a\x7cmn12_g1\x7cmp24_g0\x7ct2\x7cy__t1
+ a|b|b3|invb_a|mn12_g1|mp24_g0|t2|y 313.585442139
* device instance a_b_b3_invb_a_mn12_g1_mp24_g0_t2_y_t2 r0 *1 0,0
Ra_b_b3_invb_a_mn12_g1_mp24_g0_t2_y_t2
+ a\x7cb\x7cb3\x7cinvb_a\x7cmn12_g1\x7cmp24_g0\x7ct2\x7cy__t2
+ a|b|b3|invb_a|mn12_g1|mp24_g0|t2|y 312.928261153
* device instance a_b_b3_invb_a_mn12_g1_mp24_g0_t2_y_t3 r0 *1 0,0
Ra_b_b3_invb_a_mn12_g1_mp24_g0_t2_y_t3
+ a\x7cb\x7cb3\x7cinvb_a\x7cmn12_g1\x7cmp24_g0\x7ct2\x7cy__t3
+ a|b|b3|invb_a|mn12_g1|mp24_g0|t2|y 425.2506178
* device instance a_b_b3_invb_a_mn12_g1_mp24_g0_t2_y_t4 r0 *1 0,0
Ra_b_b3_invb_a_mn12_g1_mp24_g0_t2_y_t4
+ a\x7cb\x7cb3\x7cinvb_a\x7cmn12_g1\x7cmp24_g0\x7ct2\x7cy__t4
+ a|b|b3|invb_a|mn12_g1|mp24_g0|t2|y 422.873561928
* device instance a_b_b3_invb_a_mn12_g1_mp24_g0_t2_y_t5 r0 *1 0,0
Ra_b_b3_invb_a_mn12_g1_mp24_g0_t2_y_t5
+ a\x7cb\x7cb3\x7cinvb_a\x7cmn12_g1\x7cmp24_g0\x7ct2\x7cy__t5
+ a|b|b3|invb_a|mn12_g1|mp24_g0|t2|y 314.138675751
* device instance a_b_b3_invb_a_mn12_g1_mp24_g0_t2_y_t6 r0 *1 0,0
Ra_b_b3_invb_a_mn12_g1_mp24_g0_t2_y_t6
+ a\x7cb\x7cb3\x7cinvb_a\x7cmn12_g1\x7cmp24_g0\x7ct2\x7cy__t6
+ a|b|b3|invb_a|mn12_g1|mp24_g0|t2|y 305.885364036
* device instance a_b_b3_invb_a_mn12_g1_mp24_g0_t2_y_t7 r0 *1 0,0
Ra_b_b3_invb_a_mn12_g1_mp24_g0_t2_y_t7
+ a\x7cb\x7cb3\x7cinvb_a\x7cmn12_g1\x7cmp24_g0\x7ct2\x7cy__t7
+ a|b|b3|invb_a|mn12_g1|mp24_g0|t2|y 440.626235455
* device instance a_b_b3_invb_a_mn12_g1_mp24_g0_t2_y r0 *1 0,0
Ca_b_b3_invb_a_mn12_g1_mp24_g0_t2_y a|b|b3|invb_a|mn12_g1|mp24_g0|t2|y vsubs
+ 9.920674e-15
* device instance a_b_d_invb_a_mn12_g1_mp24_g0_ro2_ro2_esc_sr2_d_stub_tg_d_a_y_t0 r0 *1 0,0
Ra_b_d_invb_a_mn12_g1_mp24_g0_ro2_ro2_esc_sr2_d_stub_tg_d_a_y_t0
+ a\x7cb\x7cd\x7cinvb_a\x7cmn12_g1\x7cmp24_g0\x7cro2\x7cro2_esc\x7csr2_d_stub\x7ctg_d_a\x7cy__t0
+ a|b|d|invb_a|mn12_g1|mp24_g0|ro2|ro2_esc|sr2_d_stub|tg_d_a|y 285.406748926
* device instance a_b_d_invb_a_mn12_g1_mp24_g0_ro2_ro2_esc_sr2_d_stub_tg_d_a_y_t1 r0 *1 0,0
Ra_b_d_invb_a_mn12_g1_mp24_g0_ro2_ro2_esc_sr2_d_stub_tg_d_a_y_t1
+ a\x7cb\x7cd\x7cinvb_a\x7cmn12_g1\x7cmp24_g0\x7cro2\x7cro2_esc\x7csr2_d_stub\x7ctg_d_a\x7cy__t1
+ a|b|d|invb_a|mn12_g1|mp24_g0|ro2|ro2_esc|sr2_d_stub|tg_d_a|y 422.188817865
* device instance a_b_d_invb_a_mn12_g1_mp24_g0_ro2_ro2_esc_sr2_d_stub_tg_d_a_y_t2 r0 *1 0,0
Ra_b_d_invb_a_mn12_g1_mp24_g0_ro2_ro2_esc_sr2_d_stub_tg_d_a_y_t2
+ a\x7cb\x7cd\x7cinvb_a\x7cmn12_g1\x7cmp24_g0\x7cro2\x7cro2_esc\x7csr2_d_stub\x7ctg_d_a\x7cy__t2
+ a|b|d|invb_a|mn12_g1|mp24_g0|ro2|ro2_esc|sr2_d_stub|tg_d_a|y 112.934224289
* device instance a_b_d_invb_a_mn12_g1_mp24_g0_ro2_ro2_esc_sr2_d_stub_tg_d_a_y_t3 r0 *1 0,0
Ra_b_d_invb_a_mn12_g1_mp24_g0_ro2_ro2_esc_sr2_d_stub_tg_d_a_y_t3
+ a\x7cb\x7cd\x7cinvb_a\x7cmn12_g1\x7cmp24_g0\x7cro2\x7cro2_esc\x7csr2_d_stub\x7ctg_d_a\x7cy__t3
+ a|b|d|invb_a|mn12_g1|mp24_g0|ro2|ro2_esc|sr2_d_stub|tg_d_a|y 111.183828859
* device instance a_b_d_invb_a_mn12_g1_mp24_g0_ro2_ro2_esc_sr2_d_stub_tg_d_a_y_t4 r0 *1 0,0
Ra_b_d_invb_a_mn12_g1_mp24_g0_ro2_ro2_esc_sr2_d_stub_tg_d_a_y_t4
+ a\x7cb\x7cd\x7cinvb_a\x7cmn12_g1\x7cmp24_g0\x7cro2\x7cro2_esc\x7csr2_d_stub\x7ctg_d_a\x7cy__t4
+ a|b|d|invb_a|mn12_g1|mp24_g0|ro2|ro2_esc|sr2_d_stub|tg_d_a|y 418.267814415
* device instance a_b_d_invb_a_mn12_g1_mp24_g0_ro2_ro2_esc_sr2_d_stub_tg_d_a_y_t5 r0 *1 0,0
Ra_b_d_invb_a_mn12_g1_mp24_g0_ro2_ro2_esc_sr2_d_stub_tg_d_a_y_t5
+ a\x7cb\x7cd\x7cinvb_a\x7cmn12_g1\x7cmp24_g0\x7cro2\x7cro2_esc\x7csr2_d_stub\x7ctg_d_a\x7cy__t5
+ a|b|d|invb_a|mn12_g1|mp24_g0|ro2|ro2_esc|sr2_d_stub|tg_d_a|y 250.190981376
* device instance a_b_d_invb_a_mn12_g1_mp24_g0_ro2_ro2_esc_sr2_d_stub_tg_d_a_y_t6 r0 *1 0,0
Ra_b_d_invb_a_mn12_g1_mp24_g0_ro2_ro2_esc_sr2_d_stub_tg_d_a_y_t6
+ a\x7cb\x7cd\x7cinvb_a\x7cmn12_g1\x7cmp24_g0\x7cro2\x7cro2_esc\x7csr2_d_stub\x7ctg_d_a\x7cy__t6
+ a|b|d|invb_a|mn12_g1|mp24_g0|ro2|ro2_esc|sr2_d_stub|tg_d_a|y 253.725731933
* device instance a_b_d_invb_a_mn12_g1_mp24_g0_ro2_ro2_esc_sr2_d_stub_tg_d_a_y_t7 r0 *1 0,0
Ra_b_d_invb_a_mn12_g1_mp24_g0_ro2_ro2_esc_sr2_d_stub_tg_d_a_y_t7
+ a\x7cb\x7cd\x7cinvb_a\x7cmn12_g1\x7cmp24_g0\x7cro2\x7cro2_esc\x7csr2_d_stub\x7ctg_d_a\x7cy__t7
+ a|b|d|invb_a|mn12_g1|mp24_g0|ro2|ro2_esc|sr2_d_stub|tg_d_a|y 274.314252337
* device instance a_b_d_invb_a_mn12_g1_mp24_g0_ro2_ro2_esc_sr2_d_stub_tg_d_a_y r0 *1 0,0
Ca_b_d_invb_a_mn12_g1_mp24_g0_ro2_ro2_esc_sr2_d_stub_tg_d_a_y
+ a|b|d|invb_a|mn12_g1|mp24_g0|ro2|ro2_esc|sr2_d_stub|tg_d_a|y vsubs
+ 3.0572758e-14
* device instance a_b_d_invb_a_mn12_g1_mp24_g0_ro4_ro4_esc_sr4_d_stub_tg_d_a_y_t0 r0 *1 0,0
Ra_b_d_invb_a_mn12_g1_mp24_g0_ro4_ro4_esc_sr4_d_stub_tg_d_a_y_t0
+ a\x7cb\x7cd\x7cinvb_a\x7cmn12_g1\x7cmp24_g0\x7cro4\x7cro4_esc\x7csr4_d_stub\x7ctg_d_a\x7cy__t0
+ a|b|d|invb_a|mn12_g1|mp24_g0|ro4|ro4_esc|sr4_d_stub|tg_d_a|y 272.450155459
* device instance a_b_d_invb_a_mn12_g1_mp24_g0_ro4_ro4_esc_sr4_d_stub_tg_d_a_y_t1 r0 *1 0,0
Ra_b_d_invb_a_mn12_g1_mp24_g0_ro4_ro4_esc_sr4_d_stub_tg_d_a_y_t1
+ a\x7cb\x7cd\x7cinvb_a\x7cmn12_g1\x7cmp24_g0\x7cro4\x7cro4_esc\x7csr4_d_stub\x7ctg_d_a\x7cy__t1
+ a|b|d|invb_a|mn12_g1|mp24_g0|ro4|ro4_esc|sr4_d_stub|tg_d_a|y 171.057928278
* device instance a_b_d_invb_a_mn12_g1_mp24_g0_ro4_ro4_esc_sr4_d_stub_tg_d_a_y_t2 r0 *1 0,0
Ra_b_d_invb_a_mn12_g1_mp24_g0_ro4_ro4_esc_sr4_d_stub_tg_d_a_y_t2
+ a\x7cb\x7cd\x7cinvb_a\x7cmn12_g1\x7cmp24_g0\x7cro4\x7cro4_esc\x7csr4_d_stub\x7ctg_d_a\x7cy__t2
+ a|b|d|invb_a|mn12_g1|mp24_g0|ro4|ro4_esc|sr4_d_stub|tg_d_a|y 355.013466054
* device instance a_b_d_invb_a_mn12_g1_mp24_g0_ro4_ro4_esc_sr4_d_stub_tg_d_a_y_t3 r0 *1 0,0
Ra_b_d_invb_a_mn12_g1_mp24_g0_ro4_ro4_esc_sr4_d_stub_tg_d_a_y_t3
+ a\x7cb\x7cd\x7cinvb_a\x7cmn12_g1\x7cmp24_g0\x7cro4\x7cro4_esc\x7csr4_d_stub\x7ctg_d_a\x7cy__t3
+ a|b|d|invb_a|mn12_g1|mp24_g0|ro4|ro4_esc|sr4_d_stub|tg_d_a|y 353.355312994
* device instance a_b_d_invb_a_mn12_g1_mp24_g0_ro4_ro4_esc_sr4_d_stub_tg_d_a_y_t4 r0 *1 0,0
Ra_b_d_invb_a_mn12_g1_mp24_g0_ro4_ro4_esc_sr4_d_stub_tg_d_a_y_t4
+ a\x7cb\x7cd\x7cinvb_a\x7cmn12_g1\x7cmp24_g0\x7cro4\x7cro4_esc\x7csr4_d_stub\x7ctg_d_a\x7cy__t4
+ a|b|d|invb_a|mn12_g1|mp24_g0|ro4|ro4_esc|sr4_d_stub|tg_d_a|y 170.648732577
* device instance a_b_d_invb_a_mn12_g1_mp24_g0_ro4_ro4_esc_sr4_d_stub_tg_d_a_y_t5 r0 *1 0,0
Ra_b_d_invb_a_mn12_g1_mp24_g0_ro4_ro4_esc_sr4_d_stub_tg_d_a_y_t5
+ a\x7cb\x7cd\x7cinvb_a\x7cmn12_g1\x7cmp24_g0\x7cro4\x7cro4_esc\x7csr4_d_stub\x7ctg_d_a\x7cy__t5
+ a|b|d|invb_a|mn12_g1|mp24_g0|ro4|ro4_esc|sr4_d_stub|tg_d_a|y 253.106115853
* device instance a_b_d_invb_a_mn12_g1_mp24_g0_ro4_ro4_esc_sr4_d_stub_tg_d_a_y_t6 r0 *1 0,0
Ra_b_d_invb_a_mn12_g1_mp24_g0_ro4_ro4_esc_sr4_d_stub_tg_d_a_y_t6
+ a\x7cb\x7cd\x7cinvb_a\x7cmn12_g1\x7cmp24_g0\x7cro4\x7cro4_esc\x7csr4_d_stub\x7ctg_d_a\x7cy__t6
+ a|b|d|invb_a|mn12_g1|mp24_g0|ro4|ro4_esc|sr4_d_stub|tg_d_a|y 254.357193838
* device instance a_b_d_invb_a_mn12_g1_mp24_g0_ro4_ro4_esc_sr4_d_stub_tg_d_a_y_t7 r0 *1 0,0
Ra_b_d_invb_a_mn12_g1_mp24_g0_ro4_ro4_esc_sr4_d_stub_tg_d_a_y_t7
+ a\x7cb\x7cd\x7cinvb_a\x7cmn12_g1\x7cmp24_g0\x7cro4\x7cro4_esc\x7csr4_d_stub\x7ctg_d_a\x7cy__t7
+ a|b|d|invb_a|mn12_g1|mp24_g0|ro4|ro4_esc|sr4_d_stub|tg_d_a|y 268.156694947
* device instance a_b_d_invb_a_mn12_g1_mp24_g0_ro4_ro4_esc_sr4_d_stub_tg_d_a_y r0 *1 0,0
Ca_b_d_invb_a_mn12_g1_mp24_g0_ro4_ro4_esc_sr4_d_stub_tg_d_a_y
+ a|b|d|invb_a|mn12_g1|mp24_g0|ro4|ro4_esc|sr4_d_stub|tg_d_a|y vsubs
+ 2.7927101e-14
* device instance a_b_inv_q_a_inv_q_a_via_s_tg_fbs_b_tg_fbs_b_via_tg_s_b_tg_s_b_via_t0 r0 *1 0,0
Ra_b_inv_q_a_inv_q_a_via_s_tg_fbs_b_tg_fbs_b_via_tg_s_b_tg_s_b_via_t0
+ a\x7cb\x7cinv_q_a\x7cinv_q_a_via\x7cs\x7ctg_fbs_b\x7ctg_fbs_b_via\x7ctg_s_b\x7ctg_s_b_via__t0
+ a|b|inv_q_a|inv_q_a_via|s|tg_fbs_b|tg_fbs_b_via|tg_s_b|tg_s_b_via
+ 68.9738937426
* device instance a_b_inv_q_a_inv_q_a_via_s_tg_fbs_b_tg_fbs_b_via_tg_s_b_tg_s_b_via_t1 r0 *1 0,0
Ra_b_inv_q_a_inv_q_a_via_s_tg_fbs_b_tg_fbs_b_via_tg_s_b_tg_s_b_via_t1
+ a\x7cb\x7cinv_q_a\x7cinv_q_a_via\x7cs\x7ctg_fbs_b\x7ctg_fbs_b_via\x7ctg_s_b\x7ctg_s_b_via__t1
+ a|b|inv_q_a|inv_q_a_via|s|tg_fbs_b|tg_fbs_b_via|tg_s_b|tg_s_b_via
+ 68.9738937426
* device instance a_b_inv_q_a_inv_q_a_via_s_tg_fbs_b_tg_fbs_b_via_tg_s_b_tg_s_b_via_t2 r0 *1 0,0
Ra_b_inv_q_a_inv_q_a_via_s_tg_fbs_b_tg_fbs_b_via_tg_s_b_tg_s_b_via_t2
+ a\x7cb\x7cinv_q_a\x7cinv_q_a_via\x7cs\x7ctg_fbs_b\x7ctg_fbs_b_via\x7ctg_s_b\x7ctg_s_b_via__t2
+ a|b|inv_q_a|inv_q_a_via|s|tg_fbs_b|tg_fbs_b_via|tg_s_b|tg_s_b_via
+ 242.567979706
* device instance a_b_inv_q_a_inv_q_a_via_s_tg_fbs_b_tg_fbs_b_via_tg_s_b_tg_s_b_via_t3 r0 *1 0,0
Ra_b_inv_q_a_inv_q_a_via_s_tg_fbs_b_tg_fbs_b_via_tg_s_b_tg_s_b_via_t3
+ a\x7cb\x7cinv_q_a\x7cinv_q_a_via\x7cs\x7ctg_fbs_b\x7ctg_fbs_b_via\x7ctg_s_b\x7ctg_s_b_via__t3
+ a|b|inv_q_a|inv_q_a_via|s|tg_fbs_b|tg_fbs_b_via|tg_s_b|tg_s_b_via
+ 293.672426551
* device instance a_b_inv_q_a_inv_q_a_via_s_tg_fbs_b_tg_fbs_b_via_tg_s_b_tg_s_b_via_t4 r0 *1 0,0
Ra_b_inv_q_a_inv_q_a_via_s_tg_fbs_b_tg_fbs_b_via_tg_s_b_tg_s_b_via_t4
+ a\x7cb\x7cinv_q_a\x7cinv_q_a_via\x7cs\x7ctg_fbs_b\x7ctg_fbs_b_via\x7ctg_s_b\x7ctg_s_b_via__t4
+ a|b|inv_q_a|inv_q_a_via|s|tg_fbs_b|tg_fbs_b_via|tg_s_b|tg_s_b_via
+ 242.567979706
* device instance a_b_inv_q_a_inv_q_a_via_s_tg_fbs_b_tg_fbs_b_via_tg_s_b_tg_s_b_via_t5 r0 *1 0,0
Ra_b_inv_q_a_inv_q_a_via_s_tg_fbs_b_tg_fbs_b_via_tg_s_b_tg_s_b_via_t5
+ a\x7cb\x7cinv_q_a\x7cinv_q_a_via\x7cs\x7ctg_fbs_b\x7ctg_fbs_b_via\x7ctg_s_b\x7ctg_s_b_via__t5
+ a|b|inv_q_a|inv_q_a_via|s|tg_fbs_b|tg_fbs_b_via|tg_s_b|tg_s_b_via
+ 293.672426551
* device instance a_b_inv_q_a_inv_q_a_via_s_tg_fbs_b_tg_fbs_b_via_tg_s_b_tg_s_b_via r0 *1 0,0
Ca_b_inv_q_a_inv_q_a_via_s_tg_fbs_b_tg_fbs_b_via_tg_s_b_tg_s_b_via
+ a|b|inv_q_a|inv_q_a_via|s|tg_fbs_b|tg_fbs_b_via|tg_s_b|tg_s_b_via vsubs
+ 3.84792e-15
* device instance a_b_inv_q_a_inv_q_a_via_s_tg_fbs_b_tg_fbs_b_via_tg_s_b_tg_s_b_via_dup1_t0 r0 *1 0,0
Ra_b_inv_q_a_inv_q_a_via_s_tg_fbs_b_tg_fbs_b_via_tg_s_b_tg_s_b_via_dup1_t0
+ a\x7cb\x7cinv_q_a\x7cinv_q_a_via\x7cs\x7ctg_fbs_b\x7ctg_fbs_b_via\x7ctg_s_b\x7ctg_s_b_via__t02
+ a|b|inv_q_a|inv_q_a_via|s|tg_fbs_b|tg_fbs_b_via|tg_s_b|tg_s_b_via$1
+ 68.9738937426
* device instance a_b_inv_q_a_inv_q_a_via_s_tg_fbs_b_tg_fbs_b_via_tg_s_b_tg_s_b_via_dup1_t1 r0 *1 0,0
Ra_b_inv_q_a_inv_q_a_via_s_tg_fbs_b_tg_fbs_b_via_tg_s_b_tg_s_b_via_dup1_t1
+ a\x7cb\x7cinv_q_a\x7cinv_q_a_via\x7cs\x7ctg_fbs_b\x7ctg_fbs_b_via\x7ctg_s_b\x7ctg_s_b_via__t12
+ a|b|inv_q_a|inv_q_a_via|s|tg_fbs_b|tg_fbs_b_via|tg_s_b|tg_s_b_via$1
+ 68.9738937426
* device instance a_b_inv_q_a_inv_q_a_via_s_tg_fbs_b_tg_fbs_b_via_tg_s_b_tg_s_b_via_dup1_t2 r0 *1 0,0
Ra_b_inv_q_a_inv_q_a_via_s_tg_fbs_b_tg_fbs_b_via_tg_s_b_tg_s_b_via_dup1_t2
+ a\x7cb\x7cinv_q_a\x7cinv_q_a_via\x7cs\x7ctg_fbs_b\x7ctg_fbs_b_via\x7ctg_s_b\x7ctg_s_b_via__t22
+ a|b|inv_q_a|inv_q_a_via|s|tg_fbs_b|tg_fbs_b_via|tg_s_b|tg_s_b_via$1
+ 293.672426551
* device instance a_b_inv_q_a_inv_q_a_via_s_tg_fbs_b_tg_fbs_b_via_tg_s_b_tg_s_b_via_dup1_t3 r0 *1 0,0
Ra_b_inv_q_a_inv_q_a_via_s_tg_fbs_b_tg_fbs_b_via_tg_s_b_tg_s_b_via_dup1_t3
+ a\x7cb\x7cinv_q_a\x7cinv_q_a_via\x7cs\x7ctg_fbs_b\x7ctg_fbs_b_via\x7ctg_s_b\x7ctg_s_b_via__t32
+ a|b|inv_q_a|inv_q_a_via|s|tg_fbs_b|tg_fbs_b_via|tg_s_b|tg_s_b_via$1
+ 242.567979706
* device instance a_b_inv_q_a_inv_q_a_via_s_tg_fbs_b_tg_fbs_b_via_tg_s_b_tg_s_b_via_dup1_t4 r0 *1 0,0
Ra_b_inv_q_a_inv_q_a_via_s_tg_fbs_b_tg_fbs_b_via_tg_s_b_tg_s_b_via_dup1_t4
+ a\x7cb\x7cinv_q_a\x7cinv_q_a_via\x7cs\x7ctg_fbs_b\x7ctg_fbs_b_via\x7ctg_s_b\x7ctg_s_b_via__t42
+ a|b|inv_q_a|inv_q_a_via|s|tg_fbs_b|tg_fbs_b_via|tg_s_b|tg_s_b_via$1
+ 293.672426551
* device instance a_b_inv_q_a_inv_q_a_via_s_tg_fbs_b_tg_fbs_b_via_tg_s_b_tg_s_b_via_dup1_t5 r0 *1 0,0
Ra_b_inv_q_a_inv_q_a_via_s_tg_fbs_b_tg_fbs_b_via_tg_s_b_tg_s_b_via_dup1_t5
+ a\x7cb\x7cinv_q_a\x7cinv_q_a_via\x7cs\x7ctg_fbs_b\x7ctg_fbs_b_via\x7ctg_s_b\x7ctg_s_b_via__t52
+ a|b|inv_q_a|inv_q_a_via|s|tg_fbs_b|tg_fbs_b_via|tg_s_b|tg_s_b_via$1
+ 242.567979706
* device instance a_b_inv_q_a_inv_q_a_via_s_tg_fbs_b_tg_fbs_b_via_tg_s_b_tg_s_b_via_dup1 r0 *1 0,0
Ca_b_inv_q_a_inv_q_a_via_s_tg_fbs_b_tg_fbs_b_via_tg_s_b_tg_s_b_via_dup1
+ a|b|inv_q_a|inv_q_a_via|s|tg_fbs_b|tg_fbs_b_via|tg_s_b|tg_s_b_via$1 vsubs
+ 3.84792e-15
* device instance a_b_inv_q_a_inv_q_a_via_s_tg_fbs_b_tg_fbs_b_via_tg_s_b_tg_s_b_via_dup2_t0 r0 *1 0,0
Ra_b_inv_q_a_inv_q_a_via_s_tg_fbs_b_tg_fbs_b_via_tg_s_b_tg_s_b_via_dup2_t0
+ a\x7cb\x7cinv_q_a\x7cinv_q_a_via\x7cs\x7ctg_fbs_b\x7ctg_fbs_b_via\x7ctg_s_b\x7ctg_s_b_via__t03
+ a|b|inv_q_a|inv_q_a_via|s|tg_fbs_b|tg_fbs_b_via|tg_s_b|tg_s_b_via$2
+ 68.9738937426
* device instance a_b_inv_q_a_inv_q_a_via_s_tg_fbs_b_tg_fbs_b_via_tg_s_b_tg_s_b_via_dup2_t1 r0 *1 0,0
Ra_b_inv_q_a_inv_q_a_via_s_tg_fbs_b_tg_fbs_b_via_tg_s_b_tg_s_b_via_dup2_t1
+ a\x7cb\x7cinv_q_a\x7cinv_q_a_via\x7cs\x7ctg_fbs_b\x7ctg_fbs_b_via\x7ctg_s_b\x7ctg_s_b_via__t13
+ a|b|inv_q_a|inv_q_a_via|s|tg_fbs_b|tg_fbs_b_via|tg_s_b|tg_s_b_via$2
+ 68.9738937426
* device instance a_b_inv_q_a_inv_q_a_via_s_tg_fbs_b_tg_fbs_b_via_tg_s_b_tg_s_b_via_dup2_t2 r0 *1 0,0
Ra_b_inv_q_a_inv_q_a_via_s_tg_fbs_b_tg_fbs_b_via_tg_s_b_tg_s_b_via_dup2_t2
+ a\x7cb\x7cinv_q_a\x7cinv_q_a_via\x7cs\x7ctg_fbs_b\x7ctg_fbs_b_via\x7ctg_s_b\x7ctg_s_b_via__t23
+ a|b|inv_q_a|inv_q_a_via|s|tg_fbs_b|tg_fbs_b_via|tg_s_b|tg_s_b_via$2
+ 293.672426551
* device instance a_b_inv_q_a_inv_q_a_via_s_tg_fbs_b_tg_fbs_b_via_tg_s_b_tg_s_b_via_dup2_t3 r0 *1 0,0
Ra_b_inv_q_a_inv_q_a_via_s_tg_fbs_b_tg_fbs_b_via_tg_s_b_tg_s_b_via_dup2_t3
+ a\x7cb\x7cinv_q_a\x7cinv_q_a_via\x7cs\x7ctg_fbs_b\x7ctg_fbs_b_via\x7ctg_s_b\x7ctg_s_b_via__t33
+ a|b|inv_q_a|inv_q_a_via|s|tg_fbs_b|tg_fbs_b_via|tg_s_b|tg_s_b_via$2
+ 242.567979706
* device instance a_b_inv_q_a_inv_q_a_via_s_tg_fbs_b_tg_fbs_b_via_tg_s_b_tg_s_b_via_dup2_t4 r0 *1 0,0
Ra_b_inv_q_a_inv_q_a_via_s_tg_fbs_b_tg_fbs_b_via_tg_s_b_tg_s_b_via_dup2_t4
+ a\x7cb\x7cinv_q_a\x7cinv_q_a_via\x7cs\x7ctg_fbs_b\x7ctg_fbs_b_via\x7ctg_s_b\x7ctg_s_b_via__t43
+ a|b|inv_q_a|inv_q_a_via|s|tg_fbs_b|tg_fbs_b_via|tg_s_b|tg_s_b_via$2
+ 293.672426551
* device instance a_b_inv_q_a_inv_q_a_via_s_tg_fbs_b_tg_fbs_b_via_tg_s_b_tg_s_b_via_dup2_t5 r0 *1 0,0
Ra_b_inv_q_a_inv_q_a_via_s_tg_fbs_b_tg_fbs_b_via_tg_s_b_tg_s_b_via_dup2_t5
+ a\x7cb\x7cinv_q_a\x7cinv_q_a_via\x7cs\x7ctg_fbs_b\x7ctg_fbs_b_via\x7ctg_s_b\x7ctg_s_b_via__t53
+ a|b|inv_q_a|inv_q_a_via|s|tg_fbs_b|tg_fbs_b_via|tg_s_b|tg_s_b_via$2
+ 242.567979706
* device instance a_b_inv_q_a_inv_q_a_via_s_tg_fbs_b_tg_fbs_b_via_tg_s_b_tg_s_b_via_dup2 r0 *1 0,0
Ca_b_inv_q_a_inv_q_a_via_s_tg_fbs_b_tg_fbs_b_via_tg_s_b_tg_s_b_via_dup2
+ a|b|inv_q_a|inv_q_a_via|s|tg_fbs_b|tg_fbs_b_via|tg_s_b|tg_s_b_via$2 vsubs
+ 3.84792e-15
* device instance a_b_inv_q_a_inv_q_a_via_s_tg_fbs_b_tg_fbs_b_via_tg_s_b_tg_s_b_via_dup3_t0 r0 *1 0,0
Ra_b_inv_q_a_inv_q_a_via_s_tg_fbs_b_tg_fbs_b_via_tg_s_b_tg_s_b_via_dup3_t0
+ a\x7cb\x7cinv_q_a\x7cinv_q_a_via\x7cs\x7ctg_fbs_b\x7ctg_fbs_b_via\x7ctg_s_b\x7ctg_s_b_via__t04
+ a|b|inv_q_a|inv_q_a_via|s|tg_fbs_b|tg_fbs_b_via|tg_s_b|tg_s_b_via$3
+ 68.9738937426
* device instance a_b_inv_q_a_inv_q_a_via_s_tg_fbs_b_tg_fbs_b_via_tg_s_b_tg_s_b_via_dup3_t1 r0 *1 0,0
Ra_b_inv_q_a_inv_q_a_via_s_tg_fbs_b_tg_fbs_b_via_tg_s_b_tg_s_b_via_dup3_t1
+ a\x7cb\x7cinv_q_a\x7cinv_q_a_via\x7cs\x7ctg_fbs_b\x7ctg_fbs_b_via\x7ctg_s_b\x7ctg_s_b_via__t14
+ a|b|inv_q_a|inv_q_a_via|s|tg_fbs_b|tg_fbs_b_via|tg_s_b|tg_s_b_via$3
+ 68.9738937426
* device instance a_b_inv_q_a_inv_q_a_via_s_tg_fbs_b_tg_fbs_b_via_tg_s_b_tg_s_b_via_dup3_t2 r0 *1 0,0
Ra_b_inv_q_a_inv_q_a_via_s_tg_fbs_b_tg_fbs_b_via_tg_s_b_tg_s_b_via_dup3_t2
+ a\x7cb\x7cinv_q_a\x7cinv_q_a_via\x7cs\x7ctg_fbs_b\x7ctg_fbs_b_via\x7ctg_s_b\x7ctg_s_b_via__t24
+ a|b|inv_q_a|inv_q_a_via|s|tg_fbs_b|tg_fbs_b_via|tg_s_b|tg_s_b_via$3
+ 293.672426551
* device instance a_b_inv_q_a_inv_q_a_via_s_tg_fbs_b_tg_fbs_b_via_tg_s_b_tg_s_b_via_dup3_t3 r0 *1 0,0
Ra_b_inv_q_a_inv_q_a_via_s_tg_fbs_b_tg_fbs_b_via_tg_s_b_tg_s_b_via_dup3_t3
+ a\x7cb\x7cinv_q_a\x7cinv_q_a_via\x7cs\x7ctg_fbs_b\x7ctg_fbs_b_via\x7ctg_s_b\x7ctg_s_b_via__t34
+ a|b|inv_q_a|inv_q_a_via|s|tg_fbs_b|tg_fbs_b_via|tg_s_b|tg_s_b_via$3
+ 242.567979706
* device instance a_b_inv_q_a_inv_q_a_via_s_tg_fbs_b_tg_fbs_b_via_tg_s_b_tg_s_b_via_dup3_t4 r0 *1 0,0
Ra_b_inv_q_a_inv_q_a_via_s_tg_fbs_b_tg_fbs_b_via_tg_s_b_tg_s_b_via_dup3_t4
+ a\x7cb\x7cinv_q_a\x7cinv_q_a_via\x7cs\x7ctg_fbs_b\x7ctg_fbs_b_via\x7ctg_s_b\x7ctg_s_b_via__t44
+ a|b|inv_q_a|inv_q_a_via|s|tg_fbs_b|tg_fbs_b_via|tg_s_b|tg_s_b_via$3
+ 293.672426551
* device instance a_b_inv_q_a_inv_q_a_via_s_tg_fbs_b_tg_fbs_b_via_tg_s_b_tg_s_b_via_dup3_t5 r0 *1 0,0
Ra_b_inv_q_a_inv_q_a_via_s_tg_fbs_b_tg_fbs_b_via_tg_s_b_tg_s_b_via_dup3_t5
+ a\x7cb\x7cinv_q_a\x7cinv_q_a_via\x7cs\x7ctg_fbs_b\x7ctg_fbs_b_via\x7ctg_s_b\x7ctg_s_b_via__t54
+ a|b|inv_q_a|inv_q_a_via|s|tg_fbs_b|tg_fbs_b_via|tg_s_b|tg_s_b_via$3
+ 242.567979706
* device instance a_b_inv_q_a_inv_q_a_via_s_tg_fbs_b_tg_fbs_b_via_tg_s_b_tg_s_b_via_dup3 r0 *1 0,0
Ca_b_inv_q_a_inv_q_a_via_s_tg_fbs_b_tg_fbs_b_via_tg_s_b_tg_s_b_via_dup3
+ a|b|inv_q_a|inv_q_a_via|s|tg_fbs_b|tg_fbs_b_via|tg_s_b|tg_s_b_via$3 vsubs
+ 3.84792e-15
* device instance a_b_inv_q_a_inv_q_a_via_s_tg_fbs_b_tg_fbs_b_via_tg_s_b_tg_s_b_via_dup4_t0 r0 *1 0,0
Ra_b_inv_q_a_inv_q_a_via_s_tg_fbs_b_tg_fbs_b_via_tg_s_b_tg_s_b_via_dup4_t0
+ a\x7cb\x7cinv_q_a\x7cinv_q_a_via\x7cs\x7ctg_fbs_b\x7ctg_fbs_b_via\x7ctg_s_b\x7ctg_s_b_via__t05
+ a|b|inv_q_a|inv_q_a_via|s|tg_fbs_b|tg_fbs_b_via|tg_s_b|tg_s_b_via$4
+ 68.9738937426
* device instance a_b_inv_q_a_inv_q_a_via_s_tg_fbs_b_tg_fbs_b_via_tg_s_b_tg_s_b_via_dup4_t1 r0 *1 0,0
Ra_b_inv_q_a_inv_q_a_via_s_tg_fbs_b_tg_fbs_b_via_tg_s_b_tg_s_b_via_dup4_t1
+ a\x7cb\x7cinv_q_a\x7cinv_q_a_via\x7cs\x7ctg_fbs_b\x7ctg_fbs_b_via\x7ctg_s_b\x7ctg_s_b_via__t15
+ a|b|inv_q_a|inv_q_a_via|s|tg_fbs_b|tg_fbs_b_via|tg_s_b|tg_s_b_via$4
+ 68.9738937426
* device instance a_b_inv_q_a_inv_q_a_via_s_tg_fbs_b_tg_fbs_b_via_tg_s_b_tg_s_b_via_dup4_t2 r0 *1 0,0
Ra_b_inv_q_a_inv_q_a_via_s_tg_fbs_b_tg_fbs_b_via_tg_s_b_tg_s_b_via_dup4_t2
+ a\x7cb\x7cinv_q_a\x7cinv_q_a_via\x7cs\x7ctg_fbs_b\x7ctg_fbs_b_via\x7ctg_s_b\x7ctg_s_b_via__t25
+ a|b|inv_q_a|inv_q_a_via|s|tg_fbs_b|tg_fbs_b_via|tg_s_b|tg_s_b_via$4
+ 242.567979706
* device instance a_b_inv_q_a_inv_q_a_via_s_tg_fbs_b_tg_fbs_b_via_tg_s_b_tg_s_b_via_dup4_t3 r0 *1 0,0
Ra_b_inv_q_a_inv_q_a_via_s_tg_fbs_b_tg_fbs_b_via_tg_s_b_tg_s_b_via_dup4_t3
+ a\x7cb\x7cinv_q_a\x7cinv_q_a_via\x7cs\x7ctg_fbs_b\x7ctg_fbs_b_via\x7ctg_s_b\x7ctg_s_b_via__t35
+ a|b|inv_q_a|inv_q_a_via|s|tg_fbs_b|tg_fbs_b_via|tg_s_b|tg_s_b_via$4
+ 293.672426551
* device instance a_b_inv_q_a_inv_q_a_via_s_tg_fbs_b_tg_fbs_b_via_tg_s_b_tg_s_b_via_dup4_t4 r0 *1 0,0
Ra_b_inv_q_a_inv_q_a_via_s_tg_fbs_b_tg_fbs_b_via_tg_s_b_tg_s_b_via_dup4_t4
+ a\x7cb\x7cinv_q_a\x7cinv_q_a_via\x7cs\x7ctg_fbs_b\x7ctg_fbs_b_via\x7ctg_s_b\x7ctg_s_b_via__t45
+ a|b|inv_q_a|inv_q_a_via|s|tg_fbs_b|tg_fbs_b_via|tg_s_b|tg_s_b_via$4
+ 242.567979706
* device instance a_b_inv_q_a_inv_q_a_via_s_tg_fbs_b_tg_fbs_b_via_tg_s_b_tg_s_b_via_dup4_t5 r0 *1 0,0
Ra_b_inv_q_a_inv_q_a_via_s_tg_fbs_b_tg_fbs_b_via_tg_s_b_tg_s_b_via_dup4_t5
+ a\x7cb\x7cinv_q_a\x7cinv_q_a_via\x7cs\x7ctg_fbs_b\x7ctg_fbs_b_via\x7ctg_s_b\x7ctg_s_b_via__t55
+ a|b|inv_q_a|inv_q_a_via|s|tg_fbs_b|tg_fbs_b_via|tg_s_b|tg_s_b_via$4
+ 293.672426551
* device instance a_b_inv_q_a_inv_q_a_via_s_tg_fbs_b_tg_fbs_b_via_tg_s_b_tg_s_b_via_dup4 r0 *1 0,0
Ca_b_inv_q_a_inv_q_a_via_s_tg_fbs_b_tg_fbs_b_via_tg_s_b_tg_s_b_via_dup4
+ a|b|inv_q_a|inv_q_a_via|s|tg_fbs_b|tg_fbs_b_via|tg_s_b|tg_s_b_via$4 vsubs
+ 3.84792e-15
* device instance a_b_inv_q_a_inv_q_a_via_s_tg_fbs_b_tg_fbs_b_via_tg_s_b_tg_s_b_via_dup5_t0 r0 *1 0,0
Ra_b_inv_q_a_inv_q_a_via_s_tg_fbs_b_tg_fbs_b_via_tg_s_b_tg_s_b_via_dup5_t0
+ a\x7cb\x7cinv_q_a\x7cinv_q_a_via\x7cs\x7ctg_fbs_b\x7ctg_fbs_b_via\x7ctg_s_b\x7ctg_s_b_via__t06
+ a|b|inv_q_a|inv_q_a_via|s|tg_fbs_b|tg_fbs_b_via|tg_s_b|tg_s_b_via$5
+ 68.9738937426
* device instance a_b_inv_q_a_inv_q_a_via_s_tg_fbs_b_tg_fbs_b_via_tg_s_b_tg_s_b_via_dup5_t1 r0 *1 0,0
Ra_b_inv_q_a_inv_q_a_via_s_tg_fbs_b_tg_fbs_b_via_tg_s_b_tg_s_b_via_dup5_t1
+ a\x7cb\x7cinv_q_a\x7cinv_q_a_via\x7cs\x7ctg_fbs_b\x7ctg_fbs_b_via\x7ctg_s_b\x7ctg_s_b_via__t16
+ a|b|inv_q_a|inv_q_a_via|s|tg_fbs_b|tg_fbs_b_via|tg_s_b|tg_s_b_via$5
+ 68.9738937426
* device instance a_b_inv_q_a_inv_q_a_via_s_tg_fbs_b_tg_fbs_b_via_tg_s_b_tg_s_b_via_dup5_t2 r0 *1 0,0
Ra_b_inv_q_a_inv_q_a_via_s_tg_fbs_b_tg_fbs_b_via_tg_s_b_tg_s_b_via_dup5_t2
+ a\x7cb\x7cinv_q_a\x7cinv_q_a_via\x7cs\x7ctg_fbs_b\x7ctg_fbs_b_via\x7ctg_s_b\x7ctg_s_b_via__t26
+ a|b|inv_q_a|inv_q_a_via|s|tg_fbs_b|tg_fbs_b_via|tg_s_b|tg_s_b_via$5
+ 242.567979706
* device instance a_b_inv_q_a_inv_q_a_via_s_tg_fbs_b_tg_fbs_b_via_tg_s_b_tg_s_b_via_dup5_t3 r0 *1 0,0
Ra_b_inv_q_a_inv_q_a_via_s_tg_fbs_b_tg_fbs_b_via_tg_s_b_tg_s_b_via_dup5_t3
+ a\x7cb\x7cinv_q_a\x7cinv_q_a_via\x7cs\x7ctg_fbs_b\x7ctg_fbs_b_via\x7ctg_s_b\x7ctg_s_b_via__t36
+ a|b|inv_q_a|inv_q_a_via|s|tg_fbs_b|tg_fbs_b_via|tg_s_b|tg_s_b_via$5
+ 293.672426551
* device instance a_b_inv_q_a_inv_q_a_via_s_tg_fbs_b_tg_fbs_b_via_tg_s_b_tg_s_b_via_dup5_t4 r0 *1 0,0
Ra_b_inv_q_a_inv_q_a_via_s_tg_fbs_b_tg_fbs_b_via_tg_s_b_tg_s_b_via_dup5_t4
+ a\x7cb\x7cinv_q_a\x7cinv_q_a_via\x7cs\x7ctg_fbs_b\x7ctg_fbs_b_via\x7ctg_s_b\x7ctg_s_b_via__t46
+ a|b|inv_q_a|inv_q_a_via|s|tg_fbs_b|tg_fbs_b_via|tg_s_b|tg_s_b_via$5
+ 293.672426551
* device instance a_b_inv_q_a_inv_q_a_via_s_tg_fbs_b_tg_fbs_b_via_tg_s_b_tg_s_b_via_dup5_t5 r0 *1 0,0
Ra_b_inv_q_a_inv_q_a_via_s_tg_fbs_b_tg_fbs_b_via_tg_s_b_tg_s_b_via_dup5_t5
+ a\x7cb\x7cinv_q_a\x7cinv_q_a_via\x7cs\x7ctg_fbs_b\x7ctg_fbs_b_via\x7ctg_s_b\x7ctg_s_b_via__t56
+ a|b|inv_q_a|inv_q_a_via|s|tg_fbs_b|tg_fbs_b_via|tg_s_b|tg_s_b_via$5
+ 242.567979706
* device instance a_b_inv_q_a_inv_q_a_via_s_tg_fbs_b_tg_fbs_b_via_tg_s_b_tg_s_b_via_dup5 r0 *1 0,0
Ca_b_inv_q_a_inv_q_a_via_s_tg_fbs_b_tg_fbs_b_via_tg_s_b_tg_s_b_via_dup5
+ a|b|inv_q_a|inv_q_a_via|s|tg_fbs_b|tg_fbs_b_via|tg_s_b|tg_s_b_via$5 vsubs
+ 3.84792e-15
* device instance a_b_m_east_m_west_nand_m_a_nand_m_a_ext_via_nand_m_a_ext_via2_nand_m_a_stub_tg_d_b_tg_d_b_via_tg_d_b_via2_tg_fbm_b_tg_fbm_b_alt_via_tg_fbm_b_alt_via2_t0 r0 *1 0,0
Ra_b_m_east_m_west_nand_m_a_nand_m_a_ext_via_nand_m_a_ext_via2_nand_m_a_stub_tg_d_b_tg_d_b_via_tg_d_b_via2_tg_fbm_b_tg_fbm_b_alt_via_tg_fbm_b_alt_via2_t0
+ a\x7cb\x7cm_east\x7cm_west\x7cnand_m_a\x7cnand_m_a_ext_via\x7cnand_m_a_ext_via2\x7cnand_m_a_stub\x7ctg_d_b\x7ctg_d_b_via\x7ctg_d_b_via2\x7ctg_fbm_b\x7ctg_fbm_b_alt_via\x7ctg_fbm_b_alt_via2__t0
+ a|b|m_east|m_west|nand_m_a|nand_m_a_ext_via|nand_m_a_ext_via2|nand_m_a_stub|tg_d_b|tg_d_b_via|tg_d_b_via2|tg_fbm_b|tg_fbm_b_alt_via|tg_fbm_b_alt_via2
+ 64.6372259156
* device instance a_b_m_east_m_west_nand_m_a_nand_m_a_ext_via_nand_m_a_ext_via2_nand_m_a_stub_tg_d_b_tg_d_b_via_tg_d_b_via2_tg_fbm_b_tg_fbm_b_alt_via_tg_fbm_b_alt_via2_t1 r0 *1 0,0
Ra_b_m_east_m_west_nand_m_a_nand_m_a_ext_via_nand_m_a_ext_via2_nand_m_a_stub_tg_d_b_tg_d_b_via_tg_d_b_via2_tg_fbm_b_tg_fbm_b_alt_via_tg_fbm_b_alt_via2_t1
+ a\x7cb\x7cm_east\x7cm_west\x7cnand_m_a\x7cnand_m_a_ext_via\x7cnand_m_a_ext_via2\x7cnand_m_a_stub\x7ctg_d_b\x7ctg_d_b_via\x7ctg_d_b_via2\x7ctg_fbm_b\x7ctg_fbm_b_alt_via\x7ctg_fbm_b_alt_via2__t1
+ a|b|m_east|m_west|nand_m_a|nand_m_a_ext_via|nand_m_a_ext_via2|nand_m_a_stub|tg_d_b|tg_d_b_via|tg_d_b_via2|tg_fbm_b|tg_fbm_b_alt_via|tg_fbm_b_alt_via2
+ 61.22954383
* device instance a_b_m_east_m_west_nand_m_a_nand_m_a_ext_via_nand_m_a_ext_via2_nand_m_a_stub_tg_d_b_tg_d_b_via_tg_d_b_via2_tg_fbm_b_tg_fbm_b_alt_via_tg_fbm_b_alt_via2_t2 r0 *1 0,0
Ra_b_m_east_m_west_nand_m_a_nand_m_a_ext_via_nand_m_a_ext_via2_nand_m_a_stub_tg_d_b_tg_d_b_via_tg_d_b_via2_tg_fbm_b_tg_fbm_b_alt_via_tg_fbm_b_alt_via2_t2
+ a\x7cb\x7cm_east\x7cm_west\x7cnand_m_a\x7cnand_m_a_ext_via\x7cnand_m_a_ext_via2\x7cnand_m_a_stub\x7ctg_d_b\x7ctg_d_b_via\x7ctg_d_b_via2\x7ctg_fbm_b\x7ctg_fbm_b_alt_via\x7ctg_fbm_b_alt_via2__t2
+ a|b|m_east|m_west|nand_m_a|nand_m_a_ext_via|nand_m_a_ext_via2|nand_m_a_stub|tg_d_b|tg_d_b_via|tg_d_b_via2|tg_fbm_b|tg_fbm_b_alt_via|tg_fbm_b_alt_via2
+ 272.263191622
* device instance a_b_m_east_m_west_nand_m_a_nand_m_a_ext_via_nand_m_a_ext_via2_nand_m_a_stub_tg_d_b_tg_d_b_via_tg_d_b_via2_tg_fbm_b_tg_fbm_b_alt_via_tg_fbm_b_alt_via2_t3 r0 *1 0,0
Ra_b_m_east_m_west_nand_m_a_nand_m_a_ext_via_nand_m_a_ext_via2_nand_m_a_stub_tg_d_b_tg_d_b_via_tg_d_b_via2_tg_fbm_b_tg_fbm_b_alt_via_tg_fbm_b_alt_via2_t3
+ a\x7cb\x7cm_east\x7cm_west\x7cnand_m_a\x7cnand_m_a_ext_via\x7cnand_m_a_ext_via2\x7cnand_m_a_stub\x7ctg_d_b\x7ctg_d_b_via\x7ctg_d_b_via2\x7ctg_fbm_b\x7ctg_fbm_b_alt_via\x7ctg_fbm_b_alt_via2__t3
+ a|b|m_east|m_west|nand_m_a|nand_m_a_ext_via|nand_m_a_ext_via2|nand_m_a_stub|tg_d_b|tg_d_b_via|tg_d_b_via2|tg_fbm_b|tg_fbm_b_alt_via|tg_fbm_b_alt_via2
+ 306.402959413
* device instance a_b_m_east_m_west_nand_m_a_nand_m_a_ext_via_nand_m_a_ext_via2_nand_m_a_stub_tg_d_b_tg_d_b_via_tg_d_b_via2_tg_fbm_b_tg_fbm_b_alt_via_tg_fbm_b_alt_via2_t4 r0 *1 0,0
Ra_b_m_east_m_west_nand_m_a_nand_m_a_ext_via_nand_m_a_ext_via2_nand_m_a_stub_tg_d_b_tg_d_b_via_tg_d_b_via2_tg_fbm_b_tg_fbm_b_alt_via_tg_fbm_b_alt_via2_t4
+ a\x7cb\x7cm_east\x7cm_west\x7cnand_m_a\x7cnand_m_a_ext_via\x7cnand_m_a_ext_via2\x7cnand_m_a_stub\x7ctg_d_b\x7ctg_d_b_via\x7ctg_d_b_via2\x7ctg_fbm_b\x7ctg_fbm_b_alt_via\x7ctg_fbm_b_alt_via2__t4
+ a|b|m_east|m_west|nand_m_a|nand_m_a_ext_via|nand_m_a_ext_via2|nand_m_a_stub|tg_d_b|tg_d_b_via|tg_d_b_via2|tg_fbm_b|tg_fbm_b_alt_via|tg_fbm_b_alt_via2
+ 271.890414185
* device instance a_b_m_east_m_west_nand_m_a_nand_m_a_ext_via_nand_m_a_ext_via2_nand_m_a_stub_tg_d_b_tg_d_b_via_tg_d_b_via2_tg_fbm_b_tg_fbm_b_alt_via_tg_fbm_b_alt_via2_t5 r0 *1 0,0
Ra_b_m_east_m_west_nand_m_a_nand_m_a_ext_via_nand_m_a_ext_via2_nand_m_a_stub_tg_d_b_tg_d_b_via_tg_d_b_via2_tg_fbm_b_tg_fbm_b_alt_via_tg_fbm_b_alt_via2_t5
+ a\x7cb\x7cm_east\x7cm_west\x7cnand_m_a\x7cnand_m_a_ext_via\x7cnand_m_a_ext_via2\x7cnand_m_a_stub\x7ctg_d_b\x7ctg_d_b_via\x7ctg_d_b_via2\x7ctg_fbm_b\x7ctg_fbm_b_alt_via\x7ctg_fbm_b_alt_via2__t5
+ a|b|m_east|m_west|nand_m_a|nand_m_a_ext_via|nand_m_a_ext_via2|nand_m_a_stub|tg_d_b|tg_d_b_via|tg_d_b_via2|tg_fbm_b|tg_fbm_b_alt_via|tg_fbm_b_alt_via2
+ 306.071765034
* device instance a_b_m_east_m_west_nand_m_a_nand_m_a_ext_via_nand_m_a_ext_via2_nand_m_a_stub_tg_d_b_tg_d_b_via_tg_d_b_via2_tg_fbm_b_tg_fbm_b_alt_via_tg_fbm_b_alt_via2 r0 *1 0,0
Ca_b_m_east_m_west_nand_m_a_nand_m_a_ext_via_nand_m_a_ext_via2_nand_m_a_stub_tg_d_b_tg_d_b_via_tg_d_b_via2_tg_fbm_b_tg_fbm_b_alt_via_tg_fbm_b_alt_via2
+ a|b|m_east|m_west|nand_m_a|nand_m_a_ext_via|nand_m_a_ext_via2|nand_m_a_stub|tg_d_b|tg_d_b_via|tg_d_b_via2|tg_fbm_b|tg_fbm_b_alt_via|tg_fbm_b_alt_via2
+ vsubs 3.815311e-15
* device instance a_b_m_east_m_west_nand_m_a_nand_m_a_ext_via_nand_m_a_ext_via2_nand_m_a_stub_tg_d_b_tg_d_b_via_tg_d_b_via2_tg_fbm_b_tg_fbm_b_alt_via_tg_fbm_b_alt_via2_dup1_t0 r0 *1 0,0
Ra_b_m_east_m_west_nand_m_a_nand_m_a_ext_via_nand_m_a_ext_via2_nand_m_a_stub_tg_d_b_tg_d_b_via_tg_d_b_via2_tg_fbm_b_tg_fbm_b_alt_via_tg_fbm_b_alt_via2_dup1_t0
+ a\x7cb\x7cm_east\x7cm_west\x7cnand_m_a\x7cnand_m_a_ext_via\x7cnand_m_a_ext_via2\x7cnand_m_a_stub\x7ctg_d_b\x7ctg_d_b_via\x7ctg_d_b_via2\x7ctg_fbm_b\x7ctg_fbm_b_alt_via\x7ctg_fbm_b_alt_via2__t02
+ a|b|m_east|m_west|nand_m_a|nand_m_a_ext_via|nand_m_a_ext_via2|nand_m_a_stub|tg_d_b|tg_d_b_via|tg_d_b_via2|tg_fbm_b|tg_fbm_b_alt_via|tg_fbm_b_alt_via2$1
+ 61.22954383
* device instance a_b_m_east_m_west_nand_m_a_nand_m_a_ext_via_nand_m_a_ext_via2_nand_m_a_stub_tg_d_b_tg_d_b_via_tg_d_b_via2_tg_fbm_b_tg_fbm_b_alt_via_tg_fbm_b_alt_via2_dup1_t1 r0 *1 0,0
Ra_b_m_east_m_west_nand_m_a_nand_m_a_ext_via_nand_m_a_ext_via2_nand_m_a_stub_tg_d_b_tg_d_b_via_tg_d_b_via2_tg_fbm_b_tg_fbm_b_alt_via_tg_fbm_b_alt_via2_dup1_t1
+ a\x7cb\x7cm_east\x7cm_west\x7cnand_m_a\x7cnand_m_a_ext_via\x7cnand_m_a_ext_via2\x7cnand_m_a_stub\x7ctg_d_b\x7ctg_d_b_via\x7ctg_d_b_via2\x7ctg_fbm_b\x7ctg_fbm_b_alt_via\x7ctg_fbm_b_alt_via2__t12
+ a|b|m_east|m_west|nand_m_a|nand_m_a_ext_via|nand_m_a_ext_via2|nand_m_a_stub|tg_d_b|tg_d_b_via|tg_d_b_via2|tg_fbm_b|tg_fbm_b_alt_via|tg_fbm_b_alt_via2$1
+ 272.263191622
* device instance a_b_m_east_m_west_nand_m_a_nand_m_a_ext_via_nand_m_a_ext_via2_nand_m_a_stub_tg_d_b_tg_d_b_via_tg_d_b_via2_tg_fbm_b_tg_fbm_b_alt_via_tg_fbm_b_alt_via2_dup1_t2 r0 *1 0,0
Ra_b_m_east_m_west_nand_m_a_nand_m_a_ext_via_nand_m_a_ext_via2_nand_m_a_stub_tg_d_b_tg_d_b_via_tg_d_b_via2_tg_fbm_b_tg_fbm_b_alt_via_tg_fbm_b_alt_via2_dup1_t2
+ a\x7cb\x7cm_east\x7cm_west\x7cnand_m_a\x7cnand_m_a_ext_via\x7cnand_m_a_ext_via2\x7cnand_m_a_stub\x7ctg_d_b\x7ctg_d_b_via\x7ctg_d_b_via2\x7ctg_fbm_b\x7ctg_fbm_b_alt_via\x7ctg_fbm_b_alt_via2__t22
+ a|b|m_east|m_west|nand_m_a|nand_m_a_ext_via|nand_m_a_ext_via2|nand_m_a_stub|tg_d_b|tg_d_b_via|tg_d_b_via2|tg_fbm_b|tg_fbm_b_alt_via|tg_fbm_b_alt_via2$1
+ 306.402959413
* device instance a_b_m_east_m_west_nand_m_a_nand_m_a_ext_via_nand_m_a_ext_via2_nand_m_a_stub_tg_d_b_tg_d_b_via_tg_d_b_via2_tg_fbm_b_tg_fbm_b_alt_via_tg_fbm_b_alt_via2_dup1_t3 r0 *1 0,0
Ra_b_m_east_m_west_nand_m_a_nand_m_a_ext_via_nand_m_a_ext_via2_nand_m_a_stub_tg_d_b_tg_d_b_via_tg_d_b_via2_tg_fbm_b_tg_fbm_b_alt_via_tg_fbm_b_alt_via2_dup1_t3
+ a\x7cb\x7cm_east\x7cm_west\x7cnand_m_a\x7cnand_m_a_ext_via\x7cnand_m_a_ext_via2\x7cnand_m_a_stub\x7ctg_d_b\x7ctg_d_b_via\x7ctg_d_b_via2\x7ctg_fbm_b\x7ctg_fbm_b_alt_via\x7ctg_fbm_b_alt_via2__t32
+ a|b|m_east|m_west|nand_m_a|nand_m_a_ext_via|nand_m_a_ext_via2|nand_m_a_stub|tg_d_b|tg_d_b_via|tg_d_b_via2|tg_fbm_b|tg_fbm_b_alt_via|tg_fbm_b_alt_via2$1
+ 271.890414185
* device instance a_b_m_east_m_west_nand_m_a_nand_m_a_ext_via_nand_m_a_ext_via2_nand_m_a_stub_tg_d_b_tg_d_b_via_tg_d_b_via2_tg_fbm_b_tg_fbm_b_alt_via_tg_fbm_b_alt_via2_dup1_t4 r0 *1 0,0
Ra_b_m_east_m_west_nand_m_a_nand_m_a_ext_via_nand_m_a_ext_via2_nand_m_a_stub_tg_d_b_tg_d_b_via_tg_d_b_via2_tg_fbm_b_tg_fbm_b_alt_via_tg_fbm_b_alt_via2_dup1_t4
+ a\x7cb\x7cm_east\x7cm_west\x7cnand_m_a\x7cnand_m_a_ext_via\x7cnand_m_a_ext_via2\x7cnand_m_a_stub\x7ctg_d_b\x7ctg_d_b_via\x7ctg_d_b_via2\x7ctg_fbm_b\x7ctg_fbm_b_alt_via\x7ctg_fbm_b_alt_via2__t42
+ a|b|m_east|m_west|nand_m_a|nand_m_a_ext_via|nand_m_a_ext_via2|nand_m_a_stub|tg_d_b|tg_d_b_via|tg_d_b_via2|tg_fbm_b|tg_fbm_b_alt_via|tg_fbm_b_alt_via2$1
+ 306.071765034
* device instance a_b_m_east_m_west_nand_m_a_nand_m_a_ext_via_nand_m_a_ext_via2_nand_m_a_stub_tg_d_b_tg_d_b_via_tg_d_b_via2_tg_fbm_b_tg_fbm_b_alt_via_tg_fbm_b_alt_via2_dup1_t5 r0 *1 0,0
Ra_b_m_east_m_west_nand_m_a_nand_m_a_ext_via_nand_m_a_ext_via2_nand_m_a_stub_tg_d_b_tg_d_b_via_tg_d_b_via2_tg_fbm_b_tg_fbm_b_alt_via_tg_fbm_b_alt_via2_dup1_t5
+ a\x7cb\x7cm_east\x7cm_west\x7cnand_m_a\x7cnand_m_a_ext_via\x7cnand_m_a_ext_via2\x7cnand_m_a_stub\x7ctg_d_b\x7ctg_d_b_via\x7ctg_d_b_via2\x7ctg_fbm_b\x7ctg_fbm_b_alt_via\x7ctg_fbm_b_alt_via2__t52
+ a|b|m_east|m_west|nand_m_a|nand_m_a_ext_via|nand_m_a_ext_via2|nand_m_a_stub|tg_d_b|tg_d_b_via|tg_d_b_via2|tg_fbm_b|tg_fbm_b_alt_via|tg_fbm_b_alt_via2$1
+ 64.6372259156
* device instance a_b_m_east_m_west_nand_m_a_nand_m_a_ext_via_nand_m_a_ext_via2_nand_m_a_stub_tg_d_b_tg_d_b_via_tg_d_b_via2_tg_fbm_b_tg_fbm_b_alt_via_tg_fbm_b_alt_via2_dup1 r0 *1 0,0
Ca_b_m_east_m_west_nand_m_a_nand_m_a_ext_via_nand_m_a_ext_via2_nand_m_a_stub_tg_d_b_tg_d_b_via_tg_d_b_via2_tg_fbm_b_tg_fbm_b_alt_via_tg_fbm_b_alt_via2_dup1
+ a|b|m_east|m_west|nand_m_a|nand_m_a_ext_via|nand_m_a_ext_via2|nand_m_a_stub|tg_d_b|tg_d_b_via|tg_d_b_via2|tg_fbm_b|tg_fbm_b_alt_via|tg_fbm_b_alt_via2$1
+ vsubs 3.815311e-15
* device instance a_b_m_east_m_west_nand_m_a_nand_m_a_ext_via_nand_m_a_ext_via2_nand_m_a_stub_tg_d_b_tg_d_b_via_tg_d_b_via2_tg_fbm_b_tg_fbm_b_alt_via_tg_fbm_b_alt_via2_dup2_t0 r0 *1 0,0
Ra_b_m_east_m_west_nand_m_a_nand_m_a_ext_via_nand_m_a_ext_via2_nand_m_a_stub_tg_d_b_tg_d_b_via_tg_d_b_via2_tg_fbm_b_tg_fbm_b_alt_via_tg_fbm_b_alt_via2_dup2_t0
+ a\x7cb\x7cm_east\x7cm_west\x7cnand_m_a\x7cnand_m_a_ext_via\x7cnand_m_a_ext_via2\x7cnand_m_a_stub\x7ctg_d_b\x7ctg_d_b_via\x7ctg_d_b_via2\x7ctg_fbm_b\x7ctg_fbm_b_alt_via\x7ctg_fbm_b_alt_via2__t03
+ a|b|m_east|m_west|nand_m_a|nand_m_a_ext_via|nand_m_a_ext_via2|nand_m_a_stub|tg_d_b|tg_d_b_via|tg_d_b_via2|tg_fbm_b|tg_fbm_b_alt_via|tg_fbm_b_alt_via2$2
+ 61.22954383
* device instance a_b_m_east_m_west_nand_m_a_nand_m_a_ext_via_nand_m_a_ext_via2_nand_m_a_stub_tg_d_b_tg_d_b_via_tg_d_b_via2_tg_fbm_b_tg_fbm_b_alt_via_tg_fbm_b_alt_via2_dup2_t1 r0 *1 0,0
Ra_b_m_east_m_west_nand_m_a_nand_m_a_ext_via_nand_m_a_ext_via2_nand_m_a_stub_tg_d_b_tg_d_b_via_tg_d_b_via2_tg_fbm_b_tg_fbm_b_alt_via_tg_fbm_b_alt_via2_dup2_t1
+ a\x7cb\x7cm_east\x7cm_west\x7cnand_m_a\x7cnand_m_a_ext_via\x7cnand_m_a_ext_via2\x7cnand_m_a_stub\x7ctg_d_b\x7ctg_d_b_via\x7ctg_d_b_via2\x7ctg_fbm_b\x7ctg_fbm_b_alt_via\x7ctg_fbm_b_alt_via2__t13
+ a|b|m_east|m_west|nand_m_a|nand_m_a_ext_via|nand_m_a_ext_via2|nand_m_a_stub|tg_d_b|tg_d_b_via|tg_d_b_via2|tg_fbm_b|tg_fbm_b_alt_via|tg_fbm_b_alt_via2$2
+ 306.402959413
* device instance a_b_m_east_m_west_nand_m_a_nand_m_a_ext_via_nand_m_a_ext_via2_nand_m_a_stub_tg_d_b_tg_d_b_via_tg_d_b_via2_tg_fbm_b_tg_fbm_b_alt_via_tg_fbm_b_alt_via2_dup2_t2 r0 *1 0,0
Ra_b_m_east_m_west_nand_m_a_nand_m_a_ext_via_nand_m_a_ext_via2_nand_m_a_stub_tg_d_b_tg_d_b_via_tg_d_b_via2_tg_fbm_b_tg_fbm_b_alt_via_tg_fbm_b_alt_via2_dup2_t2
+ a\x7cb\x7cm_east\x7cm_west\x7cnand_m_a\x7cnand_m_a_ext_via\x7cnand_m_a_ext_via2\x7cnand_m_a_stub\x7ctg_d_b\x7ctg_d_b_via\x7ctg_d_b_via2\x7ctg_fbm_b\x7ctg_fbm_b_alt_via\x7ctg_fbm_b_alt_via2__t23
+ a|b|m_east|m_west|nand_m_a|nand_m_a_ext_via|nand_m_a_ext_via2|nand_m_a_stub|tg_d_b|tg_d_b_via|tg_d_b_via2|tg_fbm_b|tg_fbm_b_alt_via|tg_fbm_b_alt_via2$2
+ 272.263191622
* device instance a_b_m_east_m_west_nand_m_a_nand_m_a_ext_via_nand_m_a_ext_via2_nand_m_a_stub_tg_d_b_tg_d_b_via_tg_d_b_via2_tg_fbm_b_tg_fbm_b_alt_via_tg_fbm_b_alt_via2_dup2_t3 r0 *1 0,0
Ra_b_m_east_m_west_nand_m_a_nand_m_a_ext_via_nand_m_a_ext_via2_nand_m_a_stub_tg_d_b_tg_d_b_via_tg_d_b_via2_tg_fbm_b_tg_fbm_b_alt_via_tg_fbm_b_alt_via2_dup2_t3
+ a\x7cb\x7cm_east\x7cm_west\x7cnand_m_a\x7cnand_m_a_ext_via\x7cnand_m_a_ext_via2\x7cnand_m_a_stub\x7ctg_d_b\x7ctg_d_b_via\x7ctg_d_b_via2\x7ctg_fbm_b\x7ctg_fbm_b_alt_via\x7ctg_fbm_b_alt_via2__t33
+ a|b|m_east|m_west|nand_m_a|nand_m_a_ext_via|nand_m_a_ext_via2|nand_m_a_stub|tg_d_b|tg_d_b_via|tg_d_b_via2|tg_fbm_b|tg_fbm_b_alt_via|tg_fbm_b_alt_via2$2
+ 306.071765034
* device instance a_b_m_east_m_west_nand_m_a_nand_m_a_ext_via_nand_m_a_ext_via2_nand_m_a_stub_tg_d_b_tg_d_b_via_tg_d_b_via2_tg_fbm_b_tg_fbm_b_alt_via_tg_fbm_b_alt_via2_dup2_t4 r0 *1 0,0
Ra_b_m_east_m_west_nand_m_a_nand_m_a_ext_via_nand_m_a_ext_via2_nand_m_a_stub_tg_d_b_tg_d_b_via_tg_d_b_via2_tg_fbm_b_tg_fbm_b_alt_via_tg_fbm_b_alt_via2_dup2_t4
+ a\x7cb\x7cm_east\x7cm_west\x7cnand_m_a\x7cnand_m_a_ext_via\x7cnand_m_a_ext_via2\x7cnand_m_a_stub\x7ctg_d_b\x7ctg_d_b_via\x7ctg_d_b_via2\x7ctg_fbm_b\x7ctg_fbm_b_alt_via\x7ctg_fbm_b_alt_via2__t43
+ a|b|m_east|m_west|nand_m_a|nand_m_a_ext_via|nand_m_a_ext_via2|nand_m_a_stub|tg_d_b|tg_d_b_via|tg_d_b_via2|tg_fbm_b|tg_fbm_b_alt_via|tg_fbm_b_alt_via2$2
+ 271.890414185
* device instance a_b_m_east_m_west_nand_m_a_nand_m_a_ext_via_nand_m_a_ext_via2_nand_m_a_stub_tg_d_b_tg_d_b_via_tg_d_b_via2_tg_fbm_b_tg_fbm_b_alt_via_tg_fbm_b_alt_via2_dup2_t5 r0 *1 0,0
Ra_b_m_east_m_west_nand_m_a_nand_m_a_ext_via_nand_m_a_ext_via2_nand_m_a_stub_tg_d_b_tg_d_b_via_tg_d_b_via2_tg_fbm_b_tg_fbm_b_alt_via_tg_fbm_b_alt_via2_dup2_t5
+ a\x7cb\x7cm_east\x7cm_west\x7cnand_m_a\x7cnand_m_a_ext_via\x7cnand_m_a_ext_via2\x7cnand_m_a_stub\x7ctg_d_b\x7ctg_d_b_via\x7ctg_d_b_via2\x7ctg_fbm_b\x7ctg_fbm_b_alt_via\x7ctg_fbm_b_alt_via2__t53
+ a|b|m_east|m_west|nand_m_a|nand_m_a_ext_via|nand_m_a_ext_via2|nand_m_a_stub|tg_d_b|tg_d_b_via|tg_d_b_via2|tg_fbm_b|tg_fbm_b_alt_via|tg_fbm_b_alt_via2$2
+ 64.6372259156
* device instance a_b_m_east_m_west_nand_m_a_nand_m_a_ext_via_nand_m_a_ext_via2_nand_m_a_stub_tg_d_b_tg_d_b_via_tg_d_b_via2_tg_fbm_b_tg_fbm_b_alt_via_tg_fbm_b_alt_via2_dup2 r0 *1 0,0
Ca_b_m_east_m_west_nand_m_a_nand_m_a_ext_via_nand_m_a_ext_via2_nand_m_a_stub_tg_d_b_tg_d_b_via_tg_d_b_via2_tg_fbm_b_tg_fbm_b_alt_via_tg_fbm_b_alt_via2_dup2
+ a|b|m_east|m_west|nand_m_a|nand_m_a_ext_via|nand_m_a_ext_via2|nand_m_a_stub|tg_d_b|tg_d_b_via|tg_d_b_via2|tg_fbm_b|tg_fbm_b_alt_via|tg_fbm_b_alt_via2$2
+ vsubs 3.815311e-15
* device instance a_b_m_east_m_west_nand_m_a_nand_m_a_ext_via_nand_m_a_ext_via2_nand_m_a_stub_tg_d_b_tg_d_b_via_tg_d_b_via2_tg_fbm_b_tg_fbm_b_alt_via_tg_fbm_b_alt_via2_dup3_t0 r0 *1 0,0
Ra_b_m_east_m_west_nand_m_a_nand_m_a_ext_via_nand_m_a_ext_via2_nand_m_a_stub_tg_d_b_tg_d_b_via_tg_d_b_via2_tg_fbm_b_tg_fbm_b_alt_via_tg_fbm_b_alt_via2_dup3_t0
+ a\x7cb\x7cm_east\x7cm_west\x7cnand_m_a\x7cnand_m_a_ext_via\x7cnand_m_a_ext_via2\x7cnand_m_a_stub\x7ctg_d_b\x7ctg_d_b_via\x7ctg_d_b_via2\x7ctg_fbm_b\x7ctg_fbm_b_alt_via\x7ctg_fbm_b_alt_via2__t04
+ a|b|m_east|m_west|nand_m_a|nand_m_a_ext_via|nand_m_a_ext_via2|nand_m_a_stub|tg_d_b|tg_d_b_via|tg_d_b_via2|tg_fbm_b|tg_fbm_b_alt_via|tg_fbm_b_alt_via2$3
+ 61.22954383
* device instance a_b_m_east_m_west_nand_m_a_nand_m_a_ext_via_nand_m_a_ext_via2_nand_m_a_stub_tg_d_b_tg_d_b_via_tg_d_b_via2_tg_fbm_b_tg_fbm_b_alt_via_tg_fbm_b_alt_via2_dup3_t1 r0 *1 0,0
Ra_b_m_east_m_west_nand_m_a_nand_m_a_ext_via_nand_m_a_ext_via2_nand_m_a_stub_tg_d_b_tg_d_b_via_tg_d_b_via2_tg_fbm_b_tg_fbm_b_alt_via_tg_fbm_b_alt_via2_dup3_t1
+ a\x7cb\x7cm_east\x7cm_west\x7cnand_m_a\x7cnand_m_a_ext_via\x7cnand_m_a_ext_via2\x7cnand_m_a_stub\x7ctg_d_b\x7ctg_d_b_via\x7ctg_d_b_via2\x7ctg_fbm_b\x7ctg_fbm_b_alt_via\x7ctg_fbm_b_alt_via2__t14
+ a|b|m_east|m_west|nand_m_a|nand_m_a_ext_via|nand_m_a_ext_via2|nand_m_a_stub|tg_d_b|tg_d_b_via|tg_d_b_via2|tg_fbm_b|tg_fbm_b_alt_via|tg_fbm_b_alt_via2$3
+ 306.402959413
* device instance a_b_m_east_m_west_nand_m_a_nand_m_a_ext_via_nand_m_a_ext_via2_nand_m_a_stub_tg_d_b_tg_d_b_via_tg_d_b_via2_tg_fbm_b_tg_fbm_b_alt_via_tg_fbm_b_alt_via2_dup3_t2 r0 *1 0,0
Ra_b_m_east_m_west_nand_m_a_nand_m_a_ext_via_nand_m_a_ext_via2_nand_m_a_stub_tg_d_b_tg_d_b_via_tg_d_b_via2_tg_fbm_b_tg_fbm_b_alt_via_tg_fbm_b_alt_via2_dup3_t2
+ a\x7cb\x7cm_east\x7cm_west\x7cnand_m_a\x7cnand_m_a_ext_via\x7cnand_m_a_ext_via2\x7cnand_m_a_stub\x7ctg_d_b\x7ctg_d_b_via\x7ctg_d_b_via2\x7ctg_fbm_b\x7ctg_fbm_b_alt_via\x7ctg_fbm_b_alt_via2__t24
+ a|b|m_east|m_west|nand_m_a|nand_m_a_ext_via|nand_m_a_ext_via2|nand_m_a_stub|tg_d_b|tg_d_b_via|tg_d_b_via2|tg_fbm_b|tg_fbm_b_alt_via|tg_fbm_b_alt_via2$3
+ 272.263191622
* device instance a_b_m_east_m_west_nand_m_a_nand_m_a_ext_via_nand_m_a_ext_via2_nand_m_a_stub_tg_d_b_tg_d_b_via_tg_d_b_via2_tg_fbm_b_tg_fbm_b_alt_via_tg_fbm_b_alt_via2_dup3_t3 r0 *1 0,0
Ra_b_m_east_m_west_nand_m_a_nand_m_a_ext_via_nand_m_a_ext_via2_nand_m_a_stub_tg_d_b_tg_d_b_via_tg_d_b_via2_tg_fbm_b_tg_fbm_b_alt_via_tg_fbm_b_alt_via2_dup3_t3
+ a\x7cb\x7cm_east\x7cm_west\x7cnand_m_a\x7cnand_m_a_ext_via\x7cnand_m_a_ext_via2\x7cnand_m_a_stub\x7ctg_d_b\x7ctg_d_b_via\x7ctg_d_b_via2\x7ctg_fbm_b\x7ctg_fbm_b_alt_via\x7ctg_fbm_b_alt_via2__t34
+ a|b|m_east|m_west|nand_m_a|nand_m_a_ext_via|nand_m_a_ext_via2|nand_m_a_stub|tg_d_b|tg_d_b_via|tg_d_b_via2|tg_fbm_b|tg_fbm_b_alt_via|tg_fbm_b_alt_via2$3
+ 306.071765034
* device instance a_b_m_east_m_west_nand_m_a_nand_m_a_ext_via_nand_m_a_ext_via2_nand_m_a_stub_tg_d_b_tg_d_b_via_tg_d_b_via2_tg_fbm_b_tg_fbm_b_alt_via_tg_fbm_b_alt_via2_dup3_t4 r0 *1 0,0
Ra_b_m_east_m_west_nand_m_a_nand_m_a_ext_via_nand_m_a_ext_via2_nand_m_a_stub_tg_d_b_tg_d_b_via_tg_d_b_via2_tg_fbm_b_tg_fbm_b_alt_via_tg_fbm_b_alt_via2_dup3_t4
+ a\x7cb\x7cm_east\x7cm_west\x7cnand_m_a\x7cnand_m_a_ext_via\x7cnand_m_a_ext_via2\x7cnand_m_a_stub\x7ctg_d_b\x7ctg_d_b_via\x7ctg_d_b_via2\x7ctg_fbm_b\x7ctg_fbm_b_alt_via\x7ctg_fbm_b_alt_via2__t44
+ a|b|m_east|m_west|nand_m_a|nand_m_a_ext_via|nand_m_a_ext_via2|nand_m_a_stub|tg_d_b|tg_d_b_via|tg_d_b_via2|tg_fbm_b|tg_fbm_b_alt_via|tg_fbm_b_alt_via2$3
+ 271.890414185
* device instance a_b_m_east_m_west_nand_m_a_nand_m_a_ext_via_nand_m_a_ext_via2_nand_m_a_stub_tg_d_b_tg_d_b_via_tg_d_b_via2_tg_fbm_b_tg_fbm_b_alt_via_tg_fbm_b_alt_via2_dup3_t5 r0 *1 0,0
Ra_b_m_east_m_west_nand_m_a_nand_m_a_ext_via_nand_m_a_ext_via2_nand_m_a_stub_tg_d_b_tg_d_b_via_tg_d_b_via2_tg_fbm_b_tg_fbm_b_alt_via_tg_fbm_b_alt_via2_dup3_t5
+ a\x7cb\x7cm_east\x7cm_west\x7cnand_m_a\x7cnand_m_a_ext_via\x7cnand_m_a_ext_via2\x7cnand_m_a_stub\x7ctg_d_b\x7ctg_d_b_via\x7ctg_d_b_via2\x7ctg_fbm_b\x7ctg_fbm_b_alt_via\x7ctg_fbm_b_alt_via2__t54
+ a|b|m_east|m_west|nand_m_a|nand_m_a_ext_via|nand_m_a_ext_via2|nand_m_a_stub|tg_d_b|tg_d_b_via|tg_d_b_via2|tg_fbm_b|tg_fbm_b_alt_via|tg_fbm_b_alt_via2$3
+ 64.6372259156
* device instance a_b_m_east_m_west_nand_m_a_nand_m_a_ext_via_nand_m_a_ext_via2_nand_m_a_stub_tg_d_b_tg_d_b_via_tg_d_b_via2_tg_fbm_b_tg_fbm_b_alt_via_tg_fbm_b_alt_via2_dup3 r0 *1 0,0
Ca_b_m_east_m_west_nand_m_a_nand_m_a_ext_via_nand_m_a_ext_via2_nand_m_a_stub_tg_d_b_tg_d_b_via_tg_d_b_via2_tg_fbm_b_tg_fbm_b_alt_via_tg_fbm_b_alt_via2_dup3
+ a|b|m_east|m_west|nand_m_a|nand_m_a_ext_via|nand_m_a_ext_via2|nand_m_a_stub|tg_d_b|tg_d_b_via|tg_d_b_via2|tg_fbm_b|tg_fbm_b_alt_via|tg_fbm_b_alt_via2$3
+ vsubs 3.815311e-15
* device instance a_b_m_east_m_west_nand_m_a_nand_m_a_ext_via_nand_m_a_ext_via2_nand_m_a_stub_tg_d_b_tg_d_b_via_tg_d_b_via2_tg_fbm_b_tg_fbm_b_alt_via_tg_fbm_b_alt_via2_dup4_t0 r0 *1 0,0
Ra_b_m_east_m_west_nand_m_a_nand_m_a_ext_via_nand_m_a_ext_via2_nand_m_a_stub_tg_d_b_tg_d_b_via_tg_d_b_via2_tg_fbm_b_tg_fbm_b_alt_via_tg_fbm_b_alt_via2_dup4_t0
+ a\x7cb\x7cm_east\x7cm_west\x7cnand_m_a\x7cnand_m_a_ext_via\x7cnand_m_a_ext_via2\x7cnand_m_a_stub\x7ctg_d_b\x7ctg_d_b_via\x7ctg_d_b_via2\x7ctg_fbm_b\x7ctg_fbm_b_alt_via\x7ctg_fbm_b_alt_via2__t05
+ a|b|m_east|m_west|nand_m_a|nand_m_a_ext_via|nand_m_a_ext_via2|nand_m_a_stub|tg_d_b|tg_d_b_via|tg_d_b_via2|tg_fbm_b|tg_fbm_b_alt_via|tg_fbm_b_alt_via2$4
+ 61.22954383
* device instance a_b_m_east_m_west_nand_m_a_nand_m_a_ext_via_nand_m_a_ext_via2_nand_m_a_stub_tg_d_b_tg_d_b_via_tg_d_b_via2_tg_fbm_b_tg_fbm_b_alt_via_tg_fbm_b_alt_via2_dup4_t1 r0 *1 0,0
Ra_b_m_east_m_west_nand_m_a_nand_m_a_ext_via_nand_m_a_ext_via2_nand_m_a_stub_tg_d_b_tg_d_b_via_tg_d_b_via2_tg_fbm_b_tg_fbm_b_alt_via_tg_fbm_b_alt_via2_dup4_t1
+ a\x7cb\x7cm_east\x7cm_west\x7cnand_m_a\x7cnand_m_a_ext_via\x7cnand_m_a_ext_via2\x7cnand_m_a_stub\x7ctg_d_b\x7ctg_d_b_via\x7ctg_d_b_via2\x7ctg_fbm_b\x7ctg_fbm_b_alt_via\x7ctg_fbm_b_alt_via2__t15
+ a|b|m_east|m_west|nand_m_a|nand_m_a_ext_via|nand_m_a_ext_via2|nand_m_a_stub|tg_d_b|tg_d_b_via|tg_d_b_via2|tg_fbm_b|tg_fbm_b_alt_via|tg_fbm_b_alt_via2$4
+ 272.263191622
* device instance a_b_m_east_m_west_nand_m_a_nand_m_a_ext_via_nand_m_a_ext_via2_nand_m_a_stub_tg_d_b_tg_d_b_via_tg_d_b_via2_tg_fbm_b_tg_fbm_b_alt_via_tg_fbm_b_alt_via2_dup4_t2 r0 *1 0,0
Ra_b_m_east_m_west_nand_m_a_nand_m_a_ext_via_nand_m_a_ext_via2_nand_m_a_stub_tg_d_b_tg_d_b_via_tg_d_b_via2_tg_fbm_b_tg_fbm_b_alt_via_tg_fbm_b_alt_via2_dup4_t2
+ a\x7cb\x7cm_east\x7cm_west\x7cnand_m_a\x7cnand_m_a_ext_via\x7cnand_m_a_ext_via2\x7cnand_m_a_stub\x7ctg_d_b\x7ctg_d_b_via\x7ctg_d_b_via2\x7ctg_fbm_b\x7ctg_fbm_b_alt_via\x7ctg_fbm_b_alt_via2__t25
+ a|b|m_east|m_west|nand_m_a|nand_m_a_ext_via|nand_m_a_ext_via2|nand_m_a_stub|tg_d_b|tg_d_b_via|tg_d_b_via2|tg_fbm_b|tg_fbm_b_alt_via|tg_fbm_b_alt_via2$4
+ 306.402959413
* device instance a_b_m_east_m_west_nand_m_a_nand_m_a_ext_via_nand_m_a_ext_via2_nand_m_a_stub_tg_d_b_tg_d_b_via_tg_d_b_via2_tg_fbm_b_tg_fbm_b_alt_via_tg_fbm_b_alt_via2_dup4_t3 r0 *1 0,0
Ra_b_m_east_m_west_nand_m_a_nand_m_a_ext_via_nand_m_a_ext_via2_nand_m_a_stub_tg_d_b_tg_d_b_via_tg_d_b_via2_tg_fbm_b_tg_fbm_b_alt_via_tg_fbm_b_alt_via2_dup4_t3
+ a\x7cb\x7cm_east\x7cm_west\x7cnand_m_a\x7cnand_m_a_ext_via\x7cnand_m_a_ext_via2\x7cnand_m_a_stub\x7ctg_d_b\x7ctg_d_b_via\x7ctg_d_b_via2\x7ctg_fbm_b\x7ctg_fbm_b_alt_via\x7ctg_fbm_b_alt_via2__t35
+ a|b|m_east|m_west|nand_m_a|nand_m_a_ext_via|nand_m_a_ext_via2|nand_m_a_stub|tg_d_b|tg_d_b_via|tg_d_b_via2|tg_fbm_b|tg_fbm_b_alt_via|tg_fbm_b_alt_via2$4
+ 306.071765034
* device instance a_b_m_east_m_west_nand_m_a_nand_m_a_ext_via_nand_m_a_ext_via2_nand_m_a_stub_tg_d_b_tg_d_b_via_tg_d_b_via2_tg_fbm_b_tg_fbm_b_alt_via_tg_fbm_b_alt_via2_dup4_t4 r0 *1 0,0
Ra_b_m_east_m_west_nand_m_a_nand_m_a_ext_via_nand_m_a_ext_via2_nand_m_a_stub_tg_d_b_tg_d_b_via_tg_d_b_via2_tg_fbm_b_tg_fbm_b_alt_via_tg_fbm_b_alt_via2_dup4_t4
+ a\x7cb\x7cm_east\x7cm_west\x7cnand_m_a\x7cnand_m_a_ext_via\x7cnand_m_a_ext_via2\x7cnand_m_a_stub\x7ctg_d_b\x7ctg_d_b_via\x7ctg_d_b_via2\x7ctg_fbm_b\x7ctg_fbm_b_alt_via\x7ctg_fbm_b_alt_via2__t45
+ a|b|m_east|m_west|nand_m_a|nand_m_a_ext_via|nand_m_a_ext_via2|nand_m_a_stub|tg_d_b|tg_d_b_via|tg_d_b_via2|tg_fbm_b|tg_fbm_b_alt_via|tg_fbm_b_alt_via2$4
+ 271.890414185
* device instance a_b_m_east_m_west_nand_m_a_nand_m_a_ext_via_nand_m_a_ext_via2_nand_m_a_stub_tg_d_b_tg_d_b_via_tg_d_b_via2_tg_fbm_b_tg_fbm_b_alt_via_tg_fbm_b_alt_via2_dup4_t5 r0 *1 0,0
Ra_b_m_east_m_west_nand_m_a_nand_m_a_ext_via_nand_m_a_ext_via2_nand_m_a_stub_tg_d_b_tg_d_b_via_tg_d_b_via2_tg_fbm_b_tg_fbm_b_alt_via_tg_fbm_b_alt_via2_dup4_t5
+ a\x7cb\x7cm_east\x7cm_west\x7cnand_m_a\x7cnand_m_a_ext_via\x7cnand_m_a_ext_via2\x7cnand_m_a_stub\x7ctg_d_b\x7ctg_d_b_via\x7ctg_d_b_via2\x7ctg_fbm_b\x7ctg_fbm_b_alt_via\x7ctg_fbm_b_alt_via2__t55
+ a|b|m_east|m_west|nand_m_a|nand_m_a_ext_via|nand_m_a_ext_via2|nand_m_a_stub|tg_d_b|tg_d_b_via|tg_d_b_via2|tg_fbm_b|tg_fbm_b_alt_via|tg_fbm_b_alt_via2$4
+ 64.6372259156
* device instance a_b_m_east_m_west_nand_m_a_nand_m_a_ext_via_nand_m_a_ext_via2_nand_m_a_stub_tg_d_b_tg_d_b_via_tg_d_b_via2_tg_fbm_b_tg_fbm_b_alt_via_tg_fbm_b_alt_via2_dup4 r0 *1 0,0
Ca_b_m_east_m_west_nand_m_a_nand_m_a_ext_via_nand_m_a_ext_via2_nand_m_a_stub_tg_d_b_tg_d_b_via_tg_d_b_via2_tg_fbm_b_tg_fbm_b_alt_via_tg_fbm_b_alt_via2_dup4
+ a|b|m_east|m_west|nand_m_a|nand_m_a_ext_via|nand_m_a_ext_via2|nand_m_a_stub|tg_d_b|tg_d_b_via|tg_d_b_via2|tg_fbm_b|tg_fbm_b_alt_via|tg_fbm_b_alt_via2$4
+ vsubs 3.815311e-15
* device instance a_b_m_east_m_west_nand_m_a_nand_m_a_ext_via_nand_m_a_ext_via2_nand_m_a_stub_tg_d_b_tg_d_b_via_tg_d_b_via2_tg_fbm_b_tg_fbm_b_alt_via_tg_fbm_b_alt_via2_dup5_t0 r0 *1 0,0
Ra_b_m_east_m_west_nand_m_a_nand_m_a_ext_via_nand_m_a_ext_via2_nand_m_a_stub_tg_d_b_tg_d_b_via_tg_d_b_via2_tg_fbm_b_tg_fbm_b_alt_via_tg_fbm_b_alt_via2_dup5_t0
+ a\x7cb\x7cm_east\x7cm_west\x7cnand_m_a\x7cnand_m_a_ext_via\x7cnand_m_a_ext_via2\x7cnand_m_a_stub\x7ctg_d_b\x7ctg_d_b_via\x7ctg_d_b_via2\x7ctg_fbm_b\x7ctg_fbm_b_alt_via\x7ctg_fbm_b_alt_via2__t06
+ a|b|m_east|m_west|nand_m_a|nand_m_a_ext_via|nand_m_a_ext_via2|nand_m_a_stub|tg_d_b|tg_d_b_via|tg_d_b_via2|tg_fbm_b|tg_fbm_b_alt_via|tg_fbm_b_alt_via2$5
+ 61.22954383
* device instance a_b_m_east_m_west_nand_m_a_nand_m_a_ext_via_nand_m_a_ext_via2_nand_m_a_stub_tg_d_b_tg_d_b_via_tg_d_b_via2_tg_fbm_b_tg_fbm_b_alt_via_tg_fbm_b_alt_via2_dup5_t1 r0 *1 0,0
Ra_b_m_east_m_west_nand_m_a_nand_m_a_ext_via_nand_m_a_ext_via2_nand_m_a_stub_tg_d_b_tg_d_b_via_tg_d_b_via2_tg_fbm_b_tg_fbm_b_alt_via_tg_fbm_b_alt_via2_dup5_t1
+ a\x7cb\x7cm_east\x7cm_west\x7cnand_m_a\x7cnand_m_a_ext_via\x7cnand_m_a_ext_via2\x7cnand_m_a_stub\x7ctg_d_b\x7ctg_d_b_via\x7ctg_d_b_via2\x7ctg_fbm_b\x7ctg_fbm_b_alt_via\x7ctg_fbm_b_alt_via2__t16
+ a|b|m_east|m_west|nand_m_a|nand_m_a_ext_via|nand_m_a_ext_via2|nand_m_a_stub|tg_d_b|tg_d_b_via|tg_d_b_via2|tg_fbm_b|tg_fbm_b_alt_via|tg_fbm_b_alt_via2$5
+ 272.263191622
* device instance a_b_m_east_m_west_nand_m_a_nand_m_a_ext_via_nand_m_a_ext_via2_nand_m_a_stub_tg_d_b_tg_d_b_via_tg_d_b_via2_tg_fbm_b_tg_fbm_b_alt_via_tg_fbm_b_alt_via2_dup5_t2 r0 *1 0,0
Ra_b_m_east_m_west_nand_m_a_nand_m_a_ext_via_nand_m_a_ext_via2_nand_m_a_stub_tg_d_b_tg_d_b_via_tg_d_b_via2_tg_fbm_b_tg_fbm_b_alt_via_tg_fbm_b_alt_via2_dup5_t2
+ a\x7cb\x7cm_east\x7cm_west\x7cnand_m_a\x7cnand_m_a_ext_via\x7cnand_m_a_ext_via2\x7cnand_m_a_stub\x7ctg_d_b\x7ctg_d_b_via\x7ctg_d_b_via2\x7ctg_fbm_b\x7ctg_fbm_b_alt_via\x7ctg_fbm_b_alt_via2__t26
+ a|b|m_east|m_west|nand_m_a|nand_m_a_ext_via|nand_m_a_ext_via2|nand_m_a_stub|tg_d_b|tg_d_b_via|tg_d_b_via2|tg_fbm_b|tg_fbm_b_alt_via|tg_fbm_b_alt_via2$5
+ 306.402959413
* device instance a_b_m_east_m_west_nand_m_a_nand_m_a_ext_via_nand_m_a_ext_via2_nand_m_a_stub_tg_d_b_tg_d_b_via_tg_d_b_via2_tg_fbm_b_tg_fbm_b_alt_via_tg_fbm_b_alt_via2_dup5_t3 r0 *1 0,0
Ra_b_m_east_m_west_nand_m_a_nand_m_a_ext_via_nand_m_a_ext_via2_nand_m_a_stub_tg_d_b_tg_d_b_via_tg_d_b_via2_tg_fbm_b_tg_fbm_b_alt_via_tg_fbm_b_alt_via2_dup5_t3
+ a\x7cb\x7cm_east\x7cm_west\x7cnand_m_a\x7cnand_m_a_ext_via\x7cnand_m_a_ext_via2\x7cnand_m_a_stub\x7ctg_d_b\x7ctg_d_b_via\x7ctg_d_b_via2\x7ctg_fbm_b\x7ctg_fbm_b_alt_via\x7ctg_fbm_b_alt_via2__t36
+ a|b|m_east|m_west|nand_m_a|nand_m_a_ext_via|nand_m_a_ext_via2|nand_m_a_stub|tg_d_b|tg_d_b_via|tg_d_b_via2|tg_fbm_b|tg_fbm_b_alt_via|tg_fbm_b_alt_via2$5
+ 306.071765034
* device instance a_b_m_east_m_west_nand_m_a_nand_m_a_ext_via_nand_m_a_ext_via2_nand_m_a_stub_tg_d_b_tg_d_b_via_tg_d_b_via2_tg_fbm_b_tg_fbm_b_alt_via_tg_fbm_b_alt_via2_dup5_t4 r0 *1 0,0
Ra_b_m_east_m_west_nand_m_a_nand_m_a_ext_via_nand_m_a_ext_via2_nand_m_a_stub_tg_d_b_tg_d_b_via_tg_d_b_via2_tg_fbm_b_tg_fbm_b_alt_via_tg_fbm_b_alt_via2_dup5_t4
+ a\x7cb\x7cm_east\x7cm_west\x7cnand_m_a\x7cnand_m_a_ext_via\x7cnand_m_a_ext_via2\x7cnand_m_a_stub\x7ctg_d_b\x7ctg_d_b_via\x7ctg_d_b_via2\x7ctg_fbm_b\x7ctg_fbm_b_alt_via\x7ctg_fbm_b_alt_via2__t46
+ a|b|m_east|m_west|nand_m_a|nand_m_a_ext_via|nand_m_a_ext_via2|nand_m_a_stub|tg_d_b|tg_d_b_via|tg_d_b_via2|tg_fbm_b|tg_fbm_b_alt_via|tg_fbm_b_alt_via2$5
+ 271.890414185
* device instance a_b_m_east_m_west_nand_m_a_nand_m_a_ext_via_nand_m_a_ext_via2_nand_m_a_stub_tg_d_b_tg_d_b_via_tg_d_b_via2_tg_fbm_b_tg_fbm_b_alt_via_tg_fbm_b_alt_via2_dup5_t5 r0 *1 0,0
Ra_b_m_east_m_west_nand_m_a_nand_m_a_ext_via_nand_m_a_ext_via2_nand_m_a_stub_tg_d_b_tg_d_b_via_tg_d_b_via2_tg_fbm_b_tg_fbm_b_alt_via_tg_fbm_b_alt_via2_dup5_t5
+ a\x7cb\x7cm_east\x7cm_west\x7cnand_m_a\x7cnand_m_a_ext_via\x7cnand_m_a_ext_via2\x7cnand_m_a_stub\x7ctg_d_b\x7ctg_d_b_via\x7ctg_d_b_via2\x7ctg_fbm_b\x7ctg_fbm_b_alt_via\x7ctg_fbm_b_alt_via2__t56
+ a|b|m_east|m_west|nand_m_a|nand_m_a_ext_via|nand_m_a_ext_via2|nand_m_a_stub|tg_d_b|tg_d_b_via|tg_d_b_via2|tg_fbm_b|tg_fbm_b_alt_via|tg_fbm_b_alt_via2$5
+ 64.6372259156
* device instance a_b_m_east_m_west_nand_m_a_nand_m_a_ext_via_nand_m_a_ext_via2_nand_m_a_stub_tg_d_b_tg_d_b_via_tg_d_b_via2_tg_fbm_b_tg_fbm_b_alt_via_tg_fbm_b_alt_via2_dup5 r0 *1 0,0
Ca_b_m_east_m_west_nand_m_a_nand_m_a_ext_via_nand_m_a_ext_via2_nand_m_a_stub_tg_d_b_tg_d_b_via_tg_d_b_via2_tg_fbm_b_tg_fbm_b_alt_via_tg_fbm_b_alt_via2_dup5
+ a|b|m_east|m_west|nand_m_a|nand_m_a_ext_via|nand_m_a_ext_via2|nand_m_a_stub|tg_d_b|tg_d_b_via|tg_d_b_via2|tg_fbm_b|tg_fbm_b_alt_via|tg_fbm_b_alt_via2$5
+ vsubs 3.815311e-15
* device instance a_clk_ctrl_ctrlb_inv_clk_a_inv_clk_clk_via_tg_d_ctrl_tg_d_ctrl_via_tg_fbm_ctrlb_tg_fbm_ctrlb_via_tg_fbs_ctrl_tg_fbs_ctrl_via_tg_s_ctrlb_tg_s_ctrlb_via_t0 r0 *1 0,0
Ra_clk_ctrl_ctrlb_inv_clk_a_inv_clk_clk_via_tg_d_ctrl_tg_d_ctrl_via_tg_fbm_ctrlb_tg_fbm_ctrlb_via_tg_fbs_ctrl_tg_fbs_ctrl_via_tg_s_ctrlb_tg_s_ctrlb_via_t0
+ a\x7cclk\x7cctrl\x7cctrlb\x7cinv_clk_a\x7cinv_clk_clk_via\x7ctg_d_ctrl\x7ctg_d_ctrl_via\x7ctg_fbm_ctrlb\x7ctg_fbm_ctrlb_via\x7ctg_fbs_ctrl\x7ctg_fbs_ctrl_via\x7ctg_s_ctrlb\x7ctg_s_ctrlb_via__t0
+ a|clk|ctrl|ctrlb|inv_clk_a|inv_clk_clk_via|tg_d_ctrl|tg_d_ctrl_via|tg_fbm_ctrlb|tg_fbm_ctrlb_via|tg_fbs_ctrl|tg_fbs_ctrl_via|tg_s_ctrlb|tg_s_ctrlb_via
+ 527.520008989
* device instance a_clk_ctrl_ctrlb_inv_clk_a_inv_clk_clk_via_tg_d_ctrl_tg_d_ctrl_via_tg_fbm_ctrlb_tg_fbm_ctrlb_via_tg_fbs_ctrl_tg_fbs_ctrl_via_tg_s_ctrlb_tg_s_ctrlb_via_t1 r0 *1 0,0
Ra_clk_ctrl_ctrlb_inv_clk_a_inv_clk_clk_via_tg_d_ctrl_tg_d_ctrl_via_tg_fbm_ctrlb_tg_fbm_ctrlb_via_tg_fbs_ctrl_tg_fbs_ctrl_via_tg_s_ctrlb_tg_s_ctrlb_via_t1
+ a\x7cclk\x7cctrl\x7cctrlb\x7cinv_clk_a\x7cinv_clk_clk_via\x7ctg_d_ctrl\x7ctg_d_ctrl_via\x7ctg_fbm_ctrlb\x7ctg_fbm_ctrlb_via\x7ctg_fbs_ctrl\x7ctg_fbs_ctrl_via\x7ctg_s_ctrlb\x7ctg_s_ctrlb_via__t1
+ a|clk|ctrl|ctrlb|inv_clk_a|inv_clk_clk_via|tg_d_ctrl|tg_d_ctrl_via|tg_fbm_ctrlb|tg_fbm_ctrlb_via|tg_fbs_ctrl|tg_fbs_ctrl_via|tg_s_ctrlb|tg_s_ctrlb_via
+ 527.520008989
* device instance a_clk_ctrl_ctrlb_inv_clk_a_inv_clk_clk_via_tg_d_ctrl_tg_d_ctrl_via_tg_fbm_ctrlb_tg_fbm_ctrlb_via_tg_fbs_ctrl_tg_fbs_ctrl_via_tg_s_ctrlb_tg_s_ctrlb_via_t2 r0 *1 0,0
Ra_clk_ctrl_ctrlb_inv_clk_a_inv_clk_clk_via_tg_d_ctrl_tg_d_ctrl_via_tg_fbm_ctrlb_tg_fbm_ctrlb_via_tg_fbs_ctrl_tg_fbs_ctrl_via_tg_s_ctrlb_tg_s_ctrlb_via_t2
+ a\x7cclk\x7cctrl\x7cctrlb\x7cinv_clk_a\x7cinv_clk_clk_via\x7ctg_d_ctrl\x7ctg_d_ctrl_via\x7ctg_fbm_ctrlb\x7ctg_fbm_ctrlb_via\x7ctg_fbs_ctrl\x7ctg_fbs_ctrl_via\x7ctg_s_ctrlb\x7ctg_s_ctrlb_via__t2
+ a|clk|ctrl|ctrlb|inv_clk_a|inv_clk_clk_via|tg_d_ctrl|tg_d_ctrl_via|tg_fbm_ctrlb|tg_fbm_ctrlb_via|tg_fbs_ctrl|tg_fbs_ctrl_via|tg_s_ctrlb|tg_s_ctrlb_via
+ 221.085265654
* device instance a_clk_ctrl_ctrlb_inv_clk_a_inv_clk_clk_via_tg_d_ctrl_tg_d_ctrl_via_tg_fbm_ctrlb_tg_fbm_ctrlb_via_tg_fbs_ctrl_tg_fbs_ctrl_via_tg_s_ctrlb_tg_s_ctrlb_via_t3 r0 *1 0,0
Ra_clk_ctrl_ctrlb_inv_clk_a_inv_clk_clk_via_tg_d_ctrl_tg_d_ctrl_via_tg_fbm_ctrlb_tg_fbm_ctrlb_via_tg_fbs_ctrl_tg_fbs_ctrl_via_tg_s_ctrlb_tg_s_ctrlb_via_t3
+ a\x7cclk\x7cctrl\x7cctrlb\x7cinv_clk_a\x7cinv_clk_clk_via\x7ctg_d_ctrl\x7ctg_d_ctrl_via\x7ctg_fbm_ctrlb\x7ctg_fbm_ctrlb_via\x7ctg_fbs_ctrl\x7ctg_fbs_ctrl_via\x7ctg_s_ctrlb\x7ctg_s_ctrlb_via__t3
+ a|clk|ctrl|ctrlb|inv_clk_a|inv_clk_clk_via|tg_d_ctrl|tg_d_ctrl_via|tg_fbm_ctrlb|tg_fbm_ctrlb_via|tg_fbs_ctrl|tg_fbs_ctrl_via|tg_s_ctrlb|tg_s_ctrlb_via
+ 301.938185692
* device instance a_clk_ctrl_ctrlb_inv_clk_a_inv_clk_clk_via_tg_d_ctrl_tg_d_ctrl_via_tg_fbm_ctrlb_tg_fbm_ctrlb_via_tg_fbs_ctrl_tg_fbs_ctrl_via_tg_s_ctrlb_tg_s_ctrlb_via_t4 r0 *1 0,0
Ra_clk_ctrl_ctrlb_inv_clk_a_inv_clk_clk_via_tg_d_ctrl_tg_d_ctrl_via_tg_fbm_ctrlb_tg_fbm_ctrlb_via_tg_fbs_ctrl_tg_fbs_ctrl_via_tg_s_ctrlb_tg_s_ctrlb_via_t4
+ a\x7cclk\x7cctrl\x7cctrlb\x7cinv_clk_a\x7cinv_clk_clk_via\x7ctg_d_ctrl\x7ctg_d_ctrl_via\x7ctg_fbm_ctrlb\x7ctg_fbm_ctrlb_via\x7ctg_fbs_ctrl\x7ctg_fbs_ctrl_via\x7ctg_s_ctrlb\x7ctg_s_ctrlb_via__t4
+ a|clk|ctrl|ctrlb|inv_clk_a|inv_clk_clk_via|tg_d_ctrl|tg_d_ctrl_via|tg_fbm_ctrlb|tg_fbm_ctrlb_via|tg_fbs_ctrl|tg_fbs_ctrl_via|tg_s_ctrlb|tg_s_ctrlb_via
+ 132.158606992
* device instance a_clk_ctrl_ctrlb_inv_clk_a_inv_clk_clk_via_tg_d_ctrl_tg_d_ctrl_via_tg_fbm_ctrlb_tg_fbm_ctrlb_via_tg_fbs_ctrl_tg_fbs_ctrl_via_tg_s_ctrlb_tg_s_ctrlb_via_t5 r0 *1 0,0
Ra_clk_ctrl_ctrlb_inv_clk_a_inv_clk_clk_via_tg_d_ctrl_tg_d_ctrl_via_tg_fbm_ctrlb_tg_fbm_ctrlb_via_tg_fbs_ctrl_tg_fbs_ctrl_via_tg_s_ctrlb_tg_s_ctrlb_via_t5
+ a\x7cclk\x7cctrl\x7cctrlb\x7cinv_clk_a\x7cinv_clk_clk_via\x7ctg_d_ctrl\x7ctg_d_ctrl_via\x7ctg_fbm_ctrlb\x7ctg_fbm_ctrlb_via\x7ctg_fbs_ctrl\x7ctg_fbs_ctrl_via\x7ctg_s_ctrlb\x7ctg_s_ctrlb_via__t5
+ a|clk|ctrl|ctrlb|inv_clk_a|inv_clk_clk_via|tg_d_ctrl|tg_d_ctrl_via|tg_fbm_ctrlb|tg_fbm_ctrlb_via|tg_fbs_ctrl|tg_fbs_ctrl_via|tg_s_ctrlb|tg_s_ctrlb_via
+ 114.895898309
* device instance a_clk_ctrl_ctrlb_inv_clk_a_inv_clk_clk_via_tg_d_ctrl_tg_d_ctrl_via_tg_fbm_ctrlb_tg_fbm_ctrlb_via_tg_fbs_ctrl_tg_fbs_ctrl_via_tg_s_ctrlb_tg_s_ctrlb_via_t6 r0 *1 0,0
Ra_clk_ctrl_ctrlb_inv_clk_a_inv_clk_clk_via_tg_d_ctrl_tg_d_ctrl_via_tg_fbm_ctrlb_tg_fbm_ctrlb_via_tg_fbs_ctrl_tg_fbs_ctrl_via_tg_s_ctrlb_tg_s_ctrlb_via_t6
+ a\x7cclk\x7cctrl\x7cctrlb\x7cinv_clk_a\x7cinv_clk_clk_via\x7ctg_d_ctrl\x7ctg_d_ctrl_via\x7ctg_fbm_ctrlb\x7ctg_fbm_ctrlb_via\x7ctg_fbs_ctrl\x7ctg_fbs_ctrl_via\x7ctg_s_ctrlb\x7ctg_s_ctrlb_via__t6
+ a|clk|ctrl|ctrlb|inv_clk_a|inv_clk_clk_via|tg_d_ctrl|tg_d_ctrl_via|tg_fbm_ctrlb|tg_fbm_ctrlb_via|tg_fbs_ctrl|tg_fbs_ctrl_via|tg_s_ctrlb|tg_s_ctrlb_via
+ 319.215833859
* device instance a_clk_ctrl_ctrlb_inv_clk_a_inv_clk_clk_via_tg_d_ctrl_tg_d_ctrl_via_tg_fbm_ctrlb_tg_fbm_ctrlb_via_tg_fbs_ctrl_tg_fbs_ctrl_via_tg_s_ctrlb_tg_s_ctrlb_via_t7 r0 *1 0,0
Ra_clk_ctrl_ctrlb_inv_clk_a_inv_clk_clk_via_tg_d_ctrl_tg_d_ctrl_via_tg_fbm_ctrlb_tg_fbm_ctrlb_via_tg_fbs_ctrl_tg_fbs_ctrl_via_tg_s_ctrlb_tg_s_ctrlb_via_t7
+ a\x7cclk\x7cctrl\x7cctrlb\x7cinv_clk_a\x7cinv_clk_clk_via\x7ctg_d_ctrl\x7ctg_d_ctrl_via\x7ctg_fbm_ctrlb\x7ctg_fbm_ctrlb_via\x7ctg_fbs_ctrl\x7ctg_fbs_ctrl_via\x7ctg_s_ctrlb\x7ctg_s_ctrlb_via__t7
+ a|clk|ctrl|ctrlb|inv_clk_a|inv_clk_clk_via|tg_d_ctrl|tg_d_ctrl_via|tg_fbm_ctrlb|tg_fbm_ctrlb_via|tg_fbs_ctrl|tg_fbs_ctrl_via|tg_s_ctrlb|tg_s_ctrlb_via
+ 408.179295675
* device instance a_clk_ctrl_ctrlb_inv_clk_a_inv_clk_clk_via_tg_d_ctrl_tg_d_ctrl_via_tg_fbm_ctrlb_tg_fbm_ctrlb_via_tg_fbs_ctrl_tg_fbs_ctrl_via_tg_s_ctrlb_tg_s_ctrlb_via_t8 r0 *1 0,0
Ra_clk_ctrl_ctrlb_inv_clk_a_inv_clk_clk_via_tg_d_ctrl_tg_d_ctrl_via_tg_fbm_ctrlb_tg_fbm_ctrlb_via_tg_fbs_ctrl_tg_fbs_ctrl_via_tg_s_ctrlb_tg_s_ctrlb_via_t8
+ a\x7cclk\x7cctrl\x7cctrlb\x7cinv_clk_a\x7cinv_clk_clk_via\x7ctg_d_ctrl\x7ctg_d_ctrl_via\x7ctg_fbm_ctrlb\x7ctg_fbm_ctrlb_via\x7ctg_fbs_ctrl\x7ctg_fbs_ctrl_via\x7ctg_s_ctrlb\x7ctg_s_ctrlb_via__t8
+ a|clk|ctrl|ctrlb|inv_clk_a|inv_clk_clk_via|tg_d_ctrl|tg_d_ctrl_via|tg_fbm_ctrlb|tg_fbm_ctrlb_via|tg_fbs_ctrl|tg_fbs_ctrl_via|tg_s_ctrlb|tg_s_ctrlb_via
+ 489.04477517
* device instance a_clk_ctrl_ctrlb_inv_clk_a_inv_clk_clk_via_tg_d_ctrl_tg_d_ctrl_via_tg_fbm_ctrlb_tg_fbm_ctrlb_via_tg_fbs_ctrl_tg_fbs_ctrl_via_tg_s_ctrlb_tg_s_ctrlb_via_t9 r0 *1 0,0
Ra_clk_ctrl_ctrlb_inv_clk_a_inv_clk_clk_via_tg_d_ctrl_tg_d_ctrl_via_tg_fbm_ctrlb_tg_fbm_ctrlb_via_tg_fbs_ctrl_tg_fbs_ctrl_via_tg_s_ctrlb_tg_s_ctrlb_via_t9
+ a\x7cclk\x7cctrl\x7cctrlb\x7cinv_clk_a\x7cinv_clk_clk_via\x7ctg_d_ctrl\x7ctg_d_ctrl_via\x7ctg_fbm_ctrlb\x7ctg_fbm_ctrlb_via\x7ctg_fbs_ctrl\x7ctg_fbs_ctrl_via\x7ctg_s_ctrlb\x7ctg_s_ctrlb_via__t9
+ a|clk|ctrl|ctrlb|inv_clk_a|inv_clk_clk_via|tg_d_ctrl|tg_d_ctrl_via|tg_fbm_ctrlb|tg_fbm_ctrlb_via|tg_fbs_ctrl|tg_fbs_ctrl_via|tg_s_ctrlb|tg_s_ctrlb_via
+ 506.324128776
* device instance a_clk_ctrl_ctrlb_inv_clk_a_inv_clk_clk_via_tg_d_ctrl_tg_d_ctrl_via_tg_fbm_ctrlb_tg_fbm_ctrlb_via_tg_fbs_ctrl_tg_fbs_ctrl_via_tg_s_ctrlb_tg_s_ctrlb_via_t10 r0 *1 0,0
Ra_clk_ctrl_ctrlb_inv_clk_a_inv_clk_clk_via_tg_d_ctrl_tg_d_ctrl_via_tg_fbm_ctrlb_tg_fbm_ctrlb_via_tg_fbs_ctrl_tg_fbs_ctrl_via_tg_s_ctrlb_tg_s_ctrlb_via_t10
+ a\x7cclk\x7cctrl\x7cctrlb\x7cinv_clk_a\x7cinv_clk_clk_via\x7ctg_d_ctrl\x7ctg_d_ctrl_via\x7ctg_fbm_ctrlb\x7ctg_fbm_ctrlb_via\x7ctg_fbs_ctrl\x7ctg_fbs_ctrl_via\x7ctg_s_ctrlb\x7ctg_s_ctrlb_via__t10
+ a|clk|ctrl|ctrlb|inv_clk_a|inv_clk_clk_via|tg_d_ctrl|tg_d_ctrl_via|tg_fbm_ctrlb|tg_fbm_ctrlb_via|tg_fbs_ctrl|tg_fbs_ctrl_via|tg_s_ctrlb|tg_s_ctrlb_via
+ 34.3449497287
* device instance a_clk_ctrl_ctrlb_inv_clk_a_inv_clk_clk_via_tg_d_ctrl_tg_d_ctrl_via_tg_fbm_ctrlb_tg_fbm_ctrlb_via_tg_fbs_ctrl_tg_fbs_ctrl_via_tg_s_ctrlb_tg_s_ctrlb_via_t11 r0 *1 0,0
Ra_clk_ctrl_ctrlb_inv_clk_a_inv_clk_clk_via_tg_d_ctrl_tg_d_ctrl_via_tg_fbm_ctrlb_tg_fbm_ctrlb_via_tg_fbs_ctrl_tg_fbs_ctrl_via_tg_s_ctrlb_tg_s_ctrlb_via_t11
+ a\x7cclk\x7cctrl\x7cctrlb\x7cinv_clk_a\x7cinv_clk_clk_via\x7ctg_d_ctrl\x7ctg_d_ctrl_via\x7ctg_fbm_ctrlb\x7ctg_fbm_ctrlb_via\x7ctg_fbs_ctrl\x7ctg_fbs_ctrl_via\x7ctg_s_ctrlb\x7ctg_s_ctrlb_via__t11
+ a|clk|ctrl|ctrlb|inv_clk_a|inv_clk_clk_via|tg_d_ctrl|tg_d_ctrl_via|tg_fbm_ctrlb|tg_fbm_ctrlb_via|tg_fbs_ctrl|tg_fbs_ctrl_via|tg_s_ctrlb|tg_s_ctrlb_via
+ 446.653565441
* device instance a_clk_ctrl_ctrlb_inv_clk_a_inv_clk_clk_via_tg_d_ctrl_tg_d_ctrl_via_tg_fbm_ctrlb_tg_fbm_ctrlb_via_tg_fbs_ctrl_tg_fbs_ctrl_via_tg_s_ctrlb_tg_s_ctrlb_via_t12 r0 *1 0,0
Ra_clk_ctrl_ctrlb_inv_clk_a_inv_clk_clk_via_tg_d_ctrl_tg_d_ctrl_via_tg_fbm_ctrlb_tg_fbm_ctrlb_via_tg_fbs_ctrl_tg_fbs_ctrl_via_tg_s_ctrlb_tg_s_ctrlb_via_t12
+ a\x7cclk\x7cctrl\x7cctrlb\x7cinv_clk_a\x7cinv_clk_clk_via\x7ctg_d_ctrl\x7ctg_d_ctrl_via\x7ctg_fbm_ctrlb\x7ctg_fbm_ctrlb_via\x7ctg_fbs_ctrl\x7ctg_fbs_ctrl_via\x7ctg_s_ctrlb\x7ctg_s_ctrlb_via__t12
+ a|clk|ctrl|ctrlb|inv_clk_a|inv_clk_clk_via|tg_d_ctrl|tg_d_ctrl_via|tg_fbm_ctrlb|tg_fbm_ctrlb_via|tg_fbs_ctrl|tg_fbs_ctrl_via|tg_s_ctrlb|tg_s_ctrlb_via
+ 429.374528256
* device instance a_clk_ctrl_ctrlb_inv_clk_a_inv_clk_clk_via_tg_d_ctrl_tg_d_ctrl_via_tg_fbm_ctrlb_tg_fbm_ctrlb_via_tg_fbs_ctrl_tg_fbs_ctrl_via_tg_s_ctrlb_tg_s_ctrlb_via_t13 r0 *1 0,0
Ra_clk_ctrl_ctrlb_inv_clk_a_inv_clk_clk_via_tg_d_ctrl_tg_d_ctrl_via_tg_fbm_ctrlb_tg_fbm_ctrlb_via_tg_fbs_ctrl_tg_fbs_ctrl_via_tg_s_ctrlb_tg_s_ctrlb_via_t13
+ a\x7cclk\x7cctrl\x7cctrlb\x7cinv_clk_a\x7cinv_clk_clk_via\x7ctg_d_ctrl\x7ctg_d_ctrl_via\x7ctg_fbm_ctrlb\x7ctg_fbm_ctrlb_via\x7ctg_fbs_ctrl\x7ctg_fbs_ctrl_via\x7ctg_s_ctrlb\x7ctg_s_ctrlb_via__t13
+ a|clk|ctrl|ctrlb|inv_clk_a|inv_clk_clk_via|tg_d_ctrl|tg_d_ctrl_via|tg_fbm_ctrlb|tg_fbm_ctrlb_via|tg_fbs_ctrl|tg_fbs_ctrl_via|tg_s_ctrlb|tg_s_ctrlb_via
+ 340.409911972
* device instance a_clk_ctrl_ctrlb_inv_clk_a_inv_clk_clk_via_tg_d_ctrl_tg_d_ctrl_via_tg_fbm_ctrlb_tg_fbm_ctrlb_via_tg_fbs_ctrl_tg_fbs_ctrl_via_tg_s_ctrlb_tg_s_ctrlb_via_t14 r0 *1 0,0
Ra_clk_ctrl_ctrlb_inv_clk_a_inv_clk_clk_via_tg_d_ctrl_tg_d_ctrl_via_tg_fbm_ctrlb_tg_fbm_ctrlb_via_tg_fbs_ctrl_tg_fbs_ctrl_via_tg_s_ctrlb_tg_s_ctrlb_via_t14
+ a\x7cclk\x7cctrl\x7cctrlb\x7cinv_clk_a\x7cinv_clk_clk_via\x7ctg_d_ctrl\x7ctg_d_ctrl_via\x7ctg_fbm_ctrlb\x7ctg_fbm_ctrlb_via\x7ctg_fbs_ctrl\x7ctg_fbs_ctrl_via\x7ctg_s_ctrlb\x7ctg_s_ctrlb_via__t14
+ a|clk|ctrl|ctrlb|inv_clk_a|inv_clk_clk_via|tg_d_ctrl|tg_d_ctrl_via|tg_fbm_ctrlb|tg_fbm_ctrlb_via|tg_fbs_ctrl|tg_fbs_ctrl_via|tg_s_ctrlb|tg_s_ctrlb_via
+ 259.552378566
* device instance a_clk_ctrl_ctrlb_inv_clk_a_inv_clk_clk_via_tg_d_ctrl_tg_d_ctrl_via_tg_fbm_ctrlb_tg_fbm_ctrlb_via_tg_fbs_ctrl_tg_fbs_ctrl_via_tg_s_ctrlb_tg_s_ctrlb_via_t15 r0 *1 0,0
Ra_clk_ctrl_ctrlb_inv_clk_a_inv_clk_clk_via_tg_d_ctrl_tg_d_ctrl_via_tg_fbm_ctrlb_tg_fbm_ctrlb_via_tg_fbs_ctrl_tg_fbs_ctrl_via_tg_s_ctrlb_tg_s_ctrlb_via_t15
+ a\x7cclk\x7cctrl\x7cctrlb\x7cinv_clk_a\x7cinv_clk_clk_via\x7ctg_d_ctrl\x7ctg_d_ctrl_via\x7ctg_fbm_ctrlb\x7ctg_fbm_ctrlb_via\x7ctg_fbs_ctrl\x7ctg_fbs_ctrl_via\x7ctg_s_ctrlb\x7ctg_s_ctrlb_via__t15
+ a|clk|ctrl|ctrlb|inv_clk_a|inv_clk_clk_via|tg_d_ctrl|tg_d_ctrl_via|tg_fbm_ctrlb|tg_fbm_ctrlb_via|tg_fbs_ctrl|tg_fbs_ctrl_via|tg_s_ctrlb|tg_s_ctrlb_via
+ 55.3675882521
* device instance a_clk_ctrl_ctrlb_inv_clk_a_inv_clk_clk_via_tg_d_ctrl_tg_d_ctrl_via_tg_fbm_ctrlb_tg_fbm_ctrlb_via_tg_fbs_ctrl_tg_fbs_ctrl_via_tg_s_ctrlb_tg_s_ctrlb_via_t16 r0 *1 0,0
Ra_clk_ctrl_ctrlb_inv_clk_a_inv_clk_clk_via_tg_d_ctrl_tg_d_ctrl_via_tg_fbm_ctrlb_tg_fbm_ctrlb_via_tg_fbs_ctrl_tg_fbs_ctrl_via_tg_s_ctrlb_tg_s_ctrlb_via_t16
+ a\x7cclk\x7cctrl\x7cctrlb\x7cinv_clk_a\x7cinv_clk_clk_via\x7ctg_d_ctrl\x7ctg_d_ctrl_via\x7ctg_fbm_ctrlb\x7ctg_fbm_ctrlb_via\x7ctg_fbs_ctrl\x7ctg_fbs_ctrl_via\x7ctg_s_ctrlb\x7ctg_s_ctrlb_via__t16
+ a|clk|ctrl|ctrlb|inv_clk_a|inv_clk_clk_via|tg_d_ctrl|tg_d_ctrl_via|tg_fbm_ctrlb|tg_fbm_ctrlb_via|tg_fbs_ctrl|tg_fbs_ctrl_via|tg_s_ctrlb|tg_s_ctrlb_via
+ 72.5809239974
* device instance a_clk_ctrl_ctrlb_inv_clk_a_inv_clk_clk_via_tg_d_ctrl_tg_d_ctrl_via_tg_fbm_ctrlb_tg_fbm_ctrlb_via_tg_fbs_ctrl_tg_fbs_ctrl_via_tg_s_ctrlb_tg_s_ctrlb_via_t17 r0 *1 0,0
Ra_clk_ctrl_ctrlb_inv_clk_a_inv_clk_clk_via_tg_d_ctrl_tg_d_ctrl_via_tg_fbm_ctrlb_tg_fbm_ctrlb_via_tg_fbs_ctrl_tg_fbs_ctrl_via_tg_s_ctrlb_tg_s_ctrlb_via_t17
+ a\x7cclk\x7cctrl\x7cctrlb\x7cinv_clk_a\x7cinv_clk_clk_via\x7ctg_d_ctrl\x7ctg_d_ctrl_via\x7ctg_fbm_ctrlb\x7ctg_fbm_ctrlb_via\x7ctg_fbs_ctrl\x7ctg_fbs_ctrl_via\x7ctg_s_ctrlb\x7ctg_s_ctrlb_via__t17
+ a|clk|ctrl|ctrlb|inv_clk_a|inv_clk_clk_via|tg_d_ctrl|tg_d_ctrl_via|tg_fbm_ctrlb|tg_fbm_ctrlb_via|tg_fbs_ctrl|tg_fbs_ctrl_via|tg_s_ctrlb|tg_s_ctrlb_via
+ 153.339427627
* device instance a_clk_ctrl_ctrlb_inv_clk_a_inv_clk_clk_via_tg_d_ctrl_tg_d_ctrl_via_tg_fbm_ctrlb_tg_fbm_ctrlb_via_tg_fbs_ctrl_tg_fbs_ctrl_via_tg_s_ctrlb_tg_s_ctrlb_via_t18 r0 *1 0,0
Ra_clk_ctrl_ctrlb_inv_clk_a_inv_clk_clk_via_tg_d_ctrl_tg_d_ctrl_via_tg_fbm_ctrlb_tg_fbm_ctrlb_via_tg_fbs_ctrl_tg_fbs_ctrl_via_tg_s_ctrlb_tg_s_ctrlb_via_t18
+ a\x7cclk\x7cctrl\x7cctrlb\x7cinv_clk_a\x7cinv_clk_clk_via\x7ctg_d_ctrl\x7ctg_d_ctrl_via\x7ctg_fbm_ctrlb\x7ctg_fbm_ctrlb_via\x7ctg_fbs_ctrl\x7ctg_fbs_ctrl_via\x7ctg_s_ctrlb\x7ctg_s_ctrlb_via__t18
+ a|clk|ctrl|ctrlb|inv_clk_a|inv_clk_clk_via|tg_d_ctrl|tg_d_ctrl_via|tg_fbm_ctrlb|tg_fbm_ctrlb_via|tg_fbs_ctrl|tg_fbs_ctrl_via|tg_s_ctrlb|tg_s_ctrlb_via
+ 242.27621812
* device instance a_clk_ctrl_ctrlb_inv_clk_a_inv_clk_clk_via_tg_d_ctrl_tg_d_ctrl_via_tg_fbm_ctrlb_tg_fbm_ctrlb_via_tg_fbs_ctrl_tg_fbs_ctrl_via_tg_s_ctrlb_tg_s_ctrlb_via_t19 r0 *1 0,0
Ra_clk_ctrl_ctrlb_inv_clk_a_inv_clk_clk_via_tg_d_ctrl_tg_d_ctrl_via_tg_fbm_ctrlb_tg_fbm_ctrlb_via_tg_fbs_ctrl_tg_fbs_ctrl_via_tg_s_ctrlb_tg_s_ctrlb_via_t19
+ a\x7cclk\x7cctrl\x7cctrlb\x7cinv_clk_a\x7cinv_clk_clk_via\x7ctg_d_ctrl\x7ctg_d_ctrl_via\x7ctg_fbm_ctrlb\x7ctg_fbm_ctrlb_via\x7ctg_fbs_ctrl\x7ctg_fbs_ctrl_via\x7ctg_s_ctrlb\x7ctg_s_ctrlb_via__t19
+ a|clk|ctrl|ctrlb|inv_clk_a|inv_clk_clk_via|tg_d_ctrl|tg_d_ctrl_via|tg_fbm_ctrlb|tg_fbm_ctrlb_via|tg_fbs_ctrl|tg_fbs_ctrl_via|tg_s_ctrlb|tg_s_ctrlb_via
+ 571.172717425
* device instance a_clk_ctrl_ctrlb_inv_clk_a_inv_clk_clk_via_tg_d_ctrl_tg_d_ctrl_via_tg_fbm_ctrlb_tg_fbm_ctrlb_via_tg_fbs_ctrl_tg_fbs_ctrl_via_tg_s_ctrlb_tg_s_ctrlb_via_t20 r0 *1 0,0
Ra_clk_ctrl_ctrlb_inv_clk_a_inv_clk_clk_via_tg_d_ctrl_tg_d_ctrl_via_tg_fbm_ctrlb_tg_fbm_ctrlb_via_tg_fbs_ctrl_tg_fbs_ctrl_via_tg_s_ctrlb_tg_s_ctrlb_via_t20
+ a\x7cclk\x7cctrl\x7cctrlb\x7cinv_clk_a\x7cinv_clk_clk_via\x7ctg_d_ctrl\x7ctg_d_ctrl_via\x7ctg_fbm_ctrlb\x7ctg_fbm_ctrlb_via\x7ctg_fbs_ctrl\x7ctg_fbs_ctrl_via\x7ctg_s_ctrlb\x7ctg_s_ctrlb_via__t20
+ a|clk|ctrl|ctrlb|inv_clk_a|inv_clk_clk_via|tg_d_ctrl|tg_d_ctrl_via|tg_fbm_ctrlb|tg_fbm_ctrlb_via|tg_fbs_ctrl|tg_fbs_ctrl_via|tg_s_ctrlb|tg_s_ctrlb_via
+ 424.197562718
* device instance a_clk_ctrl_ctrlb_inv_clk_a_inv_clk_clk_via_tg_d_ctrl_tg_d_ctrl_via_tg_fbm_ctrlb_tg_fbm_ctrlb_via_tg_fbs_ctrl_tg_fbs_ctrl_via_tg_s_ctrlb_tg_s_ctrlb_via_t21 r0 *1 0,0
Ra_clk_ctrl_ctrlb_inv_clk_a_inv_clk_clk_via_tg_d_ctrl_tg_d_ctrl_via_tg_fbm_ctrlb_tg_fbm_ctrlb_via_tg_fbs_ctrl_tg_fbs_ctrl_via_tg_s_ctrlb_tg_s_ctrlb_via_t21
+ a\x7cclk\x7cctrl\x7cctrlb\x7cinv_clk_a\x7cinv_clk_clk_via\x7ctg_d_ctrl\x7ctg_d_ctrl_via\x7ctg_fbm_ctrlb\x7ctg_fbm_ctrlb_via\x7ctg_fbs_ctrl\x7ctg_fbs_ctrl_via\x7ctg_s_ctrlb\x7ctg_s_ctrlb_via__t21
+ a|clk|ctrl|ctrlb|inv_clk_a|inv_clk_clk_via|tg_d_ctrl|tg_d_ctrl_via|tg_fbm_ctrlb|tg_fbm_ctrlb_via|tg_fbs_ctrl|tg_fbs_ctrl_via|tg_s_ctrlb|tg_s_ctrlb_via
+ 408.179295675
* device instance a_clk_ctrl_ctrlb_inv_clk_a_inv_clk_clk_via_tg_d_ctrl_tg_d_ctrl_via_tg_fbm_ctrlb_tg_fbm_ctrlb_via_tg_fbs_ctrl_tg_fbs_ctrl_via_tg_s_ctrlb_tg_s_ctrlb_via_t22 r0 *1 0,0
Ra_clk_ctrl_ctrlb_inv_clk_a_inv_clk_clk_via_tg_d_ctrl_tg_d_ctrl_via_tg_fbm_ctrlb_tg_fbm_ctrlb_via_tg_fbs_ctrl_tg_fbs_ctrl_via_tg_s_ctrlb_tg_s_ctrlb_via_t22
+ a\x7cclk\x7cctrl\x7cctrlb\x7cinv_clk_a\x7cinv_clk_clk_via\x7ctg_d_ctrl\x7ctg_d_ctrl_via\x7ctg_fbm_ctrlb\x7ctg_fbm_ctrlb_via\x7ctg_fbs_ctrl\x7ctg_fbs_ctrl_via\x7ctg_s_ctrlb\x7ctg_s_ctrlb_via__t22
+ a|clk|ctrl|ctrlb|inv_clk_a|inv_clk_clk_via|tg_d_ctrl|tg_d_ctrl_via|tg_fbm_ctrlb|tg_fbm_ctrlb_via|tg_fbs_ctrl|tg_fbs_ctrl_via|tg_s_ctrlb|tg_s_ctrlb_via
+ 511.501225671
* device instance a_clk_ctrl_ctrlb_inv_clk_a_inv_clk_clk_via_tg_d_ctrl_tg_d_ctrl_via_tg_fbm_ctrlb_tg_fbm_ctrlb_via_tg_fbs_ctrl_tg_fbs_ctrl_via_tg_s_ctrlb_tg_s_ctrlb_via_t23 r0 *1 0,0
Ra_clk_ctrl_ctrlb_inv_clk_a_inv_clk_clk_via_tg_d_ctrl_tg_d_ctrl_via_tg_fbm_ctrlb_tg_fbm_ctrlb_via_tg_fbs_ctrl_tg_fbs_ctrl_via_tg_s_ctrlb_tg_s_ctrlb_via_t23
+ a\x7cclk\x7cctrl\x7cctrlb\x7cinv_clk_a\x7cinv_clk_clk_via\x7ctg_d_ctrl\x7ctg_d_ctrl_via\x7ctg_fbm_ctrlb\x7ctg_fbm_ctrlb_via\x7ctg_fbs_ctrl\x7ctg_fbs_ctrl_via\x7ctg_s_ctrlb\x7ctg_s_ctrlb_via__t23
+ a|clk|ctrl|ctrlb|inv_clk_a|inv_clk_clk_via|tg_d_ctrl|tg_d_ctrl_via|tg_fbm_ctrlb|tg_fbm_ctrlb_via|tg_fbs_ctrl|tg_fbs_ctrl_via|tg_s_ctrlb|tg_s_ctrlb_via
+ 364.528900114
* device instance a_clk_ctrl_ctrlb_inv_clk_a_inv_clk_clk_via_tg_d_ctrl_tg_d_ctrl_via_tg_fbm_ctrlb_tg_fbm_ctrlb_via_tg_fbs_ctrl_tg_fbs_ctrl_via_tg_s_ctrlb_tg_s_ctrlb_via_t24 r0 *1 0,0
Ra_clk_ctrl_ctrlb_inv_clk_a_inv_clk_clk_via_tg_d_ctrl_tg_d_ctrl_via_tg_fbm_ctrlb_tg_fbm_ctrlb_via_tg_fbs_ctrl_tg_fbs_ctrl_via_tg_s_ctrlb_tg_s_ctrlb_via_t24
+ a\x7cclk\x7cctrl\x7cctrlb\x7cinv_clk_a\x7cinv_clk_clk_via\x7ctg_d_ctrl\x7ctg_d_ctrl_via\x7ctg_fbm_ctrlb\x7ctg_fbm_ctrlb_via\x7ctg_fbs_ctrl\x7ctg_fbs_ctrl_via\x7ctg_s_ctrlb\x7ctg_s_ctrlb_via__t24
+ a|clk|ctrl|ctrlb|inv_clk_a|inv_clk_clk_via|tg_d_ctrl|tg_d_ctrl_via|tg_fbm_ctrlb|tg_fbm_ctrlb_via|tg_fbs_ctrl|tg_fbs_ctrl_via|tg_s_ctrlb|tg_s_ctrlb_via
+ 340.409911972
* device instance a_clk_ctrl_ctrlb_inv_clk_a_inv_clk_clk_via_tg_d_ctrl_tg_d_ctrl_via_tg_fbm_ctrlb_tg_fbm_ctrlb_via_tg_fbs_ctrl_tg_fbs_ctrl_via_tg_s_ctrlb_tg_s_ctrlb_via_t25 r0 *1 0,0
Ra_clk_ctrl_ctrlb_inv_clk_a_inv_clk_clk_via_tg_d_ctrl_tg_d_ctrl_via_tg_fbm_ctrlb_tg_fbm_ctrlb_via_tg_fbs_ctrl_tg_fbs_ctrl_via_tg_s_ctrlb_tg_s_ctrlb_via_t25
+ a\x7cclk\x7cctrl\x7cctrlb\x7cinv_clk_a\x7cinv_clk_clk_via\x7ctg_d_ctrl\x7ctg_d_ctrl_via\x7ctg_fbm_ctrlb\x7ctg_fbm_ctrlb_via\x7ctg_fbs_ctrl\x7ctg_fbs_ctrl_via\x7ctg_s_ctrlb\x7ctg_s_ctrlb_via__t25
+ a|clk|ctrl|ctrlb|inv_clk_a|inv_clk_clk_via|tg_d_ctrl|tg_d_ctrl_via|tg_fbm_ctrlb|tg_fbm_ctrlb_via|tg_fbs_ctrl|tg_fbs_ctrl_via|tg_s_ctrlb|tg_s_ctrlb_via
+ 324.392463401
* device instance a_clk_ctrl_ctrlb_inv_clk_a_inv_clk_clk_via_tg_d_ctrl_tg_d_ctrl_via_tg_fbm_ctrlb_tg_fbm_ctrlb_via_tg_fbs_ctrl_tg_fbs_ctrl_via_tg_s_ctrlb_tg_s_ctrlb_via_t26 r0 *1 0,0
Ra_clk_ctrl_ctrlb_inv_clk_a_inv_clk_clk_via_tg_d_ctrl_tg_d_ctrl_via_tg_fbm_ctrlb_tg_fbm_ctrlb_via_tg_fbs_ctrl_tg_fbs_ctrl_via_tg_s_ctrlb_tg_s_ctrlb_via_t26
+ a\x7cclk\x7cctrl\x7cctrlb\x7cinv_clk_a\x7cinv_clk_clk_via\x7ctg_d_ctrl\x7ctg_d_ctrl_via\x7ctg_fbm_ctrlb\x7ctg_fbm_ctrlb_via\x7ctg_fbs_ctrl\x7ctg_fbs_ctrl_via\x7ctg_s_ctrlb\x7ctg_s_ctrlb_via__t26
+ a|clk|ctrl|ctrlb|inv_clk_a|inv_clk_clk_via|tg_d_ctrl|tg_d_ctrl_via|tg_fbm_ctrlb|tg_fbm_ctrlb_via|tg_fbs_ctrl|tg_fbs_ctrl_via|tg_s_ctrlb|tg_s_ctrlb_via
+ 384.059676465
* device instance a_clk_ctrl_ctrlb_inv_clk_a_inv_clk_clk_via_tg_d_ctrl_tg_d_ctrl_via_tg_fbm_ctrlb_tg_fbm_ctrlb_via_tg_fbs_ctrl_tg_fbs_ctrl_via_tg_s_ctrlb_tg_s_ctrlb_via_t27 r0 *1 0,0
Ra_clk_ctrl_ctrlb_inv_clk_a_inv_clk_clk_via_tg_d_ctrl_tg_d_ctrl_via_tg_fbm_ctrlb_tg_fbm_ctrlb_via_tg_fbs_ctrl_tg_fbs_ctrl_via_tg_s_ctrlb_tg_s_ctrlb_via_t27
+ a\x7cclk\x7cctrl\x7cctrlb\x7cinv_clk_a\x7cinv_clk_clk_via\x7ctg_d_ctrl\x7ctg_d_ctrl_via\x7ctg_fbm_ctrlb\x7ctg_fbm_ctrlb_via\x7ctg_fbs_ctrl\x7ctg_fbs_ctrl_via\x7ctg_s_ctrlb\x7ctg_s_ctrlb_via__t27
+ a|clk|ctrl|ctrlb|inv_clk_a|inv_clk_clk_via|tg_d_ctrl|tg_d_ctrl_via|tg_fbm_ctrlb|tg_fbm_ctrlb_via|tg_fbs_ctrl|tg_fbs_ctrl_via|tg_s_ctrlb|tg_s_ctrlb_via
+ 34.3449497287
* device instance a_clk_ctrl_ctrlb_inv_clk_a_inv_clk_clk_via_tg_d_ctrl_tg_d_ctrl_via_tg_fbm_ctrlb_tg_fbm_ctrlb_via_tg_fbs_ctrl_tg_fbs_ctrl_via_tg_s_ctrlb_tg_s_ctrlb_via_t28 r0 *1 0,0
Ra_clk_ctrl_ctrlb_inv_clk_a_inv_clk_clk_via_tg_d_ctrl_tg_d_ctrl_via_tg_fbm_ctrlb_tg_fbm_ctrlb_via_tg_fbs_ctrl_tg_fbs_ctrl_via_tg_s_ctrlb_tg_s_ctrlb_via_t28
+ a\x7cclk\x7cctrl\x7cctrlb\x7cinv_clk_a\x7cinv_clk_clk_via\x7ctg_d_ctrl\x7ctg_d_ctrl_via\x7ctg_fbm_ctrlb\x7ctg_fbm_ctrlb_via\x7ctg_fbs_ctrl\x7ctg_fbs_ctrl_via\x7ctg_s_ctrlb\x7ctg_s_ctrlb_via__t28
+ a|clk|ctrl|ctrlb|inv_clk_a|inv_clk_clk_via|tg_d_ctrl|tg_d_ctrl_via|tg_fbm_ctrlb|tg_fbm_ctrlb_via|tg_fbs_ctrl|tg_fbs_ctrl_via|tg_s_ctrlb|tg_s_ctrlb_via
+ 137.331570921
* device instance a_clk_ctrl_ctrlb_inv_clk_a_inv_clk_clk_via_tg_d_ctrl_tg_d_ctrl_via_tg_fbm_ctrlb_tg_fbm_ctrlb_via_tg_fbs_ctrl_tg_fbs_ctrl_via_tg_s_ctrlb_tg_s_ctrlb_via_t29 r0 *1 0,0
Ra_clk_ctrl_ctrlb_inv_clk_a_inv_clk_clk_via_tg_d_ctrl_tg_d_ctrl_via_tg_fbm_ctrlb_tg_fbm_ctrlb_via_tg_fbs_ctrl_tg_fbs_ctrl_via_tg_s_ctrlb_tg_s_ctrlb_via_t29
+ a\x7cclk\x7cctrl\x7cctrlb\x7cinv_clk_a\x7cinv_clk_clk_via\x7ctg_d_ctrl\x7ctg_d_ctrl_via\x7ctg_fbm_ctrlb\x7ctg_fbm_ctrlb_via\x7ctg_fbs_ctrl\x7ctg_fbs_ctrl_via\x7ctg_s_ctrlb\x7ctg_s_ctrlb_via__t29
+ a|clk|ctrl|ctrlb|inv_clk_a|inv_clk_clk_via|tg_d_ctrl|tg_d_ctrl_via|tg_fbm_ctrlb|tg_fbm_ctrlb_via|tg_fbs_ctrl|tg_fbs_ctrl_via|tg_s_ctrlb|tg_s_ctrlb_via
+ 153.339427627
* device instance a_clk_ctrl_ctrlb_inv_clk_a_inv_clk_clk_via_tg_d_ctrl_tg_d_ctrl_via_tg_fbm_ctrlb_tg_fbm_ctrlb_via_tg_fbs_ctrl_tg_fbs_ctrl_via_tg_s_ctrlb_tg_s_ctrlb_via_t30 r0 *1 0,0
Ra_clk_ctrl_ctrlb_inv_clk_a_inv_clk_clk_via_tg_d_ctrl_tg_d_ctrl_via_tg_fbm_ctrlb_tg_fbm_ctrlb_via_tg_fbs_ctrl_tg_fbs_ctrl_via_tg_s_ctrlb_tg_s_ctrlb_via_t30
+ a\x7cclk\x7cctrl\x7cctrlb\x7cinv_clk_a\x7cinv_clk_clk_via\x7ctg_d_ctrl\x7ctg_d_ctrl_via\x7ctg_fbm_ctrlb\x7ctg_fbm_ctrlb_via\x7ctg_fbs_ctrl\x7ctg_fbs_ctrl_via\x7ctg_s_ctrlb\x7ctg_s_ctrlb_via__t30
+ a|clk|ctrl|ctrlb|inv_clk_a|inv_clk_clk_via|tg_d_ctrl|tg_d_ctrl_via|tg_fbm_ctrlb|tg_fbm_ctrlb_via|tg_fbs_ctrl|tg_fbs_ctrl_via|tg_s_ctrlb|tg_s_ctrlb_via
+ 177.447633456
* device instance a_clk_ctrl_ctrlb_inv_clk_a_inv_clk_clk_via_tg_d_ctrl_tg_d_ctrl_via_tg_fbm_ctrlb_tg_fbm_ctrlb_via_tg_fbs_ctrl_tg_fbs_ctrl_via_tg_s_ctrlb_tg_s_ctrlb_via_t31 r0 *1 0,0
Ra_clk_ctrl_ctrlb_inv_clk_a_inv_clk_clk_via_tg_d_ctrl_tg_d_ctrl_via_tg_fbm_ctrlb_tg_fbm_ctrlb_via_tg_fbs_ctrl_tg_fbs_ctrl_via_tg_s_ctrlb_tg_s_ctrlb_via_t31
+ a\x7cclk\x7cctrl\x7cctrlb\x7cinv_clk_a\x7cinv_clk_clk_via\x7ctg_d_ctrl\x7ctg_d_ctrl_via\x7ctg_fbm_ctrlb\x7ctg_fbm_ctrlb_via\x7ctg_fbs_ctrl\x7ctg_fbs_ctrl_via\x7ctg_s_ctrlb\x7ctg_s_ctrlb_via__t31
+ a|clk|ctrl|ctrlb|inv_clk_a|inv_clk_clk_via|tg_d_ctrl|tg_d_ctrl_via|tg_fbm_ctrlb|tg_fbm_ctrlb_via|tg_fbs_ctrl|tg_fbs_ctrl_via|tg_s_ctrlb|tg_s_ctrlb_via
+ 237.100213673
* device instance a_clk_ctrl_ctrlb_inv_clk_a_inv_clk_clk_via_tg_d_ctrl_tg_d_ctrl_via_tg_fbm_ctrlb_tg_fbm_ctrlb_via_tg_fbs_ctrl_tg_fbs_ctrl_via_tg_s_ctrlb_tg_s_ctrlb_via_t32 r0 *1 0,0
Ra_clk_ctrl_ctrlb_inv_clk_a_inv_clk_clk_via_tg_d_ctrl_tg_d_ctrl_via_tg_fbm_ctrlb_tg_fbm_ctrlb_via_tg_fbs_ctrl_tg_fbs_ctrl_via_tg_s_ctrlb_tg_s_ctrlb_via_t32
+ a\x7cclk\x7cctrl\x7cctrlb\x7cinv_clk_a\x7cinv_clk_clk_via\x7ctg_d_ctrl\x7ctg_d_ctrl_via\x7ctg_fbm_ctrlb\x7ctg_fbm_ctrlb_via\x7ctg_fbs_ctrl\x7ctg_fbs_ctrl_via\x7ctg_s_ctrlb\x7ctg_s_ctrlb_via__t32
+ a|clk|ctrl|ctrlb|inv_clk_a|inv_clk_clk_via|tg_d_ctrl|tg_d_ctrl_via|tg_fbm_ctrlb|tg_fbm_ctrlb_via|tg_fbs_ctrl|tg_fbs_ctrl_via|tg_s_ctrlb|tg_s_ctrlb_via
+ 221.085265654
* device instance a_clk_ctrl_ctrlb_inv_clk_a_inv_clk_clk_via_tg_d_ctrl_tg_d_ctrl_via_tg_fbm_ctrlb_tg_fbm_ctrlb_via_tg_fbs_ctrl_tg_fbs_ctrl_via_tg_s_ctrlb_tg_s_ctrlb_via_t33 r0 *1 0,0
Ra_clk_ctrl_ctrlb_inv_clk_a_inv_clk_clk_via_tg_d_ctrl_tg_d_ctrl_via_tg_fbm_ctrlb_tg_fbm_ctrlb_via_tg_fbs_ctrl_tg_fbs_ctrl_via_tg_s_ctrlb_tg_s_ctrlb_via_t33
+ a\x7cclk\x7cctrl\x7cctrlb\x7cinv_clk_a\x7cinv_clk_clk_via\x7ctg_d_ctrl\x7ctg_d_ctrl_via\x7ctg_fbm_ctrlb\x7ctg_fbm_ctrlb_via\x7ctg_fbs_ctrl\x7ctg_fbs_ctrl_via\x7ctg_s_ctrlb\x7ctg_s_ctrlb_via__t33
+ a|clk|ctrl|ctrlb|inv_clk_a|inv_clk_clk_via|tg_d_ctrl|tg_d_ctrl_via|tg_fbm_ctrlb|tg_fbm_ctrlb_via|tg_fbs_ctrl|tg_fbs_ctrl_via|tg_s_ctrlb|tg_s_ctrlb_via
+ 196.971877823
* device instance a_clk_ctrl_ctrlb_inv_clk_a_inv_clk_clk_via_tg_d_ctrl_tg_d_ctrl_via_tg_fbm_ctrlb_tg_fbm_ctrlb_via_tg_fbs_ctrl_tg_fbs_ctrl_via_tg_s_ctrlb_tg_s_ctrlb_via_t34 r0 *1 0,0
Ra_clk_ctrl_ctrlb_inv_clk_a_inv_clk_clk_via_tg_d_ctrl_tg_d_ctrl_via_tg_fbm_ctrlb_tg_fbm_ctrlb_via_tg_fbs_ctrl_tg_fbs_ctrl_via_tg_s_ctrlb_tg_s_ctrlb_via_t34
+ a\x7cclk\x7cctrl\x7cctrlb\x7cinv_clk_a\x7cinv_clk_clk_via\x7ctg_d_ctrl\x7ctg_d_ctrl_via\x7ctg_fbm_ctrlb\x7ctg_fbm_ctrlb_via\x7ctg_fbs_ctrl\x7ctg_fbs_ctrl_via\x7ctg_s_ctrlb\x7ctg_s_ctrlb_via__t34
+ a|clk|ctrl|ctrlb|inv_clk_a|inv_clk_clk_via|tg_d_ctrl|tg_d_ctrl_via|tg_fbm_ctrlb|tg_fbm_ctrlb_via|tg_fbs_ctrl|tg_fbs_ctrl_via|tg_s_ctrlb|tg_s_ctrlb_via
+ 11.2485479351
* device instance a_clk_ctrl_ctrlb_inv_clk_a_inv_clk_clk_via_tg_d_ctrl_tg_d_ctrl_via_tg_fbm_ctrlb_tg_fbm_ctrlb_via_tg_fbs_ctrl_tg_fbs_ctrl_via_tg_s_ctrlb_tg_s_ctrlb_via_t35 r0 *1 0,0
Ra_clk_ctrl_ctrlb_inv_clk_a_inv_clk_clk_via_tg_d_ctrl_tg_d_ctrl_via_tg_fbm_ctrlb_tg_fbm_ctrlb_via_tg_fbs_ctrl_tg_fbs_ctrl_via_tg_s_ctrlb_tg_s_ctrlb_via_t35
+ a\x7cclk\x7cctrl\x7cctrlb\x7cinv_clk_a\x7cinv_clk_clk_via\x7ctg_d_ctrl\x7ctg_d_ctrl_via\x7ctg_fbm_ctrlb\x7ctg_fbm_ctrlb_via\x7ctg_fbs_ctrl\x7ctg_fbs_ctrl_via\x7ctg_s_ctrlb\x7ctg_s_ctrlb_via__t35
+ a|clk|ctrl|ctrlb|inv_clk_a|inv_clk_clk_via|tg_d_ctrl|tg_d_ctrl_via|tg_fbm_ctrlb|tg_fbm_ctrlb_via|tg_fbs_ctrl|tg_fbs_ctrl_via|tg_s_ctrlb|tg_s_ctrlb_via
+ 50.2192596757
* device instance a_clk_ctrl_ctrlb_inv_clk_a_inv_clk_clk_via_tg_d_ctrl_tg_d_ctrl_via_tg_fbm_ctrlb_tg_fbm_ctrlb_via_tg_fbs_ctrl_tg_fbs_ctrl_via_tg_s_ctrlb_tg_s_ctrlb_via r0 *1 0,0
Ca_clk_ctrl_ctrlb_inv_clk_a_inv_clk_clk_via_tg_d_ctrl_tg_d_ctrl_via_tg_fbm_ctrlb_tg_fbm_ctrlb_via_tg_fbs_ctrl_tg_fbs_ctrl_via_tg_s_ctrlb_tg_s_ctrlb_via
+ a|clk|ctrl|ctrlb|inv_clk_a|inv_clk_clk_via|tg_d_ctrl|tg_d_ctrl_via|tg_fbm_ctrlb|tg_fbm_ctrlb_via|tg_fbs_ctrl|tg_fbs_ctrl_via|tg_s_ctrlb|tg_s_ctrlb_via
+ vsubs 4.5960391e-14
* device instance a_d_inv_clk_vdd_inv_mc_vdd_inv_q_vdd_mpa_py_mpb_py_nand_m_vdd_nand_s2_vdd_nwell_vdd_sb_vdd_sr1_vdd_sr2_vdd_sr3_vdd_sr4_vdd_sv_d_vdd_tie_sv_vdd_tg_d_a_tg_d_vdd_tg_fbm_vdd_tg_fbs_vdd_tg_s_vdd_vdd_vdd_b1_vdd_b2_vdd_b3_vdd_b4_vdd_link_vdd_link_dip_vdd_x1_vdd_x2_vdd_x3_t0 r0 *1 0,0
Ra_d_inv_clk_vdd_inv_mc_vdd_inv_q_vdd_mpa_py_mpb_py_nand_m_vdd_nand_s2_vdd_nwell_vdd_sb_vdd_sr1_vdd_sr2_vdd_sr3_vdd_sr4_vdd_sv_d_vdd_tie_sv_vdd_tg_d_a_tg_d_vdd_tg_fbm_vdd_tg_fbs_vdd_tg_s_vdd_vdd_vdd_b1_vdd_b2_vdd_b3_vdd_b4_vdd_link_vdd_link_dip_vdd_x1_vdd_x2_vdd_x3_t0
+ a\x7cd\x7cinv_clk_vdd\x7cinv_mc_vdd\x7cinv_q_vdd\x7cmpa_py\x7cmpb_py\x7cnand_m_vdd\x7cnand_s2_vdd\x7cnwell_vdd\x7csb_vdd\x7csr1_vdd\x7csr2_vdd\x7csr3_vdd\x7csr4_vdd\x7csv_d_vdd_tie\x7csv_vdd\x7ctg_d_a\x7ctg_d_vdd\x7ctg_fbm_vdd\x7ctg_fbs_vdd\x7ctg_s_vdd\x7cvdd\x7cvdd_b1\x7cvdd_b2\x7cvdd_b3\x7cvdd_b4\x7cvdd_link\x7cvdd_link_dip\x7cvdd_x1\x7cvdd_x2\x7cvdd_x3__t0
+ a|d|inv_clk_vdd|inv_mc_vdd|inv_q_vdd|mpa_py|mpb_py|nand_m_vdd|nand_s2_vdd|nwell_vdd|sb_vdd|sr1_vdd|sr2_vdd|sr3_vdd|sr4_vdd|sv_d_vdd_tie|sv_vdd|tg_d_a|tg_d_vdd|tg_fbm_vdd|tg_fbs_vdd|tg_s_vdd|vdd|vdd_b1|vdd_b2|vdd_b3|vdd_b4|vdd_link|vdd_link_dip|vdd_x1|vdd_x2|vdd_x3
+ 216.604437092
* device instance a_d_inv_clk_vdd_inv_mc_vdd_inv_q_vdd_mpa_py_mpb_py_nand_m_vdd_nand_s2_vdd_nwell_vdd_sb_vdd_sr1_vdd_sr2_vdd_sr3_vdd_sr4_vdd_sv_d_vdd_tie_sv_vdd_tg_d_a_tg_d_vdd_tg_fbm_vdd_tg_fbs_vdd_tg_s_vdd_vdd_vdd_b1_vdd_b2_vdd_b3_vdd_b4_vdd_link_vdd_link_dip_vdd_x1_vdd_x2_vdd_x3_t1 r0 *1 0,0
Ra_d_inv_clk_vdd_inv_mc_vdd_inv_q_vdd_mpa_py_mpb_py_nand_m_vdd_nand_s2_vdd_nwell_vdd_sb_vdd_sr1_vdd_sr2_vdd_sr3_vdd_sr4_vdd_sv_d_vdd_tie_sv_vdd_tg_d_a_tg_d_vdd_tg_fbm_vdd_tg_fbs_vdd_tg_s_vdd_vdd_vdd_b1_vdd_b2_vdd_b3_vdd_b4_vdd_link_vdd_link_dip_vdd_x1_vdd_x2_vdd_x3_t1
+ a\x7cd\x7cinv_clk_vdd\x7cinv_mc_vdd\x7cinv_q_vdd\x7cmpa_py\x7cmpb_py\x7cnand_m_vdd\x7cnand_s2_vdd\x7cnwell_vdd\x7csb_vdd\x7csr1_vdd\x7csr2_vdd\x7csr3_vdd\x7csr4_vdd\x7csv_d_vdd_tie\x7csv_vdd\x7ctg_d_a\x7ctg_d_vdd\x7ctg_fbm_vdd\x7ctg_fbs_vdd\x7ctg_s_vdd\x7cvdd\x7cvdd_b1\x7cvdd_b2\x7cvdd_b3\x7cvdd_b4\x7cvdd_link\x7cvdd_link_dip\x7cvdd_x1\x7cvdd_x2\x7cvdd_x3__t1
+ a|d|inv_clk_vdd|inv_mc_vdd|inv_q_vdd|mpa_py|mpb_py|nand_m_vdd|nand_s2_vdd|nwell_vdd|sb_vdd|sr1_vdd|sr2_vdd|sr3_vdd|sr4_vdd|sv_d_vdd_tie|sv_vdd|tg_d_a|tg_d_vdd|tg_fbm_vdd|tg_fbs_vdd|tg_s_vdd|vdd|vdd_b1|vdd_b2|vdd_b3|vdd_b4|vdd_link|vdd_link_dip|vdd_x1|vdd_x2|vdd_x3
+ 216.604437092
* device instance a_d_inv_clk_vdd_inv_mc_vdd_inv_q_vdd_mpa_py_mpb_py_nand_m_vdd_nand_s2_vdd_nwell_vdd_sb_vdd_sr1_vdd_sr2_vdd_sr3_vdd_sr4_vdd_sv_d_vdd_tie_sv_vdd_tg_d_a_tg_d_vdd_tg_fbm_vdd_tg_fbs_vdd_tg_s_vdd_vdd_vdd_b1_vdd_b2_vdd_b3_vdd_b4_vdd_link_vdd_link_dip_vdd_x1_vdd_x2_vdd_x3_t2 r0 *1 0,0
Ra_d_inv_clk_vdd_inv_mc_vdd_inv_q_vdd_mpa_py_mpb_py_nand_m_vdd_nand_s2_vdd_nwell_vdd_sb_vdd_sr1_vdd_sr2_vdd_sr3_vdd_sr4_vdd_sv_d_vdd_tie_sv_vdd_tg_d_a_tg_d_vdd_tg_fbm_vdd_tg_fbs_vdd_tg_s_vdd_vdd_vdd_b1_vdd_b2_vdd_b3_vdd_b4_vdd_link_vdd_link_dip_vdd_x1_vdd_x2_vdd_x3_t2
+ a\x7cd\x7cinv_clk_vdd\x7cinv_mc_vdd\x7cinv_q_vdd\x7cmpa_py\x7cmpb_py\x7cnand_m_vdd\x7cnand_s2_vdd\x7cnwell_vdd\x7csb_vdd\x7csr1_vdd\x7csr2_vdd\x7csr3_vdd\x7csr4_vdd\x7csv_d_vdd_tie\x7csv_vdd\x7ctg_d_a\x7ctg_d_vdd\x7ctg_fbm_vdd\x7ctg_fbs_vdd\x7ctg_s_vdd\x7cvdd\x7cvdd_b1\x7cvdd_b2\x7cvdd_b3\x7cvdd_b4\x7cvdd_link\x7cvdd_link_dip\x7cvdd_x1\x7cvdd_x2\x7cvdd_x3__t2
+ a|d|inv_clk_vdd|inv_mc_vdd|inv_q_vdd|mpa_py|mpb_py|nand_m_vdd|nand_s2_vdd|nwell_vdd|sb_vdd|sr1_vdd|sr2_vdd|sr3_vdd|sr4_vdd|sv_d_vdd_tie|sv_vdd|tg_d_a|tg_d_vdd|tg_fbm_vdd|tg_fbs_vdd|tg_s_vdd|vdd|vdd_b1|vdd_b2|vdd_b3|vdd_b4|vdd_link|vdd_link_dip|vdd_x1|vdd_x2|vdd_x3
+ 212.666502299
* device instance a_d_inv_clk_vdd_inv_mc_vdd_inv_q_vdd_mpa_py_mpb_py_nand_m_vdd_nand_s2_vdd_nwell_vdd_sb_vdd_sr1_vdd_sr2_vdd_sr3_vdd_sr4_vdd_sv_d_vdd_tie_sv_vdd_tg_d_a_tg_d_vdd_tg_fbm_vdd_tg_fbs_vdd_tg_s_vdd_vdd_vdd_b1_vdd_b2_vdd_b3_vdd_b4_vdd_link_vdd_link_dip_vdd_x1_vdd_x2_vdd_x3_t3 r0 *1 0,0
Ra_d_inv_clk_vdd_inv_mc_vdd_inv_q_vdd_mpa_py_mpb_py_nand_m_vdd_nand_s2_vdd_nwell_vdd_sb_vdd_sr1_vdd_sr2_vdd_sr3_vdd_sr4_vdd_sv_d_vdd_tie_sv_vdd_tg_d_a_tg_d_vdd_tg_fbm_vdd_tg_fbs_vdd_tg_s_vdd_vdd_vdd_b1_vdd_b2_vdd_b3_vdd_b4_vdd_link_vdd_link_dip_vdd_x1_vdd_x2_vdd_x3_t3
+ a\x7cd\x7cinv_clk_vdd\x7cinv_mc_vdd\x7cinv_q_vdd\x7cmpa_py\x7cmpb_py\x7cnand_m_vdd\x7cnand_s2_vdd\x7cnwell_vdd\x7csb_vdd\x7csr1_vdd\x7csr2_vdd\x7csr3_vdd\x7csr4_vdd\x7csv_d_vdd_tie\x7csv_vdd\x7ctg_d_a\x7ctg_d_vdd\x7ctg_fbm_vdd\x7ctg_fbs_vdd\x7ctg_s_vdd\x7cvdd\x7cvdd_b1\x7cvdd_b2\x7cvdd_b3\x7cvdd_b4\x7cvdd_link\x7cvdd_link_dip\x7cvdd_x1\x7cvdd_x2\x7cvdd_x3__t3
+ a|d|inv_clk_vdd|inv_mc_vdd|inv_q_vdd|mpa_py|mpb_py|nand_m_vdd|nand_s2_vdd|nwell_vdd|sb_vdd|sr1_vdd|sr2_vdd|sr3_vdd|sr4_vdd|sv_d_vdd_tie|sv_vdd|tg_d_a|tg_d_vdd|tg_fbm_vdd|tg_fbs_vdd|tg_s_vdd|vdd|vdd_b1|vdd_b2|vdd_b3|vdd_b4|vdd_link|vdd_link_dip|vdd_x1|vdd_x2|vdd_x3
+ 212.666502299
* device instance a_d_inv_clk_vdd_inv_mc_vdd_inv_q_vdd_mpa_py_mpb_py_nand_m_vdd_nand_s2_vdd_nwell_vdd_sb_vdd_sr1_vdd_sr2_vdd_sr3_vdd_sr4_vdd_sv_d_vdd_tie_sv_vdd_tg_d_a_tg_d_vdd_tg_fbm_vdd_tg_fbs_vdd_tg_s_vdd_vdd_vdd_b1_vdd_b2_vdd_b3_vdd_b4_vdd_link_vdd_link_dip_vdd_x1_vdd_x2_vdd_x3_t4 r0 *1 0,0
Ra_d_inv_clk_vdd_inv_mc_vdd_inv_q_vdd_mpa_py_mpb_py_nand_m_vdd_nand_s2_vdd_nwell_vdd_sb_vdd_sr1_vdd_sr2_vdd_sr3_vdd_sr4_vdd_sv_d_vdd_tie_sv_vdd_tg_d_a_tg_d_vdd_tg_fbm_vdd_tg_fbs_vdd_tg_s_vdd_vdd_vdd_b1_vdd_b2_vdd_b3_vdd_b4_vdd_link_vdd_link_dip_vdd_x1_vdd_x2_vdd_x3_t4
+ a\x7cd\x7cinv_clk_vdd\x7cinv_mc_vdd\x7cinv_q_vdd\x7cmpa_py\x7cmpb_py\x7cnand_m_vdd\x7cnand_s2_vdd\x7cnwell_vdd\x7csb_vdd\x7csr1_vdd\x7csr2_vdd\x7csr3_vdd\x7csr4_vdd\x7csv_d_vdd_tie\x7csv_vdd\x7ctg_d_a\x7ctg_d_vdd\x7ctg_fbm_vdd\x7ctg_fbs_vdd\x7ctg_s_vdd\x7cvdd\x7cvdd_b1\x7cvdd_b2\x7cvdd_b3\x7cvdd_b4\x7cvdd_link\x7cvdd_link_dip\x7cvdd_x1\x7cvdd_x2\x7cvdd_x3__t4
+ a|d|inv_clk_vdd|inv_mc_vdd|inv_q_vdd|mpa_py|mpb_py|nand_m_vdd|nand_s2_vdd|nwell_vdd|sb_vdd|sr1_vdd|sr2_vdd|sr3_vdd|sr4_vdd|sv_d_vdd_tie|sv_vdd|tg_d_a|tg_d_vdd|tg_fbm_vdd|tg_fbs_vdd|tg_s_vdd|vdd|vdd_b1|vdd_b2|vdd_b3|vdd_b4|vdd_link|vdd_link_dip|vdd_x1|vdd_x2|vdd_x3
+ 211.636255656
* device instance a_d_inv_clk_vdd_inv_mc_vdd_inv_q_vdd_mpa_py_mpb_py_nand_m_vdd_nand_s2_vdd_nwell_vdd_sb_vdd_sr1_vdd_sr2_vdd_sr3_vdd_sr4_vdd_sv_d_vdd_tie_sv_vdd_tg_d_a_tg_d_vdd_tg_fbm_vdd_tg_fbs_vdd_tg_s_vdd_vdd_vdd_b1_vdd_b2_vdd_b3_vdd_b4_vdd_link_vdd_link_dip_vdd_x1_vdd_x2_vdd_x3_t5 r0 *1 0,0
Ra_d_inv_clk_vdd_inv_mc_vdd_inv_q_vdd_mpa_py_mpb_py_nand_m_vdd_nand_s2_vdd_nwell_vdd_sb_vdd_sr1_vdd_sr2_vdd_sr3_vdd_sr4_vdd_sv_d_vdd_tie_sv_vdd_tg_d_a_tg_d_vdd_tg_fbm_vdd_tg_fbs_vdd_tg_s_vdd_vdd_vdd_b1_vdd_b2_vdd_b3_vdd_b4_vdd_link_vdd_link_dip_vdd_x1_vdd_x2_vdd_x3_t5
+ a\x7cd\x7cinv_clk_vdd\x7cinv_mc_vdd\x7cinv_q_vdd\x7cmpa_py\x7cmpb_py\x7cnand_m_vdd\x7cnand_s2_vdd\x7cnwell_vdd\x7csb_vdd\x7csr1_vdd\x7csr2_vdd\x7csr3_vdd\x7csr4_vdd\x7csv_d_vdd_tie\x7csv_vdd\x7ctg_d_a\x7ctg_d_vdd\x7ctg_fbm_vdd\x7ctg_fbs_vdd\x7ctg_s_vdd\x7cvdd\x7cvdd_b1\x7cvdd_b2\x7cvdd_b3\x7cvdd_b4\x7cvdd_link\x7cvdd_link_dip\x7cvdd_x1\x7cvdd_x2\x7cvdd_x3__t5
+ a|d|inv_clk_vdd|inv_mc_vdd|inv_q_vdd|mpa_py|mpb_py|nand_m_vdd|nand_s2_vdd|nwell_vdd|sb_vdd|sr1_vdd|sr2_vdd|sr3_vdd|sr4_vdd|sv_d_vdd_tie|sv_vdd|tg_d_a|tg_d_vdd|tg_fbm_vdd|tg_fbs_vdd|tg_s_vdd|vdd|vdd_b1|vdd_b2|vdd_b3|vdd_b4|vdd_link|vdd_link_dip|vdd_x1|vdd_x2|vdd_x3
+ 156.863771173
* device instance a_d_inv_clk_vdd_inv_mc_vdd_inv_q_vdd_mpa_py_mpb_py_nand_m_vdd_nand_s2_vdd_nwell_vdd_sb_vdd_sr1_vdd_sr2_vdd_sr3_vdd_sr4_vdd_sv_d_vdd_tie_sv_vdd_tg_d_a_tg_d_vdd_tg_fbm_vdd_tg_fbs_vdd_tg_s_vdd_vdd_vdd_b1_vdd_b2_vdd_b3_vdd_b4_vdd_link_vdd_link_dip_vdd_x1_vdd_x2_vdd_x3_t6 r0 *1 0,0
Ra_d_inv_clk_vdd_inv_mc_vdd_inv_q_vdd_mpa_py_mpb_py_nand_m_vdd_nand_s2_vdd_nwell_vdd_sb_vdd_sr1_vdd_sr2_vdd_sr3_vdd_sr4_vdd_sv_d_vdd_tie_sv_vdd_tg_d_a_tg_d_vdd_tg_fbm_vdd_tg_fbs_vdd_tg_s_vdd_vdd_vdd_b1_vdd_b2_vdd_b3_vdd_b4_vdd_link_vdd_link_dip_vdd_x1_vdd_x2_vdd_x3_t6
+ a\x7cd\x7cinv_clk_vdd\x7cinv_mc_vdd\x7cinv_q_vdd\x7cmpa_py\x7cmpb_py\x7cnand_m_vdd\x7cnand_s2_vdd\x7cnwell_vdd\x7csb_vdd\x7csr1_vdd\x7csr2_vdd\x7csr3_vdd\x7csr4_vdd\x7csv_d_vdd_tie\x7csv_vdd\x7ctg_d_a\x7ctg_d_vdd\x7ctg_fbm_vdd\x7ctg_fbs_vdd\x7ctg_s_vdd\x7cvdd\x7cvdd_b1\x7cvdd_b2\x7cvdd_b3\x7cvdd_b4\x7cvdd_link\x7cvdd_link_dip\x7cvdd_x1\x7cvdd_x2\x7cvdd_x3__t6
+ a|d|inv_clk_vdd|inv_mc_vdd|inv_q_vdd|mpa_py|mpb_py|nand_m_vdd|nand_s2_vdd|nwell_vdd|sb_vdd|sr1_vdd|sr2_vdd|sr3_vdd|sr4_vdd|sv_d_vdd_tie|sv_vdd|tg_d_a|tg_d_vdd|tg_fbm_vdd|tg_fbs_vdd|tg_s_vdd|vdd|vdd_b1|vdd_b2|vdd_b3|vdd_b4|vdd_link|vdd_link_dip|vdd_x1|vdd_x2|vdd_x3
+ 200.667051606
* device instance a_d_inv_clk_vdd_inv_mc_vdd_inv_q_vdd_mpa_py_mpb_py_nand_m_vdd_nand_s2_vdd_nwell_vdd_sb_vdd_sr1_vdd_sr2_vdd_sr3_vdd_sr4_vdd_sv_d_vdd_tie_sv_vdd_tg_d_a_tg_d_vdd_tg_fbm_vdd_tg_fbs_vdd_tg_s_vdd_vdd_vdd_b1_vdd_b2_vdd_b3_vdd_b4_vdd_link_vdd_link_dip_vdd_x1_vdd_x2_vdd_x3_t7 r0 *1 0,0
Ra_d_inv_clk_vdd_inv_mc_vdd_inv_q_vdd_mpa_py_mpb_py_nand_m_vdd_nand_s2_vdd_nwell_vdd_sb_vdd_sr1_vdd_sr2_vdd_sr3_vdd_sr4_vdd_sv_d_vdd_tie_sv_vdd_tg_d_a_tg_d_vdd_tg_fbm_vdd_tg_fbs_vdd_tg_s_vdd_vdd_vdd_b1_vdd_b2_vdd_b3_vdd_b4_vdd_link_vdd_link_dip_vdd_x1_vdd_x2_vdd_x3_t7
+ a\x7cd\x7cinv_clk_vdd\x7cinv_mc_vdd\x7cinv_q_vdd\x7cmpa_py\x7cmpb_py\x7cnand_m_vdd\x7cnand_s2_vdd\x7cnwell_vdd\x7csb_vdd\x7csr1_vdd\x7csr2_vdd\x7csr3_vdd\x7csr4_vdd\x7csv_d_vdd_tie\x7csv_vdd\x7ctg_d_a\x7ctg_d_vdd\x7ctg_fbm_vdd\x7ctg_fbs_vdd\x7ctg_s_vdd\x7cvdd\x7cvdd_b1\x7cvdd_b2\x7cvdd_b3\x7cvdd_b4\x7cvdd_link\x7cvdd_link_dip\x7cvdd_x1\x7cvdd_x2\x7cvdd_x3__t7
+ a|d|inv_clk_vdd|inv_mc_vdd|inv_q_vdd|mpa_py|mpb_py|nand_m_vdd|nand_s2_vdd|nwell_vdd|sb_vdd|sr1_vdd|sr2_vdd|sr3_vdd|sr4_vdd|sv_d_vdd_tie|sv_vdd|tg_d_a|tg_d_vdd|tg_fbm_vdd|tg_fbs_vdd|tg_s_vdd|vdd|vdd_b1|vdd_b2|vdd_b3|vdd_b4|vdd_link|vdd_link_dip|vdd_x1|vdd_x2|vdd_x3
+ 114.96890537
* device instance a_d_inv_clk_vdd_inv_mc_vdd_inv_q_vdd_mpa_py_mpb_py_nand_m_vdd_nand_s2_vdd_nwell_vdd_sb_vdd_sr1_vdd_sr2_vdd_sr3_vdd_sr4_vdd_sv_d_vdd_tie_sv_vdd_tg_d_a_tg_d_vdd_tg_fbm_vdd_tg_fbs_vdd_tg_s_vdd_vdd_vdd_b1_vdd_b2_vdd_b3_vdd_b4_vdd_link_vdd_link_dip_vdd_x1_vdd_x2_vdd_x3_t8 r0 *1 0,0
Ra_d_inv_clk_vdd_inv_mc_vdd_inv_q_vdd_mpa_py_mpb_py_nand_m_vdd_nand_s2_vdd_nwell_vdd_sb_vdd_sr1_vdd_sr2_vdd_sr3_vdd_sr4_vdd_sv_d_vdd_tie_sv_vdd_tg_d_a_tg_d_vdd_tg_fbm_vdd_tg_fbs_vdd_tg_s_vdd_vdd_vdd_b1_vdd_b2_vdd_b3_vdd_b4_vdd_link_vdd_link_dip_vdd_x1_vdd_x2_vdd_x3_t8
+ a\x7cd\x7cinv_clk_vdd\x7cinv_mc_vdd\x7cinv_q_vdd\x7cmpa_py\x7cmpb_py\x7cnand_m_vdd\x7cnand_s2_vdd\x7cnwell_vdd\x7csb_vdd\x7csr1_vdd\x7csr2_vdd\x7csr3_vdd\x7csr4_vdd\x7csv_d_vdd_tie\x7csv_vdd\x7ctg_d_a\x7ctg_d_vdd\x7ctg_fbm_vdd\x7ctg_fbs_vdd\x7ctg_s_vdd\x7cvdd\x7cvdd_b1\x7cvdd_b2\x7cvdd_b3\x7cvdd_b4\x7cvdd_link\x7cvdd_link_dip\x7cvdd_x1\x7cvdd_x2\x7cvdd_x3__t8
+ a|d|inv_clk_vdd|inv_mc_vdd|inv_q_vdd|mpa_py|mpb_py|nand_m_vdd|nand_s2_vdd|nwell_vdd|sb_vdd|sr1_vdd|sr2_vdd|sr3_vdd|sr4_vdd|sv_d_vdd_tie|sv_vdd|tg_d_a|tg_d_vdd|tg_fbm_vdd|tg_fbs_vdd|tg_s_vdd|vdd|vdd_b1|vdd_b2|vdd_b3|vdd_b4|vdd_link|vdd_link_dip|vdd_x1|vdd_x2|vdd_x3
+ 156.863771173
* device instance a_d_inv_clk_vdd_inv_mc_vdd_inv_q_vdd_mpa_py_mpb_py_nand_m_vdd_nand_s2_vdd_nwell_vdd_sb_vdd_sr1_vdd_sr2_vdd_sr3_vdd_sr4_vdd_sv_d_vdd_tie_sv_vdd_tg_d_a_tg_d_vdd_tg_fbm_vdd_tg_fbs_vdd_tg_s_vdd_vdd_vdd_b1_vdd_b2_vdd_b3_vdd_b4_vdd_link_vdd_link_dip_vdd_x1_vdd_x2_vdd_x3_t9 r0 *1 0,0
Ra_d_inv_clk_vdd_inv_mc_vdd_inv_q_vdd_mpa_py_mpb_py_nand_m_vdd_nand_s2_vdd_nwell_vdd_sb_vdd_sr1_vdd_sr2_vdd_sr3_vdd_sr4_vdd_sv_d_vdd_tie_sv_vdd_tg_d_a_tg_d_vdd_tg_fbm_vdd_tg_fbs_vdd_tg_s_vdd_vdd_vdd_b1_vdd_b2_vdd_b3_vdd_b4_vdd_link_vdd_link_dip_vdd_x1_vdd_x2_vdd_x3_t9
+ a\x7cd\x7cinv_clk_vdd\x7cinv_mc_vdd\x7cinv_q_vdd\x7cmpa_py\x7cmpb_py\x7cnand_m_vdd\x7cnand_s2_vdd\x7cnwell_vdd\x7csb_vdd\x7csr1_vdd\x7csr2_vdd\x7csr3_vdd\x7csr4_vdd\x7csv_d_vdd_tie\x7csv_vdd\x7ctg_d_a\x7ctg_d_vdd\x7ctg_fbm_vdd\x7ctg_fbs_vdd\x7ctg_s_vdd\x7cvdd\x7cvdd_b1\x7cvdd_b2\x7cvdd_b3\x7cvdd_b4\x7cvdd_link\x7cvdd_link_dip\x7cvdd_x1\x7cvdd_x2\x7cvdd_x3__t9
+ a|d|inv_clk_vdd|inv_mc_vdd|inv_q_vdd|mpa_py|mpb_py|nand_m_vdd|nand_s2_vdd|nwell_vdd|sb_vdd|sr1_vdd|sr2_vdd|sr3_vdd|sr4_vdd|sv_d_vdd_tie|sv_vdd|tg_d_a|tg_d_vdd|tg_fbm_vdd|tg_fbs_vdd|tg_s_vdd|vdd|vdd_b1|vdd_b2|vdd_b3|vdd_b4|vdd_link|vdd_link_dip|vdd_x1|vdd_x2|vdd_x3
+ 125.02583041
* device instance a_d_inv_clk_vdd_inv_mc_vdd_inv_q_vdd_mpa_py_mpb_py_nand_m_vdd_nand_s2_vdd_nwell_vdd_sb_vdd_sr1_vdd_sr2_vdd_sr3_vdd_sr4_vdd_sv_d_vdd_tie_sv_vdd_tg_d_a_tg_d_vdd_tg_fbm_vdd_tg_fbs_vdd_tg_s_vdd_vdd_vdd_b1_vdd_b2_vdd_b3_vdd_b4_vdd_link_vdd_link_dip_vdd_x1_vdd_x2_vdd_x3_t10 r0 *1 0,0
Ra_d_inv_clk_vdd_inv_mc_vdd_inv_q_vdd_mpa_py_mpb_py_nand_m_vdd_nand_s2_vdd_nwell_vdd_sb_vdd_sr1_vdd_sr2_vdd_sr3_vdd_sr4_vdd_sv_d_vdd_tie_sv_vdd_tg_d_a_tg_d_vdd_tg_fbm_vdd_tg_fbs_vdd_tg_s_vdd_vdd_vdd_b1_vdd_b2_vdd_b3_vdd_b4_vdd_link_vdd_link_dip_vdd_x1_vdd_x2_vdd_x3_t10
+ a\x7cd\x7cinv_clk_vdd\x7cinv_mc_vdd\x7cinv_q_vdd\x7cmpa_py\x7cmpb_py\x7cnand_m_vdd\x7cnand_s2_vdd\x7cnwell_vdd\x7csb_vdd\x7csr1_vdd\x7csr2_vdd\x7csr3_vdd\x7csr4_vdd\x7csv_d_vdd_tie\x7csv_vdd\x7ctg_d_a\x7ctg_d_vdd\x7ctg_fbm_vdd\x7ctg_fbs_vdd\x7ctg_s_vdd\x7cvdd\x7cvdd_b1\x7cvdd_b2\x7cvdd_b3\x7cvdd_b4\x7cvdd_link\x7cvdd_link_dip\x7cvdd_x1\x7cvdd_x2\x7cvdd_x3__t10
+ a|d|inv_clk_vdd|inv_mc_vdd|inv_q_vdd|mpa_py|mpb_py|nand_m_vdd|nand_s2_vdd|nwell_vdd|sb_vdd|sr1_vdd|sr2_vdd|sr3_vdd|sr4_vdd|sv_d_vdd_tie|sv_vdd|tg_d_a|tg_d_vdd|tg_fbm_vdd|tg_fbs_vdd|tg_s_vdd|vdd|vdd_b1|vdd_b2|vdd_b3|vdd_b4|vdd_link|vdd_link_dip|vdd_x1|vdd_x2|vdd_x3
+ 200.667051606
* device instance a_d_inv_clk_vdd_inv_mc_vdd_inv_q_vdd_mpa_py_mpb_py_nand_m_vdd_nand_s2_vdd_nwell_vdd_sb_vdd_sr1_vdd_sr2_vdd_sr3_vdd_sr4_vdd_sv_d_vdd_tie_sv_vdd_tg_d_a_tg_d_vdd_tg_fbm_vdd_tg_fbs_vdd_tg_s_vdd_vdd_vdd_b1_vdd_b2_vdd_b3_vdd_b4_vdd_link_vdd_link_dip_vdd_x1_vdd_x2_vdd_x3_t11 r0 *1 0,0
Ra_d_inv_clk_vdd_inv_mc_vdd_inv_q_vdd_mpa_py_mpb_py_nand_m_vdd_nand_s2_vdd_nwell_vdd_sb_vdd_sr1_vdd_sr2_vdd_sr3_vdd_sr4_vdd_sv_d_vdd_tie_sv_vdd_tg_d_a_tg_d_vdd_tg_fbm_vdd_tg_fbs_vdd_tg_s_vdd_vdd_vdd_b1_vdd_b2_vdd_b3_vdd_b4_vdd_link_vdd_link_dip_vdd_x1_vdd_x2_vdd_x3_t11
+ a\x7cd\x7cinv_clk_vdd\x7cinv_mc_vdd\x7cinv_q_vdd\x7cmpa_py\x7cmpb_py\x7cnand_m_vdd\x7cnand_s2_vdd\x7cnwell_vdd\x7csb_vdd\x7csr1_vdd\x7csr2_vdd\x7csr3_vdd\x7csr4_vdd\x7csv_d_vdd_tie\x7csv_vdd\x7ctg_d_a\x7ctg_d_vdd\x7ctg_fbm_vdd\x7ctg_fbs_vdd\x7ctg_s_vdd\x7cvdd\x7cvdd_b1\x7cvdd_b2\x7cvdd_b3\x7cvdd_b4\x7cvdd_link\x7cvdd_link_dip\x7cvdd_x1\x7cvdd_x2\x7cvdd_x3__t11
+ a|d|inv_clk_vdd|inv_mc_vdd|inv_q_vdd|mpa_py|mpb_py|nand_m_vdd|nand_s2_vdd|nwell_vdd|sb_vdd|sr1_vdd|sr2_vdd|sr3_vdd|sr4_vdd|sv_d_vdd_tie|sv_vdd|tg_d_a|tg_d_vdd|tg_fbm_vdd|tg_fbs_vdd|tg_s_vdd|vdd|vdd_b1|vdd_b2|vdd_b3|vdd_b4|vdd_link|vdd_link_dip|vdd_x1|vdd_x2|vdd_x3
+ 114.96890537
* device instance a_d_inv_clk_vdd_inv_mc_vdd_inv_q_vdd_mpa_py_mpb_py_nand_m_vdd_nand_s2_vdd_nwell_vdd_sb_vdd_sr1_vdd_sr2_vdd_sr3_vdd_sr4_vdd_sv_d_vdd_tie_sv_vdd_tg_d_a_tg_d_vdd_tg_fbm_vdd_tg_fbs_vdd_tg_s_vdd_vdd_vdd_b1_vdd_b2_vdd_b3_vdd_b4_vdd_link_vdd_link_dip_vdd_x1_vdd_x2_vdd_x3_t12 r0 *1 0,0
Ra_d_inv_clk_vdd_inv_mc_vdd_inv_q_vdd_mpa_py_mpb_py_nand_m_vdd_nand_s2_vdd_nwell_vdd_sb_vdd_sr1_vdd_sr2_vdd_sr3_vdd_sr4_vdd_sv_d_vdd_tie_sv_vdd_tg_d_a_tg_d_vdd_tg_fbm_vdd_tg_fbs_vdd_tg_s_vdd_vdd_vdd_b1_vdd_b2_vdd_b3_vdd_b4_vdd_link_vdd_link_dip_vdd_x1_vdd_x2_vdd_x3_t12
+ a\x7cd\x7cinv_clk_vdd\x7cinv_mc_vdd\x7cinv_q_vdd\x7cmpa_py\x7cmpb_py\x7cnand_m_vdd\x7cnand_s2_vdd\x7cnwell_vdd\x7csb_vdd\x7csr1_vdd\x7csr2_vdd\x7csr3_vdd\x7csr4_vdd\x7csv_d_vdd_tie\x7csv_vdd\x7ctg_d_a\x7ctg_d_vdd\x7ctg_fbm_vdd\x7ctg_fbs_vdd\x7ctg_s_vdd\x7cvdd\x7cvdd_b1\x7cvdd_b2\x7cvdd_b3\x7cvdd_b4\x7cvdd_link\x7cvdd_link_dip\x7cvdd_x1\x7cvdd_x2\x7cvdd_x3__t12
+ a|d|inv_clk_vdd|inv_mc_vdd|inv_q_vdd|mpa_py|mpb_py|nand_m_vdd|nand_s2_vdd|nwell_vdd|sb_vdd|sr1_vdd|sr2_vdd|sr3_vdd|sr4_vdd|sv_d_vdd_tie|sv_vdd|tg_d_a|tg_d_vdd|tg_fbm_vdd|tg_fbs_vdd|tg_s_vdd|vdd|vdd_b1|vdd_b2|vdd_b3|vdd_b4|vdd_link|vdd_link_dip|vdd_x1|vdd_x2|vdd_x3
+ 167.554071256
* device instance a_d_inv_clk_vdd_inv_mc_vdd_inv_q_vdd_mpa_py_mpb_py_nand_m_vdd_nand_s2_vdd_nwell_vdd_sb_vdd_sr1_vdd_sr2_vdd_sr3_vdd_sr4_vdd_sv_d_vdd_tie_sv_vdd_tg_d_a_tg_d_vdd_tg_fbm_vdd_tg_fbs_vdd_tg_s_vdd_vdd_vdd_b1_vdd_b2_vdd_b3_vdd_b4_vdd_link_vdd_link_dip_vdd_x1_vdd_x2_vdd_x3_t13 r0 *1 0,0
Ra_d_inv_clk_vdd_inv_mc_vdd_inv_q_vdd_mpa_py_mpb_py_nand_m_vdd_nand_s2_vdd_nwell_vdd_sb_vdd_sr1_vdd_sr2_vdd_sr3_vdd_sr4_vdd_sv_d_vdd_tie_sv_vdd_tg_d_a_tg_d_vdd_tg_fbm_vdd_tg_fbs_vdd_tg_s_vdd_vdd_vdd_b1_vdd_b2_vdd_b3_vdd_b4_vdd_link_vdd_link_dip_vdd_x1_vdd_x2_vdd_x3_t13
+ a\x7cd\x7cinv_clk_vdd\x7cinv_mc_vdd\x7cinv_q_vdd\x7cmpa_py\x7cmpb_py\x7cnand_m_vdd\x7cnand_s2_vdd\x7cnwell_vdd\x7csb_vdd\x7csr1_vdd\x7csr2_vdd\x7csr3_vdd\x7csr4_vdd\x7csv_d_vdd_tie\x7csv_vdd\x7ctg_d_a\x7ctg_d_vdd\x7ctg_fbm_vdd\x7ctg_fbs_vdd\x7ctg_s_vdd\x7cvdd\x7cvdd_b1\x7cvdd_b2\x7cvdd_b3\x7cvdd_b4\x7cvdd_link\x7cvdd_link_dip\x7cvdd_x1\x7cvdd_x2\x7cvdd_x3__t13
+ a|d|inv_clk_vdd|inv_mc_vdd|inv_q_vdd|mpa_py|mpb_py|nand_m_vdd|nand_s2_vdd|nwell_vdd|sb_vdd|sr1_vdd|sr2_vdd|sr3_vdd|sr4_vdd|sv_d_vdd_tie|sv_vdd|tg_d_a|tg_d_vdd|tg_fbm_vdd|tg_fbs_vdd|tg_s_vdd|vdd|vdd_b1|vdd_b2|vdd_b3|vdd_b4|vdd_link|vdd_link_dip|vdd_x1|vdd_x2|vdd_x3
+ 201.6928703
* device instance a_d_inv_clk_vdd_inv_mc_vdd_inv_q_vdd_mpa_py_mpb_py_nand_m_vdd_nand_s2_vdd_nwell_vdd_sb_vdd_sr1_vdd_sr2_vdd_sr3_vdd_sr4_vdd_sv_d_vdd_tie_sv_vdd_tg_d_a_tg_d_vdd_tg_fbm_vdd_tg_fbs_vdd_tg_s_vdd_vdd_vdd_b1_vdd_b2_vdd_b3_vdd_b4_vdd_link_vdd_link_dip_vdd_x1_vdd_x2_vdd_x3_t14 r0 *1 0,0
Ra_d_inv_clk_vdd_inv_mc_vdd_inv_q_vdd_mpa_py_mpb_py_nand_m_vdd_nand_s2_vdd_nwell_vdd_sb_vdd_sr1_vdd_sr2_vdd_sr3_vdd_sr4_vdd_sv_d_vdd_tie_sv_vdd_tg_d_a_tg_d_vdd_tg_fbm_vdd_tg_fbs_vdd_tg_s_vdd_vdd_vdd_b1_vdd_b2_vdd_b3_vdd_b4_vdd_link_vdd_link_dip_vdd_x1_vdd_x2_vdd_x3_t14
+ a\x7cd\x7cinv_clk_vdd\x7cinv_mc_vdd\x7cinv_q_vdd\x7cmpa_py\x7cmpb_py\x7cnand_m_vdd\x7cnand_s2_vdd\x7cnwell_vdd\x7csb_vdd\x7csr1_vdd\x7csr2_vdd\x7csr3_vdd\x7csr4_vdd\x7csv_d_vdd_tie\x7csv_vdd\x7ctg_d_a\x7ctg_d_vdd\x7ctg_fbm_vdd\x7ctg_fbs_vdd\x7ctg_s_vdd\x7cvdd\x7cvdd_b1\x7cvdd_b2\x7cvdd_b3\x7cvdd_b4\x7cvdd_link\x7cvdd_link_dip\x7cvdd_x1\x7cvdd_x2\x7cvdd_x3__t14
+ a|d|inv_clk_vdd|inv_mc_vdd|inv_q_vdd|mpa_py|mpb_py|nand_m_vdd|nand_s2_vdd|nwell_vdd|sb_vdd|sr1_vdd|sr2_vdd|sr3_vdd|sr4_vdd|sv_d_vdd_tie|sv_vdd|tg_d_a|tg_d_vdd|tg_fbm_vdd|tg_fbs_vdd|tg_s_vdd|vdd|vdd_b1|vdd_b2|vdd_b3|vdd_b4|vdd_link|vdd_link_dip|vdd_x1|vdd_x2|vdd_x3
+ 168.560637731
* device instance a_d_inv_clk_vdd_inv_mc_vdd_inv_q_vdd_mpa_py_mpb_py_nand_m_vdd_nand_s2_vdd_nwell_vdd_sb_vdd_sr1_vdd_sr2_vdd_sr3_vdd_sr4_vdd_sv_d_vdd_tie_sv_vdd_tg_d_a_tg_d_vdd_tg_fbm_vdd_tg_fbs_vdd_tg_s_vdd_vdd_vdd_b1_vdd_b2_vdd_b3_vdd_b4_vdd_link_vdd_link_dip_vdd_x1_vdd_x2_vdd_x3_t15 r0 *1 0,0
Ra_d_inv_clk_vdd_inv_mc_vdd_inv_q_vdd_mpa_py_mpb_py_nand_m_vdd_nand_s2_vdd_nwell_vdd_sb_vdd_sr1_vdd_sr2_vdd_sr3_vdd_sr4_vdd_sv_d_vdd_tie_sv_vdd_tg_d_a_tg_d_vdd_tg_fbm_vdd_tg_fbs_vdd_tg_s_vdd_vdd_vdd_b1_vdd_b2_vdd_b3_vdd_b4_vdd_link_vdd_link_dip_vdd_x1_vdd_x2_vdd_x3_t15
+ a\x7cd\x7cinv_clk_vdd\x7cinv_mc_vdd\x7cinv_q_vdd\x7cmpa_py\x7cmpb_py\x7cnand_m_vdd\x7cnand_s2_vdd\x7cnwell_vdd\x7csb_vdd\x7csr1_vdd\x7csr2_vdd\x7csr3_vdd\x7csr4_vdd\x7csv_d_vdd_tie\x7csv_vdd\x7ctg_d_a\x7ctg_d_vdd\x7ctg_fbm_vdd\x7ctg_fbs_vdd\x7ctg_s_vdd\x7cvdd\x7cvdd_b1\x7cvdd_b2\x7cvdd_b3\x7cvdd_b4\x7cvdd_link\x7cvdd_link_dip\x7cvdd_x1\x7cvdd_x2\x7cvdd_x3__t15
+ a|d|inv_clk_vdd|inv_mc_vdd|inv_q_vdd|mpa_py|mpb_py|nand_m_vdd|nand_s2_vdd|nwell_vdd|sb_vdd|sr1_vdd|sr2_vdd|sr3_vdd|sr4_vdd|sv_d_vdd_tie|sv_vdd|tg_d_a|tg_d_vdd|tg_fbm_vdd|tg_fbs_vdd|tg_s_vdd|vdd|vdd_b1|vdd_b2|vdd_b3|vdd_b4|vdd_link|vdd_link_dip|vdd_x1|vdd_x2|vdd_x3
+ 115.900682238
* device instance a_d_inv_clk_vdd_inv_mc_vdd_inv_q_vdd_mpa_py_mpb_py_nand_m_vdd_nand_s2_vdd_nwell_vdd_sb_vdd_sr1_vdd_sr2_vdd_sr3_vdd_sr4_vdd_sv_d_vdd_tie_sv_vdd_tg_d_a_tg_d_vdd_tg_fbm_vdd_tg_fbs_vdd_tg_s_vdd_vdd_vdd_b1_vdd_b2_vdd_b3_vdd_b4_vdd_link_vdd_link_dip_vdd_x1_vdd_x2_vdd_x3_t16 r0 *1 0,0
Ra_d_inv_clk_vdd_inv_mc_vdd_inv_q_vdd_mpa_py_mpb_py_nand_m_vdd_nand_s2_vdd_nwell_vdd_sb_vdd_sr1_vdd_sr2_vdd_sr3_vdd_sr4_vdd_sv_d_vdd_tie_sv_vdd_tg_d_a_tg_d_vdd_tg_fbm_vdd_tg_fbs_vdd_tg_s_vdd_vdd_vdd_b1_vdd_b2_vdd_b3_vdd_b4_vdd_link_vdd_link_dip_vdd_x1_vdd_x2_vdd_x3_t16
+ a\x7cd\x7cinv_clk_vdd\x7cinv_mc_vdd\x7cinv_q_vdd\x7cmpa_py\x7cmpb_py\x7cnand_m_vdd\x7cnand_s2_vdd\x7cnwell_vdd\x7csb_vdd\x7csr1_vdd\x7csr2_vdd\x7csr3_vdd\x7csr4_vdd\x7csv_d_vdd_tie\x7csv_vdd\x7ctg_d_a\x7ctg_d_vdd\x7ctg_fbm_vdd\x7ctg_fbs_vdd\x7ctg_s_vdd\x7cvdd\x7cvdd_b1\x7cvdd_b2\x7cvdd_b3\x7cvdd_b4\x7cvdd_link\x7cvdd_link_dip\x7cvdd_x1\x7cvdd_x2\x7cvdd_x3__t16
+ a|d|inv_clk_vdd|inv_mc_vdd|inv_q_vdd|mpa_py|mpb_py|nand_m_vdd|nand_s2_vdd|nwell_vdd|sb_vdd|sr1_vdd|sr2_vdd|sr3_vdd|sr4_vdd|sv_d_vdd_tie|sv_vdd|tg_d_a|tg_d_vdd|tg_fbm_vdd|tg_fbs_vdd|tg_s_vdd|vdd|vdd_b1|vdd_b2|vdd_b3|vdd_b4|vdd_link|vdd_link_dip|vdd_x1|vdd_x2|vdd_x3
+ 157.861256621
* device instance a_d_inv_clk_vdd_inv_mc_vdd_inv_q_vdd_mpa_py_mpb_py_nand_m_vdd_nand_s2_vdd_nwell_vdd_sb_vdd_sr1_vdd_sr2_vdd_sr3_vdd_sr4_vdd_sv_d_vdd_tie_sv_vdd_tg_d_a_tg_d_vdd_tg_fbm_vdd_tg_fbs_vdd_tg_s_vdd_vdd_vdd_b1_vdd_b2_vdd_b3_vdd_b4_vdd_link_vdd_link_dip_vdd_x1_vdd_x2_vdd_x3_t17 r0 *1 0,0
Ra_d_inv_clk_vdd_inv_mc_vdd_inv_q_vdd_mpa_py_mpb_py_nand_m_vdd_nand_s2_vdd_nwell_vdd_sb_vdd_sr1_vdd_sr2_vdd_sr3_vdd_sr4_vdd_sv_d_vdd_tie_sv_vdd_tg_d_a_tg_d_vdd_tg_fbm_vdd_tg_fbs_vdd_tg_s_vdd_vdd_vdd_b1_vdd_b2_vdd_b3_vdd_b4_vdd_link_vdd_link_dip_vdd_x1_vdd_x2_vdd_x3_t17
+ a\x7cd\x7cinv_clk_vdd\x7cinv_mc_vdd\x7cinv_q_vdd\x7cmpa_py\x7cmpb_py\x7cnand_m_vdd\x7cnand_s2_vdd\x7cnwell_vdd\x7csb_vdd\x7csr1_vdd\x7csr2_vdd\x7csr3_vdd\x7csr4_vdd\x7csv_d_vdd_tie\x7csv_vdd\x7ctg_d_a\x7ctg_d_vdd\x7ctg_fbm_vdd\x7ctg_fbs_vdd\x7ctg_s_vdd\x7cvdd\x7cvdd_b1\x7cvdd_b2\x7cvdd_b3\x7cvdd_b4\x7cvdd_link\x7cvdd_link_dip\x7cvdd_x1\x7cvdd_x2\x7cvdd_x3__t17
+ a|d|inv_clk_vdd|inv_mc_vdd|inv_q_vdd|mpa_py|mpb_py|nand_m_vdd|nand_s2_vdd|nwell_vdd|sb_vdd|sr1_vdd|sr2_vdd|sr3_vdd|sr4_vdd|sv_d_vdd_tie|sv_vdd|tg_d_a|tg_d_vdd|tg_fbm_vdd|tg_fbs_vdd|tg_s_vdd|vdd|vdd_b1|vdd_b2|vdd_b3|vdd_b4|vdd_link|vdd_link_dip|vdd_x1|vdd_x2|vdd_x3
+ 125.980019738
* device instance a_d_inv_clk_vdd_inv_mc_vdd_inv_q_vdd_mpa_py_mpb_py_nand_m_vdd_nand_s2_vdd_nwell_vdd_sb_vdd_sr1_vdd_sr2_vdd_sr3_vdd_sr4_vdd_sv_d_vdd_tie_sv_vdd_tg_d_a_tg_d_vdd_tg_fbm_vdd_tg_fbs_vdd_tg_s_vdd_vdd_vdd_b1_vdd_b2_vdd_b3_vdd_b4_vdd_link_vdd_link_dip_vdd_x1_vdd_x2_vdd_x3_t18 r0 *1 0,0
Ra_d_inv_clk_vdd_inv_mc_vdd_inv_q_vdd_mpa_py_mpb_py_nand_m_vdd_nand_s2_vdd_nwell_vdd_sb_vdd_sr1_vdd_sr2_vdd_sr3_vdd_sr4_vdd_sv_d_vdd_tie_sv_vdd_tg_d_a_tg_d_vdd_tg_fbm_vdd_tg_fbs_vdd_tg_s_vdd_vdd_vdd_b1_vdd_b2_vdd_b3_vdd_b4_vdd_link_vdd_link_dip_vdd_x1_vdd_x2_vdd_x3_t18
+ a\x7cd\x7cinv_clk_vdd\x7cinv_mc_vdd\x7cinv_q_vdd\x7cmpa_py\x7cmpb_py\x7cnand_m_vdd\x7cnand_s2_vdd\x7cnwell_vdd\x7csb_vdd\x7csr1_vdd\x7csr2_vdd\x7csr3_vdd\x7csr4_vdd\x7csv_d_vdd_tie\x7csv_vdd\x7ctg_d_a\x7ctg_d_vdd\x7ctg_fbm_vdd\x7ctg_fbs_vdd\x7ctg_s_vdd\x7cvdd\x7cvdd_b1\x7cvdd_b2\x7cvdd_b3\x7cvdd_b4\x7cvdd_link\x7cvdd_link_dip\x7cvdd_x1\x7cvdd_x2\x7cvdd_x3__t18
+ a|d|inv_clk_vdd|inv_mc_vdd|inv_q_vdd|mpa_py|mpb_py|nand_m_vdd|nand_s2_vdd|nwell_vdd|sb_vdd|sr1_vdd|sr2_vdd|sr3_vdd|sr4_vdd|sv_d_vdd_tie|sv_vdd|tg_d_a|tg_d_vdd|tg_fbm_vdd|tg_fbs_vdd|tg_s_vdd|vdd|vdd_b1|vdd_b2|vdd_b3|vdd_b4|vdd_link|vdd_link_dip|vdd_x1|vdd_x2|vdd_x3
+ 168.560637731
* device instance a_d_inv_clk_vdd_inv_mc_vdd_inv_q_vdd_mpa_py_mpb_py_nand_m_vdd_nand_s2_vdd_nwell_vdd_sb_vdd_sr1_vdd_sr2_vdd_sr3_vdd_sr4_vdd_sv_d_vdd_tie_sv_vdd_tg_d_a_tg_d_vdd_tg_fbm_vdd_tg_fbs_vdd_tg_s_vdd_vdd_vdd_b1_vdd_b2_vdd_b3_vdd_b4_vdd_link_vdd_link_dip_vdd_x1_vdd_x2_vdd_x3_t19 r0 *1 0,0
Ra_d_inv_clk_vdd_inv_mc_vdd_inv_q_vdd_mpa_py_mpb_py_nand_m_vdd_nand_s2_vdd_nwell_vdd_sb_vdd_sr1_vdd_sr2_vdd_sr3_vdd_sr4_vdd_sv_d_vdd_tie_sv_vdd_tg_d_a_tg_d_vdd_tg_fbm_vdd_tg_fbs_vdd_tg_s_vdd_vdd_vdd_b1_vdd_b2_vdd_b3_vdd_b4_vdd_link_vdd_link_dip_vdd_x1_vdd_x2_vdd_x3_t19
+ a\x7cd\x7cinv_clk_vdd\x7cinv_mc_vdd\x7cinv_q_vdd\x7cmpa_py\x7cmpb_py\x7cnand_m_vdd\x7cnand_s2_vdd\x7cnwell_vdd\x7csb_vdd\x7csr1_vdd\x7csr2_vdd\x7csr3_vdd\x7csr4_vdd\x7csv_d_vdd_tie\x7csv_vdd\x7ctg_d_a\x7ctg_d_vdd\x7ctg_fbm_vdd\x7ctg_fbs_vdd\x7ctg_s_vdd\x7cvdd\x7cvdd_b1\x7cvdd_b2\x7cvdd_b3\x7cvdd_b4\x7cvdd_link\x7cvdd_link_dip\x7cvdd_x1\x7cvdd_x2\x7cvdd_x3__t19
+ a|d|inv_clk_vdd|inv_mc_vdd|inv_q_vdd|mpa_py|mpb_py|nand_m_vdd|nand_s2_vdd|nwell_vdd|sb_vdd|sr1_vdd|sr2_vdd|sr3_vdd|sr4_vdd|sv_d_vdd_tie|sv_vdd|tg_d_a|tg_d_vdd|tg_fbm_vdd|tg_fbs_vdd|tg_s_vdd|vdd|vdd_b1|vdd_b2|vdd_b3|vdd_b4|vdd_link|vdd_link_dip|vdd_x1|vdd_x2|vdd_x3
+ 125.980019738
* device instance a_d_inv_clk_vdd_inv_mc_vdd_inv_q_vdd_mpa_py_mpb_py_nand_m_vdd_nand_s2_vdd_nwell_vdd_sb_vdd_sr1_vdd_sr2_vdd_sr3_vdd_sr4_vdd_sv_d_vdd_tie_sv_vdd_tg_d_a_tg_d_vdd_tg_fbm_vdd_tg_fbs_vdd_tg_s_vdd_vdd_vdd_b1_vdd_b2_vdd_b3_vdd_b4_vdd_link_vdd_link_dip_vdd_x1_vdd_x2_vdd_x3_t20 r0 *1 0,0
Ra_d_inv_clk_vdd_inv_mc_vdd_inv_q_vdd_mpa_py_mpb_py_nand_m_vdd_nand_s2_vdd_nwell_vdd_sb_vdd_sr1_vdd_sr2_vdd_sr3_vdd_sr4_vdd_sv_d_vdd_tie_sv_vdd_tg_d_a_tg_d_vdd_tg_fbm_vdd_tg_fbs_vdd_tg_s_vdd_vdd_vdd_b1_vdd_b2_vdd_b3_vdd_b4_vdd_link_vdd_link_dip_vdd_x1_vdd_x2_vdd_x3_t20
+ a\x7cd\x7cinv_clk_vdd\x7cinv_mc_vdd\x7cinv_q_vdd\x7cmpa_py\x7cmpb_py\x7cnand_m_vdd\x7cnand_s2_vdd\x7cnwell_vdd\x7csb_vdd\x7csr1_vdd\x7csr2_vdd\x7csr3_vdd\x7csr4_vdd\x7csv_d_vdd_tie\x7csv_vdd\x7ctg_d_a\x7ctg_d_vdd\x7ctg_fbm_vdd\x7ctg_fbs_vdd\x7ctg_s_vdd\x7cvdd\x7cvdd_b1\x7cvdd_b2\x7cvdd_b3\x7cvdd_b4\x7cvdd_link\x7cvdd_link_dip\x7cvdd_x1\x7cvdd_x2\x7cvdd_x3__t20
+ a|d|inv_clk_vdd|inv_mc_vdd|inv_q_vdd|mpa_py|mpb_py|nand_m_vdd|nand_s2_vdd|nwell_vdd|sb_vdd|sr1_vdd|sr2_vdd|sr3_vdd|sr4_vdd|sv_d_vdd_tie|sv_vdd|tg_d_a|tg_d_vdd|tg_fbm_vdd|tg_fbs_vdd|tg_s_vdd|vdd|vdd_b1|vdd_b2|vdd_b3|vdd_b4|vdd_link|vdd_link_dip|vdd_x1|vdd_x2|vdd_x3
+ 121.521953679
* device instance a_d_inv_clk_vdd_inv_mc_vdd_inv_q_vdd_mpa_py_mpb_py_nand_m_vdd_nand_s2_vdd_nwell_vdd_sb_vdd_sr1_vdd_sr2_vdd_sr3_vdd_sr4_vdd_sv_d_vdd_tie_sv_vdd_tg_d_a_tg_d_vdd_tg_fbm_vdd_tg_fbs_vdd_tg_s_vdd_vdd_vdd_b1_vdd_b2_vdd_b3_vdd_b4_vdd_link_vdd_link_dip_vdd_x1_vdd_x2_vdd_x3_t21 r0 *1 0,0
Ra_d_inv_clk_vdd_inv_mc_vdd_inv_q_vdd_mpa_py_mpb_py_nand_m_vdd_nand_s2_vdd_nwell_vdd_sb_vdd_sr1_vdd_sr2_vdd_sr3_vdd_sr4_vdd_sv_d_vdd_tie_sv_vdd_tg_d_a_tg_d_vdd_tg_fbm_vdd_tg_fbs_vdd_tg_s_vdd_vdd_vdd_b1_vdd_b2_vdd_b3_vdd_b4_vdd_link_vdd_link_dip_vdd_x1_vdd_x2_vdd_x3_t21
+ a\x7cd\x7cinv_clk_vdd\x7cinv_mc_vdd\x7cinv_q_vdd\x7cmpa_py\x7cmpb_py\x7cnand_m_vdd\x7cnand_s2_vdd\x7cnwell_vdd\x7csb_vdd\x7csr1_vdd\x7csr2_vdd\x7csr3_vdd\x7csr4_vdd\x7csv_d_vdd_tie\x7csv_vdd\x7ctg_d_a\x7ctg_d_vdd\x7ctg_fbm_vdd\x7ctg_fbs_vdd\x7ctg_s_vdd\x7cvdd\x7cvdd_b1\x7cvdd_b2\x7cvdd_b3\x7cvdd_b4\x7cvdd_link\x7cvdd_link_dip\x7cvdd_x1\x7cvdd_x2\x7cvdd_x3__t21
+ a|d|inv_clk_vdd|inv_mc_vdd|inv_q_vdd|mpa_py|mpb_py|nand_m_vdd|nand_s2_vdd|nwell_vdd|sb_vdd|sr1_vdd|sr2_vdd|sr3_vdd|sr4_vdd|sv_d_vdd_tie|sv_vdd|tg_d_a|tg_d_vdd|tg_fbm_vdd|tg_fbs_vdd|tg_s_vdd|vdd|vdd_b1|vdd_b2|vdd_b3|vdd_b4|vdd_link|vdd_link_dip|vdd_x1|vdd_x2|vdd_x3
+ 72.7173046032
* device instance a_d_inv_clk_vdd_inv_mc_vdd_inv_q_vdd_mpa_py_mpb_py_nand_m_vdd_nand_s2_vdd_nwell_vdd_sb_vdd_sr1_vdd_sr2_vdd_sr3_vdd_sr4_vdd_sv_d_vdd_tie_sv_vdd_tg_d_a_tg_d_vdd_tg_fbm_vdd_tg_fbs_vdd_tg_s_vdd_vdd_vdd_b1_vdd_b2_vdd_b3_vdd_b4_vdd_link_vdd_link_dip_vdd_x1_vdd_x2_vdd_x3_t22 r0 *1 0,0
Ra_d_inv_clk_vdd_inv_mc_vdd_inv_q_vdd_mpa_py_mpb_py_nand_m_vdd_nand_s2_vdd_nwell_vdd_sb_vdd_sr1_vdd_sr2_vdd_sr3_vdd_sr4_vdd_sv_d_vdd_tie_sv_vdd_tg_d_a_tg_d_vdd_tg_fbm_vdd_tg_fbs_vdd_tg_s_vdd_vdd_vdd_b1_vdd_b2_vdd_b3_vdd_b4_vdd_link_vdd_link_dip_vdd_x1_vdd_x2_vdd_x3_t22
+ a\x7cd\x7cinv_clk_vdd\x7cinv_mc_vdd\x7cinv_q_vdd\x7cmpa_py\x7cmpb_py\x7cnand_m_vdd\x7cnand_s2_vdd\x7cnwell_vdd\x7csb_vdd\x7csr1_vdd\x7csr2_vdd\x7csr3_vdd\x7csr4_vdd\x7csv_d_vdd_tie\x7csv_vdd\x7ctg_d_a\x7ctg_d_vdd\x7ctg_fbm_vdd\x7ctg_fbs_vdd\x7ctg_s_vdd\x7cvdd\x7cvdd_b1\x7cvdd_b2\x7cvdd_b3\x7cvdd_b4\x7cvdd_link\x7cvdd_link_dip\x7cvdd_x1\x7cvdd_x2\x7cvdd_x3__t22
+ a|d|inv_clk_vdd|inv_mc_vdd|inv_q_vdd|mpa_py|mpb_py|nand_m_vdd|nand_s2_vdd|nwell_vdd|sb_vdd|sr1_vdd|sr2_vdd|sr3_vdd|sr4_vdd|sv_d_vdd_tie|sv_vdd|tg_d_a|tg_d_vdd|tg_fbm_vdd|tg_fbs_vdd|tg_s_vdd|vdd|vdd_b1|vdd_b2|vdd_b3|vdd_b4|vdd_link|vdd_link_dip|vdd_x1|vdd_x2|vdd_x3
+ 160.538922256
* device instance a_d_inv_clk_vdd_inv_mc_vdd_inv_q_vdd_mpa_py_mpb_py_nand_m_vdd_nand_s2_vdd_nwell_vdd_sb_vdd_sr1_vdd_sr2_vdd_sr3_vdd_sr4_vdd_sv_d_vdd_tie_sv_vdd_tg_d_a_tg_d_vdd_tg_fbm_vdd_tg_fbs_vdd_tg_s_vdd_vdd_vdd_b1_vdd_b2_vdd_b3_vdd_b4_vdd_link_vdd_link_dip_vdd_x1_vdd_x2_vdd_x3_t23 r0 *1 0,0
Ra_d_inv_clk_vdd_inv_mc_vdd_inv_q_vdd_mpa_py_mpb_py_nand_m_vdd_nand_s2_vdd_nwell_vdd_sb_vdd_sr1_vdd_sr2_vdd_sr3_vdd_sr4_vdd_sv_d_vdd_tie_sv_vdd_tg_d_a_tg_d_vdd_tg_fbm_vdd_tg_fbs_vdd_tg_s_vdd_vdd_vdd_b1_vdd_b2_vdd_b3_vdd_b4_vdd_link_vdd_link_dip_vdd_x1_vdd_x2_vdd_x3_t23
+ a\x7cd\x7cinv_clk_vdd\x7cinv_mc_vdd\x7cinv_q_vdd\x7cmpa_py\x7cmpb_py\x7cnand_m_vdd\x7cnand_s2_vdd\x7cnwell_vdd\x7csb_vdd\x7csr1_vdd\x7csr2_vdd\x7csr3_vdd\x7csr4_vdd\x7csv_d_vdd_tie\x7csv_vdd\x7ctg_d_a\x7ctg_d_vdd\x7ctg_fbm_vdd\x7ctg_fbs_vdd\x7ctg_s_vdd\x7cvdd\x7cvdd_b1\x7cvdd_b2\x7cvdd_b3\x7cvdd_b4\x7cvdd_link\x7cvdd_link_dip\x7cvdd_x1\x7cvdd_x2\x7cvdd_x3__t23
+ a|d|inv_clk_vdd|inv_mc_vdd|inv_q_vdd|mpa_py|mpb_py|nand_m_vdd|nand_s2_vdd|nwell_vdd|sb_vdd|sr1_vdd|sr2_vdd|sr3_vdd|sr4_vdd|sv_d_vdd_tie|sv_vdd|tg_d_a|tg_d_vdd|tg_fbm_vdd|tg_fbs_vdd|tg_s_vdd|vdd|vdd_b1|vdd_b2|vdd_b3|vdd_b4|vdd_link|vdd_link_dip|vdd_x1|vdd_x2|vdd_x3
+ 121.232452195
* device instance a_d_inv_clk_vdd_inv_mc_vdd_inv_q_vdd_mpa_py_mpb_py_nand_m_vdd_nand_s2_vdd_nwell_vdd_sb_vdd_sr1_vdd_sr2_vdd_sr3_vdd_sr4_vdd_sv_d_vdd_tie_sv_vdd_tg_d_a_tg_d_vdd_tg_fbm_vdd_tg_fbs_vdd_tg_s_vdd_vdd_vdd_b1_vdd_b2_vdd_b3_vdd_b4_vdd_link_vdd_link_dip_vdd_x1_vdd_x2_vdd_x3_t24 r0 *1 0,0
Ra_d_inv_clk_vdd_inv_mc_vdd_inv_q_vdd_mpa_py_mpb_py_nand_m_vdd_nand_s2_vdd_nwell_vdd_sb_vdd_sr1_vdd_sr2_vdd_sr3_vdd_sr4_vdd_sv_d_vdd_tie_sv_vdd_tg_d_a_tg_d_vdd_tg_fbm_vdd_tg_fbs_vdd_tg_s_vdd_vdd_vdd_b1_vdd_b2_vdd_b3_vdd_b4_vdd_link_vdd_link_dip_vdd_x1_vdd_x2_vdd_x3_t24
+ a\x7cd\x7cinv_clk_vdd\x7cinv_mc_vdd\x7cinv_q_vdd\x7cmpa_py\x7cmpb_py\x7cnand_m_vdd\x7cnand_s2_vdd\x7cnwell_vdd\x7csb_vdd\x7csr1_vdd\x7csr2_vdd\x7csr3_vdd\x7csr4_vdd\x7csv_d_vdd_tie\x7csv_vdd\x7ctg_d_a\x7ctg_d_vdd\x7ctg_fbm_vdd\x7ctg_fbs_vdd\x7ctg_s_vdd\x7cvdd\x7cvdd_b1\x7cvdd_b2\x7cvdd_b3\x7cvdd_b4\x7cvdd_link\x7cvdd_link_dip\x7cvdd_x1\x7cvdd_x2\x7cvdd_x3__t24
+ a|d|inv_clk_vdd|inv_mc_vdd|inv_q_vdd|mpa_py|mpb_py|nand_m_vdd|nand_s2_vdd|nwell_vdd|sb_vdd|sr1_vdd|sr2_vdd|sr3_vdd|sr4_vdd|sv_d_vdd_tie|sv_vdd|tg_d_a|tg_d_vdd|tg_fbm_vdd|tg_fbs_vdd|tg_s_vdd|vdd|vdd_b1|vdd_b2|vdd_b3|vdd_b4|vdd_link|vdd_link_dip|vdd_x1|vdd_x2|vdd_x3
+ 209.587200108
* device instance a_d_inv_clk_vdd_inv_mc_vdd_inv_q_vdd_mpa_py_mpb_py_nand_m_vdd_nand_s2_vdd_nwell_vdd_sb_vdd_sr1_vdd_sr2_vdd_sr3_vdd_sr4_vdd_sv_d_vdd_tie_sv_vdd_tg_d_a_tg_d_vdd_tg_fbm_vdd_tg_fbs_vdd_tg_s_vdd_vdd_vdd_b1_vdd_b2_vdd_b3_vdd_b4_vdd_link_vdd_link_dip_vdd_x1_vdd_x2_vdd_x3_t25 r0 *1 0,0
Ra_d_inv_clk_vdd_inv_mc_vdd_inv_q_vdd_mpa_py_mpb_py_nand_m_vdd_nand_s2_vdd_nwell_vdd_sb_vdd_sr1_vdd_sr2_vdd_sr3_vdd_sr4_vdd_sv_d_vdd_tie_sv_vdd_tg_d_a_tg_d_vdd_tg_fbm_vdd_tg_fbs_vdd_tg_s_vdd_vdd_vdd_b1_vdd_b2_vdd_b3_vdd_b4_vdd_link_vdd_link_dip_vdd_x1_vdd_x2_vdd_x3_t25
+ a\x7cd\x7cinv_clk_vdd\x7cinv_mc_vdd\x7cinv_q_vdd\x7cmpa_py\x7cmpb_py\x7cnand_m_vdd\x7cnand_s2_vdd\x7cnwell_vdd\x7csb_vdd\x7csr1_vdd\x7csr2_vdd\x7csr3_vdd\x7csr4_vdd\x7csv_d_vdd_tie\x7csv_vdd\x7ctg_d_a\x7ctg_d_vdd\x7ctg_fbm_vdd\x7ctg_fbs_vdd\x7ctg_s_vdd\x7cvdd\x7cvdd_b1\x7cvdd_b2\x7cvdd_b3\x7cvdd_b4\x7cvdd_link\x7cvdd_link_dip\x7cvdd_x1\x7cvdd_x2\x7cvdd_x3__t25
+ a|d|inv_clk_vdd|inv_mc_vdd|inv_q_vdd|mpa_py|mpb_py|nand_m_vdd|nand_s2_vdd|nwell_vdd|sb_vdd|sr1_vdd|sr2_vdd|sr3_vdd|sr4_vdd|sv_d_vdd_tie|sv_vdd|tg_d_a|tg_d_vdd|tg_fbm_vdd|tg_fbs_vdd|tg_s_vdd|vdd|vdd_b1|vdd_b2|vdd_b3|vdd_b4|vdd_link|vdd_link_dip|vdd_x1|vdd_x2|vdd_x3
+ 249.057437803
* device instance a_d_inv_clk_vdd_inv_mc_vdd_inv_q_vdd_mpa_py_mpb_py_nand_m_vdd_nand_s2_vdd_nwell_vdd_sb_vdd_sr1_vdd_sr2_vdd_sr3_vdd_sr4_vdd_sv_d_vdd_tie_sv_vdd_tg_d_a_tg_d_vdd_tg_fbm_vdd_tg_fbs_vdd_tg_s_vdd_vdd_vdd_b1_vdd_b2_vdd_b3_vdd_b4_vdd_link_vdd_link_dip_vdd_x1_vdd_x2_vdd_x3_t26 r0 *1 0,0
Ra_d_inv_clk_vdd_inv_mc_vdd_inv_q_vdd_mpa_py_mpb_py_nand_m_vdd_nand_s2_vdd_nwell_vdd_sb_vdd_sr1_vdd_sr2_vdd_sr3_vdd_sr4_vdd_sv_d_vdd_tie_sv_vdd_tg_d_a_tg_d_vdd_tg_fbm_vdd_tg_fbs_vdd_tg_s_vdd_vdd_vdd_b1_vdd_b2_vdd_b3_vdd_b4_vdd_link_vdd_link_dip_vdd_x1_vdd_x2_vdd_x3_t26
+ a\x7cd\x7cinv_clk_vdd\x7cinv_mc_vdd\x7cinv_q_vdd\x7cmpa_py\x7cmpb_py\x7cnand_m_vdd\x7cnand_s2_vdd\x7cnwell_vdd\x7csb_vdd\x7csr1_vdd\x7csr2_vdd\x7csr3_vdd\x7csr4_vdd\x7csv_d_vdd_tie\x7csv_vdd\x7ctg_d_a\x7ctg_d_vdd\x7ctg_fbm_vdd\x7ctg_fbs_vdd\x7ctg_s_vdd\x7cvdd\x7cvdd_b1\x7cvdd_b2\x7cvdd_b3\x7cvdd_b4\x7cvdd_link\x7cvdd_link_dip\x7cvdd_x1\x7cvdd_x2\x7cvdd_x3__t26
+ a|d|inv_clk_vdd|inv_mc_vdd|inv_q_vdd|mpa_py|mpb_py|nand_m_vdd|nand_s2_vdd|nwell_vdd|sb_vdd|sr1_vdd|sr2_vdd|sr3_vdd|sr4_vdd|sv_d_vdd_tie|sv_vdd|tg_d_a|tg_d_vdd|tg_fbm_vdd|tg_fbs_vdd|tg_s_vdd|vdd|vdd_b1|vdd_b2|vdd_b3|vdd_b4|vdd_link|vdd_link_dip|vdd_x1|vdd_x2|vdd_x3
+ 298.208323205
* device instance a_d_inv_clk_vdd_inv_mc_vdd_inv_q_vdd_mpa_py_mpb_py_nand_m_vdd_nand_s2_vdd_nwell_vdd_sb_vdd_sr1_vdd_sr2_vdd_sr3_vdd_sr4_vdd_sv_d_vdd_tie_sv_vdd_tg_d_a_tg_d_vdd_tg_fbm_vdd_tg_fbs_vdd_tg_s_vdd_vdd_vdd_b1_vdd_b2_vdd_b3_vdd_b4_vdd_link_vdd_link_dip_vdd_x1_vdd_x2_vdd_x3_t27 r0 *1 0,0
Ra_d_inv_clk_vdd_inv_mc_vdd_inv_q_vdd_mpa_py_mpb_py_nand_m_vdd_nand_s2_vdd_nwell_vdd_sb_vdd_sr1_vdd_sr2_vdd_sr3_vdd_sr4_vdd_sv_d_vdd_tie_sv_vdd_tg_d_a_tg_d_vdd_tg_fbm_vdd_tg_fbs_vdd_tg_s_vdd_vdd_vdd_b1_vdd_b2_vdd_b3_vdd_b4_vdd_link_vdd_link_dip_vdd_x1_vdd_x2_vdd_x3_t27
+ a\x7cd\x7cinv_clk_vdd\x7cinv_mc_vdd\x7cinv_q_vdd\x7cmpa_py\x7cmpb_py\x7cnand_m_vdd\x7cnand_s2_vdd\x7cnwell_vdd\x7csb_vdd\x7csr1_vdd\x7csr2_vdd\x7csr3_vdd\x7csr4_vdd\x7csv_d_vdd_tie\x7csv_vdd\x7ctg_d_a\x7ctg_d_vdd\x7ctg_fbm_vdd\x7ctg_fbs_vdd\x7ctg_s_vdd\x7cvdd\x7cvdd_b1\x7cvdd_b2\x7cvdd_b3\x7cvdd_b4\x7cvdd_link\x7cvdd_link_dip\x7cvdd_x1\x7cvdd_x2\x7cvdd_x3__t27
+ a|d|inv_clk_vdd|inv_mc_vdd|inv_q_vdd|mpa_py|mpb_py|nand_m_vdd|nand_s2_vdd|nwell_vdd|sb_vdd|sr1_vdd|sr2_vdd|sr3_vdd|sr4_vdd|sv_d_vdd_tie|sv_vdd|tg_d_a|tg_d_vdd|tg_fbm_vdd|tg_fbs_vdd|tg_s_vdd|vdd|vdd_b1|vdd_b2|vdd_b3|vdd_b4|vdd_link|vdd_link_dip|vdd_x1|vdd_x2|vdd_x3
+ 120.692173373
* device instance a_d_inv_clk_vdd_inv_mc_vdd_inv_q_vdd_mpa_py_mpb_py_nand_m_vdd_nand_s2_vdd_nwell_vdd_sb_vdd_sr1_vdd_sr2_vdd_sr3_vdd_sr4_vdd_sv_d_vdd_tie_sv_vdd_tg_d_a_tg_d_vdd_tg_fbm_vdd_tg_fbs_vdd_tg_s_vdd_vdd_vdd_b1_vdd_b2_vdd_b3_vdd_b4_vdd_link_vdd_link_dip_vdd_x1_vdd_x2_vdd_x3_t28 r0 *1 0,0
Ra_d_inv_clk_vdd_inv_mc_vdd_inv_q_vdd_mpa_py_mpb_py_nand_m_vdd_nand_s2_vdd_nwell_vdd_sb_vdd_sr1_vdd_sr2_vdd_sr3_vdd_sr4_vdd_sv_d_vdd_tie_sv_vdd_tg_d_a_tg_d_vdd_tg_fbm_vdd_tg_fbs_vdd_tg_s_vdd_vdd_vdd_b1_vdd_b2_vdd_b3_vdd_b4_vdd_link_vdd_link_dip_vdd_x1_vdd_x2_vdd_x3_t28
+ a\x7cd\x7cinv_clk_vdd\x7cinv_mc_vdd\x7cinv_q_vdd\x7cmpa_py\x7cmpb_py\x7cnand_m_vdd\x7cnand_s2_vdd\x7cnwell_vdd\x7csb_vdd\x7csr1_vdd\x7csr2_vdd\x7csr3_vdd\x7csr4_vdd\x7csv_d_vdd_tie\x7csv_vdd\x7ctg_d_a\x7ctg_d_vdd\x7ctg_fbm_vdd\x7ctg_fbs_vdd\x7ctg_s_vdd\x7cvdd\x7cvdd_b1\x7cvdd_b2\x7cvdd_b3\x7cvdd_b4\x7cvdd_link\x7cvdd_link_dip\x7cvdd_x1\x7cvdd_x2\x7cvdd_x3__t28
+ a|d|inv_clk_vdd|inv_mc_vdd|inv_q_vdd|mpa_py|mpb_py|nand_m_vdd|nand_s2_vdd|nwell_vdd|sb_vdd|sr1_vdd|sr2_vdd|sr3_vdd|sr4_vdd|sv_d_vdd_tie|sv_vdd|tg_d_a|tg_d_vdd|tg_fbm_vdd|tg_fbs_vdd|tg_s_vdd|vdd|vdd_b1|vdd_b2|vdd_b3|vdd_b4|vdd_link|vdd_link_dip|vdd_x1|vdd_x2|vdd_x3
+ 59.6162837122
* device instance a_d_inv_clk_vdd_inv_mc_vdd_inv_q_vdd_mpa_py_mpb_py_nand_m_vdd_nand_s2_vdd_nwell_vdd_sb_vdd_sr1_vdd_sr2_vdd_sr3_vdd_sr4_vdd_sv_d_vdd_tie_sv_vdd_tg_d_a_tg_d_vdd_tg_fbm_vdd_tg_fbs_vdd_tg_s_vdd_vdd_vdd_b1_vdd_b2_vdd_b3_vdd_b4_vdd_link_vdd_link_dip_vdd_x1_vdd_x2_vdd_x3_t29 r0 *1 0,0
Ra_d_inv_clk_vdd_inv_mc_vdd_inv_q_vdd_mpa_py_mpb_py_nand_m_vdd_nand_s2_vdd_nwell_vdd_sb_vdd_sr1_vdd_sr2_vdd_sr3_vdd_sr4_vdd_sv_d_vdd_tie_sv_vdd_tg_d_a_tg_d_vdd_tg_fbm_vdd_tg_fbs_vdd_tg_s_vdd_vdd_vdd_b1_vdd_b2_vdd_b3_vdd_b4_vdd_link_vdd_link_dip_vdd_x1_vdd_x2_vdd_x3_t29
+ a\x7cd\x7cinv_clk_vdd\x7cinv_mc_vdd\x7cinv_q_vdd\x7cmpa_py\x7cmpb_py\x7cnand_m_vdd\x7cnand_s2_vdd\x7cnwell_vdd\x7csb_vdd\x7csr1_vdd\x7csr2_vdd\x7csr3_vdd\x7csr4_vdd\x7csv_d_vdd_tie\x7csv_vdd\x7ctg_d_a\x7ctg_d_vdd\x7ctg_fbm_vdd\x7ctg_fbs_vdd\x7ctg_s_vdd\x7cvdd\x7cvdd_b1\x7cvdd_b2\x7cvdd_b3\x7cvdd_b4\x7cvdd_link\x7cvdd_link_dip\x7cvdd_x1\x7cvdd_x2\x7cvdd_x3__t29
+ a|d|inv_clk_vdd|inv_mc_vdd|inv_q_vdd|mpa_py|mpb_py|nand_m_vdd|nand_s2_vdd|nwell_vdd|sb_vdd|sr1_vdd|sr2_vdd|sr3_vdd|sr4_vdd|sv_d_vdd_tie|sv_vdd|tg_d_a|tg_d_vdd|tg_fbm_vdd|tg_fbs_vdd|tg_s_vdd|vdd|vdd_b1|vdd_b2|vdd_b3|vdd_b4|vdd_link|vdd_link_dip|vdd_x1|vdd_x2|vdd_x3
+ 35.2099854688
* device instance a_d_inv_clk_vdd_inv_mc_vdd_inv_q_vdd_mpa_py_mpb_py_nand_m_vdd_nand_s2_vdd_nwell_vdd_sb_vdd_sr1_vdd_sr2_vdd_sr3_vdd_sr4_vdd_sv_d_vdd_tie_sv_vdd_tg_d_a_tg_d_vdd_tg_fbm_vdd_tg_fbs_vdd_tg_s_vdd_vdd_vdd_b1_vdd_b2_vdd_b3_vdd_b4_vdd_link_vdd_link_dip_vdd_x1_vdd_x2_vdd_x3_t30 r0 *1 0,0
Ra_d_inv_clk_vdd_inv_mc_vdd_inv_q_vdd_mpa_py_mpb_py_nand_m_vdd_nand_s2_vdd_nwell_vdd_sb_vdd_sr1_vdd_sr2_vdd_sr3_vdd_sr4_vdd_sv_d_vdd_tie_sv_vdd_tg_d_a_tg_d_vdd_tg_fbm_vdd_tg_fbs_vdd_tg_s_vdd_vdd_vdd_b1_vdd_b2_vdd_b3_vdd_b4_vdd_link_vdd_link_dip_vdd_x1_vdd_x2_vdd_x3_t30
+ a\x7cd\x7cinv_clk_vdd\x7cinv_mc_vdd\x7cinv_q_vdd\x7cmpa_py\x7cmpb_py\x7cnand_m_vdd\x7cnand_s2_vdd\x7cnwell_vdd\x7csb_vdd\x7csr1_vdd\x7csr2_vdd\x7csr3_vdd\x7csr4_vdd\x7csv_d_vdd_tie\x7csv_vdd\x7ctg_d_a\x7ctg_d_vdd\x7ctg_fbm_vdd\x7ctg_fbs_vdd\x7ctg_s_vdd\x7cvdd\x7cvdd_b1\x7cvdd_b2\x7cvdd_b3\x7cvdd_b4\x7cvdd_link\x7cvdd_link_dip\x7cvdd_x1\x7cvdd_x2\x7cvdd_x3__t30
+ a|d|inv_clk_vdd|inv_mc_vdd|inv_q_vdd|mpa_py|mpb_py|nand_m_vdd|nand_s2_vdd|nwell_vdd|sb_vdd|sr1_vdd|sr2_vdd|sr3_vdd|sr4_vdd|sv_d_vdd_tie|sv_vdd|tg_d_a|tg_d_vdd|tg_fbm_vdd|tg_fbs_vdd|tg_s_vdd|vdd|vdd_b1|vdd_b2|vdd_b3|vdd_b4|vdd_link|vdd_link_dip|vdd_x1|vdd_x2|vdd_x3
+ 23.9747745283
* device instance a_d_inv_clk_vdd_inv_mc_vdd_inv_q_vdd_mpa_py_mpb_py_nand_m_vdd_nand_s2_vdd_nwell_vdd_sb_vdd_sr1_vdd_sr2_vdd_sr3_vdd_sr4_vdd_sv_d_vdd_tie_sv_vdd_tg_d_a_tg_d_vdd_tg_fbm_vdd_tg_fbs_vdd_tg_s_vdd_vdd_vdd_b1_vdd_b2_vdd_b3_vdd_b4_vdd_link_vdd_link_dip_vdd_x1_vdd_x2_vdd_x3_t31 r0 *1 0,0
Ra_d_inv_clk_vdd_inv_mc_vdd_inv_q_vdd_mpa_py_mpb_py_nand_m_vdd_nand_s2_vdd_nwell_vdd_sb_vdd_sr1_vdd_sr2_vdd_sr3_vdd_sr4_vdd_sv_d_vdd_tie_sv_vdd_tg_d_a_tg_d_vdd_tg_fbm_vdd_tg_fbs_vdd_tg_s_vdd_vdd_vdd_b1_vdd_b2_vdd_b3_vdd_b4_vdd_link_vdd_link_dip_vdd_x1_vdd_x2_vdd_x3_t31
+ a\x7cd\x7cinv_clk_vdd\x7cinv_mc_vdd\x7cinv_q_vdd\x7cmpa_py\x7cmpb_py\x7cnand_m_vdd\x7cnand_s2_vdd\x7cnwell_vdd\x7csb_vdd\x7csr1_vdd\x7csr2_vdd\x7csr3_vdd\x7csr4_vdd\x7csv_d_vdd_tie\x7csv_vdd\x7ctg_d_a\x7ctg_d_vdd\x7ctg_fbm_vdd\x7ctg_fbs_vdd\x7ctg_s_vdd\x7cvdd\x7cvdd_b1\x7cvdd_b2\x7cvdd_b3\x7cvdd_b4\x7cvdd_link\x7cvdd_link_dip\x7cvdd_x1\x7cvdd_x2\x7cvdd_x3__t31
+ a|d|inv_clk_vdd|inv_mc_vdd|inv_q_vdd|mpa_py|mpb_py|nand_m_vdd|nand_s2_vdd|nwell_vdd|sb_vdd|sr1_vdd|sr2_vdd|sr3_vdd|sr4_vdd|sv_d_vdd_tie|sv_vdd|tg_d_a|tg_d_vdd|tg_fbm_vdd|tg_fbs_vdd|tg_s_vdd|vdd|vdd_b1|vdd_b2|vdd_b3|vdd_b4|vdd_link|vdd_link_dip|vdd_x1|vdd_x2|vdd_x3
+ 107.859611691
* device instance a_d_inv_clk_vdd_inv_mc_vdd_inv_q_vdd_mpa_py_mpb_py_nand_m_vdd_nand_s2_vdd_nwell_vdd_sb_vdd_sr1_vdd_sr2_vdd_sr3_vdd_sr4_vdd_sv_d_vdd_tie_sv_vdd_tg_d_a_tg_d_vdd_tg_fbm_vdd_tg_fbs_vdd_tg_s_vdd_vdd_vdd_b1_vdd_b2_vdd_b3_vdd_b4_vdd_link_vdd_link_dip_vdd_x1_vdd_x2_vdd_x3_t32 r0 *1 0,0
Ra_d_inv_clk_vdd_inv_mc_vdd_inv_q_vdd_mpa_py_mpb_py_nand_m_vdd_nand_s2_vdd_nwell_vdd_sb_vdd_sr1_vdd_sr2_vdd_sr3_vdd_sr4_vdd_sv_d_vdd_tie_sv_vdd_tg_d_a_tg_d_vdd_tg_fbm_vdd_tg_fbs_vdd_tg_s_vdd_vdd_vdd_b1_vdd_b2_vdd_b3_vdd_b4_vdd_link_vdd_link_dip_vdd_x1_vdd_x2_vdd_x3_t32
+ a\x7cd\x7cinv_clk_vdd\x7cinv_mc_vdd\x7cinv_q_vdd\x7cmpa_py\x7cmpb_py\x7cnand_m_vdd\x7cnand_s2_vdd\x7cnwell_vdd\x7csb_vdd\x7csr1_vdd\x7csr2_vdd\x7csr3_vdd\x7csr4_vdd\x7csv_d_vdd_tie\x7csv_vdd\x7ctg_d_a\x7ctg_d_vdd\x7ctg_fbm_vdd\x7ctg_fbs_vdd\x7ctg_s_vdd\x7cvdd\x7cvdd_b1\x7cvdd_b2\x7cvdd_b3\x7cvdd_b4\x7cvdd_link\x7cvdd_link_dip\x7cvdd_x1\x7cvdd_x2\x7cvdd_x3__t32
+ a|d|inv_clk_vdd|inv_mc_vdd|inv_q_vdd|mpa_py|mpb_py|nand_m_vdd|nand_s2_vdd|nwell_vdd|sb_vdd|sr1_vdd|sr2_vdd|sr3_vdd|sr4_vdd|sv_d_vdd_tie|sv_vdd|tg_d_a|tg_d_vdd|tg_fbm_vdd|tg_fbs_vdd|tg_s_vdd|vdd|vdd_b1|vdd_b2|vdd_b3|vdd_b4|vdd_link|vdd_link_dip|vdd_x1|vdd_x2|vdd_x3
+ 147.106703063
* device instance a_d_inv_clk_vdd_inv_mc_vdd_inv_q_vdd_mpa_py_mpb_py_nand_m_vdd_nand_s2_vdd_nwell_vdd_sb_vdd_sr1_vdd_sr2_vdd_sr3_vdd_sr4_vdd_sv_d_vdd_tie_sv_vdd_tg_d_a_tg_d_vdd_tg_fbm_vdd_tg_fbs_vdd_tg_s_vdd_vdd_vdd_b1_vdd_b2_vdd_b3_vdd_b4_vdd_link_vdd_link_dip_vdd_x1_vdd_x2_vdd_x3_t33 r0 *1 0,0
Ra_d_inv_clk_vdd_inv_mc_vdd_inv_q_vdd_mpa_py_mpb_py_nand_m_vdd_nand_s2_vdd_nwell_vdd_sb_vdd_sr1_vdd_sr2_vdd_sr3_vdd_sr4_vdd_sv_d_vdd_tie_sv_vdd_tg_d_a_tg_d_vdd_tg_fbm_vdd_tg_fbs_vdd_tg_s_vdd_vdd_vdd_b1_vdd_b2_vdd_b3_vdd_b4_vdd_link_vdd_link_dip_vdd_x1_vdd_x2_vdd_x3_t33
+ a\x7cd\x7cinv_clk_vdd\x7cinv_mc_vdd\x7cinv_q_vdd\x7cmpa_py\x7cmpb_py\x7cnand_m_vdd\x7cnand_s2_vdd\x7cnwell_vdd\x7csb_vdd\x7csr1_vdd\x7csr2_vdd\x7csr3_vdd\x7csr4_vdd\x7csv_d_vdd_tie\x7csv_vdd\x7ctg_d_a\x7ctg_d_vdd\x7ctg_fbm_vdd\x7ctg_fbs_vdd\x7ctg_s_vdd\x7cvdd\x7cvdd_b1\x7cvdd_b2\x7cvdd_b3\x7cvdd_b4\x7cvdd_link\x7cvdd_link_dip\x7cvdd_x1\x7cvdd_x2\x7cvdd_x3__t33
+ a|d|inv_clk_vdd|inv_mc_vdd|inv_q_vdd|mpa_py|mpb_py|nand_m_vdd|nand_s2_vdd|nwell_vdd|sb_vdd|sr1_vdd|sr2_vdd|sr3_vdd|sr4_vdd|sv_d_vdd_tie|sv_vdd|tg_d_a|tg_d_vdd|tg_fbm_vdd|tg_fbs_vdd|tg_s_vdd|vdd|vdd_b1|vdd_b2|vdd_b3|vdd_b4|vdd_link|vdd_link_dip|vdd_x1|vdd_x2|vdd_x3
+ 196.123747797
* device instance a_d_inv_clk_vdd_inv_mc_vdd_inv_q_vdd_mpa_py_mpb_py_nand_m_vdd_nand_s2_vdd_nwell_vdd_sb_vdd_sr1_vdd_sr2_vdd_sr3_vdd_sr4_vdd_sv_d_vdd_tie_sv_vdd_tg_d_a_tg_d_vdd_tg_fbm_vdd_tg_fbs_vdd_tg_s_vdd_vdd_vdd_b1_vdd_b2_vdd_b3_vdd_b4_vdd_link_vdd_link_dip_vdd_x1_vdd_x2_vdd_x3_t34 r0 *1 0,0
Ra_d_inv_clk_vdd_inv_mc_vdd_inv_q_vdd_mpa_py_mpb_py_nand_m_vdd_nand_s2_vdd_nwell_vdd_sb_vdd_sr1_vdd_sr2_vdd_sr3_vdd_sr4_vdd_sv_d_vdd_tie_sv_vdd_tg_d_a_tg_d_vdd_tg_fbm_vdd_tg_fbs_vdd_tg_s_vdd_vdd_vdd_b1_vdd_b2_vdd_b3_vdd_b4_vdd_link_vdd_link_dip_vdd_x1_vdd_x2_vdd_x3_t34
+ a\x7cd\x7cinv_clk_vdd\x7cinv_mc_vdd\x7cinv_q_vdd\x7cmpa_py\x7cmpb_py\x7cnand_m_vdd\x7cnand_s2_vdd\x7cnwell_vdd\x7csb_vdd\x7csr1_vdd\x7csr2_vdd\x7csr3_vdd\x7csr4_vdd\x7csv_d_vdd_tie\x7csv_vdd\x7ctg_d_a\x7ctg_d_vdd\x7ctg_fbm_vdd\x7ctg_fbs_vdd\x7ctg_s_vdd\x7cvdd\x7cvdd_b1\x7cvdd_b2\x7cvdd_b3\x7cvdd_b4\x7cvdd_link\x7cvdd_link_dip\x7cvdd_x1\x7cvdd_x2\x7cvdd_x3__t34
+ a|d|inv_clk_vdd|inv_mc_vdd|inv_q_vdd|mpa_py|mpb_py|nand_m_vdd|nand_s2_vdd|nwell_vdd|sb_vdd|sr1_vdd|sr2_vdd|sr3_vdd|sr4_vdd|sv_d_vdd_tie|sv_vdd|tg_d_a|tg_d_vdd|tg_fbm_vdd|tg_fbs_vdd|tg_s_vdd|vdd|vdd_b1|vdd_b2|vdd_b3|vdd_b4|vdd_link|vdd_link_dip|vdd_x1|vdd_x2|vdd_x3
+ 55.0030748458
* device instance a_d_inv_clk_vdd_inv_mc_vdd_inv_q_vdd_mpa_py_mpb_py_nand_m_vdd_nand_s2_vdd_nwell_vdd_sb_vdd_sr1_vdd_sr2_vdd_sr3_vdd_sr4_vdd_sv_d_vdd_tie_sv_vdd_tg_d_a_tg_d_vdd_tg_fbm_vdd_tg_fbs_vdd_tg_s_vdd_vdd_vdd_b1_vdd_b2_vdd_b3_vdd_b4_vdd_link_vdd_link_dip_vdd_x1_vdd_x2_vdd_x3_t35 r0 *1 0,0
Ra_d_inv_clk_vdd_inv_mc_vdd_inv_q_vdd_mpa_py_mpb_py_nand_m_vdd_nand_s2_vdd_nwell_vdd_sb_vdd_sr1_vdd_sr2_vdd_sr3_vdd_sr4_vdd_sv_d_vdd_tie_sv_vdd_tg_d_a_tg_d_vdd_tg_fbm_vdd_tg_fbs_vdd_tg_s_vdd_vdd_vdd_b1_vdd_b2_vdd_b3_vdd_b4_vdd_link_vdd_link_dip_vdd_x1_vdd_x2_vdd_x3_t35
+ a\x7cd\x7cinv_clk_vdd\x7cinv_mc_vdd\x7cinv_q_vdd\x7cmpa_py\x7cmpb_py\x7cnand_m_vdd\x7cnand_s2_vdd\x7cnwell_vdd\x7csb_vdd\x7csr1_vdd\x7csr2_vdd\x7csr3_vdd\x7csr4_vdd\x7csv_d_vdd_tie\x7csv_vdd\x7ctg_d_a\x7ctg_d_vdd\x7ctg_fbm_vdd\x7ctg_fbs_vdd\x7ctg_s_vdd\x7cvdd\x7cvdd_b1\x7cvdd_b2\x7cvdd_b3\x7cvdd_b4\x7cvdd_link\x7cvdd_link_dip\x7cvdd_x1\x7cvdd_x2\x7cvdd_x3__t35
+ a|d|inv_clk_vdd|inv_mc_vdd|inv_q_vdd|mpa_py|mpb_py|nand_m_vdd|nand_s2_vdd|nwell_vdd|sb_vdd|sr1_vdd|sr2_vdd|sr3_vdd|sr4_vdd|sv_d_vdd_tie|sv_vdd|tg_d_a|tg_d_vdd|tg_fbm_vdd|tg_fbs_vdd|tg_s_vdd|vdd|vdd_b1|vdd_b2|vdd_b3|vdd_b4|vdd_link|vdd_link_dip|vdd_x1|vdd_x2|vdd_x3
+ 102.703905242
* device instance a_d_inv_clk_vdd_inv_mc_vdd_inv_q_vdd_mpa_py_mpb_py_nand_m_vdd_nand_s2_vdd_nwell_vdd_sb_vdd_sr1_vdd_sr2_vdd_sr3_vdd_sr4_vdd_sv_d_vdd_tie_sv_vdd_tg_d_a_tg_d_vdd_tg_fbm_vdd_tg_fbs_vdd_tg_s_vdd_vdd_vdd_b1_vdd_b2_vdd_b3_vdd_b4_vdd_link_vdd_link_dip_vdd_x1_vdd_x2_vdd_x3_t36 r0 *1 0,0
Ra_d_inv_clk_vdd_inv_mc_vdd_inv_q_vdd_mpa_py_mpb_py_nand_m_vdd_nand_s2_vdd_nwell_vdd_sb_vdd_sr1_vdd_sr2_vdd_sr3_vdd_sr4_vdd_sv_d_vdd_tie_sv_vdd_tg_d_a_tg_d_vdd_tg_fbm_vdd_tg_fbs_vdd_tg_s_vdd_vdd_vdd_b1_vdd_b2_vdd_b3_vdd_b4_vdd_link_vdd_link_dip_vdd_x1_vdd_x2_vdd_x3_t36
+ a\x7cd\x7cinv_clk_vdd\x7cinv_mc_vdd\x7cinv_q_vdd\x7cmpa_py\x7cmpb_py\x7cnand_m_vdd\x7cnand_s2_vdd\x7cnwell_vdd\x7csb_vdd\x7csr1_vdd\x7csr2_vdd\x7csr3_vdd\x7csr4_vdd\x7csv_d_vdd_tie\x7csv_vdd\x7ctg_d_a\x7ctg_d_vdd\x7ctg_fbm_vdd\x7ctg_fbs_vdd\x7ctg_s_vdd\x7cvdd\x7cvdd_b1\x7cvdd_b2\x7cvdd_b3\x7cvdd_b4\x7cvdd_link\x7cvdd_link_dip\x7cvdd_x1\x7cvdd_x2\x7cvdd_x3__t36
+ a|d|inv_clk_vdd|inv_mc_vdd|inv_q_vdd|mpa_py|mpb_py|nand_m_vdd|nand_s2_vdd|nwell_vdd|sb_vdd|sr1_vdd|sr2_vdd|sr3_vdd|sr4_vdd|sv_d_vdd_tie|sv_vdd|tg_d_a|tg_d_vdd|tg_fbm_vdd|tg_fbs_vdd|tg_s_vdd|vdd|vdd_b1|vdd_b2|vdd_b3|vdd_b4|vdd_link|vdd_link_dip|vdd_x1|vdd_x2|vdd_x3
+ 140.54070116
* device instance a_d_inv_clk_vdd_inv_mc_vdd_inv_q_vdd_mpa_py_mpb_py_nand_m_vdd_nand_s2_vdd_nwell_vdd_sb_vdd_sr1_vdd_sr2_vdd_sr3_vdd_sr4_vdd_sv_d_vdd_tie_sv_vdd_tg_d_a_tg_d_vdd_tg_fbm_vdd_tg_fbs_vdd_tg_s_vdd_vdd_vdd_b1_vdd_b2_vdd_b3_vdd_b4_vdd_link_vdd_link_dip_vdd_x1_vdd_x2_vdd_x3_t37 r0 *1 0,0
Ra_d_inv_clk_vdd_inv_mc_vdd_inv_q_vdd_mpa_py_mpb_py_nand_m_vdd_nand_s2_vdd_nwell_vdd_sb_vdd_sr1_vdd_sr2_vdd_sr3_vdd_sr4_vdd_sv_d_vdd_tie_sv_vdd_tg_d_a_tg_d_vdd_tg_fbm_vdd_tg_fbs_vdd_tg_s_vdd_vdd_vdd_b1_vdd_b2_vdd_b3_vdd_b4_vdd_link_vdd_link_dip_vdd_x1_vdd_x2_vdd_x3_t37
+ a\x7cd\x7cinv_clk_vdd\x7cinv_mc_vdd\x7cinv_q_vdd\x7cmpa_py\x7cmpb_py\x7cnand_m_vdd\x7cnand_s2_vdd\x7cnwell_vdd\x7csb_vdd\x7csr1_vdd\x7csr2_vdd\x7csr3_vdd\x7csr4_vdd\x7csv_d_vdd_tie\x7csv_vdd\x7ctg_d_a\x7ctg_d_vdd\x7ctg_fbm_vdd\x7ctg_fbs_vdd\x7ctg_s_vdd\x7cvdd\x7cvdd_b1\x7cvdd_b2\x7cvdd_b3\x7cvdd_b4\x7cvdd_link\x7cvdd_link_dip\x7cvdd_x1\x7cvdd_x2\x7cvdd_x3__t37
+ a|d|inv_clk_vdd|inv_mc_vdd|inv_q_vdd|mpa_py|mpb_py|nand_m_vdd|nand_s2_vdd|nwell_vdd|sb_vdd|sr1_vdd|sr2_vdd|sr3_vdd|sr4_vdd|sv_d_vdd_tie|sv_vdd|tg_d_a|tg_d_vdd|tg_fbm_vdd|tg_fbs_vdd|tg_s_vdd|vdd|vdd_b1|vdd_b2|vdd_b3|vdd_b4|vdd_link|vdd_link_dip|vdd_x1|vdd_x2|vdd_x3
+ 72.7173046032
* device instance a_d_inv_clk_vdd_inv_mc_vdd_inv_q_vdd_mpa_py_mpb_py_nand_m_vdd_nand_s2_vdd_nwell_vdd_sb_vdd_sr1_vdd_sr2_vdd_sr3_vdd_sr4_vdd_sv_d_vdd_tie_sv_vdd_tg_d_a_tg_d_vdd_tg_fbm_vdd_tg_fbs_vdd_tg_s_vdd_vdd_vdd_b1_vdd_b2_vdd_b3_vdd_b4_vdd_link_vdd_link_dip_vdd_x1_vdd_x2_vdd_x3_t38 r0 *1 0,0
Ra_d_inv_clk_vdd_inv_mc_vdd_inv_q_vdd_mpa_py_mpb_py_nand_m_vdd_nand_s2_vdd_nwell_vdd_sb_vdd_sr1_vdd_sr2_vdd_sr3_vdd_sr4_vdd_sv_d_vdd_tie_sv_vdd_tg_d_a_tg_d_vdd_tg_fbm_vdd_tg_fbs_vdd_tg_s_vdd_vdd_vdd_b1_vdd_b2_vdd_b3_vdd_b4_vdd_link_vdd_link_dip_vdd_x1_vdd_x2_vdd_x3_t38
+ a\x7cd\x7cinv_clk_vdd\x7cinv_mc_vdd\x7cinv_q_vdd\x7cmpa_py\x7cmpb_py\x7cnand_m_vdd\x7cnand_s2_vdd\x7cnwell_vdd\x7csb_vdd\x7csr1_vdd\x7csr2_vdd\x7csr3_vdd\x7csr4_vdd\x7csv_d_vdd_tie\x7csv_vdd\x7ctg_d_a\x7ctg_d_vdd\x7ctg_fbm_vdd\x7ctg_fbs_vdd\x7ctg_s_vdd\x7cvdd\x7cvdd_b1\x7cvdd_b2\x7cvdd_b3\x7cvdd_b4\x7cvdd_link\x7cvdd_link_dip\x7cvdd_x1\x7cvdd_x2\x7cvdd_x3__t38
+ a|d|inv_clk_vdd|inv_mc_vdd|inv_q_vdd|mpa_py|mpb_py|nand_m_vdd|nand_s2_vdd|nwell_vdd|sb_vdd|sr1_vdd|sr2_vdd|sr3_vdd|sr4_vdd|sv_d_vdd_tie|sv_vdd|tg_d_a|tg_d_vdd|tg_fbm_vdd|tg_fbs_vdd|tg_s_vdd|vdd|vdd_b1|vdd_b2|vdd_b3|vdd_b4|vdd_link|vdd_link_dip|vdd_x1|vdd_x2|vdd_x3
+ 70.7109821764
* device instance a_d_inv_clk_vdd_inv_mc_vdd_inv_q_vdd_mpa_py_mpb_py_nand_m_vdd_nand_s2_vdd_nwell_vdd_sb_vdd_sr1_vdd_sr2_vdd_sr3_vdd_sr4_vdd_sv_d_vdd_tie_sv_vdd_tg_d_a_tg_d_vdd_tg_fbm_vdd_tg_fbs_vdd_tg_s_vdd_vdd_vdd_b1_vdd_b2_vdd_b3_vdd_b4_vdd_link_vdd_link_dip_vdd_x1_vdd_x2_vdd_x3_t39 r0 *1 0,0
Ra_d_inv_clk_vdd_inv_mc_vdd_inv_q_vdd_mpa_py_mpb_py_nand_m_vdd_nand_s2_vdd_nwell_vdd_sb_vdd_sr1_vdd_sr2_vdd_sr3_vdd_sr4_vdd_sv_d_vdd_tie_sv_vdd_tg_d_a_tg_d_vdd_tg_fbm_vdd_tg_fbs_vdd_tg_s_vdd_vdd_vdd_b1_vdd_b2_vdd_b3_vdd_b4_vdd_link_vdd_link_dip_vdd_x1_vdd_x2_vdd_x3_t39
+ a\x7cd\x7cinv_clk_vdd\x7cinv_mc_vdd\x7cinv_q_vdd\x7cmpa_py\x7cmpb_py\x7cnand_m_vdd\x7cnand_s2_vdd\x7cnwell_vdd\x7csb_vdd\x7csr1_vdd\x7csr2_vdd\x7csr3_vdd\x7csr4_vdd\x7csv_d_vdd_tie\x7csv_vdd\x7ctg_d_a\x7ctg_d_vdd\x7ctg_fbm_vdd\x7ctg_fbs_vdd\x7ctg_s_vdd\x7cvdd\x7cvdd_b1\x7cvdd_b2\x7cvdd_b3\x7cvdd_b4\x7cvdd_link\x7cvdd_link_dip\x7cvdd_x1\x7cvdd_x2\x7cvdd_x3__t39
+ a|d|inv_clk_vdd|inv_mc_vdd|inv_q_vdd|mpa_py|mpb_py|nand_m_vdd|nand_s2_vdd|nwell_vdd|sb_vdd|sr1_vdd|sr2_vdd|sr3_vdd|sr4_vdd|sv_d_vdd_tie|sv_vdd|tg_d_a|tg_d_vdd|tg_fbm_vdd|tg_fbs_vdd|tg_s_vdd|vdd|vdd_b1|vdd_b2|vdd_b3|vdd_b4|vdd_link|vdd_link_dip|vdd_x1|vdd_x2|vdd_x3
+ 305.817696169
* device instance a_d_inv_clk_vdd_inv_mc_vdd_inv_q_vdd_mpa_py_mpb_py_nand_m_vdd_nand_s2_vdd_nwell_vdd_sb_vdd_sr1_vdd_sr2_vdd_sr3_vdd_sr4_vdd_sv_d_vdd_tie_sv_vdd_tg_d_a_tg_d_vdd_tg_fbm_vdd_tg_fbs_vdd_tg_s_vdd_vdd_vdd_b1_vdd_b2_vdd_b3_vdd_b4_vdd_link_vdd_link_dip_vdd_x1_vdd_x2_vdd_x3_t40 r0 *1 0,0
Ra_d_inv_clk_vdd_inv_mc_vdd_inv_q_vdd_mpa_py_mpb_py_nand_m_vdd_nand_s2_vdd_nwell_vdd_sb_vdd_sr1_vdd_sr2_vdd_sr3_vdd_sr4_vdd_sv_d_vdd_tie_sv_vdd_tg_d_a_tg_d_vdd_tg_fbm_vdd_tg_fbs_vdd_tg_s_vdd_vdd_vdd_b1_vdd_b2_vdd_b3_vdd_b4_vdd_link_vdd_link_dip_vdd_x1_vdd_x2_vdd_x3_t40
+ a\x7cd\x7cinv_clk_vdd\x7cinv_mc_vdd\x7cinv_q_vdd\x7cmpa_py\x7cmpb_py\x7cnand_m_vdd\x7cnand_s2_vdd\x7cnwell_vdd\x7csb_vdd\x7csr1_vdd\x7csr2_vdd\x7csr3_vdd\x7csr4_vdd\x7csv_d_vdd_tie\x7csv_vdd\x7ctg_d_a\x7ctg_d_vdd\x7ctg_fbm_vdd\x7ctg_fbs_vdd\x7ctg_s_vdd\x7cvdd\x7cvdd_b1\x7cvdd_b2\x7cvdd_b3\x7cvdd_b4\x7cvdd_link\x7cvdd_link_dip\x7cvdd_x1\x7cvdd_x2\x7cvdd_x3__t40
+ a|d|inv_clk_vdd|inv_mc_vdd|inv_q_vdd|mpa_py|mpb_py|nand_m_vdd|nand_s2_vdd|nwell_vdd|sb_vdd|sr1_vdd|sr2_vdd|sr3_vdd|sr4_vdd|sv_d_vdd_tie|sv_vdd|tg_d_a|tg_d_vdd|tg_fbm_vdd|tg_fbs_vdd|tg_s_vdd|vdd|vdd_b1|vdd_b2|vdd_b3|vdd_b4|vdd_link|vdd_link_dip|vdd_x1|vdd_x2|vdd_x3
+ 285.928833001
* device instance a_d_inv_clk_vdd_inv_mc_vdd_inv_q_vdd_mpa_py_mpb_py_nand_m_vdd_nand_s2_vdd_nwell_vdd_sb_vdd_sr1_vdd_sr2_vdd_sr3_vdd_sr4_vdd_sv_d_vdd_tie_sv_vdd_tg_d_a_tg_d_vdd_tg_fbm_vdd_tg_fbs_vdd_tg_s_vdd_vdd_vdd_b1_vdd_b2_vdd_b3_vdd_b4_vdd_link_vdd_link_dip_vdd_x1_vdd_x2_vdd_x3_t41 r0 *1 0,0
Ra_d_inv_clk_vdd_inv_mc_vdd_inv_q_vdd_mpa_py_mpb_py_nand_m_vdd_nand_s2_vdd_nwell_vdd_sb_vdd_sr1_vdd_sr2_vdd_sr3_vdd_sr4_vdd_sv_d_vdd_tie_sv_vdd_tg_d_a_tg_d_vdd_tg_fbm_vdd_tg_fbs_vdd_tg_s_vdd_vdd_vdd_b1_vdd_b2_vdd_b3_vdd_b4_vdd_link_vdd_link_dip_vdd_x1_vdd_x2_vdd_x3_t41
+ a\x7cd\x7cinv_clk_vdd\x7cinv_mc_vdd\x7cinv_q_vdd\x7cmpa_py\x7cmpb_py\x7cnand_m_vdd\x7cnand_s2_vdd\x7cnwell_vdd\x7csb_vdd\x7csr1_vdd\x7csr2_vdd\x7csr3_vdd\x7csr4_vdd\x7csv_d_vdd_tie\x7csv_vdd\x7ctg_d_a\x7ctg_d_vdd\x7ctg_fbm_vdd\x7ctg_fbs_vdd\x7ctg_s_vdd\x7cvdd\x7cvdd_b1\x7cvdd_b2\x7cvdd_b3\x7cvdd_b4\x7cvdd_link\x7cvdd_link_dip\x7cvdd_x1\x7cvdd_x2\x7cvdd_x3__t41
+ a|d|inv_clk_vdd|inv_mc_vdd|inv_q_vdd|mpa_py|mpb_py|nand_m_vdd|nand_s2_vdd|nwell_vdd|sb_vdd|sr1_vdd|sr2_vdd|sr3_vdd|sr4_vdd|sv_d_vdd_tie|sv_vdd|tg_d_a|tg_d_vdd|tg_fbm_vdd|tg_fbs_vdd|tg_s_vdd|vdd|vdd_b1|vdd_b2|vdd_b3|vdd_b4|vdd_link|vdd_link_dip|vdd_x1|vdd_x2|vdd_x3
+ 275.090177955
* device instance a_d_inv_clk_vdd_inv_mc_vdd_inv_q_vdd_mpa_py_mpb_py_nand_m_vdd_nand_s2_vdd_nwell_vdd_sb_vdd_sr1_vdd_sr2_vdd_sr3_vdd_sr4_vdd_sv_d_vdd_tie_sv_vdd_tg_d_a_tg_d_vdd_tg_fbm_vdd_tg_fbs_vdd_tg_s_vdd_vdd_vdd_b1_vdd_b2_vdd_b3_vdd_b4_vdd_link_vdd_link_dip_vdd_x1_vdd_x2_vdd_x3_t42 r0 *1 0,0
Ra_d_inv_clk_vdd_inv_mc_vdd_inv_q_vdd_mpa_py_mpb_py_nand_m_vdd_nand_s2_vdd_nwell_vdd_sb_vdd_sr1_vdd_sr2_vdd_sr3_vdd_sr4_vdd_sv_d_vdd_tie_sv_vdd_tg_d_a_tg_d_vdd_tg_fbm_vdd_tg_fbs_vdd_tg_s_vdd_vdd_vdd_b1_vdd_b2_vdd_b3_vdd_b4_vdd_link_vdd_link_dip_vdd_x1_vdd_x2_vdd_x3_t42
+ a\x7cd\x7cinv_clk_vdd\x7cinv_mc_vdd\x7cinv_q_vdd\x7cmpa_py\x7cmpb_py\x7cnand_m_vdd\x7cnand_s2_vdd\x7cnwell_vdd\x7csb_vdd\x7csr1_vdd\x7csr2_vdd\x7csr3_vdd\x7csr4_vdd\x7csv_d_vdd_tie\x7csv_vdd\x7ctg_d_a\x7ctg_d_vdd\x7ctg_fbm_vdd\x7ctg_fbs_vdd\x7ctg_s_vdd\x7cvdd\x7cvdd_b1\x7cvdd_b2\x7cvdd_b3\x7cvdd_b4\x7cvdd_link\x7cvdd_link_dip\x7cvdd_x1\x7cvdd_x2\x7cvdd_x3__t42
+ a|d|inv_clk_vdd|inv_mc_vdd|inv_q_vdd|mpa_py|mpb_py|nand_m_vdd|nand_s2_vdd|nwell_vdd|sb_vdd|sr1_vdd|sr2_vdd|sr3_vdd|sr4_vdd|sv_d_vdd_tie|sv_vdd|tg_d_a|tg_d_vdd|tg_fbm_vdd|tg_fbs_vdd|tg_s_vdd|vdd|vdd_b1|vdd_b2|vdd_b3|vdd_b4|vdd_link|vdd_link_dip|vdd_x1|vdd_x2|vdd_x3
+ 266.904441326
* device instance a_d_inv_clk_vdd_inv_mc_vdd_inv_q_vdd_mpa_py_mpb_py_nand_m_vdd_nand_s2_vdd_nwell_vdd_sb_vdd_sr1_vdd_sr2_vdd_sr3_vdd_sr4_vdd_sv_d_vdd_tie_sv_vdd_tg_d_a_tg_d_vdd_tg_fbm_vdd_tg_fbs_vdd_tg_s_vdd_vdd_vdd_b1_vdd_b2_vdd_b3_vdd_b4_vdd_link_vdd_link_dip_vdd_x1_vdd_x2_vdd_x3_t43 r0 *1 0,0
Ra_d_inv_clk_vdd_inv_mc_vdd_inv_q_vdd_mpa_py_mpb_py_nand_m_vdd_nand_s2_vdd_nwell_vdd_sb_vdd_sr1_vdd_sr2_vdd_sr3_vdd_sr4_vdd_sv_d_vdd_tie_sv_vdd_tg_d_a_tg_d_vdd_tg_fbm_vdd_tg_fbs_vdd_tg_s_vdd_vdd_vdd_b1_vdd_b2_vdd_b3_vdd_b4_vdd_link_vdd_link_dip_vdd_x1_vdd_x2_vdd_x3_t43
+ a\x7cd\x7cinv_clk_vdd\x7cinv_mc_vdd\x7cinv_q_vdd\x7cmpa_py\x7cmpb_py\x7cnand_m_vdd\x7cnand_s2_vdd\x7cnwell_vdd\x7csb_vdd\x7csr1_vdd\x7csr2_vdd\x7csr3_vdd\x7csr4_vdd\x7csv_d_vdd_tie\x7csv_vdd\x7ctg_d_a\x7ctg_d_vdd\x7ctg_fbm_vdd\x7ctg_fbs_vdd\x7ctg_s_vdd\x7cvdd\x7cvdd_b1\x7cvdd_b2\x7cvdd_b3\x7cvdd_b4\x7cvdd_link\x7cvdd_link_dip\x7cvdd_x1\x7cvdd_x2\x7cvdd_x3__t43
+ a|d|inv_clk_vdd|inv_mc_vdd|inv_q_vdd|mpa_py|mpb_py|nand_m_vdd|nand_s2_vdd|nwell_vdd|sb_vdd|sr1_vdd|sr2_vdd|sr3_vdd|sr4_vdd|sv_d_vdd_tie|sv_vdd|tg_d_a|tg_d_vdd|tg_fbm_vdd|tg_fbs_vdd|tg_s_vdd|vdd|vdd_b1|vdd_b2|vdd_b3|vdd_b4|vdd_link|vdd_link_dip|vdd_x1|vdd_x2|vdd_x3
+ 259.316753764
* device instance a_d_inv_clk_vdd_inv_mc_vdd_inv_q_vdd_mpa_py_mpb_py_nand_m_vdd_nand_s2_vdd_nwell_vdd_sb_vdd_sr1_vdd_sr2_vdd_sr3_vdd_sr4_vdd_sv_d_vdd_tie_sv_vdd_tg_d_a_tg_d_vdd_tg_fbm_vdd_tg_fbs_vdd_tg_s_vdd_vdd_vdd_b1_vdd_b2_vdd_b3_vdd_b4_vdd_link_vdd_link_dip_vdd_x1_vdd_x2_vdd_x3_t44 r0 *1 0,0
Ra_d_inv_clk_vdd_inv_mc_vdd_inv_q_vdd_mpa_py_mpb_py_nand_m_vdd_nand_s2_vdd_nwell_vdd_sb_vdd_sr1_vdd_sr2_vdd_sr3_vdd_sr4_vdd_sv_d_vdd_tie_sv_vdd_tg_d_a_tg_d_vdd_tg_fbm_vdd_tg_fbs_vdd_tg_s_vdd_vdd_vdd_b1_vdd_b2_vdd_b3_vdd_b4_vdd_link_vdd_link_dip_vdd_x1_vdd_x2_vdd_x3_t44
+ a\x7cd\x7cinv_clk_vdd\x7cinv_mc_vdd\x7cinv_q_vdd\x7cmpa_py\x7cmpb_py\x7cnand_m_vdd\x7cnand_s2_vdd\x7cnwell_vdd\x7csb_vdd\x7csr1_vdd\x7csr2_vdd\x7csr3_vdd\x7csr4_vdd\x7csv_d_vdd_tie\x7csv_vdd\x7ctg_d_a\x7ctg_d_vdd\x7ctg_fbm_vdd\x7ctg_fbs_vdd\x7ctg_s_vdd\x7cvdd\x7cvdd_b1\x7cvdd_b2\x7cvdd_b3\x7cvdd_b4\x7cvdd_link\x7cvdd_link_dip\x7cvdd_x1\x7cvdd_x2\x7cvdd_x3__t44
+ a|d|inv_clk_vdd|inv_mc_vdd|inv_q_vdd|mpa_py|mpb_py|nand_m_vdd|nand_s2_vdd|nwell_vdd|sb_vdd|sr1_vdd|sr2_vdd|sr3_vdd|sr4_vdd|sv_d_vdd_tie|sv_vdd|tg_d_a|tg_d_vdd|tg_fbm_vdd|tg_fbs_vdd|tg_s_vdd|vdd|vdd_b1|vdd_b2|vdd_b3|vdd_b4|vdd_link|vdd_link_dip|vdd_x1|vdd_x2|vdd_x3
+ 236.193256305
* device instance a_d_inv_clk_vdd_inv_mc_vdd_inv_q_vdd_mpa_py_mpb_py_nand_m_vdd_nand_s2_vdd_nwell_vdd_sb_vdd_sr1_vdd_sr2_vdd_sr3_vdd_sr4_vdd_sv_d_vdd_tie_sv_vdd_tg_d_a_tg_d_vdd_tg_fbm_vdd_tg_fbs_vdd_tg_s_vdd_vdd_vdd_b1_vdd_b2_vdd_b3_vdd_b4_vdd_link_vdd_link_dip_vdd_x1_vdd_x2_vdd_x3_t45 r0 *1 0,0
Ra_d_inv_clk_vdd_inv_mc_vdd_inv_q_vdd_mpa_py_mpb_py_nand_m_vdd_nand_s2_vdd_nwell_vdd_sb_vdd_sr1_vdd_sr2_vdd_sr3_vdd_sr4_vdd_sv_d_vdd_tie_sv_vdd_tg_d_a_tg_d_vdd_tg_fbm_vdd_tg_fbs_vdd_tg_s_vdd_vdd_vdd_b1_vdd_b2_vdd_b3_vdd_b4_vdd_link_vdd_link_dip_vdd_x1_vdd_x2_vdd_x3_t45
+ a\x7cd\x7cinv_clk_vdd\x7cinv_mc_vdd\x7cinv_q_vdd\x7cmpa_py\x7cmpb_py\x7cnand_m_vdd\x7cnand_s2_vdd\x7cnwell_vdd\x7csb_vdd\x7csr1_vdd\x7csr2_vdd\x7csr3_vdd\x7csr4_vdd\x7csv_d_vdd_tie\x7csv_vdd\x7ctg_d_a\x7ctg_d_vdd\x7ctg_fbm_vdd\x7ctg_fbs_vdd\x7ctg_s_vdd\x7cvdd\x7cvdd_b1\x7cvdd_b2\x7cvdd_b3\x7cvdd_b4\x7cvdd_link\x7cvdd_link_dip\x7cvdd_x1\x7cvdd_x2\x7cvdd_x3__t45
+ a|d|inv_clk_vdd|inv_mc_vdd|inv_q_vdd|mpa_py|mpb_py|nand_m_vdd|nand_s2_vdd|nwell_vdd|sb_vdd|sr1_vdd|sr2_vdd|sr3_vdd|sr4_vdd|sv_d_vdd_tie|sv_vdd|tg_d_a|tg_d_vdd|tg_fbm_vdd|tg_fbs_vdd|tg_s_vdd|vdd|vdd_b1|vdd_b2|vdd_b3|vdd_b4|vdd_link|vdd_link_dip|vdd_x1|vdd_x2|vdd_x3
+ 228.609701783
* device instance a_d_inv_clk_vdd_inv_mc_vdd_inv_q_vdd_mpa_py_mpb_py_nand_m_vdd_nand_s2_vdd_nwell_vdd_sb_vdd_sr1_vdd_sr2_vdd_sr3_vdd_sr4_vdd_sv_d_vdd_tie_sv_vdd_tg_d_a_tg_d_vdd_tg_fbm_vdd_tg_fbs_vdd_tg_s_vdd_vdd_vdd_b1_vdd_b2_vdd_b3_vdd_b4_vdd_link_vdd_link_dip_vdd_x1_vdd_x2_vdd_x3_t46 r0 *1 0,0
Ra_d_inv_clk_vdd_inv_mc_vdd_inv_q_vdd_mpa_py_mpb_py_nand_m_vdd_nand_s2_vdd_nwell_vdd_sb_vdd_sr1_vdd_sr2_vdd_sr3_vdd_sr4_vdd_sv_d_vdd_tie_sv_vdd_tg_d_a_tg_d_vdd_tg_fbm_vdd_tg_fbs_vdd_tg_s_vdd_vdd_vdd_b1_vdd_b2_vdd_b3_vdd_b4_vdd_link_vdd_link_dip_vdd_x1_vdd_x2_vdd_x3_t46
+ a\x7cd\x7cinv_clk_vdd\x7cinv_mc_vdd\x7cinv_q_vdd\x7cmpa_py\x7cmpb_py\x7cnand_m_vdd\x7cnand_s2_vdd\x7cnwell_vdd\x7csb_vdd\x7csr1_vdd\x7csr2_vdd\x7csr3_vdd\x7csr4_vdd\x7csv_d_vdd_tie\x7csv_vdd\x7ctg_d_a\x7ctg_d_vdd\x7ctg_fbm_vdd\x7ctg_fbs_vdd\x7ctg_s_vdd\x7cvdd\x7cvdd_b1\x7cvdd_b2\x7cvdd_b3\x7cvdd_b4\x7cvdd_link\x7cvdd_link_dip\x7cvdd_x1\x7cvdd_x2\x7cvdd_x3__t46
+ a|d|inv_clk_vdd|inv_mc_vdd|inv_q_vdd|mpa_py|mpb_py|nand_m_vdd|nand_s2_vdd|nwell_vdd|sb_vdd|sr1_vdd|sr2_vdd|sr3_vdd|sr4_vdd|sv_d_vdd_tie|sv_vdd|tg_d_a|tg_d_vdd|tg_fbm_vdd|tg_fbs_vdd|tg_s_vdd|vdd|vdd_b1|vdd_b2|vdd_b3|vdd_b4|vdd_link|vdd_link_dip|vdd_x1|vdd_x2|vdd_x3
+ 197.33586021
* device instance a_d_inv_clk_vdd_inv_mc_vdd_inv_q_vdd_mpa_py_mpb_py_nand_m_vdd_nand_s2_vdd_nwell_vdd_sb_vdd_sr1_vdd_sr2_vdd_sr3_vdd_sr4_vdd_sv_d_vdd_tie_sv_vdd_tg_d_a_tg_d_vdd_tg_fbm_vdd_tg_fbs_vdd_tg_s_vdd_vdd_vdd_b1_vdd_b2_vdd_b3_vdd_b4_vdd_link_vdd_link_dip_vdd_x1_vdd_x2_vdd_x3_t47 r0 *1 0,0
Ra_d_inv_clk_vdd_inv_mc_vdd_inv_q_vdd_mpa_py_mpb_py_nand_m_vdd_nand_s2_vdd_nwell_vdd_sb_vdd_sr1_vdd_sr2_vdd_sr3_vdd_sr4_vdd_sv_d_vdd_tie_sv_vdd_tg_d_a_tg_d_vdd_tg_fbm_vdd_tg_fbs_vdd_tg_s_vdd_vdd_vdd_b1_vdd_b2_vdd_b3_vdd_b4_vdd_link_vdd_link_dip_vdd_x1_vdd_x2_vdd_x3_t47
+ a\x7cd\x7cinv_clk_vdd\x7cinv_mc_vdd\x7cinv_q_vdd\x7cmpa_py\x7cmpb_py\x7cnand_m_vdd\x7cnand_s2_vdd\x7cnwell_vdd\x7csb_vdd\x7csr1_vdd\x7csr2_vdd\x7csr3_vdd\x7csr4_vdd\x7csv_d_vdd_tie\x7csv_vdd\x7ctg_d_a\x7ctg_d_vdd\x7ctg_fbm_vdd\x7ctg_fbs_vdd\x7ctg_s_vdd\x7cvdd\x7cvdd_b1\x7cvdd_b2\x7cvdd_b3\x7cvdd_b4\x7cvdd_link\x7cvdd_link_dip\x7cvdd_x1\x7cvdd_x2\x7cvdd_x3__t47
+ a|d|inv_clk_vdd|inv_mc_vdd|inv_q_vdd|mpa_py|mpb_py|nand_m_vdd|nand_s2_vdd|nwell_vdd|sb_vdd|sr1_vdd|sr2_vdd|sr3_vdd|sr4_vdd|sv_d_vdd_tie|sv_vdd|tg_d_a|tg_d_vdd|tg_fbm_vdd|tg_fbs_vdd|tg_s_vdd|vdd|vdd_b1|vdd_b2|vdd_b3|vdd_b4|vdd_link|vdd_link_dip|vdd_x1|vdd_x2|vdd_x3
+ 160.538922256
* device instance a_d_inv_clk_vdd_inv_mc_vdd_inv_q_vdd_mpa_py_mpb_py_nand_m_vdd_nand_s2_vdd_nwell_vdd_sb_vdd_sr1_vdd_sr2_vdd_sr3_vdd_sr4_vdd_sv_d_vdd_tie_sv_vdd_tg_d_a_tg_d_vdd_tg_fbm_vdd_tg_fbs_vdd_tg_s_vdd_vdd_vdd_b1_vdd_b2_vdd_b3_vdd_b4_vdd_link_vdd_link_dip_vdd_x1_vdd_x2_vdd_x3_t48 r0 *1 0,0
Ra_d_inv_clk_vdd_inv_mc_vdd_inv_q_vdd_mpa_py_mpb_py_nand_m_vdd_nand_s2_vdd_nwell_vdd_sb_vdd_sr1_vdd_sr2_vdd_sr3_vdd_sr4_vdd_sv_d_vdd_tie_sv_vdd_tg_d_a_tg_d_vdd_tg_fbm_vdd_tg_fbs_vdd_tg_s_vdd_vdd_vdd_b1_vdd_b2_vdd_b3_vdd_b4_vdd_link_vdd_link_dip_vdd_x1_vdd_x2_vdd_x3_t48
+ a\x7cd\x7cinv_clk_vdd\x7cinv_mc_vdd\x7cinv_q_vdd\x7cmpa_py\x7cmpb_py\x7cnand_m_vdd\x7cnand_s2_vdd\x7cnwell_vdd\x7csb_vdd\x7csr1_vdd\x7csr2_vdd\x7csr3_vdd\x7csr4_vdd\x7csv_d_vdd_tie\x7csv_vdd\x7ctg_d_a\x7ctg_d_vdd\x7ctg_fbm_vdd\x7ctg_fbs_vdd\x7ctg_s_vdd\x7cvdd\x7cvdd_b1\x7cvdd_b2\x7cvdd_b3\x7cvdd_b4\x7cvdd_link\x7cvdd_link_dip\x7cvdd_x1\x7cvdd_x2\x7cvdd_x3__t48
+ a|d|inv_clk_vdd|inv_mc_vdd|inv_q_vdd|mpa_py|mpb_py|nand_m_vdd|nand_s2_vdd|nwell_vdd|sb_vdd|sr1_vdd|sr2_vdd|sr3_vdd|sr4_vdd|sv_d_vdd_tie|sv_vdd|tg_d_a|tg_d_vdd|tg_fbm_vdd|tg_fbs_vdd|tg_s_vdd|vdd|vdd_b1|vdd_b2|vdd_b3|vdd_b4|vdd_link|vdd_link_dip|vdd_x1|vdd_x2|vdd_x3
+ 158.491152237
* device instance a_d_inv_clk_vdd_inv_mc_vdd_inv_q_vdd_mpa_py_mpb_py_nand_m_vdd_nand_s2_vdd_nwell_vdd_sb_vdd_sr1_vdd_sr2_vdd_sr3_vdd_sr4_vdd_sv_d_vdd_tie_sv_vdd_tg_d_a_tg_d_vdd_tg_fbm_vdd_tg_fbs_vdd_tg_s_vdd_vdd_vdd_b1_vdd_b2_vdd_b3_vdd_b4_vdd_link_vdd_link_dip_vdd_x1_vdd_x2_vdd_x3_t49 r0 *1 0,0
Ra_d_inv_clk_vdd_inv_mc_vdd_inv_q_vdd_mpa_py_mpb_py_nand_m_vdd_nand_s2_vdd_nwell_vdd_sb_vdd_sr1_vdd_sr2_vdd_sr3_vdd_sr4_vdd_sv_d_vdd_tie_sv_vdd_tg_d_a_tg_d_vdd_tg_fbm_vdd_tg_fbs_vdd_tg_s_vdd_vdd_vdd_b1_vdd_b2_vdd_b3_vdd_b4_vdd_link_vdd_link_dip_vdd_x1_vdd_x2_vdd_x3_t49
+ a\x7cd\x7cinv_clk_vdd\x7cinv_mc_vdd\x7cinv_q_vdd\x7cmpa_py\x7cmpb_py\x7cnand_m_vdd\x7cnand_s2_vdd\x7cnwell_vdd\x7csb_vdd\x7csr1_vdd\x7csr2_vdd\x7csr3_vdd\x7csr4_vdd\x7csv_d_vdd_tie\x7csv_vdd\x7ctg_d_a\x7ctg_d_vdd\x7ctg_fbm_vdd\x7ctg_fbs_vdd\x7ctg_s_vdd\x7cvdd\x7cvdd_b1\x7cvdd_b2\x7cvdd_b3\x7cvdd_b4\x7cvdd_link\x7cvdd_link_dip\x7cvdd_x1\x7cvdd_x2\x7cvdd_x3__t49
+ a|d|inv_clk_vdd|inv_mc_vdd|inv_q_vdd|mpa_py|mpb_py|nand_m_vdd|nand_s2_vdd|nwell_vdd|sb_vdd|sr1_vdd|sr2_vdd|sr3_vdd|sr4_vdd|sv_d_vdd_tie|sv_vdd|tg_d_a|tg_d_vdd|tg_fbm_vdd|tg_fbs_vdd|tg_s_vdd|vdd|vdd_b1|vdd_b2|vdd_b3|vdd_b4|vdd_link|vdd_link_dip|vdd_x1|vdd_x2|vdd_x3
+ 127.586530765
* device instance a_d_inv_clk_vdd_inv_mc_vdd_inv_q_vdd_mpa_py_mpb_py_nand_m_vdd_nand_s2_vdd_nwell_vdd_sb_vdd_sr1_vdd_sr2_vdd_sr3_vdd_sr4_vdd_sv_d_vdd_tie_sv_vdd_tg_d_a_tg_d_vdd_tg_fbm_vdd_tg_fbs_vdd_tg_s_vdd_vdd_vdd_b1_vdd_b2_vdd_b3_vdd_b4_vdd_link_vdd_link_dip_vdd_x1_vdd_x2_vdd_x3_t50 r0 *1 0,0
Ra_d_inv_clk_vdd_inv_mc_vdd_inv_q_vdd_mpa_py_mpb_py_nand_m_vdd_nand_s2_vdd_nwell_vdd_sb_vdd_sr1_vdd_sr2_vdd_sr3_vdd_sr4_vdd_sv_d_vdd_tie_sv_vdd_tg_d_a_tg_d_vdd_tg_fbm_vdd_tg_fbs_vdd_tg_s_vdd_vdd_vdd_b1_vdd_b2_vdd_b3_vdd_b4_vdd_link_vdd_link_dip_vdd_x1_vdd_x2_vdd_x3_t50
+ a\x7cd\x7cinv_clk_vdd\x7cinv_mc_vdd\x7cinv_q_vdd\x7cmpa_py\x7cmpb_py\x7cnand_m_vdd\x7cnand_s2_vdd\x7cnwell_vdd\x7csb_vdd\x7csr1_vdd\x7csr2_vdd\x7csr3_vdd\x7csr4_vdd\x7csv_d_vdd_tie\x7csv_vdd\x7ctg_d_a\x7ctg_d_vdd\x7ctg_fbm_vdd\x7ctg_fbs_vdd\x7ctg_s_vdd\x7cvdd\x7cvdd_b1\x7cvdd_b2\x7cvdd_b3\x7cvdd_b4\x7cvdd_link\x7cvdd_link_dip\x7cvdd_x1\x7cvdd_x2\x7cvdd_x3__t50
+ a|d|inv_clk_vdd|inv_mc_vdd|inv_q_vdd|mpa_py|mpb_py|nand_m_vdd|nand_s2_vdd|nwell_vdd|sb_vdd|sr1_vdd|sr2_vdd|sr3_vdd|sr4_vdd|sv_d_vdd_tie|sv_vdd|tg_d_a|tg_d_vdd|tg_fbm_vdd|tg_fbs_vdd|tg_s_vdd|vdd|vdd_b1|vdd_b2|vdd_b3|vdd_b4|vdd_link|vdd_link_dip|vdd_x1|vdd_x2|vdd_x3
+ 121.232452195
* device instance a_d_inv_clk_vdd_inv_mc_vdd_inv_q_vdd_mpa_py_mpb_py_nand_m_vdd_nand_s2_vdd_nwell_vdd_sb_vdd_sr1_vdd_sr2_vdd_sr3_vdd_sr4_vdd_sv_d_vdd_tie_sv_vdd_tg_d_a_tg_d_vdd_tg_fbm_vdd_tg_fbs_vdd_tg_s_vdd_vdd_vdd_b1_vdd_b2_vdd_b3_vdd_b4_vdd_link_vdd_link_dip_vdd_x1_vdd_x2_vdd_x3_t51 r0 *1 0,0
Ra_d_inv_clk_vdd_inv_mc_vdd_inv_q_vdd_mpa_py_mpb_py_nand_m_vdd_nand_s2_vdd_nwell_vdd_sb_vdd_sr1_vdd_sr2_vdd_sr3_vdd_sr4_vdd_sv_d_vdd_tie_sv_vdd_tg_d_a_tg_d_vdd_tg_fbm_vdd_tg_fbs_vdd_tg_s_vdd_vdd_vdd_b1_vdd_b2_vdd_b3_vdd_b4_vdd_link_vdd_link_dip_vdd_x1_vdd_x2_vdd_x3_t51
+ a\x7cd\x7cinv_clk_vdd\x7cinv_mc_vdd\x7cinv_q_vdd\x7cmpa_py\x7cmpb_py\x7cnand_m_vdd\x7cnand_s2_vdd\x7cnwell_vdd\x7csb_vdd\x7csr1_vdd\x7csr2_vdd\x7csr3_vdd\x7csr4_vdd\x7csv_d_vdd_tie\x7csv_vdd\x7ctg_d_a\x7ctg_d_vdd\x7ctg_fbm_vdd\x7ctg_fbs_vdd\x7ctg_s_vdd\x7cvdd\x7cvdd_b1\x7cvdd_b2\x7cvdd_b3\x7cvdd_b4\x7cvdd_link\x7cvdd_link_dip\x7cvdd_x1\x7cvdd_x2\x7cvdd_x3__t51
+ a|d|inv_clk_vdd|inv_mc_vdd|inv_q_vdd|mpa_py|mpb_py|nand_m_vdd|nand_s2_vdd|nwell_vdd|sb_vdd|sr1_vdd|sr2_vdd|sr3_vdd|sr4_vdd|sv_d_vdd_tie|sv_vdd|tg_d_a|tg_d_vdd|tg_fbm_vdd|tg_fbs_vdd|tg_s_vdd|vdd|vdd_b1|vdd_b2|vdd_b3|vdd_b4|vdd_link|vdd_link_dip|vdd_x1|vdd_x2|vdd_x3
+ 119.192603341
* device instance a_d_inv_clk_vdd_inv_mc_vdd_inv_q_vdd_mpa_py_mpb_py_nand_m_vdd_nand_s2_vdd_nwell_vdd_sb_vdd_sr1_vdd_sr2_vdd_sr3_vdd_sr4_vdd_sv_d_vdd_tie_sv_vdd_tg_d_a_tg_d_vdd_tg_fbm_vdd_tg_fbs_vdd_tg_s_vdd_vdd_vdd_b1_vdd_b2_vdd_b3_vdd_b4_vdd_link_vdd_link_dip_vdd_x1_vdd_x2_vdd_x3_t52 r0 *1 0,0
Ra_d_inv_clk_vdd_inv_mc_vdd_inv_q_vdd_mpa_py_mpb_py_nand_m_vdd_nand_s2_vdd_nwell_vdd_sb_vdd_sr1_vdd_sr2_vdd_sr3_vdd_sr4_vdd_sv_d_vdd_tie_sv_vdd_tg_d_a_tg_d_vdd_tg_fbm_vdd_tg_fbs_vdd_tg_s_vdd_vdd_vdd_b1_vdd_b2_vdd_b3_vdd_b4_vdd_link_vdd_link_dip_vdd_x1_vdd_x2_vdd_x3_t52
+ a\x7cd\x7cinv_clk_vdd\x7cinv_mc_vdd\x7cinv_q_vdd\x7cmpa_py\x7cmpb_py\x7cnand_m_vdd\x7cnand_s2_vdd\x7cnwell_vdd\x7csb_vdd\x7csr1_vdd\x7csr2_vdd\x7csr3_vdd\x7csr4_vdd\x7csv_d_vdd_tie\x7csv_vdd\x7ctg_d_a\x7ctg_d_vdd\x7ctg_fbm_vdd\x7ctg_fbs_vdd\x7ctg_s_vdd\x7cvdd\x7cvdd_b1\x7cvdd_b2\x7cvdd_b3\x7cvdd_b4\x7cvdd_link\x7cvdd_link_dip\x7cvdd_x1\x7cvdd_x2\x7cvdd_x3__t52
+ a|d|inv_clk_vdd|inv_mc_vdd|inv_q_vdd|mpa_py|mpb_py|nand_m_vdd|nand_s2_vdd|nwell_vdd|sb_vdd|sr1_vdd|sr2_vdd|sr3_vdd|sr4_vdd|sv_d_vdd_tie|sv_vdd|tg_d_a|tg_d_vdd|tg_fbm_vdd|tg_fbs_vdd|tg_s_vdd|vdd|vdd_b1|vdd_b2|vdd_b3|vdd_b4|vdd_link|vdd_link_dip|vdd_x1|vdd_x2|vdd_x3
+ 207.535121948
* device instance a_d_inv_clk_vdd_inv_mc_vdd_inv_q_vdd_mpa_py_mpb_py_nand_m_vdd_nand_s2_vdd_nwell_vdd_sb_vdd_sr1_vdd_sr2_vdd_sr3_vdd_sr4_vdd_sv_d_vdd_tie_sv_vdd_tg_d_a_tg_d_vdd_tg_fbm_vdd_tg_fbs_vdd_tg_s_vdd_vdd_vdd_b1_vdd_b2_vdd_b3_vdd_b4_vdd_link_vdd_link_dip_vdd_x1_vdd_x2_vdd_x3_t53 r0 *1 0,0
Ra_d_inv_clk_vdd_inv_mc_vdd_inv_q_vdd_mpa_py_mpb_py_nand_m_vdd_nand_s2_vdd_nwell_vdd_sb_vdd_sr1_vdd_sr2_vdd_sr3_vdd_sr4_vdd_sv_d_vdd_tie_sv_vdd_tg_d_a_tg_d_vdd_tg_fbm_vdd_tg_fbs_vdd_tg_s_vdd_vdd_vdd_b1_vdd_b2_vdd_b3_vdd_b4_vdd_link_vdd_link_dip_vdd_x1_vdd_x2_vdd_x3_t53
+ a\x7cd\x7cinv_clk_vdd\x7cinv_mc_vdd\x7cinv_q_vdd\x7cmpa_py\x7cmpb_py\x7cnand_m_vdd\x7cnand_s2_vdd\x7cnwell_vdd\x7csb_vdd\x7csr1_vdd\x7csr2_vdd\x7csr3_vdd\x7csr4_vdd\x7csv_d_vdd_tie\x7csv_vdd\x7ctg_d_a\x7ctg_d_vdd\x7ctg_fbm_vdd\x7ctg_fbs_vdd\x7ctg_s_vdd\x7cvdd\x7cvdd_b1\x7cvdd_b2\x7cvdd_b3\x7cvdd_b4\x7cvdd_link\x7cvdd_link_dip\x7cvdd_x1\x7cvdd_x2\x7cvdd_x3__t53
+ a|d|inv_clk_vdd|inv_mc_vdd|inv_q_vdd|mpa_py|mpb_py|nand_m_vdd|nand_s2_vdd|nwell_vdd|sb_vdd|sr1_vdd|sr2_vdd|sr3_vdd|sr4_vdd|sv_d_vdd_tie|sv_vdd|tg_d_a|tg_d_vdd|tg_fbm_vdd|tg_fbs_vdd|tg_s_vdd|vdd|vdd_b1|vdd_b2|vdd_b3|vdd_b4|vdd_link|vdd_link_dip|vdd_x1|vdd_x2|vdd_x3
+ 217.107279244
* device instance a_d_inv_clk_vdd_inv_mc_vdd_inv_q_vdd_mpa_py_mpb_py_nand_m_vdd_nand_s2_vdd_nwell_vdd_sb_vdd_sr1_vdd_sr2_vdd_sr3_vdd_sr4_vdd_sv_d_vdd_tie_sv_vdd_tg_d_a_tg_d_vdd_tg_fbm_vdd_tg_fbs_vdd_tg_s_vdd_vdd_vdd_b1_vdd_b2_vdd_b3_vdd_b4_vdd_link_vdd_link_dip_vdd_x1_vdd_x2_vdd_x3_t54 r0 *1 0,0
Ra_d_inv_clk_vdd_inv_mc_vdd_inv_q_vdd_mpa_py_mpb_py_nand_m_vdd_nand_s2_vdd_nwell_vdd_sb_vdd_sr1_vdd_sr2_vdd_sr3_vdd_sr4_vdd_sv_d_vdd_tie_sv_vdd_tg_d_a_tg_d_vdd_tg_fbm_vdd_tg_fbs_vdd_tg_s_vdd_vdd_vdd_b1_vdd_b2_vdd_b3_vdd_b4_vdd_link_vdd_link_dip_vdd_x1_vdd_x2_vdd_x3_t54
+ a\x7cd\x7cinv_clk_vdd\x7cinv_mc_vdd\x7cinv_q_vdd\x7cmpa_py\x7cmpb_py\x7cnand_m_vdd\x7cnand_s2_vdd\x7cnwell_vdd\x7csb_vdd\x7csr1_vdd\x7csr2_vdd\x7csr3_vdd\x7csr4_vdd\x7csv_d_vdd_tie\x7csv_vdd\x7ctg_d_a\x7ctg_d_vdd\x7ctg_fbm_vdd\x7ctg_fbs_vdd\x7ctg_s_vdd\x7cvdd\x7cvdd_b1\x7cvdd_b2\x7cvdd_b3\x7cvdd_b4\x7cvdd_link\x7cvdd_link_dip\x7cvdd_x1\x7cvdd_x2\x7cvdd_x3__t54
+ a|d|inv_clk_vdd|inv_mc_vdd|inv_q_vdd|mpa_py|mpb_py|nand_m_vdd|nand_s2_vdd|nwell_vdd|sb_vdd|sr1_vdd|sr2_vdd|sr3_vdd|sr4_vdd|sv_d_vdd_tie|sv_vdd|tg_d_a|tg_d_vdd|tg_fbm_vdd|tg_fbs_vdd|tg_s_vdd|vdd|vdd_b1|vdd_b2|vdd_b3|vdd_b4|vdd_link|vdd_link_dip|vdd_x1|vdd_x2|vdd_x3
+ 186.518170234
* device instance a_d_inv_clk_vdd_inv_mc_vdd_inv_q_vdd_mpa_py_mpb_py_nand_m_vdd_nand_s2_vdd_nwell_vdd_sb_vdd_sr1_vdd_sr2_vdd_sr3_vdd_sr4_vdd_sv_d_vdd_tie_sv_vdd_tg_d_a_tg_d_vdd_tg_fbm_vdd_tg_fbs_vdd_tg_s_vdd_vdd_vdd_b1_vdd_b2_vdd_b3_vdd_b4_vdd_link_vdd_link_dip_vdd_x1_vdd_x2_vdd_x3_t55 r0 *1 0,0
Ra_d_inv_clk_vdd_inv_mc_vdd_inv_q_vdd_mpa_py_mpb_py_nand_m_vdd_nand_s2_vdd_nwell_vdd_sb_vdd_sr1_vdd_sr2_vdd_sr3_vdd_sr4_vdd_sv_d_vdd_tie_sv_vdd_tg_d_a_tg_d_vdd_tg_fbm_vdd_tg_fbs_vdd_tg_s_vdd_vdd_vdd_b1_vdd_b2_vdd_b3_vdd_b4_vdd_link_vdd_link_dip_vdd_x1_vdd_x2_vdd_x3_t55
+ a\x7cd\x7cinv_clk_vdd\x7cinv_mc_vdd\x7cinv_q_vdd\x7cmpa_py\x7cmpb_py\x7cnand_m_vdd\x7cnand_s2_vdd\x7cnwell_vdd\x7csb_vdd\x7csr1_vdd\x7csr2_vdd\x7csr3_vdd\x7csr4_vdd\x7csv_d_vdd_tie\x7csv_vdd\x7ctg_d_a\x7ctg_d_vdd\x7ctg_fbm_vdd\x7ctg_fbs_vdd\x7ctg_s_vdd\x7cvdd\x7cvdd_b1\x7cvdd_b2\x7cvdd_b3\x7cvdd_b4\x7cvdd_link\x7cvdd_link_dip\x7cvdd_x1\x7cvdd_x2\x7cvdd_x3__t55
+ a|d|inv_clk_vdd|inv_mc_vdd|inv_q_vdd|mpa_py|mpb_py|nand_m_vdd|nand_s2_vdd|nwell_vdd|sb_vdd|sr1_vdd|sr2_vdd|sr3_vdd|sr4_vdd|sv_d_vdd_tie|sv_vdd|tg_d_a|tg_d_vdd|tg_fbm_vdd|tg_fbs_vdd|tg_s_vdd|vdd|vdd_b1|vdd_b2|vdd_b3|vdd_b4|vdd_link|vdd_link_dip|vdd_x1|vdd_x2|vdd_x3
+ 209.587200108
* device instance a_d_inv_clk_vdd_inv_mc_vdd_inv_q_vdd_mpa_py_mpb_py_nand_m_vdd_nand_s2_vdd_nwell_vdd_sb_vdd_sr1_vdd_sr2_vdd_sr3_vdd_sr4_vdd_sv_d_vdd_tie_sv_vdd_tg_d_a_tg_d_vdd_tg_fbm_vdd_tg_fbs_vdd_tg_s_vdd_vdd_vdd_b1_vdd_b2_vdd_b3_vdd_b4_vdd_link_vdd_link_dip_vdd_x1_vdd_x2_vdd_x3_t56 r0 *1 0,0
Ra_d_inv_clk_vdd_inv_mc_vdd_inv_q_vdd_mpa_py_mpb_py_nand_m_vdd_nand_s2_vdd_nwell_vdd_sb_vdd_sr1_vdd_sr2_vdd_sr3_vdd_sr4_vdd_sv_d_vdd_tie_sv_vdd_tg_d_a_tg_d_vdd_tg_fbm_vdd_tg_fbs_vdd_tg_s_vdd_vdd_vdd_b1_vdd_b2_vdd_b3_vdd_b4_vdd_link_vdd_link_dip_vdd_x1_vdd_x2_vdd_x3_t56
+ a\x7cd\x7cinv_clk_vdd\x7cinv_mc_vdd\x7cinv_q_vdd\x7cmpa_py\x7cmpb_py\x7cnand_m_vdd\x7cnand_s2_vdd\x7cnwell_vdd\x7csb_vdd\x7csr1_vdd\x7csr2_vdd\x7csr3_vdd\x7csr4_vdd\x7csv_d_vdd_tie\x7csv_vdd\x7ctg_d_a\x7ctg_d_vdd\x7ctg_fbm_vdd\x7ctg_fbs_vdd\x7ctg_s_vdd\x7cvdd\x7cvdd_b1\x7cvdd_b2\x7cvdd_b3\x7cvdd_b4\x7cvdd_link\x7cvdd_link_dip\x7cvdd_x1\x7cvdd_x2\x7cvdd_x3__t56
+ a|d|inv_clk_vdd|inv_mc_vdd|inv_q_vdd|mpa_py|mpb_py|nand_m_vdd|nand_s2_vdd|nwell_vdd|sb_vdd|sr1_vdd|sr2_vdd|sr3_vdd|sr4_vdd|sv_d_vdd_tie|sv_vdd|tg_d_a|tg_d_vdd|tg_fbm_vdd|tg_fbs_vdd|tg_s_vdd|vdd|vdd_b1|vdd_b2|vdd_b3|vdd_b4|vdd_link|vdd_link_dip|vdd_x1|vdd_x2|vdd_x3
+ 188.993530351
* device instance a_d_inv_clk_vdd_inv_mc_vdd_inv_q_vdd_mpa_py_mpb_py_nand_m_vdd_nand_s2_vdd_nwell_vdd_sb_vdd_sr1_vdd_sr2_vdd_sr3_vdd_sr4_vdd_sv_d_vdd_tie_sv_vdd_tg_d_a_tg_d_vdd_tg_fbm_vdd_tg_fbs_vdd_tg_s_vdd_vdd_vdd_b1_vdd_b2_vdd_b3_vdd_b4_vdd_link_vdd_link_dip_vdd_x1_vdd_x2_vdd_x3_t57 r0 *1 0,0
Ra_d_inv_clk_vdd_inv_mc_vdd_inv_q_vdd_mpa_py_mpb_py_nand_m_vdd_nand_s2_vdd_nwell_vdd_sb_vdd_sr1_vdd_sr2_vdd_sr3_vdd_sr4_vdd_sv_d_vdd_tie_sv_vdd_tg_d_a_tg_d_vdd_tg_fbm_vdd_tg_fbs_vdd_tg_s_vdd_vdd_vdd_b1_vdd_b2_vdd_b3_vdd_b4_vdd_link_vdd_link_dip_vdd_x1_vdd_x2_vdd_x3_t57
+ a\x7cd\x7cinv_clk_vdd\x7cinv_mc_vdd\x7cinv_q_vdd\x7cmpa_py\x7cmpb_py\x7cnand_m_vdd\x7cnand_s2_vdd\x7cnwell_vdd\x7csb_vdd\x7csr1_vdd\x7csr2_vdd\x7csr3_vdd\x7csr4_vdd\x7csv_d_vdd_tie\x7csv_vdd\x7ctg_d_a\x7ctg_d_vdd\x7ctg_fbm_vdd\x7ctg_fbs_vdd\x7ctg_s_vdd\x7cvdd\x7cvdd_b1\x7cvdd_b2\x7cvdd_b3\x7cvdd_b4\x7cvdd_link\x7cvdd_link_dip\x7cvdd_x1\x7cvdd_x2\x7cvdd_x3__t57
+ a|d|inv_clk_vdd|inv_mc_vdd|inv_q_vdd|mpa_py|mpb_py|nand_m_vdd|nand_s2_vdd|nwell_vdd|sb_vdd|sr1_vdd|sr2_vdd|sr3_vdd|sr4_vdd|sv_d_vdd_tie|sv_vdd|tg_d_a|tg_d_vdd|tg_fbm_vdd|tg_fbs_vdd|tg_s_vdd|vdd|vdd_b1|vdd_b2|vdd_b3|vdd_b4|vdd_link|vdd_link_dip|vdd_x1|vdd_x2|vdd_x3
+ 247.003583517
* device instance a_d_inv_clk_vdd_inv_mc_vdd_inv_q_vdd_mpa_py_mpb_py_nand_m_vdd_nand_s2_vdd_nwell_vdd_sb_vdd_sr1_vdd_sr2_vdd_sr3_vdd_sr4_vdd_sv_d_vdd_tie_sv_vdd_tg_d_a_tg_d_vdd_tg_fbm_vdd_tg_fbs_vdd_tg_s_vdd_vdd_vdd_b1_vdd_b2_vdd_b3_vdd_b4_vdd_link_vdd_link_dip_vdd_x1_vdd_x2_vdd_x3_t58 r0 *1 0,0
Ra_d_inv_clk_vdd_inv_mc_vdd_inv_q_vdd_mpa_py_mpb_py_nand_m_vdd_nand_s2_vdd_nwell_vdd_sb_vdd_sr1_vdd_sr2_vdd_sr3_vdd_sr4_vdd_sv_d_vdd_tie_sv_vdd_tg_d_a_tg_d_vdd_tg_fbm_vdd_tg_fbs_vdd_tg_s_vdd_vdd_vdd_b1_vdd_b2_vdd_b3_vdd_b4_vdd_link_vdd_link_dip_vdd_x1_vdd_x2_vdd_x3_t58
+ a\x7cd\x7cinv_clk_vdd\x7cinv_mc_vdd\x7cinv_q_vdd\x7cmpa_py\x7cmpb_py\x7cnand_m_vdd\x7cnand_s2_vdd\x7cnwell_vdd\x7csb_vdd\x7csr1_vdd\x7csr2_vdd\x7csr3_vdd\x7csr4_vdd\x7csv_d_vdd_tie\x7csv_vdd\x7ctg_d_a\x7ctg_d_vdd\x7ctg_fbm_vdd\x7ctg_fbs_vdd\x7ctg_s_vdd\x7cvdd\x7cvdd_b1\x7cvdd_b2\x7cvdd_b3\x7cvdd_b4\x7cvdd_link\x7cvdd_link_dip\x7cvdd_x1\x7cvdd_x2\x7cvdd_x3__t58
+ a|d|inv_clk_vdd|inv_mc_vdd|inv_q_vdd|mpa_py|mpb_py|nand_m_vdd|nand_s2_vdd|nwell_vdd|sb_vdd|sr1_vdd|sr2_vdd|sr3_vdd|sr4_vdd|sv_d_vdd_tie|sv_vdd|tg_d_a|tg_d_vdd|tg_fbm_vdd|tg_fbs_vdd|tg_s_vdd|vdd|vdd_b1|vdd_b2|vdd_b3|vdd_b4|vdd_link|vdd_link_dip|vdd_x1|vdd_x2|vdd_x3
+ 172.434021845
* device instance a_d_inv_clk_vdd_inv_mc_vdd_inv_q_vdd_mpa_py_mpb_py_nand_m_vdd_nand_s2_vdd_nwell_vdd_sb_vdd_sr1_vdd_sr2_vdd_sr3_vdd_sr4_vdd_sv_d_vdd_tie_sv_vdd_tg_d_a_tg_d_vdd_tg_fbm_vdd_tg_fbs_vdd_tg_s_vdd_vdd_vdd_b1_vdd_b2_vdd_b3_vdd_b4_vdd_link_vdd_link_dip_vdd_x1_vdd_x2_vdd_x3_t59 r0 *1 0,0
Ra_d_inv_clk_vdd_inv_mc_vdd_inv_q_vdd_mpa_py_mpb_py_nand_m_vdd_nand_s2_vdd_nwell_vdd_sb_vdd_sr1_vdd_sr2_vdd_sr3_vdd_sr4_vdd_sv_d_vdd_tie_sv_vdd_tg_d_a_tg_d_vdd_tg_fbm_vdd_tg_fbs_vdd_tg_s_vdd_vdd_vdd_b1_vdd_b2_vdd_b3_vdd_b4_vdd_link_vdd_link_dip_vdd_x1_vdd_x2_vdd_x3_t59
+ a\x7cd\x7cinv_clk_vdd\x7cinv_mc_vdd\x7cinv_q_vdd\x7cmpa_py\x7cmpb_py\x7cnand_m_vdd\x7cnand_s2_vdd\x7cnwell_vdd\x7csb_vdd\x7csr1_vdd\x7csr2_vdd\x7csr3_vdd\x7csr4_vdd\x7csv_d_vdd_tie\x7csv_vdd\x7ctg_d_a\x7ctg_d_vdd\x7ctg_fbm_vdd\x7ctg_fbs_vdd\x7ctg_s_vdd\x7cvdd\x7cvdd_b1\x7cvdd_b2\x7cvdd_b3\x7cvdd_b4\x7cvdd_link\x7cvdd_link_dip\x7cvdd_x1\x7cvdd_x2\x7cvdd_x3__t59
+ a|d|inv_clk_vdd|inv_mc_vdd|inv_q_vdd|mpa_py|mpb_py|nand_m_vdd|nand_s2_vdd|nwell_vdd|sb_vdd|sr1_vdd|sr2_vdd|sr3_vdd|sr4_vdd|sv_d_vdd_tie|sv_vdd|tg_d_a|tg_d_vdd|tg_fbm_vdd|tg_fbs_vdd|tg_s_vdd|vdd|vdd_b1|vdd_b2|vdd_b3|vdd_b4|vdd_link|vdd_link_dip|vdd_x1|vdd_x2|vdd_x3
+ 249.057437803
* device instance a_d_inv_clk_vdd_inv_mc_vdd_inv_q_vdd_mpa_py_mpb_py_nand_m_vdd_nand_s2_vdd_nwell_vdd_sb_vdd_sr1_vdd_sr2_vdd_sr3_vdd_sr4_vdd_sv_d_vdd_tie_sv_vdd_tg_d_a_tg_d_vdd_tg_fbm_vdd_tg_fbs_vdd_tg_s_vdd_vdd_vdd_b1_vdd_b2_vdd_b3_vdd_b4_vdd_link_vdd_link_dip_vdd_x1_vdd_x2_vdd_x3_t60 r0 *1 0,0
Ra_d_inv_clk_vdd_inv_mc_vdd_inv_q_vdd_mpa_py_mpb_py_nand_m_vdd_nand_s2_vdd_nwell_vdd_sb_vdd_sr1_vdd_sr2_vdd_sr3_vdd_sr4_vdd_sv_d_vdd_tie_sv_vdd_tg_d_a_tg_d_vdd_tg_fbm_vdd_tg_fbs_vdd_tg_s_vdd_vdd_vdd_b1_vdd_b2_vdd_b3_vdd_b4_vdd_link_vdd_link_dip_vdd_x1_vdd_x2_vdd_x3_t60
+ a\x7cd\x7cinv_clk_vdd\x7cinv_mc_vdd\x7cinv_q_vdd\x7cmpa_py\x7cmpb_py\x7cnand_m_vdd\x7cnand_s2_vdd\x7cnwell_vdd\x7csb_vdd\x7csr1_vdd\x7csr2_vdd\x7csr3_vdd\x7csr4_vdd\x7csv_d_vdd_tie\x7csv_vdd\x7ctg_d_a\x7ctg_d_vdd\x7ctg_fbm_vdd\x7ctg_fbs_vdd\x7ctg_s_vdd\x7cvdd\x7cvdd_b1\x7cvdd_b2\x7cvdd_b3\x7cvdd_b4\x7cvdd_link\x7cvdd_link_dip\x7cvdd_x1\x7cvdd_x2\x7cvdd_x3__t60
+ a|d|inv_clk_vdd|inv_mc_vdd|inv_q_vdd|mpa_py|mpb_py|nand_m_vdd|nand_s2_vdd|nwell_vdd|sb_vdd|sr1_vdd|sr2_vdd|sr3_vdd|sr4_vdd|sv_d_vdd_tie|sv_vdd|tg_d_a|tg_d_vdd|tg_fbm_vdd|tg_fbs_vdd|tg_s_vdd|vdd|vdd_b1|vdd_b2|vdd_b3|vdd_b4|vdd_link|vdd_link_dip|vdd_x1|vdd_x2|vdd_x3
+ 296.153169133
* device instance a_d_inv_clk_vdd_inv_mc_vdd_inv_q_vdd_mpa_py_mpb_py_nand_m_vdd_nand_s2_vdd_nwell_vdd_sb_vdd_sr1_vdd_sr2_vdd_sr3_vdd_sr4_vdd_sv_d_vdd_tie_sv_vdd_tg_d_a_tg_d_vdd_tg_fbm_vdd_tg_fbs_vdd_tg_s_vdd_vdd_vdd_b1_vdd_b2_vdd_b3_vdd_b4_vdd_link_vdd_link_dip_vdd_x1_vdd_x2_vdd_x3_t61 r0 *1 0,0
Ra_d_inv_clk_vdd_inv_mc_vdd_inv_q_vdd_mpa_py_mpb_py_nand_m_vdd_nand_s2_vdd_nwell_vdd_sb_vdd_sr1_vdd_sr2_vdd_sr3_vdd_sr4_vdd_sv_d_vdd_tie_sv_vdd_tg_d_a_tg_d_vdd_tg_fbm_vdd_tg_fbs_vdd_tg_s_vdd_vdd_vdd_b1_vdd_b2_vdd_b3_vdd_b4_vdd_link_vdd_link_dip_vdd_x1_vdd_x2_vdd_x3_t61
+ a\x7cd\x7cinv_clk_vdd\x7cinv_mc_vdd\x7cinv_q_vdd\x7cmpa_py\x7cmpb_py\x7cnand_m_vdd\x7cnand_s2_vdd\x7cnwell_vdd\x7csb_vdd\x7csr1_vdd\x7csr2_vdd\x7csr3_vdd\x7csr4_vdd\x7csv_d_vdd_tie\x7csv_vdd\x7ctg_d_a\x7ctg_d_vdd\x7ctg_fbm_vdd\x7ctg_fbs_vdd\x7ctg_s_vdd\x7cvdd\x7cvdd_b1\x7cvdd_b2\x7cvdd_b3\x7cvdd_b4\x7cvdd_link\x7cvdd_link_dip\x7cvdd_x1\x7cvdd_x2\x7cvdd_x3__t61
+ a|d|inv_clk_vdd|inv_mc_vdd|inv_q_vdd|mpa_py|mpb_py|nand_m_vdd|nand_s2_vdd|nwell_vdd|sb_vdd|sr1_vdd|sr2_vdd|sr3_vdd|sr4_vdd|sv_d_vdd_tie|sv_vdd|tg_d_a|tg_d_vdd|tg_fbm_vdd|tg_fbs_vdd|tg_s_vdd|vdd|vdd_b1|vdd_b2|vdd_b3|vdd_b4|vdd_link|vdd_link_dip|vdd_x1|vdd_x2|vdd_x3
+ 298.208323205
* device instance a_d_inv_clk_vdd_inv_mc_vdd_inv_q_vdd_mpa_py_mpb_py_nand_m_vdd_nand_s2_vdd_nwell_vdd_sb_vdd_sr1_vdd_sr2_vdd_sr3_vdd_sr4_vdd_sv_d_vdd_tie_sv_vdd_tg_d_a_tg_d_vdd_tg_fbm_vdd_tg_fbs_vdd_tg_s_vdd_vdd_vdd_b1_vdd_b2_vdd_b3_vdd_b4_vdd_link_vdd_link_dip_vdd_x1_vdd_x2_vdd_x3_t62 r0 *1 0,0
Ra_d_inv_clk_vdd_inv_mc_vdd_inv_q_vdd_mpa_py_mpb_py_nand_m_vdd_nand_s2_vdd_nwell_vdd_sb_vdd_sr1_vdd_sr2_vdd_sr3_vdd_sr4_vdd_sv_d_vdd_tie_sv_vdd_tg_d_a_tg_d_vdd_tg_fbm_vdd_tg_fbs_vdd_tg_s_vdd_vdd_vdd_b1_vdd_b2_vdd_b3_vdd_b4_vdd_link_vdd_link_dip_vdd_x1_vdd_x2_vdd_x3_t62
+ a\x7cd\x7cinv_clk_vdd\x7cinv_mc_vdd\x7cinv_q_vdd\x7cmpa_py\x7cmpb_py\x7cnand_m_vdd\x7cnand_s2_vdd\x7cnwell_vdd\x7csb_vdd\x7csr1_vdd\x7csr2_vdd\x7csr3_vdd\x7csr4_vdd\x7csv_d_vdd_tie\x7csv_vdd\x7ctg_d_a\x7ctg_d_vdd\x7ctg_fbm_vdd\x7ctg_fbs_vdd\x7ctg_s_vdd\x7cvdd\x7cvdd_b1\x7cvdd_b2\x7cvdd_b3\x7cvdd_b4\x7cvdd_link\x7cvdd_link_dip\x7cvdd_x1\x7cvdd_x2\x7cvdd_x3__t62
+ a|d|inv_clk_vdd|inv_mc_vdd|inv_q_vdd|mpa_py|mpb_py|nand_m_vdd|nand_s2_vdd|nwell_vdd|sb_vdd|sr1_vdd|sr2_vdd|sr3_vdd|sr4_vdd|sv_d_vdd_tie|sv_vdd|tg_d_a|tg_d_vdd|tg_fbm_vdd|tg_fbs_vdd|tg_s_vdd|vdd|vdd_b1|vdd_b2|vdd_b3|vdd_b4|vdd_link|vdd_link_dip|vdd_x1|vdd_x2|vdd_x3
+ 43.2151550485
* device instance a_d_inv_clk_vdd_inv_mc_vdd_inv_q_vdd_mpa_py_mpb_py_nand_m_vdd_nand_s2_vdd_nwell_vdd_sb_vdd_sr1_vdd_sr2_vdd_sr3_vdd_sr4_vdd_sv_d_vdd_tie_sv_vdd_tg_d_a_tg_d_vdd_tg_fbm_vdd_tg_fbs_vdd_tg_s_vdd_vdd_vdd_b1_vdd_b2_vdd_b3_vdd_b4_vdd_link_vdd_link_dip_vdd_x1_vdd_x2_vdd_x3_t63 r0 *1 0,0
Ra_d_inv_clk_vdd_inv_mc_vdd_inv_q_vdd_mpa_py_mpb_py_nand_m_vdd_nand_s2_vdd_nwell_vdd_sb_vdd_sr1_vdd_sr2_vdd_sr3_vdd_sr4_vdd_sv_d_vdd_tie_sv_vdd_tg_d_a_tg_d_vdd_tg_fbm_vdd_tg_fbs_vdd_tg_s_vdd_vdd_vdd_b1_vdd_b2_vdd_b3_vdd_b4_vdd_link_vdd_link_dip_vdd_x1_vdd_x2_vdd_x3_t63
+ a\x7cd\x7cinv_clk_vdd\x7cinv_mc_vdd\x7cinv_q_vdd\x7cmpa_py\x7cmpb_py\x7cnand_m_vdd\x7cnand_s2_vdd\x7cnwell_vdd\x7csb_vdd\x7csr1_vdd\x7csr2_vdd\x7csr3_vdd\x7csr4_vdd\x7csv_d_vdd_tie\x7csv_vdd\x7ctg_d_a\x7ctg_d_vdd\x7ctg_fbm_vdd\x7ctg_fbs_vdd\x7ctg_s_vdd\x7cvdd\x7cvdd_b1\x7cvdd_b2\x7cvdd_b3\x7cvdd_b4\x7cvdd_link\x7cvdd_link_dip\x7cvdd_x1\x7cvdd_x2\x7cvdd_x3__t63
+ a|d|inv_clk_vdd|inv_mc_vdd|inv_q_vdd|mpa_py|mpb_py|nand_m_vdd|nand_s2_vdd|nwell_vdd|sb_vdd|sr1_vdd|sr2_vdd|sr3_vdd|sr4_vdd|sv_d_vdd_tie|sv_vdd|tg_d_a|tg_d_vdd|tg_fbm_vdd|tg_fbs_vdd|tg_s_vdd|vdd|vdd_b1|vdd_b2|vdd_b3|vdd_b4|vdd_link|vdd_link_dip|vdd_x1|vdd_x2|vdd_x3
+ 144.903445918
* device instance a_d_inv_clk_vdd_inv_mc_vdd_inv_q_vdd_mpa_py_mpb_py_nand_m_vdd_nand_s2_vdd_nwell_vdd_sb_vdd_sr1_vdd_sr2_vdd_sr3_vdd_sr4_vdd_sv_d_vdd_tie_sv_vdd_tg_d_a_tg_d_vdd_tg_fbm_vdd_tg_fbs_vdd_tg_s_vdd_vdd_vdd_b1_vdd_b2_vdd_b3_vdd_b4_vdd_link_vdd_link_dip_vdd_x1_vdd_x2_vdd_x3_t64 r0 *1 0,0
Ra_d_inv_clk_vdd_inv_mc_vdd_inv_q_vdd_mpa_py_mpb_py_nand_m_vdd_nand_s2_vdd_nwell_vdd_sb_vdd_sr1_vdd_sr2_vdd_sr3_vdd_sr4_vdd_sv_d_vdd_tie_sv_vdd_tg_d_a_tg_d_vdd_tg_fbm_vdd_tg_fbs_vdd_tg_s_vdd_vdd_vdd_b1_vdd_b2_vdd_b3_vdd_b4_vdd_link_vdd_link_dip_vdd_x1_vdd_x2_vdd_x3_t64
+ a\x7cd\x7cinv_clk_vdd\x7cinv_mc_vdd\x7cinv_q_vdd\x7cmpa_py\x7cmpb_py\x7cnand_m_vdd\x7cnand_s2_vdd\x7cnwell_vdd\x7csb_vdd\x7csr1_vdd\x7csr2_vdd\x7csr3_vdd\x7csr4_vdd\x7csv_d_vdd_tie\x7csv_vdd\x7ctg_d_a\x7ctg_d_vdd\x7ctg_fbm_vdd\x7ctg_fbs_vdd\x7ctg_s_vdd\x7cvdd\x7cvdd_b1\x7cvdd_b2\x7cvdd_b3\x7cvdd_b4\x7cvdd_link\x7cvdd_link_dip\x7cvdd_x1\x7cvdd_x2\x7cvdd_x3__t64
+ a|d|inv_clk_vdd|inv_mc_vdd|inv_q_vdd|mpa_py|mpb_py|nand_m_vdd|nand_s2_vdd|nwell_vdd|sb_vdd|sr1_vdd|sr2_vdd|sr3_vdd|sr4_vdd|sv_d_vdd_tie|sv_vdd|tg_d_a|tg_d_vdd|tg_fbm_vdd|tg_fbs_vdd|tg_s_vdd|vdd|vdd_b1|vdd_b2|vdd_b3|vdd_b4|vdd_link|vdd_link_dip|vdd_x1|vdd_x2|vdd_x3
+ 128.856674127
* device instance a_d_inv_clk_vdd_inv_mc_vdd_inv_q_vdd_mpa_py_mpb_py_nand_m_vdd_nand_s2_vdd_nwell_vdd_sb_vdd_sr1_vdd_sr2_vdd_sr3_vdd_sr4_vdd_sv_d_vdd_tie_sv_vdd_tg_d_a_tg_d_vdd_tg_fbm_vdd_tg_fbs_vdd_tg_s_vdd_vdd_vdd_b1_vdd_b2_vdd_b3_vdd_b4_vdd_link_vdd_link_dip_vdd_x1_vdd_x2_vdd_x3_t65 r0 *1 0,0
Ra_d_inv_clk_vdd_inv_mc_vdd_inv_q_vdd_mpa_py_mpb_py_nand_m_vdd_nand_s2_vdd_nwell_vdd_sb_vdd_sr1_vdd_sr2_vdd_sr3_vdd_sr4_vdd_sv_d_vdd_tie_sv_vdd_tg_d_a_tg_d_vdd_tg_fbm_vdd_tg_fbs_vdd_tg_s_vdd_vdd_vdd_b1_vdd_b2_vdd_b3_vdd_b4_vdd_link_vdd_link_dip_vdd_x1_vdd_x2_vdd_x3_t65
+ a\x7cd\x7cinv_clk_vdd\x7cinv_mc_vdd\x7cinv_q_vdd\x7cmpa_py\x7cmpb_py\x7cnand_m_vdd\x7cnand_s2_vdd\x7cnwell_vdd\x7csb_vdd\x7csr1_vdd\x7csr2_vdd\x7csr3_vdd\x7csr4_vdd\x7csv_d_vdd_tie\x7csv_vdd\x7ctg_d_a\x7ctg_d_vdd\x7ctg_fbm_vdd\x7ctg_fbs_vdd\x7ctg_s_vdd\x7cvdd\x7cvdd_b1\x7cvdd_b2\x7cvdd_b3\x7cvdd_b4\x7cvdd_link\x7cvdd_link_dip\x7cvdd_x1\x7cvdd_x2\x7cvdd_x3__t65
+ a|d|inv_clk_vdd|inv_mc_vdd|inv_q_vdd|mpa_py|mpb_py|nand_m_vdd|nand_s2_vdd|nwell_vdd|sb_vdd|sr1_vdd|sr2_vdd|sr3_vdd|sr4_vdd|sv_d_vdd_tie|sv_vdd|tg_d_a|tg_d_vdd|tg_fbm_vdd|tg_fbs_vdd|tg_s_vdd|vdd|vdd_b1|vdd_b2|vdd_b3|vdd_b4|vdd_link|vdd_link_dip|vdd_x1|vdd_x2|vdd_x3
+ 209.024505261
* device instance a_d_inv_clk_vdd_inv_mc_vdd_inv_q_vdd_mpa_py_mpb_py_nand_m_vdd_nand_s2_vdd_nwell_vdd_sb_vdd_sr1_vdd_sr2_vdd_sr3_vdd_sr4_vdd_sv_d_vdd_tie_sv_vdd_tg_d_a_tg_d_vdd_tg_fbm_vdd_tg_fbs_vdd_tg_s_vdd_vdd_vdd_b1_vdd_b2_vdd_b3_vdd_b4_vdd_link_vdd_link_dip_vdd_x1_vdd_x2_vdd_x3_t66 r0 *1 0,0
Ra_d_inv_clk_vdd_inv_mc_vdd_inv_q_vdd_mpa_py_mpb_py_nand_m_vdd_nand_s2_vdd_nwell_vdd_sb_vdd_sr1_vdd_sr2_vdd_sr3_vdd_sr4_vdd_sv_d_vdd_tie_sv_vdd_tg_d_a_tg_d_vdd_tg_fbm_vdd_tg_fbs_vdd_tg_s_vdd_vdd_vdd_b1_vdd_b2_vdd_b3_vdd_b4_vdd_link_vdd_link_dip_vdd_x1_vdd_x2_vdd_x3_t66
+ a\x7cd\x7cinv_clk_vdd\x7cinv_mc_vdd\x7cinv_q_vdd\x7cmpa_py\x7cmpb_py\x7cnand_m_vdd\x7cnand_s2_vdd\x7cnwell_vdd\x7csb_vdd\x7csr1_vdd\x7csr2_vdd\x7csr3_vdd\x7csr4_vdd\x7csv_d_vdd_tie\x7csv_vdd\x7ctg_d_a\x7ctg_d_vdd\x7ctg_fbm_vdd\x7ctg_fbs_vdd\x7ctg_s_vdd\x7cvdd\x7cvdd_b1\x7cvdd_b2\x7cvdd_b3\x7cvdd_b4\x7cvdd_link\x7cvdd_link_dip\x7cvdd_x1\x7cvdd_x2\x7cvdd_x3__t66
+ a|d|inv_clk_vdd|inv_mc_vdd|inv_q_vdd|mpa_py|mpb_py|nand_m_vdd|nand_s2_vdd|nwell_vdd|sb_vdd|sr1_vdd|sr2_vdd|sr3_vdd|sr4_vdd|sv_d_vdd_tie|sv_vdd|tg_d_a|tg_d_vdd|tg_fbm_vdd|tg_fbs_vdd|tg_s_vdd|vdd|vdd_b1|vdd_b2|vdd_b3|vdd_b4|vdd_link|vdd_link_dip|vdd_x1|vdd_x2|vdd_x3
+ 185.930124671
* device instance a_d_inv_clk_vdd_inv_mc_vdd_inv_q_vdd_mpa_py_mpb_py_nand_m_vdd_nand_s2_vdd_nwell_vdd_sb_vdd_sr1_vdd_sr2_vdd_sr3_vdd_sr4_vdd_sv_d_vdd_tie_sv_vdd_tg_d_a_tg_d_vdd_tg_fbm_vdd_tg_fbs_vdd_tg_s_vdd_vdd_vdd_b1_vdd_b2_vdd_b3_vdd_b4_vdd_link_vdd_link_dip_vdd_x1_vdd_x2_vdd_x3_t67 r0 *1 0,0
Ra_d_inv_clk_vdd_inv_mc_vdd_inv_q_vdd_mpa_py_mpb_py_nand_m_vdd_nand_s2_vdd_nwell_vdd_sb_vdd_sr1_vdd_sr2_vdd_sr3_vdd_sr4_vdd_sv_d_vdd_tie_sv_vdd_tg_d_a_tg_d_vdd_tg_fbm_vdd_tg_fbs_vdd_tg_s_vdd_vdd_vdd_b1_vdd_b2_vdd_b3_vdd_b4_vdd_link_vdd_link_dip_vdd_x1_vdd_x2_vdd_x3_t67
+ a\x7cd\x7cinv_clk_vdd\x7cinv_mc_vdd\x7cinv_q_vdd\x7cmpa_py\x7cmpb_py\x7cnand_m_vdd\x7cnand_s2_vdd\x7cnwell_vdd\x7csb_vdd\x7csr1_vdd\x7csr2_vdd\x7csr3_vdd\x7csr4_vdd\x7csv_d_vdd_tie\x7csv_vdd\x7ctg_d_a\x7ctg_d_vdd\x7ctg_fbm_vdd\x7ctg_fbs_vdd\x7ctg_s_vdd\x7cvdd\x7cvdd_b1\x7cvdd_b2\x7cvdd_b3\x7cvdd_b4\x7cvdd_link\x7cvdd_link_dip\x7cvdd_x1\x7cvdd_x2\x7cvdd_x3__t67
+ a|d|inv_clk_vdd|inv_mc_vdd|inv_q_vdd|mpa_py|mpb_py|nand_m_vdd|nand_s2_vdd|nwell_vdd|sb_vdd|sr1_vdd|sr2_vdd|sr3_vdd|sr4_vdd|sv_d_vdd_tie|sv_vdd|tg_d_a|tg_d_vdd|tg_fbm_vdd|tg_fbs_vdd|tg_s_vdd|vdd|vdd_b1|vdd_b2|vdd_b3|vdd_b4|vdd_link|vdd_link_dip|vdd_x1|vdd_x2|vdd_x3
+ 178.358392946
* device instance a_d_inv_clk_vdd_inv_mc_vdd_inv_q_vdd_mpa_py_mpb_py_nand_m_vdd_nand_s2_vdd_nwell_vdd_sb_vdd_sr1_vdd_sr2_vdd_sr3_vdd_sr4_vdd_sv_d_vdd_tie_sv_vdd_tg_d_a_tg_d_vdd_tg_fbm_vdd_tg_fbs_vdd_tg_s_vdd_vdd_vdd_b1_vdd_b2_vdd_b3_vdd_b4_vdd_link_vdd_link_dip_vdd_x1_vdd_x2_vdd_x3_t68 r0 *1 0,0
Ra_d_inv_clk_vdd_inv_mc_vdd_inv_q_vdd_mpa_py_mpb_py_nand_m_vdd_nand_s2_vdd_nwell_vdd_sb_vdd_sr1_vdd_sr2_vdd_sr3_vdd_sr4_vdd_sv_d_vdd_tie_sv_vdd_tg_d_a_tg_d_vdd_tg_fbm_vdd_tg_fbs_vdd_tg_s_vdd_vdd_vdd_b1_vdd_b2_vdd_b3_vdd_b4_vdd_link_vdd_link_dip_vdd_x1_vdd_x2_vdd_x3_t68
+ a\x7cd\x7cinv_clk_vdd\x7cinv_mc_vdd\x7cinv_q_vdd\x7cmpa_py\x7cmpb_py\x7cnand_m_vdd\x7cnand_s2_vdd\x7cnwell_vdd\x7csb_vdd\x7csr1_vdd\x7csr2_vdd\x7csr3_vdd\x7csr4_vdd\x7csv_d_vdd_tie\x7csv_vdd\x7ctg_d_a\x7ctg_d_vdd\x7ctg_fbm_vdd\x7ctg_fbs_vdd\x7ctg_s_vdd\x7cvdd\x7cvdd_b1\x7cvdd_b2\x7cvdd_b3\x7cvdd_b4\x7cvdd_link\x7cvdd_link_dip\x7cvdd_x1\x7cvdd_x2\x7cvdd_x3__t68
+ a|d|inv_clk_vdd|inv_mc_vdd|inv_q_vdd|mpa_py|mpb_py|nand_m_vdd|nand_s2_vdd|nwell_vdd|sb_vdd|sr1_vdd|sr2_vdd|sr3_vdd|sr4_vdd|sv_d_vdd_tie|sv_vdd|tg_d_a|tg_d_vdd|tg_fbm_vdd|tg_fbs_vdd|tg_s_vdd|vdd|vdd_b1|vdd_b2|vdd_b3|vdd_b4|vdd_link|vdd_link_dip|vdd_x1|vdd_x2|vdd_x3
+ 170.193833797
* device instance a_d_inv_clk_vdd_inv_mc_vdd_inv_q_vdd_mpa_py_mpb_py_nand_m_vdd_nand_s2_vdd_nwell_vdd_sb_vdd_sr1_vdd_sr2_vdd_sr3_vdd_sr4_vdd_sv_d_vdd_tie_sv_vdd_tg_d_a_tg_d_vdd_tg_fbm_vdd_tg_fbs_vdd_tg_s_vdd_vdd_vdd_b1_vdd_b2_vdd_b3_vdd_b4_vdd_link_vdd_link_dip_vdd_x1_vdd_x2_vdd_x3_t69 r0 *1 0,0
Ra_d_inv_clk_vdd_inv_mc_vdd_inv_q_vdd_mpa_py_mpb_py_nand_m_vdd_nand_s2_vdd_nwell_vdd_sb_vdd_sr1_vdd_sr2_vdd_sr3_vdd_sr4_vdd_sv_d_vdd_tie_sv_vdd_tg_d_a_tg_d_vdd_tg_fbm_vdd_tg_fbs_vdd_tg_s_vdd_vdd_vdd_b1_vdd_b2_vdd_b3_vdd_b4_vdd_link_vdd_link_dip_vdd_x1_vdd_x2_vdd_x3_t69
+ a\x7cd\x7cinv_clk_vdd\x7cinv_mc_vdd\x7cinv_q_vdd\x7cmpa_py\x7cmpb_py\x7cnand_m_vdd\x7cnand_s2_vdd\x7cnwell_vdd\x7csb_vdd\x7csr1_vdd\x7csr2_vdd\x7csr3_vdd\x7csr4_vdd\x7csv_d_vdd_tie\x7csv_vdd\x7ctg_d_a\x7ctg_d_vdd\x7ctg_fbm_vdd\x7ctg_fbs_vdd\x7ctg_s_vdd\x7cvdd\x7cvdd_b1\x7cvdd_b2\x7cvdd_b3\x7cvdd_b4\x7cvdd_link\x7cvdd_link_dip\x7cvdd_x1\x7cvdd_x2\x7cvdd_x3__t69
+ a|d|inv_clk_vdd|inv_mc_vdd|inv_q_vdd|mpa_py|mpb_py|nand_m_vdd|nand_s2_vdd|nwell_vdd|sb_vdd|sr1_vdd|sr2_vdd|sr3_vdd|sr4_vdd|sv_d_vdd_tie|sv_vdd|tg_d_a|tg_d_vdd|tg_fbm_vdd|tg_fbs_vdd|tg_s_vdd|vdd|vdd_b1|vdd_b2|vdd_b3|vdd_b4|vdd_link|vdd_link_dip|vdd_x1|vdd_x2|vdd_x3
+ 159.390226843
* device instance a_d_inv_clk_vdd_inv_mc_vdd_inv_q_vdd_mpa_py_mpb_py_nand_m_vdd_nand_s2_vdd_nwell_vdd_sb_vdd_sr1_vdd_sr2_vdd_sr3_vdd_sr4_vdd_sv_d_vdd_tie_sv_vdd_tg_d_a_tg_d_vdd_tg_fbm_vdd_tg_fbs_vdd_tg_s_vdd_vdd_vdd_b1_vdd_b2_vdd_b3_vdd_b4_vdd_link_vdd_link_dip_vdd_x1_vdd_x2_vdd_x3_t70 r0 *1 0,0
Ra_d_inv_clk_vdd_inv_mc_vdd_inv_q_vdd_mpa_py_mpb_py_nand_m_vdd_nand_s2_vdd_nwell_vdd_sb_vdd_sr1_vdd_sr2_vdd_sr3_vdd_sr4_vdd_sv_d_vdd_tie_sv_vdd_tg_d_a_tg_d_vdd_tg_fbm_vdd_tg_fbs_vdd_tg_s_vdd_vdd_vdd_b1_vdd_b2_vdd_b3_vdd_b4_vdd_link_vdd_link_dip_vdd_x1_vdd_x2_vdd_x3_t70
+ a\x7cd\x7cinv_clk_vdd\x7cinv_mc_vdd\x7cinv_q_vdd\x7cmpa_py\x7cmpb_py\x7cnand_m_vdd\x7cnand_s2_vdd\x7cnwell_vdd\x7csb_vdd\x7csr1_vdd\x7csr2_vdd\x7csr3_vdd\x7csr4_vdd\x7csv_d_vdd_tie\x7csv_vdd\x7ctg_d_a\x7ctg_d_vdd\x7ctg_fbm_vdd\x7ctg_fbs_vdd\x7ctg_s_vdd\x7cvdd\x7cvdd_b1\x7cvdd_b2\x7cvdd_b3\x7cvdd_b4\x7cvdd_link\x7cvdd_link_dip\x7cvdd_x1\x7cvdd_x2\x7cvdd_x3__t70
+ a|d|inv_clk_vdd|inv_mc_vdd|inv_q_vdd|mpa_py|mpb_py|nand_m_vdd|nand_s2_vdd|nwell_vdd|sb_vdd|sr1_vdd|sr2_vdd|sr3_vdd|sr4_vdd|sv_d_vdd_tie|sv_vdd|tg_d_a|tg_d_vdd|tg_fbm_vdd|tg_fbs_vdd|tg_s_vdd|vdd|vdd_b1|vdd_b2|vdd_b3|vdd_b4|vdd_link|vdd_link_dip|vdd_x1|vdd_x2|vdd_x3
+ 139.590631508
* device instance a_d_inv_clk_vdd_inv_mc_vdd_inv_q_vdd_mpa_py_mpb_py_nand_m_vdd_nand_s2_vdd_nwell_vdd_sb_vdd_sr1_vdd_sr2_vdd_sr3_vdd_sr4_vdd_sv_d_vdd_tie_sv_vdd_tg_d_a_tg_d_vdd_tg_fbm_vdd_tg_fbs_vdd_tg_s_vdd_vdd_vdd_b1_vdd_b2_vdd_b3_vdd_b4_vdd_link_vdd_link_dip_vdd_x1_vdd_x2_vdd_x3_t71 r0 *1 0,0
Ra_d_inv_clk_vdd_inv_mc_vdd_inv_q_vdd_mpa_py_mpb_py_nand_m_vdd_nand_s2_vdd_nwell_vdd_sb_vdd_sr1_vdd_sr2_vdd_sr3_vdd_sr4_vdd_sv_d_vdd_tie_sv_vdd_tg_d_a_tg_d_vdd_tg_fbm_vdd_tg_fbs_vdd_tg_s_vdd_vdd_vdd_b1_vdd_b2_vdd_b3_vdd_b4_vdd_link_vdd_link_dip_vdd_x1_vdd_x2_vdd_x3_t71
+ a\x7cd\x7cinv_clk_vdd\x7cinv_mc_vdd\x7cinv_q_vdd\x7cmpa_py\x7cmpb_py\x7cnand_m_vdd\x7cnand_s2_vdd\x7cnwell_vdd\x7csb_vdd\x7csr1_vdd\x7csr2_vdd\x7csr3_vdd\x7csr4_vdd\x7csv_d_vdd_tie\x7csv_vdd\x7ctg_d_a\x7ctg_d_vdd\x7ctg_fbm_vdd\x7ctg_fbs_vdd\x7ctg_s_vdd\x7cvdd\x7cvdd_b1\x7cvdd_b2\x7cvdd_b3\x7cvdd_b4\x7cvdd_link\x7cvdd_link_dip\x7cvdd_x1\x7cvdd_x2\x7cvdd_x3__t71
+ a|d|inv_clk_vdd|inv_mc_vdd|inv_q_vdd|mpa_py|mpb_py|nand_m_vdd|nand_s2_vdd|nwell_vdd|sb_vdd|sr1_vdd|sr2_vdd|sr3_vdd|sr4_vdd|sv_d_vdd_tie|sv_vdd|tg_d_a|tg_d_vdd|tg_fbm_vdd|tg_fbs_vdd|tg_s_vdd|vdd|vdd_b1|vdd_b2|vdd_b3|vdd_b4|vdd_link|vdd_link_dip|vdd_x1|vdd_x2|vdd_x3
+ 128.228778725
* device instance a_d_inv_clk_vdd_inv_mc_vdd_inv_q_vdd_mpa_py_mpb_py_nand_m_vdd_nand_s2_vdd_nwell_vdd_sb_vdd_sr1_vdd_sr2_vdd_sr3_vdd_sr4_vdd_sv_d_vdd_tie_sv_vdd_tg_d_a_tg_d_vdd_tg_fbm_vdd_tg_fbs_vdd_tg_s_vdd_vdd_vdd_b1_vdd_b2_vdd_b3_vdd_b4_vdd_link_vdd_link_dip_vdd_x1_vdd_x2_vdd_x3_t72 r0 *1 0,0
Ra_d_inv_clk_vdd_inv_mc_vdd_inv_q_vdd_mpa_py_mpb_py_nand_m_vdd_nand_s2_vdd_nwell_vdd_sb_vdd_sr1_vdd_sr2_vdd_sr3_vdd_sr4_vdd_sv_d_vdd_tie_sv_vdd_tg_d_a_tg_d_vdd_tg_fbm_vdd_tg_fbs_vdd_tg_s_vdd_vdd_vdd_b1_vdd_b2_vdd_b3_vdd_b4_vdd_link_vdd_link_dip_vdd_x1_vdd_x2_vdd_x3_t72
+ a\x7cd\x7cinv_clk_vdd\x7cinv_mc_vdd\x7cinv_q_vdd\x7cmpa_py\x7cmpb_py\x7cnand_m_vdd\x7cnand_s2_vdd\x7cnwell_vdd\x7csb_vdd\x7csr1_vdd\x7csr2_vdd\x7csr3_vdd\x7csr4_vdd\x7csv_d_vdd_tie\x7csv_vdd\x7ctg_d_a\x7ctg_d_vdd\x7ctg_fbm_vdd\x7ctg_fbs_vdd\x7ctg_s_vdd\x7cvdd\x7cvdd_b1\x7cvdd_b2\x7cvdd_b3\x7cvdd_b4\x7cvdd_link\x7cvdd_link_dip\x7cvdd_x1\x7cvdd_x2\x7cvdd_x3__t72
+ a|d|inv_clk_vdd|inv_mc_vdd|inv_q_vdd|mpa_py|mpb_py|nand_m_vdd|nand_s2_vdd|nwell_vdd|sb_vdd|sr1_vdd|sr2_vdd|sr3_vdd|sr4_vdd|sv_d_vdd_tie|sv_vdd|tg_d_a|tg_d_vdd|tg_fbm_vdd|tg_fbs_vdd|tg_s_vdd|vdd|vdd_b1|vdd_b2|vdd_b3|vdd_b4|vdd_link|vdd_link_dip|vdd_x1|vdd_x2|vdd_x3
+ 120.692173373
* device instance a_d_inv_clk_vdd_inv_mc_vdd_inv_q_vdd_mpa_py_mpb_py_nand_m_vdd_nand_s2_vdd_nwell_vdd_sb_vdd_sr1_vdd_sr2_vdd_sr3_vdd_sr4_vdd_sv_d_vdd_tie_sv_vdd_tg_d_a_tg_d_vdd_tg_fbm_vdd_tg_fbs_vdd_tg_s_vdd_vdd_vdd_b1_vdd_b2_vdd_b3_vdd_b4_vdd_link_vdd_link_dip_vdd_x1_vdd_x2_vdd_x3_t73 r0 *1 0,0
Ra_d_inv_clk_vdd_inv_mc_vdd_inv_q_vdd_mpa_py_mpb_py_nand_m_vdd_nand_s2_vdd_nwell_vdd_sb_vdd_sr1_vdd_sr2_vdd_sr3_vdd_sr4_vdd_sv_d_vdd_tie_sv_vdd_tg_d_a_tg_d_vdd_tg_fbm_vdd_tg_fbs_vdd_tg_s_vdd_vdd_vdd_b1_vdd_b2_vdd_b3_vdd_b4_vdd_link_vdd_link_dip_vdd_x1_vdd_x2_vdd_x3_t73
+ a\x7cd\x7cinv_clk_vdd\x7cinv_mc_vdd\x7cinv_q_vdd\x7cmpa_py\x7cmpb_py\x7cnand_m_vdd\x7cnand_s2_vdd\x7cnwell_vdd\x7csb_vdd\x7csr1_vdd\x7csr2_vdd\x7csr3_vdd\x7csr4_vdd\x7csv_d_vdd_tie\x7csv_vdd\x7ctg_d_a\x7ctg_d_vdd\x7ctg_fbm_vdd\x7ctg_fbs_vdd\x7ctg_s_vdd\x7cvdd\x7cvdd_b1\x7cvdd_b2\x7cvdd_b3\x7cvdd_b4\x7cvdd_link\x7cvdd_link_dip\x7cvdd_x1\x7cvdd_x2\x7cvdd_x3__t73
+ a|d|inv_clk_vdd|inv_mc_vdd|inv_q_vdd|mpa_py|mpb_py|nand_m_vdd|nand_s2_vdd|nwell_vdd|sb_vdd|sr1_vdd|sr2_vdd|sr3_vdd|sr4_vdd|sv_d_vdd_tie|sv_vdd|tg_d_a|tg_d_vdd|tg_fbm_vdd|tg_fbs_vdd|tg_s_vdd|vdd|vdd_b1|vdd_b2|vdd_b3|vdd_b4|vdd_link|vdd_link_dip|vdd_x1|vdd_x2|vdd_x3
+ 97.781386643
* device instance a_d_inv_clk_vdd_inv_mc_vdd_inv_q_vdd_mpa_py_mpb_py_nand_m_vdd_nand_s2_vdd_nwell_vdd_sb_vdd_sr1_vdd_sr2_vdd_sr3_vdd_sr4_vdd_sv_d_vdd_tie_sv_vdd_tg_d_a_tg_d_vdd_tg_fbm_vdd_tg_fbs_vdd_tg_s_vdd_vdd_vdd_b1_vdd_b2_vdd_b3_vdd_b4_vdd_link_vdd_link_dip_vdd_x1_vdd_x2_vdd_x3_t74 r0 *1 0,0
Ra_d_inv_clk_vdd_inv_mc_vdd_inv_q_vdd_mpa_py_mpb_py_nand_m_vdd_nand_s2_vdd_nwell_vdd_sb_vdd_sr1_vdd_sr2_vdd_sr3_vdd_sr4_vdd_sv_d_vdd_tie_sv_vdd_tg_d_a_tg_d_vdd_tg_fbm_vdd_tg_fbs_vdd_tg_s_vdd_vdd_vdd_b1_vdd_b2_vdd_b3_vdd_b4_vdd_link_vdd_link_dip_vdd_x1_vdd_x2_vdd_x3_t74
+ a\x7cd\x7cinv_clk_vdd\x7cinv_mc_vdd\x7cinv_q_vdd\x7cmpa_py\x7cmpb_py\x7cnand_m_vdd\x7cnand_s2_vdd\x7cnwell_vdd\x7csb_vdd\x7csr1_vdd\x7csr2_vdd\x7csr3_vdd\x7csr4_vdd\x7csv_d_vdd_tie\x7csv_vdd\x7ctg_d_a\x7ctg_d_vdd\x7ctg_fbm_vdd\x7ctg_fbs_vdd\x7ctg_s_vdd\x7cvdd\x7cvdd_b1\x7cvdd_b2\x7cvdd_b3\x7cvdd_b4\x7cvdd_link\x7cvdd_link_dip\x7cvdd_x1\x7cvdd_x2\x7cvdd_x3__t74
+ a|d|inv_clk_vdd|inv_mc_vdd|inv_q_vdd|mpa_py|mpb_py|nand_m_vdd|nand_s2_vdd|nwell_vdd|sb_vdd|sr1_vdd|sr2_vdd|sr3_vdd|sr4_vdd|sv_d_vdd_tie|sv_vdd|tg_d_a|tg_d_vdd|tg_fbm_vdd|tg_fbs_vdd|tg_s_vdd|vdd|vdd_b1|vdd_b2|vdd_b3|vdd_b4|vdd_link|vdd_link_dip|vdd_x1|vdd_x2|vdd_x3
+ 217.193080742
* device instance a_d_inv_clk_vdd_inv_mc_vdd_inv_q_vdd_mpa_py_mpb_py_nand_m_vdd_nand_s2_vdd_nwell_vdd_sb_vdd_sr1_vdd_sr2_vdd_sr3_vdd_sr4_vdd_sv_d_vdd_tie_sv_vdd_tg_d_a_tg_d_vdd_tg_fbm_vdd_tg_fbs_vdd_tg_s_vdd_vdd_vdd_b1_vdd_b2_vdd_b3_vdd_b4_vdd_link_vdd_link_dip_vdd_x1_vdd_x2_vdd_x3_t75 r0 *1 0,0
Ra_d_inv_clk_vdd_inv_mc_vdd_inv_q_vdd_mpa_py_mpb_py_nand_m_vdd_nand_s2_vdd_nwell_vdd_sb_vdd_sr1_vdd_sr2_vdd_sr3_vdd_sr4_vdd_sv_d_vdd_tie_sv_vdd_tg_d_a_tg_d_vdd_tg_fbm_vdd_tg_fbs_vdd_tg_s_vdd_vdd_vdd_b1_vdd_b2_vdd_b3_vdd_b4_vdd_link_vdd_link_dip_vdd_x1_vdd_x2_vdd_x3_t75
+ a\x7cd\x7cinv_clk_vdd\x7cinv_mc_vdd\x7cinv_q_vdd\x7cmpa_py\x7cmpb_py\x7cnand_m_vdd\x7cnand_s2_vdd\x7cnwell_vdd\x7csb_vdd\x7csr1_vdd\x7csr2_vdd\x7csr3_vdd\x7csr4_vdd\x7csv_d_vdd_tie\x7csv_vdd\x7ctg_d_a\x7ctg_d_vdd\x7ctg_fbm_vdd\x7ctg_fbs_vdd\x7ctg_s_vdd\x7cvdd\x7cvdd_b1\x7cvdd_b2\x7cvdd_b3\x7cvdd_b4\x7cvdd_link\x7cvdd_link_dip\x7cvdd_x1\x7cvdd_x2\x7cvdd_x3__t75
+ a|d|inv_clk_vdd|inv_mc_vdd|inv_q_vdd|mpa_py|mpb_py|nand_m_vdd|nand_s2_vdd|nwell_vdd|sb_vdd|sr1_vdd|sr2_vdd|sr3_vdd|sr4_vdd|sv_d_vdd_tie|sv_vdd|tg_d_a|tg_d_vdd|tg_fbm_vdd|tg_fbs_vdd|tg_s_vdd|vdd|vdd_b1|vdd_b2|vdd_b3|vdd_b4|vdd_link|vdd_link_dip|vdd_x1|vdd_x2|vdd_x3
+ 52.99681623
* device instance a_d_inv_clk_vdd_inv_mc_vdd_inv_q_vdd_mpa_py_mpb_py_nand_m_vdd_nand_s2_vdd_nwell_vdd_sb_vdd_sr1_vdd_sr2_vdd_sr3_vdd_sr4_vdd_sv_d_vdd_tie_sv_vdd_tg_d_a_tg_d_vdd_tg_fbm_vdd_tg_fbs_vdd_tg_s_vdd_vdd_vdd_b1_vdd_b2_vdd_b3_vdd_b4_vdd_link_vdd_link_dip_vdd_x1_vdd_x2_vdd_x3_t76 r0 *1 0,0
Ra_d_inv_clk_vdd_inv_mc_vdd_inv_q_vdd_mpa_py_mpb_py_nand_m_vdd_nand_s2_vdd_nwell_vdd_sb_vdd_sr1_vdd_sr2_vdd_sr3_vdd_sr4_vdd_sv_d_vdd_tie_sv_vdd_tg_d_a_tg_d_vdd_tg_fbm_vdd_tg_fbs_vdd_tg_s_vdd_vdd_vdd_b1_vdd_b2_vdd_b3_vdd_b4_vdd_link_vdd_link_dip_vdd_x1_vdd_x2_vdd_x3_t76
+ a\x7cd\x7cinv_clk_vdd\x7cinv_mc_vdd\x7cinv_q_vdd\x7cmpa_py\x7cmpb_py\x7cnand_m_vdd\x7cnand_s2_vdd\x7cnwell_vdd\x7csb_vdd\x7csr1_vdd\x7csr2_vdd\x7csr3_vdd\x7csr4_vdd\x7csv_d_vdd_tie\x7csv_vdd\x7ctg_d_a\x7ctg_d_vdd\x7ctg_fbm_vdd\x7ctg_fbs_vdd\x7ctg_s_vdd\x7cvdd\x7cvdd_b1\x7cvdd_b2\x7cvdd_b3\x7cvdd_b4\x7cvdd_link\x7cvdd_link_dip\x7cvdd_x1\x7cvdd_x2\x7cvdd_x3__t76
+ a|d|inv_clk_vdd|inv_mc_vdd|inv_q_vdd|mpa_py|mpb_py|nand_m_vdd|nand_s2_vdd|nwell_vdd|sb_vdd|sr1_vdd|sr2_vdd|sr3_vdd|sr4_vdd|sv_d_vdd_tie|sv_vdd|tg_d_a|tg_d_vdd|tg_fbm_vdd|tg_fbs_vdd|tg_s_vdd|vdd|vdd_b1|vdd_b2|vdd_b3|vdd_b4|vdd_link|vdd_link_dip|vdd_x1|vdd_x2|vdd_x3
+ 59.6162837122
* device instance a_d_inv_clk_vdd_inv_mc_vdd_inv_q_vdd_mpa_py_mpb_py_nand_m_vdd_nand_s2_vdd_nwell_vdd_sb_vdd_sr1_vdd_sr2_vdd_sr3_vdd_sr4_vdd_sv_d_vdd_tie_sv_vdd_tg_d_a_tg_d_vdd_tg_fbm_vdd_tg_fbs_vdd_tg_s_vdd_vdd_vdd_b1_vdd_b2_vdd_b3_vdd_b4_vdd_link_vdd_link_dip_vdd_x1_vdd_x2_vdd_x3_t77 r0 *1 0,0
Ra_d_inv_clk_vdd_inv_mc_vdd_inv_q_vdd_mpa_py_mpb_py_nand_m_vdd_nand_s2_vdd_nwell_vdd_sb_vdd_sr1_vdd_sr2_vdd_sr3_vdd_sr4_vdd_sv_d_vdd_tie_sv_vdd_tg_d_a_tg_d_vdd_tg_fbm_vdd_tg_fbs_vdd_tg_s_vdd_vdd_vdd_b1_vdd_b2_vdd_b3_vdd_b4_vdd_link_vdd_link_dip_vdd_x1_vdd_x2_vdd_x3_t77
+ a\x7cd\x7cinv_clk_vdd\x7cinv_mc_vdd\x7cinv_q_vdd\x7cmpa_py\x7cmpb_py\x7cnand_m_vdd\x7cnand_s2_vdd\x7cnwell_vdd\x7csb_vdd\x7csr1_vdd\x7csr2_vdd\x7csr3_vdd\x7csr4_vdd\x7csv_d_vdd_tie\x7csv_vdd\x7ctg_d_a\x7ctg_d_vdd\x7ctg_fbm_vdd\x7ctg_fbs_vdd\x7ctg_s_vdd\x7cvdd\x7cvdd_b1\x7cvdd_b2\x7cvdd_b3\x7cvdd_b4\x7cvdd_link\x7cvdd_link_dip\x7cvdd_x1\x7cvdd_x2\x7cvdd_x3__t77
+ a|d|inv_clk_vdd|inv_mc_vdd|inv_q_vdd|mpa_py|mpb_py|nand_m_vdd|nand_s2_vdd|nwell_vdd|sb_vdd|sr1_vdd|sr2_vdd|sr3_vdd|sr4_vdd|sv_d_vdd_tie|sv_vdd|tg_d_a|tg_d_vdd|tg_fbm_vdd|tg_fbs_vdd|tg_s_vdd|vdd|vdd_b1|vdd_b2|vdd_b3|vdd_b4|vdd_link|vdd_link_dip|vdd_x1|vdd_x2|vdd_x3
+ 61.6014949214
* device instance a_d_inv_clk_vdd_inv_mc_vdd_inv_q_vdd_mpa_py_mpb_py_nand_m_vdd_nand_s2_vdd_nwell_vdd_sb_vdd_sr1_vdd_sr2_vdd_sr3_vdd_sr4_vdd_sv_d_vdd_tie_sv_vdd_tg_d_a_tg_d_vdd_tg_fbm_vdd_tg_fbs_vdd_tg_s_vdd_vdd_vdd_b1_vdd_b2_vdd_b3_vdd_b4_vdd_link_vdd_link_dip_vdd_x1_vdd_x2_vdd_x3_t78 r0 *1 0,0
Ra_d_inv_clk_vdd_inv_mc_vdd_inv_q_vdd_mpa_py_mpb_py_nand_m_vdd_nand_s2_vdd_nwell_vdd_sb_vdd_sr1_vdd_sr2_vdd_sr3_vdd_sr4_vdd_sv_d_vdd_tie_sv_vdd_tg_d_a_tg_d_vdd_tg_fbm_vdd_tg_fbs_vdd_tg_s_vdd_vdd_vdd_b1_vdd_b2_vdd_b3_vdd_b4_vdd_link_vdd_link_dip_vdd_x1_vdd_x2_vdd_x3_t78
+ a\x7cd\x7cinv_clk_vdd\x7cinv_mc_vdd\x7cinv_q_vdd\x7cmpa_py\x7cmpb_py\x7cnand_m_vdd\x7cnand_s2_vdd\x7cnwell_vdd\x7csb_vdd\x7csr1_vdd\x7csr2_vdd\x7csr3_vdd\x7csr4_vdd\x7csv_d_vdd_tie\x7csv_vdd\x7ctg_d_a\x7ctg_d_vdd\x7ctg_fbm_vdd\x7ctg_fbs_vdd\x7ctg_s_vdd\x7cvdd\x7cvdd_b1\x7cvdd_b2\x7cvdd_b3\x7cvdd_b4\x7cvdd_link\x7cvdd_link_dip\x7cvdd_x1\x7cvdd_x2\x7cvdd_x3__t78
+ a|d|inv_clk_vdd|inv_mc_vdd|inv_q_vdd|mpa_py|mpb_py|nand_m_vdd|nand_s2_vdd|nwell_vdd|sb_vdd|sr1_vdd|sr2_vdd|sr3_vdd|sr4_vdd|sv_d_vdd_tie|sv_vdd|tg_d_a|tg_d_vdd|tg_fbm_vdd|tg_fbs_vdd|tg_s_vdd|vdd|vdd_b1|vdd_b2|vdd_b3|vdd_b4|vdd_link|vdd_link_dip|vdd_x1|vdd_x2|vdd_x3
+ 16.3234289912
* device instance a_d_inv_clk_vdd_inv_mc_vdd_inv_q_vdd_mpa_py_mpb_py_nand_m_vdd_nand_s2_vdd_nwell_vdd_sb_vdd_sr1_vdd_sr2_vdd_sr3_vdd_sr4_vdd_sv_d_vdd_tie_sv_vdd_tg_d_a_tg_d_vdd_tg_fbm_vdd_tg_fbs_vdd_tg_s_vdd_vdd_vdd_b1_vdd_b2_vdd_b3_vdd_b4_vdd_link_vdd_link_dip_vdd_x1_vdd_x2_vdd_x3_t79 r0 *1 0,0
Ra_d_inv_clk_vdd_inv_mc_vdd_inv_q_vdd_mpa_py_mpb_py_nand_m_vdd_nand_s2_vdd_nwell_vdd_sb_vdd_sr1_vdd_sr2_vdd_sr3_vdd_sr4_vdd_sv_d_vdd_tie_sv_vdd_tg_d_a_tg_d_vdd_tg_fbm_vdd_tg_fbs_vdd_tg_s_vdd_vdd_vdd_b1_vdd_b2_vdd_b3_vdd_b4_vdd_link_vdd_link_dip_vdd_x1_vdd_x2_vdd_x3_t79
+ a\x7cd\x7cinv_clk_vdd\x7cinv_mc_vdd\x7cinv_q_vdd\x7cmpa_py\x7cmpb_py\x7cnand_m_vdd\x7cnand_s2_vdd\x7cnwell_vdd\x7csb_vdd\x7csr1_vdd\x7csr2_vdd\x7csr3_vdd\x7csr4_vdd\x7csv_d_vdd_tie\x7csv_vdd\x7ctg_d_a\x7ctg_d_vdd\x7ctg_fbm_vdd\x7ctg_fbs_vdd\x7ctg_s_vdd\x7cvdd\x7cvdd_b1\x7cvdd_b2\x7cvdd_b3\x7cvdd_b4\x7cvdd_link\x7cvdd_link_dip\x7cvdd_x1\x7cvdd_x2\x7cvdd_x3__t79
+ a|d|inv_clk_vdd|inv_mc_vdd|inv_q_vdd|mpa_py|mpb_py|nand_m_vdd|nand_s2_vdd|nwell_vdd|sb_vdd|sr1_vdd|sr2_vdd|sr3_vdd|sr4_vdd|sv_d_vdd_tie|sv_vdd|tg_d_a|tg_d_vdd|tg_fbm_vdd|tg_fbs_vdd|tg_s_vdd|vdd|vdd_b1|vdd_b2|vdd_b3|vdd_b4|vdd_link|vdd_link_dip|vdd_x1|vdd_x2|vdd_x3
+ 18.0086224576
* device instance a_d_inv_clk_vdd_inv_mc_vdd_inv_q_vdd_mpa_py_mpb_py_nand_m_vdd_nand_s2_vdd_nwell_vdd_sb_vdd_sr1_vdd_sr2_vdd_sr3_vdd_sr4_vdd_sv_d_vdd_tie_sv_vdd_tg_d_a_tg_d_vdd_tg_fbm_vdd_tg_fbs_vdd_tg_s_vdd_vdd_vdd_b1_vdd_b2_vdd_b3_vdd_b4_vdd_link_vdd_link_dip_vdd_x1_vdd_x2_vdd_x3_t80 r0 *1 0,0
Ra_d_inv_clk_vdd_inv_mc_vdd_inv_q_vdd_mpa_py_mpb_py_nand_m_vdd_nand_s2_vdd_nwell_vdd_sb_vdd_sr1_vdd_sr2_vdd_sr3_vdd_sr4_vdd_sv_d_vdd_tie_sv_vdd_tg_d_a_tg_d_vdd_tg_fbm_vdd_tg_fbs_vdd_tg_s_vdd_vdd_vdd_b1_vdd_b2_vdd_b3_vdd_b4_vdd_link_vdd_link_dip_vdd_x1_vdd_x2_vdd_x3_t80
+ a\x7cd\x7cinv_clk_vdd\x7cinv_mc_vdd\x7cinv_q_vdd\x7cmpa_py\x7cmpb_py\x7cnand_m_vdd\x7cnand_s2_vdd\x7cnwell_vdd\x7csb_vdd\x7csr1_vdd\x7csr2_vdd\x7csr3_vdd\x7csr4_vdd\x7csv_d_vdd_tie\x7csv_vdd\x7ctg_d_a\x7ctg_d_vdd\x7ctg_fbm_vdd\x7ctg_fbs_vdd\x7ctg_s_vdd\x7cvdd\x7cvdd_b1\x7cvdd_b2\x7cvdd_b3\x7cvdd_b4\x7cvdd_link\x7cvdd_link_dip\x7cvdd_x1\x7cvdd_x2\x7cvdd_x3__t80
+ a|d|inv_clk_vdd|inv_mc_vdd|inv_q_vdd|mpa_py|mpb_py|nand_m_vdd|nand_s2_vdd|nwell_vdd|sb_vdd|sr1_vdd|sr2_vdd|sr3_vdd|sr4_vdd|sv_d_vdd_tie|sv_vdd|tg_d_a|tg_d_vdd|tg_fbm_vdd|tg_fbs_vdd|tg_s_vdd|vdd|vdd_b1|vdd_b2|vdd_b3|vdd_b4|vdd_link|vdd_link_dip|vdd_x1|vdd_x2|vdd_x3
+ 34.8407839029
* device instance a_d_inv_clk_vdd_inv_mc_vdd_inv_q_vdd_mpa_py_mpb_py_nand_m_vdd_nand_s2_vdd_nwell_vdd_sb_vdd_sr1_vdd_sr2_vdd_sr3_vdd_sr4_vdd_sv_d_vdd_tie_sv_vdd_tg_d_a_tg_d_vdd_tg_fbm_vdd_tg_fbs_vdd_tg_s_vdd_vdd_vdd_b1_vdd_b2_vdd_b3_vdd_b4_vdd_link_vdd_link_dip_vdd_x1_vdd_x2_vdd_x3_t81 r0 *1 0,0
Ra_d_inv_clk_vdd_inv_mc_vdd_inv_q_vdd_mpa_py_mpb_py_nand_m_vdd_nand_s2_vdd_nwell_vdd_sb_vdd_sr1_vdd_sr2_vdd_sr3_vdd_sr4_vdd_sv_d_vdd_tie_sv_vdd_tg_d_a_tg_d_vdd_tg_fbm_vdd_tg_fbs_vdd_tg_s_vdd_vdd_vdd_b1_vdd_b2_vdd_b3_vdd_b4_vdd_link_vdd_link_dip_vdd_x1_vdd_x2_vdd_x3_t81
+ a\x7cd\x7cinv_clk_vdd\x7cinv_mc_vdd\x7cinv_q_vdd\x7cmpa_py\x7cmpb_py\x7cnand_m_vdd\x7cnand_s2_vdd\x7cnwell_vdd\x7csb_vdd\x7csr1_vdd\x7csr2_vdd\x7csr3_vdd\x7csr4_vdd\x7csv_d_vdd_tie\x7csv_vdd\x7ctg_d_a\x7ctg_d_vdd\x7ctg_fbm_vdd\x7ctg_fbs_vdd\x7ctg_s_vdd\x7cvdd\x7cvdd_b1\x7cvdd_b2\x7cvdd_b3\x7cvdd_b4\x7cvdd_link\x7cvdd_link_dip\x7cvdd_x1\x7cvdd_x2\x7cvdd_x3__t81
+ a|d|inv_clk_vdd|inv_mc_vdd|inv_q_vdd|mpa_py|mpb_py|nand_m_vdd|nand_s2_vdd|nwell_vdd|sb_vdd|sr1_vdd|sr2_vdd|sr3_vdd|sr4_vdd|sv_d_vdd_tie|sv_vdd|tg_d_a|tg_d_vdd|tg_fbm_vdd|tg_fbs_vdd|tg_s_vdd|vdd|vdd_b1|vdd_b2|vdd_b3|vdd_b4|vdd_link|vdd_link_dip|vdd_x1|vdd_x2|vdd_x3
+ 41.7094691189
* device instance a_d_inv_clk_vdd_inv_mc_vdd_inv_q_vdd_mpa_py_mpb_py_nand_m_vdd_nand_s2_vdd_nwell_vdd_sb_vdd_sr1_vdd_sr2_vdd_sr3_vdd_sr4_vdd_sv_d_vdd_tie_sv_vdd_tg_d_a_tg_d_vdd_tg_fbm_vdd_tg_fbs_vdd_tg_s_vdd_vdd_vdd_b1_vdd_b2_vdd_b3_vdd_b4_vdd_link_vdd_link_dip_vdd_x1_vdd_x2_vdd_x3_t82 r0 *1 0,0
Ra_d_inv_clk_vdd_inv_mc_vdd_inv_q_vdd_mpa_py_mpb_py_nand_m_vdd_nand_s2_vdd_nwell_vdd_sb_vdd_sr1_vdd_sr2_vdd_sr3_vdd_sr4_vdd_sv_d_vdd_tie_sv_vdd_tg_d_a_tg_d_vdd_tg_fbm_vdd_tg_fbs_vdd_tg_s_vdd_vdd_vdd_b1_vdd_b2_vdd_b3_vdd_b4_vdd_link_vdd_link_dip_vdd_x1_vdd_x2_vdd_x3_t82
+ a\x7cd\x7cinv_clk_vdd\x7cinv_mc_vdd\x7cinv_q_vdd\x7cmpa_py\x7cmpb_py\x7cnand_m_vdd\x7cnand_s2_vdd\x7cnwell_vdd\x7csb_vdd\x7csr1_vdd\x7csr2_vdd\x7csr3_vdd\x7csr4_vdd\x7csv_d_vdd_tie\x7csv_vdd\x7ctg_d_a\x7ctg_d_vdd\x7ctg_fbm_vdd\x7ctg_fbs_vdd\x7ctg_s_vdd\x7cvdd\x7cvdd_b1\x7cvdd_b2\x7cvdd_b3\x7cvdd_b4\x7cvdd_link\x7cvdd_link_dip\x7cvdd_x1\x7cvdd_x2\x7cvdd_x3__t82
+ a|d|inv_clk_vdd|inv_mc_vdd|inv_q_vdd|mpa_py|mpb_py|nand_m_vdd|nand_s2_vdd|nwell_vdd|sb_vdd|sr1_vdd|sr2_vdd|sr3_vdd|sr4_vdd|sv_d_vdd_tie|sv_vdd|tg_d_a|tg_d_vdd|tg_fbm_vdd|tg_fbs_vdd|tg_s_vdd|vdd|vdd_b1|vdd_b2|vdd_b3|vdd_b4|vdd_link|vdd_link_dip|vdd_x1|vdd_x2|vdd_x3
+ 52.4355126904
* device instance a_d_inv_clk_vdd_inv_mc_vdd_inv_q_vdd_mpa_py_mpb_py_nand_m_vdd_nand_s2_vdd_nwell_vdd_sb_vdd_sr1_vdd_sr2_vdd_sr3_vdd_sr4_vdd_sv_d_vdd_tie_sv_vdd_tg_d_a_tg_d_vdd_tg_fbm_vdd_tg_fbs_vdd_tg_s_vdd_vdd_vdd_b1_vdd_b2_vdd_b3_vdd_b4_vdd_link_vdd_link_dip_vdd_x1_vdd_x2_vdd_x3_t83 r0 *1 0,0
Ra_d_inv_clk_vdd_inv_mc_vdd_inv_q_vdd_mpa_py_mpb_py_nand_m_vdd_nand_s2_vdd_nwell_vdd_sb_vdd_sr1_vdd_sr2_vdd_sr3_vdd_sr4_vdd_sv_d_vdd_tie_sv_vdd_tg_d_a_tg_d_vdd_tg_fbm_vdd_tg_fbs_vdd_tg_s_vdd_vdd_vdd_b1_vdd_b2_vdd_b3_vdd_b4_vdd_link_vdd_link_dip_vdd_x1_vdd_x2_vdd_x3_t83
+ a\x7cd\x7cinv_clk_vdd\x7cinv_mc_vdd\x7cinv_q_vdd\x7cmpa_py\x7cmpb_py\x7cnand_m_vdd\x7cnand_s2_vdd\x7cnwell_vdd\x7csb_vdd\x7csr1_vdd\x7csr2_vdd\x7csr3_vdd\x7csr4_vdd\x7csv_d_vdd_tie\x7csv_vdd\x7ctg_d_a\x7ctg_d_vdd\x7ctg_fbm_vdd\x7ctg_fbs_vdd\x7ctg_s_vdd\x7cvdd\x7cvdd_b1\x7cvdd_b2\x7cvdd_b3\x7cvdd_b4\x7cvdd_link\x7cvdd_link_dip\x7cvdd_x1\x7cvdd_x2\x7cvdd_x3__t83
+ a|d|inv_clk_vdd|inv_mc_vdd|inv_q_vdd|mpa_py|mpb_py|nand_m_vdd|nand_s2_vdd|nwell_vdd|sb_vdd|sr1_vdd|sr2_vdd|sr3_vdd|sr4_vdd|sv_d_vdd_tie|sv_vdd|tg_d_a|tg_d_vdd|tg_fbm_vdd|tg_fbs_vdd|tg_s_vdd|vdd|vdd_b1|vdd_b2|vdd_b3|vdd_b4|vdd_link|vdd_link_dip|vdd_x1|vdd_x2|vdd_x3
+ 71.6338596465
* device instance a_d_inv_clk_vdd_inv_mc_vdd_inv_q_vdd_mpa_py_mpb_py_nand_m_vdd_nand_s2_vdd_nwell_vdd_sb_vdd_sr1_vdd_sr2_vdd_sr3_vdd_sr4_vdd_sv_d_vdd_tie_sv_vdd_tg_d_a_tg_d_vdd_tg_fbm_vdd_tg_fbs_vdd_tg_s_vdd_vdd_vdd_b1_vdd_b2_vdd_b3_vdd_b4_vdd_link_vdd_link_dip_vdd_x1_vdd_x2_vdd_x3_t84 r0 *1 0,0
Ra_d_inv_clk_vdd_inv_mc_vdd_inv_q_vdd_mpa_py_mpb_py_nand_m_vdd_nand_s2_vdd_nwell_vdd_sb_vdd_sr1_vdd_sr2_vdd_sr3_vdd_sr4_vdd_sv_d_vdd_tie_sv_vdd_tg_d_a_tg_d_vdd_tg_fbm_vdd_tg_fbs_vdd_tg_s_vdd_vdd_vdd_b1_vdd_b2_vdd_b3_vdd_b4_vdd_link_vdd_link_dip_vdd_x1_vdd_x2_vdd_x3_t84
+ a\x7cd\x7cinv_clk_vdd\x7cinv_mc_vdd\x7cinv_q_vdd\x7cmpa_py\x7cmpb_py\x7cnand_m_vdd\x7cnand_s2_vdd\x7cnwell_vdd\x7csb_vdd\x7csr1_vdd\x7csr2_vdd\x7csr3_vdd\x7csr4_vdd\x7csv_d_vdd_tie\x7csv_vdd\x7ctg_d_a\x7ctg_d_vdd\x7ctg_fbm_vdd\x7ctg_fbs_vdd\x7ctg_s_vdd\x7cvdd\x7cvdd_b1\x7cvdd_b2\x7cvdd_b3\x7cvdd_b4\x7cvdd_link\x7cvdd_link_dip\x7cvdd_x1\x7cvdd_x2\x7cvdd_x3__t84
+ a|d|inv_clk_vdd|inv_mc_vdd|inv_q_vdd|mpa_py|mpb_py|nand_m_vdd|nand_s2_vdd|nwell_vdd|sb_vdd|sr1_vdd|sr2_vdd|sr3_vdd|sr4_vdd|sv_d_vdd_tie|sv_vdd|tg_d_a|tg_d_vdd|tg_fbm_vdd|tg_fbs_vdd|tg_s_vdd|vdd|vdd_b1|vdd_b2|vdd_b3|vdd_b4|vdd_link|vdd_link_dip|vdd_x1|vdd_x2|vdd_x3
+ 82.2425003298
* device instance a_d_inv_clk_vdd_inv_mc_vdd_inv_q_vdd_mpa_py_mpb_py_nand_m_vdd_nand_s2_vdd_nwell_vdd_sb_vdd_sr1_vdd_sr2_vdd_sr3_vdd_sr4_vdd_sv_d_vdd_tie_sv_vdd_tg_d_a_tg_d_vdd_tg_fbm_vdd_tg_fbs_vdd_tg_s_vdd_vdd_vdd_b1_vdd_b2_vdd_b3_vdd_b4_vdd_link_vdd_link_dip_vdd_x1_vdd_x2_vdd_x3_t85 r0 *1 0,0
Ra_d_inv_clk_vdd_inv_mc_vdd_inv_q_vdd_mpa_py_mpb_py_nand_m_vdd_nand_s2_vdd_nwell_vdd_sb_vdd_sr1_vdd_sr2_vdd_sr3_vdd_sr4_vdd_sv_d_vdd_tie_sv_vdd_tg_d_a_tg_d_vdd_tg_fbm_vdd_tg_fbs_vdd_tg_s_vdd_vdd_vdd_b1_vdd_b2_vdd_b3_vdd_b4_vdd_link_vdd_link_dip_vdd_x1_vdd_x2_vdd_x3_t85
+ a\x7cd\x7cinv_clk_vdd\x7cinv_mc_vdd\x7cinv_q_vdd\x7cmpa_py\x7cmpb_py\x7cnand_m_vdd\x7cnand_s2_vdd\x7cnwell_vdd\x7csb_vdd\x7csr1_vdd\x7csr2_vdd\x7csr3_vdd\x7csr4_vdd\x7csv_d_vdd_tie\x7csv_vdd\x7ctg_d_a\x7ctg_d_vdd\x7ctg_fbm_vdd\x7ctg_fbs_vdd\x7ctg_s_vdd\x7cvdd\x7cvdd_b1\x7cvdd_b2\x7cvdd_b3\x7cvdd_b4\x7cvdd_link\x7cvdd_link_dip\x7cvdd_x1\x7cvdd_x2\x7cvdd_x3__t85
+ a|d|inv_clk_vdd|inv_mc_vdd|inv_q_vdd|mpa_py|mpb_py|nand_m_vdd|nand_s2_vdd|nwell_vdd|sb_vdd|sr1_vdd|sr2_vdd|sr3_vdd|sr4_vdd|sv_d_vdd_tie|sv_vdd|tg_d_a|tg_d_vdd|tg_fbm_vdd|tg_fbs_vdd|tg_s_vdd|vdd|vdd_b1|vdd_b2|vdd_b3|vdd_b4|vdd_link|vdd_link_dip|vdd_x1|vdd_x2|vdd_x3
+ 90.2946512063
* device instance a_d_inv_clk_vdd_inv_mc_vdd_inv_q_vdd_mpa_py_mpb_py_nand_m_vdd_nand_s2_vdd_nwell_vdd_sb_vdd_sr1_vdd_sr2_vdd_sr3_vdd_sr4_vdd_sv_d_vdd_tie_sv_vdd_tg_d_a_tg_d_vdd_tg_fbm_vdd_tg_fbs_vdd_tg_s_vdd_vdd_vdd_b1_vdd_b2_vdd_b3_vdd_b4_vdd_link_vdd_link_dip_vdd_x1_vdd_x2_vdd_x3_t86 r0 *1 0,0
Ra_d_inv_clk_vdd_inv_mc_vdd_inv_q_vdd_mpa_py_mpb_py_nand_m_vdd_nand_s2_vdd_nwell_vdd_sb_vdd_sr1_vdd_sr2_vdd_sr3_vdd_sr4_vdd_sv_d_vdd_tie_sv_vdd_tg_d_a_tg_d_vdd_tg_fbm_vdd_tg_fbs_vdd_tg_s_vdd_vdd_vdd_b1_vdd_b2_vdd_b3_vdd_b4_vdd_link_vdd_link_dip_vdd_x1_vdd_x2_vdd_x3_t86
+ a\x7cd\x7cinv_clk_vdd\x7cinv_mc_vdd\x7cinv_q_vdd\x7cmpa_py\x7cmpb_py\x7cnand_m_vdd\x7cnand_s2_vdd\x7cnwell_vdd\x7csb_vdd\x7csr1_vdd\x7csr2_vdd\x7csr3_vdd\x7csr4_vdd\x7csv_d_vdd_tie\x7csv_vdd\x7ctg_d_a\x7ctg_d_vdd\x7ctg_fbm_vdd\x7ctg_fbs_vdd\x7ctg_s_vdd\x7cvdd\x7cvdd_b1\x7cvdd_b2\x7cvdd_b3\x7cvdd_b4\x7cvdd_link\x7cvdd_link_dip\x7cvdd_x1\x7cvdd_x2\x7cvdd_x3__t86
+ a|d|inv_clk_vdd|inv_mc_vdd|inv_q_vdd|mpa_py|mpb_py|nand_m_vdd|nand_s2_vdd|nwell_vdd|sb_vdd|sr1_vdd|sr2_vdd|sr3_vdd|sr4_vdd|sv_d_vdd_tie|sv_vdd|tg_d_a|tg_d_vdd|tg_fbm_vdd|tg_fbs_vdd|tg_s_vdd|vdd|vdd_b1|vdd_b2|vdd_b3|vdd_b4|vdd_link|vdd_link_dip|vdd_x1|vdd_x2|vdd_x3
+ 178.35044916
* device instance a_d_inv_clk_vdd_inv_mc_vdd_inv_q_vdd_mpa_py_mpb_py_nand_m_vdd_nand_s2_vdd_nwell_vdd_sb_vdd_sr1_vdd_sr2_vdd_sr3_vdd_sr4_vdd_sv_d_vdd_tie_sv_vdd_tg_d_a_tg_d_vdd_tg_fbm_vdd_tg_fbs_vdd_tg_s_vdd_vdd_vdd_b1_vdd_b2_vdd_b3_vdd_b4_vdd_link_vdd_link_dip_vdd_x1_vdd_x2_vdd_x3_t87 r0 *1 0,0
Ra_d_inv_clk_vdd_inv_mc_vdd_inv_q_vdd_mpa_py_mpb_py_nand_m_vdd_nand_s2_vdd_nwell_vdd_sb_vdd_sr1_vdd_sr2_vdd_sr3_vdd_sr4_vdd_sv_d_vdd_tie_sv_vdd_tg_d_a_tg_d_vdd_tg_fbm_vdd_tg_fbs_vdd_tg_s_vdd_vdd_vdd_b1_vdd_b2_vdd_b3_vdd_b4_vdd_link_vdd_link_dip_vdd_x1_vdd_x2_vdd_x3_t87
+ a\x7cd\x7cinv_clk_vdd\x7cinv_mc_vdd\x7cinv_q_vdd\x7cmpa_py\x7cmpb_py\x7cnand_m_vdd\x7cnand_s2_vdd\x7cnwell_vdd\x7csb_vdd\x7csr1_vdd\x7csr2_vdd\x7csr3_vdd\x7csr4_vdd\x7csv_d_vdd_tie\x7csv_vdd\x7ctg_d_a\x7ctg_d_vdd\x7ctg_fbm_vdd\x7ctg_fbs_vdd\x7ctg_s_vdd\x7cvdd\x7cvdd_b1\x7cvdd_b2\x7cvdd_b3\x7cvdd_b4\x7cvdd_link\x7cvdd_link_dip\x7cvdd_x1\x7cvdd_x2\x7cvdd_x3__t87
+ a|d|inv_clk_vdd|inv_mc_vdd|inv_q_vdd|mpa_py|mpb_py|nand_m_vdd|nand_s2_vdd|nwell_vdd|sb_vdd|sr1_vdd|sr2_vdd|sr3_vdd|sr4_vdd|sv_d_vdd_tie|sv_vdd|tg_d_a|tg_d_vdd|tg_fbm_vdd|tg_fbs_vdd|tg_s_vdd|vdd|vdd_b1|vdd_b2|vdd_b3|vdd_b4|vdd_link|vdd_link_dip|vdd_x1|vdd_x2|vdd_x3
+ 170.781439528
* device instance a_d_inv_clk_vdd_inv_mc_vdd_inv_q_vdd_mpa_py_mpb_py_nand_m_vdd_nand_s2_vdd_nwell_vdd_sb_vdd_sr1_vdd_sr2_vdd_sr3_vdd_sr4_vdd_sv_d_vdd_tie_sv_vdd_tg_d_a_tg_d_vdd_tg_fbm_vdd_tg_fbs_vdd_tg_s_vdd_vdd_vdd_b1_vdd_b2_vdd_b3_vdd_b4_vdd_link_vdd_link_dip_vdd_x1_vdd_x2_vdd_x3_t88 r0 *1 0,0
Ra_d_inv_clk_vdd_inv_mc_vdd_inv_q_vdd_mpa_py_mpb_py_nand_m_vdd_nand_s2_vdd_nwell_vdd_sb_vdd_sr1_vdd_sr2_vdd_sr3_vdd_sr4_vdd_sv_d_vdd_tie_sv_vdd_tg_d_a_tg_d_vdd_tg_fbm_vdd_tg_fbs_vdd_tg_s_vdd_vdd_vdd_b1_vdd_b2_vdd_b3_vdd_b4_vdd_link_vdd_link_dip_vdd_x1_vdd_x2_vdd_x3_t88
+ a\x7cd\x7cinv_clk_vdd\x7cinv_mc_vdd\x7cinv_q_vdd\x7cmpa_py\x7cmpb_py\x7cnand_m_vdd\x7cnand_s2_vdd\x7cnwell_vdd\x7csb_vdd\x7csr1_vdd\x7csr2_vdd\x7csr3_vdd\x7csr4_vdd\x7csv_d_vdd_tie\x7csv_vdd\x7ctg_d_a\x7ctg_d_vdd\x7ctg_fbm_vdd\x7ctg_fbs_vdd\x7ctg_s_vdd\x7cvdd\x7cvdd_b1\x7cvdd_b2\x7cvdd_b3\x7cvdd_b4\x7cvdd_link\x7cvdd_link_dip\x7cvdd_x1\x7cvdd_x2\x7cvdd_x3__t88
+ a|d|inv_clk_vdd|inv_mc_vdd|inv_q_vdd|mpa_py|mpb_py|nand_m_vdd|nand_s2_vdd|nwell_vdd|sb_vdd|sr1_vdd|sr2_vdd|sr3_vdd|sr4_vdd|sv_d_vdd_tie|sv_vdd|tg_d_a|tg_d_vdd|tg_fbm_vdd|tg_fbs_vdd|tg_s_vdd|vdd|vdd_b1|vdd_b2|vdd_b3|vdd_b4|vdd_link|vdd_link_dip|vdd_x1|vdd_x2|vdd_x3
+ 35.2099854688
* device instance a_d_inv_clk_vdd_inv_mc_vdd_inv_q_vdd_mpa_py_mpb_py_nand_m_vdd_nand_s2_vdd_nwell_vdd_sb_vdd_sr1_vdd_sr2_vdd_sr3_vdd_sr4_vdd_sv_d_vdd_tie_sv_vdd_tg_d_a_tg_d_vdd_tg_fbm_vdd_tg_fbs_vdd_tg_s_vdd_vdd_vdd_b1_vdd_b2_vdd_b3_vdd_b4_vdd_link_vdd_link_dip_vdd_x1_vdd_x2_vdd_x3_t89 r0 *1 0,0
Ra_d_inv_clk_vdd_inv_mc_vdd_inv_q_vdd_mpa_py_mpb_py_nand_m_vdd_nand_s2_vdd_nwell_vdd_sb_vdd_sr1_vdd_sr2_vdd_sr3_vdd_sr4_vdd_sv_d_vdd_tie_sv_vdd_tg_d_a_tg_d_vdd_tg_fbm_vdd_tg_fbs_vdd_tg_s_vdd_vdd_vdd_b1_vdd_b2_vdd_b3_vdd_b4_vdd_link_vdd_link_dip_vdd_x1_vdd_x2_vdd_x3_t89
+ a\x7cd\x7cinv_clk_vdd\x7cinv_mc_vdd\x7cinv_q_vdd\x7cmpa_py\x7cmpb_py\x7cnand_m_vdd\x7cnand_s2_vdd\x7cnwell_vdd\x7csb_vdd\x7csr1_vdd\x7csr2_vdd\x7csr3_vdd\x7csr4_vdd\x7csv_d_vdd_tie\x7csv_vdd\x7ctg_d_a\x7ctg_d_vdd\x7ctg_fbm_vdd\x7ctg_fbs_vdd\x7ctg_s_vdd\x7cvdd\x7cvdd_b1\x7cvdd_b2\x7cvdd_b3\x7cvdd_b4\x7cvdd_link\x7cvdd_link_dip\x7cvdd_x1\x7cvdd_x2\x7cvdd_x3__t89
+ a|d|inv_clk_vdd|inv_mc_vdd|inv_q_vdd|mpa_py|mpb_py|nand_m_vdd|nand_s2_vdd|nwell_vdd|sb_vdd|sr1_vdd|sr2_vdd|sr3_vdd|sr4_vdd|sv_d_vdd_tie|sv_vdd|tg_d_a|tg_d_vdd|tg_fbm_vdd|tg_fbs_vdd|tg_s_vdd|vdd|vdd_b1|vdd_b2|vdd_b3|vdd_b4|vdd_link|vdd_link_dip|vdd_x1|vdd_x2|vdd_x3
+ 147.7301832
* device instance a_d_inv_clk_vdd_inv_mc_vdd_inv_q_vdd_mpa_py_mpb_py_nand_m_vdd_nand_s2_vdd_nwell_vdd_sb_vdd_sr1_vdd_sr2_vdd_sr3_vdd_sr4_vdd_sv_d_vdd_tie_sv_vdd_tg_d_a_tg_d_vdd_tg_fbm_vdd_tg_fbs_vdd_tg_s_vdd_vdd_vdd_b1_vdd_b2_vdd_b3_vdd_b4_vdd_link_vdd_link_dip_vdd_x1_vdd_x2_vdd_x3_t90 r0 *1 0,0
Ra_d_inv_clk_vdd_inv_mc_vdd_inv_q_vdd_mpa_py_mpb_py_nand_m_vdd_nand_s2_vdd_nwell_vdd_sb_vdd_sr1_vdd_sr2_vdd_sr3_vdd_sr4_vdd_sv_d_vdd_tie_sv_vdd_tg_d_a_tg_d_vdd_tg_fbm_vdd_tg_fbs_vdd_tg_s_vdd_vdd_vdd_b1_vdd_b2_vdd_b3_vdd_b4_vdd_link_vdd_link_dip_vdd_x1_vdd_x2_vdd_x3_t90
+ a\x7cd\x7cinv_clk_vdd\x7cinv_mc_vdd\x7cinv_q_vdd\x7cmpa_py\x7cmpb_py\x7cnand_m_vdd\x7cnand_s2_vdd\x7cnwell_vdd\x7csb_vdd\x7csr1_vdd\x7csr2_vdd\x7csr3_vdd\x7csr4_vdd\x7csv_d_vdd_tie\x7csv_vdd\x7ctg_d_a\x7ctg_d_vdd\x7ctg_fbm_vdd\x7ctg_fbs_vdd\x7ctg_s_vdd\x7cvdd\x7cvdd_b1\x7cvdd_b2\x7cvdd_b3\x7cvdd_b4\x7cvdd_link\x7cvdd_link_dip\x7cvdd_x1\x7cvdd_x2\x7cvdd_x3__t90
+ a|d|inv_clk_vdd|inv_mc_vdd|inv_q_vdd|mpa_py|mpb_py|nand_m_vdd|nand_s2_vdd|nwell_vdd|sb_vdd|sr1_vdd|sr2_vdd|sr3_vdd|sr4_vdd|sv_d_vdd_tie|sv_vdd|tg_d_a|tg_d_vdd|tg_fbm_vdd|tg_fbs_vdd|tg_s_vdd|vdd|vdd_b1|vdd_b2|vdd_b3|vdd_b4|vdd_link|vdd_link_dip|vdd_x1|vdd_x2|vdd_x3
+ 140.176916225
* device instance a_d_inv_clk_vdd_inv_mc_vdd_inv_q_vdd_mpa_py_mpb_py_nand_m_vdd_nand_s2_vdd_nwell_vdd_sb_vdd_sr1_vdd_sr2_vdd_sr3_vdd_sr4_vdd_sv_d_vdd_tie_sv_vdd_tg_d_a_tg_d_vdd_tg_fbm_vdd_tg_fbs_vdd_tg_s_vdd_vdd_vdd_b1_vdd_b2_vdd_b3_vdd_b4_vdd_link_vdd_link_dip_vdd_x1_vdd_x2_vdd_x3_t91 r0 *1 0,0
Ra_d_inv_clk_vdd_inv_mc_vdd_inv_q_vdd_mpa_py_mpb_py_nand_m_vdd_nand_s2_vdd_nwell_vdd_sb_vdd_sr1_vdd_sr2_vdd_sr3_vdd_sr4_vdd_sv_d_vdd_tie_sv_vdd_tg_d_a_tg_d_vdd_tg_fbm_vdd_tg_fbs_vdd_tg_s_vdd_vdd_vdd_b1_vdd_b2_vdd_b3_vdd_b4_vdd_link_vdd_link_dip_vdd_x1_vdd_x2_vdd_x3_t91
+ a\x7cd\x7cinv_clk_vdd\x7cinv_mc_vdd\x7cinv_q_vdd\x7cmpa_py\x7cmpb_py\x7cnand_m_vdd\x7cnand_s2_vdd\x7cnwell_vdd\x7csb_vdd\x7csr1_vdd\x7csr2_vdd\x7csr3_vdd\x7csr4_vdd\x7csv_d_vdd_tie\x7csv_vdd\x7ctg_d_a\x7ctg_d_vdd\x7ctg_fbm_vdd\x7ctg_fbs_vdd\x7ctg_s_vdd\x7cvdd\x7cvdd_b1\x7cvdd_b2\x7cvdd_b3\x7cvdd_b4\x7cvdd_link\x7cvdd_link_dip\x7cvdd_x1\x7cvdd_x2\x7cvdd_x3__t91
+ a|d|inv_clk_vdd|inv_mc_vdd|inv_q_vdd|mpa_py|mpb_py|nand_m_vdd|nand_s2_vdd|nwell_vdd|sb_vdd|sr1_vdd|sr2_vdd|sr3_vdd|sr4_vdd|sv_d_vdd_tie|sv_vdd|tg_d_a|tg_d_vdd|tg_fbm_vdd|tg_fbs_vdd|tg_s_vdd|vdd|vdd_b1|vdd_b2|vdd_b3|vdd_b4|vdd_link|vdd_link_dip|vdd_x1|vdd_x2|vdd_x3
+ 33.3893566304
* device instance a_d_inv_clk_vdd_inv_mc_vdd_inv_q_vdd_mpa_py_mpb_py_nand_m_vdd_nand_s2_vdd_nwell_vdd_sb_vdd_sr1_vdd_sr2_vdd_sr3_vdd_sr4_vdd_sv_d_vdd_tie_sv_vdd_tg_d_a_tg_d_vdd_tg_fbm_vdd_tg_fbs_vdd_tg_s_vdd_vdd_vdd_b1_vdd_b2_vdd_b3_vdd_b4_vdd_link_vdd_link_dip_vdd_x1_vdd_x2_vdd_x3_t92 r0 *1 0,0
Ra_d_inv_clk_vdd_inv_mc_vdd_inv_q_vdd_mpa_py_mpb_py_nand_m_vdd_nand_s2_vdd_nwell_vdd_sb_vdd_sr1_vdd_sr2_vdd_sr3_vdd_sr4_vdd_sv_d_vdd_tie_sv_vdd_tg_d_a_tg_d_vdd_tg_fbm_vdd_tg_fbs_vdd_tg_s_vdd_vdd_vdd_b1_vdd_b2_vdd_b3_vdd_b4_vdd_link_vdd_link_dip_vdd_x1_vdd_x2_vdd_x3_t92
+ a\x7cd\x7cinv_clk_vdd\x7cinv_mc_vdd\x7cinv_q_vdd\x7cmpa_py\x7cmpb_py\x7cnand_m_vdd\x7cnand_s2_vdd\x7cnwell_vdd\x7csb_vdd\x7csr1_vdd\x7csr2_vdd\x7csr3_vdd\x7csr4_vdd\x7csv_d_vdd_tie\x7csv_vdd\x7ctg_d_a\x7ctg_d_vdd\x7ctg_fbm_vdd\x7ctg_fbs_vdd\x7ctg_s_vdd\x7cvdd\x7cvdd_b1\x7cvdd_b2\x7cvdd_b3\x7cvdd_b4\x7cvdd_link\x7cvdd_link_dip\x7cvdd_x1\x7cvdd_x2\x7cvdd_x3__t92
+ a|d|inv_clk_vdd|inv_mc_vdd|inv_q_vdd|mpa_py|mpb_py|nand_m_vdd|nand_s2_vdd|nwell_vdd|sb_vdd|sr1_vdd|sr2_vdd|sr3_vdd|sr4_vdd|sv_d_vdd_tie|sv_vdd|tg_d_a|tg_d_vdd|tg_fbm_vdd|tg_fbs_vdd|tg_s_vdd|vdd|vdd_b1|vdd_b2|vdd_b3|vdd_b4|vdd_link|vdd_link_dip|vdd_x1|vdd_x2|vdd_x3
+ 23.9747745283
* device instance a_d_inv_clk_vdd_inv_mc_vdd_inv_q_vdd_mpa_py_mpb_py_nand_m_vdd_nand_s2_vdd_nwell_vdd_sb_vdd_sr1_vdd_sr2_vdd_sr3_vdd_sr4_vdd_sv_d_vdd_tie_sv_vdd_tg_d_a_tg_d_vdd_tg_fbm_vdd_tg_fbs_vdd_tg_s_vdd_vdd_vdd_b1_vdd_b2_vdd_b3_vdd_b4_vdd_link_vdd_link_dip_vdd_x1_vdd_x2_vdd_x3_t93 r0 *1 0,0
Ra_d_inv_clk_vdd_inv_mc_vdd_inv_q_vdd_mpa_py_mpb_py_nand_m_vdd_nand_s2_vdd_nwell_vdd_sb_vdd_sr1_vdd_sr2_vdd_sr3_vdd_sr4_vdd_sv_d_vdd_tie_sv_vdd_tg_d_a_tg_d_vdd_tg_fbm_vdd_tg_fbs_vdd_tg_s_vdd_vdd_vdd_b1_vdd_b2_vdd_b3_vdd_b4_vdd_link_vdd_link_dip_vdd_x1_vdd_x2_vdd_x3_t93
+ a\x7cd\x7cinv_clk_vdd\x7cinv_mc_vdd\x7cinv_q_vdd\x7cmpa_py\x7cmpb_py\x7cnand_m_vdd\x7cnand_s2_vdd\x7cnwell_vdd\x7csb_vdd\x7csr1_vdd\x7csr2_vdd\x7csr3_vdd\x7csr4_vdd\x7csv_d_vdd_tie\x7csv_vdd\x7ctg_d_a\x7ctg_d_vdd\x7ctg_fbm_vdd\x7ctg_fbs_vdd\x7ctg_s_vdd\x7cvdd\x7cvdd_b1\x7cvdd_b2\x7cvdd_b3\x7cvdd_b4\x7cvdd_link\x7cvdd_link_dip\x7cvdd_x1\x7cvdd_x2\x7cvdd_x3__t93
+ a|d|inv_clk_vdd|inv_mc_vdd|inv_q_vdd|mpa_py|mpb_py|nand_m_vdd|nand_s2_vdd|nwell_vdd|sb_vdd|sr1_vdd|sr2_vdd|sr3_vdd|sr4_vdd|sv_d_vdd_tie|sv_vdd|tg_d_a|tg_d_vdd|tg_fbm_vdd|tg_fbs_vdd|tg_s_vdd|vdd|vdd_b1|vdd_b2|vdd_b3|vdd_b4|vdd_link|vdd_link_dip|vdd_x1|vdd_x2|vdd_x3
+ 128.81431578
* device instance a_d_inv_clk_vdd_inv_mc_vdd_inv_q_vdd_mpa_py_mpb_py_nand_m_vdd_nand_s2_vdd_nwell_vdd_sb_vdd_sr1_vdd_sr2_vdd_sr3_vdd_sr4_vdd_sv_d_vdd_tie_sv_vdd_tg_d_a_tg_d_vdd_tg_fbm_vdd_tg_fbs_vdd_tg_s_vdd_vdd_vdd_b1_vdd_b2_vdd_b3_vdd_b4_vdd_link_vdd_link_dip_vdd_x1_vdd_x2_vdd_x3_t94 r0 *1 0,0
Ra_d_inv_clk_vdd_inv_mc_vdd_inv_q_vdd_mpa_py_mpb_py_nand_m_vdd_nand_s2_vdd_nwell_vdd_sb_vdd_sr1_vdd_sr2_vdd_sr3_vdd_sr4_vdd_sv_d_vdd_tie_sv_vdd_tg_d_a_tg_d_vdd_tg_fbm_vdd_tg_fbs_vdd_tg_s_vdd_vdd_vdd_b1_vdd_b2_vdd_b3_vdd_b4_vdd_link_vdd_link_dip_vdd_x1_vdd_x2_vdd_x3_t94
+ a\x7cd\x7cinv_clk_vdd\x7cinv_mc_vdd\x7cinv_q_vdd\x7cmpa_py\x7cmpb_py\x7cnand_m_vdd\x7cnand_s2_vdd\x7cnwell_vdd\x7csb_vdd\x7csr1_vdd\x7csr2_vdd\x7csr3_vdd\x7csr4_vdd\x7csv_d_vdd_tie\x7csv_vdd\x7ctg_d_a\x7ctg_d_vdd\x7ctg_fbm_vdd\x7ctg_fbs_vdd\x7ctg_s_vdd\x7cvdd\x7cvdd_b1\x7cvdd_b2\x7cvdd_b3\x7cvdd_b4\x7cvdd_link\x7cvdd_link_dip\x7cvdd_x1\x7cvdd_x2\x7cvdd_x3__t94
+ a|d|inv_clk_vdd|inv_mc_vdd|inv_q_vdd|mpa_py|mpb_py|nand_m_vdd|nand_s2_vdd|nwell_vdd|sb_vdd|sr1_vdd|sr2_vdd|sr3_vdd|sr4_vdd|sv_d_vdd_tie|sv_vdd|tg_d_a|tg_d_vdd|tg_fbm_vdd|tg_fbs_vdd|tg_s_vdd|vdd|vdd_b1|vdd_b2|vdd_b3|vdd_b4|vdd_link|vdd_link_dip|vdd_x1|vdd_x2|vdd_x3
+ 25.5453177452
* device instance a_d_inv_clk_vdd_inv_mc_vdd_inv_q_vdd_mpa_py_mpb_py_nand_m_vdd_nand_s2_vdd_nwell_vdd_sb_vdd_sr1_vdd_sr2_vdd_sr3_vdd_sr4_vdd_sv_d_vdd_tie_sv_vdd_tg_d_a_tg_d_vdd_tg_fbm_vdd_tg_fbs_vdd_tg_s_vdd_vdd_vdd_b1_vdd_b2_vdd_b3_vdd_b4_vdd_link_vdd_link_dip_vdd_x1_vdd_x2_vdd_x3_t95 r0 *1 0,0
Ra_d_inv_clk_vdd_inv_mc_vdd_inv_q_vdd_mpa_py_mpb_py_nand_m_vdd_nand_s2_vdd_nwell_vdd_sb_vdd_sr1_vdd_sr2_vdd_sr3_vdd_sr4_vdd_sv_d_vdd_tie_sv_vdd_tg_d_a_tg_d_vdd_tg_fbm_vdd_tg_fbs_vdd_tg_s_vdd_vdd_vdd_b1_vdd_b2_vdd_b3_vdd_b4_vdd_link_vdd_link_dip_vdd_x1_vdd_x2_vdd_x3_t95
+ a\x7cd\x7cinv_clk_vdd\x7cinv_mc_vdd\x7cinv_q_vdd\x7cmpa_py\x7cmpb_py\x7cnand_m_vdd\x7cnand_s2_vdd\x7cnwell_vdd\x7csb_vdd\x7csr1_vdd\x7csr2_vdd\x7csr3_vdd\x7csr4_vdd\x7csv_d_vdd_tie\x7csv_vdd\x7ctg_d_a\x7ctg_d_vdd\x7ctg_fbm_vdd\x7ctg_fbs_vdd\x7ctg_s_vdd\x7cvdd\x7cvdd_b1\x7cvdd_b2\x7cvdd_b3\x7cvdd_b4\x7cvdd_link\x7cvdd_link_dip\x7cvdd_x1\x7cvdd_x2\x7cvdd_x3__t95
+ a|d|inv_clk_vdd|inv_mc_vdd|inv_q_vdd|mpa_py|mpb_py|nand_m_vdd|nand_s2_vdd|nwell_vdd|sb_vdd|sr1_vdd|sr2_vdd|sr3_vdd|sr4_vdd|sv_d_vdd_tie|sv_vdd|tg_d_a|tg_d_vdd|tg_fbm_vdd|tg_fbs_vdd|tg_s_vdd|vdd|vdd_b1|vdd_b2|vdd_b3|vdd_b4|vdd_link|vdd_link_dip|vdd_x1|vdd_x2|vdd_x3
+ 198.175103284
* device instance a_d_inv_clk_vdd_inv_mc_vdd_inv_q_vdd_mpa_py_mpb_py_nand_m_vdd_nand_s2_vdd_nwell_vdd_sb_vdd_sr1_vdd_sr2_vdd_sr3_vdd_sr4_vdd_sv_d_vdd_tie_sv_vdd_tg_d_a_tg_d_vdd_tg_fbm_vdd_tg_fbs_vdd_tg_s_vdd_vdd_vdd_b1_vdd_b2_vdd_b3_vdd_b4_vdd_link_vdd_link_dip_vdd_x1_vdd_x2_vdd_x3_t96 r0 *1 0,0
Ra_d_inv_clk_vdd_inv_mc_vdd_inv_q_vdd_mpa_py_mpb_py_nand_m_vdd_nand_s2_vdd_nwell_vdd_sb_vdd_sr1_vdd_sr2_vdd_sr3_vdd_sr4_vdd_sv_d_vdd_tie_sv_vdd_tg_d_a_tg_d_vdd_tg_fbm_vdd_tg_fbs_vdd_tg_s_vdd_vdd_vdd_b1_vdd_b2_vdd_b3_vdd_b4_vdd_link_vdd_link_dip_vdd_x1_vdd_x2_vdd_x3_t96
+ a\x7cd\x7cinv_clk_vdd\x7cinv_mc_vdd\x7cinv_q_vdd\x7cmpa_py\x7cmpb_py\x7cnand_m_vdd\x7cnand_s2_vdd\x7cnwell_vdd\x7csb_vdd\x7csr1_vdd\x7csr2_vdd\x7csr3_vdd\x7csr4_vdd\x7csv_d_vdd_tie\x7csv_vdd\x7ctg_d_a\x7ctg_d_vdd\x7ctg_fbm_vdd\x7ctg_fbs_vdd\x7ctg_s_vdd\x7cvdd\x7cvdd_b1\x7cvdd_b2\x7cvdd_b3\x7cvdd_b4\x7cvdd_link\x7cvdd_link_dip\x7cvdd_x1\x7cvdd_x2\x7cvdd_x3__t96
+ a|d|inv_clk_vdd|inv_mc_vdd|inv_q_vdd|mpa_py|mpb_py|nand_m_vdd|nand_s2_vdd|nwell_vdd|sb_vdd|sr1_vdd|sr2_vdd|sr3_vdd|sr4_vdd|sv_d_vdd_tie|sv_vdd|tg_d_a|tg_d_vdd|tg_fbm_vdd|tg_fbs_vdd|tg_s_vdd|vdd|vdd_b1|vdd_b2|vdd_b3|vdd_b4|vdd_link|vdd_link_dip|vdd_x1|vdd_x2|vdd_x3
+ 107.859611691
* device instance a_d_inv_clk_vdd_inv_mc_vdd_inv_q_vdd_mpa_py_mpb_py_nand_m_vdd_nand_s2_vdd_nwell_vdd_sb_vdd_sr1_vdd_sr2_vdd_sr3_vdd_sr4_vdd_sv_d_vdd_tie_sv_vdd_tg_d_a_tg_d_vdd_tg_fbm_vdd_tg_fbs_vdd_tg_s_vdd_vdd_vdd_b1_vdd_b2_vdd_b3_vdd_b4_vdd_link_vdd_link_dip_vdd_x1_vdd_x2_vdd_x3_t97 r0 *1 0,0
Ra_d_inv_clk_vdd_inv_mc_vdd_inv_q_vdd_mpa_py_mpb_py_nand_m_vdd_nand_s2_vdd_nwell_vdd_sb_vdd_sr1_vdd_sr2_vdd_sr3_vdd_sr4_vdd_sv_d_vdd_tie_sv_vdd_tg_d_a_tg_d_vdd_tg_fbm_vdd_tg_fbs_vdd_tg_s_vdd_vdd_vdd_b1_vdd_b2_vdd_b3_vdd_b4_vdd_link_vdd_link_dip_vdd_x1_vdd_x2_vdd_x3_t97
+ a\x7cd\x7cinv_clk_vdd\x7cinv_mc_vdd\x7cinv_q_vdd\x7cmpa_py\x7cmpb_py\x7cnand_m_vdd\x7cnand_s2_vdd\x7cnwell_vdd\x7csb_vdd\x7csr1_vdd\x7csr2_vdd\x7csr3_vdd\x7csr4_vdd\x7csv_d_vdd_tie\x7csv_vdd\x7ctg_d_a\x7ctg_d_vdd\x7ctg_fbm_vdd\x7ctg_fbs_vdd\x7ctg_s_vdd\x7cvdd\x7cvdd_b1\x7cvdd_b2\x7cvdd_b3\x7cvdd_b4\x7cvdd_link\x7cvdd_link_dip\x7cvdd_x1\x7cvdd_x2\x7cvdd_x3__t97
+ a|d|inv_clk_vdd|inv_mc_vdd|inv_q_vdd|mpa_py|mpb_py|nand_m_vdd|nand_s2_vdd|nwell_vdd|sb_vdd|sr1_vdd|sr2_vdd|sr3_vdd|sr4_vdd|sv_d_vdd_tie|sv_vdd|tg_d_a|tg_d_vdd|tg_fbm_vdd|tg_fbs_vdd|tg_s_vdd|vdd|vdd_b1|vdd_b2|vdd_b3|vdd_b4|vdd_link|vdd_link_dip|vdd_x1|vdd_x2|vdd_x3
+ 42.2533332735
* device instance a_d_inv_clk_vdd_inv_mc_vdd_inv_q_vdd_mpa_py_mpb_py_nand_m_vdd_nand_s2_vdd_nwell_vdd_sb_vdd_sr1_vdd_sr2_vdd_sr3_vdd_sr4_vdd_sv_d_vdd_tie_sv_vdd_tg_d_a_tg_d_vdd_tg_fbm_vdd_tg_fbs_vdd_tg_s_vdd_vdd_vdd_b1_vdd_b2_vdd_b3_vdd_b4_vdd_link_vdd_link_dip_vdd_x1_vdd_x2_vdd_x3_t98 r0 *1 0,0
Ra_d_inv_clk_vdd_inv_mc_vdd_inv_q_vdd_mpa_py_mpb_py_nand_m_vdd_nand_s2_vdd_nwell_vdd_sb_vdd_sr1_vdd_sr2_vdd_sr3_vdd_sr4_vdd_sv_d_vdd_tie_sv_vdd_tg_d_a_tg_d_vdd_tg_fbm_vdd_tg_fbs_vdd_tg_s_vdd_vdd_vdd_b1_vdd_b2_vdd_b3_vdd_b4_vdd_link_vdd_link_dip_vdd_x1_vdd_x2_vdd_x3_t98
+ a\x7cd\x7cinv_clk_vdd\x7cinv_mc_vdd\x7cinv_q_vdd\x7cmpa_py\x7cmpb_py\x7cnand_m_vdd\x7cnand_s2_vdd\x7cnwell_vdd\x7csb_vdd\x7csr1_vdd\x7csr2_vdd\x7csr3_vdd\x7csr4_vdd\x7csv_d_vdd_tie\x7csv_vdd\x7ctg_d_a\x7ctg_d_vdd\x7ctg_fbm_vdd\x7ctg_fbs_vdd\x7ctg_s_vdd\x7cvdd\x7cvdd_b1\x7cvdd_b2\x7cvdd_b3\x7cvdd_b4\x7cvdd_link\x7cvdd_link_dip\x7cvdd_x1\x7cvdd_x2\x7cvdd_x3__t98
+ a|d|inv_clk_vdd|inv_mc_vdd|inv_q_vdd|mpa_py|mpb_py|nand_m_vdd|nand_s2_vdd|nwell_vdd|sb_vdd|sr1_vdd|sr2_vdd|sr3_vdd|sr4_vdd|sv_d_vdd_tie|sv_vdd|tg_d_a|tg_d_vdd|tg_fbm_vdd|tg_fbs_vdd|tg_s_vdd|vdd|vdd_b1|vdd_b2|vdd_b3|vdd_b4|vdd_link|vdd_link_dip|vdd_x1|vdd_x2|vdd_x3
+ 25.089796295
* device instance a_d_inv_clk_vdd_inv_mc_vdd_inv_q_vdd_mpa_py_mpb_py_nand_m_vdd_nand_s2_vdd_nwell_vdd_sb_vdd_sr1_vdd_sr2_vdd_sr3_vdd_sr4_vdd_sv_d_vdd_tie_sv_vdd_tg_d_a_tg_d_vdd_tg_fbm_vdd_tg_fbs_vdd_tg_s_vdd_vdd_vdd_b1_vdd_b2_vdd_b3_vdd_b4_vdd_link_vdd_link_dip_vdd_x1_vdd_x2_vdd_x3_t99 r0 *1 0,0
Ra_d_inv_clk_vdd_inv_mc_vdd_inv_q_vdd_mpa_py_mpb_py_nand_m_vdd_nand_s2_vdd_nwell_vdd_sb_vdd_sr1_vdd_sr2_vdd_sr3_vdd_sr4_vdd_sv_d_vdd_tie_sv_vdd_tg_d_a_tg_d_vdd_tg_fbm_vdd_tg_fbs_vdd_tg_s_vdd_vdd_vdd_b1_vdd_b2_vdd_b3_vdd_b4_vdd_link_vdd_link_dip_vdd_x1_vdd_x2_vdd_x3_t99
+ a\x7cd\x7cinv_clk_vdd\x7cinv_mc_vdd\x7cinv_q_vdd\x7cmpa_py\x7cmpb_py\x7cnand_m_vdd\x7cnand_s2_vdd\x7cnwell_vdd\x7csb_vdd\x7csr1_vdd\x7csr2_vdd\x7csr3_vdd\x7csr4_vdd\x7csv_d_vdd_tie\x7csv_vdd\x7ctg_d_a\x7ctg_d_vdd\x7ctg_fbm_vdd\x7ctg_fbs_vdd\x7ctg_s_vdd\x7cvdd\x7cvdd_b1\x7cvdd_b2\x7cvdd_b3\x7cvdd_b4\x7cvdd_link\x7cvdd_link_dip\x7cvdd_x1\x7cvdd_x2\x7cvdd_x3__t99
+ a|d|inv_clk_vdd|inv_mc_vdd|inv_q_vdd|mpa_py|mpb_py|nand_m_vdd|nand_s2_vdd|nwell_vdd|sb_vdd|sr1_vdd|sr2_vdd|sr3_vdd|sr4_vdd|sv_d_vdd_tie|sv_vdd|tg_d_a|tg_d_vdd|tg_fbm_vdd|tg_fbs_vdd|tg_s_vdd|vdd|vdd_b1|vdd_b2|vdd_b3|vdd_b4|vdd_link|vdd_link_dip|vdd_x1|vdd_x2|vdd_x3
+ 109.084868354
* device instance a_d_inv_clk_vdd_inv_mc_vdd_inv_q_vdd_mpa_py_mpb_py_nand_m_vdd_nand_s2_vdd_nwell_vdd_sb_vdd_sr1_vdd_sr2_vdd_sr3_vdd_sr4_vdd_sv_d_vdd_tie_sv_vdd_tg_d_a_tg_d_vdd_tg_fbm_vdd_tg_fbs_vdd_tg_s_vdd_vdd_vdd_b1_vdd_b2_vdd_b3_vdd_b4_vdd_link_vdd_link_dip_vdd_x1_vdd_x2_vdd_x3_t100 r0 *1 0,0
Ra_d_inv_clk_vdd_inv_mc_vdd_inv_q_vdd_mpa_py_mpb_py_nand_m_vdd_nand_s2_vdd_nwell_vdd_sb_vdd_sr1_vdd_sr2_vdd_sr3_vdd_sr4_vdd_sv_d_vdd_tie_sv_vdd_tg_d_a_tg_d_vdd_tg_fbm_vdd_tg_fbs_vdd_tg_s_vdd_vdd_vdd_b1_vdd_b2_vdd_b3_vdd_b4_vdd_link_vdd_link_dip_vdd_x1_vdd_x2_vdd_x3_t100
+ a\x7cd\x7cinv_clk_vdd\x7cinv_mc_vdd\x7cinv_q_vdd\x7cmpa_py\x7cmpb_py\x7cnand_m_vdd\x7cnand_s2_vdd\x7cnwell_vdd\x7csb_vdd\x7csr1_vdd\x7csr2_vdd\x7csr3_vdd\x7csr4_vdd\x7csv_d_vdd_tie\x7csv_vdd\x7ctg_d_a\x7ctg_d_vdd\x7ctg_fbm_vdd\x7ctg_fbs_vdd\x7ctg_s_vdd\x7cvdd\x7cvdd_b1\x7cvdd_b2\x7cvdd_b3\x7cvdd_b4\x7cvdd_link\x7cvdd_link_dip\x7cvdd_x1\x7cvdd_x2\x7cvdd_x3__t100
+ a|d|inv_clk_vdd|inv_mc_vdd|inv_q_vdd|mpa_py|mpb_py|nand_m_vdd|nand_s2_vdd|nwell_vdd|sb_vdd|sr1_vdd|sr2_vdd|sr3_vdd|sr4_vdd|sv_d_vdd_tie|sv_vdd|tg_d_a|tg_d_vdd|tg_fbm_vdd|tg_fbs_vdd|tg_s_vdd|vdd|vdd_b1|vdd_b2|vdd_b3|vdd_b4|vdd_link|vdd_link_dip|vdd_x1|vdd_x2|vdd_x3
+ 18.2657946451
* device instance a_d_inv_clk_vdd_inv_mc_vdd_inv_q_vdd_mpa_py_mpb_py_nand_m_vdd_nand_s2_vdd_nwell_vdd_sb_vdd_sr1_vdd_sr2_vdd_sr3_vdd_sr4_vdd_sv_d_vdd_tie_sv_vdd_tg_d_a_tg_d_vdd_tg_fbm_vdd_tg_fbs_vdd_tg_s_vdd_vdd_vdd_b1_vdd_b2_vdd_b3_vdd_b4_vdd_link_vdd_link_dip_vdd_x1_vdd_x2_vdd_x3_t101 r0 *1 0,0
Ra_d_inv_clk_vdd_inv_mc_vdd_inv_q_vdd_mpa_py_mpb_py_nand_m_vdd_nand_s2_vdd_nwell_vdd_sb_vdd_sr1_vdd_sr2_vdd_sr3_vdd_sr4_vdd_sv_d_vdd_tie_sv_vdd_tg_d_a_tg_d_vdd_tg_fbm_vdd_tg_fbs_vdd_tg_s_vdd_vdd_vdd_b1_vdd_b2_vdd_b3_vdd_b4_vdd_link_vdd_link_dip_vdd_x1_vdd_x2_vdd_x3_t101
+ a\x7cd\x7cinv_clk_vdd\x7cinv_mc_vdd\x7cinv_q_vdd\x7cmpa_py\x7cmpb_py\x7cnand_m_vdd\x7cnand_s2_vdd\x7cnwell_vdd\x7csb_vdd\x7csr1_vdd\x7csr2_vdd\x7csr3_vdd\x7csr4_vdd\x7csv_d_vdd_tie\x7csv_vdd\x7ctg_d_a\x7ctg_d_vdd\x7ctg_fbm_vdd\x7ctg_fbs_vdd\x7ctg_s_vdd\x7cvdd\x7cvdd_b1\x7cvdd_b2\x7cvdd_b3\x7cvdd_b4\x7cvdd_link\x7cvdd_link_dip\x7cvdd_x1\x7cvdd_x2\x7cvdd_x3__t101
+ a|d|inv_clk_vdd|inv_mc_vdd|inv_q_vdd|mpa_py|mpb_py|nand_m_vdd|nand_s2_vdd|nwell_vdd|sb_vdd|sr1_vdd|sr2_vdd|sr3_vdd|sr4_vdd|sv_d_vdd_tie|sv_vdd|tg_d_a|tg_d_vdd|tg_fbm_vdd|tg_fbs_vdd|tg_s_vdd|vdd|vdd_b1|vdd_b2|vdd_b3|vdd_b4|vdd_link|vdd_link_dip|vdd_x1|vdd_x2|vdd_x3
+ 98.3634700637
* device instance a_d_inv_clk_vdd_inv_mc_vdd_inv_q_vdd_mpa_py_mpb_py_nand_m_vdd_nand_s2_vdd_nwell_vdd_sb_vdd_sr1_vdd_sr2_vdd_sr3_vdd_sr4_vdd_sv_d_vdd_tie_sv_vdd_tg_d_a_tg_d_vdd_tg_fbm_vdd_tg_fbs_vdd_tg_s_vdd_vdd_vdd_b1_vdd_b2_vdd_b3_vdd_b4_vdd_link_vdd_link_dip_vdd_x1_vdd_x2_vdd_x3_t102 r0 *1 0,0
Ra_d_inv_clk_vdd_inv_mc_vdd_inv_q_vdd_mpa_py_mpb_py_nand_m_vdd_nand_s2_vdd_nwell_vdd_sb_vdd_sr1_vdd_sr2_vdd_sr3_vdd_sr4_vdd_sv_d_vdd_tie_sv_vdd_tg_d_a_tg_d_vdd_tg_fbm_vdd_tg_fbs_vdd_tg_s_vdd_vdd_vdd_b1_vdd_b2_vdd_b3_vdd_b4_vdd_link_vdd_link_dip_vdd_x1_vdd_x2_vdd_x3_t102
+ a\x7cd\x7cinv_clk_vdd\x7cinv_mc_vdd\x7cinv_q_vdd\x7cmpa_py\x7cmpb_py\x7cnand_m_vdd\x7cnand_s2_vdd\x7cnwell_vdd\x7csb_vdd\x7csr1_vdd\x7csr2_vdd\x7csr3_vdd\x7csr4_vdd\x7csv_d_vdd_tie\x7csv_vdd\x7ctg_d_a\x7ctg_d_vdd\x7ctg_fbm_vdd\x7ctg_fbs_vdd\x7ctg_s_vdd\x7cvdd\x7cvdd_b1\x7cvdd_b2\x7cvdd_b3\x7cvdd_b4\x7cvdd_link\x7cvdd_link_dip\x7cvdd_x1\x7cvdd_x2\x7cvdd_x3__t102
+ a|d|inv_clk_vdd|inv_mc_vdd|inv_q_vdd|mpa_py|mpb_py|nand_m_vdd|nand_s2_vdd|nwell_vdd|sb_vdd|sr1_vdd|sr2_vdd|sr3_vdd|sr4_vdd|sv_d_vdd_tie|sv_vdd|tg_d_a|tg_d_vdd|tg_fbm_vdd|tg_fbs_vdd|tg_s_vdd|vdd|vdd_b1|vdd_b2|vdd_b3|vdd_b4|vdd_link|vdd_link_dip|vdd_x1|vdd_x2|vdd_x3
+ 149.152813625
* device instance a_d_inv_clk_vdd_inv_mc_vdd_inv_q_vdd_mpa_py_mpb_py_nand_m_vdd_nand_s2_vdd_nwell_vdd_sb_vdd_sr1_vdd_sr2_vdd_sr3_vdd_sr4_vdd_sv_d_vdd_tie_sv_vdd_tg_d_a_tg_d_vdd_tg_fbm_vdd_tg_fbs_vdd_tg_s_vdd_vdd_vdd_b1_vdd_b2_vdd_b3_vdd_b4_vdd_link_vdd_link_dip_vdd_x1_vdd_x2_vdd_x3_t103 r0 *1 0,0
Ra_d_inv_clk_vdd_inv_mc_vdd_inv_q_vdd_mpa_py_mpb_py_nand_m_vdd_nand_s2_vdd_nwell_vdd_sb_vdd_sr1_vdd_sr2_vdd_sr3_vdd_sr4_vdd_sv_d_vdd_tie_sv_vdd_tg_d_a_tg_d_vdd_tg_fbm_vdd_tg_fbs_vdd_tg_s_vdd_vdd_vdd_b1_vdd_b2_vdd_b3_vdd_b4_vdd_link_vdd_link_dip_vdd_x1_vdd_x2_vdd_x3_t103
+ a\x7cd\x7cinv_clk_vdd\x7cinv_mc_vdd\x7cinv_q_vdd\x7cmpa_py\x7cmpb_py\x7cnand_m_vdd\x7cnand_s2_vdd\x7cnwell_vdd\x7csb_vdd\x7csr1_vdd\x7csr2_vdd\x7csr3_vdd\x7csr4_vdd\x7csv_d_vdd_tie\x7csv_vdd\x7ctg_d_a\x7ctg_d_vdd\x7ctg_fbm_vdd\x7ctg_fbs_vdd\x7ctg_s_vdd\x7cvdd\x7cvdd_b1\x7cvdd_b2\x7cvdd_b3\x7cvdd_b4\x7cvdd_link\x7cvdd_link_dip\x7cvdd_x1\x7cvdd_x2\x7cvdd_x3__t103
+ a|d|inv_clk_vdd|inv_mc_vdd|inv_q_vdd|mpa_py|mpb_py|nand_m_vdd|nand_s2_vdd|nwell_vdd|sb_vdd|sr1_vdd|sr2_vdd|sr3_vdd|sr4_vdd|sv_d_vdd_tie|sv_vdd|tg_d_a|tg_d_vdd|tg_fbm_vdd|tg_fbs_vdd|tg_s_vdd|vdd|vdd_b1|vdd_b2|vdd_b3|vdd_b4|vdd_link|vdd_link_dip|vdd_x1|vdd_x2|vdd_x3
+ 147.106703063
* device instance a_d_inv_clk_vdd_inv_mc_vdd_inv_q_vdd_mpa_py_mpb_py_nand_m_vdd_nand_s2_vdd_nwell_vdd_sb_vdd_sr1_vdd_sr2_vdd_sr3_vdd_sr4_vdd_sv_d_vdd_tie_sv_vdd_tg_d_a_tg_d_vdd_tg_fbm_vdd_tg_fbs_vdd_tg_s_vdd_vdd_vdd_b1_vdd_b2_vdd_b3_vdd_b4_vdd_link_vdd_link_dip_vdd_x1_vdd_x2_vdd_x3_t104 r0 *1 0,0
Ra_d_inv_clk_vdd_inv_mc_vdd_inv_q_vdd_mpa_py_mpb_py_nand_m_vdd_nand_s2_vdd_nwell_vdd_sb_vdd_sr1_vdd_sr2_vdd_sr3_vdd_sr4_vdd_sv_d_vdd_tie_sv_vdd_tg_d_a_tg_d_vdd_tg_fbm_vdd_tg_fbs_vdd_tg_s_vdd_vdd_vdd_b1_vdd_b2_vdd_b3_vdd_b4_vdd_link_vdd_link_dip_vdd_x1_vdd_x2_vdd_x3_t104
+ a\x7cd\x7cinv_clk_vdd\x7cinv_mc_vdd\x7cinv_q_vdd\x7cmpa_py\x7cmpb_py\x7cnand_m_vdd\x7cnand_s2_vdd\x7cnwell_vdd\x7csb_vdd\x7csr1_vdd\x7csr2_vdd\x7csr3_vdd\x7csr4_vdd\x7csv_d_vdd_tie\x7csv_vdd\x7ctg_d_a\x7ctg_d_vdd\x7ctg_fbm_vdd\x7ctg_fbs_vdd\x7ctg_s_vdd\x7cvdd\x7cvdd_b1\x7cvdd_b2\x7cvdd_b3\x7cvdd_b4\x7cvdd_link\x7cvdd_link_dip\x7cvdd_x1\x7cvdd_x2\x7cvdd_x3__t104
+ a|d|inv_clk_vdd|inv_mc_vdd|inv_q_vdd|mpa_py|mpb_py|nand_m_vdd|nand_s2_vdd|nwell_vdd|sb_vdd|sr1_vdd|sr2_vdd|sr3_vdd|sr4_vdd|sv_d_vdd_tie|sv_vdd|tg_d_a|tg_d_vdd|tg_fbm_vdd|tg_fbs_vdd|tg_s_vdd|vdd|vdd_b1|vdd_b2|vdd_b3|vdd_b4|vdd_link|vdd_link_dip|vdd_x1|vdd_x2|vdd_x3
+ 90.2868053873
* device instance a_d_inv_clk_vdd_inv_mc_vdd_inv_q_vdd_mpa_py_mpb_py_nand_m_vdd_nand_s2_vdd_nwell_vdd_sb_vdd_sr1_vdd_sr2_vdd_sr3_vdd_sr4_vdd_sv_d_vdd_tie_sv_vdd_tg_d_a_tg_d_vdd_tg_fbm_vdd_tg_fbs_vdd_tg_s_vdd_vdd_vdd_b1_vdd_b2_vdd_b3_vdd_b4_vdd_link_vdd_link_dip_vdd_x1_vdd_x2_vdd_x3_t105 r0 *1 0,0
Ra_d_inv_clk_vdd_inv_mc_vdd_inv_q_vdd_mpa_py_mpb_py_nand_m_vdd_nand_s2_vdd_nwell_vdd_sb_vdd_sr1_vdd_sr2_vdd_sr3_vdd_sr4_vdd_sv_d_vdd_tie_sv_vdd_tg_d_a_tg_d_vdd_tg_fbm_vdd_tg_fbs_vdd_tg_s_vdd_vdd_vdd_b1_vdd_b2_vdd_b3_vdd_b4_vdd_link_vdd_link_dip_vdd_x1_vdd_x2_vdd_x3_t105
+ a\x7cd\x7cinv_clk_vdd\x7cinv_mc_vdd\x7cinv_q_vdd\x7cmpa_py\x7cmpb_py\x7cnand_m_vdd\x7cnand_s2_vdd\x7cnwell_vdd\x7csb_vdd\x7csr1_vdd\x7csr2_vdd\x7csr3_vdd\x7csr4_vdd\x7csv_d_vdd_tie\x7csv_vdd\x7ctg_d_a\x7ctg_d_vdd\x7ctg_fbm_vdd\x7ctg_fbs_vdd\x7ctg_s_vdd\x7cvdd\x7cvdd_b1\x7cvdd_b2\x7cvdd_b3\x7cvdd_b4\x7cvdd_link\x7cvdd_link_dip\x7cvdd_x1\x7cvdd_x2\x7cvdd_x3__t105
+ a|d|inv_clk_vdd|inv_mc_vdd|inv_q_vdd|mpa_py|mpb_py|nand_m_vdd|nand_s2_vdd|nwell_vdd|sb_vdd|sr1_vdd|sr2_vdd|sr3_vdd|sr4_vdd|sv_d_vdd_tie|sv_vdd|tg_d_a|tg_d_vdd|tg_fbm_vdd|tg_fbs_vdd|tg_s_vdd|vdd|vdd_b1|vdd_b2|vdd_b3|vdd_b4|vdd_link|vdd_link_dip|vdd_x1|vdd_x2|vdd_x3
+ 82.8211566405
* device instance a_d_inv_clk_vdd_inv_mc_vdd_inv_q_vdd_mpa_py_mpb_py_nand_m_vdd_nand_s2_vdd_nwell_vdd_sb_vdd_sr1_vdd_sr2_vdd_sr3_vdd_sr4_vdd_sv_d_vdd_tie_sv_vdd_tg_d_a_tg_d_vdd_tg_fbm_vdd_tg_fbs_vdd_tg_s_vdd_vdd_vdd_b1_vdd_b2_vdd_b3_vdd_b4_vdd_link_vdd_link_dip_vdd_x1_vdd_x2_vdd_x3_t106 r0 *1 0,0
Ra_d_inv_clk_vdd_inv_mc_vdd_inv_q_vdd_mpa_py_mpb_py_nand_m_vdd_nand_s2_vdd_nwell_vdd_sb_vdd_sr1_vdd_sr2_vdd_sr3_vdd_sr4_vdd_sv_d_vdd_tie_sv_vdd_tg_d_a_tg_d_vdd_tg_fbm_vdd_tg_fbs_vdd_tg_s_vdd_vdd_vdd_b1_vdd_b2_vdd_b3_vdd_b4_vdd_link_vdd_link_dip_vdd_x1_vdd_x2_vdd_x3_t106
+ a\x7cd\x7cinv_clk_vdd\x7cinv_mc_vdd\x7cinv_q_vdd\x7cmpa_py\x7cmpb_py\x7cnand_m_vdd\x7cnand_s2_vdd\x7cnwell_vdd\x7csb_vdd\x7csr1_vdd\x7csr2_vdd\x7csr3_vdd\x7csr4_vdd\x7csv_d_vdd_tie\x7csv_vdd\x7ctg_d_a\x7ctg_d_vdd\x7ctg_fbm_vdd\x7ctg_fbs_vdd\x7ctg_s_vdd\x7cvdd\x7cvdd_b1\x7cvdd_b2\x7cvdd_b3\x7cvdd_b4\x7cvdd_link\x7cvdd_link_dip\x7cvdd_x1\x7cvdd_x2\x7cvdd_x3__t106
+ a|d|inv_clk_vdd|inv_mc_vdd|inv_q_vdd|mpa_py|mpb_py|nand_m_vdd|nand_s2_vdd|nwell_vdd|sb_vdd|sr1_vdd|sr2_vdd|sr3_vdd|sr4_vdd|sv_d_vdd_tie|sv_vdd|tg_d_a|tg_d_vdd|tg_fbm_vdd|tg_fbs_vdd|tg_s_vdd|vdd|vdd_b1|vdd_b2|vdd_b3|vdd_b4|vdd_link|vdd_link_dip|vdd_x1|vdd_x2|vdd_x3
+ 60.2750556023
* device instance a_d_inv_clk_vdd_inv_mc_vdd_inv_q_vdd_mpa_py_mpb_py_nand_m_vdd_nand_s2_vdd_nwell_vdd_sb_vdd_sr1_vdd_sr2_vdd_sr3_vdd_sr4_vdd_sv_d_vdd_tie_sv_vdd_tg_d_a_tg_d_vdd_tg_fbm_vdd_tg_fbs_vdd_tg_s_vdd_vdd_vdd_b1_vdd_b2_vdd_b3_vdd_b4_vdd_link_vdd_link_dip_vdd_x1_vdd_x2_vdd_x3_t107 r0 *1 0,0
Ra_d_inv_clk_vdd_inv_mc_vdd_inv_q_vdd_mpa_py_mpb_py_nand_m_vdd_nand_s2_vdd_nwell_vdd_sb_vdd_sr1_vdd_sr2_vdd_sr3_vdd_sr4_vdd_sv_d_vdd_tie_sv_vdd_tg_d_a_tg_d_vdd_tg_fbm_vdd_tg_fbs_vdd_tg_s_vdd_vdd_vdd_b1_vdd_b2_vdd_b3_vdd_b4_vdd_link_vdd_link_dip_vdd_x1_vdd_x2_vdd_x3_t107
+ a\x7cd\x7cinv_clk_vdd\x7cinv_mc_vdd\x7cinv_q_vdd\x7cmpa_py\x7cmpb_py\x7cnand_m_vdd\x7cnand_s2_vdd\x7cnwell_vdd\x7csb_vdd\x7csr1_vdd\x7csr2_vdd\x7csr3_vdd\x7csr4_vdd\x7csv_d_vdd_tie\x7csv_vdd\x7ctg_d_a\x7ctg_d_vdd\x7ctg_fbm_vdd\x7ctg_fbs_vdd\x7ctg_s_vdd\x7cvdd\x7cvdd_b1\x7cvdd_b2\x7cvdd_b3\x7cvdd_b4\x7cvdd_link\x7cvdd_link_dip\x7cvdd_x1\x7cvdd_x2\x7cvdd_x3__t107
+ a|d|inv_clk_vdd|inv_mc_vdd|inv_q_vdd|mpa_py|mpb_py|nand_m_vdd|nand_s2_vdd|nwell_vdd|sb_vdd|sr1_vdd|sr2_vdd|sr3_vdd|sr4_vdd|sv_d_vdd_tie|sv_vdd|tg_d_a|tg_d_vdd|tg_fbm_vdd|tg_fbs_vdd|tg_s_vdd|vdd|vdd_b1|vdd_b2|vdd_b3|vdd_b4|vdd_link|vdd_link_dip|vdd_x1|vdd_x2|vdd_x3
+ 109.895432628
* device instance a_d_inv_clk_vdd_inv_mc_vdd_inv_q_vdd_mpa_py_mpb_py_nand_m_vdd_nand_s2_vdd_nwell_vdd_sb_vdd_sr1_vdd_sr2_vdd_sr3_vdd_sr4_vdd_sv_d_vdd_tie_sv_vdd_tg_d_a_tg_d_vdd_tg_fbm_vdd_tg_fbs_vdd_tg_s_vdd_vdd_vdd_b1_vdd_b2_vdd_b3_vdd_b4_vdd_link_vdd_link_dip_vdd_x1_vdd_x2_vdd_x3_t108 r0 *1 0,0
Ra_d_inv_clk_vdd_inv_mc_vdd_inv_q_vdd_mpa_py_mpb_py_nand_m_vdd_nand_s2_vdd_nwell_vdd_sb_vdd_sr1_vdd_sr2_vdd_sr3_vdd_sr4_vdd_sv_d_vdd_tie_sv_vdd_tg_d_a_tg_d_vdd_tg_fbm_vdd_tg_fbs_vdd_tg_s_vdd_vdd_vdd_b1_vdd_b2_vdd_b3_vdd_b4_vdd_link_vdd_link_dip_vdd_x1_vdd_x2_vdd_x3_t108
+ a\x7cd\x7cinv_clk_vdd\x7cinv_mc_vdd\x7cinv_q_vdd\x7cmpa_py\x7cmpb_py\x7cnand_m_vdd\x7cnand_s2_vdd\x7cnwell_vdd\x7csb_vdd\x7csr1_vdd\x7csr2_vdd\x7csr3_vdd\x7csr4_vdd\x7csv_d_vdd_tie\x7csv_vdd\x7ctg_d_a\x7ctg_d_vdd\x7ctg_fbm_vdd\x7ctg_fbs_vdd\x7ctg_s_vdd\x7cvdd\x7cvdd_b1\x7cvdd_b2\x7cvdd_b3\x7cvdd_b4\x7cvdd_link\x7cvdd_link_dip\x7cvdd_x1\x7cvdd_x2\x7cvdd_x3__t108
+ a|d|inv_clk_vdd|inv_mc_vdd|inv_q_vdd|mpa_py|mpb_py|nand_m_vdd|nand_s2_vdd|nwell_vdd|sb_vdd|sr1_vdd|sr2_vdd|sr3_vdd|sr4_vdd|sv_d_vdd_tie|sv_vdd|tg_d_a|tg_d_vdd|tg_fbm_vdd|tg_fbs_vdd|tg_s_vdd|vdd|vdd_b1|vdd_b2|vdd_b3|vdd_b4|vdd_link|vdd_link_dip|vdd_x1|vdd_x2|vdd_x3
+ 196.123747797
* device instance a_d_inv_clk_vdd_inv_mc_vdd_inv_q_vdd_mpa_py_mpb_py_nand_m_vdd_nand_s2_vdd_nwell_vdd_sb_vdd_sr1_vdd_sr2_vdd_sr3_vdd_sr4_vdd_sv_d_vdd_tie_sv_vdd_tg_d_a_tg_d_vdd_tg_fbm_vdd_tg_fbs_vdd_tg_s_vdd_vdd_vdd_b1_vdd_b2_vdd_b3_vdd_b4_vdd_link_vdd_link_dip_vdd_x1_vdd_x2_vdd_x3_t109 r0 *1 0,0
Ra_d_inv_clk_vdd_inv_mc_vdd_inv_q_vdd_mpa_py_mpb_py_nand_m_vdd_nand_s2_vdd_nwell_vdd_sb_vdd_sr1_vdd_sr2_vdd_sr3_vdd_sr4_vdd_sv_d_vdd_tie_sv_vdd_tg_d_a_tg_d_vdd_tg_fbm_vdd_tg_fbs_vdd_tg_s_vdd_vdd_vdd_b1_vdd_b2_vdd_b3_vdd_b4_vdd_link_vdd_link_dip_vdd_x1_vdd_x2_vdd_x3_t109
+ a\x7cd\x7cinv_clk_vdd\x7cinv_mc_vdd\x7cinv_q_vdd\x7cmpa_py\x7cmpb_py\x7cnand_m_vdd\x7cnand_s2_vdd\x7cnwell_vdd\x7csb_vdd\x7csr1_vdd\x7csr2_vdd\x7csr3_vdd\x7csr4_vdd\x7csv_d_vdd_tie\x7csv_vdd\x7ctg_d_a\x7ctg_d_vdd\x7ctg_fbm_vdd\x7ctg_fbs_vdd\x7ctg_s_vdd\x7cvdd\x7cvdd_b1\x7cvdd_b2\x7cvdd_b3\x7cvdd_b4\x7cvdd_link\x7cvdd_link_dip\x7cvdd_x1\x7cvdd_x2\x7cvdd_x3__t109
+ a|d|inv_clk_vdd|inv_mc_vdd|inv_q_vdd|mpa_py|mpb_py|nand_m_vdd|nand_s2_vdd|nwell_vdd|sb_vdd|sr1_vdd|sr2_vdd|sr3_vdd|sr4_vdd|sv_d_vdd_tie|sv_vdd|tg_d_a|tg_d_vdd|tg_fbm_vdd|tg_fbs_vdd|tg_s_vdd|vdd|vdd_b1|vdd_b2|vdd_b3|vdd_b4|vdd_link|vdd_link_dip|vdd_x1|vdd_x2|vdd_x3
+ 55.0030748458
* device instance a_d_inv_clk_vdd_inv_mc_vdd_inv_q_vdd_mpa_py_mpb_py_nand_m_vdd_nand_s2_vdd_nwell_vdd_sb_vdd_sr1_vdd_sr2_vdd_sr3_vdd_sr4_vdd_sv_d_vdd_tie_sv_vdd_tg_d_a_tg_d_vdd_tg_fbm_vdd_tg_fbs_vdd_tg_s_vdd_vdd_vdd_b1_vdd_b2_vdd_b3_vdd_b4_vdd_link_vdd_link_dip_vdd_x1_vdd_x2_vdd_x3_t110 r0 *1 0,0
Ra_d_inv_clk_vdd_inv_mc_vdd_inv_q_vdd_mpa_py_mpb_py_nand_m_vdd_nand_s2_vdd_nwell_vdd_sb_vdd_sr1_vdd_sr2_vdd_sr3_vdd_sr4_vdd_sv_d_vdd_tie_sv_vdd_tg_d_a_tg_d_vdd_tg_fbm_vdd_tg_fbs_vdd_tg_s_vdd_vdd_vdd_b1_vdd_b2_vdd_b3_vdd_b4_vdd_link_vdd_link_dip_vdd_x1_vdd_x2_vdd_x3_t110
+ a\x7cd\x7cinv_clk_vdd\x7cinv_mc_vdd\x7cinv_q_vdd\x7cmpa_py\x7cmpb_py\x7cnand_m_vdd\x7cnand_s2_vdd\x7cnwell_vdd\x7csb_vdd\x7csr1_vdd\x7csr2_vdd\x7csr3_vdd\x7csr4_vdd\x7csv_d_vdd_tie\x7csv_vdd\x7ctg_d_a\x7ctg_d_vdd\x7ctg_fbm_vdd\x7ctg_fbs_vdd\x7ctg_s_vdd\x7cvdd\x7cvdd_b1\x7cvdd_b2\x7cvdd_b3\x7cvdd_b4\x7cvdd_link\x7cvdd_link_dip\x7cvdd_x1\x7cvdd_x2\x7cvdd_x3__t110
+ a|d|inv_clk_vdd|inv_mc_vdd|inv_q_vdd|mpa_py|mpb_py|nand_m_vdd|nand_s2_vdd|nwell_vdd|sb_vdd|sr1_vdd|sr2_vdd|sr3_vdd|sr4_vdd|sv_d_vdd_tie|sv_vdd|tg_d_a|tg_d_vdd|tg_fbm_vdd|tg_fbs_vdd|tg_s_vdd|vdd|vdd_b1|vdd_b2|vdd_b3|vdd_b4|vdd_link|vdd_link_dip|vdd_x1|vdd_x2|vdd_x3
+ 102.703905242
* device instance a_d_inv_clk_vdd_inv_mc_vdd_inv_q_vdd_mpa_py_mpb_py_nand_m_vdd_nand_s2_vdd_nwell_vdd_sb_vdd_sr1_vdd_sr2_vdd_sr3_vdd_sr4_vdd_sv_d_vdd_tie_sv_vdd_tg_d_a_tg_d_vdd_tg_fbm_vdd_tg_fbs_vdd_tg_s_vdd_vdd_vdd_b1_vdd_b2_vdd_b3_vdd_b4_vdd_link_vdd_link_dip_vdd_x1_vdd_x2_vdd_x3_t111 r0 *1 0,0
Ra_d_inv_clk_vdd_inv_mc_vdd_inv_q_vdd_mpa_py_mpb_py_nand_m_vdd_nand_s2_vdd_nwell_vdd_sb_vdd_sr1_vdd_sr2_vdd_sr3_vdd_sr4_vdd_sv_d_vdd_tie_sv_vdd_tg_d_a_tg_d_vdd_tg_fbm_vdd_tg_fbs_vdd_tg_s_vdd_vdd_vdd_b1_vdd_b2_vdd_b3_vdd_b4_vdd_link_vdd_link_dip_vdd_x1_vdd_x2_vdd_x3_t111
+ a\x7cd\x7cinv_clk_vdd\x7cinv_mc_vdd\x7cinv_q_vdd\x7cmpa_py\x7cmpb_py\x7cnand_m_vdd\x7cnand_s2_vdd\x7cnwell_vdd\x7csb_vdd\x7csr1_vdd\x7csr2_vdd\x7csr3_vdd\x7csr4_vdd\x7csv_d_vdd_tie\x7csv_vdd\x7ctg_d_a\x7ctg_d_vdd\x7ctg_fbm_vdd\x7ctg_fbs_vdd\x7ctg_s_vdd\x7cvdd\x7cvdd_b1\x7cvdd_b2\x7cvdd_b3\x7cvdd_b4\x7cvdd_link\x7cvdd_link_dip\x7cvdd_x1\x7cvdd_x2\x7cvdd_x3__t111
+ a|d|inv_clk_vdd|inv_mc_vdd|inv_q_vdd|mpa_py|mpb_py|nand_m_vdd|nand_s2_vdd|nwell_vdd|sb_vdd|sr1_vdd|sr2_vdd|sr3_vdd|sr4_vdd|sv_d_vdd_tie|sv_vdd|tg_d_a|tg_d_vdd|tg_fbm_vdd|tg_fbs_vdd|tg_s_vdd|vdd|vdd_b1|vdd_b2|vdd_b3|vdd_b4|vdd_link|vdd_link_dip|vdd_x1|vdd_x2|vdd_x3
+ 140.54070116
* device instance a_d_inv_clk_vdd_inv_mc_vdd_inv_q_vdd_mpa_py_mpb_py_nand_m_vdd_nand_s2_vdd_nwell_vdd_sb_vdd_sr1_vdd_sr2_vdd_sr3_vdd_sr4_vdd_sv_d_vdd_tie_sv_vdd_tg_d_a_tg_d_vdd_tg_fbm_vdd_tg_fbs_vdd_tg_s_vdd_vdd_vdd_b1_vdd_b2_vdd_b3_vdd_b4_vdd_link_vdd_link_dip_vdd_x1_vdd_x2_vdd_x3_t112 r0 *1 0,0
Ra_d_inv_clk_vdd_inv_mc_vdd_inv_q_vdd_mpa_py_mpb_py_nand_m_vdd_nand_s2_vdd_nwell_vdd_sb_vdd_sr1_vdd_sr2_vdd_sr3_vdd_sr4_vdd_sv_d_vdd_tie_sv_vdd_tg_d_a_tg_d_vdd_tg_fbm_vdd_tg_fbs_vdd_tg_s_vdd_vdd_vdd_b1_vdd_b2_vdd_b3_vdd_b4_vdd_link_vdd_link_dip_vdd_x1_vdd_x2_vdd_x3_t112
+ a\x7cd\x7cinv_clk_vdd\x7cinv_mc_vdd\x7cinv_q_vdd\x7cmpa_py\x7cmpb_py\x7cnand_m_vdd\x7cnand_s2_vdd\x7cnwell_vdd\x7csb_vdd\x7csr1_vdd\x7csr2_vdd\x7csr3_vdd\x7csr4_vdd\x7csv_d_vdd_tie\x7csv_vdd\x7ctg_d_a\x7ctg_d_vdd\x7ctg_fbm_vdd\x7ctg_fbs_vdd\x7ctg_s_vdd\x7cvdd\x7cvdd_b1\x7cvdd_b2\x7cvdd_b3\x7cvdd_b4\x7cvdd_link\x7cvdd_link_dip\x7cvdd_x1\x7cvdd_x2\x7cvdd_x3__t112
+ a|d|inv_clk_vdd|inv_mc_vdd|inv_q_vdd|mpa_py|mpb_py|nand_m_vdd|nand_s2_vdd|nwell_vdd|sb_vdd|sr1_vdd|sr2_vdd|sr3_vdd|sr4_vdd|sv_d_vdd_tie|sv_vdd|tg_d_a|tg_d_vdd|tg_fbm_vdd|tg_fbs_vdd|tg_s_vdd|vdd|vdd_b1|vdd_b2|vdd_b3|vdd_b4|vdd_link|vdd_link_dip|vdd_x1|vdd_x2|vdd_x3
+ 70.7109821764
* device instance a_d_inv_clk_vdd_inv_mc_vdd_inv_q_vdd_mpa_py_mpb_py_nand_m_vdd_nand_s2_vdd_nwell_vdd_sb_vdd_sr1_vdd_sr2_vdd_sr3_vdd_sr4_vdd_sv_d_vdd_tie_sv_vdd_tg_d_a_tg_d_vdd_tg_fbm_vdd_tg_fbs_vdd_tg_s_vdd_vdd_vdd_b1_vdd_b2_vdd_b3_vdd_b4_vdd_link_vdd_link_dip_vdd_x1_vdd_x2_vdd_x3_t113 r0 *1 0,0
Ra_d_inv_clk_vdd_inv_mc_vdd_inv_q_vdd_mpa_py_mpb_py_nand_m_vdd_nand_s2_vdd_nwell_vdd_sb_vdd_sr1_vdd_sr2_vdd_sr3_vdd_sr4_vdd_sv_d_vdd_tie_sv_vdd_tg_d_a_tg_d_vdd_tg_fbm_vdd_tg_fbs_vdd_tg_s_vdd_vdd_vdd_b1_vdd_b2_vdd_b3_vdd_b4_vdd_link_vdd_link_dip_vdd_x1_vdd_x2_vdd_x3_t113
+ a\x7cd\x7cinv_clk_vdd\x7cinv_mc_vdd\x7cinv_q_vdd\x7cmpa_py\x7cmpb_py\x7cnand_m_vdd\x7cnand_s2_vdd\x7cnwell_vdd\x7csb_vdd\x7csr1_vdd\x7csr2_vdd\x7csr3_vdd\x7csr4_vdd\x7csv_d_vdd_tie\x7csv_vdd\x7ctg_d_a\x7ctg_d_vdd\x7ctg_fbm_vdd\x7ctg_fbs_vdd\x7ctg_s_vdd\x7cvdd\x7cvdd_b1\x7cvdd_b2\x7cvdd_b3\x7cvdd_b4\x7cvdd_link\x7cvdd_link_dip\x7cvdd_x1\x7cvdd_x2\x7cvdd_x3__t113
+ a|d|inv_clk_vdd|inv_mc_vdd|inv_q_vdd|mpa_py|mpb_py|nand_m_vdd|nand_s2_vdd|nwell_vdd|sb_vdd|sr1_vdd|sr2_vdd|sr3_vdd|sr4_vdd|sv_d_vdd_tie|sv_vdd|tg_d_a|tg_d_vdd|tg_fbm_vdd|tg_fbs_vdd|tg_s_vdd|vdd|vdd_b1|vdd_b2|vdd_b3|vdd_b4|vdd_link|vdd_link_dip|vdd_x1|vdd_x2|vdd_x3
+ 285.928833001
* device instance a_d_inv_clk_vdd_inv_mc_vdd_inv_q_vdd_mpa_py_mpb_py_nand_m_vdd_nand_s2_vdd_nwell_vdd_sb_vdd_sr1_vdd_sr2_vdd_sr3_vdd_sr4_vdd_sv_d_vdd_tie_sv_vdd_tg_d_a_tg_d_vdd_tg_fbm_vdd_tg_fbs_vdd_tg_s_vdd_vdd_vdd_b1_vdd_b2_vdd_b3_vdd_b4_vdd_link_vdd_link_dip_vdd_x1_vdd_x2_vdd_x3_t114 r0 *1 0,0
Ra_d_inv_clk_vdd_inv_mc_vdd_inv_q_vdd_mpa_py_mpb_py_nand_m_vdd_nand_s2_vdd_nwell_vdd_sb_vdd_sr1_vdd_sr2_vdd_sr3_vdd_sr4_vdd_sv_d_vdd_tie_sv_vdd_tg_d_a_tg_d_vdd_tg_fbm_vdd_tg_fbs_vdd_tg_s_vdd_vdd_vdd_b1_vdd_b2_vdd_b3_vdd_b4_vdd_link_vdd_link_dip_vdd_x1_vdd_x2_vdd_x3_t114
+ a\x7cd\x7cinv_clk_vdd\x7cinv_mc_vdd\x7cinv_q_vdd\x7cmpa_py\x7cmpb_py\x7cnand_m_vdd\x7cnand_s2_vdd\x7cnwell_vdd\x7csb_vdd\x7csr1_vdd\x7csr2_vdd\x7csr3_vdd\x7csr4_vdd\x7csv_d_vdd_tie\x7csv_vdd\x7ctg_d_a\x7ctg_d_vdd\x7ctg_fbm_vdd\x7ctg_fbs_vdd\x7ctg_s_vdd\x7cvdd\x7cvdd_b1\x7cvdd_b2\x7cvdd_b3\x7cvdd_b4\x7cvdd_link\x7cvdd_link_dip\x7cvdd_x1\x7cvdd_x2\x7cvdd_x3__t114
+ a|d|inv_clk_vdd|inv_mc_vdd|inv_q_vdd|mpa_py|mpb_py|nand_m_vdd|nand_s2_vdd|nwell_vdd|sb_vdd|sr1_vdd|sr2_vdd|sr3_vdd|sr4_vdd|sv_d_vdd_tie|sv_vdd|tg_d_a|tg_d_vdd|tg_fbm_vdd|tg_fbs_vdd|tg_s_vdd|vdd|vdd_b1|vdd_b2|vdd_b3|vdd_b4|vdd_link|vdd_link_dip|vdd_x1|vdd_x2|vdd_x3
+ 259.316753764
* device instance a_d_inv_clk_vdd_inv_mc_vdd_inv_q_vdd_mpa_py_mpb_py_nand_m_vdd_nand_s2_vdd_nwell_vdd_sb_vdd_sr1_vdd_sr2_vdd_sr3_vdd_sr4_vdd_sv_d_vdd_tie_sv_vdd_tg_d_a_tg_d_vdd_tg_fbm_vdd_tg_fbs_vdd_tg_s_vdd_vdd_vdd_b1_vdd_b2_vdd_b3_vdd_b4_vdd_link_vdd_link_dip_vdd_x1_vdd_x2_vdd_x3_t115 r0 *1 0,0
Ra_d_inv_clk_vdd_inv_mc_vdd_inv_q_vdd_mpa_py_mpb_py_nand_m_vdd_nand_s2_vdd_nwell_vdd_sb_vdd_sr1_vdd_sr2_vdd_sr3_vdd_sr4_vdd_sv_d_vdd_tie_sv_vdd_tg_d_a_tg_d_vdd_tg_fbm_vdd_tg_fbs_vdd_tg_s_vdd_vdd_vdd_b1_vdd_b2_vdd_b3_vdd_b4_vdd_link_vdd_link_dip_vdd_x1_vdd_x2_vdd_x3_t115
+ a\x7cd\x7cinv_clk_vdd\x7cinv_mc_vdd\x7cinv_q_vdd\x7cmpa_py\x7cmpb_py\x7cnand_m_vdd\x7cnand_s2_vdd\x7cnwell_vdd\x7csb_vdd\x7csr1_vdd\x7csr2_vdd\x7csr3_vdd\x7csr4_vdd\x7csv_d_vdd_tie\x7csv_vdd\x7ctg_d_a\x7ctg_d_vdd\x7ctg_fbm_vdd\x7ctg_fbs_vdd\x7ctg_s_vdd\x7cvdd\x7cvdd_b1\x7cvdd_b2\x7cvdd_b3\x7cvdd_b4\x7cvdd_link\x7cvdd_link_dip\x7cvdd_x1\x7cvdd_x2\x7cvdd_x3__t115
+ a|d|inv_clk_vdd|inv_mc_vdd|inv_q_vdd|mpa_py|mpb_py|nand_m_vdd|nand_s2_vdd|nwell_vdd|sb_vdd|sr1_vdd|sr2_vdd|sr3_vdd|sr4_vdd|sv_d_vdd_tie|sv_vdd|tg_d_a|tg_d_vdd|tg_fbm_vdd|tg_fbs_vdd|tg_s_vdd|vdd|vdd_b1|vdd_b2|vdd_b3|vdd_b4|vdd_link|vdd_link_dip|vdd_x1|vdd_x2|vdd_x3
+ 228.609701783
* device instance a_d_inv_clk_vdd_inv_mc_vdd_inv_q_vdd_mpa_py_mpb_py_nand_m_vdd_nand_s2_vdd_nwell_vdd_sb_vdd_sr1_vdd_sr2_vdd_sr3_vdd_sr4_vdd_sv_d_vdd_tie_sv_vdd_tg_d_a_tg_d_vdd_tg_fbm_vdd_tg_fbs_vdd_tg_s_vdd_vdd_vdd_b1_vdd_b2_vdd_b3_vdd_b4_vdd_link_vdd_link_dip_vdd_x1_vdd_x2_vdd_x3_t116 r0 *1 0,0
Ra_d_inv_clk_vdd_inv_mc_vdd_inv_q_vdd_mpa_py_mpb_py_nand_m_vdd_nand_s2_vdd_nwell_vdd_sb_vdd_sr1_vdd_sr2_vdd_sr3_vdd_sr4_vdd_sv_d_vdd_tie_sv_vdd_tg_d_a_tg_d_vdd_tg_fbm_vdd_tg_fbs_vdd_tg_s_vdd_vdd_vdd_b1_vdd_b2_vdd_b3_vdd_b4_vdd_link_vdd_link_dip_vdd_x1_vdd_x2_vdd_x3_t116
+ a\x7cd\x7cinv_clk_vdd\x7cinv_mc_vdd\x7cinv_q_vdd\x7cmpa_py\x7cmpb_py\x7cnand_m_vdd\x7cnand_s2_vdd\x7cnwell_vdd\x7csb_vdd\x7csr1_vdd\x7csr2_vdd\x7csr3_vdd\x7csr4_vdd\x7csv_d_vdd_tie\x7csv_vdd\x7ctg_d_a\x7ctg_d_vdd\x7ctg_fbm_vdd\x7ctg_fbs_vdd\x7ctg_s_vdd\x7cvdd\x7cvdd_b1\x7cvdd_b2\x7cvdd_b3\x7cvdd_b4\x7cvdd_link\x7cvdd_link_dip\x7cvdd_x1\x7cvdd_x2\x7cvdd_x3__t116
+ a|d|inv_clk_vdd|inv_mc_vdd|inv_q_vdd|mpa_py|mpb_py|nand_m_vdd|nand_s2_vdd|nwell_vdd|sb_vdd|sr1_vdd|sr2_vdd|sr3_vdd|sr4_vdd|sv_d_vdd_tie|sv_vdd|tg_d_a|tg_d_vdd|tg_fbm_vdd|tg_fbs_vdd|tg_s_vdd|vdd|vdd_b1|vdd_b2|vdd_b3|vdd_b4|vdd_link|vdd_link_dip|vdd_x1|vdd_x2|vdd_x3
+ 197.33586021
* device instance a_d_inv_clk_vdd_inv_mc_vdd_inv_q_vdd_mpa_py_mpb_py_nand_m_vdd_nand_s2_vdd_nwell_vdd_sb_vdd_sr1_vdd_sr2_vdd_sr3_vdd_sr4_vdd_sv_d_vdd_tie_sv_vdd_tg_d_a_tg_d_vdd_tg_fbm_vdd_tg_fbs_vdd_tg_s_vdd_vdd_vdd_b1_vdd_b2_vdd_b3_vdd_b4_vdd_link_vdd_link_dip_vdd_x1_vdd_x2_vdd_x3_t117 r0 *1 0,0
Ra_d_inv_clk_vdd_inv_mc_vdd_inv_q_vdd_mpa_py_mpb_py_nand_m_vdd_nand_s2_vdd_nwell_vdd_sb_vdd_sr1_vdd_sr2_vdd_sr3_vdd_sr4_vdd_sv_d_vdd_tie_sv_vdd_tg_d_a_tg_d_vdd_tg_fbm_vdd_tg_fbs_vdd_tg_s_vdd_vdd_vdd_b1_vdd_b2_vdd_b3_vdd_b4_vdd_link_vdd_link_dip_vdd_x1_vdd_x2_vdd_x3_t117
+ a\x7cd\x7cinv_clk_vdd\x7cinv_mc_vdd\x7cinv_q_vdd\x7cmpa_py\x7cmpb_py\x7cnand_m_vdd\x7cnand_s2_vdd\x7cnwell_vdd\x7csb_vdd\x7csr1_vdd\x7csr2_vdd\x7csr3_vdd\x7csr4_vdd\x7csv_d_vdd_tie\x7csv_vdd\x7ctg_d_a\x7ctg_d_vdd\x7ctg_fbm_vdd\x7ctg_fbs_vdd\x7ctg_s_vdd\x7cvdd\x7cvdd_b1\x7cvdd_b2\x7cvdd_b3\x7cvdd_b4\x7cvdd_link\x7cvdd_link_dip\x7cvdd_x1\x7cvdd_x2\x7cvdd_x3__t117
+ a|d|inv_clk_vdd|inv_mc_vdd|inv_q_vdd|mpa_py|mpb_py|nand_m_vdd|nand_s2_vdd|nwell_vdd|sb_vdd|sr1_vdd|sr2_vdd|sr3_vdd|sr4_vdd|sv_d_vdd_tie|sv_vdd|tg_d_a|tg_d_vdd|tg_fbm_vdd|tg_fbs_vdd|tg_s_vdd|vdd|vdd_b1|vdd_b2|vdd_b3|vdd_b4|vdd_link|vdd_link_dip|vdd_x1|vdd_x2|vdd_x3
+ 158.491152237
* device instance a_d_inv_clk_vdd_inv_mc_vdd_inv_q_vdd_mpa_py_mpb_py_nand_m_vdd_nand_s2_vdd_nwell_vdd_sb_vdd_sr1_vdd_sr2_vdd_sr3_vdd_sr4_vdd_sv_d_vdd_tie_sv_vdd_tg_d_a_tg_d_vdd_tg_fbm_vdd_tg_fbs_vdd_tg_s_vdd_vdd_vdd_b1_vdd_b2_vdd_b3_vdd_b4_vdd_link_vdd_link_dip_vdd_x1_vdd_x2_vdd_x3_t118 r0 *1 0,0
Ra_d_inv_clk_vdd_inv_mc_vdd_inv_q_vdd_mpa_py_mpb_py_nand_m_vdd_nand_s2_vdd_nwell_vdd_sb_vdd_sr1_vdd_sr2_vdd_sr3_vdd_sr4_vdd_sv_d_vdd_tie_sv_vdd_tg_d_a_tg_d_vdd_tg_fbm_vdd_tg_fbs_vdd_tg_s_vdd_vdd_vdd_b1_vdd_b2_vdd_b3_vdd_b4_vdd_link_vdd_link_dip_vdd_x1_vdd_x2_vdd_x3_t118
+ a\x7cd\x7cinv_clk_vdd\x7cinv_mc_vdd\x7cinv_q_vdd\x7cmpa_py\x7cmpb_py\x7cnand_m_vdd\x7cnand_s2_vdd\x7cnwell_vdd\x7csb_vdd\x7csr1_vdd\x7csr2_vdd\x7csr3_vdd\x7csr4_vdd\x7csv_d_vdd_tie\x7csv_vdd\x7ctg_d_a\x7ctg_d_vdd\x7ctg_fbm_vdd\x7ctg_fbs_vdd\x7ctg_s_vdd\x7cvdd\x7cvdd_b1\x7cvdd_b2\x7cvdd_b3\x7cvdd_b4\x7cvdd_link\x7cvdd_link_dip\x7cvdd_x1\x7cvdd_x2\x7cvdd_x3__t118
+ a|d|inv_clk_vdd|inv_mc_vdd|inv_q_vdd|mpa_py|mpb_py|nand_m_vdd|nand_s2_vdd|nwell_vdd|sb_vdd|sr1_vdd|sr2_vdd|sr3_vdd|sr4_vdd|sv_d_vdd_tie|sv_vdd|tg_d_a|tg_d_vdd|tg_fbm_vdd|tg_fbs_vdd|tg_s_vdd|vdd|vdd_b1|vdd_b2|vdd_b3|vdd_b4|vdd_link|vdd_link_dip|vdd_x1|vdd_x2|vdd_x3
+ 127.586530765
* device instance a_d_inv_clk_vdd_inv_mc_vdd_inv_q_vdd_mpa_py_mpb_py_nand_m_vdd_nand_s2_vdd_nwell_vdd_sb_vdd_sr1_vdd_sr2_vdd_sr3_vdd_sr4_vdd_sv_d_vdd_tie_sv_vdd_tg_d_a_tg_d_vdd_tg_fbm_vdd_tg_fbs_vdd_tg_s_vdd_vdd_vdd_b1_vdd_b2_vdd_b3_vdd_b4_vdd_link_vdd_link_dip_vdd_x1_vdd_x2_vdd_x3_t119 r0 *1 0,0
Ra_d_inv_clk_vdd_inv_mc_vdd_inv_q_vdd_mpa_py_mpb_py_nand_m_vdd_nand_s2_vdd_nwell_vdd_sb_vdd_sr1_vdd_sr2_vdd_sr3_vdd_sr4_vdd_sv_d_vdd_tie_sv_vdd_tg_d_a_tg_d_vdd_tg_fbm_vdd_tg_fbs_vdd_tg_s_vdd_vdd_vdd_b1_vdd_b2_vdd_b3_vdd_b4_vdd_link_vdd_link_dip_vdd_x1_vdd_x2_vdd_x3_t119
+ a\x7cd\x7cinv_clk_vdd\x7cinv_mc_vdd\x7cinv_q_vdd\x7cmpa_py\x7cmpb_py\x7cnand_m_vdd\x7cnand_s2_vdd\x7cnwell_vdd\x7csb_vdd\x7csr1_vdd\x7csr2_vdd\x7csr3_vdd\x7csr4_vdd\x7csv_d_vdd_tie\x7csv_vdd\x7ctg_d_a\x7ctg_d_vdd\x7ctg_fbm_vdd\x7ctg_fbs_vdd\x7ctg_s_vdd\x7cvdd\x7cvdd_b1\x7cvdd_b2\x7cvdd_b3\x7cvdd_b4\x7cvdd_link\x7cvdd_link_dip\x7cvdd_x1\x7cvdd_x2\x7cvdd_x3__t119
+ a|d|inv_clk_vdd|inv_mc_vdd|inv_q_vdd|mpa_py|mpb_py|nand_m_vdd|nand_s2_vdd|nwell_vdd|sb_vdd|sr1_vdd|sr2_vdd|sr3_vdd|sr4_vdd|sv_d_vdd_tie|sv_vdd|tg_d_a|tg_d_vdd|tg_fbm_vdd|tg_fbs_vdd|tg_s_vdd|vdd|vdd_b1|vdd_b2|vdd_b3|vdd_b4|vdd_link|vdd_link_dip|vdd_x1|vdd_x2|vdd_x3
+ 119.192603341
* device instance a_d_inv_clk_vdd_inv_mc_vdd_inv_q_vdd_mpa_py_mpb_py_nand_m_vdd_nand_s2_vdd_nwell_vdd_sb_vdd_sr1_vdd_sr2_vdd_sr3_vdd_sr4_vdd_sv_d_vdd_tie_sv_vdd_tg_d_a_tg_d_vdd_tg_fbm_vdd_tg_fbs_vdd_tg_s_vdd_vdd_vdd_b1_vdd_b2_vdd_b3_vdd_b4_vdd_link_vdd_link_dip_vdd_x1_vdd_x2_vdd_x3_t120 r0 *1 0,0
Ra_d_inv_clk_vdd_inv_mc_vdd_inv_q_vdd_mpa_py_mpb_py_nand_m_vdd_nand_s2_vdd_nwell_vdd_sb_vdd_sr1_vdd_sr2_vdd_sr3_vdd_sr4_vdd_sv_d_vdd_tie_sv_vdd_tg_d_a_tg_d_vdd_tg_fbm_vdd_tg_fbs_vdd_tg_s_vdd_vdd_vdd_b1_vdd_b2_vdd_b3_vdd_b4_vdd_link_vdd_link_dip_vdd_x1_vdd_x2_vdd_x3_t120
+ a\x7cd\x7cinv_clk_vdd\x7cinv_mc_vdd\x7cinv_q_vdd\x7cmpa_py\x7cmpb_py\x7cnand_m_vdd\x7cnand_s2_vdd\x7cnwell_vdd\x7csb_vdd\x7csr1_vdd\x7csr2_vdd\x7csr3_vdd\x7csr4_vdd\x7csv_d_vdd_tie\x7csv_vdd\x7ctg_d_a\x7ctg_d_vdd\x7ctg_fbm_vdd\x7ctg_fbs_vdd\x7ctg_s_vdd\x7cvdd\x7cvdd_b1\x7cvdd_b2\x7cvdd_b3\x7cvdd_b4\x7cvdd_link\x7cvdd_link_dip\x7cvdd_x1\x7cvdd_x2\x7cvdd_x3__t120
+ a|d|inv_clk_vdd|inv_mc_vdd|inv_q_vdd|mpa_py|mpb_py|nand_m_vdd|nand_s2_vdd|nwell_vdd|sb_vdd|sr1_vdd|sr2_vdd|sr3_vdd|sr4_vdd|sv_d_vdd_tie|sv_vdd|tg_d_a|tg_d_vdd|tg_fbm_vdd|tg_fbs_vdd|tg_s_vdd|vdd|vdd_b1|vdd_b2|vdd_b3|vdd_b4|vdd_link|vdd_link_dip|vdd_x1|vdd_x2|vdd_x3
+ 207.535121948
* device instance a_d_inv_clk_vdd_inv_mc_vdd_inv_q_vdd_mpa_py_mpb_py_nand_m_vdd_nand_s2_vdd_nwell_vdd_sb_vdd_sr1_vdd_sr2_vdd_sr3_vdd_sr4_vdd_sv_d_vdd_tie_sv_vdd_tg_d_a_tg_d_vdd_tg_fbm_vdd_tg_fbs_vdd_tg_s_vdd_vdd_vdd_b1_vdd_b2_vdd_b3_vdd_b4_vdd_link_vdd_link_dip_vdd_x1_vdd_x2_vdd_x3_t121 r0 *1 0,0
Ra_d_inv_clk_vdd_inv_mc_vdd_inv_q_vdd_mpa_py_mpb_py_nand_m_vdd_nand_s2_vdd_nwell_vdd_sb_vdd_sr1_vdd_sr2_vdd_sr3_vdd_sr4_vdd_sv_d_vdd_tie_sv_vdd_tg_d_a_tg_d_vdd_tg_fbm_vdd_tg_fbs_vdd_tg_s_vdd_vdd_vdd_b1_vdd_b2_vdd_b3_vdd_b4_vdd_link_vdd_link_dip_vdd_x1_vdd_x2_vdd_x3_t121
+ a\x7cd\x7cinv_clk_vdd\x7cinv_mc_vdd\x7cinv_q_vdd\x7cmpa_py\x7cmpb_py\x7cnand_m_vdd\x7cnand_s2_vdd\x7cnwell_vdd\x7csb_vdd\x7csr1_vdd\x7csr2_vdd\x7csr3_vdd\x7csr4_vdd\x7csv_d_vdd_tie\x7csv_vdd\x7ctg_d_a\x7ctg_d_vdd\x7ctg_fbm_vdd\x7ctg_fbs_vdd\x7ctg_s_vdd\x7cvdd\x7cvdd_b1\x7cvdd_b2\x7cvdd_b3\x7cvdd_b4\x7cvdd_link\x7cvdd_link_dip\x7cvdd_x1\x7cvdd_x2\x7cvdd_x3__t121
+ a|d|inv_clk_vdd|inv_mc_vdd|inv_q_vdd|mpa_py|mpb_py|nand_m_vdd|nand_s2_vdd|nwell_vdd|sb_vdd|sr1_vdd|sr2_vdd|sr3_vdd|sr4_vdd|sv_d_vdd_tie|sv_vdd|tg_d_a|tg_d_vdd|tg_fbm_vdd|tg_fbs_vdd|tg_s_vdd|vdd|vdd_b1|vdd_b2|vdd_b3|vdd_b4|vdd_link|vdd_link_dip|vdd_x1|vdd_x2|vdd_x3
+ 217.107279244
* device instance a_d_inv_clk_vdd_inv_mc_vdd_inv_q_vdd_mpa_py_mpb_py_nand_m_vdd_nand_s2_vdd_nwell_vdd_sb_vdd_sr1_vdd_sr2_vdd_sr3_vdd_sr4_vdd_sv_d_vdd_tie_sv_vdd_tg_d_a_tg_d_vdd_tg_fbm_vdd_tg_fbs_vdd_tg_s_vdd_vdd_vdd_b1_vdd_b2_vdd_b3_vdd_b4_vdd_link_vdd_link_dip_vdd_x1_vdd_x2_vdd_x3_t122 r0 *1 0,0
Ra_d_inv_clk_vdd_inv_mc_vdd_inv_q_vdd_mpa_py_mpb_py_nand_m_vdd_nand_s2_vdd_nwell_vdd_sb_vdd_sr1_vdd_sr2_vdd_sr3_vdd_sr4_vdd_sv_d_vdd_tie_sv_vdd_tg_d_a_tg_d_vdd_tg_fbm_vdd_tg_fbs_vdd_tg_s_vdd_vdd_vdd_b1_vdd_b2_vdd_b3_vdd_b4_vdd_link_vdd_link_dip_vdd_x1_vdd_x2_vdd_x3_t122
+ a\x7cd\x7cinv_clk_vdd\x7cinv_mc_vdd\x7cinv_q_vdd\x7cmpa_py\x7cmpb_py\x7cnand_m_vdd\x7cnand_s2_vdd\x7cnwell_vdd\x7csb_vdd\x7csr1_vdd\x7csr2_vdd\x7csr3_vdd\x7csr4_vdd\x7csv_d_vdd_tie\x7csv_vdd\x7ctg_d_a\x7ctg_d_vdd\x7ctg_fbm_vdd\x7ctg_fbs_vdd\x7ctg_s_vdd\x7cvdd\x7cvdd_b1\x7cvdd_b2\x7cvdd_b3\x7cvdd_b4\x7cvdd_link\x7cvdd_link_dip\x7cvdd_x1\x7cvdd_x2\x7cvdd_x3__t122
+ a|d|inv_clk_vdd|inv_mc_vdd|inv_q_vdd|mpa_py|mpb_py|nand_m_vdd|nand_s2_vdd|nwell_vdd|sb_vdd|sr1_vdd|sr2_vdd|sr3_vdd|sr4_vdd|sv_d_vdd_tie|sv_vdd|tg_d_a|tg_d_vdd|tg_fbm_vdd|tg_fbs_vdd|tg_s_vdd|vdd|vdd_b1|vdd_b2|vdd_b3|vdd_b4|vdd_link|vdd_link_dip|vdd_x1|vdd_x2|vdd_x3
+ 188.993530351
* device instance a_d_inv_clk_vdd_inv_mc_vdd_inv_q_vdd_mpa_py_mpb_py_nand_m_vdd_nand_s2_vdd_nwell_vdd_sb_vdd_sr1_vdd_sr2_vdd_sr3_vdd_sr4_vdd_sv_d_vdd_tie_sv_vdd_tg_d_a_tg_d_vdd_tg_fbm_vdd_tg_fbs_vdd_tg_s_vdd_vdd_vdd_b1_vdd_b2_vdd_b3_vdd_b4_vdd_link_vdd_link_dip_vdd_x1_vdd_x2_vdd_x3_t123 r0 *1 0,0
Ra_d_inv_clk_vdd_inv_mc_vdd_inv_q_vdd_mpa_py_mpb_py_nand_m_vdd_nand_s2_vdd_nwell_vdd_sb_vdd_sr1_vdd_sr2_vdd_sr3_vdd_sr4_vdd_sv_d_vdd_tie_sv_vdd_tg_d_a_tg_d_vdd_tg_fbm_vdd_tg_fbs_vdd_tg_s_vdd_vdd_vdd_b1_vdd_b2_vdd_b3_vdd_b4_vdd_link_vdd_link_dip_vdd_x1_vdd_x2_vdd_x3_t123
+ a\x7cd\x7cinv_clk_vdd\x7cinv_mc_vdd\x7cinv_q_vdd\x7cmpa_py\x7cmpb_py\x7cnand_m_vdd\x7cnand_s2_vdd\x7cnwell_vdd\x7csb_vdd\x7csr1_vdd\x7csr2_vdd\x7csr3_vdd\x7csr4_vdd\x7csv_d_vdd_tie\x7csv_vdd\x7ctg_d_a\x7ctg_d_vdd\x7ctg_fbm_vdd\x7ctg_fbs_vdd\x7ctg_s_vdd\x7cvdd\x7cvdd_b1\x7cvdd_b2\x7cvdd_b3\x7cvdd_b4\x7cvdd_link\x7cvdd_link_dip\x7cvdd_x1\x7cvdd_x2\x7cvdd_x3__t123
+ a|d|inv_clk_vdd|inv_mc_vdd|inv_q_vdd|mpa_py|mpb_py|nand_m_vdd|nand_s2_vdd|nwell_vdd|sb_vdd|sr1_vdd|sr2_vdd|sr3_vdd|sr4_vdd|sv_d_vdd_tie|sv_vdd|tg_d_a|tg_d_vdd|tg_fbm_vdd|tg_fbs_vdd|tg_s_vdd|vdd|vdd_b1|vdd_b2|vdd_b3|vdd_b4|vdd_link|vdd_link_dip|vdd_x1|vdd_x2|vdd_x3
+ 247.003583517
* device instance a_d_inv_clk_vdd_inv_mc_vdd_inv_q_vdd_mpa_py_mpb_py_nand_m_vdd_nand_s2_vdd_nwell_vdd_sb_vdd_sr1_vdd_sr2_vdd_sr3_vdd_sr4_vdd_sv_d_vdd_tie_sv_vdd_tg_d_a_tg_d_vdd_tg_fbm_vdd_tg_fbs_vdd_tg_s_vdd_vdd_vdd_b1_vdd_b2_vdd_b3_vdd_b4_vdd_link_vdd_link_dip_vdd_x1_vdd_x2_vdd_x3_t124 r0 *1 0,0
Ra_d_inv_clk_vdd_inv_mc_vdd_inv_q_vdd_mpa_py_mpb_py_nand_m_vdd_nand_s2_vdd_nwell_vdd_sb_vdd_sr1_vdd_sr2_vdd_sr3_vdd_sr4_vdd_sv_d_vdd_tie_sv_vdd_tg_d_a_tg_d_vdd_tg_fbm_vdd_tg_fbs_vdd_tg_s_vdd_vdd_vdd_b1_vdd_b2_vdd_b3_vdd_b4_vdd_link_vdd_link_dip_vdd_x1_vdd_x2_vdd_x3_t124
+ a\x7cd\x7cinv_clk_vdd\x7cinv_mc_vdd\x7cinv_q_vdd\x7cmpa_py\x7cmpb_py\x7cnand_m_vdd\x7cnand_s2_vdd\x7cnwell_vdd\x7csb_vdd\x7csr1_vdd\x7csr2_vdd\x7csr3_vdd\x7csr4_vdd\x7csv_d_vdd_tie\x7csv_vdd\x7ctg_d_a\x7ctg_d_vdd\x7ctg_fbm_vdd\x7ctg_fbs_vdd\x7ctg_s_vdd\x7cvdd\x7cvdd_b1\x7cvdd_b2\x7cvdd_b3\x7cvdd_b4\x7cvdd_link\x7cvdd_link_dip\x7cvdd_x1\x7cvdd_x2\x7cvdd_x3__t124
+ a|d|inv_clk_vdd|inv_mc_vdd|inv_q_vdd|mpa_py|mpb_py|nand_m_vdd|nand_s2_vdd|nwell_vdd|sb_vdd|sr1_vdd|sr2_vdd|sr3_vdd|sr4_vdd|sv_d_vdd_tie|sv_vdd|tg_d_a|tg_d_vdd|tg_fbm_vdd|tg_fbs_vdd|tg_s_vdd|vdd|vdd_b1|vdd_b2|vdd_b3|vdd_b4|vdd_link|vdd_link_dip|vdd_x1|vdd_x2|vdd_x3
+ 172.434021845
* device instance a_d_inv_clk_vdd_inv_mc_vdd_inv_q_vdd_mpa_py_mpb_py_nand_m_vdd_nand_s2_vdd_nwell_vdd_sb_vdd_sr1_vdd_sr2_vdd_sr3_vdd_sr4_vdd_sv_d_vdd_tie_sv_vdd_tg_d_a_tg_d_vdd_tg_fbm_vdd_tg_fbs_vdd_tg_s_vdd_vdd_vdd_b1_vdd_b2_vdd_b3_vdd_b4_vdd_link_vdd_link_dip_vdd_x1_vdd_x2_vdd_x3_t125 r0 *1 0,0
Ra_d_inv_clk_vdd_inv_mc_vdd_inv_q_vdd_mpa_py_mpb_py_nand_m_vdd_nand_s2_vdd_nwell_vdd_sb_vdd_sr1_vdd_sr2_vdd_sr3_vdd_sr4_vdd_sv_d_vdd_tie_sv_vdd_tg_d_a_tg_d_vdd_tg_fbm_vdd_tg_fbs_vdd_tg_s_vdd_vdd_vdd_b1_vdd_b2_vdd_b3_vdd_b4_vdd_link_vdd_link_dip_vdd_x1_vdd_x2_vdd_x3_t125
+ a\x7cd\x7cinv_clk_vdd\x7cinv_mc_vdd\x7cinv_q_vdd\x7cmpa_py\x7cmpb_py\x7cnand_m_vdd\x7cnand_s2_vdd\x7cnwell_vdd\x7csb_vdd\x7csr1_vdd\x7csr2_vdd\x7csr3_vdd\x7csr4_vdd\x7csv_d_vdd_tie\x7csv_vdd\x7ctg_d_a\x7ctg_d_vdd\x7ctg_fbm_vdd\x7ctg_fbs_vdd\x7ctg_s_vdd\x7cvdd\x7cvdd_b1\x7cvdd_b2\x7cvdd_b3\x7cvdd_b4\x7cvdd_link\x7cvdd_link_dip\x7cvdd_x1\x7cvdd_x2\x7cvdd_x3__t125
+ a|d|inv_clk_vdd|inv_mc_vdd|inv_q_vdd|mpa_py|mpb_py|nand_m_vdd|nand_s2_vdd|nwell_vdd|sb_vdd|sr1_vdd|sr2_vdd|sr3_vdd|sr4_vdd|sv_d_vdd_tie|sv_vdd|tg_d_a|tg_d_vdd|tg_fbm_vdd|tg_fbs_vdd|tg_s_vdd|vdd|vdd_b1|vdd_b2|vdd_b3|vdd_b4|vdd_link|vdd_link_dip|vdd_x1|vdd_x2|vdd_x3
+ 296.153169133
* device instance a_d_inv_clk_vdd_inv_mc_vdd_inv_q_vdd_mpa_py_mpb_py_nand_m_vdd_nand_s2_vdd_nwell_vdd_sb_vdd_sr1_vdd_sr2_vdd_sr3_vdd_sr4_vdd_sv_d_vdd_tie_sv_vdd_tg_d_a_tg_d_vdd_tg_fbm_vdd_tg_fbs_vdd_tg_s_vdd_vdd_vdd_b1_vdd_b2_vdd_b3_vdd_b4_vdd_link_vdd_link_dip_vdd_x1_vdd_x2_vdd_x3_t126 r0 *1 0,0
Ra_d_inv_clk_vdd_inv_mc_vdd_inv_q_vdd_mpa_py_mpb_py_nand_m_vdd_nand_s2_vdd_nwell_vdd_sb_vdd_sr1_vdd_sr2_vdd_sr3_vdd_sr4_vdd_sv_d_vdd_tie_sv_vdd_tg_d_a_tg_d_vdd_tg_fbm_vdd_tg_fbs_vdd_tg_s_vdd_vdd_vdd_b1_vdd_b2_vdd_b3_vdd_b4_vdd_link_vdd_link_dip_vdd_x1_vdd_x2_vdd_x3_t126
+ a\x7cd\x7cinv_clk_vdd\x7cinv_mc_vdd\x7cinv_q_vdd\x7cmpa_py\x7cmpb_py\x7cnand_m_vdd\x7cnand_s2_vdd\x7cnwell_vdd\x7csb_vdd\x7csr1_vdd\x7csr2_vdd\x7csr3_vdd\x7csr4_vdd\x7csv_d_vdd_tie\x7csv_vdd\x7ctg_d_a\x7ctg_d_vdd\x7ctg_fbm_vdd\x7ctg_fbs_vdd\x7ctg_s_vdd\x7cvdd\x7cvdd_b1\x7cvdd_b2\x7cvdd_b3\x7cvdd_b4\x7cvdd_link\x7cvdd_link_dip\x7cvdd_x1\x7cvdd_x2\x7cvdd_x3__t126
+ a|d|inv_clk_vdd|inv_mc_vdd|inv_q_vdd|mpa_py|mpb_py|nand_m_vdd|nand_s2_vdd|nwell_vdd|sb_vdd|sr1_vdd|sr2_vdd|sr3_vdd|sr4_vdd|sv_d_vdd_tie|sv_vdd|tg_d_a|tg_d_vdd|tg_fbm_vdd|tg_fbs_vdd|tg_s_vdd|vdd|vdd_b1|vdd_b2|vdd_b3|vdd_b4|vdd_link|vdd_link_dip|vdd_x1|vdd_x2|vdd_x3
+ 43.2151550485
* device instance a_d_inv_clk_vdd_inv_mc_vdd_inv_q_vdd_mpa_py_mpb_py_nand_m_vdd_nand_s2_vdd_nwell_vdd_sb_vdd_sr1_vdd_sr2_vdd_sr3_vdd_sr4_vdd_sv_d_vdd_tie_sv_vdd_tg_d_a_tg_d_vdd_tg_fbm_vdd_tg_fbs_vdd_tg_s_vdd_vdd_vdd_b1_vdd_b2_vdd_b3_vdd_b4_vdd_link_vdd_link_dip_vdd_x1_vdd_x2_vdd_x3_t127 r0 *1 0,0
Ra_d_inv_clk_vdd_inv_mc_vdd_inv_q_vdd_mpa_py_mpb_py_nand_m_vdd_nand_s2_vdd_nwell_vdd_sb_vdd_sr1_vdd_sr2_vdd_sr3_vdd_sr4_vdd_sv_d_vdd_tie_sv_vdd_tg_d_a_tg_d_vdd_tg_fbm_vdd_tg_fbs_vdd_tg_s_vdd_vdd_vdd_b1_vdd_b2_vdd_b3_vdd_b4_vdd_link_vdd_link_dip_vdd_x1_vdd_x2_vdd_x3_t127
+ a\x7cd\x7cinv_clk_vdd\x7cinv_mc_vdd\x7cinv_q_vdd\x7cmpa_py\x7cmpb_py\x7cnand_m_vdd\x7cnand_s2_vdd\x7cnwell_vdd\x7csb_vdd\x7csr1_vdd\x7csr2_vdd\x7csr3_vdd\x7csr4_vdd\x7csv_d_vdd_tie\x7csv_vdd\x7ctg_d_a\x7ctg_d_vdd\x7ctg_fbm_vdd\x7ctg_fbs_vdd\x7ctg_s_vdd\x7cvdd\x7cvdd_b1\x7cvdd_b2\x7cvdd_b3\x7cvdd_b4\x7cvdd_link\x7cvdd_link_dip\x7cvdd_x1\x7cvdd_x2\x7cvdd_x3__t127
+ a|d|inv_clk_vdd|inv_mc_vdd|inv_q_vdd|mpa_py|mpb_py|nand_m_vdd|nand_s2_vdd|nwell_vdd|sb_vdd|sr1_vdd|sr2_vdd|sr3_vdd|sr4_vdd|sv_d_vdd_tie|sv_vdd|tg_d_a|tg_d_vdd|tg_fbm_vdd|tg_fbs_vdd|tg_s_vdd|vdd|vdd_b1|vdd_b2|vdd_b3|vdd_b4|vdd_link|vdd_link_dip|vdd_x1|vdd_x2|vdd_x3
+ 144.903445918
* device instance a_d_inv_clk_vdd_inv_mc_vdd_inv_q_vdd_mpa_py_mpb_py_nand_m_vdd_nand_s2_vdd_nwell_vdd_sb_vdd_sr1_vdd_sr2_vdd_sr3_vdd_sr4_vdd_sv_d_vdd_tie_sv_vdd_tg_d_a_tg_d_vdd_tg_fbm_vdd_tg_fbs_vdd_tg_s_vdd_vdd_vdd_b1_vdd_b2_vdd_b3_vdd_b4_vdd_link_vdd_link_dip_vdd_x1_vdd_x2_vdd_x3_t128 r0 *1 0,0
Ra_d_inv_clk_vdd_inv_mc_vdd_inv_q_vdd_mpa_py_mpb_py_nand_m_vdd_nand_s2_vdd_nwell_vdd_sb_vdd_sr1_vdd_sr2_vdd_sr3_vdd_sr4_vdd_sv_d_vdd_tie_sv_vdd_tg_d_a_tg_d_vdd_tg_fbm_vdd_tg_fbs_vdd_tg_s_vdd_vdd_vdd_b1_vdd_b2_vdd_b3_vdd_b4_vdd_link_vdd_link_dip_vdd_x1_vdd_x2_vdd_x3_t128
+ a\x7cd\x7cinv_clk_vdd\x7cinv_mc_vdd\x7cinv_q_vdd\x7cmpa_py\x7cmpb_py\x7cnand_m_vdd\x7cnand_s2_vdd\x7cnwell_vdd\x7csb_vdd\x7csr1_vdd\x7csr2_vdd\x7csr3_vdd\x7csr4_vdd\x7csv_d_vdd_tie\x7csv_vdd\x7ctg_d_a\x7ctg_d_vdd\x7ctg_fbm_vdd\x7ctg_fbs_vdd\x7ctg_s_vdd\x7cvdd\x7cvdd_b1\x7cvdd_b2\x7cvdd_b3\x7cvdd_b4\x7cvdd_link\x7cvdd_link_dip\x7cvdd_x1\x7cvdd_x2\x7cvdd_x3__t128
+ a|d|inv_clk_vdd|inv_mc_vdd|inv_q_vdd|mpa_py|mpb_py|nand_m_vdd|nand_s2_vdd|nwell_vdd|sb_vdd|sr1_vdd|sr2_vdd|sr3_vdd|sr4_vdd|sv_d_vdd_tie|sv_vdd|tg_d_a|tg_d_vdd|tg_fbm_vdd|tg_fbs_vdd|tg_s_vdd|vdd|vdd_b1|vdd_b2|vdd_b3|vdd_b4|vdd_link|vdd_link_dip|vdd_x1|vdd_x2|vdd_x3
+ 128.856674127
* device instance a_d_inv_clk_vdd_inv_mc_vdd_inv_q_vdd_mpa_py_mpb_py_nand_m_vdd_nand_s2_vdd_nwell_vdd_sb_vdd_sr1_vdd_sr2_vdd_sr3_vdd_sr4_vdd_sv_d_vdd_tie_sv_vdd_tg_d_a_tg_d_vdd_tg_fbm_vdd_tg_fbs_vdd_tg_s_vdd_vdd_vdd_b1_vdd_b2_vdd_b3_vdd_b4_vdd_link_vdd_link_dip_vdd_x1_vdd_x2_vdd_x3_t129 r0 *1 0,0
Ra_d_inv_clk_vdd_inv_mc_vdd_inv_q_vdd_mpa_py_mpb_py_nand_m_vdd_nand_s2_vdd_nwell_vdd_sb_vdd_sr1_vdd_sr2_vdd_sr3_vdd_sr4_vdd_sv_d_vdd_tie_sv_vdd_tg_d_a_tg_d_vdd_tg_fbm_vdd_tg_fbs_vdd_tg_s_vdd_vdd_vdd_b1_vdd_b2_vdd_b3_vdd_b4_vdd_link_vdd_link_dip_vdd_x1_vdd_x2_vdd_x3_t129
+ a\x7cd\x7cinv_clk_vdd\x7cinv_mc_vdd\x7cinv_q_vdd\x7cmpa_py\x7cmpb_py\x7cnand_m_vdd\x7cnand_s2_vdd\x7cnwell_vdd\x7csb_vdd\x7csr1_vdd\x7csr2_vdd\x7csr3_vdd\x7csr4_vdd\x7csv_d_vdd_tie\x7csv_vdd\x7ctg_d_a\x7ctg_d_vdd\x7ctg_fbm_vdd\x7ctg_fbs_vdd\x7ctg_s_vdd\x7cvdd\x7cvdd_b1\x7cvdd_b2\x7cvdd_b3\x7cvdd_b4\x7cvdd_link\x7cvdd_link_dip\x7cvdd_x1\x7cvdd_x2\x7cvdd_x3__t129
+ a|d|inv_clk_vdd|inv_mc_vdd|inv_q_vdd|mpa_py|mpb_py|nand_m_vdd|nand_s2_vdd|nwell_vdd|sb_vdd|sr1_vdd|sr2_vdd|sr3_vdd|sr4_vdd|sv_d_vdd_tie|sv_vdd|tg_d_a|tg_d_vdd|tg_fbm_vdd|tg_fbs_vdd|tg_s_vdd|vdd|vdd_b1|vdd_b2|vdd_b3|vdd_b4|vdd_link|vdd_link_dip|vdd_x1|vdd_x2|vdd_x3
+ 185.930124671
* device instance a_d_inv_clk_vdd_inv_mc_vdd_inv_q_vdd_mpa_py_mpb_py_nand_m_vdd_nand_s2_vdd_nwell_vdd_sb_vdd_sr1_vdd_sr2_vdd_sr3_vdd_sr4_vdd_sv_d_vdd_tie_sv_vdd_tg_d_a_tg_d_vdd_tg_fbm_vdd_tg_fbs_vdd_tg_s_vdd_vdd_vdd_b1_vdd_b2_vdd_b3_vdd_b4_vdd_link_vdd_link_dip_vdd_x1_vdd_x2_vdd_x3_t130 r0 *1 0,0
Ra_d_inv_clk_vdd_inv_mc_vdd_inv_q_vdd_mpa_py_mpb_py_nand_m_vdd_nand_s2_vdd_nwell_vdd_sb_vdd_sr1_vdd_sr2_vdd_sr3_vdd_sr4_vdd_sv_d_vdd_tie_sv_vdd_tg_d_a_tg_d_vdd_tg_fbm_vdd_tg_fbs_vdd_tg_s_vdd_vdd_vdd_b1_vdd_b2_vdd_b3_vdd_b4_vdd_link_vdd_link_dip_vdd_x1_vdd_x2_vdd_x3_t130
+ a\x7cd\x7cinv_clk_vdd\x7cinv_mc_vdd\x7cinv_q_vdd\x7cmpa_py\x7cmpb_py\x7cnand_m_vdd\x7cnand_s2_vdd\x7cnwell_vdd\x7csb_vdd\x7csr1_vdd\x7csr2_vdd\x7csr3_vdd\x7csr4_vdd\x7csv_d_vdd_tie\x7csv_vdd\x7ctg_d_a\x7ctg_d_vdd\x7ctg_fbm_vdd\x7ctg_fbs_vdd\x7ctg_s_vdd\x7cvdd\x7cvdd_b1\x7cvdd_b2\x7cvdd_b3\x7cvdd_b4\x7cvdd_link\x7cvdd_link_dip\x7cvdd_x1\x7cvdd_x2\x7cvdd_x3__t130
+ a|d|inv_clk_vdd|inv_mc_vdd|inv_q_vdd|mpa_py|mpb_py|nand_m_vdd|nand_s2_vdd|nwell_vdd|sb_vdd|sr1_vdd|sr2_vdd|sr3_vdd|sr4_vdd|sv_d_vdd_tie|sv_vdd|tg_d_a|tg_d_vdd|tg_fbm_vdd|tg_fbs_vdd|tg_s_vdd|vdd|vdd_b1|vdd_b2|vdd_b3|vdd_b4|vdd_link|vdd_link_dip|vdd_x1|vdd_x2|vdd_x3
+ 159.390226843
* device instance a_d_inv_clk_vdd_inv_mc_vdd_inv_q_vdd_mpa_py_mpb_py_nand_m_vdd_nand_s2_vdd_nwell_vdd_sb_vdd_sr1_vdd_sr2_vdd_sr3_vdd_sr4_vdd_sv_d_vdd_tie_sv_vdd_tg_d_a_tg_d_vdd_tg_fbm_vdd_tg_fbs_vdd_tg_s_vdd_vdd_vdd_b1_vdd_b2_vdd_b3_vdd_b4_vdd_link_vdd_link_dip_vdd_x1_vdd_x2_vdd_x3_t131 r0 *1 0,0
Ra_d_inv_clk_vdd_inv_mc_vdd_inv_q_vdd_mpa_py_mpb_py_nand_m_vdd_nand_s2_vdd_nwell_vdd_sb_vdd_sr1_vdd_sr2_vdd_sr3_vdd_sr4_vdd_sv_d_vdd_tie_sv_vdd_tg_d_a_tg_d_vdd_tg_fbm_vdd_tg_fbs_vdd_tg_s_vdd_vdd_vdd_b1_vdd_b2_vdd_b3_vdd_b4_vdd_link_vdd_link_dip_vdd_x1_vdd_x2_vdd_x3_t131
+ a\x7cd\x7cinv_clk_vdd\x7cinv_mc_vdd\x7cinv_q_vdd\x7cmpa_py\x7cmpb_py\x7cnand_m_vdd\x7cnand_s2_vdd\x7cnwell_vdd\x7csb_vdd\x7csr1_vdd\x7csr2_vdd\x7csr3_vdd\x7csr4_vdd\x7csv_d_vdd_tie\x7csv_vdd\x7ctg_d_a\x7ctg_d_vdd\x7ctg_fbm_vdd\x7ctg_fbs_vdd\x7ctg_s_vdd\x7cvdd\x7cvdd_b1\x7cvdd_b2\x7cvdd_b3\x7cvdd_b4\x7cvdd_link\x7cvdd_link_dip\x7cvdd_x1\x7cvdd_x2\x7cvdd_x3__t131
+ a|d|inv_clk_vdd|inv_mc_vdd|inv_q_vdd|mpa_py|mpb_py|nand_m_vdd|nand_s2_vdd|nwell_vdd|sb_vdd|sr1_vdd|sr2_vdd|sr3_vdd|sr4_vdd|sv_d_vdd_tie|sv_vdd|tg_d_a|tg_d_vdd|tg_fbm_vdd|tg_fbs_vdd|tg_s_vdd|vdd|vdd_b1|vdd_b2|vdd_b3|vdd_b4|vdd_link|vdd_link_dip|vdd_x1|vdd_x2|vdd_x3
+ 128.228778725
* device instance a_d_inv_clk_vdd_inv_mc_vdd_inv_q_vdd_mpa_py_mpb_py_nand_m_vdd_nand_s2_vdd_nwell_vdd_sb_vdd_sr1_vdd_sr2_vdd_sr3_vdd_sr4_vdd_sv_d_vdd_tie_sv_vdd_tg_d_a_tg_d_vdd_tg_fbm_vdd_tg_fbs_vdd_tg_s_vdd_vdd_vdd_b1_vdd_b2_vdd_b3_vdd_b4_vdd_link_vdd_link_dip_vdd_x1_vdd_x2_vdd_x3_t132 r0 *1 0,0
Ra_d_inv_clk_vdd_inv_mc_vdd_inv_q_vdd_mpa_py_mpb_py_nand_m_vdd_nand_s2_vdd_nwell_vdd_sb_vdd_sr1_vdd_sr2_vdd_sr3_vdd_sr4_vdd_sv_d_vdd_tie_sv_vdd_tg_d_a_tg_d_vdd_tg_fbm_vdd_tg_fbs_vdd_tg_s_vdd_vdd_vdd_b1_vdd_b2_vdd_b3_vdd_b4_vdd_link_vdd_link_dip_vdd_x1_vdd_x2_vdd_x3_t132
+ a\x7cd\x7cinv_clk_vdd\x7cinv_mc_vdd\x7cinv_q_vdd\x7cmpa_py\x7cmpb_py\x7cnand_m_vdd\x7cnand_s2_vdd\x7cnwell_vdd\x7csb_vdd\x7csr1_vdd\x7csr2_vdd\x7csr3_vdd\x7csr4_vdd\x7csv_d_vdd_tie\x7csv_vdd\x7ctg_d_a\x7ctg_d_vdd\x7ctg_fbm_vdd\x7ctg_fbs_vdd\x7ctg_s_vdd\x7cvdd\x7cvdd_b1\x7cvdd_b2\x7cvdd_b3\x7cvdd_b4\x7cvdd_link\x7cvdd_link_dip\x7cvdd_x1\x7cvdd_x2\x7cvdd_x3__t132
+ a|d|inv_clk_vdd|inv_mc_vdd|inv_q_vdd|mpa_py|mpb_py|nand_m_vdd|nand_s2_vdd|nwell_vdd|sb_vdd|sr1_vdd|sr2_vdd|sr3_vdd|sr4_vdd|sv_d_vdd_tie|sv_vdd|tg_d_a|tg_d_vdd|tg_fbm_vdd|tg_fbs_vdd|tg_s_vdd|vdd|vdd_b1|vdd_b2|vdd_b3|vdd_b4|vdd_link|vdd_link_dip|vdd_x1|vdd_x2|vdd_x3
+ 97.781386643
* device instance a_d_inv_clk_vdd_inv_mc_vdd_inv_q_vdd_mpa_py_mpb_py_nand_m_vdd_nand_s2_vdd_nwell_vdd_sb_vdd_sr1_vdd_sr2_vdd_sr3_vdd_sr4_vdd_sv_d_vdd_tie_sv_vdd_tg_d_a_tg_d_vdd_tg_fbm_vdd_tg_fbs_vdd_tg_s_vdd_vdd_vdd_b1_vdd_b2_vdd_b3_vdd_b4_vdd_link_vdd_link_dip_vdd_x1_vdd_x2_vdd_x3_t133 r0 *1 0,0
Ra_d_inv_clk_vdd_inv_mc_vdd_inv_q_vdd_mpa_py_mpb_py_nand_m_vdd_nand_s2_vdd_nwell_vdd_sb_vdd_sr1_vdd_sr2_vdd_sr3_vdd_sr4_vdd_sv_d_vdd_tie_sv_vdd_tg_d_a_tg_d_vdd_tg_fbm_vdd_tg_fbs_vdd_tg_s_vdd_vdd_vdd_b1_vdd_b2_vdd_b3_vdd_b4_vdd_link_vdd_link_dip_vdd_x1_vdd_x2_vdd_x3_t133
+ a\x7cd\x7cinv_clk_vdd\x7cinv_mc_vdd\x7cinv_q_vdd\x7cmpa_py\x7cmpb_py\x7cnand_m_vdd\x7cnand_s2_vdd\x7cnwell_vdd\x7csb_vdd\x7csr1_vdd\x7csr2_vdd\x7csr3_vdd\x7csr4_vdd\x7csv_d_vdd_tie\x7csv_vdd\x7ctg_d_a\x7ctg_d_vdd\x7ctg_fbm_vdd\x7ctg_fbs_vdd\x7ctg_s_vdd\x7cvdd\x7cvdd_b1\x7cvdd_b2\x7cvdd_b3\x7cvdd_b4\x7cvdd_link\x7cvdd_link_dip\x7cvdd_x1\x7cvdd_x2\x7cvdd_x3__t133
+ a|d|inv_clk_vdd|inv_mc_vdd|inv_q_vdd|mpa_py|mpb_py|nand_m_vdd|nand_s2_vdd|nwell_vdd|sb_vdd|sr1_vdd|sr2_vdd|sr3_vdd|sr4_vdd|sv_d_vdd_tie|sv_vdd|tg_d_a|tg_d_vdd|tg_fbm_vdd|tg_fbs_vdd|tg_s_vdd|vdd|vdd_b1|vdd_b2|vdd_b3|vdd_b4|vdd_link|vdd_link_dip|vdd_x1|vdd_x2|vdd_x3
+ 52.99681623
* device instance a_d_inv_clk_vdd_inv_mc_vdd_inv_q_vdd_mpa_py_mpb_py_nand_m_vdd_nand_s2_vdd_nwell_vdd_sb_vdd_sr1_vdd_sr2_vdd_sr3_vdd_sr4_vdd_sv_d_vdd_tie_sv_vdd_tg_d_a_tg_d_vdd_tg_fbm_vdd_tg_fbs_vdd_tg_s_vdd_vdd_vdd_b1_vdd_b2_vdd_b3_vdd_b4_vdd_link_vdd_link_dip_vdd_x1_vdd_x2_vdd_x3_t134 r0 *1 0,0
Ra_d_inv_clk_vdd_inv_mc_vdd_inv_q_vdd_mpa_py_mpb_py_nand_m_vdd_nand_s2_vdd_nwell_vdd_sb_vdd_sr1_vdd_sr2_vdd_sr3_vdd_sr4_vdd_sv_d_vdd_tie_sv_vdd_tg_d_a_tg_d_vdd_tg_fbm_vdd_tg_fbs_vdd_tg_s_vdd_vdd_vdd_b1_vdd_b2_vdd_b3_vdd_b4_vdd_link_vdd_link_dip_vdd_x1_vdd_x2_vdd_x3_t134
+ a\x7cd\x7cinv_clk_vdd\x7cinv_mc_vdd\x7cinv_q_vdd\x7cmpa_py\x7cmpb_py\x7cnand_m_vdd\x7cnand_s2_vdd\x7cnwell_vdd\x7csb_vdd\x7csr1_vdd\x7csr2_vdd\x7csr3_vdd\x7csr4_vdd\x7csv_d_vdd_tie\x7csv_vdd\x7ctg_d_a\x7ctg_d_vdd\x7ctg_fbm_vdd\x7ctg_fbs_vdd\x7ctg_s_vdd\x7cvdd\x7cvdd_b1\x7cvdd_b2\x7cvdd_b3\x7cvdd_b4\x7cvdd_link\x7cvdd_link_dip\x7cvdd_x1\x7cvdd_x2\x7cvdd_x3__t134
+ a|d|inv_clk_vdd|inv_mc_vdd|inv_q_vdd|mpa_py|mpb_py|nand_m_vdd|nand_s2_vdd|nwell_vdd|sb_vdd|sr1_vdd|sr2_vdd|sr3_vdd|sr4_vdd|sv_d_vdd_tie|sv_vdd|tg_d_a|tg_d_vdd|tg_fbm_vdd|tg_fbs_vdd|tg_s_vdd|vdd|vdd_b1|vdd_b2|vdd_b3|vdd_b4|vdd_link|vdd_link_dip|vdd_x1|vdd_x2|vdd_x3
+ 61.6014949214
* device instance a_d_inv_clk_vdd_inv_mc_vdd_inv_q_vdd_mpa_py_mpb_py_nand_m_vdd_nand_s2_vdd_nwell_vdd_sb_vdd_sr1_vdd_sr2_vdd_sr3_vdd_sr4_vdd_sv_d_vdd_tie_sv_vdd_tg_d_a_tg_d_vdd_tg_fbm_vdd_tg_fbs_vdd_tg_s_vdd_vdd_vdd_b1_vdd_b2_vdd_b3_vdd_b4_vdd_link_vdd_link_dip_vdd_x1_vdd_x2_vdd_x3_t135 r0 *1 0,0
Ra_d_inv_clk_vdd_inv_mc_vdd_inv_q_vdd_mpa_py_mpb_py_nand_m_vdd_nand_s2_vdd_nwell_vdd_sb_vdd_sr1_vdd_sr2_vdd_sr3_vdd_sr4_vdd_sv_d_vdd_tie_sv_vdd_tg_d_a_tg_d_vdd_tg_fbm_vdd_tg_fbs_vdd_tg_s_vdd_vdd_vdd_b1_vdd_b2_vdd_b3_vdd_b4_vdd_link_vdd_link_dip_vdd_x1_vdd_x2_vdd_x3_t135
+ a\x7cd\x7cinv_clk_vdd\x7cinv_mc_vdd\x7cinv_q_vdd\x7cmpa_py\x7cmpb_py\x7cnand_m_vdd\x7cnand_s2_vdd\x7cnwell_vdd\x7csb_vdd\x7csr1_vdd\x7csr2_vdd\x7csr3_vdd\x7csr4_vdd\x7csv_d_vdd_tie\x7csv_vdd\x7ctg_d_a\x7ctg_d_vdd\x7ctg_fbm_vdd\x7ctg_fbs_vdd\x7ctg_s_vdd\x7cvdd\x7cvdd_b1\x7cvdd_b2\x7cvdd_b3\x7cvdd_b4\x7cvdd_link\x7cvdd_link_dip\x7cvdd_x1\x7cvdd_x2\x7cvdd_x3__t135
+ a|d|inv_clk_vdd|inv_mc_vdd|inv_q_vdd|mpa_py|mpb_py|nand_m_vdd|nand_s2_vdd|nwell_vdd|sb_vdd|sr1_vdd|sr2_vdd|sr3_vdd|sr4_vdd|sv_d_vdd_tie|sv_vdd|tg_d_a|tg_d_vdd|tg_fbm_vdd|tg_fbs_vdd|tg_s_vdd|vdd|vdd_b1|vdd_b2|vdd_b3|vdd_b4|vdd_link|vdd_link_dip|vdd_x1|vdd_x2|vdd_x3
+ 18.0086224576
* device instance a_d_inv_clk_vdd_inv_mc_vdd_inv_q_vdd_mpa_py_mpb_py_nand_m_vdd_nand_s2_vdd_nwell_vdd_sb_vdd_sr1_vdd_sr2_vdd_sr3_vdd_sr4_vdd_sv_d_vdd_tie_sv_vdd_tg_d_a_tg_d_vdd_tg_fbm_vdd_tg_fbs_vdd_tg_s_vdd_vdd_vdd_b1_vdd_b2_vdd_b3_vdd_b4_vdd_link_vdd_link_dip_vdd_x1_vdd_x2_vdd_x3_t136 r0 *1 0,0
Ra_d_inv_clk_vdd_inv_mc_vdd_inv_q_vdd_mpa_py_mpb_py_nand_m_vdd_nand_s2_vdd_nwell_vdd_sb_vdd_sr1_vdd_sr2_vdd_sr3_vdd_sr4_vdd_sv_d_vdd_tie_sv_vdd_tg_d_a_tg_d_vdd_tg_fbm_vdd_tg_fbs_vdd_tg_s_vdd_vdd_vdd_b1_vdd_b2_vdd_b3_vdd_b4_vdd_link_vdd_link_dip_vdd_x1_vdd_x2_vdd_x3_t136
+ a\x7cd\x7cinv_clk_vdd\x7cinv_mc_vdd\x7cinv_q_vdd\x7cmpa_py\x7cmpb_py\x7cnand_m_vdd\x7cnand_s2_vdd\x7cnwell_vdd\x7csb_vdd\x7csr1_vdd\x7csr2_vdd\x7csr3_vdd\x7csr4_vdd\x7csv_d_vdd_tie\x7csv_vdd\x7ctg_d_a\x7ctg_d_vdd\x7ctg_fbm_vdd\x7ctg_fbs_vdd\x7ctg_s_vdd\x7cvdd\x7cvdd_b1\x7cvdd_b2\x7cvdd_b3\x7cvdd_b4\x7cvdd_link\x7cvdd_link_dip\x7cvdd_x1\x7cvdd_x2\x7cvdd_x3__t136
+ a|d|inv_clk_vdd|inv_mc_vdd|inv_q_vdd|mpa_py|mpb_py|nand_m_vdd|nand_s2_vdd|nwell_vdd|sb_vdd|sr1_vdd|sr2_vdd|sr3_vdd|sr4_vdd|sv_d_vdd_tie|sv_vdd|tg_d_a|tg_d_vdd|tg_fbm_vdd|tg_fbs_vdd|tg_s_vdd|vdd|vdd_b1|vdd_b2|vdd_b3|vdd_b4|vdd_link|vdd_link_dip|vdd_x1|vdd_x2|vdd_x3
+ 41.7094691189
* device instance a_d_inv_clk_vdd_inv_mc_vdd_inv_q_vdd_mpa_py_mpb_py_nand_m_vdd_nand_s2_vdd_nwell_vdd_sb_vdd_sr1_vdd_sr2_vdd_sr3_vdd_sr4_vdd_sv_d_vdd_tie_sv_vdd_tg_d_a_tg_d_vdd_tg_fbm_vdd_tg_fbs_vdd_tg_s_vdd_vdd_vdd_b1_vdd_b2_vdd_b3_vdd_b4_vdd_link_vdd_link_dip_vdd_x1_vdd_x2_vdd_x3_t137 r0 *1 0,0
Ra_d_inv_clk_vdd_inv_mc_vdd_inv_q_vdd_mpa_py_mpb_py_nand_m_vdd_nand_s2_vdd_nwell_vdd_sb_vdd_sr1_vdd_sr2_vdd_sr3_vdd_sr4_vdd_sv_d_vdd_tie_sv_vdd_tg_d_a_tg_d_vdd_tg_fbm_vdd_tg_fbs_vdd_tg_s_vdd_vdd_vdd_b1_vdd_b2_vdd_b3_vdd_b4_vdd_link_vdd_link_dip_vdd_x1_vdd_x2_vdd_x3_t137
+ a\x7cd\x7cinv_clk_vdd\x7cinv_mc_vdd\x7cinv_q_vdd\x7cmpa_py\x7cmpb_py\x7cnand_m_vdd\x7cnand_s2_vdd\x7cnwell_vdd\x7csb_vdd\x7csr1_vdd\x7csr2_vdd\x7csr3_vdd\x7csr4_vdd\x7csv_d_vdd_tie\x7csv_vdd\x7ctg_d_a\x7ctg_d_vdd\x7ctg_fbm_vdd\x7ctg_fbs_vdd\x7ctg_s_vdd\x7cvdd\x7cvdd_b1\x7cvdd_b2\x7cvdd_b3\x7cvdd_b4\x7cvdd_link\x7cvdd_link_dip\x7cvdd_x1\x7cvdd_x2\x7cvdd_x3__t137
+ a|d|inv_clk_vdd|inv_mc_vdd|inv_q_vdd|mpa_py|mpb_py|nand_m_vdd|nand_s2_vdd|nwell_vdd|sb_vdd|sr1_vdd|sr2_vdd|sr3_vdd|sr4_vdd|sv_d_vdd_tie|sv_vdd|tg_d_a|tg_d_vdd|tg_fbm_vdd|tg_fbs_vdd|tg_s_vdd|vdd|vdd_b1|vdd_b2|vdd_b3|vdd_b4|vdd_link|vdd_link_dip|vdd_x1|vdd_x2|vdd_x3
+ 71.6338596465
* device instance a_d_inv_clk_vdd_inv_mc_vdd_inv_q_vdd_mpa_py_mpb_py_nand_m_vdd_nand_s2_vdd_nwell_vdd_sb_vdd_sr1_vdd_sr2_vdd_sr3_vdd_sr4_vdd_sv_d_vdd_tie_sv_vdd_tg_d_a_tg_d_vdd_tg_fbm_vdd_tg_fbs_vdd_tg_s_vdd_vdd_vdd_b1_vdd_b2_vdd_b3_vdd_b4_vdd_link_vdd_link_dip_vdd_x1_vdd_x2_vdd_x3_t138 r0 *1 0,0
Ra_d_inv_clk_vdd_inv_mc_vdd_inv_q_vdd_mpa_py_mpb_py_nand_m_vdd_nand_s2_vdd_nwell_vdd_sb_vdd_sr1_vdd_sr2_vdd_sr3_vdd_sr4_vdd_sv_d_vdd_tie_sv_vdd_tg_d_a_tg_d_vdd_tg_fbm_vdd_tg_fbs_vdd_tg_s_vdd_vdd_vdd_b1_vdd_b2_vdd_b3_vdd_b4_vdd_link_vdd_link_dip_vdd_x1_vdd_x2_vdd_x3_t138
+ a\x7cd\x7cinv_clk_vdd\x7cinv_mc_vdd\x7cinv_q_vdd\x7cmpa_py\x7cmpb_py\x7cnand_m_vdd\x7cnand_s2_vdd\x7cnwell_vdd\x7csb_vdd\x7csr1_vdd\x7csr2_vdd\x7csr3_vdd\x7csr4_vdd\x7csv_d_vdd_tie\x7csv_vdd\x7ctg_d_a\x7ctg_d_vdd\x7ctg_fbm_vdd\x7ctg_fbs_vdd\x7ctg_s_vdd\x7cvdd\x7cvdd_b1\x7cvdd_b2\x7cvdd_b3\x7cvdd_b4\x7cvdd_link\x7cvdd_link_dip\x7cvdd_x1\x7cvdd_x2\x7cvdd_x3__t138
+ a|d|inv_clk_vdd|inv_mc_vdd|inv_q_vdd|mpa_py|mpb_py|nand_m_vdd|nand_s2_vdd|nwell_vdd|sb_vdd|sr1_vdd|sr2_vdd|sr3_vdd|sr4_vdd|sv_d_vdd_tie|sv_vdd|tg_d_a|tg_d_vdd|tg_fbm_vdd|tg_fbs_vdd|tg_s_vdd|vdd|vdd_b1|vdd_b2|vdd_b3|vdd_b4|vdd_link|vdd_link_dip|vdd_x1|vdd_x2|vdd_x3
+ 170.781439528
* device instance a_d_inv_clk_vdd_inv_mc_vdd_inv_q_vdd_mpa_py_mpb_py_nand_m_vdd_nand_s2_vdd_nwell_vdd_sb_vdd_sr1_vdd_sr2_vdd_sr3_vdd_sr4_vdd_sv_d_vdd_tie_sv_vdd_tg_d_a_tg_d_vdd_tg_fbm_vdd_tg_fbs_vdd_tg_s_vdd_vdd_vdd_b1_vdd_b2_vdd_b3_vdd_b4_vdd_link_vdd_link_dip_vdd_x1_vdd_x2_vdd_x3_t139 r0 *1 0,0
Ra_d_inv_clk_vdd_inv_mc_vdd_inv_q_vdd_mpa_py_mpb_py_nand_m_vdd_nand_s2_vdd_nwell_vdd_sb_vdd_sr1_vdd_sr2_vdd_sr3_vdd_sr4_vdd_sv_d_vdd_tie_sv_vdd_tg_d_a_tg_d_vdd_tg_fbm_vdd_tg_fbs_vdd_tg_s_vdd_vdd_vdd_b1_vdd_b2_vdd_b3_vdd_b4_vdd_link_vdd_link_dip_vdd_x1_vdd_x2_vdd_x3_t139
+ a\x7cd\x7cinv_clk_vdd\x7cinv_mc_vdd\x7cinv_q_vdd\x7cmpa_py\x7cmpb_py\x7cnand_m_vdd\x7cnand_s2_vdd\x7cnwell_vdd\x7csb_vdd\x7csr1_vdd\x7csr2_vdd\x7csr3_vdd\x7csr4_vdd\x7csv_d_vdd_tie\x7csv_vdd\x7ctg_d_a\x7ctg_d_vdd\x7ctg_fbm_vdd\x7ctg_fbs_vdd\x7ctg_s_vdd\x7cvdd\x7cvdd_b1\x7cvdd_b2\x7cvdd_b3\x7cvdd_b4\x7cvdd_link\x7cvdd_link_dip\x7cvdd_x1\x7cvdd_x2\x7cvdd_x3__t139
+ a|d|inv_clk_vdd|inv_mc_vdd|inv_q_vdd|mpa_py|mpb_py|nand_m_vdd|nand_s2_vdd|nwell_vdd|sb_vdd|sr1_vdd|sr2_vdd|sr3_vdd|sr4_vdd|sv_d_vdd_tie|sv_vdd|tg_d_a|tg_d_vdd|tg_fbm_vdd|tg_fbs_vdd|tg_s_vdd|vdd|vdd_b1|vdd_b2|vdd_b3|vdd_b4|vdd_link|vdd_link_dip|vdd_x1|vdd_x2|vdd_x3
+ 140.176916225
* device instance a_d_inv_clk_vdd_inv_mc_vdd_inv_q_vdd_mpa_py_mpb_py_nand_m_vdd_nand_s2_vdd_nwell_vdd_sb_vdd_sr1_vdd_sr2_vdd_sr3_vdd_sr4_vdd_sv_d_vdd_tie_sv_vdd_tg_d_a_tg_d_vdd_tg_fbm_vdd_tg_fbs_vdd_tg_s_vdd_vdd_vdd_b1_vdd_b2_vdd_b3_vdd_b4_vdd_link_vdd_link_dip_vdd_x1_vdd_x2_vdd_x3_t140 r0 *1 0,0
Ra_d_inv_clk_vdd_inv_mc_vdd_inv_q_vdd_mpa_py_mpb_py_nand_m_vdd_nand_s2_vdd_nwell_vdd_sb_vdd_sr1_vdd_sr2_vdd_sr3_vdd_sr4_vdd_sv_d_vdd_tie_sv_vdd_tg_d_a_tg_d_vdd_tg_fbm_vdd_tg_fbs_vdd_tg_s_vdd_vdd_vdd_b1_vdd_b2_vdd_b3_vdd_b4_vdd_link_vdd_link_dip_vdd_x1_vdd_x2_vdd_x3_t140
+ a\x7cd\x7cinv_clk_vdd\x7cinv_mc_vdd\x7cinv_q_vdd\x7cmpa_py\x7cmpb_py\x7cnand_m_vdd\x7cnand_s2_vdd\x7cnwell_vdd\x7csb_vdd\x7csr1_vdd\x7csr2_vdd\x7csr3_vdd\x7csr4_vdd\x7csv_d_vdd_tie\x7csv_vdd\x7ctg_d_a\x7ctg_d_vdd\x7ctg_fbm_vdd\x7ctg_fbs_vdd\x7ctg_s_vdd\x7cvdd\x7cvdd_b1\x7cvdd_b2\x7cvdd_b3\x7cvdd_b4\x7cvdd_link\x7cvdd_link_dip\x7cvdd_x1\x7cvdd_x2\x7cvdd_x3__t140
+ a|d|inv_clk_vdd|inv_mc_vdd|inv_q_vdd|mpa_py|mpb_py|nand_m_vdd|nand_s2_vdd|nwell_vdd|sb_vdd|sr1_vdd|sr2_vdd|sr3_vdd|sr4_vdd|sv_d_vdd_tie|sv_vdd|tg_d_a|tg_d_vdd|tg_fbm_vdd|tg_fbs_vdd|tg_s_vdd|vdd|vdd_b1|vdd_b2|vdd_b3|vdd_b4|vdd_link|vdd_link_dip|vdd_x1|vdd_x2|vdd_x3
+ 33.3893566304
* device instance a_d_inv_clk_vdd_inv_mc_vdd_inv_q_vdd_mpa_py_mpb_py_nand_m_vdd_nand_s2_vdd_nwell_vdd_sb_vdd_sr1_vdd_sr2_vdd_sr3_vdd_sr4_vdd_sv_d_vdd_tie_sv_vdd_tg_d_a_tg_d_vdd_tg_fbm_vdd_tg_fbs_vdd_tg_s_vdd_vdd_vdd_b1_vdd_b2_vdd_b3_vdd_b4_vdd_link_vdd_link_dip_vdd_x1_vdd_x2_vdd_x3_t141 r0 *1 0,0
Ra_d_inv_clk_vdd_inv_mc_vdd_inv_q_vdd_mpa_py_mpb_py_nand_m_vdd_nand_s2_vdd_nwell_vdd_sb_vdd_sr1_vdd_sr2_vdd_sr3_vdd_sr4_vdd_sv_d_vdd_tie_sv_vdd_tg_d_a_tg_d_vdd_tg_fbm_vdd_tg_fbs_vdd_tg_s_vdd_vdd_vdd_b1_vdd_b2_vdd_b3_vdd_b4_vdd_link_vdd_link_dip_vdd_x1_vdd_x2_vdd_x3_t141
+ a\x7cd\x7cinv_clk_vdd\x7cinv_mc_vdd\x7cinv_q_vdd\x7cmpa_py\x7cmpb_py\x7cnand_m_vdd\x7cnand_s2_vdd\x7cnwell_vdd\x7csb_vdd\x7csr1_vdd\x7csr2_vdd\x7csr3_vdd\x7csr4_vdd\x7csv_d_vdd_tie\x7csv_vdd\x7ctg_d_a\x7ctg_d_vdd\x7ctg_fbm_vdd\x7ctg_fbs_vdd\x7ctg_s_vdd\x7cvdd\x7cvdd_b1\x7cvdd_b2\x7cvdd_b3\x7cvdd_b4\x7cvdd_link\x7cvdd_link_dip\x7cvdd_x1\x7cvdd_x2\x7cvdd_x3__t141
+ a|d|inv_clk_vdd|inv_mc_vdd|inv_q_vdd|mpa_py|mpb_py|nand_m_vdd|nand_s2_vdd|nwell_vdd|sb_vdd|sr1_vdd|sr2_vdd|sr3_vdd|sr4_vdd|sv_d_vdd_tie|sv_vdd|tg_d_a|tg_d_vdd|tg_fbm_vdd|tg_fbs_vdd|tg_s_vdd|vdd|vdd_b1|vdd_b2|vdd_b3|vdd_b4|vdd_link|vdd_link_dip|vdd_x1|vdd_x2|vdd_x3
+ 25.5453177452
* device instance a_d_inv_clk_vdd_inv_mc_vdd_inv_q_vdd_mpa_py_mpb_py_nand_m_vdd_nand_s2_vdd_nwell_vdd_sb_vdd_sr1_vdd_sr2_vdd_sr3_vdd_sr4_vdd_sv_d_vdd_tie_sv_vdd_tg_d_a_tg_d_vdd_tg_fbm_vdd_tg_fbs_vdd_tg_s_vdd_vdd_vdd_b1_vdd_b2_vdd_b3_vdd_b4_vdd_link_vdd_link_dip_vdd_x1_vdd_x2_vdd_x3_t142 r0 *1 0,0
Ra_d_inv_clk_vdd_inv_mc_vdd_inv_q_vdd_mpa_py_mpb_py_nand_m_vdd_nand_s2_vdd_nwell_vdd_sb_vdd_sr1_vdd_sr2_vdd_sr3_vdd_sr4_vdd_sv_d_vdd_tie_sv_vdd_tg_d_a_tg_d_vdd_tg_fbm_vdd_tg_fbs_vdd_tg_s_vdd_vdd_vdd_b1_vdd_b2_vdd_b3_vdd_b4_vdd_link_vdd_link_dip_vdd_x1_vdd_x2_vdd_x3_t142
+ a\x7cd\x7cinv_clk_vdd\x7cinv_mc_vdd\x7cinv_q_vdd\x7cmpa_py\x7cmpb_py\x7cnand_m_vdd\x7cnand_s2_vdd\x7cnwell_vdd\x7csb_vdd\x7csr1_vdd\x7csr2_vdd\x7csr3_vdd\x7csr4_vdd\x7csv_d_vdd_tie\x7csv_vdd\x7ctg_d_a\x7ctg_d_vdd\x7ctg_fbm_vdd\x7ctg_fbs_vdd\x7ctg_s_vdd\x7cvdd\x7cvdd_b1\x7cvdd_b2\x7cvdd_b3\x7cvdd_b4\x7cvdd_link\x7cvdd_link_dip\x7cvdd_x1\x7cvdd_x2\x7cvdd_x3__t142
+ a|d|inv_clk_vdd|inv_mc_vdd|inv_q_vdd|mpa_py|mpb_py|nand_m_vdd|nand_s2_vdd|nwell_vdd|sb_vdd|sr1_vdd|sr2_vdd|sr3_vdd|sr4_vdd|sv_d_vdd_tie|sv_vdd|tg_d_a|tg_d_vdd|tg_fbm_vdd|tg_fbs_vdd|tg_s_vdd|vdd|vdd_b1|vdd_b2|vdd_b3|vdd_b4|vdd_link|vdd_link_dip|vdd_x1|vdd_x2|vdd_x3
+ 198.175103284
* device instance a_d_inv_clk_vdd_inv_mc_vdd_inv_q_vdd_mpa_py_mpb_py_nand_m_vdd_nand_s2_vdd_nwell_vdd_sb_vdd_sr1_vdd_sr2_vdd_sr3_vdd_sr4_vdd_sv_d_vdd_tie_sv_vdd_tg_d_a_tg_d_vdd_tg_fbm_vdd_tg_fbs_vdd_tg_s_vdd_vdd_vdd_b1_vdd_b2_vdd_b3_vdd_b4_vdd_link_vdd_link_dip_vdd_x1_vdd_x2_vdd_x3_t143 r0 *1 0,0
Ra_d_inv_clk_vdd_inv_mc_vdd_inv_q_vdd_mpa_py_mpb_py_nand_m_vdd_nand_s2_vdd_nwell_vdd_sb_vdd_sr1_vdd_sr2_vdd_sr3_vdd_sr4_vdd_sv_d_vdd_tie_sv_vdd_tg_d_a_tg_d_vdd_tg_fbm_vdd_tg_fbs_vdd_tg_s_vdd_vdd_vdd_b1_vdd_b2_vdd_b3_vdd_b4_vdd_link_vdd_link_dip_vdd_x1_vdd_x2_vdd_x3_t143
+ a\x7cd\x7cinv_clk_vdd\x7cinv_mc_vdd\x7cinv_q_vdd\x7cmpa_py\x7cmpb_py\x7cnand_m_vdd\x7cnand_s2_vdd\x7cnwell_vdd\x7csb_vdd\x7csr1_vdd\x7csr2_vdd\x7csr3_vdd\x7csr4_vdd\x7csv_d_vdd_tie\x7csv_vdd\x7ctg_d_a\x7ctg_d_vdd\x7ctg_fbm_vdd\x7ctg_fbs_vdd\x7ctg_s_vdd\x7cvdd\x7cvdd_b1\x7cvdd_b2\x7cvdd_b3\x7cvdd_b4\x7cvdd_link\x7cvdd_link_dip\x7cvdd_x1\x7cvdd_x2\x7cvdd_x3__t143
+ a|d|inv_clk_vdd|inv_mc_vdd|inv_q_vdd|mpa_py|mpb_py|nand_m_vdd|nand_s2_vdd|nwell_vdd|sb_vdd|sr1_vdd|sr2_vdd|sr3_vdd|sr4_vdd|sv_d_vdd_tie|sv_vdd|tg_d_a|tg_d_vdd|tg_fbm_vdd|tg_fbs_vdd|tg_s_vdd|vdd|vdd_b1|vdd_b2|vdd_b3|vdd_b4|vdd_link|vdd_link_dip|vdd_x1|vdd_x2|vdd_x3
+ 25.089796295
* device instance a_d_inv_clk_vdd_inv_mc_vdd_inv_q_vdd_mpa_py_mpb_py_nand_m_vdd_nand_s2_vdd_nwell_vdd_sb_vdd_sr1_vdd_sr2_vdd_sr3_vdd_sr4_vdd_sv_d_vdd_tie_sv_vdd_tg_d_a_tg_d_vdd_tg_fbm_vdd_tg_fbs_vdd_tg_s_vdd_vdd_vdd_b1_vdd_b2_vdd_b3_vdd_b4_vdd_link_vdd_link_dip_vdd_x1_vdd_x2_vdd_x3_t144 r0 *1 0,0
Ra_d_inv_clk_vdd_inv_mc_vdd_inv_q_vdd_mpa_py_mpb_py_nand_m_vdd_nand_s2_vdd_nwell_vdd_sb_vdd_sr1_vdd_sr2_vdd_sr3_vdd_sr4_vdd_sv_d_vdd_tie_sv_vdd_tg_d_a_tg_d_vdd_tg_fbm_vdd_tg_fbs_vdd_tg_s_vdd_vdd_vdd_b1_vdd_b2_vdd_b3_vdd_b4_vdd_link_vdd_link_dip_vdd_x1_vdd_x2_vdd_x3_t144
+ a\x7cd\x7cinv_clk_vdd\x7cinv_mc_vdd\x7cinv_q_vdd\x7cmpa_py\x7cmpb_py\x7cnand_m_vdd\x7cnand_s2_vdd\x7cnwell_vdd\x7csb_vdd\x7csr1_vdd\x7csr2_vdd\x7csr3_vdd\x7csr4_vdd\x7csv_d_vdd_tie\x7csv_vdd\x7ctg_d_a\x7ctg_d_vdd\x7ctg_fbm_vdd\x7ctg_fbs_vdd\x7ctg_s_vdd\x7cvdd\x7cvdd_b1\x7cvdd_b2\x7cvdd_b3\x7cvdd_b4\x7cvdd_link\x7cvdd_link_dip\x7cvdd_x1\x7cvdd_x2\x7cvdd_x3__t144
+ a|d|inv_clk_vdd|inv_mc_vdd|inv_q_vdd|mpa_py|mpb_py|nand_m_vdd|nand_s2_vdd|nwell_vdd|sb_vdd|sr1_vdd|sr2_vdd|sr3_vdd|sr4_vdd|sv_d_vdd_tie|sv_vdd|tg_d_a|tg_d_vdd|tg_fbm_vdd|tg_fbs_vdd|tg_s_vdd|vdd|vdd_b1|vdd_b2|vdd_b3|vdd_b4|vdd_link|vdd_link_dip|vdd_x1|vdd_x2|vdd_x3
+ 109.084868354
* device instance a_d_inv_clk_vdd_inv_mc_vdd_inv_q_vdd_mpa_py_mpb_py_nand_m_vdd_nand_s2_vdd_nwell_vdd_sb_vdd_sr1_vdd_sr2_vdd_sr3_vdd_sr4_vdd_sv_d_vdd_tie_sv_vdd_tg_d_a_tg_d_vdd_tg_fbm_vdd_tg_fbs_vdd_tg_s_vdd_vdd_vdd_b1_vdd_b2_vdd_b3_vdd_b4_vdd_link_vdd_link_dip_vdd_x1_vdd_x2_vdd_x3_t145 r0 *1 0,0
Ra_d_inv_clk_vdd_inv_mc_vdd_inv_q_vdd_mpa_py_mpb_py_nand_m_vdd_nand_s2_vdd_nwell_vdd_sb_vdd_sr1_vdd_sr2_vdd_sr3_vdd_sr4_vdd_sv_d_vdd_tie_sv_vdd_tg_d_a_tg_d_vdd_tg_fbm_vdd_tg_fbs_vdd_tg_s_vdd_vdd_vdd_b1_vdd_b2_vdd_b3_vdd_b4_vdd_link_vdd_link_dip_vdd_x1_vdd_x2_vdd_x3_t145
+ a\x7cd\x7cinv_clk_vdd\x7cinv_mc_vdd\x7cinv_q_vdd\x7cmpa_py\x7cmpb_py\x7cnand_m_vdd\x7cnand_s2_vdd\x7cnwell_vdd\x7csb_vdd\x7csr1_vdd\x7csr2_vdd\x7csr3_vdd\x7csr4_vdd\x7csv_d_vdd_tie\x7csv_vdd\x7ctg_d_a\x7ctg_d_vdd\x7ctg_fbm_vdd\x7ctg_fbs_vdd\x7ctg_s_vdd\x7cvdd\x7cvdd_b1\x7cvdd_b2\x7cvdd_b3\x7cvdd_b4\x7cvdd_link\x7cvdd_link_dip\x7cvdd_x1\x7cvdd_x2\x7cvdd_x3__t145
+ a|d|inv_clk_vdd|inv_mc_vdd|inv_q_vdd|mpa_py|mpb_py|nand_m_vdd|nand_s2_vdd|nwell_vdd|sb_vdd|sr1_vdd|sr2_vdd|sr3_vdd|sr4_vdd|sv_d_vdd_tie|sv_vdd|tg_d_a|tg_d_vdd|tg_fbm_vdd|tg_fbs_vdd|tg_s_vdd|vdd|vdd_b1|vdd_b2|vdd_b3|vdd_b4|vdd_link|vdd_link_dip|vdd_x1|vdd_x2|vdd_x3
+ 149.152813625
* device instance a_d_inv_clk_vdd_inv_mc_vdd_inv_q_vdd_mpa_py_mpb_py_nand_m_vdd_nand_s2_vdd_nwell_vdd_sb_vdd_sr1_vdd_sr2_vdd_sr3_vdd_sr4_vdd_sv_d_vdd_tie_sv_vdd_tg_d_a_tg_d_vdd_tg_fbm_vdd_tg_fbs_vdd_tg_s_vdd_vdd_vdd_b1_vdd_b2_vdd_b3_vdd_b4_vdd_link_vdd_link_dip_vdd_x1_vdd_x2_vdd_x3_t146 r0 *1 0,0
Ra_d_inv_clk_vdd_inv_mc_vdd_inv_q_vdd_mpa_py_mpb_py_nand_m_vdd_nand_s2_vdd_nwell_vdd_sb_vdd_sr1_vdd_sr2_vdd_sr3_vdd_sr4_vdd_sv_d_vdd_tie_sv_vdd_tg_d_a_tg_d_vdd_tg_fbm_vdd_tg_fbs_vdd_tg_s_vdd_vdd_vdd_b1_vdd_b2_vdd_b3_vdd_b4_vdd_link_vdd_link_dip_vdd_x1_vdd_x2_vdd_x3_t146
+ a\x7cd\x7cinv_clk_vdd\x7cinv_mc_vdd\x7cinv_q_vdd\x7cmpa_py\x7cmpb_py\x7cnand_m_vdd\x7cnand_s2_vdd\x7cnwell_vdd\x7csb_vdd\x7csr1_vdd\x7csr2_vdd\x7csr3_vdd\x7csr4_vdd\x7csv_d_vdd_tie\x7csv_vdd\x7ctg_d_a\x7ctg_d_vdd\x7ctg_fbm_vdd\x7ctg_fbs_vdd\x7ctg_s_vdd\x7cvdd\x7cvdd_b1\x7cvdd_b2\x7cvdd_b3\x7cvdd_b4\x7cvdd_link\x7cvdd_link_dip\x7cvdd_x1\x7cvdd_x2\x7cvdd_x3__t146
+ a|d|inv_clk_vdd|inv_mc_vdd|inv_q_vdd|mpa_py|mpb_py|nand_m_vdd|nand_s2_vdd|nwell_vdd|sb_vdd|sr1_vdd|sr2_vdd|sr3_vdd|sr4_vdd|sv_d_vdd_tie|sv_vdd|tg_d_a|tg_d_vdd|tg_fbm_vdd|tg_fbs_vdd|tg_s_vdd|vdd|vdd_b1|vdd_b2|vdd_b3|vdd_b4|vdd_link|vdd_link_dip|vdd_x1|vdd_x2|vdd_x3
+ 82.8211566405
* device instance a_d_inv_clk_vdd_inv_mc_vdd_inv_q_vdd_mpa_py_mpb_py_nand_m_vdd_nand_s2_vdd_nwell_vdd_sb_vdd_sr1_vdd_sr2_vdd_sr3_vdd_sr4_vdd_sv_d_vdd_tie_sv_vdd_tg_d_a_tg_d_vdd_tg_fbm_vdd_tg_fbs_vdd_tg_s_vdd_vdd_vdd_b1_vdd_b2_vdd_b3_vdd_b4_vdd_link_vdd_link_dip_vdd_x1_vdd_x2_vdd_x3_t147 r0 *1 0,0
Ra_d_inv_clk_vdd_inv_mc_vdd_inv_q_vdd_mpa_py_mpb_py_nand_m_vdd_nand_s2_vdd_nwell_vdd_sb_vdd_sr1_vdd_sr2_vdd_sr3_vdd_sr4_vdd_sv_d_vdd_tie_sv_vdd_tg_d_a_tg_d_vdd_tg_fbm_vdd_tg_fbs_vdd_tg_s_vdd_vdd_vdd_b1_vdd_b2_vdd_b3_vdd_b4_vdd_link_vdd_link_dip_vdd_x1_vdd_x2_vdd_x3_t147
+ a\x7cd\x7cinv_clk_vdd\x7cinv_mc_vdd\x7cinv_q_vdd\x7cmpa_py\x7cmpb_py\x7cnand_m_vdd\x7cnand_s2_vdd\x7cnwell_vdd\x7csb_vdd\x7csr1_vdd\x7csr2_vdd\x7csr3_vdd\x7csr4_vdd\x7csv_d_vdd_tie\x7csv_vdd\x7ctg_d_a\x7ctg_d_vdd\x7ctg_fbm_vdd\x7ctg_fbs_vdd\x7ctg_s_vdd\x7cvdd\x7cvdd_b1\x7cvdd_b2\x7cvdd_b3\x7cvdd_b4\x7cvdd_link\x7cvdd_link_dip\x7cvdd_x1\x7cvdd_x2\x7cvdd_x3__t147
+ a|d|inv_clk_vdd|inv_mc_vdd|inv_q_vdd|mpa_py|mpb_py|nand_m_vdd|nand_s2_vdd|nwell_vdd|sb_vdd|sr1_vdd|sr2_vdd|sr3_vdd|sr4_vdd|sv_d_vdd_tie|sv_vdd|tg_d_a|tg_d_vdd|tg_fbm_vdd|tg_fbs_vdd|tg_s_vdd|vdd|vdd_b1|vdd_b2|vdd_b3|vdd_b4|vdd_link|vdd_link_dip|vdd_x1|vdd_x2|vdd_x3
+ 109.895432628
* device instance a_d_inv_clk_vdd_inv_mc_vdd_inv_q_vdd_mpa_py_mpb_py_nand_m_vdd_nand_s2_vdd_nwell_vdd_sb_vdd_sr1_vdd_sr2_vdd_sr3_vdd_sr4_vdd_sv_d_vdd_tie_sv_vdd_tg_d_a_tg_d_vdd_tg_fbm_vdd_tg_fbs_vdd_tg_s_vdd_vdd_vdd_b1_vdd_b2_vdd_b3_vdd_b4_vdd_link_vdd_link_dip_vdd_x1_vdd_x2_vdd_x3 r0 *1 0,0
Ca_d_inv_clk_vdd_inv_mc_vdd_inv_q_vdd_mpa_py_mpb_py_nand_m_vdd_nand_s2_vdd_nwell_vdd_sb_vdd_sr1_vdd_sr2_vdd_sr3_vdd_sr4_vdd_sv_d_vdd_tie_sv_vdd_tg_d_a_tg_d_vdd_tg_fbm_vdd_tg_fbs_vdd_tg_s_vdd_vdd_vdd_b1_vdd_b2_vdd_b3_vdd_b4_vdd_link_vdd_link_dip_vdd_x1_vdd_x2_vdd_x3
+ a|d|inv_clk_vdd|inv_mc_vdd|inv_q_vdd|mpa_py|mpb_py|nand_m_vdd|nand_s2_vdd|nwell_vdd|sb_vdd|sr1_vdd|sr2_vdd|sr3_vdd|sr4_vdd|sv_d_vdd_tie|sv_vdd|tg_d_a|tg_d_vdd|tg_fbm_vdd|tg_fbs_vdd|tg_s_vdd|vdd|vdd_b1|vdd_b2|vdd_b3|vdd_b4|vdd_link|vdd_link_dip|vdd_x1|vdd_x2|vdd_x3
+ vsubs 1.3113907e-13
* device instance a_d_inva_a_mn12_g0_mp13_g0_ro1_ro1_esc_sr1_d_stub_tg_d_a_y_t0 r0 *1 0,0
Ra_d_inva_a_mn12_g0_mp13_g0_ro1_ro1_esc_sr1_d_stub_tg_d_a_y_t0
+ a\x7cd\x7cinva_a\x7cmn12_g0\x7cmp13_g0\x7cro1\x7cro1_esc\x7csr1_d_stub\x7ctg_d_a\x7cy__t0
+ a|d|inva_a|mn12_g0|mp13_g0|ro1|ro1_esc|sr1_d_stub|tg_d_a|y 271.369771052
* device instance a_d_inva_a_mn12_g0_mp13_g0_ro1_ro1_esc_sr1_d_stub_tg_d_a_y_t1 r0 *1 0,0
Ra_d_inva_a_mn12_g0_mp13_g0_ro1_ro1_esc_sr1_d_stub_tg_d_a_y_t1
+ a\x7cd\x7cinva_a\x7cmn12_g0\x7cmp13_g0\x7cro1\x7cro1_esc\x7csr1_d_stub\x7ctg_d_a\x7cy__t1
+ a|d|inva_a|mn12_g0|mp13_g0|ro1|ro1_esc|sr1_d_stub|tg_d_a|y 39.2641131444
* device instance a_d_inva_a_mn12_g0_mp13_g0_ro1_ro1_esc_sr1_d_stub_tg_d_a_y_t2 r0 *1 0,0
Ra_d_inva_a_mn12_g0_mp13_g0_ro1_ro1_esc_sr1_d_stub_tg_d_a_y_t2
+ a\x7cd\x7cinva_a\x7cmn12_g0\x7cmp13_g0\x7cro1\x7cro1_esc\x7csr1_d_stub\x7ctg_d_a\x7cy__t2
+ a|d|inva_a|mn12_g0|mp13_g0|ro1|ro1_esc|sr1_d_stub|tg_d_a|y 488.502106559
* device instance a_d_inva_a_mn12_g0_mp13_g0_ro1_ro1_esc_sr1_d_stub_tg_d_a_y_t3 r0 *1 0,0
Ra_d_inva_a_mn12_g0_mp13_g0_ro1_ro1_esc_sr1_d_stub_tg_d_a_y_t3
+ a\x7cd\x7cinva_a\x7cmn12_g0\x7cmp13_g0\x7cro1\x7cro1_esc\x7csr1_d_stub\x7ctg_d_a\x7cy__t3
+ a|d|inva_a|mn12_g0|mp13_g0|ro1|ro1_esc|sr1_d_stub|tg_d_a|y 26.2653032058
* device instance a_d_inva_a_mn12_g0_mp13_g0_ro1_ro1_esc_sr1_d_stub_tg_d_a_y_t4 r0 *1 0,0
Ra_d_inva_a_mn12_g0_mp13_g0_ro1_ro1_esc_sr1_d_stub_tg_d_a_y_t4
+ a\x7cd\x7cinva_a\x7cmn12_g0\x7cmp13_g0\x7cro1\x7cro1_esc\x7csr1_d_stub\x7ctg_d_a\x7cy__t4
+ a|d|inva_a|mn12_g0|mp13_g0|ro1|ro1_esc|sr1_d_stub|tg_d_a|y 481.122455853
* device instance a_d_inva_a_mn12_g0_mp13_g0_ro1_ro1_esc_sr1_d_stub_tg_d_a_y_t5 r0 *1 0,0
Ra_d_inva_a_mn12_g0_mp13_g0_ro1_ro1_esc_sr1_d_stub_tg_d_a_y_t5
+ a\x7cd\x7cinva_a\x7cmn12_g0\x7cmp13_g0\x7cro1\x7cro1_esc\x7csr1_d_stub\x7ctg_d_a\x7cy__t5
+ a|d|inva_a|mn12_g0|mp13_g0|ro1|ro1_esc|sr1_d_stub|tg_d_a|y 275.713973251
* device instance a_d_inva_a_mn12_g0_mp13_g0_ro1_ro1_esc_sr1_d_stub_tg_d_a_y_t6 r0 *1 0,0
Ra_d_inva_a_mn12_g0_mp13_g0_ro1_ro1_esc_sr1_d_stub_tg_d_a_y_t6
+ a\x7cd\x7cinva_a\x7cmn12_g0\x7cmp13_g0\x7cro1\x7cro1_esc\x7csr1_d_stub\x7ctg_d_a\x7cy__t6
+ a|d|inva_a|mn12_g0|mp13_g0|ro1|ro1_esc|sr1_d_stub|tg_d_a|y 282.640797753
* device instance a_d_inva_a_mn12_g0_mp13_g0_ro1_ro1_esc_sr1_d_stub_tg_d_a_y_t7 r0 *1 0,0
Ra_d_inva_a_mn12_g0_mp13_g0_ro1_ro1_esc_sr1_d_stub_tg_d_a_y_t7
+ a\x7cd\x7cinva_a\x7cmn12_g0\x7cmp13_g0\x7cro1\x7cro1_esc\x7csr1_d_stub\x7ctg_d_a\x7cy__t7
+ a|d|inva_a|mn12_g0|mp13_g0|ro1|ro1_esc|sr1_d_stub|tg_d_a|y 202.862579182
* device instance a_d_inva_a_mn12_g0_mp13_g0_ro1_ro1_esc_sr1_d_stub_tg_d_a_y r0 *1 0,0
Ca_d_inva_a_mn12_g0_mp13_g0_ro1_ro1_esc_sr1_d_stub_tg_d_a_y
+ a|d|inva_a|mn12_g0|mp13_g0|ro1|ro1_esc|sr1_d_stub|tg_d_a|y vsubs 2.4036736e-14
* device instance a_d_inva_a_mn12_g0_mp13_g0_ro3_ro3_esc_e_ro3_esc_w_ro3_hop_sr3_d_stub_tg_d_a_y_t0 r0 *1 0,0
Ra_d_inva_a_mn12_g0_mp13_g0_ro3_ro3_esc_e_ro3_esc_w_ro3_hop_sr3_d_stub_tg_d_a_y_t0
+ a\x7cd\x7cinva_a\x7cmn12_g0\x7cmp13_g0\x7cro3\x7cro3_esc_e\x7cro3_esc_w\x7cro3_hop\x7csr3_d_stub\x7ctg_d_a\x7cy__t0
+ a|d|inva_a|mn12_g0|mp13_g0|ro3|ro3_esc_e|ro3_esc_w|ro3_hop|sr3_d_stub|tg_d_a|y
+ 281.880523039
* device instance a_d_inva_a_mn12_g0_mp13_g0_ro3_ro3_esc_e_ro3_esc_w_ro3_hop_sr3_d_stub_tg_d_a_y_t1 r0 *1 0,0
Ra_d_inva_a_mn12_g0_mp13_g0_ro3_ro3_esc_e_ro3_esc_w_ro3_hop_sr3_d_stub_tg_d_a_y_t1
+ a\x7cd\x7cinva_a\x7cmn12_g0\x7cmp13_g0\x7cro3\x7cro3_esc_e\x7cro3_esc_w\x7cro3_hop\x7csr3_d_stub\x7ctg_d_a\x7cy__t1
+ a|d|inva_a|mn12_g0|mp13_g0|ro3|ro3_esc_e|ro3_esc_w|ro3_hop|sr3_d_stub|tg_d_a|y
+ 404.410035921
* device instance a_d_inva_a_mn12_g0_mp13_g0_ro3_ro3_esc_e_ro3_esc_w_ro3_hop_sr3_d_stub_tg_d_a_y_t2 r0 *1 0,0
Ra_d_inva_a_mn12_g0_mp13_g0_ro3_ro3_esc_e_ro3_esc_w_ro3_hop_sr3_d_stub_tg_d_a_y_t2
+ a\x7cd\x7cinva_a\x7cmn12_g0\x7cmp13_g0\x7cro3\x7cro3_esc_e\x7cro3_esc_w\x7cro3_hop\x7csr3_d_stub\x7ctg_d_a\x7cy__t2
+ a|d|inva_a|mn12_g0|mp13_g0|ro3|ro3_esc_e|ro3_esc_w|ro3_hop|sr3_d_stub|tg_d_a|y
+ 155.323121043
* device instance a_d_inva_a_mn12_g0_mp13_g0_ro3_ro3_esc_e_ro3_esc_w_ro3_hop_sr3_d_stub_tg_d_a_y_t3 r0 *1 0,0
Ra_d_inva_a_mn12_g0_mp13_g0_ro3_ro3_esc_e_ro3_esc_w_ro3_hop_sr3_d_stub_tg_d_a_y_t3
+ a\x7cd\x7cinva_a\x7cmn12_g0\x7cmp13_g0\x7cro3\x7cro3_esc_e\x7cro3_esc_w\x7cro3_hop\x7csr3_d_stub\x7ctg_d_a\x7cy__t3
+ a|d|inva_a|mn12_g0|mp13_g0|ro3|ro3_esc_e|ro3_esc_w|ro3_hop|sr3_d_stub|tg_d_a|y
+ 154.498484449
* device instance a_d_inva_a_mn12_g0_mp13_g0_ro3_ro3_esc_e_ro3_esc_w_ro3_hop_sr3_d_stub_tg_d_a_y_t4 r0 *1 0,0
Ra_d_inva_a_mn12_g0_mp13_g0_ro3_ro3_esc_e_ro3_esc_w_ro3_hop_sr3_d_stub_tg_d_a_y_t4
+ a\x7cd\x7cinva_a\x7cmn12_g0\x7cmp13_g0\x7cro3\x7cro3_esc_e\x7cro3_esc_w\x7cro3_hop\x7csr3_d_stub\x7ctg_d_a\x7cy__t4
+ a|d|inva_a|mn12_g0|mp13_g0|ro3|ro3_esc_e|ro3_esc_w|ro3_hop|sr3_d_stub|tg_d_a|y
+ 401.747755682
* device instance a_d_inva_a_mn12_g0_mp13_g0_ro3_ro3_esc_e_ro3_esc_w_ro3_hop_sr3_d_stub_tg_d_a_y_t5 r0 *1 0,0
Ra_d_inva_a_mn12_g0_mp13_g0_ro3_ro3_esc_e_ro3_esc_w_ro3_hop_sr3_d_stub_tg_d_a_y_t5
+ a\x7cd\x7cinva_a\x7cmn12_g0\x7cmp13_g0\x7cro3\x7cro3_esc_e\x7cro3_esc_w\x7cro3_hop\x7csr3_d_stub\x7ctg_d_a\x7cy__t5
+ a|d|inva_a|mn12_g0|mp13_g0|ro3|ro3_esc_e|ro3_esc_w|ro3_hop|sr3_d_stub|tg_d_a|y
+ 290.010063254
* device instance a_d_inva_a_mn12_g0_mp13_g0_ro3_ro3_esc_e_ro3_esc_w_ro3_hop_sr3_d_stub_tg_d_a_y_t6 r0 *1 0,0
Ra_d_inva_a_mn12_g0_mp13_g0_ro3_ro3_esc_e_ro3_esc_w_ro3_hop_sr3_d_stub_tg_d_a_y_t6
+ a\x7cd\x7cinva_a\x7cmn12_g0\x7cmp13_g0\x7cro3\x7cro3_esc_e\x7cro3_esc_w\x7cro3_hop\x7csr3_d_stub\x7ctg_d_a\x7cy__t6
+ a|d|inva_a|mn12_g0|mp13_g0|ro3|ro3_esc_e|ro3_esc_w|ro3_hop|sr3_d_stub|tg_d_a|y
+ 292.003240469
* device instance a_d_inva_a_mn12_g0_mp13_g0_ro3_ro3_esc_e_ro3_esc_w_ro3_hop_sr3_d_stub_tg_d_a_y_t7 r0 *1 0,0
Ra_d_inva_a_mn12_g0_mp13_g0_ro3_ro3_esc_e_ro3_esc_w_ro3_hop_sr3_d_stub_tg_d_a_y_t7
+ a\x7cd\x7cinva_a\x7cmn12_g0\x7cmp13_g0\x7cro3\x7cro3_esc_e\x7cro3_esc_w\x7cro3_hop\x7csr3_d_stub\x7ctg_d_a\x7cy__t7
+ a|d|inva_a|mn12_g0|mp13_g0|ro3|ro3_esc_e|ro3_esc_w|ro3_hop|sr3_d_stub|tg_d_a|y
+ 249.903576144
* device instance a_d_inva_a_mn12_g0_mp13_g0_ro3_ro3_esc_e_ro3_esc_w_ro3_hop_sr3_d_stub_tg_d_a_y r0 *1 0,0
Ca_d_inva_a_mn12_g0_mp13_g0_ro3_ro3_esc_e_ro3_esc_w_ro3_hop_sr3_d_stub_tg_d_a_y
+ a|d|inva_a|mn12_g0|mp13_g0|ro3|ro3_esc_e|ro3_esc_w|ro3_hop|sr3_d_stub|tg_d_a|y
+ vsubs 4.2078303e-14
* device instance a_d_sb_d_stub_tg_d_a_xo_xo_dip_xo_hop_xo_stub_y_t0 r0 *1 0,0
Ra_d_sb_d_stub_tg_d_a_xo_xo_dip_xo_hop_xo_stub_y_t0
+ a\x7cd\x7csb_d_stub\x7ctg_d_a\x7cxo\x7cxo_dip\x7cxo_hop\x7cxo_stub\x7cy__t0
+ a|d|sb_d_stub|tg_d_a|xo|xo_dip|xo_hop|xo_stub|y 311.202026102
* device instance a_d_sb_d_stub_tg_d_a_xo_xo_dip_xo_hop_xo_stub_y_t1 r0 *1 0,0
Ra_d_sb_d_stub_tg_d_a_xo_xo_dip_xo_hop_xo_stub_y_t1
+ a\x7cd\x7csb_d_stub\x7ctg_d_a\x7cxo\x7cxo_dip\x7cxo_hop\x7cxo_stub\x7cy__t1
+ a|d|sb_d_stub|tg_d_a|xo|xo_dip|xo_hop|xo_stub|y 368.093694215
* device instance a_d_sb_d_stub_tg_d_a_xo_xo_dip_xo_hop_xo_stub_y_t2 r0 *1 0,0
Ra_d_sb_d_stub_tg_d_a_xo_xo_dip_xo_hop_xo_stub_y_t2
+ a\x7cd\x7csb_d_stub\x7ctg_d_a\x7cxo\x7cxo_dip\x7cxo_hop\x7cxo_stub\x7cy__t2
+ a|d|sb_d_stub|tg_d_a|xo|xo_dip|xo_hop|xo_stub|y 615.398449609
* device instance a_d_sb_d_stub_tg_d_a_xo_xo_dip_xo_hop_xo_stub_y_t3 r0 *1 0,0
Ra_d_sb_d_stub_tg_d_a_xo_xo_dip_xo_hop_xo_stub_y_t3
+ a\x7cd\x7csb_d_stub\x7ctg_d_a\x7cxo\x7cxo_dip\x7cxo_hop\x7cxo_stub\x7cy__t3
+ a|d|sb_d_stub|tg_d_a|xo|xo_dip|xo_hop|xo_stub|y 593.736590558
* device instance a_d_sb_d_stub_tg_d_a_xo_xo_dip_xo_hop_xo_stub_y_t4 r0 *1 0,0
Ra_d_sb_d_stub_tg_d_a_xo_xo_dip_xo_hop_xo_stub_y_t4
+ a\x7cd\x7csb_d_stub\x7ctg_d_a\x7cxo\x7cxo_dip\x7cxo_hop\x7cxo_stub\x7cy__t4
+ a|d|sb_d_stub|tg_d_a|xo|xo_dip|xo_hop|xo_stub|y 312.132117475
* device instance a_d_sb_d_stub_tg_d_a_xo_xo_dip_xo_hop_xo_stub_y_t5 r0 *1 0,0
Ra_d_sb_d_stub_tg_d_a_xo_xo_dip_xo_hop_xo_stub_y_t5
+ a\x7cd\x7csb_d_stub\x7ctg_d_a\x7cxo\x7cxo_dip\x7cxo_hop\x7cxo_stub\x7cy__t5
+ a|d|sb_d_stub|tg_d_a|xo|xo_dip|xo_hop|xo_stub|y 236.212422042
* device instance a_d_sb_d_stub_tg_d_a_xo_xo_dip_xo_hop_xo_stub_y r0 *1 0,0
Ca_d_sb_d_stub_tg_d_a_xo_xo_dip_xo_hop_xo_stub_y
+ a|d|sb_d_stub|tg_d_a|xo|xo_dip|xo_hop|xo_stub|y vsubs 1.4282284e-14
* device instance a_g_a_rn1_ro_s4_y_y_t0 r0 *1 0,0
Ra_g_a_rn1_ro_s4_y_y_t0 a\x7cg_a\x7crn1\x7cro\x7cs4_y\x7cy__t0
+ a|g_a|rn1|ro|s4_y|y 126.702317094
* device instance a_g_a_rn1_ro_s4_y_y_t1 r0 *1 0,0
Ra_g_a_rn1_ro_s4_y_y_t1 a\x7cg_a\x7crn1\x7cro\x7cs4_y\x7cy__t1
+ a|g_a|rn1|ro|s4_y|y 123.915720768
* device instance a_g_a_rn1_ro_s4_y_y_t2 r0 *1 0,0
Ra_g_a_rn1_ro_s4_y_y_t2 a\x7cg_a\x7crn1\x7cro\x7cs4_y\x7cy__t2
+ a|g_a|rn1|ro|s4_y|y 265.524234306
* device instance a_g_a_rn1_ro_s4_y_y_t3 r0 *1 0,0
Ra_g_a_rn1_ro_s4_y_y_t3 a\x7cg_a\x7crn1\x7cro\x7cs4_y\x7cy__t3
+ a|g_a|rn1|ro|s4_y|y 265.314164861
* device instance a_g_a_rn1_ro_s4_y_y_t4 r0 *1 0,0
Ra_g_a_rn1_ro_s4_y_y_t4 a\x7cg_a\x7crn1\x7cro\x7cs4_y\x7cy__t4
+ a|g_a|rn1|ro|s4_y|y 384.216215082
* device instance a_g_a_rn1_ro_s4_y_y_t5 r0 *1 0,0
Ra_g_a_rn1_ro_s4_y_y_t5 a\x7cg_a\x7crn1\x7cro\x7cs4_y\x7cy__t5
+ a|g_a|rn1|ro|s4_y|y 390.628947889
* device instance a_g_a_rn1_ro_s4_y_y r0 *1 0,0
Ca_g_a_rn1_ro_s4_y_y a|g_a|rn1|ro|s4_y|y vsubs 6.402999e-15
* device instance a_g_a_rn2_ro_s4_y_y_t0 r0 *1 0,0
Ra_g_a_rn2_ro_s4_y_y_t0 a\x7cg_a\x7crn2\x7cro\x7cs4_y\x7cy__t0
+ a|g_a|rn2|ro|s4_y|y 126.702317094
* device instance a_g_a_rn2_ro_s4_y_y_t1 r0 *1 0,0
Ra_g_a_rn2_ro_s4_y_y_t1 a\x7cg_a\x7crn2\x7cro\x7cs4_y\x7cy__t1
+ a|g_a|rn2|ro|s4_y|y 123.915720768
* device instance a_g_a_rn2_ro_s4_y_y_t2 r0 *1 0,0
Ra_g_a_rn2_ro_s4_y_y_t2 a\x7cg_a\x7crn2\x7cro\x7cs4_y\x7cy__t2
+ a|g_a|rn2|ro|s4_y|y 265.524234306
* device instance a_g_a_rn2_ro_s4_y_y_t3 r0 *1 0,0
Ra_g_a_rn2_ro_s4_y_y_t3 a\x7cg_a\x7crn2\x7cro\x7cs4_y\x7cy__t3
+ a|g_a|rn2|ro|s4_y|y 265.314164861
* device instance a_g_a_rn2_ro_s4_y_y_t4 r0 *1 0,0
Ra_g_a_rn2_ro_s4_y_y_t4 a\x7cg_a\x7crn2\x7cro\x7cs4_y\x7cy__t4
+ a|g_a|rn2|ro|s4_y|y 384.216215082
* device instance a_g_a_rn2_ro_s4_y_y_t5 r0 *1 0,0
Ra_g_a_rn2_ro_s4_y_y_t5 a\x7cg_a\x7crn2\x7cro\x7cs4_y\x7cy__t5
+ a|g_a|rn2|ro|s4_y|y 390.628947889
* device instance a_g_a_rn2_ro_s4_y_y r0 *1 0,0
Ca_g_a_rn2_ro_s4_y_y a|g_a|rn2|ro|s4_y|y vsubs 6.402999e-15
* device instance a_g_a_rn3_ro_s4_y_y_t0 r0 *1 0,0
Ra_g_a_rn3_ro_s4_y_y_t0 a\x7cg_a\x7crn3\x7cro\x7cs4_y\x7cy__t0
+ a|g_a|rn3|ro|s4_y|y 126.702317094
* device instance a_g_a_rn3_ro_s4_y_y_t1 r0 *1 0,0
Ra_g_a_rn3_ro_s4_y_y_t1 a\x7cg_a\x7crn3\x7cro\x7cs4_y\x7cy__t1
+ a|g_a|rn3|ro|s4_y|y 123.915720768
* device instance a_g_a_rn3_ro_s4_y_y_t2 r0 *1 0,0
Ra_g_a_rn3_ro_s4_y_y_t2 a\x7cg_a\x7crn3\x7cro\x7cs4_y\x7cy__t2
+ a|g_a|rn3|ro|s4_y|y 265.524234306
* device instance a_g_a_rn3_ro_s4_y_y_t3 r0 *1 0,0
Ra_g_a_rn3_ro_s4_y_y_t3 a\x7cg_a\x7crn3\x7cro\x7cs4_y\x7cy__t3
+ a|g_a|rn3|ro|s4_y|y 384.216215082
* device instance a_g_a_rn3_ro_s4_y_y_t4 r0 *1 0,0
Ra_g_a_rn3_ro_s4_y_y_t4 a\x7cg_a\x7crn3\x7cro\x7cs4_y\x7cy__t4
+ a|g_a|rn3|ro|s4_y|y 265.314164861
* device instance a_g_a_rn3_ro_s4_y_y_t5 r0 *1 0,0
Ra_g_a_rn3_ro_s4_y_y_t5 a\x7cg_a\x7crn3\x7cro\x7cs4_y\x7cy__t5
+ a|g_a|rn3|ro|s4_y|y 390.628947889
* device instance a_g_a_rn3_ro_s4_y_y r0 *1 0,0
Ca_g_a_rn3_ro_s4_y_y a|g_a|rn3|ro|s4_y|y vsubs 6.402999e-15
* device instance a_g_a_rn4_ro_s4_y_y_t0 r0 *1 0,0
Ra_g_a_rn4_ro_s4_y_y_t0 a\x7cg_a\x7crn4\x7cro\x7cs4_y\x7cy__t0
+ a|g_a|rn4|ro|s4_y|y 126.702317094
* device instance a_g_a_rn4_ro_s4_y_y_t1 r0 *1 0,0
Ra_g_a_rn4_ro_s4_y_y_t1 a\x7cg_a\x7crn4\x7cro\x7cs4_y\x7cy__t1
+ a|g_a|rn4|ro|s4_y|y 123.915720768
* device instance a_g_a_rn4_ro_s4_y_y_t2 r0 *1 0,0
Ra_g_a_rn4_ro_s4_y_y_t2 a\x7cg_a\x7crn4\x7cro\x7cs4_y\x7cy__t2
+ a|g_a|rn4|ro|s4_y|y 265.524234306
* device instance a_g_a_rn4_ro_s4_y_y_t3 r0 *1 0,0
Ra_g_a_rn4_ro_s4_y_y_t3 a\x7cg_a\x7crn4\x7cro\x7cs4_y\x7cy__t3
+ a|g_a|rn4|ro|s4_y|y 384.216215082
* device instance a_g_a_rn4_ro_s4_y_y_t4 r0 *1 0,0
Ra_g_a_rn4_ro_s4_y_y_t4 a\x7cg_a\x7crn4\x7cro\x7cs4_y\x7cy__t4
+ a|g_a|rn4|ro|s4_y|y 265.314164861
* device instance a_g_a_rn4_ro_s4_y_y_t5 r0 *1 0,0
Ra_g_a_rn4_ro_s4_y_y_t5 a\x7cg_a\x7crn4\x7cro\x7cs4_y\x7cy__t5
+ a|g_a|rn4|ro|s4_y|y 390.628947889
* device instance a_g_a_rn4_ro_s4_y_y r0 *1 0,0
Ca_g_a_rn4_ro_s4_y_y a|g_a|rn4|ro|s4_y|y vsubs 6.399383e-15
* device instance a_g_y_mnab_y_mpa_y_mpb_y_n1_s1_a_y_t0 r0 *1 0,0
Ra_g_y_mnab_y_mpa_y_mpb_y_n1_s1_a_y_t0
+ a\x7cg_y\x7cmnab_y\x7cmpa_y\x7cmpb_y\x7cn1\x7cs1_a\x7cy__t0
+ a|g_y|mnab_y|mpa_y|mpb_y|n1|s1_a|y 128.359871717
* device instance a_g_y_mnab_y_mpa_y_mpb_y_n1_s1_a_y_t1 r0 *1 0,0
Ra_g_y_mnab_y_mpa_y_mpb_y_n1_s1_a_y_t1
+ a\x7cg_y\x7cmnab_y\x7cmpa_y\x7cmpb_y\x7cn1\x7cs1_a\x7cy__t1
+ a|g_y|mnab_y|mpa_y|mpb_y|n1|s1_a|y 165.838297843
* device instance a_g_y_mnab_y_mpa_y_mpb_y_n1_s1_a_y_t2 r0 *1 0,0
Ra_g_y_mnab_y_mpa_y_mpb_y_n1_s1_a_y_t2
+ a\x7cg_y\x7cmnab_y\x7cmpa_y\x7cmpb_y\x7cn1\x7cs1_a\x7cy__t2
+ a|g_y|mnab_y|mpa_y|mpb_y|n1|s1_a|y 153.784254215
* device instance a_g_y_mnab_y_mpa_y_mpb_y_n1_s1_a_y_t3 r0 *1 0,0
Ra_g_y_mnab_y_mpa_y_mpb_y_n1_s1_a_y_t3
+ a\x7cg_y\x7cmnab_y\x7cmpa_y\x7cmpb_y\x7cn1\x7cs1_a\x7cy__t3
+ a|g_y|mnab_y|mpa_y|mpb_y|n1|s1_a|y 93.6501322123
* device instance a_g_y_mnab_y_mpa_y_mpb_y_n1_s1_a_y_t4 r0 *1 0,0
Ra_g_y_mnab_y_mpa_y_mpb_y_n1_s1_a_y_t4
+ a\x7cg_y\x7cmnab_y\x7cmpa_y\x7cmpb_y\x7cn1\x7cs1_a\x7cy__t4
+ a|g_y|mnab_y|mpa_y|mpb_y|n1|s1_a|y 114.324644013
* device instance a_g_y_mnab_y_mpa_y_mpb_y_n1_s1_a_y r0 *1 0,0
Ca_g_y_mnab_y_mpa_y_mpb_y_n1_s1_a_y a|g_y|mnab_y|mpa_y|mpb_y|n1|s1_a|y vsubs
+ 2.632209e-15
* device instance a_g_y_mnab_y_mpa_y_mpb_y_n1_s1_a_y_dup1_t0 r0 *1 0,0
Ra_g_y_mnab_y_mpa_y_mpb_y_n1_s1_a_y_dup1_t0
+ a\x7cg_y\x7cmnab_y\x7cmpa_y\x7cmpb_y\x7cn1\x7cs1_a\x7cy__t02
+ a|g_y|mnab_y|mpa_y|mpb_y|n1|s1_a|y$1 128.359871717
* device instance a_g_y_mnab_y_mpa_y_mpb_y_n1_s1_a_y_dup1_t1 r0 *1 0,0
Ra_g_y_mnab_y_mpa_y_mpb_y_n1_s1_a_y_dup1_t1
+ a\x7cg_y\x7cmnab_y\x7cmpa_y\x7cmpb_y\x7cn1\x7cs1_a\x7cy__t12
+ a|g_y|mnab_y|mpa_y|mpb_y|n1|s1_a|y$1 165.838297843
* device instance a_g_y_mnab_y_mpa_y_mpb_y_n1_s1_a_y_dup1_t2 r0 *1 0,0
Ra_g_y_mnab_y_mpa_y_mpb_y_n1_s1_a_y_dup1_t2
+ a\x7cg_y\x7cmnab_y\x7cmpa_y\x7cmpb_y\x7cn1\x7cs1_a\x7cy__t22
+ a|g_y|mnab_y|mpa_y|mpb_y|n1|s1_a|y$1 153.784254215
* device instance a_g_y_mnab_y_mpa_y_mpb_y_n1_s1_a_y_dup1_t3 r0 *1 0,0
Ra_g_y_mnab_y_mpa_y_mpb_y_n1_s1_a_y_dup1_t3
+ a\x7cg_y\x7cmnab_y\x7cmpa_y\x7cmpb_y\x7cn1\x7cs1_a\x7cy__t32
+ a|g_y|mnab_y|mpa_y|mpb_y|n1|s1_a|y$1 93.6501322123
* device instance a_g_y_mnab_y_mpa_y_mpb_y_n1_s1_a_y_dup1_t4 r0 *1 0,0
Ra_g_y_mnab_y_mpa_y_mpb_y_n1_s1_a_y_dup1_t4
+ a\x7cg_y\x7cmnab_y\x7cmpa_y\x7cmpb_y\x7cn1\x7cs1_a\x7cy__t42
+ a|g_y|mnab_y|mpa_y|mpb_y|n1|s1_a|y$1 114.324644013
* device instance a_g_y_mnab_y_mpa_y_mpb_y_n1_s1_a_y_dup1 r0 *1 0,0
Ca_g_y_mnab_y_mpa_y_mpb_y_n1_s1_a_y_dup1 a|g_y|mnab_y|mpa_y|mpb_y|n1|s1_a|y$1
+ vsubs 2.632209e-15
* device instance a_g_y_mnab_y_mpa_y_mpb_y_n1_s1_a_y_dup2_t0 r0 *1 0,0
Ra_g_y_mnab_y_mpa_y_mpb_y_n1_s1_a_y_dup2_t0
+ a\x7cg_y\x7cmnab_y\x7cmpa_y\x7cmpb_y\x7cn1\x7cs1_a\x7cy__t03
+ a|g_y|mnab_y|mpa_y|mpb_y|n1|s1_a|y$2 128.359871717
* device instance a_g_y_mnab_y_mpa_y_mpb_y_n1_s1_a_y_dup2_t1 r0 *1 0,0
Ra_g_y_mnab_y_mpa_y_mpb_y_n1_s1_a_y_dup2_t1
+ a\x7cg_y\x7cmnab_y\x7cmpa_y\x7cmpb_y\x7cn1\x7cs1_a\x7cy__t13
+ a|g_y|mnab_y|mpa_y|mpb_y|n1|s1_a|y$2 165.838297843
* device instance a_g_y_mnab_y_mpa_y_mpb_y_n1_s1_a_y_dup2_t2 r0 *1 0,0
Ra_g_y_mnab_y_mpa_y_mpb_y_n1_s1_a_y_dup2_t2
+ a\x7cg_y\x7cmnab_y\x7cmpa_y\x7cmpb_y\x7cn1\x7cs1_a\x7cy__t23
+ a|g_y|mnab_y|mpa_y|mpb_y|n1|s1_a|y$2 153.784254215
* device instance a_g_y_mnab_y_mpa_y_mpb_y_n1_s1_a_y_dup2_t3 r0 *1 0,0
Ra_g_y_mnab_y_mpa_y_mpb_y_n1_s1_a_y_dup2_t3
+ a\x7cg_y\x7cmnab_y\x7cmpa_y\x7cmpb_y\x7cn1\x7cs1_a\x7cy__t33
+ a|g_y|mnab_y|mpa_y|mpb_y|n1|s1_a|y$2 93.6501322123
* device instance a_g_y_mnab_y_mpa_y_mpb_y_n1_s1_a_y_dup2_t4 r0 *1 0,0
Ra_g_y_mnab_y_mpa_y_mpb_y_n1_s1_a_y_dup2_t4
+ a\x7cg_y\x7cmnab_y\x7cmpa_y\x7cmpb_y\x7cn1\x7cs1_a\x7cy__t43
+ a|g_y|mnab_y|mpa_y|mpb_y|n1|s1_a|y$2 114.324644013
* device instance a_g_y_mnab_y_mpa_y_mpb_y_n1_s1_a_y_dup2 r0 *1 0,0
Ca_g_y_mnab_y_mpa_y_mpb_y_n1_s1_a_y_dup2 a|g_y|mnab_y|mpa_y|mpb_y|n1|s1_a|y$2
+ vsubs 2.632209e-15
* device instance a_g_y_mnab_y_mpa_y_mpb_y_n1_s1_a_y_dup3_t0 r0 *1 0,0
Ra_g_y_mnab_y_mpa_y_mpb_y_n1_s1_a_y_dup3_t0
+ a\x7cg_y\x7cmnab_y\x7cmpa_y\x7cmpb_y\x7cn1\x7cs1_a\x7cy__t04
+ a|g_y|mnab_y|mpa_y|mpb_y|n1|s1_a|y$3 128.359871717
* device instance a_g_y_mnab_y_mpa_y_mpb_y_n1_s1_a_y_dup3_t1 r0 *1 0,0
Ra_g_y_mnab_y_mpa_y_mpb_y_n1_s1_a_y_dup3_t1
+ a\x7cg_y\x7cmnab_y\x7cmpa_y\x7cmpb_y\x7cn1\x7cs1_a\x7cy__t14
+ a|g_y|mnab_y|mpa_y|mpb_y|n1|s1_a|y$3 165.838297843
* device instance a_g_y_mnab_y_mpa_y_mpb_y_n1_s1_a_y_dup3_t2 r0 *1 0,0
Ra_g_y_mnab_y_mpa_y_mpb_y_n1_s1_a_y_dup3_t2
+ a\x7cg_y\x7cmnab_y\x7cmpa_y\x7cmpb_y\x7cn1\x7cs1_a\x7cy__t24
+ a|g_y|mnab_y|mpa_y|mpb_y|n1|s1_a|y$3 153.784254215
* device instance a_g_y_mnab_y_mpa_y_mpb_y_n1_s1_a_y_dup3_t3 r0 *1 0,0
Ra_g_y_mnab_y_mpa_y_mpb_y_n1_s1_a_y_dup3_t3
+ a\x7cg_y\x7cmnab_y\x7cmpa_y\x7cmpb_y\x7cn1\x7cs1_a\x7cy__t34
+ a|g_y|mnab_y|mpa_y|mpb_y|n1|s1_a|y$3 93.6501322123
* device instance a_g_y_mnab_y_mpa_y_mpb_y_n1_s1_a_y_dup3_t4 r0 *1 0,0
Ra_g_y_mnab_y_mpa_y_mpb_y_n1_s1_a_y_dup3_t4
+ a\x7cg_y\x7cmnab_y\x7cmpa_y\x7cmpb_y\x7cn1\x7cs1_a\x7cy__t44
+ a|g_y|mnab_y|mpa_y|mpb_y|n1|s1_a|y$3 114.324644013
* device instance a_g_y_mnab_y_mpa_y_mpb_y_n1_s1_a_y_dup3 r0 *1 0,0
Ca_g_y_mnab_y_mpa_y_mpb_y_n1_s1_a_y_dup3 a|g_y|mnab_y|mpa_y|mpb_y|n1|s1_a|y$3
+ vsubs 2.632209e-15
* device instance a_inv_mc_a_mb_mnab_y_mpa_y_mpb_y_nand_m_y_tg_s_a_y_t0 r0 *1 0,0
Ra_inv_mc_a_mb_mnab_y_mpa_y_mpb_y_nand_m_y_tg_s_a_y_t0
+ a\x7cinv_mc_a\x7cmb\x7cmnab_y\x7cmpa_y\x7cmpb_y\x7cnand_m_y\x7ctg_s_a\x7cy__t0
+ a|inv_mc_a|mb|mnab_y|mpa_y|mpb_y|nand_m_y|tg_s_a|y 167.430274441
* device instance a_inv_mc_a_mb_mnab_y_mpa_y_mpb_y_nand_m_y_tg_s_a_y_t1 r0 *1 0,0
Ra_inv_mc_a_mb_mnab_y_mpa_y_mpb_y_nand_m_y_tg_s_a_y_t1
+ a\x7cinv_mc_a\x7cmb\x7cmnab_y\x7cmpa_y\x7cmpb_y\x7cnand_m_y\x7ctg_s_a\x7cy__t1
+ a|inv_mc_a|mb|mnab_y|mpa_y|mpb_y|nand_m_y|tg_s_a|y 246.866973374
* device instance a_inv_mc_a_mb_mnab_y_mpa_y_mpb_y_nand_m_y_tg_s_a_y_t2 r0 *1 0,0
Ra_inv_mc_a_mb_mnab_y_mpa_y_mpb_y_nand_m_y_tg_s_a_y_t2
+ a\x7cinv_mc_a\x7cmb\x7cmnab_y\x7cmpa_y\x7cmpb_y\x7cnand_m_y\x7ctg_s_a\x7cy__t2
+ a|inv_mc_a|mb|mnab_y|mpa_y|mpb_y|nand_m_y|tg_s_a|y 244.54403591
* device instance a_inv_mc_a_mb_mnab_y_mpa_y_mpb_y_nand_m_y_tg_s_a_y_t3 r0 *1 0,0
Ra_inv_mc_a_mb_mnab_y_mpa_y_mpb_y_nand_m_y_tg_s_a_y_t3
+ a\x7cinv_mc_a\x7cmb\x7cmnab_y\x7cmpa_y\x7cmpb_y\x7cnand_m_y\x7ctg_s_a\x7cy__t3
+ a|inv_mc_a|mb|mnab_y|mpa_y|mpb_y|nand_m_y|tg_s_a|y 185.501222126
* device instance a_inv_mc_a_mb_mnab_y_mpa_y_mpb_y_nand_m_y_tg_s_a_y_t4 r0 *1 0,0
Ra_inv_mc_a_mb_mnab_y_mpa_y_mpb_y_nand_m_y_tg_s_a_y_t4
+ a\x7cinv_mc_a\x7cmb\x7cmnab_y\x7cmpa_y\x7cmpb_y\x7cnand_m_y\x7ctg_s_a\x7cy__t4
+ a|inv_mc_a|mb|mnab_y|mpa_y|mpb_y|nand_m_y|tg_s_a|y 47.2529843038
* device instance a_inv_mc_a_mb_mnab_y_mpa_y_mpb_y_nand_m_y_tg_s_a_y_t5 r0 *1 0,0
Ra_inv_mc_a_mb_mnab_y_mpa_y_mpb_y_nand_m_y_tg_s_a_y_t5
+ a\x7cinv_mc_a\x7cmb\x7cmnab_y\x7cmpa_y\x7cmpb_y\x7cnand_m_y\x7ctg_s_a\x7cy__t5
+ a|inv_mc_a|mb|mnab_y|mpa_y|mpb_y|nand_m_y|tg_s_a|y 33.0352460576
* device instance a_inv_mc_a_mb_mnab_y_mpa_y_mpb_y_nand_m_y_tg_s_a_y_t6 r0 *1 0,0
Ra_inv_mc_a_mb_mnab_y_mpa_y_mpb_y_nand_m_y_tg_s_a_y_t6
+ a\x7cinv_mc_a\x7cmb\x7cmnab_y\x7cmpa_y\x7cmpb_y\x7cnand_m_y\x7ctg_s_a\x7cy__t6
+ a|inv_mc_a|mb|mnab_y|mpa_y|mpb_y|nand_m_y|tg_s_a|y 155.253663787
* device instance a_inv_mc_a_mb_mnab_y_mpa_y_mpb_y_nand_m_y_tg_s_a_y r0 *1 0,0
Ca_inv_mc_a_mb_mnab_y_mpa_y_mpb_y_nand_m_y_tg_s_a_y
+ a|inv_mc_a|mb|mnab_y|mpa_y|mpb_y|nand_m_y|tg_s_a|y vsubs 4.01273e-15
* device instance a_inv_mc_a_mb_mnab_y_mpa_y_mpb_y_nand_m_y_tg_s_a_y_dup1_t0 r0 *1 0,0
Ra_inv_mc_a_mb_mnab_y_mpa_y_mpb_y_nand_m_y_tg_s_a_y_dup1_t0
+ a\x7cinv_mc_a\x7cmb\x7cmnab_y\x7cmpa_y\x7cmpb_y\x7cnand_m_y\x7ctg_s_a\x7cy__t02
+ a|inv_mc_a|mb|mnab_y|mpa_y|mpb_y|nand_m_y|tg_s_a|y$1 246.866973374
* device instance a_inv_mc_a_mb_mnab_y_mpa_y_mpb_y_nand_m_y_tg_s_a_y_dup1_t1 r0 *1 0,0
Ra_inv_mc_a_mb_mnab_y_mpa_y_mpb_y_nand_m_y_tg_s_a_y_dup1_t1
+ a\x7cinv_mc_a\x7cmb\x7cmnab_y\x7cmpa_y\x7cmpb_y\x7cnand_m_y\x7ctg_s_a\x7cy__t12
+ a|inv_mc_a|mb|mnab_y|mpa_y|mpb_y|nand_m_y|tg_s_a|y$1 244.54403591
* device instance a_inv_mc_a_mb_mnab_y_mpa_y_mpb_y_nand_m_y_tg_s_a_y_dup1_t2 r0 *1 0,0
Ra_inv_mc_a_mb_mnab_y_mpa_y_mpb_y_nand_m_y_tg_s_a_y_dup1_t2
+ a\x7cinv_mc_a\x7cmb\x7cmnab_y\x7cmpa_y\x7cmpb_y\x7cnand_m_y\x7ctg_s_a\x7cy__t22
+ a|inv_mc_a|mb|mnab_y|mpa_y|mpb_y|nand_m_y|tg_s_a|y$1 185.501222126
* device instance a_inv_mc_a_mb_mnab_y_mpa_y_mpb_y_nand_m_y_tg_s_a_y_dup1_t3 r0 *1 0,0
Ra_inv_mc_a_mb_mnab_y_mpa_y_mpb_y_nand_m_y_tg_s_a_y_dup1_t3
+ a\x7cinv_mc_a\x7cmb\x7cmnab_y\x7cmpa_y\x7cmpb_y\x7cnand_m_y\x7ctg_s_a\x7cy__t32
+ a|inv_mc_a|mb|mnab_y|mpa_y|mpb_y|nand_m_y|tg_s_a|y$1 47.2529843038
* device instance a_inv_mc_a_mb_mnab_y_mpa_y_mpb_y_nand_m_y_tg_s_a_y_dup1_t4 r0 *1 0,0
Ra_inv_mc_a_mb_mnab_y_mpa_y_mpb_y_nand_m_y_tg_s_a_y_dup1_t4
+ a\x7cinv_mc_a\x7cmb\x7cmnab_y\x7cmpa_y\x7cmpb_y\x7cnand_m_y\x7ctg_s_a\x7cy__t42
+ a|inv_mc_a|mb|mnab_y|mpa_y|mpb_y|nand_m_y|tg_s_a|y$1 33.0352460576
* device instance a_inv_mc_a_mb_mnab_y_mpa_y_mpb_y_nand_m_y_tg_s_a_y_dup1_t5 r0 *1 0,0
Ra_inv_mc_a_mb_mnab_y_mpa_y_mpb_y_nand_m_y_tg_s_a_y_dup1_t5
+ a\x7cinv_mc_a\x7cmb\x7cmnab_y\x7cmpa_y\x7cmpb_y\x7cnand_m_y\x7ctg_s_a\x7cy__t52
+ a|inv_mc_a|mb|mnab_y|mpa_y|mpb_y|nand_m_y|tg_s_a|y$1 155.253663787
* device instance a_inv_mc_a_mb_mnab_y_mpa_y_mpb_y_nand_m_y_tg_s_a_y_dup1_t6 r0 *1 0,0
Ra_inv_mc_a_mb_mnab_y_mpa_y_mpb_y_nand_m_y_tg_s_a_y_dup1_t6
+ a\x7cinv_mc_a\x7cmb\x7cmnab_y\x7cmpa_y\x7cmpb_y\x7cnand_m_y\x7ctg_s_a\x7cy__t62
+ a|inv_mc_a|mb|mnab_y|mpa_y|mpb_y|nand_m_y|tg_s_a|y$1 167.430274441
* device instance a_inv_mc_a_mb_mnab_y_mpa_y_mpb_y_nand_m_y_tg_s_a_y_dup1 r0 *1 0,0
Ca_inv_mc_a_mb_mnab_y_mpa_y_mpb_y_nand_m_y_tg_s_a_y_dup1
+ a|inv_mc_a|mb|mnab_y|mpa_y|mpb_y|nand_m_y|tg_s_a|y$1 vsubs 4.01273e-15
* device instance a_inv_mc_a_mb_mnab_y_mpa_y_mpb_y_nand_m_y_tg_s_a_y_dup2_t0 r0 *1 0,0
Ra_inv_mc_a_mb_mnab_y_mpa_y_mpb_y_nand_m_y_tg_s_a_y_dup2_t0
+ a\x7cinv_mc_a\x7cmb\x7cmnab_y\x7cmpa_y\x7cmpb_y\x7cnand_m_y\x7ctg_s_a\x7cy__t03
+ a|inv_mc_a|mb|mnab_y|mpa_y|mpb_y|nand_m_y|tg_s_a|y$2 246.866973374
* device instance a_inv_mc_a_mb_mnab_y_mpa_y_mpb_y_nand_m_y_tg_s_a_y_dup2_t1 r0 *1 0,0
Ra_inv_mc_a_mb_mnab_y_mpa_y_mpb_y_nand_m_y_tg_s_a_y_dup2_t1
+ a\x7cinv_mc_a\x7cmb\x7cmnab_y\x7cmpa_y\x7cmpb_y\x7cnand_m_y\x7ctg_s_a\x7cy__t13
+ a|inv_mc_a|mb|mnab_y|mpa_y|mpb_y|nand_m_y|tg_s_a|y$2 185.501222126
* device instance a_inv_mc_a_mb_mnab_y_mpa_y_mpb_y_nand_m_y_tg_s_a_y_dup2_t2 r0 *1 0,0
Ra_inv_mc_a_mb_mnab_y_mpa_y_mpb_y_nand_m_y_tg_s_a_y_dup2_t2
+ a\x7cinv_mc_a\x7cmb\x7cmnab_y\x7cmpa_y\x7cmpb_y\x7cnand_m_y\x7ctg_s_a\x7cy__t23
+ a|inv_mc_a|mb|mnab_y|mpa_y|mpb_y|nand_m_y|tg_s_a|y$2 244.54403591
* device instance a_inv_mc_a_mb_mnab_y_mpa_y_mpb_y_nand_m_y_tg_s_a_y_dup2_t3 r0 *1 0,0
Ra_inv_mc_a_mb_mnab_y_mpa_y_mpb_y_nand_m_y_tg_s_a_y_dup2_t3
+ a\x7cinv_mc_a\x7cmb\x7cmnab_y\x7cmpa_y\x7cmpb_y\x7cnand_m_y\x7ctg_s_a\x7cy__t33
+ a|inv_mc_a|mb|mnab_y|mpa_y|mpb_y|nand_m_y|tg_s_a|y$2 47.2529843038
* device instance a_inv_mc_a_mb_mnab_y_mpa_y_mpb_y_nand_m_y_tg_s_a_y_dup2_t4 r0 *1 0,0
Ra_inv_mc_a_mb_mnab_y_mpa_y_mpb_y_nand_m_y_tg_s_a_y_dup2_t4
+ a\x7cinv_mc_a\x7cmb\x7cmnab_y\x7cmpa_y\x7cmpb_y\x7cnand_m_y\x7ctg_s_a\x7cy__t43
+ a|inv_mc_a|mb|mnab_y|mpa_y|mpb_y|nand_m_y|tg_s_a|y$2 33.0352460576
* device instance a_inv_mc_a_mb_mnab_y_mpa_y_mpb_y_nand_m_y_tg_s_a_y_dup2_t5 r0 *1 0,0
Ra_inv_mc_a_mb_mnab_y_mpa_y_mpb_y_nand_m_y_tg_s_a_y_dup2_t5
+ a\x7cinv_mc_a\x7cmb\x7cmnab_y\x7cmpa_y\x7cmpb_y\x7cnand_m_y\x7ctg_s_a\x7cy__t53
+ a|inv_mc_a|mb|mnab_y|mpa_y|mpb_y|nand_m_y|tg_s_a|y$2 155.253663787
* device instance a_inv_mc_a_mb_mnab_y_mpa_y_mpb_y_nand_m_y_tg_s_a_y_dup2_t6 r0 *1 0,0
Ra_inv_mc_a_mb_mnab_y_mpa_y_mpb_y_nand_m_y_tg_s_a_y_dup2_t6
+ a\x7cinv_mc_a\x7cmb\x7cmnab_y\x7cmpa_y\x7cmpb_y\x7cnand_m_y\x7ctg_s_a\x7cy__t63
+ a|inv_mc_a|mb|mnab_y|mpa_y|mpb_y|nand_m_y|tg_s_a|y$2 167.430274441
* device instance a_inv_mc_a_mb_mnab_y_mpa_y_mpb_y_nand_m_y_tg_s_a_y_dup2 r0 *1 0,0
Ca_inv_mc_a_mb_mnab_y_mpa_y_mpb_y_nand_m_y_tg_s_a_y_dup2
+ a|inv_mc_a|mb|mnab_y|mpa_y|mpb_y|nand_m_y|tg_s_a|y$2 vsubs 4.01273e-15
* device instance a_inv_mc_a_mb_mnab_y_mpa_y_mpb_y_nand_m_y_tg_s_a_y_dup3_t0 r0 *1 0,0
Ra_inv_mc_a_mb_mnab_y_mpa_y_mpb_y_nand_m_y_tg_s_a_y_dup3_t0
+ a\x7cinv_mc_a\x7cmb\x7cmnab_y\x7cmpa_y\x7cmpb_y\x7cnand_m_y\x7ctg_s_a\x7cy__t04
+ a|inv_mc_a|mb|mnab_y|mpa_y|mpb_y|nand_m_y|tg_s_a|y$3 246.866973374
* device instance a_inv_mc_a_mb_mnab_y_mpa_y_mpb_y_nand_m_y_tg_s_a_y_dup3_t1 r0 *1 0,0
Ra_inv_mc_a_mb_mnab_y_mpa_y_mpb_y_nand_m_y_tg_s_a_y_dup3_t1
+ a\x7cinv_mc_a\x7cmb\x7cmnab_y\x7cmpa_y\x7cmpb_y\x7cnand_m_y\x7ctg_s_a\x7cy__t14
+ a|inv_mc_a|mb|mnab_y|mpa_y|mpb_y|nand_m_y|tg_s_a|y$3 185.501222126
* device instance a_inv_mc_a_mb_mnab_y_mpa_y_mpb_y_nand_m_y_tg_s_a_y_dup3_t2 r0 *1 0,0
Ra_inv_mc_a_mb_mnab_y_mpa_y_mpb_y_nand_m_y_tg_s_a_y_dup3_t2
+ a\x7cinv_mc_a\x7cmb\x7cmnab_y\x7cmpa_y\x7cmpb_y\x7cnand_m_y\x7ctg_s_a\x7cy__t24
+ a|inv_mc_a|mb|mnab_y|mpa_y|mpb_y|nand_m_y|tg_s_a|y$3 244.54403591
* device instance a_inv_mc_a_mb_mnab_y_mpa_y_mpb_y_nand_m_y_tg_s_a_y_dup3_t3 r0 *1 0,0
Ra_inv_mc_a_mb_mnab_y_mpa_y_mpb_y_nand_m_y_tg_s_a_y_dup3_t3
+ a\x7cinv_mc_a\x7cmb\x7cmnab_y\x7cmpa_y\x7cmpb_y\x7cnand_m_y\x7ctg_s_a\x7cy__t34
+ a|inv_mc_a|mb|mnab_y|mpa_y|mpb_y|nand_m_y|tg_s_a|y$3 47.2529843038
* device instance a_inv_mc_a_mb_mnab_y_mpa_y_mpb_y_nand_m_y_tg_s_a_y_dup3_t4 r0 *1 0,0
Ra_inv_mc_a_mb_mnab_y_mpa_y_mpb_y_nand_m_y_tg_s_a_y_dup3_t4
+ a\x7cinv_mc_a\x7cmb\x7cmnab_y\x7cmpa_y\x7cmpb_y\x7cnand_m_y\x7ctg_s_a\x7cy__t44
+ a|inv_mc_a|mb|mnab_y|mpa_y|mpb_y|nand_m_y|tg_s_a|y$3 33.0352460576
* device instance a_inv_mc_a_mb_mnab_y_mpa_y_mpb_y_nand_m_y_tg_s_a_y_dup3_t5 r0 *1 0,0
Ra_inv_mc_a_mb_mnab_y_mpa_y_mpb_y_nand_m_y_tg_s_a_y_dup3_t5
+ a\x7cinv_mc_a\x7cmb\x7cmnab_y\x7cmpa_y\x7cmpb_y\x7cnand_m_y\x7ctg_s_a\x7cy__t54
+ a|inv_mc_a|mb|mnab_y|mpa_y|mpb_y|nand_m_y|tg_s_a|y$3 155.253663787
* device instance a_inv_mc_a_mb_mnab_y_mpa_y_mpb_y_nand_m_y_tg_s_a_y_dup3_t6 r0 *1 0,0
Ra_inv_mc_a_mb_mnab_y_mpa_y_mpb_y_nand_m_y_tg_s_a_y_dup3_t6
+ a\x7cinv_mc_a\x7cmb\x7cmnab_y\x7cmpa_y\x7cmpb_y\x7cnand_m_y\x7ctg_s_a\x7cy__t64
+ a|inv_mc_a|mb|mnab_y|mpa_y|mpb_y|nand_m_y|tg_s_a|y$3 167.430274441
* device instance a_inv_mc_a_mb_mnab_y_mpa_y_mpb_y_nand_m_y_tg_s_a_y_dup3 r0 *1 0,0
Ca_inv_mc_a_mb_mnab_y_mpa_y_mpb_y_nand_m_y_tg_s_a_y_dup3
+ a|inv_mc_a|mb|mnab_y|mpa_y|mpb_y|nand_m_y|tg_s_a|y$3 vsubs 4.01273e-15
* device instance a_inv_mc_a_mb_mnab_y_mpa_y_mpb_y_nand_m_y_tg_s_a_y_dup4_t0 r0 *1 0,0
Ra_inv_mc_a_mb_mnab_y_mpa_y_mpb_y_nand_m_y_tg_s_a_y_dup4_t0
+ a\x7cinv_mc_a\x7cmb\x7cmnab_y\x7cmpa_y\x7cmpb_y\x7cnand_m_y\x7ctg_s_a\x7cy__t05
+ a|inv_mc_a|mb|mnab_y|mpa_y|mpb_y|nand_m_y|tg_s_a|y$4 246.866973374
* device instance a_inv_mc_a_mb_mnab_y_mpa_y_mpb_y_nand_m_y_tg_s_a_y_dup4_t1 r0 *1 0,0
Ra_inv_mc_a_mb_mnab_y_mpa_y_mpb_y_nand_m_y_tg_s_a_y_dup4_t1
+ a\x7cinv_mc_a\x7cmb\x7cmnab_y\x7cmpa_y\x7cmpb_y\x7cnand_m_y\x7ctg_s_a\x7cy__t15
+ a|inv_mc_a|mb|mnab_y|mpa_y|mpb_y|nand_m_y|tg_s_a|y$4 185.501222126
* device instance a_inv_mc_a_mb_mnab_y_mpa_y_mpb_y_nand_m_y_tg_s_a_y_dup4_t2 r0 *1 0,0
Ra_inv_mc_a_mb_mnab_y_mpa_y_mpb_y_nand_m_y_tg_s_a_y_dup4_t2
+ a\x7cinv_mc_a\x7cmb\x7cmnab_y\x7cmpa_y\x7cmpb_y\x7cnand_m_y\x7ctg_s_a\x7cy__t25
+ a|inv_mc_a|mb|mnab_y|mpa_y|mpb_y|nand_m_y|tg_s_a|y$4 244.54403591
* device instance a_inv_mc_a_mb_mnab_y_mpa_y_mpb_y_nand_m_y_tg_s_a_y_dup4_t3 r0 *1 0,0
Ra_inv_mc_a_mb_mnab_y_mpa_y_mpb_y_nand_m_y_tg_s_a_y_dup4_t3
+ a\x7cinv_mc_a\x7cmb\x7cmnab_y\x7cmpa_y\x7cmpb_y\x7cnand_m_y\x7ctg_s_a\x7cy__t35
+ a|inv_mc_a|mb|mnab_y|mpa_y|mpb_y|nand_m_y|tg_s_a|y$4 47.2529843038
* device instance a_inv_mc_a_mb_mnab_y_mpa_y_mpb_y_nand_m_y_tg_s_a_y_dup4_t4 r0 *1 0,0
Ra_inv_mc_a_mb_mnab_y_mpa_y_mpb_y_nand_m_y_tg_s_a_y_dup4_t4
+ a\x7cinv_mc_a\x7cmb\x7cmnab_y\x7cmpa_y\x7cmpb_y\x7cnand_m_y\x7ctg_s_a\x7cy__t45
+ a|inv_mc_a|mb|mnab_y|mpa_y|mpb_y|nand_m_y|tg_s_a|y$4 33.0352460576
* device instance a_inv_mc_a_mb_mnab_y_mpa_y_mpb_y_nand_m_y_tg_s_a_y_dup4_t5 r0 *1 0,0
Ra_inv_mc_a_mb_mnab_y_mpa_y_mpb_y_nand_m_y_tg_s_a_y_dup4_t5
+ a\x7cinv_mc_a\x7cmb\x7cmnab_y\x7cmpa_y\x7cmpb_y\x7cnand_m_y\x7ctg_s_a\x7cy__t55
+ a|inv_mc_a|mb|mnab_y|mpa_y|mpb_y|nand_m_y|tg_s_a|y$4 155.253663787
* device instance a_inv_mc_a_mb_mnab_y_mpa_y_mpb_y_nand_m_y_tg_s_a_y_dup4_t6 r0 *1 0,0
Ra_inv_mc_a_mb_mnab_y_mpa_y_mpb_y_nand_m_y_tg_s_a_y_dup4_t6
+ a\x7cinv_mc_a\x7cmb\x7cmnab_y\x7cmpa_y\x7cmpb_y\x7cnand_m_y\x7ctg_s_a\x7cy__t65
+ a|inv_mc_a|mb|mnab_y|mpa_y|mpb_y|nand_m_y|tg_s_a|y$4 167.430274441
* device instance a_inv_mc_a_mb_mnab_y_mpa_y_mpb_y_nand_m_y_tg_s_a_y_dup4 r0 *1 0,0
Ca_inv_mc_a_mb_mnab_y_mpa_y_mpb_y_nand_m_y_tg_s_a_y_dup4
+ a|inv_mc_a|mb|mnab_y|mpa_y|mpb_y|nand_m_y|tg_s_a|y$4 vsubs 4.01273e-15
* device instance a_inv_mc_a_mb_mnab_y_mpa_y_mpb_y_nand_m_y_tg_s_a_y_dup5_t0 r0 *1 0,0
Ra_inv_mc_a_mb_mnab_y_mpa_y_mpb_y_nand_m_y_tg_s_a_y_dup5_t0
+ a\x7cinv_mc_a\x7cmb\x7cmnab_y\x7cmpa_y\x7cmpb_y\x7cnand_m_y\x7ctg_s_a\x7cy__t06
+ a|inv_mc_a|mb|mnab_y|mpa_y|mpb_y|nand_m_y|tg_s_a|y$5 246.866973374
* device instance a_inv_mc_a_mb_mnab_y_mpa_y_mpb_y_nand_m_y_tg_s_a_y_dup5_t1 r0 *1 0,0
Ra_inv_mc_a_mb_mnab_y_mpa_y_mpb_y_nand_m_y_tg_s_a_y_dup5_t1
+ a\x7cinv_mc_a\x7cmb\x7cmnab_y\x7cmpa_y\x7cmpb_y\x7cnand_m_y\x7ctg_s_a\x7cy__t16
+ a|inv_mc_a|mb|mnab_y|mpa_y|mpb_y|nand_m_y|tg_s_a|y$5 244.54403591
* device instance a_inv_mc_a_mb_mnab_y_mpa_y_mpb_y_nand_m_y_tg_s_a_y_dup5_t2 r0 *1 0,0
Ra_inv_mc_a_mb_mnab_y_mpa_y_mpb_y_nand_m_y_tg_s_a_y_dup5_t2
+ a\x7cinv_mc_a\x7cmb\x7cmnab_y\x7cmpa_y\x7cmpb_y\x7cnand_m_y\x7ctg_s_a\x7cy__t26
+ a|inv_mc_a|mb|mnab_y|mpa_y|mpb_y|nand_m_y|tg_s_a|y$5 185.501222126
* device instance a_inv_mc_a_mb_mnab_y_mpa_y_mpb_y_nand_m_y_tg_s_a_y_dup5_t3 r0 *1 0,0
Ra_inv_mc_a_mb_mnab_y_mpa_y_mpb_y_nand_m_y_tg_s_a_y_dup5_t3
+ a\x7cinv_mc_a\x7cmb\x7cmnab_y\x7cmpa_y\x7cmpb_y\x7cnand_m_y\x7ctg_s_a\x7cy__t36
+ a|inv_mc_a|mb|mnab_y|mpa_y|mpb_y|nand_m_y|tg_s_a|y$5 47.2529843038
* device instance a_inv_mc_a_mb_mnab_y_mpa_y_mpb_y_nand_m_y_tg_s_a_y_dup5_t4 r0 *1 0,0
Ra_inv_mc_a_mb_mnab_y_mpa_y_mpb_y_nand_m_y_tg_s_a_y_dup5_t4
+ a\x7cinv_mc_a\x7cmb\x7cmnab_y\x7cmpa_y\x7cmpb_y\x7cnand_m_y\x7ctg_s_a\x7cy__t46
+ a|inv_mc_a|mb|mnab_y|mpa_y|mpb_y|nand_m_y|tg_s_a|y$5 33.0352460576
* device instance a_inv_mc_a_mb_mnab_y_mpa_y_mpb_y_nand_m_y_tg_s_a_y_dup5_t5 r0 *1 0,0
Ra_inv_mc_a_mb_mnab_y_mpa_y_mpb_y_nand_m_y_tg_s_a_y_dup5_t5
+ a\x7cinv_mc_a\x7cmb\x7cmnab_y\x7cmpa_y\x7cmpb_y\x7cnand_m_y\x7ctg_s_a\x7cy__t56
+ a|inv_mc_a|mb|mnab_y|mpa_y|mpb_y|nand_m_y|tg_s_a|y$5 155.253663787
* device instance a_inv_mc_a_mb_mnab_y_mpa_y_mpb_y_nand_m_y_tg_s_a_y_dup5_t6 r0 *1 0,0
Ra_inv_mc_a_mb_mnab_y_mpa_y_mpb_y_nand_m_y_tg_s_a_y_dup5_t6
+ a\x7cinv_mc_a\x7cmb\x7cmnab_y\x7cmpa_y\x7cmpb_y\x7cnand_m_y\x7ctg_s_a\x7cy__t66
+ a|inv_mc_a|mb|mnab_y|mpa_y|mpb_y|nand_m_y|tg_s_a|y$5 167.430274441
* device instance a_inv_mc_a_mb_mnab_y_mpa_y_mpb_y_nand_m_y_tg_s_a_y_dup5 r0 *1 0,0
Ca_inv_mc_a_mb_mnab_y_mpa_y_mpb_y_nand_m_y_tg_s_a_y_dup5
+ a|inv_mc_a|mb|mnab_y|mpa_y|mpb_y|nand_m_y|tg_s_a|y$5 vsubs 4.01273e-15
* device instance a_inv_mc_y_inv_mc_y_via_mc_tg_fbm_a_tg_fbm_a_via_y_t0 r0 *1 0,0
Ra_inv_mc_y_inv_mc_y_via_mc_tg_fbm_a_tg_fbm_a_via_y_t0
+ a\x7cinv_mc_y\x7cinv_mc_y_via\x7cmc\x7ctg_fbm_a\x7ctg_fbm_a_via\x7cy__t0
+ a|inv_mc_y|inv_mc_y_via|mc|tg_fbm_a|tg_fbm_a_via|y 214.9829
* device instance a_inv_mc_y_inv_mc_y_via_mc_tg_fbm_a_tg_fbm_a_via_y_t1 r0 *1 0,0
Ra_inv_mc_y_inv_mc_y_via_mc_tg_fbm_a_tg_fbm_a_via_y_t1
+ a\x7cinv_mc_y\x7cinv_mc_y_via\x7cmc\x7ctg_fbm_a\x7ctg_fbm_a_via\x7cy__t1
+ a|inv_mc_y|inv_mc_y_via|mc|tg_fbm_a|tg_fbm_a_via|y 214.9829
* device instance a_inv_mc_y_inv_mc_y_via_mc_tg_fbm_a_tg_fbm_a_via_y_t2 r0 *1 0,0
Ra_inv_mc_y_inv_mc_y_via_mc_tg_fbm_a_tg_fbm_a_via_y_t2
+ a\x7cinv_mc_y\x7cinv_mc_y_via\x7cmc\x7ctg_fbm_a\x7ctg_fbm_a_via\x7cy__t2
+ a|inv_mc_y|inv_mc_y_via|mc|tg_fbm_a|tg_fbm_a_via|y 214.9829
* device instance a_inv_mc_y_inv_mc_y_via_mc_tg_fbm_a_tg_fbm_a_via_y_t3 r0 *1 0,0
Ra_inv_mc_y_inv_mc_y_via_mc_tg_fbm_a_tg_fbm_a_via_y_t3
+ a\x7cinv_mc_y\x7cinv_mc_y_via\x7cmc\x7ctg_fbm_a\x7ctg_fbm_a_via\x7cy__t3
+ a|inv_mc_y|inv_mc_y_via|mc|tg_fbm_a|tg_fbm_a_via|y 214.9829
* device instance a_inv_mc_y_inv_mc_y_via_mc_tg_fbm_a_tg_fbm_a_via_y r0 *1 0,0
Ca_inv_mc_y_inv_mc_y_via_mc_tg_fbm_a_tg_fbm_a_via_y
+ a|inv_mc_y|inv_mc_y_via|mc|tg_fbm_a|tg_fbm_a_via|y vsubs 1.955756e-15
* device instance a_inv_mc_y_inv_mc_y_via_mc_tg_fbm_a_tg_fbm_a_via_y_dup1_t0 r0 *1 0,0
Ra_inv_mc_y_inv_mc_y_via_mc_tg_fbm_a_tg_fbm_a_via_y_dup1_t0
+ a\x7cinv_mc_y\x7cinv_mc_y_via\x7cmc\x7ctg_fbm_a\x7ctg_fbm_a_via\x7cy__t02
+ a|inv_mc_y|inv_mc_y_via|mc|tg_fbm_a|tg_fbm_a_via|y$1 214.9829
* device instance a_inv_mc_y_inv_mc_y_via_mc_tg_fbm_a_tg_fbm_a_via_y_dup1_t1 r0 *1 0,0
Ra_inv_mc_y_inv_mc_y_via_mc_tg_fbm_a_tg_fbm_a_via_y_dup1_t1
+ a\x7cinv_mc_y\x7cinv_mc_y_via\x7cmc\x7ctg_fbm_a\x7ctg_fbm_a_via\x7cy__t12
+ a|inv_mc_y|inv_mc_y_via|mc|tg_fbm_a|tg_fbm_a_via|y$1 214.9829
* device instance a_inv_mc_y_inv_mc_y_via_mc_tg_fbm_a_tg_fbm_a_via_y_dup1_t2 r0 *1 0,0
Ra_inv_mc_y_inv_mc_y_via_mc_tg_fbm_a_tg_fbm_a_via_y_dup1_t2
+ a\x7cinv_mc_y\x7cinv_mc_y_via\x7cmc\x7ctg_fbm_a\x7ctg_fbm_a_via\x7cy__t22
+ a|inv_mc_y|inv_mc_y_via|mc|tg_fbm_a|tg_fbm_a_via|y$1 214.9829
* device instance a_inv_mc_y_inv_mc_y_via_mc_tg_fbm_a_tg_fbm_a_via_y_dup1_t3 r0 *1 0,0
Ra_inv_mc_y_inv_mc_y_via_mc_tg_fbm_a_tg_fbm_a_via_y_dup1_t3
+ a\x7cinv_mc_y\x7cinv_mc_y_via\x7cmc\x7ctg_fbm_a\x7ctg_fbm_a_via\x7cy__t32
+ a|inv_mc_y|inv_mc_y_via|mc|tg_fbm_a|tg_fbm_a_via|y$1 214.9829
* device instance a_inv_mc_y_inv_mc_y_via_mc_tg_fbm_a_tg_fbm_a_via_y_dup1 r0 *1 0,0
Ca_inv_mc_y_inv_mc_y_via_mc_tg_fbm_a_tg_fbm_a_via_y_dup1
+ a|inv_mc_y|inv_mc_y_via|mc|tg_fbm_a|tg_fbm_a_via|y$1 vsubs 1.955756e-15
* device instance a_inv_mc_y_inv_mc_y_via_mc_tg_fbm_a_tg_fbm_a_via_y_dup2_t0 r0 *1 0,0
Ra_inv_mc_y_inv_mc_y_via_mc_tg_fbm_a_tg_fbm_a_via_y_dup2_t0
+ a\x7cinv_mc_y\x7cinv_mc_y_via\x7cmc\x7ctg_fbm_a\x7ctg_fbm_a_via\x7cy__t03
+ a|inv_mc_y|inv_mc_y_via|mc|tg_fbm_a|tg_fbm_a_via|y$2 214.9829
* device instance a_inv_mc_y_inv_mc_y_via_mc_tg_fbm_a_tg_fbm_a_via_y_dup2_t1 r0 *1 0,0
Ra_inv_mc_y_inv_mc_y_via_mc_tg_fbm_a_tg_fbm_a_via_y_dup2_t1
+ a\x7cinv_mc_y\x7cinv_mc_y_via\x7cmc\x7ctg_fbm_a\x7ctg_fbm_a_via\x7cy__t13
+ a|inv_mc_y|inv_mc_y_via|mc|tg_fbm_a|tg_fbm_a_via|y$2 214.9829
* device instance a_inv_mc_y_inv_mc_y_via_mc_tg_fbm_a_tg_fbm_a_via_y_dup2_t2 r0 *1 0,0
Ra_inv_mc_y_inv_mc_y_via_mc_tg_fbm_a_tg_fbm_a_via_y_dup2_t2
+ a\x7cinv_mc_y\x7cinv_mc_y_via\x7cmc\x7ctg_fbm_a\x7ctg_fbm_a_via\x7cy__t23
+ a|inv_mc_y|inv_mc_y_via|mc|tg_fbm_a|tg_fbm_a_via|y$2 214.9829
* device instance a_inv_mc_y_inv_mc_y_via_mc_tg_fbm_a_tg_fbm_a_via_y_dup2_t3 r0 *1 0,0
Ra_inv_mc_y_inv_mc_y_via_mc_tg_fbm_a_tg_fbm_a_via_y_dup2_t3
+ a\x7cinv_mc_y\x7cinv_mc_y_via\x7cmc\x7ctg_fbm_a\x7ctg_fbm_a_via\x7cy__t33
+ a|inv_mc_y|inv_mc_y_via|mc|tg_fbm_a|tg_fbm_a_via|y$2 214.9829
* device instance a_inv_mc_y_inv_mc_y_via_mc_tg_fbm_a_tg_fbm_a_via_y_dup2 r0 *1 0,0
Ca_inv_mc_y_inv_mc_y_via_mc_tg_fbm_a_tg_fbm_a_via_y_dup2
+ a|inv_mc_y|inv_mc_y_via|mc|tg_fbm_a|tg_fbm_a_via|y$2 vsubs 1.955756e-15
* device instance a_inv_mc_y_inv_mc_y_via_mc_tg_fbm_a_tg_fbm_a_via_y_dup3_t0 r0 *1 0,0
Ra_inv_mc_y_inv_mc_y_via_mc_tg_fbm_a_tg_fbm_a_via_y_dup3_t0
+ a\x7cinv_mc_y\x7cinv_mc_y_via\x7cmc\x7ctg_fbm_a\x7ctg_fbm_a_via\x7cy__t04
+ a|inv_mc_y|inv_mc_y_via|mc|tg_fbm_a|tg_fbm_a_via|y$3 214.9829
* device instance a_inv_mc_y_inv_mc_y_via_mc_tg_fbm_a_tg_fbm_a_via_y_dup3_t1 r0 *1 0,0
Ra_inv_mc_y_inv_mc_y_via_mc_tg_fbm_a_tg_fbm_a_via_y_dup3_t1
+ a\x7cinv_mc_y\x7cinv_mc_y_via\x7cmc\x7ctg_fbm_a\x7ctg_fbm_a_via\x7cy__t14
+ a|inv_mc_y|inv_mc_y_via|mc|tg_fbm_a|tg_fbm_a_via|y$3 214.9829
* device instance a_inv_mc_y_inv_mc_y_via_mc_tg_fbm_a_tg_fbm_a_via_y_dup3_t2 r0 *1 0,0
Ra_inv_mc_y_inv_mc_y_via_mc_tg_fbm_a_tg_fbm_a_via_y_dup3_t2
+ a\x7cinv_mc_y\x7cinv_mc_y_via\x7cmc\x7ctg_fbm_a\x7ctg_fbm_a_via\x7cy__t24
+ a|inv_mc_y|inv_mc_y_via|mc|tg_fbm_a|tg_fbm_a_via|y$3 214.9829
* device instance a_inv_mc_y_inv_mc_y_via_mc_tg_fbm_a_tg_fbm_a_via_y_dup3_t3 r0 *1 0,0
Ra_inv_mc_y_inv_mc_y_via_mc_tg_fbm_a_tg_fbm_a_via_y_dup3_t3
+ a\x7cinv_mc_y\x7cinv_mc_y_via\x7cmc\x7ctg_fbm_a\x7ctg_fbm_a_via\x7cy__t34
+ a|inv_mc_y|inv_mc_y_via|mc|tg_fbm_a|tg_fbm_a_via|y$3 214.9829
* device instance a_inv_mc_y_inv_mc_y_via_mc_tg_fbm_a_tg_fbm_a_via_y_dup3 r0 *1 0,0
Ca_inv_mc_y_inv_mc_y_via_mc_tg_fbm_a_tg_fbm_a_via_y_dup3
+ a|inv_mc_y|inv_mc_y_via|mc|tg_fbm_a|tg_fbm_a_via|y$3 vsubs 1.955756e-15
* device instance a_inv_mc_y_inv_mc_y_via_mc_tg_fbm_a_tg_fbm_a_via_y_dup4_t0 r0 *1 0,0
Ra_inv_mc_y_inv_mc_y_via_mc_tg_fbm_a_tg_fbm_a_via_y_dup4_t0
+ a\x7cinv_mc_y\x7cinv_mc_y_via\x7cmc\x7ctg_fbm_a\x7ctg_fbm_a_via\x7cy__t05
+ a|inv_mc_y|inv_mc_y_via|mc|tg_fbm_a|tg_fbm_a_via|y$4 214.9829
* device instance a_inv_mc_y_inv_mc_y_via_mc_tg_fbm_a_tg_fbm_a_via_y_dup4_t1 r0 *1 0,0
Ra_inv_mc_y_inv_mc_y_via_mc_tg_fbm_a_tg_fbm_a_via_y_dup4_t1
+ a\x7cinv_mc_y\x7cinv_mc_y_via\x7cmc\x7ctg_fbm_a\x7ctg_fbm_a_via\x7cy__t15
+ a|inv_mc_y|inv_mc_y_via|mc|tg_fbm_a|tg_fbm_a_via|y$4 214.9829
* device instance a_inv_mc_y_inv_mc_y_via_mc_tg_fbm_a_tg_fbm_a_via_y_dup4_t2 r0 *1 0,0
Ra_inv_mc_y_inv_mc_y_via_mc_tg_fbm_a_tg_fbm_a_via_y_dup4_t2
+ a\x7cinv_mc_y\x7cinv_mc_y_via\x7cmc\x7ctg_fbm_a\x7ctg_fbm_a_via\x7cy__t25
+ a|inv_mc_y|inv_mc_y_via|mc|tg_fbm_a|tg_fbm_a_via|y$4 214.9829
* device instance a_inv_mc_y_inv_mc_y_via_mc_tg_fbm_a_tg_fbm_a_via_y_dup4_t3 r0 *1 0,0
Ra_inv_mc_y_inv_mc_y_via_mc_tg_fbm_a_tg_fbm_a_via_y_dup4_t3
+ a\x7cinv_mc_y\x7cinv_mc_y_via\x7cmc\x7ctg_fbm_a\x7ctg_fbm_a_via\x7cy__t35
+ a|inv_mc_y|inv_mc_y_via|mc|tg_fbm_a|tg_fbm_a_via|y$4 214.9829
* device instance a_inv_mc_y_inv_mc_y_via_mc_tg_fbm_a_tg_fbm_a_via_y_dup4 r0 *1 0,0
Ca_inv_mc_y_inv_mc_y_via_mc_tg_fbm_a_tg_fbm_a_via_y_dup4
+ a|inv_mc_y|inv_mc_y_via|mc|tg_fbm_a|tg_fbm_a_via|y$4 vsubs 1.955756e-15
* device instance a_inv_mc_y_inv_mc_y_via_mc_tg_fbm_a_tg_fbm_a_via_y_dup5_t0 r0 *1 0,0
Ra_inv_mc_y_inv_mc_y_via_mc_tg_fbm_a_tg_fbm_a_via_y_dup5_t0
+ a\x7cinv_mc_y\x7cinv_mc_y_via\x7cmc\x7ctg_fbm_a\x7ctg_fbm_a_via\x7cy__t06
+ a|inv_mc_y|inv_mc_y_via|mc|tg_fbm_a|tg_fbm_a_via|y$5 214.9829
* device instance a_inv_mc_y_inv_mc_y_via_mc_tg_fbm_a_tg_fbm_a_via_y_dup5_t1 r0 *1 0,0
Ra_inv_mc_y_inv_mc_y_via_mc_tg_fbm_a_tg_fbm_a_via_y_dup5_t1
+ a\x7cinv_mc_y\x7cinv_mc_y_via\x7cmc\x7ctg_fbm_a\x7ctg_fbm_a_via\x7cy__t16
+ a|inv_mc_y|inv_mc_y_via|mc|tg_fbm_a|tg_fbm_a_via|y$5 214.9829
* device instance a_inv_mc_y_inv_mc_y_via_mc_tg_fbm_a_tg_fbm_a_via_y_dup5_t2 r0 *1 0,0
Ra_inv_mc_y_inv_mc_y_via_mc_tg_fbm_a_tg_fbm_a_via_y_dup5_t2
+ a\x7cinv_mc_y\x7cinv_mc_y_via\x7cmc\x7ctg_fbm_a\x7ctg_fbm_a_via\x7cy__t26
+ a|inv_mc_y|inv_mc_y_via|mc|tg_fbm_a|tg_fbm_a_via|y$5 214.9829
* device instance a_inv_mc_y_inv_mc_y_via_mc_tg_fbm_a_tg_fbm_a_via_y_dup5_t3 r0 *1 0,0
Ra_inv_mc_y_inv_mc_y_via_mc_tg_fbm_a_tg_fbm_a_via_y_dup5_t3
+ a\x7cinv_mc_y\x7cinv_mc_y_via\x7cmc\x7ctg_fbm_a\x7ctg_fbm_a_via\x7cy__t36
+ a|inv_mc_y|inv_mc_y_via|mc|tg_fbm_a|tg_fbm_a_via|y$5 214.9829
* device instance a_inv_mc_y_inv_mc_y_via_mc_tg_fbm_a_tg_fbm_a_via_y_dup5 r0 *1 0,0
Ca_inv_mc_y_inv_mc_y_via_mc_tg_fbm_a_tg_fbm_a_via_y_dup5
+ a|inv_mc_y|inv_mc_y_via|mc|tg_fbm_a|tg_fbm_a_via|y$5 vsubs 1.955756e-15
* device instance a_inv_q_y_inv_q_y_via_inv_q_y_via2_nand_s2_a_nand_s2_a_stub_nand_s2_a_via_nand_s2_a_via2_q_y_t0 r0 *1 0,0
Ra_inv_q_y_inv_q_y_via_inv_q_y_via2_nand_s2_a_nand_s2_a_stub_nand_s2_a_via_nand_s2_a_via2_q_y_t0
+ a\x7cinv_q_y\x7cinv_q_y_via\x7cinv_q_y_via2\x7cnand_s2_a\x7cnand_s2_a_stub\x7cnand_s2_a_via\x7cnand_s2_a_via2\x7cq\x7cy__t0
+ a|inv_q_y|inv_q_y_via|inv_q_y_via2|nand_s2_a|nand_s2_a_stub|nand_s2_a_via|nand_s2_a_via2|q|y
+ 245.658725457
* device instance a_inv_q_y_inv_q_y_via_inv_q_y_via2_nand_s2_a_nand_s2_a_stub_nand_s2_a_via_nand_s2_a_via2_q_y_t1 r0 *1 0,0
Ra_inv_q_y_inv_q_y_via_inv_q_y_via2_nand_s2_a_nand_s2_a_stub_nand_s2_a_via_nand_s2_a_via2_q_y_t1
+ a\x7cinv_q_y\x7cinv_q_y_via\x7cinv_q_y_via2\x7cnand_s2_a\x7cnand_s2_a_stub\x7cnand_s2_a_via\x7cnand_s2_a_via2\x7cq\x7cy__t1
+ a|inv_q_y|inv_q_y_via|inv_q_y_via2|nand_s2_a|nand_s2_a_stub|nand_s2_a_via|nand_s2_a_via2|q|y
+ 243.131837768
* device instance a_inv_q_y_inv_q_y_via_inv_q_y_via2_nand_s2_a_nand_s2_a_stub_nand_s2_a_via_nand_s2_a_via2_q_y_t2 r0 *1 0,0
Ra_inv_q_y_inv_q_y_via_inv_q_y_via2_nand_s2_a_nand_s2_a_stub_nand_s2_a_via_nand_s2_a_via2_q_y_t2
+ a\x7cinv_q_y\x7cinv_q_y_via\x7cinv_q_y_via2\x7cnand_s2_a\x7cnand_s2_a_stub\x7cnand_s2_a_via\x7cnand_s2_a_via2\x7cq\x7cy__t2
+ a|inv_q_y|inv_q_y_via|inv_q_y_via2|nand_s2_a|nand_s2_a_stub|nand_s2_a_via|nand_s2_a_via2|q|y
+ 259.625692045
* device instance a_inv_q_y_inv_q_y_via_inv_q_y_via2_nand_s2_a_nand_s2_a_stub_nand_s2_a_via_nand_s2_a_via2_q_y_t3 r0 *1 0,0
Ra_inv_q_y_inv_q_y_via_inv_q_y_via2_nand_s2_a_nand_s2_a_stub_nand_s2_a_via_nand_s2_a_via2_q_y_t3
+ a\x7cinv_q_y\x7cinv_q_y_via\x7cinv_q_y_via2\x7cnand_s2_a\x7cnand_s2_a_stub\x7cnand_s2_a_via\x7cnand_s2_a_via2\x7cq\x7cy__t3
+ a|inv_q_y|inv_q_y_via|inv_q_y_via2|nand_s2_a|nand_s2_a_stub|nand_s2_a_via|nand_s2_a_via2|q|y
+ 234.34304473
* device instance a_inv_q_y_inv_q_y_via_inv_q_y_via2_nand_s2_a_nand_s2_a_stub_nand_s2_a_via_nand_s2_a_via2_q_y r0 *1 0,0
Ca_inv_q_y_inv_q_y_via_inv_q_y_via2_nand_s2_a_nand_s2_a_stub_nand_s2_a_via_nand_s2_a_via2_q_y
+ a|inv_q_y|inv_q_y_via|inv_q_y_via2|nand_s2_a|nand_s2_a_stub|nand_s2_a_via|nand_s2_a_via2|q|y
+ vsubs 2.217373e-15
* device instance a_inv_q_y_inv_q_y_via_inv_q_y_via2_nand_s2_a_nand_s2_a_stub_nand_s2_a_via_nand_s2_a_via2_q_y_dup1_t0 r0 *1 0,0
Ra_inv_q_y_inv_q_y_via_inv_q_y_via2_nand_s2_a_nand_s2_a_stub_nand_s2_a_via_nand_s2_a_via2_q_y_dup1_t0
+ a\x7cinv_q_y\x7cinv_q_y_via\x7cinv_q_y_via2\x7cnand_s2_a\x7cnand_s2_a_stub\x7cnand_s2_a_via\x7cnand_s2_a_via2\x7cq\x7cy__t02
+ a|inv_q_y|inv_q_y_via|inv_q_y_via2|nand_s2_a|nand_s2_a_stub|nand_s2_a_via|nand_s2_a_via2|q|y$1
+ 245.658725457
* device instance a_inv_q_y_inv_q_y_via_inv_q_y_via2_nand_s2_a_nand_s2_a_stub_nand_s2_a_via_nand_s2_a_via2_q_y_dup1_t1 r0 *1 0,0
Ra_inv_q_y_inv_q_y_via_inv_q_y_via2_nand_s2_a_nand_s2_a_stub_nand_s2_a_via_nand_s2_a_via2_q_y_dup1_t1
+ a\x7cinv_q_y\x7cinv_q_y_via\x7cinv_q_y_via2\x7cnand_s2_a\x7cnand_s2_a_stub\x7cnand_s2_a_via\x7cnand_s2_a_via2\x7cq\x7cy__t12
+ a|inv_q_y|inv_q_y_via|inv_q_y_via2|nand_s2_a|nand_s2_a_stub|nand_s2_a_via|nand_s2_a_via2|q|y$1
+ 243.131837768
* device instance a_inv_q_y_inv_q_y_via_inv_q_y_via2_nand_s2_a_nand_s2_a_stub_nand_s2_a_via_nand_s2_a_via2_q_y_dup1_t2 r0 *1 0,0
Ra_inv_q_y_inv_q_y_via_inv_q_y_via2_nand_s2_a_nand_s2_a_stub_nand_s2_a_via_nand_s2_a_via2_q_y_dup1_t2
+ a\x7cinv_q_y\x7cinv_q_y_via\x7cinv_q_y_via2\x7cnand_s2_a\x7cnand_s2_a_stub\x7cnand_s2_a_via\x7cnand_s2_a_via2\x7cq\x7cy__t22
+ a|inv_q_y|inv_q_y_via|inv_q_y_via2|nand_s2_a|nand_s2_a_stub|nand_s2_a_via|nand_s2_a_via2|q|y$1
+ 259.625692045
* device instance a_inv_q_y_inv_q_y_via_inv_q_y_via2_nand_s2_a_nand_s2_a_stub_nand_s2_a_via_nand_s2_a_via2_q_y_dup1_t3 r0 *1 0,0
Ra_inv_q_y_inv_q_y_via_inv_q_y_via2_nand_s2_a_nand_s2_a_stub_nand_s2_a_via_nand_s2_a_via2_q_y_dup1_t3
+ a\x7cinv_q_y\x7cinv_q_y_via\x7cinv_q_y_via2\x7cnand_s2_a\x7cnand_s2_a_stub\x7cnand_s2_a_via\x7cnand_s2_a_via2\x7cq\x7cy__t32
+ a|inv_q_y|inv_q_y_via|inv_q_y_via2|nand_s2_a|nand_s2_a_stub|nand_s2_a_via|nand_s2_a_via2|q|y$1
+ 234.34304473
* device instance a_inv_q_y_inv_q_y_via_inv_q_y_via2_nand_s2_a_nand_s2_a_stub_nand_s2_a_via_nand_s2_a_via2_q_y_dup1 r0 *1 0,0
Ca_inv_q_y_inv_q_y_via_inv_q_y_via2_nand_s2_a_nand_s2_a_stub_nand_s2_a_via_nand_s2_a_via2_q_y_dup1
+ a|inv_q_y|inv_q_y_via|inv_q_y_via2|nand_s2_a|nand_s2_a_stub|nand_s2_a_via|nand_s2_a_via2|q|y$1
+ vsubs 2.217373e-15
* device instance a_inv_q_y_inv_q_y_via_inv_q_y_via2_nand_s2_a_nand_s2_a_stub_nand_s2_a_via_nand_s2_a_via2_q_y_dup2_t0 r0 *1 0,0
Ra_inv_q_y_inv_q_y_via_inv_q_y_via2_nand_s2_a_nand_s2_a_stub_nand_s2_a_via_nand_s2_a_via2_q_y_dup2_t0
+ a\x7cinv_q_y\x7cinv_q_y_via\x7cinv_q_y_via2\x7cnand_s2_a\x7cnand_s2_a_stub\x7cnand_s2_a_via\x7cnand_s2_a_via2\x7cq\x7cy__t03
+ a|inv_q_y|inv_q_y_via|inv_q_y_via2|nand_s2_a|nand_s2_a_stub|nand_s2_a_via|nand_s2_a_via2|q|y$2
+ 245.658725457
* device instance a_inv_q_y_inv_q_y_via_inv_q_y_via2_nand_s2_a_nand_s2_a_stub_nand_s2_a_via_nand_s2_a_via2_q_y_dup2_t1 r0 *1 0,0
Ra_inv_q_y_inv_q_y_via_inv_q_y_via2_nand_s2_a_nand_s2_a_stub_nand_s2_a_via_nand_s2_a_via2_q_y_dup2_t1
+ a\x7cinv_q_y\x7cinv_q_y_via\x7cinv_q_y_via2\x7cnand_s2_a\x7cnand_s2_a_stub\x7cnand_s2_a_via\x7cnand_s2_a_via2\x7cq\x7cy__t13
+ a|inv_q_y|inv_q_y_via|inv_q_y_via2|nand_s2_a|nand_s2_a_stub|nand_s2_a_via|nand_s2_a_via2|q|y$2
+ 243.131837768
* device instance a_inv_q_y_inv_q_y_via_inv_q_y_via2_nand_s2_a_nand_s2_a_stub_nand_s2_a_via_nand_s2_a_via2_q_y_dup2_t2 r0 *1 0,0
Ra_inv_q_y_inv_q_y_via_inv_q_y_via2_nand_s2_a_nand_s2_a_stub_nand_s2_a_via_nand_s2_a_via2_q_y_dup2_t2
+ a\x7cinv_q_y\x7cinv_q_y_via\x7cinv_q_y_via2\x7cnand_s2_a\x7cnand_s2_a_stub\x7cnand_s2_a_via\x7cnand_s2_a_via2\x7cq\x7cy__t23
+ a|inv_q_y|inv_q_y_via|inv_q_y_via2|nand_s2_a|nand_s2_a_stub|nand_s2_a_via|nand_s2_a_via2|q|y$2
+ 259.625692045
* device instance a_inv_q_y_inv_q_y_via_inv_q_y_via2_nand_s2_a_nand_s2_a_stub_nand_s2_a_via_nand_s2_a_via2_q_y_dup2_t3 r0 *1 0,0
Ra_inv_q_y_inv_q_y_via_inv_q_y_via2_nand_s2_a_nand_s2_a_stub_nand_s2_a_via_nand_s2_a_via2_q_y_dup2_t3
+ a\x7cinv_q_y\x7cinv_q_y_via\x7cinv_q_y_via2\x7cnand_s2_a\x7cnand_s2_a_stub\x7cnand_s2_a_via\x7cnand_s2_a_via2\x7cq\x7cy__t33
+ a|inv_q_y|inv_q_y_via|inv_q_y_via2|nand_s2_a|nand_s2_a_stub|nand_s2_a_via|nand_s2_a_via2|q|y$2
+ 234.34304473
* device instance a_inv_q_y_inv_q_y_via_inv_q_y_via2_nand_s2_a_nand_s2_a_stub_nand_s2_a_via_nand_s2_a_via2_q_y_dup2 r0 *1 0,0
Ca_inv_q_y_inv_q_y_via_inv_q_y_via2_nand_s2_a_nand_s2_a_stub_nand_s2_a_via_nand_s2_a_via2_q_y_dup2
+ a|inv_q_y|inv_q_y_via|inv_q_y_via2|nand_s2_a|nand_s2_a_stub|nand_s2_a_via|nand_s2_a_via2|q|y$2
+ vsubs 2.217373e-15
* device instance a_inv_q_y_inv_q_y_via_inv_q_y_via2_nand_s2_a_nand_s2_a_stub_nand_s2_a_via_nand_s2_a_via2_q_y_dup3_t0 r0 *1 0,0
Ra_inv_q_y_inv_q_y_via_inv_q_y_via2_nand_s2_a_nand_s2_a_stub_nand_s2_a_via_nand_s2_a_via2_q_y_dup3_t0
+ a\x7cinv_q_y\x7cinv_q_y_via\x7cinv_q_y_via2\x7cnand_s2_a\x7cnand_s2_a_stub\x7cnand_s2_a_via\x7cnand_s2_a_via2\x7cq\x7cy__t04
+ a|inv_q_y|inv_q_y_via|inv_q_y_via2|nand_s2_a|nand_s2_a_stub|nand_s2_a_via|nand_s2_a_via2|q|y$3
+ 245.658725457
* device instance a_inv_q_y_inv_q_y_via_inv_q_y_via2_nand_s2_a_nand_s2_a_stub_nand_s2_a_via_nand_s2_a_via2_q_y_dup3_t1 r0 *1 0,0
Ra_inv_q_y_inv_q_y_via_inv_q_y_via2_nand_s2_a_nand_s2_a_stub_nand_s2_a_via_nand_s2_a_via2_q_y_dup3_t1
+ a\x7cinv_q_y\x7cinv_q_y_via\x7cinv_q_y_via2\x7cnand_s2_a\x7cnand_s2_a_stub\x7cnand_s2_a_via\x7cnand_s2_a_via2\x7cq\x7cy__t14
+ a|inv_q_y|inv_q_y_via|inv_q_y_via2|nand_s2_a|nand_s2_a_stub|nand_s2_a_via|nand_s2_a_via2|q|y$3
+ 243.131837768
* device instance a_inv_q_y_inv_q_y_via_inv_q_y_via2_nand_s2_a_nand_s2_a_stub_nand_s2_a_via_nand_s2_a_via2_q_y_dup3_t2 r0 *1 0,0
Ra_inv_q_y_inv_q_y_via_inv_q_y_via2_nand_s2_a_nand_s2_a_stub_nand_s2_a_via_nand_s2_a_via2_q_y_dup3_t2
+ a\x7cinv_q_y\x7cinv_q_y_via\x7cinv_q_y_via2\x7cnand_s2_a\x7cnand_s2_a_stub\x7cnand_s2_a_via\x7cnand_s2_a_via2\x7cq\x7cy__t24
+ a|inv_q_y|inv_q_y_via|inv_q_y_via2|nand_s2_a|nand_s2_a_stub|nand_s2_a_via|nand_s2_a_via2|q|y$3
+ 259.625692045
* device instance a_inv_q_y_inv_q_y_via_inv_q_y_via2_nand_s2_a_nand_s2_a_stub_nand_s2_a_via_nand_s2_a_via2_q_y_dup3_t3 r0 *1 0,0
Ra_inv_q_y_inv_q_y_via_inv_q_y_via2_nand_s2_a_nand_s2_a_stub_nand_s2_a_via_nand_s2_a_via2_q_y_dup3_t3
+ a\x7cinv_q_y\x7cinv_q_y_via\x7cinv_q_y_via2\x7cnand_s2_a\x7cnand_s2_a_stub\x7cnand_s2_a_via\x7cnand_s2_a_via2\x7cq\x7cy__t34
+ a|inv_q_y|inv_q_y_via|inv_q_y_via2|nand_s2_a|nand_s2_a_stub|nand_s2_a_via|nand_s2_a_via2|q|y$3
+ 234.34304473
* device instance a_inv_q_y_inv_q_y_via_inv_q_y_via2_nand_s2_a_nand_s2_a_stub_nand_s2_a_via_nand_s2_a_via2_q_y_dup3 r0 *1 0,0
Ca_inv_q_y_inv_q_y_via_inv_q_y_via2_nand_s2_a_nand_s2_a_stub_nand_s2_a_via_nand_s2_a_via2_q_y_dup3
+ a|inv_q_y|inv_q_y_via|inv_q_y_via2|nand_s2_a|nand_s2_a_stub|nand_s2_a_via|nand_s2_a_via2|q|y$3
+ vsubs 2.217373e-15
* device instance a_inv_q_y_inv_q_y_via_inv_q_y_via2_nand_s2_a_nand_s2_a_stub_nand_s2_a_via_nand_s2_a_via2_q_y_dup4_t0 r0 *1 0,0
Ra_inv_q_y_inv_q_y_via_inv_q_y_via2_nand_s2_a_nand_s2_a_stub_nand_s2_a_via_nand_s2_a_via2_q_y_dup4_t0
+ a\x7cinv_q_y\x7cinv_q_y_via\x7cinv_q_y_via2\x7cnand_s2_a\x7cnand_s2_a_stub\x7cnand_s2_a_via\x7cnand_s2_a_via2\x7cq\x7cy__t05
+ a|inv_q_y|inv_q_y_via|inv_q_y_via2|nand_s2_a|nand_s2_a_stub|nand_s2_a_via|nand_s2_a_via2|q|y$4
+ 245.658725457
* device instance a_inv_q_y_inv_q_y_via_inv_q_y_via2_nand_s2_a_nand_s2_a_stub_nand_s2_a_via_nand_s2_a_via2_q_y_dup4_t1 r0 *1 0,0
Ra_inv_q_y_inv_q_y_via_inv_q_y_via2_nand_s2_a_nand_s2_a_stub_nand_s2_a_via_nand_s2_a_via2_q_y_dup4_t1
+ a\x7cinv_q_y\x7cinv_q_y_via\x7cinv_q_y_via2\x7cnand_s2_a\x7cnand_s2_a_stub\x7cnand_s2_a_via\x7cnand_s2_a_via2\x7cq\x7cy__t15
+ a|inv_q_y|inv_q_y_via|inv_q_y_via2|nand_s2_a|nand_s2_a_stub|nand_s2_a_via|nand_s2_a_via2|q|y$4
+ 243.131837768
* device instance a_inv_q_y_inv_q_y_via_inv_q_y_via2_nand_s2_a_nand_s2_a_stub_nand_s2_a_via_nand_s2_a_via2_q_y_dup4_t2 r0 *1 0,0
Ra_inv_q_y_inv_q_y_via_inv_q_y_via2_nand_s2_a_nand_s2_a_stub_nand_s2_a_via_nand_s2_a_via2_q_y_dup4_t2
+ a\x7cinv_q_y\x7cinv_q_y_via\x7cinv_q_y_via2\x7cnand_s2_a\x7cnand_s2_a_stub\x7cnand_s2_a_via\x7cnand_s2_a_via2\x7cq\x7cy__t25
+ a|inv_q_y|inv_q_y_via|inv_q_y_via2|nand_s2_a|nand_s2_a_stub|nand_s2_a_via|nand_s2_a_via2|q|y$4
+ 259.625692045
* device instance a_inv_q_y_inv_q_y_via_inv_q_y_via2_nand_s2_a_nand_s2_a_stub_nand_s2_a_via_nand_s2_a_via2_q_y_dup4_t3 r0 *1 0,0
Ra_inv_q_y_inv_q_y_via_inv_q_y_via2_nand_s2_a_nand_s2_a_stub_nand_s2_a_via_nand_s2_a_via2_q_y_dup4_t3
+ a\x7cinv_q_y\x7cinv_q_y_via\x7cinv_q_y_via2\x7cnand_s2_a\x7cnand_s2_a_stub\x7cnand_s2_a_via\x7cnand_s2_a_via2\x7cq\x7cy__t35
+ a|inv_q_y|inv_q_y_via|inv_q_y_via2|nand_s2_a|nand_s2_a_stub|nand_s2_a_via|nand_s2_a_via2|q|y$4
+ 234.34304473
* device instance a_inv_q_y_inv_q_y_via_inv_q_y_via2_nand_s2_a_nand_s2_a_stub_nand_s2_a_via_nand_s2_a_via2_q_y_dup4 r0 *1 0,0
Ca_inv_q_y_inv_q_y_via_inv_q_y_via2_nand_s2_a_nand_s2_a_stub_nand_s2_a_via_nand_s2_a_via2_q_y_dup4
+ a|inv_q_y|inv_q_y_via|inv_q_y_via2|nand_s2_a|nand_s2_a_stub|nand_s2_a_via|nand_s2_a_via2|q|y$4
+ vsubs 2.217373e-15
* device instance a_inv_q_y_inv_q_y_via_inv_q_y_via2_nand_s2_a_nand_s2_a_stub_nand_s2_a_via_nand_s2_a_via2_q_y_dup5_t0 r0 *1 0,0
Ra_inv_q_y_inv_q_y_via_inv_q_y_via2_nand_s2_a_nand_s2_a_stub_nand_s2_a_via_nand_s2_a_via2_q_y_dup5_t0
+ a\x7cinv_q_y\x7cinv_q_y_via\x7cinv_q_y_via2\x7cnand_s2_a\x7cnand_s2_a_stub\x7cnand_s2_a_via\x7cnand_s2_a_via2\x7cq\x7cy__t06
+ a|inv_q_y|inv_q_y_via|inv_q_y_via2|nand_s2_a|nand_s2_a_stub|nand_s2_a_via|nand_s2_a_via2|q|y$5
+ 245.658725457
* device instance a_inv_q_y_inv_q_y_via_inv_q_y_via2_nand_s2_a_nand_s2_a_stub_nand_s2_a_via_nand_s2_a_via2_q_y_dup5_t1 r0 *1 0,0
Ra_inv_q_y_inv_q_y_via_inv_q_y_via2_nand_s2_a_nand_s2_a_stub_nand_s2_a_via_nand_s2_a_via2_q_y_dup5_t1
+ a\x7cinv_q_y\x7cinv_q_y_via\x7cinv_q_y_via2\x7cnand_s2_a\x7cnand_s2_a_stub\x7cnand_s2_a_via\x7cnand_s2_a_via2\x7cq\x7cy__t16
+ a|inv_q_y|inv_q_y_via|inv_q_y_via2|nand_s2_a|nand_s2_a_stub|nand_s2_a_via|nand_s2_a_via2|q|y$5
+ 243.131837768
* device instance a_inv_q_y_inv_q_y_via_inv_q_y_via2_nand_s2_a_nand_s2_a_stub_nand_s2_a_via_nand_s2_a_via2_q_y_dup5_t2 r0 *1 0,0
Ra_inv_q_y_inv_q_y_via_inv_q_y_via2_nand_s2_a_nand_s2_a_stub_nand_s2_a_via_nand_s2_a_via2_q_y_dup5_t2
+ a\x7cinv_q_y\x7cinv_q_y_via\x7cinv_q_y_via2\x7cnand_s2_a\x7cnand_s2_a_stub\x7cnand_s2_a_via\x7cnand_s2_a_via2\x7cq\x7cy__t26
+ a|inv_q_y|inv_q_y_via|inv_q_y_via2|nand_s2_a|nand_s2_a_stub|nand_s2_a_via|nand_s2_a_via2|q|y$5
+ 259.625692045
* device instance a_inv_q_y_inv_q_y_via_inv_q_y_via2_nand_s2_a_nand_s2_a_stub_nand_s2_a_via_nand_s2_a_via2_q_y_dup5_t3 r0 *1 0,0
Ra_inv_q_y_inv_q_y_via_inv_q_y_via2_nand_s2_a_nand_s2_a_stub_nand_s2_a_via_nand_s2_a_via2_q_y_dup5_t3
+ a\x7cinv_q_y\x7cinv_q_y_via\x7cinv_q_y_via2\x7cnand_s2_a\x7cnand_s2_a_stub\x7cnand_s2_a_via\x7cnand_s2_a_via2\x7cq\x7cy__t36
+ a|inv_q_y|inv_q_y_via|inv_q_y_via2|nand_s2_a|nand_s2_a_stub|nand_s2_a_via|nand_s2_a_via2|q|y$5
+ 234.34304473
* device instance a_inv_q_y_inv_q_y_via_inv_q_y_via2_nand_s2_a_nand_s2_a_stub_nand_s2_a_via_nand_s2_a_via2_q_y_dup5 r0 *1 0,0
Ca_inv_q_y_inv_q_y_via_inv_q_y_via2_nand_s2_a_nand_s2_a_stub_nand_s2_a_via_nand_s2_a_via2_q_y_dup5
+ a|inv_q_y|inv_q_y_via|inv_q_y_via2|nand_s2_a|nand_s2_a_stub|nand_s2_a_via|nand_s2_a_via2|q|y$5
+ vsubs 2.217373e-15
* device instance a_inva_a_mn12_g0_mp13_g0_t1_y_t0 r0 *1 0,0
Ra_inva_a_mn12_g0_mp13_g0_t1_y_t0
+ a\x7cinva_a\x7cmn12_g0\x7cmp13_g0\x7ct1\x7cy__t0
+ a|inva_a|mn12_g0|mp13_g0|t1|y 419.786258702
* device instance a_inva_a_mn12_g0_mp13_g0_t1_y_t1 r0 *1 0,0
Ra_inva_a_mn12_g0_mp13_g0_t1_y_t1
+ a\x7cinva_a\x7cmn12_g0\x7cmp13_g0\x7ct1\x7cy__t1
+ a|inva_a|mn12_g0|mp13_g0|t1|y 378.589153398
* device instance a_inva_a_mn12_g0_mp13_g0_t1_y_t2 r0 *1 0,0
Ra_inva_a_mn12_g0_mp13_g0_t1_y_t2
+ a\x7cinva_a\x7cmn12_g0\x7cmp13_g0\x7ct1\x7cy__t2
+ a|inva_a|mn12_g0|mp13_g0|t1|y 332.607504746
* device instance a_inva_a_mn12_g0_mp13_g0_t1_y_t3 r0 *1 0,0
Ra_inva_a_mn12_g0_mp13_g0_t1_y_t3
+ a\x7cinva_a\x7cmn12_g0\x7cmp13_g0\x7ct1\x7cy__t3
+ a|inva_a|mn12_g0|mp13_g0|t1|y 318.770323812
* device instance a_inva_a_mn12_g0_mp13_g0_t1_y_t4 r0 *1 0,0
Ra_inva_a_mn12_g0_mp13_g0_t1_y_t4
+ a\x7cinva_a\x7cmn12_g0\x7cmp13_g0\x7ct1\x7cy__t4
+ a|inva_a|mn12_g0|mp13_g0|t1|y 317.26897702
* device instance a_inva_a_mn12_g0_mp13_g0_t1_y_t5 r0 *1 0,0
Ra_inva_a_mn12_g0_mp13_g0_t1_y_t5
+ a\x7cinva_a\x7cmn12_g0\x7cmp13_g0\x7ct1\x7cy__t5
+ a|inva_a|mn12_g0|mp13_g0|t1|y 476.903687784
* device instance a_inva_a_mn12_g0_mp13_g0_t1_y_t6 r0 *1 0,0
Ra_inva_a_mn12_g0_mp13_g0_t1_y_t6
+ a\x7cinva_a\x7cmn12_g0\x7cmp13_g0\x7ct1\x7cy__t6
+ a|inva_a|mn12_g0|mp13_g0|t1|y 422.977502385
* device instance a_inva_a_mn12_g0_mp13_g0_t1_y_t7 r0 *1 0,0
Ra_inva_a_mn12_g0_mp13_g0_t1_y_t7
+ a\x7cinva_a\x7cmn12_g0\x7cmp13_g0\x7ct1\x7cy__t7
+ a|inva_a|mn12_g0|mp13_g0|t1|y 328.474792154
* device instance a_inva_a_mn12_g0_mp13_g0_t1_y r0 *1 0,0
Ca_inva_a_mn12_g0_mp13_g0_t1_y a|inva_a|mn12_g0|mp13_g0|t1|y vsubs 1.2916904e-14
* device instance a_mnab_y_mpa_y_mpb_y_nand_s2_y_qb_tg_fbs_a_y_t0 r0 *1 0,0
Ra_mnab_y_mpa_y_mpb_y_nand_s2_y_qb_tg_fbs_a_y_t0
+ a\x7cmnab_y\x7cmpa_y\x7cmpb_y\x7cnand_s2_y\x7cqb\x7ctg_fbs_a\x7cy__t0
+ a|mnab_y|mpa_y|mpb_y|nand_s2_y|qb|tg_fbs_a|y 141.656603839
* device instance a_mnab_y_mpa_y_mpb_y_nand_s2_y_qb_tg_fbs_a_y_t1 r0 *1 0,0
Ra_mnab_y_mpa_y_mpb_y_nand_s2_y_qb_tg_fbs_a_y_t1
+ a\x7cmnab_y\x7cmpa_y\x7cmpb_y\x7cnand_s2_y\x7cqb\x7ctg_fbs_a\x7cy__t1
+ a|mnab_y|mpa_y|mpb_y|nand_s2_y|qb|tg_fbs_a|y 127.509506058
* device instance a_mnab_y_mpa_y_mpb_y_nand_s2_y_qb_tg_fbs_a_y_t2 r0 *1 0,0
Ra_mnab_y_mpa_y_mpb_y_nand_s2_y_qb_tg_fbs_a_y_t2
+ a\x7cmnab_y\x7cmpa_y\x7cmpb_y\x7cnand_s2_y\x7cqb\x7ctg_fbs_a\x7cy__t2
+ a|mnab_y|mpa_y|mpb_y|nand_s2_y|qb|tg_fbs_a|y 118.925454613
* device instance a_mnab_y_mpa_y_mpb_y_nand_s2_y_qb_tg_fbs_a_y_t3 r0 *1 0,0
Ra_mnab_y_mpa_y_mpb_y_nand_s2_y_qb_tg_fbs_a_y_t3
+ a\x7cmnab_y\x7cmpa_y\x7cmpb_y\x7cnand_s2_y\x7cqb\x7ctg_fbs_a\x7cy__t3
+ a|mnab_y|mpa_y|mpb_y|nand_s2_y|qb|tg_fbs_a|y 79.2876741218
* device instance a_mnab_y_mpa_y_mpb_y_nand_s2_y_qb_tg_fbs_a_y_t4 r0 *1 0,0
Ra_mnab_y_mpa_y_mpb_y_nand_s2_y_qb_tg_fbs_a_y_t4
+ a\x7cmnab_y\x7cmpa_y\x7cmpb_y\x7cnand_s2_y\x7cqb\x7ctg_fbs_a\x7cy__t4
+ a|mnab_y|mpa_y|mpb_y|nand_s2_y|qb|tg_fbs_a|y 106.619261369
* device instance a_mnab_y_mpa_y_mpb_y_nand_s2_y_qb_tg_fbs_a_y r0 *1 0,0
Ca_mnab_y_mpa_y_mpb_y_nand_s2_y_qb_tg_fbs_a_y
+ a|mnab_y|mpa_y|mpb_y|nand_s2_y|qb|tg_fbs_a|y vsubs 2.242968e-15
* device instance a_mnab_y_mpa_y_mpb_y_nand_s2_y_qb_tg_fbs_a_y_dup1_t0 r0 *1 0,0
Ra_mnab_y_mpa_y_mpb_y_nand_s2_y_qb_tg_fbs_a_y_dup1_t0
+ a\x7cmnab_y\x7cmpa_y\x7cmpb_y\x7cnand_s2_y\x7cqb\x7ctg_fbs_a\x7cy__t02
+ a|mnab_y|mpa_y|mpb_y|nand_s2_y|qb|tg_fbs_a|y$1 141.656603839
* device instance a_mnab_y_mpa_y_mpb_y_nand_s2_y_qb_tg_fbs_a_y_dup1_t1 r0 *1 0,0
Ra_mnab_y_mpa_y_mpb_y_nand_s2_y_qb_tg_fbs_a_y_dup1_t1
+ a\x7cmnab_y\x7cmpa_y\x7cmpb_y\x7cnand_s2_y\x7cqb\x7ctg_fbs_a\x7cy__t12
+ a|mnab_y|mpa_y|mpb_y|nand_s2_y|qb|tg_fbs_a|y$1 118.925454613
* device instance a_mnab_y_mpa_y_mpb_y_nand_s2_y_qb_tg_fbs_a_y_dup1_t2 r0 *1 0,0
Ra_mnab_y_mpa_y_mpb_y_nand_s2_y_qb_tg_fbs_a_y_dup1_t2
+ a\x7cmnab_y\x7cmpa_y\x7cmpb_y\x7cnand_s2_y\x7cqb\x7ctg_fbs_a\x7cy__t22
+ a|mnab_y|mpa_y|mpb_y|nand_s2_y|qb|tg_fbs_a|y$1 127.509506058
* device instance a_mnab_y_mpa_y_mpb_y_nand_s2_y_qb_tg_fbs_a_y_dup1_t3 r0 *1 0,0
Ra_mnab_y_mpa_y_mpb_y_nand_s2_y_qb_tg_fbs_a_y_dup1_t3
+ a\x7cmnab_y\x7cmpa_y\x7cmpb_y\x7cnand_s2_y\x7cqb\x7ctg_fbs_a\x7cy__t32
+ a|mnab_y|mpa_y|mpb_y|nand_s2_y|qb|tg_fbs_a|y$1 79.2876741218
* device instance a_mnab_y_mpa_y_mpb_y_nand_s2_y_qb_tg_fbs_a_y_dup1_t4 r0 *1 0,0
Ra_mnab_y_mpa_y_mpb_y_nand_s2_y_qb_tg_fbs_a_y_dup1_t4
+ a\x7cmnab_y\x7cmpa_y\x7cmpb_y\x7cnand_s2_y\x7cqb\x7ctg_fbs_a\x7cy__t42
+ a|mnab_y|mpa_y|mpb_y|nand_s2_y|qb|tg_fbs_a|y$1 106.619261369
* device instance a_mnab_y_mpa_y_mpb_y_nand_s2_y_qb_tg_fbs_a_y_dup1 r0 *1 0,0
Ca_mnab_y_mpa_y_mpb_y_nand_s2_y_qb_tg_fbs_a_y_dup1
+ a|mnab_y|mpa_y|mpb_y|nand_s2_y|qb|tg_fbs_a|y$1 vsubs 2.242968e-15
* device instance a_mnab_y_mpa_y_mpb_y_nand_s2_y_qb_tg_fbs_a_y_dup2_t0 r0 *1 0,0
Ra_mnab_y_mpa_y_mpb_y_nand_s2_y_qb_tg_fbs_a_y_dup2_t0
+ a\x7cmnab_y\x7cmpa_y\x7cmpb_y\x7cnand_s2_y\x7cqb\x7ctg_fbs_a\x7cy__t03
+ a|mnab_y|mpa_y|mpb_y|nand_s2_y|qb|tg_fbs_a|y$2 141.656603839
* device instance a_mnab_y_mpa_y_mpb_y_nand_s2_y_qb_tg_fbs_a_y_dup2_t1 r0 *1 0,0
Ra_mnab_y_mpa_y_mpb_y_nand_s2_y_qb_tg_fbs_a_y_dup2_t1
+ a\x7cmnab_y\x7cmpa_y\x7cmpb_y\x7cnand_s2_y\x7cqb\x7ctg_fbs_a\x7cy__t13
+ a|mnab_y|mpa_y|mpb_y|nand_s2_y|qb|tg_fbs_a|y$2 118.925454613
* device instance a_mnab_y_mpa_y_mpb_y_nand_s2_y_qb_tg_fbs_a_y_dup2_t2 r0 *1 0,0
Ra_mnab_y_mpa_y_mpb_y_nand_s2_y_qb_tg_fbs_a_y_dup2_t2
+ a\x7cmnab_y\x7cmpa_y\x7cmpb_y\x7cnand_s2_y\x7cqb\x7ctg_fbs_a\x7cy__t23
+ a|mnab_y|mpa_y|mpb_y|nand_s2_y|qb|tg_fbs_a|y$2 127.509506058
* device instance a_mnab_y_mpa_y_mpb_y_nand_s2_y_qb_tg_fbs_a_y_dup2_t3 r0 *1 0,0
Ra_mnab_y_mpa_y_mpb_y_nand_s2_y_qb_tg_fbs_a_y_dup2_t3
+ a\x7cmnab_y\x7cmpa_y\x7cmpb_y\x7cnand_s2_y\x7cqb\x7ctg_fbs_a\x7cy__t33
+ a|mnab_y|mpa_y|mpb_y|nand_s2_y|qb|tg_fbs_a|y$2 79.2876741218
* device instance a_mnab_y_mpa_y_mpb_y_nand_s2_y_qb_tg_fbs_a_y_dup2_t4 r0 *1 0,0
Ra_mnab_y_mpa_y_mpb_y_nand_s2_y_qb_tg_fbs_a_y_dup2_t4
+ a\x7cmnab_y\x7cmpa_y\x7cmpb_y\x7cnand_s2_y\x7cqb\x7ctg_fbs_a\x7cy__t43
+ a|mnab_y|mpa_y|mpb_y|nand_s2_y|qb|tg_fbs_a|y$2 106.619261369
* device instance a_mnab_y_mpa_y_mpb_y_nand_s2_y_qb_tg_fbs_a_y_dup2 r0 *1 0,0
Ca_mnab_y_mpa_y_mpb_y_nand_s2_y_qb_tg_fbs_a_y_dup2
+ a|mnab_y|mpa_y|mpb_y|nand_s2_y|qb|tg_fbs_a|y$2 vsubs 2.242968e-15
* device instance a_mnab_y_mpa_y_mpb_y_nand_s2_y_qb_tg_fbs_a_y_dup3_t0 r0 *1 0,0
Ra_mnab_y_mpa_y_mpb_y_nand_s2_y_qb_tg_fbs_a_y_dup3_t0
+ a\x7cmnab_y\x7cmpa_y\x7cmpb_y\x7cnand_s2_y\x7cqb\x7ctg_fbs_a\x7cy__t04
+ a|mnab_y|mpa_y|mpb_y|nand_s2_y|qb|tg_fbs_a|y$3 141.656603839
* device instance a_mnab_y_mpa_y_mpb_y_nand_s2_y_qb_tg_fbs_a_y_dup3_t1 r0 *1 0,0
Ra_mnab_y_mpa_y_mpb_y_nand_s2_y_qb_tg_fbs_a_y_dup3_t1
+ a\x7cmnab_y\x7cmpa_y\x7cmpb_y\x7cnand_s2_y\x7cqb\x7ctg_fbs_a\x7cy__t14
+ a|mnab_y|mpa_y|mpb_y|nand_s2_y|qb|tg_fbs_a|y$3 118.925454613
* device instance a_mnab_y_mpa_y_mpb_y_nand_s2_y_qb_tg_fbs_a_y_dup3_t2 r0 *1 0,0
Ra_mnab_y_mpa_y_mpb_y_nand_s2_y_qb_tg_fbs_a_y_dup3_t2
+ a\x7cmnab_y\x7cmpa_y\x7cmpb_y\x7cnand_s2_y\x7cqb\x7ctg_fbs_a\x7cy__t24
+ a|mnab_y|mpa_y|mpb_y|nand_s2_y|qb|tg_fbs_a|y$3 127.509506058
* device instance a_mnab_y_mpa_y_mpb_y_nand_s2_y_qb_tg_fbs_a_y_dup3_t3 r0 *1 0,0
Ra_mnab_y_mpa_y_mpb_y_nand_s2_y_qb_tg_fbs_a_y_dup3_t3
+ a\x7cmnab_y\x7cmpa_y\x7cmpb_y\x7cnand_s2_y\x7cqb\x7ctg_fbs_a\x7cy__t34
+ a|mnab_y|mpa_y|mpb_y|nand_s2_y|qb|tg_fbs_a|y$3 79.2876741218
* device instance a_mnab_y_mpa_y_mpb_y_nand_s2_y_qb_tg_fbs_a_y_dup3_t4 r0 *1 0,0
Ra_mnab_y_mpa_y_mpb_y_nand_s2_y_qb_tg_fbs_a_y_dup3_t4
+ a\x7cmnab_y\x7cmpa_y\x7cmpb_y\x7cnand_s2_y\x7cqb\x7ctg_fbs_a\x7cy__t44
+ a|mnab_y|mpa_y|mpb_y|nand_s2_y|qb|tg_fbs_a|y$3 106.619261369
* device instance a_mnab_y_mpa_y_mpb_y_nand_s2_y_qb_tg_fbs_a_y_dup3 r0 *1 0,0
Ca_mnab_y_mpa_y_mpb_y_nand_s2_y_qb_tg_fbs_a_y_dup3
+ a|mnab_y|mpa_y|mpb_y|nand_s2_y|qb|tg_fbs_a|y$3 vsubs 2.242968e-15
* device instance a_mnab_y_mpa_y_mpb_y_nand_s2_y_qb_tg_fbs_a_y_dup4_t0 r0 *1 0,0
Ra_mnab_y_mpa_y_mpb_y_nand_s2_y_qb_tg_fbs_a_y_dup4_t0
+ a\x7cmnab_y\x7cmpa_y\x7cmpb_y\x7cnand_s2_y\x7cqb\x7ctg_fbs_a\x7cy__t05
+ a|mnab_y|mpa_y|mpb_y|nand_s2_y|qb|tg_fbs_a|y$4 141.656603839
* device instance a_mnab_y_mpa_y_mpb_y_nand_s2_y_qb_tg_fbs_a_y_dup4_t1 r0 *1 0,0
Ra_mnab_y_mpa_y_mpb_y_nand_s2_y_qb_tg_fbs_a_y_dup4_t1
+ a\x7cmnab_y\x7cmpa_y\x7cmpb_y\x7cnand_s2_y\x7cqb\x7ctg_fbs_a\x7cy__t15
+ a|mnab_y|mpa_y|mpb_y|nand_s2_y|qb|tg_fbs_a|y$4 118.925454613
* device instance a_mnab_y_mpa_y_mpb_y_nand_s2_y_qb_tg_fbs_a_y_dup4_t2 r0 *1 0,0
Ra_mnab_y_mpa_y_mpb_y_nand_s2_y_qb_tg_fbs_a_y_dup4_t2
+ a\x7cmnab_y\x7cmpa_y\x7cmpb_y\x7cnand_s2_y\x7cqb\x7ctg_fbs_a\x7cy__t25
+ a|mnab_y|mpa_y|mpb_y|nand_s2_y|qb|tg_fbs_a|y$4 127.509506058
* device instance a_mnab_y_mpa_y_mpb_y_nand_s2_y_qb_tg_fbs_a_y_dup4_t3 r0 *1 0,0
Ra_mnab_y_mpa_y_mpb_y_nand_s2_y_qb_tg_fbs_a_y_dup4_t3
+ a\x7cmnab_y\x7cmpa_y\x7cmpb_y\x7cnand_s2_y\x7cqb\x7ctg_fbs_a\x7cy__t35
+ a|mnab_y|mpa_y|mpb_y|nand_s2_y|qb|tg_fbs_a|y$4 79.2876741218
* device instance a_mnab_y_mpa_y_mpb_y_nand_s2_y_qb_tg_fbs_a_y_dup4_t4 r0 *1 0,0
Ra_mnab_y_mpa_y_mpb_y_nand_s2_y_qb_tg_fbs_a_y_dup4_t4
+ a\x7cmnab_y\x7cmpa_y\x7cmpb_y\x7cnand_s2_y\x7cqb\x7ctg_fbs_a\x7cy__t45
+ a|mnab_y|mpa_y|mpb_y|nand_s2_y|qb|tg_fbs_a|y$4 106.619261369
* device instance a_mnab_y_mpa_y_mpb_y_nand_s2_y_qb_tg_fbs_a_y_dup4 r0 *1 0,0
Ca_mnab_y_mpa_y_mpb_y_nand_s2_y_qb_tg_fbs_a_y_dup4
+ a|mnab_y|mpa_y|mpb_y|nand_s2_y|qb|tg_fbs_a|y$4 vsubs 2.242968e-15
* device instance a_mnab_y_mpa_y_mpb_y_nand_s2_y_qb_tg_fbs_a_y_dup5_t0 r0 *1 0,0
Ra_mnab_y_mpa_y_mpb_y_nand_s2_y_qb_tg_fbs_a_y_dup5_t0
+ a\x7cmnab_y\x7cmpa_y\x7cmpb_y\x7cnand_s2_y\x7cqb\x7ctg_fbs_a\x7cy__t06
+ a|mnab_y|mpa_y|mpb_y|nand_s2_y|qb|tg_fbs_a|y$5 141.656603839
* device instance a_mnab_y_mpa_y_mpb_y_nand_s2_y_qb_tg_fbs_a_y_dup5_t1 r0 *1 0,0
Ra_mnab_y_mpa_y_mpb_y_nand_s2_y_qb_tg_fbs_a_y_dup5_t1
+ a\x7cmnab_y\x7cmpa_y\x7cmpb_y\x7cnand_s2_y\x7cqb\x7ctg_fbs_a\x7cy__t16
+ a|mnab_y|mpa_y|mpb_y|nand_s2_y|qb|tg_fbs_a|y$5 127.509506058
* device instance a_mnab_y_mpa_y_mpb_y_nand_s2_y_qb_tg_fbs_a_y_dup5_t2 r0 *1 0,0
Ra_mnab_y_mpa_y_mpb_y_nand_s2_y_qb_tg_fbs_a_y_dup5_t2
+ a\x7cmnab_y\x7cmpa_y\x7cmpb_y\x7cnand_s2_y\x7cqb\x7ctg_fbs_a\x7cy__t26
+ a|mnab_y|mpa_y|mpb_y|nand_s2_y|qb|tg_fbs_a|y$5 118.925454613
* device instance a_mnab_y_mpa_y_mpb_y_nand_s2_y_qb_tg_fbs_a_y_dup5_t3 r0 *1 0,0
Ra_mnab_y_mpa_y_mpb_y_nand_s2_y_qb_tg_fbs_a_y_dup5_t3
+ a\x7cmnab_y\x7cmpa_y\x7cmpb_y\x7cnand_s2_y\x7cqb\x7ctg_fbs_a\x7cy__t36
+ a|mnab_y|mpa_y|mpb_y|nand_s2_y|qb|tg_fbs_a|y$5 79.2876741218
* device instance a_mnab_y_mpa_y_mpb_y_nand_s2_y_qb_tg_fbs_a_y_dup5_t4 r0 *1 0,0
Ra_mnab_y_mpa_y_mpb_y_nand_s2_y_qb_tg_fbs_a_y_dup5_t4
+ a\x7cmnab_y\x7cmpa_y\x7cmpb_y\x7cnand_s2_y\x7cqb\x7ctg_fbs_a\x7cy__t46
+ a|mnab_y|mpa_y|mpb_y|nand_s2_y|qb|tg_fbs_a|y$5 106.619261369
* device instance a_mnab_y_mpa_y_mpb_y_nand_s2_y_qb_tg_fbs_a_y_dup5 r0 *1 0,0
Ca_mnab_y_mpa_y_mpb_y_nand_s2_y_qb_tg_fbs_a_y_dup5
+ a|mnab_y|mpa_y|mpb_y|nand_s2_y|qb|tg_fbs_a|y$5 vsubs 2.242968e-15
* device instance a_n2_s1_y_s2_a_y_t0 r0 *1 0,0
Ra_n2_s1_y_s2_a_y_t0 a\x7cn2\x7cs1_y\x7cs2_a\x7cy__t0 a|n2|s1_y|s2_a|y
+ 225.155136025
* device instance a_n2_s1_y_s2_a_y_t1 r0 *1 0,0
Ra_n2_s1_y_s2_a_y_t1 a\x7cn2\x7cs1_y\x7cs2_a\x7cy__t1 a|n2|s1_y|s2_a|y
+ 234.635313975
* device instance a_n2_s1_y_s2_a_y_t2 r0 *1 0,0
Ra_n2_s1_y_s2_a_y_t2 a\x7cn2\x7cs1_y\x7cs2_a\x7cy__t2 a|n2|s1_y|s2_a|y
+ 234.635313975
* device instance a_n2_s1_y_s2_a_y_t3 r0 *1 0,0
Ra_n2_s1_y_s2_a_y_t3 a\x7cn2\x7cs1_y\x7cs2_a\x7cy__t3 a|n2|s1_y|s2_a|y
+ 225.155136025
* device instance a_n2_s1_y_s2_a_y r0 *1 0,0
Ca_n2_s1_y_s2_a_y a|n2|s1_y|s2_a|y vsubs 2.529995e-15
* device instance a_n2_s1_y_s2_a_y_dup1_t0 r0 *1 0,0
Ra_n2_s1_y_s2_a_y_dup1_t0 a\x7cn2\x7cs1_y\x7cs2_a\x7cy__t02 a|n2|s1_y|s2_a|y$1
+ 225.155136025
* device instance a_n2_s1_y_s2_a_y_dup1_t1 r0 *1 0,0
Ra_n2_s1_y_s2_a_y_dup1_t1 a\x7cn2\x7cs1_y\x7cs2_a\x7cy__t12 a|n2|s1_y|s2_a|y$1
+ 234.635313975
* device instance a_n2_s1_y_s2_a_y_dup1_t2 r0 *1 0,0
Ra_n2_s1_y_s2_a_y_dup1_t2 a\x7cn2\x7cs1_y\x7cs2_a\x7cy__t22 a|n2|s1_y|s2_a|y$1
+ 234.635313975
* device instance a_n2_s1_y_s2_a_y_dup1_t3 r0 *1 0,0
Ra_n2_s1_y_s2_a_y_dup1_t3 a\x7cn2\x7cs1_y\x7cs2_a\x7cy__t32 a|n2|s1_y|s2_a|y$1
+ 225.155136025
* device instance a_n2_s1_y_s2_a_y_dup1 r0 *1 0,0
Ca_n2_s1_y_s2_a_y_dup1 a|n2|s1_y|s2_a|y$1 vsubs 2.529995e-15
* device instance a_n2_s1_y_s2_a_y_dup2_t0 r0 *1 0,0
Ra_n2_s1_y_s2_a_y_dup2_t0 a\x7cn2\x7cs1_y\x7cs2_a\x7cy__t03 a|n2|s1_y|s2_a|y$2
+ 225.155136025
* device instance a_n2_s1_y_s2_a_y_dup2_t1 r0 *1 0,0
Ra_n2_s1_y_s2_a_y_dup2_t1 a\x7cn2\x7cs1_y\x7cs2_a\x7cy__t13 a|n2|s1_y|s2_a|y$2
+ 234.635313975
* device instance a_n2_s1_y_s2_a_y_dup2_t2 r0 *1 0,0
Ra_n2_s1_y_s2_a_y_dup2_t2 a\x7cn2\x7cs1_y\x7cs2_a\x7cy__t23 a|n2|s1_y|s2_a|y$2
+ 234.635313975
* device instance a_n2_s1_y_s2_a_y_dup2_t3 r0 *1 0,0
Ra_n2_s1_y_s2_a_y_dup2_t3 a\x7cn2\x7cs1_y\x7cs2_a\x7cy__t33 a|n2|s1_y|s2_a|y$2
+ 225.155136025
* device instance a_n2_s1_y_s2_a_y_dup2 r0 *1 0,0
Ca_n2_s1_y_s2_a_y_dup2 a|n2|s1_y|s2_a|y$2 vsubs 2.529995e-15
* device instance a_n2_s1_y_s2_a_y_dup3_t0 r0 *1 0,0
Ra_n2_s1_y_s2_a_y_dup3_t0 a\x7cn2\x7cs1_y\x7cs2_a\x7cy__t04 a|n2|s1_y|s2_a|y$3
+ 225.155136025
* device instance a_n2_s1_y_s2_a_y_dup3_t1 r0 *1 0,0
Ra_n2_s1_y_s2_a_y_dup3_t1 a\x7cn2\x7cs1_y\x7cs2_a\x7cy__t14 a|n2|s1_y|s2_a|y$3
+ 234.635313975
* device instance a_n2_s1_y_s2_a_y_dup3_t2 r0 *1 0,0
Ra_n2_s1_y_s2_a_y_dup3_t2 a\x7cn2\x7cs1_y\x7cs2_a\x7cy__t24 a|n2|s1_y|s2_a|y$3
+ 234.635313975
* device instance a_n2_s1_y_s2_a_y_dup3_t3 r0 *1 0,0
Ra_n2_s1_y_s2_a_y_dup3_t3 a\x7cn2\x7cs1_y\x7cs2_a\x7cy__t34 a|n2|s1_y|s2_a|y$3
+ 225.155136025
* device instance a_n2_s1_y_s2_a_y_dup3 r0 *1 0,0
Ca_n2_s1_y_s2_a_y_dup3 a|n2|s1_y|s2_a|y$3 vsubs 2.529995e-15
* device instance a_n3_s2_y_s3_a_y_t0 r0 *1 0,0
Ra_n3_s2_y_s3_a_y_t0 a\x7cn3\x7cs2_y\x7cs3_a\x7cy__t0 a|n3|s2_y|s3_a|y
+ 225.155136025
* device instance a_n3_s2_y_s3_a_y_t1 r0 *1 0,0
Ra_n3_s2_y_s3_a_y_t1 a\x7cn3\x7cs2_y\x7cs3_a\x7cy__t1 a|n3|s2_y|s3_a|y
+ 234.635313975
* device instance a_n3_s2_y_s3_a_y_t2 r0 *1 0,0
Ra_n3_s2_y_s3_a_y_t2 a\x7cn3\x7cs2_y\x7cs3_a\x7cy__t2 a|n3|s2_y|s3_a|y
+ 234.635313975
* device instance a_n3_s2_y_s3_a_y_t3 r0 *1 0,0
Ra_n3_s2_y_s3_a_y_t3 a\x7cn3\x7cs2_y\x7cs3_a\x7cy__t3 a|n3|s2_y|s3_a|y
+ 225.155136025
* device instance a_n3_s2_y_s3_a_y r0 *1 0,0
Ca_n3_s2_y_s3_a_y a|n3|s2_y|s3_a|y vsubs 2.529995e-15
* device instance a_n3_s2_y_s3_a_y_dup1_t0 r0 *1 0,0
Ra_n3_s2_y_s3_a_y_dup1_t0 a\x7cn3\x7cs2_y\x7cs3_a\x7cy__t02 a|n3|s2_y|s3_a|y$1
+ 225.155136025
* device instance a_n3_s2_y_s3_a_y_dup1_t1 r0 *1 0,0
Ra_n3_s2_y_s3_a_y_dup1_t1 a\x7cn3\x7cs2_y\x7cs3_a\x7cy__t12 a|n3|s2_y|s3_a|y$1
+ 234.635313975
* device instance a_n3_s2_y_s3_a_y_dup1_t2 r0 *1 0,0
Ra_n3_s2_y_s3_a_y_dup1_t2 a\x7cn3\x7cs2_y\x7cs3_a\x7cy__t22 a|n3|s2_y|s3_a|y$1
+ 234.635313975
* device instance a_n3_s2_y_s3_a_y_dup1_t3 r0 *1 0,0
Ra_n3_s2_y_s3_a_y_dup1_t3 a\x7cn3\x7cs2_y\x7cs3_a\x7cy__t32 a|n3|s2_y|s3_a|y$1
+ 225.155136025
* device instance a_n3_s2_y_s3_a_y_dup1 r0 *1 0,0
Ca_n3_s2_y_s3_a_y_dup1 a|n3|s2_y|s3_a|y$1 vsubs 2.529995e-15
* device instance a_n3_s2_y_s3_a_y_dup2_t0 r0 *1 0,0
Ra_n3_s2_y_s3_a_y_dup2_t0 a\x7cn3\x7cs2_y\x7cs3_a\x7cy__t03 a|n3|s2_y|s3_a|y$2
+ 225.155136025
* device instance a_n3_s2_y_s3_a_y_dup2_t1 r0 *1 0,0
Ra_n3_s2_y_s3_a_y_dup2_t1 a\x7cn3\x7cs2_y\x7cs3_a\x7cy__t13 a|n3|s2_y|s3_a|y$2
+ 234.635313975
* device instance a_n3_s2_y_s3_a_y_dup2_t2 r0 *1 0,0
Ra_n3_s2_y_s3_a_y_dup2_t2 a\x7cn3\x7cs2_y\x7cs3_a\x7cy__t23 a|n3|s2_y|s3_a|y$2
+ 234.635313975
* device instance a_n3_s2_y_s3_a_y_dup2_t3 r0 *1 0,0
Ra_n3_s2_y_s3_a_y_dup2_t3 a\x7cn3\x7cs2_y\x7cs3_a\x7cy__t33 a|n3|s2_y|s3_a|y$2
+ 225.155136025
* device instance a_n3_s2_y_s3_a_y_dup2 r0 *1 0,0
Ca_n3_s2_y_s3_a_y_dup2 a|n3|s2_y|s3_a|y$2 vsubs 2.529995e-15
* device instance a_n3_s2_y_s3_a_y_dup3_t0 r0 *1 0,0
Ra_n3_s2_y_s3_a_y_dup3_t0 a\x7cn3\x7cs2_y\x7cs3_a\x7cy__t04 a|n3|s2_y|s3_a|y$3
+ 225.155136025
* device instance a_n3_s2_y_s3_a_y_dup3_t1 r0 *1 0,0
Ra_n3_s2_y_s3_a_y_dup3_t1 a\x7cn3\x7cs2_y\x7cs3_a\x7cy__t14 a|n3|s2_y|s3_a|y$3
+ 234.635313975
* device instance a_n3_s2_y_s3_a_y_dup3_t2 r0 *1 0,0
Ra_n3_s2_y_s3_a_y_dup3_t2 a\x7cn3\x7cs2_y\x7cs3_a\x7cy__t24 a|n3|s2_y|s3_a|y$3
+ 234.635313975
* device instance a_n3_s2_y_s3_a_y_dup3_t3 r0 *1 0,0
Ra_n3_s2_y_s3_a_y_dup3_t3 a\x7cn3\x7cs2_y\x7cs3_a\x7cy__t34 a|n3|s2_y|s3_a|y$3
+ 225.155136025
* device instance a_n3_s2_y_s3_a_y_dup3 r0 *1 0,0
Ca_n3_s2_y_s3_a_y_dup3 a|n3|s2_y|s3_a|y$3 vsubs 2.529995e-15
* device instance a_n4_s3_y_s4_a_y_t0 r0 *1 0,0
Ra_n4_s3_y_s4_a_y_t0 a\x7cn4\x7cs3_y\x7cs4_a\x7cy__t0 a|n4|s3_y|s4_a|y
+ 225.155136025
* device instance a_n4_s3_y_s4_a_y_t1 r0 *1 0,0
Ra_n4_s3_y_s4_a_y_t1 a\x7cn4\x7cs3_y\x7cs4_a\x7cy__t1 a|n4|s3_y|s4_a|y
+ 234.635313975
* device instance a_n4_s3_y_s4_a_y_t2 r0 *1 0,0
Ra_n4_s3_y_s4_a_y_t2 a\x7cn4\x7cs3_y\x7cs4_a\x7cy__t2 a|n4|s3_y|s4_a|y
+ 234.635313975
* device instance a_n4_s3_y_s4_a_y_t3 r0 *1 0,0
Ra_n4_s3_y_s4_a_y_t3 a\x7cn4\x7cs3_y\x7cs4_a\x7cy__t3 a|n4|s3_y|s4_a|y
+ 225.155136025
* device instance a_n4_s3_y_s4_a_y r0 *1 0,0
Ca_n4_s3_y_s4_a_y a|n4|s3_y|s4_a|y vsubs 2.529995e-15
* device instance a_n4_s3_y_s4_a_y_dup1_t0 r0 *1 0,0
Ra_n4_s3_y_s4_a_y_dup1_t0 a\x7cn4\x7cs3_y\x7cs4_a\x7cy__t02 a|n4|s3_y|s4_a|y$1
+ 225.155136025
* device instance a_n4_s3_y_s4_a_y_dup1_t1 r0 *1 0,0
Ra_n4_s3_y_s4_a_y_dup1_t1 a\x7cn4\x7cs3_y\x7cs4_a\x7cy__t12 a|n4|s3_y|s4_a|y$1
+ 234.635313975
* device instance a_n4_s3_y_s4_a_y_dup1_t2 r0 *1 0,0
Ra_n4_s3_y_s4_a_y_dup1_t2 a\x7cn4\x7cs3_y\x7cs4_a\x7cy__t22 a|n4|s3_y|s4_a|y$1
+ 234.635313975
* device instance a_n4_s3_y_s4_a_y_dup1_t3 r0 *1 0,0
Ra_n4_s3_y_s4_a_y_dup1_t3 a\x7cn4\x7cs3_y\x7cs4_a\x7cy__t32 a|n4|s3_y|s4_a|y$1
+ 225.155136025
* device instance a_n4_s3_y_s4_a_y_dup1 r0 *1 0,0
Ca_n4_s3_y_s4_a_y_dup1 a|n4|s3_y|s4_a|y$1 vsubs 2.529995e-15
* device instance a_n4_s3_y_s4_a_y_dup2_t0 r0 *1 0,0
Ra_n4_s3_y_s4_a_y_dup2_t0 a\x7cn4\x7cs3_y\x7cs4_a\x7cy__t03 a|n4|s3_y|s4_a|y$2
+ 225.155136025
* device instance a_n4_s3_y_s4_a_y_dup2_t1 r0 *1 0,0
Ra_n4_s3_y_s4_a_y_dup2_t1 a\x7cn4\x7cs3_y\x7cs4_a\x7cy__t13 a|n4|s3_y|s4_a|y$2
+ 234.635313975
* device instance a_n4_s3_y_s4_a_y_dup2_t2 r0 *1 0,0
Ra_n4_s3_y_s4_a_y_dup2_t2 a\x7cn4\x7cs3_y\x7cs4_a\x7cy__t23 a|n4|s3_y|s4_a|y$2
+ 234.635313975
* device instance a_n4_s3_y_s4_a_y_dup2_t3 r0 *1 0,0
Ra_n4_s3_y_s4_a_y_dup2_t3 a\x7cn4\x7cs3_y\x7cs4_a\x7cy__t33 a|n4|s3_y|s4_a|y$2
+ 225.155136025
* device instance a_n4_s3_y_s4_a_y_dup2 r0 *1 0,0
Ca_n4_s3_y_s4_a_y_dup2 a|n4|s3_y|s4_a|y$2 vsubs 2.529995e-15
* device instance a_n4_s3_y_s4_a_y_dup3_t0 r0 *1 0,0
Ra_n4_s3_y_s4_a_y_dup3_t0 a\x7cn4\x7cs3_y\x7cs4_a\x7cy__t04 a|n4|s3_y|s4_a|y$3
+ 225.155136025
* device instance a_n4_s3_y_s4_a_y_dup3_t1 r0 *1 0,0
Ra_n4_s3_y_s4_a_y_dup3_t1 a\x7cn4\x7cs3_y\x7cs4_a\x7cy__t14 a|n4|s3_y|s4_a|y$3
+ 234.635313975
* device instance a_n4_s3_y_s4_a_y_dup3_t2 r0 *1 0,0
Ra_n4_s3_y_s4_a_y_dup3_t2 a\x7cn4\x7cs3_y\x7cs4_a\x7cy__t24 a|n4|s3_y|s4_a|y$3
+ 234.635313975
* device instance a_n4_s3_y_s4_a_y_dup3_t3 r0 *1 0,0
Ra_n4_s3_y_s4_a_y_dup3_t3 a\x7cn4\x7cs3_y\x7cs4_a\x7cy__t34 a|n4|s3_y|s4_a|y$3
+ 225.155136025
* device instance a_n4_s3_y_s4_a_y_dup3 r0 *1 0,0
Ca_n4_s3_y_s4_a_y_dup3 a|n4|s3_y|s4_a|y$3 vsubs 2.529995e-15
* device instance bn_invb_y_mn34_g1_mp24_g1_y_t0 r0 *1 0,0
Rbn_invb_y_mn34_g1_mp24_g1_y_t0 bn\x7cinvb_y\x7cmn34_g1\x7cmp24_g1\x7cy__t0
+ bn|invb_y|mn34_g1|mp24_g1|y 198.995695593
* device instance bn_invb_y_mn34_g1_mp24_g1_y_t1 r0 *1 0,0
Rbn_invb_y_mn34_g1_mp24_g1_y_t1 bn\x7cinvb_y\x7cmn34_g1\x7cmp24_g1\x7cy__t1
+ bn|invb_y|mn34_g1|mp24_g1|y 186.809338642
* device instance bn_invb_y_mn34_g1_mp24_g1_y_t2 r0 *1 0,0
Rbn_invb_y_mn34_g1_mp24_g1_y_t2 bn\x7cinvb_y\x7cmn34_g1\x7cmp24_g1\x7cy__t2
+ bn|invb_y|mn34_g1|mp24_g1|y 176.037794575
* device instance bn_invb_y_mn34_g1_mp24_g1_y_t3 r0 *1 0,0
Rbn_invb_y_mn34_g1_mp24_g1_y_t3 bn\x7cinvb_y\x7cmn34_g1\x7cmp24_g1\x7cy__t3
+ bn|invb_y|mn34_g1|mp24_g1|y 315.14977119
* device instance bn_invb_y_mn34_g1_mp24_g1_y r0 *1 0,0
Cbn_invb_y_mn34_g1_mp24_g1_y bn|invb_y|mn34_g1|mp24_g1|y vsubs 5.127304e-15
* device instance bn_invb_y_mn34_g1_mp24_g1_y_dup1_t0 r0 *1 0,0
Rbn_invb_y_mn34_g1_mp24_g1_y_dup1_t0
+ bn\x7cinvb_y\x7cmn34_g1\x7cmp24_g1\x7cy__t02 bn|invb_y|mn34_g1|mp24_g1|y$1
+ 198.995695593
* device instance bn_invb_y_mn34_g1_mp24_g1_y_dup1_t1 r0 *1 0,0
Rbn_invb_y_mn34_g1_mp24_g1_y_dup1_t1
+ bn\x7cinvb_y\x7cmn34_g1\x7cmp24_g1\x7cy__t12 bn|invb_y|mn34_g1|mp24_g1|y$1
+ 186.809338642
* device instance bn_invb_y_mn34_g1_mp24_g1_y_dup1_t2 r0 *1 0,0
Rbn_invb_y_mn34_g1_mp24_g1_y_dup1_t2
+ bn\x7cinvb_y\x7cmn34_g1\x7cmp24_g1\x7cy__t22 bn|invb_y|mn34_g1|mp24_g1|y$1
+ 176.037794575
* device instance bn_invb_y_mn34_g1_mp24_g1_y_dup1_t3 r0 *1 0,0
Rbn_invb_y_mn34_g1_mp24_g1_y_dup1_t3
+ bn\x7cinvb_y\x7cmn34_g1\x7cmp24_g1\x7cy__t32 bn|invb_y|mn34_g1|mp24_g1|y$1
+ 315.14977119
* device instance bn_invb_y_mn34_g1_mp24_g1_y_dup1 r0 *1 0,0
Cbn_invb_y_mn34_g1_mp24_g1_y_dup1 bn|invb_y|mn34_g1|mp24_g1|y$1 vsubs
+ 5.127304e-15
* device instance bn_invb_y_mn34_g1_mp24_g1_y_dup2_t0 r0 *1 0,0
Rbn_invb_y_mn34_g1_mp24_g1_y_dup2_t0
+ bn\x7cinvb_y\x7cmn34_g1\x7cmp24_g1\x7cy__t03 bn|invb_y|mn34_g1|mp24_g1|y$2
+ 198.995695593
* device instance bn_invb_y_mn34_g1_mp24_g1_y_dup2_t1 r0 *1 0,0
Rbn_invb_y_mn34_g1_mp24_g1_y_dup2_t1
+ bn\x7cinvb_y\x7cmn34_g1\x7cmp24_g1\x7cy__t13 bn|invb_y|mn34_g1|mp24_g1|y$2
+ 186.809338642
* device instance bn_invb_y_mn34_g1_mp24_g1_y_dup2_t2 r0 *1 0,0
Rbn_invb_y_mn34_g1_mp24_g1_y_dup2_t2
+ bn\x7cinvb_y\x7cmn34_g1\x7cmp24_g1\x7cy__t23 bn|invb_y|mn34_g1|mp24_g1|y$2
+ 176.037794575
* device instance bn_invb_y_mn34_g1_mp24_g1_y_dup2_t3 r0 *1 0,0
Rbn_invb_y_mn34_g1_mp24_g1_y_dup2_t3
+ bn\x7cinvb_y\x7cmn34_g1\x7cmp24_g1\x7cy__t33 bn|invb_y|mn34_g1|mp24_g1|y$2
+ 315.14977119
* device instance bn_invb_y_mn34_g1_mp24_g1_y_dup2 r0 *1 0,0
Cbn_invb_y_mn34_g1_mp24_g1_y_dup2 bn|invb_y|mn34_g1|mp24_g1|y$2 vsubs
+ 5.126559e-15
* device instance clkb_clkb_bridge1_clkb_bridge2_clkb_mid_clkb_w_ctrl_ctrlb_inv_clk_y_tg_d_ctrlb_tg_fbm_ctrl_tg_fbs_ctrlb_tg_s_ctrl_y_t0 r0 *1 0,0
Rclkb_clkb_bridge1_clkb_bridge2_clkb_mid_clkb_w_ctrl_ctrlb_inv_clk_y_tg_d_ctrlb_tg_fbm_ctrl_tg_fbs_ctrlb_tg_s_ctrl_y_t0
+ clkb\x7cclkb_bridge1\x7cclkb_bridge2\x7cclkb_mid\x7cclkb_w\x7cctrl\x7cctrlb\x7cinv_clk_y\x7ctg_d_ctrlb\x7ctg_fbm_ctrl\x7ctg_fbs_ctrlb\x7ctg_s_ctrl\x7cy__t0
+ clkb|clkb_bridge1|clkb_bridge2|clkb_mid|clkb_w|ctrl|ctrlb|inv_clk_y|tg_d_ctrlb|tg_fbm_ctrl|tg_fbs_ctrlb|tg_s_ctrl|y
+ 259.586366866
* device instance clkb_clkb_bridge1_clkb_bridge2_clkb_mid_clkb_w_ctrl_ctrlb_inv_clk_y_tg_d_ctrlb_tg_fbm_ctrl_tg_fbs_ctrlb_tg_s_ctrl_y_t1 r0 *1 0,0
Rclkb_clkb_bridge1_clkb_bridge2_clkb_mid_clkb_w_ctrl_ctrlb_inv_clk_y_tg_d_ctrlb_tg_fbm_ctrl_tg_fbs_ctrlb_tg_s_ctrl_y_t1
+ clkb\x7cclkb_bridge1\x7cclkb_bridge2\x7cclkb_mid\x7cclkb_w\x7cctrl\x7cctrlb\x7cinv_clk_y\x7ctg_d_ctrlb\x7ctg_fbm_ctrl\x7ctg_fbs_ctrlb\x7ctg_s_ctrl\x7cy__t1
+ clkb|clkb_bridge1|clkb_bridge2|clkb_mid|clkb_w|ctrl|ctrlb|inv_clk_y|tg_d_ctrlb|tg_fbm_ctrl|tg_fbs_ctrlb|tg_s_ctrl|y
+ 259.586366866
* device instance clkb_clkb_bridge1_clkb_bridge2_clkb_mid_clkb_w_ctrl_ctrlb_inv_clk_y_tg_d_ctrlb_tg_fbm_ctrl_tg_fbs_ctrlb_tg_s_ctrl_y_t2 r0 *1 0,0
Rclkb_clkb_bridge1_clkb_bridge2_clkb_mid_clkb_w_ctrl_ctrlb_inv_clk_y_tg_d_ctrlb_tg_fbm_ctrl_tg_fbs_ctrlb_tg_s_ctrl_y_t2
+ clkb\x7cclkb_bridge1\x7cclkb_bridge2\x7cclkb_mid\x7cclkb_w\x7cctrl\x7cctrlb\x7cinv_clk_y\x7ctg_d_ctrlb\x7ctg_fbm_ctrl\x7ctg_fbs_ctrlb\x7ctg_s_ctrl\x7cy__t2
+ clkb|clkb_bridge1|clkb_bridge2|clkb_mid|clkb_w|ctrl|ctrlb|inv_clk_y|tg_d_ctrlb|tg_fbm_ctrl|tg_fbs_ctrlb|tg_s_ctrl|y
+ 190.613947185
* device instance clkb_clkb_bridge1_clkb_bridge2_clkb_mid_clkb_w_ctrl_ctrlb_inv_clk_y_tg_d_ctrlb_tg_fbm_ctrl_tg_fbs_ctrlb_tg_s_ctrl_y_t3 r0 *1 0,0
Rclkb_clkb_bridge1_clkb_bridge2_clkb_mid_clkb_w_ctrl_ctrlb_inv_clk_y_tg_d_ctrlb_tg_fbm_ctrl_tg_fbs_ctrlb_tg_s_ctrl_y_t3
+ clkb\x7cclkb_bridge1\x7cclkb_bridge2\x7cclkb_mid\x7cclkb_w\x7cctrl\x7cctrlb\x7cinv_clk_y\x7ctg_d_ctrlb\x7ctg_fbm_ctrl\x7ctg_fbs_ctrlb\x7ctg_s_ctrl\x7cy__t3
+ clkb|clkb_bridge1|clkb_bridge2|clkb_mid|clkb_w|ctrl|ctrlb|inv_clk_y|tg_d_ctrlb|tg_fbm_ctrl|tg_fbs_ctrlb|tg_s_ctrl|y
+ 448.186014016
* device instance clkb_clkb_bridge1_clkb_bridge2_clkb_mid_clkb_w_ctrl_ctrlb_inv_clk_y_tg_d_ctrlb_tg_fbm_ctrl_tg_fbs_ctrlb_tg_s_ctrl_y_t4 r0 *1 0,0
Rclkb_clkb_bridge1_clkb_bridge2_clkb_mid_clkb_w_ctrl_ctrlb_inv_clk_y_tg_d_ctrlb_tg_fbm_ctrl_tg_fbs_ctrlb_tg_s_ctrl_y_t4
+ clkb\x7cclkb_bridge1\x7cclkb_bridge2\x7cclkb_mid\x7cclkb_w\x7cctrl\x7cctrlb\x7cinv_clk_y\x7ctg_d_ctrlb\x7ctg_fbm_ctrl\x7ctg_fbs_ctrlb\x7ctg_s_ctrl\x7cy__t4
+ clkb|clkb_bridge1|clkb_bridge2|clkb_mid|clkb_w|ctrl|ctrlb|inv_clk_y|tg_d_ctrlb|tg_fbm_ctrl|tg_fbs_ctrlb|tg_s_ctrl|y
+ 94.93603628
* device instance clkb_clkb_bridge1_clkb_bridge2_clkb_mid_clkb_w_ctrl_ctrlb_inv_clk_y_tg_d_ctrlb_tg_fbm_ctrl_tg_fbs_ctrlb_tg_s_ctrl_y_t5 r0 *1 0,0
Rclkb_clkb_bridge1_clkb_bridge2_clkb_mid_clkb_w_ctrl_ctrlb_inv_clk_y_tg_d_ctrlb_tg_fbm_ctrl_tg_fbs_ctrlb_tg_s_ctrl_y_t5
+ clkb\x7cclkb_bridge1\x7cclkb_bridge2\x7cclkb_mid\x7cclkb_w\x7cctrl\x7cctrlb\x7cinv_clk_y\x7ctg_d_ctrlb\x7ctg_fbm_ctrl\x7ctg_fbs_ctrlb\x7ctg_s_ctrl\x7cy__t5
+ clkb|clkb_bridge1|clkb_bridge2|clkb_mid|clkb_w|ctrl|ctrlb|inv_clk_y|tg_d_ctrlb|tg_fbm_ctrl|tg_fbs_ctrlb|tg_s_ctrl|y
+ 168.394968787
* device instance clkb_clkb_bridge1_clkb_bridge2_clkb_mid_clkb_w_ctrl_ctrlb_inv_clk_y_tg_d_ctrlb_tg_fbm_ctrl_tg_fbs_ctrlb_tg_s_ctrl_y r0 *1 0,0
Cclkb_clkb_bridge1_clkb_bridge2_clkb_mid_clkb_w_ctrl_ctrlb_inv_clk_y_tg_d_ctrlb_tg_fbm_ctrl_tg_fbs_ctrlb_tg_s_ctrl_y
+ clkb|clkb_bridge1|clkb_bridge2|clkb_mid|clkb_w|ctrl|ctrlb|inv_clk_y|tg_d_ctrlb|tg_fbm_ctrl|tg_fbs_ctrlb|tg_s_ctrl|y
+ vsubs 6.706821e-15
* device instance clkb_clkb_bridge1_clkb_bridge2_clkb_mid_clkb_w_ctrl_ctrlb_inv_clk_y_tg_d_ctrlb_tg_fbm_ctrl_tg_fbs_ctrlb_tg_s_ctrl_y_dup1_t0 r0 *1 0,0
Rclkb_clkb_bridge1_clkb_bridge2_clkb_mid_clkb_w_ctrl_ctrlb_inv_clk_y_tg_d_ctrlb_tg_fbm_ctrl_tg_fbs_ctrlb_tg_s_ctrl_y_dup1_t0
+ clkb\x7cclkb_bridge1\x7cclkb_bridge2\x7cclkb_mid\x7cclkb_w\x7cctrl\x7cctrlb\x7cinv_clk_y\x7ctg_d_ctrlb\x7ctg_fbm_ctrl\x7ctg_fbs_ctrlb\x7ctg_s_ctrl\x7cy__t02
+ clkb|clkb_bridge1|clkb_bridge2|clkb_mid|clkb_w|ctrl|ctrlb|inv_clk_y|tg_d_ctrlb|tg_fbm_ctrl|tg_fbs_ctrlb|tg_s_ctrl|y$1
+ 259.586366866
* device instance clkb_clkb_bridge1_clkb_bridge2_clkb_mid_clkb_w_ctrl_ctrlb_inv_clk_y_tg_d_ctrlb_tg_fbm_ctrl_tg_fbs_ctrlb_tg_s_ctrl_y_dup1_t1 r0 *1 0,0
Rclkb_clkb_bridge1_clkb_bridge2_clkb_mid_clkb_w_ctrl_ctrlb_inv_clk_y_tg_d_ctrlb_tg_fbm_ctrl_tg_fbs_ctrlb_tg_s_ctrl_y_dup1_t1
+ clkb\x7cclkb_bridge1\x7cclkb_bridge2\x7cclkb_mid\x7cclkb_w\x7cctrl\x7cctrlb\x7cinv_clk_y\x7ctg_d_ctrlb\x7ctg_fbm_ctrl\x7ctg_fbs_ctrlb\x7ctg_s_ctrl\x7cy__t12
+ clkb|clkb_bridge1|clkb_bridge2|clkb_mid|clkb_w|ctrl|ctrlb|inv_clk_y|tg_d_ctrlb|tg_fbm_ctrl|tg_fbs_ctrlb|tg_s_ctrl|y$1
+ 259.586366866
* device instance clkb_clkb_bridge1_clkb_bridge2_clkb_mid_clkb_w_ctrl_ctrlb_inv_clk_y_tg_d_ctrlb_tg_fbm_ctrl_tg_fbs_ctrlb_tg_s_ctrl_y_dup1_t2 r0 *1 0,0
Rclkb_clkb_bridge1_clkb_bridge2_clkb_mid_clkb_w_ctrl_ctrlb_inv_clk_y_tg_d_ctrlb_tg_fbm_ctrl_tg_fbs_ctrlb_tg_s_ctrl_y_dup1_t2
+ clkb\x7cclkb_bridge1\x7cclkb_bridge2\x7cclkb_mid\x7cclkb_w\x7cctrl\x7cctrlb\x7cinv_clk_y\x7ctg_d_ctrlb\x7ctg_fbm_ctrl\x7ctg_fbs_ctrlb\x7ctg_s_ctrl\x7cy__t22
+ clkb|clkb_bridge1|clkb_bridge2|clkb_mid|clkb_w|ctrl|ctrlb|inv_clk_y|tg_d_ctrlb|tg_fbm_ctrl|tg_fbs_ctrlb|tg_s_ctrl|y$1
+ 190.613947185
* device instance clkb_clkb_bridge1_clkb_bridge2_clkb_mid_clkb_w_ctrl_ctrlb_inv_clk_y_tg_d_ctrlb_tg_fbm_ctrl_tg_fbs_ctrlb_tg_s_ctrl_y_dup1_t3 r0 *1 0,0
Rclkb_clkb_bridge1_clkb_bridge2_clkb_mid_clkb_w_ctrl_ctrlb_inv_clk_y_tg_d_ctrlb_tg_fbm_ctrl_tg_fbs_ctrlb_tg_s_ctrl_y_dup1_t3
+ clkb\x7cclkb_bridge1\x7cclkb_bridge2\x7cclkb_mid\x7cclkb_w\x7cctrl\x7cctrlb\x7cinv_clk_y\x7ctg_d_ctrlb\x7ctg_fbm_ctrl\x7ctg_fbs_ctrlb\x7ctg_s_ctrl\x7cy__t32
+ clkb|clkb_bridge1|clkb_bridge2|clkb_mid|clkb_w|ctrl|ctrlb|inv_clk_y|tg_d_ctrlb|tg_fbm_ctrl|tg_fbs_ctrlb|tg_s_ctrl|y$1
+ 448.186014016
* device instance clkb_clkb_bridge1_clkb_bridge2_clkb_mid_clkb_w_ctrl_ctrlb_inv_clk_y_tg_d_ctrlb_tg_fbm_ctrl_tg_fbs_ctrlb_tg_s_ctrl_y_dup1_t4 r0 *1 0,0
Rclkb_clkb_bridge1_clkb_bridge2_clkb_mid_clkb_w_ctrl_ctrlb_inv_clk_y_tg_d_ctrlb_tg_fbm_ctrl_tg_fbs_ctrlb_tg_s_ctrl_y_dup1_t4
+ clkb\x7cclkb_bridge1\x7cclkb_bridge2\x7cclkb_mid\x7cclkb_w\x7cctrl\x7cctrlb\x7cinv_clk_y\x7ctg_d_ctrlb\x7ctg_fbm_ctrl\x7ctg_fbs_ctrlb\x7ctg_s_ctrl\x7cy__t42
+ clkb|clkb_bridge1|clkb_bridge2|clkb_mid|clkb_w|ctrl|ctrlb|inv_clk_y|tg_d_ctrlb|tg_fbm_ctrl|tg_fbs_ctrlb|tg_s_ctrl|y$1
+ 168.394968787
* device instance clkb_clkb_bridge1_clkb_bridge2_clkb_mid_clkb_w_ctrl_ctrlb_inv_clk_y_tg_d_ctrlb_tg_fbm_ctrl_tg_fbs_ctrlb_tg_s_ctrl_y_dup1_t5 r0 *1 0,0
Rclkb_clkb_bridge1_clkb_bridge2_clkb_mid_clkb_w_ctrl_ctrlb_inv_clk_y_tg_d_ctrlb_tg_fbm_ctrl_tg_fbs_ctrlb_tg_s_ctrl_y_dup1_t5
+ clkb\x7cclkb_bridge1\x7cclkb_bridge2\x7cclkb_mid\x7cclkb_w\x7cctrl\x7cctrlb\x7cinv_clk_y\x7ctg_d_ctrlb\x7ctg_fbm_ctrl\x7ctg_fbs_ctrlb\x7ctg_s_ctrl\x7cy__t52
+ clkb|clkb_bridge1|clkb_bridge2|clkb_mid|clkb_w|ctrl|ctrlb|inv_clk_y|tg_d_ctrlb|tg_fbm_ctrl|tg_fbs_ctrlb|tg_s_ctrl|y$1
+ 94.93603628
* device instance clkb_clkb_bridge1_clkb_bridge2_clkb_mid_clkb_w_ctrl_ctrlb_inv_clk_y_tg_d_ctrlb_tg_fbm_ctrl_tg_fbs_ctrlb_tg_s_ctrl_y_dup1 r0 *1 0,0
Cclkb_clkb_bridge1_clkb_bridge2_clkb_mid_clkb_w_ctrl_ctrlb_inv_clk_y_tg_d_ctrlb_tg_fbm_ctrl_tg_fbs_ctrlb_tg_s_ctrl_y_dup1
+ clkb|clkb_bridge1|clkb_bridge2|clkb_mid|clkb_w|ctrl|ctrlb|inv_clk_y|tg_d_ctrlb|tg_fbm_ctrl|tg_fbs_ctrlb|tg_s_ctrl|y$1
+ vsubs 6.706821e-15
* device instance clkb_clkb_bridge1_clkb_bridge2_clkb_mid_clkb_w_ctrl_ctrlb_inv_clk_y_tg_d_ctrlb_tg_fbm_ctrl_tg_fbs_ctrlb_tg_s_ctrl_y_dup2_t0 r0 *1 0,0
Rclkb_clkb_bridge1_clkb_bridge2_clkb_mid_clkb_w_ctrl_ctrlb_inv_clk_y_tg_d_ctrlb_tg_fbm_ctrl_tg_fbs_ctrlb_tg_s_ctrl_y_dup2_t0
+ clkb\x7cclkb_bridge1\x7cclkb_bridge2\x7cclkb_mid\x7cclkb_w\x7cctrl\x7cctrlb\x7cinv_clk_y\x7ctg_d_ctrlb\x7ctg_fbm_ctrl\x7ctg_fbs_ctrlb\x7ctg_s_ctrl\x7cy__t03
+ clkb|clkb_bridge1|clkb_bridge2|clkb_mid|clkb_w|ctrl|ctrlb|inv_clk_y|tg_d_ctrlb|tg_fbm_ctrl|tg_fbs_ctrlb|tg_s_ctrl|y$2
+ 259.586366866
* device instance clkb_clkb_bridge1_clkb_bridge2_clkb_mid_clkb_w_ctrl_ctrlb_inv_clk_y_tg_d_ctrlb_tg_fbm_ctrl_tg_fbs_ctrlb_tg_s_ctrl_y_dup2_t1 r0 *1 0,0
Rclkb_clkb_bridge1_clkb_bridge2_clkb_mid_clkb_w_ctrl_ctrlb_inv_clk_y_tg_d_ctrlb_tg_fbm_ctrl_tg_fbs_ctrlb_tg_s_ctrl_y_dup2_t1
+ clkb\x7cclkb_bridge1\x7cclkb_bridge2\x7cclkb_mid\x7cclkb_w\x7cctrl\x7cctrlb\x7cinv_clk_y\x7ctg_d_ctrlb\x7ctg_fbm_ctrl\x7ctg_fbs_ctrlb\x7ctg_s_ctrl\x7cy__t13
+ clkb|clkb_bridge1|clkb_bridge2|clkb_mid|clkb_w|ctrl|ctrlb|inv_clk_y|tg_d_ctrlb|tg_fbm_ctrl|tg_fbs_ctrlb|tg_s_ctrl|y$2
+ 259.586366866
* device instance clkb_clkb_bridge1_clkb_bridge2_clkb_mid_clkb_w_ctrl_ctrlb_inv_clk_y_tg_d_ctrlb_tg_fbm_ctrl_tg_fbs_ctrlb_tg_s_ctrl_y_dup2_t2 r0 *1 0,0
Rclkb_clkb_bridge1_clkb_bridge2_clkb_mid_clkb_w_ctrl_ctrlb_inv_clk_y_tg_d_ctrlb_tg_fbm_ctrl_tg_fbs_ctrlb_tg_s_ctrl_y_dup2_t2
+ clkb\x7cclkb_bridge1\x7cclkb_bridge2\x7cclkb_mid\x7cclkb_w\x7cctrl\x7cctrlb\x7cinv_clk_y\x7ctg_d_ctrlb\x7ctg_fbm_ctrl\x7ctg_fbs_ctrlb\x7ctg_s_ctrl\x7cy__t23
+ clkb|clkb_bridge1|clkb_bridge2|clkb_mid|clkb_w|ctrl|ctrlb|inv_clk_y|tg_d_ctrlb|tg_fbm_ctrl|tg_fbs_ctrlb|tg_s_ctrl|y$2
+ 448.186014016
* device instance clkb_clkb_bridge1_clkb_bridge2_clkb_mid_clkb_w_ctrl_ctrlb_inv_clk_y_tg_d_ctrlb_tg_fbm_ctrl_tg_fbs_ctrlb_tg_s_ctrl_y_dup2_t3 r0 *1 0,0
Rclkb_clkb_bridge1_clkb_bridge2_clkb_mid_clkb_w_ctrl_ctrlb_inv_clk_y_tg_d_ctrlb_tg_fbm_ctrl_tg_fbs_ctrlb_tg_s_ctrl_y_dup2_t3
+ clkb\x7cclkb_bridge1\x7cclkb_bridge2\x7cclkb_mid\x7cclkb_w\x7cctrl\x7cctrlb\x7cinv_clk_y\x7ctg_d_ctrlb\x7ctg_fbm_ctrl\x7ctg_fbs_ctrlb\x7ctg_s_ctrl\x7cy__t33
+ clkb|clkb_bridge1|clkb_bridge2|clkb_mid|clkb_w|ctrl|ctrlb|inv_clk_y|tg_d_ctrlb|tg_fbm_ctrl|tg_fbs_ctrlb|tg_s_ctrl|y$2
+ 190.613947185
* device instance clkb_clkb_bridge1_clkb_bridge2_clkb_mid_clkb_w_ctrl_ctrlb_inv_clk_y_tg_d_ctrlb_tg_fbm_ctrl_tg_fbs_ctrlb_tg_s_ctrl_y_dup2_t4 r0 *1 0,0
Rclkb_clkb_bridge1_clkb_bridge2_clkb_mid_clkb_w_ctrl_ctrlb_inv_clk_y_tg_d_ctrlb_tg_fbm_ctrl_tg_fbs_ctrlb_tg_s_ctrl_y_dup2_t4
+ clkb\x7cclkb_bridge1\x7cclkb_bridge2\x7cclkb_mid\x7cclkb_w\x7cctrl\x7cctrlb\x7cinv_clk_y\x7ctg_d_ctrlb\x7ctg_fbm_ctrl\x7ctg_fbs_ctrlb\x7ctg_s_ctrl\x7cy__t43
+ clkb|clkb_bridge1|clkb_bridge2|clkb_mid|clkb_w|ctrl|ctrlb|inv_clk_y|tg_d_ctrlb|tg_fbm_ctrl|tg_fbs_ctrlb|tg_s_ctrl|y$2
+ 94.93603628
* device instance clkb_clkb_bridge1_clkb_bridge2_clkb_mid_clkb_w_ctrl_ctrlb_inv_clk_y_tg_d_ctrlb_tg_fbm_ctrl_tg_fbs_ctrlb_tg_s_ctrl_y_dup2_t5 r0 *1 0,0
Rclkb_clkb_bridge1_clkb_bridge2_clkb_mid_clkb_w_ctrl_ctrlb_inv_clk_y_tg_d_ctrlb_tg_fbm_ctrl_tg_fbs_ctrlb_tg_s_ctrl_y_dup2_t5
+ clkb\x7cclkb_bridge1\x7cclkb_bridge2\x7cclkb_mid\x7cclkb_w\x7cctrl\x7cctrlb\x7cinv_clk_y\x7ctg_d_ctrlb\x7ctg_fbm_ctrl\x7ctg_fbs_ctrlb\x7ctg_s_ctrl\x7cy__t53
+ clkb|clkb_bridge1|clkb_bridge2|clkb_mid|clkb_w|ctrl|ctrlb|inv_clk_y|tg_d_ctrlb|tg_fbm_ctrl|tg_fbs_ctrlb|tg_s_ctrl|y$2
+ 168.394968787
* device instance clkb_clkb_bridge1_clkb_bridge2_clkb_mid_clkb_w_ctrl_ctrlb_inv_clk_y_tg_d_ctrlb_tg_fbm_ctrl_tg_fbs_ctrlb_tg_s_ctrl_y_dup2 r0 *1 0,0
Cclkb_clkb_bridge1_clkb_bridge2_clkb_mid_clkb_w_ctrl_ctrlb_inv_clk_y_tg_d_ctrlb_tg_fbm_ctrl_tg_fbs_ctrlb_tg_s_ctrl_y_dup2
+ clkb|clkb_bridge1|clkb_bridge2|clkb_mid|clkb_w|ctrl|ctrlb|inv_clk_y|tg_d_ctrlb|tg_fbm_ctrl|tg_fbs_ctrlb|tg_s_ctrl|y$2
+ vsubs 6.706821e-15
* device instance clkb_clkb_bridge1_clkb_bridge2_clkb_mid_clkb_w_ctrl_ctrlb_inv_clk_y_tg_d_ctrlb_tg_fbm_ctrl_tg_fbs_ctrlb_tg_s_ctrl_y_dup3_t0 r0 *1 0,0
Rclkb_clkb_bridge1_clkb_bridge2_clkb_mid_clkb_w_ctrl_ctrlb_inv_clk_y_tg_d_ctrlb_tg_fbm_ctrl_tg_fbs_ctrlb_tg_s_ctrl_y_dup3_t0
+ clkb\x7cclkb_bridge1\x7cclkb_bridge2\x7cclkb_mid\x7cclkb_w\x7cctrl\x7cctrlb\x7cinv_clk_y\x7ctg_d_ctrlb\x7ctg_fbm_ctrl\x7ctg_fbs_ctrlb\x7ctg_s_ctrl\x7cy__t04
+ clkb|clkb_bridge1|clkb_bridge2|clkb_mid|clkb_w|ctrl|ctrlb|inv_clk_y|tg_d_ctrlb|tg_fbm_ctrl|tg_fbs_ctrlb|tg_s_ctrl|y$3
+ 259.586366866
* device instance clkb_clkb_bridge1_clkb_bridge2_clkb_mid_clkb_w_ctrl_ctrlb_inv_clk_y_tg_d_ctrlb_tg_fbm_ctrl_tg_fbs_ctrlb_tg_s_ctrl_y_dup3_t1 r0 *1 0,0
Rclkb_clkb_bridge1_clkb_bridge2_clkb_mid_clkb_w_ctrl_ctrlb_inv_clk_y_tg_d_ctrlb_tg_fbm_ctrl_tg_fbs_ctrlb_tg_s_ctrl_y_dup3_t1
+ clkb\x7cclkb_bridge1\x7cclkb_bridge2\x7cclkb_mid\x7cclkb_w\x7cctrl\x7cctrlb\x7cinv_clk_y\x7ctg_d_ctrlb\x7ctg_fbm_ctrl\x7ctg_fbs_ctrlb\x7ctg_s_ctrl\x7cy__t14
+ clkb|clkb_bridge1|clkb_bridge2|clkb_mid|clkb_w|ctrl|ctrlb|inv_clk_y|tg_d_ctrlb|tg_fbm_ctrl|tg_fbs_ctrlb|tg_s_ctrl|y$3
+ 259.586366866
* device instance clkb_clkb_bridge1_clkb_bridge2_clkb_mid_clkb_w_ctrl_ctrlb_inv_clk_y_tg_d_ctrlb_tg_fbm_ctrl_tg_fbs_ctrlb_tg_s_ctrl_y_dup3_t2 r0 *1 0,0
Rclkb_clkb_bridge1_clkb_bridge2_clkb_mid_clkb_w_ctrl_ctrlb_inv_clk_y_tg_d_ctrlb_tg_fbm_ctrl_tg_fbs_ctrlb_tg_s_ctrl_y_dup3_t2
+ clkb\x7cclkb_bridge1\x7cclkb_bridge2\x7cclkb_mid\x7cclkb_w\x7cctrl\x7cctrlb\x7cinv_clk_y\x7ctg_d_ctrlb\x7ctg_fbm_ctrl\x7ctg_fbs_ctrlb\x7ctg_s_ctrl\x7cy__t24
+ clkb|clkb_bridge1|clkb_bridge2|clkb_mid|clkb_w|ctrl|ctrlb|inv_clk_y|tg_d_ctrlb|tg_fbm_ctrl|tg_fbs_ctrlb|tg_s_ctrl|y$3
+ 448.186014016
* device instance clkb_clkb_bridge1_clkb_bridge2_clkb_mid_clkb_w_ctrl_ctrlb_inv_clk_y_tg_d_ctrlb_tg_fbm_ctrl_tg_fbs_ctrlb_tg_s_ctrl_y_dup3_t3 r0 *1 0,0
Rclkb_clkb_bridge1_clkb_bridge2_clkb_mid_clkb_w_ctrl_ctrlb_inv_clk_y_tg_d_ctrlb_tg_fbm_ctrl_tg_fbs_ctrlb_tg_s_ctrl_y_dup3_t3
+ clkb\x7cclkb_bridge1\x7cclkb_bridge2\x7cclkb_mid\x7cclkb_w\x7cctrl\x7cctrlb\x7cinv_clk_y\x7ctg_d_ctrlb\x7ctg_fbm_ctrl\x7ctg_fbs_ctrlb\x7ctg_s_ctrl\x7cy__t34
+ clkb|clkb_bridge1|clkb_bridge2|clkb_mid|clkb_w|ctrl|ctrlb|inv_clk_y|tg_d_ctrlb|tg_fbm_ctrl|tg_fbs_ctrlb|tg_s_ctrl|y$3
+ 190.613947185
* device instance clkb_clkb_bridge1_clkb_bridge2_clkb_mid_clkb_w_ctrl_ctrlb_inv_clk_y_tg_d_ctrlb_tg_fbm_ctrl_tg_fbs_ctrlb_tg_s_ctrl_y_dup3_t4 r0 *1 0,0
Rclkb_clkb_bridge1_clkb_bridge2_clkb_mid_clkb_w_ctrl_ctrlb_inv_clk_y_tg_d_ctrlb_tg_fbm_ctrl_tg_fbs_ctrlb_tg_s_ctrl_y_dup3_t4
+ clkb\x7cclkb_bridge1\x7cclkb_bridge2\x7cclkb_mid\x7cclkb_w\x7cctrl\x7cctrlb\x7cinv_clk_y\x7ctg_d_ctrlb\x7ctg_fbm_ctrl\x7ctg_fbs_ctrlb\x7ctg_s_ctrl\x7cy__t44
+ clkb|clkb_bridge1|clkb_bridge2|clkb_mid|clkb_w|ctrl|ctrlb|inv_clk_y|tg_d_ctrlb|tg_fbm_ctrl|tg_fbs_ctrlb|tg_s_ctrl|y$3
+ 168.394968787
* device instance clkb_clkb_bridge1_clkb_bridge2_clkb_mid_clkb_w_ctrl_ctrlb_inv_clk_y_tg_d_ctrlb_tg_fbm_ctrl_tg_fbs_ctrlb_tg_s_ctrl_y_dup3_t5 r0 *1 0,0
Rclkb_clkb_bridge1_clkb_bridge2_clkb_mid_clkb_w_ctrl_ctrlb_inv_clk_y_tg_d_ctrlb_tg_fbm_ctrl_tg_fbs_ctrlb_tg_s_ctrl_y_dup3_t5
+ clkb\x7cclkb_bridge1\x7cclkb_bridge2\x7cclkb_mid\x7cclkb_w\x7cctrl\x7cctrlb\x7cinv_clk_y\x7ctg_d_ctrlb\x7ctg_fbm_ctrl\x7ctg_fbs_ctrlb\x7ctg_s_ctrl\x7cy__t54
+ clkb|clkb_bridge1|clkb_bridge2|clkb_mid|clkb_w|ctrl|ctrlb|inv_clk_y|tg_d_ctrlb|tg_fbm_ctrl|tg_fbs_ctrlb|tg_s_ctrl|y$3
+ 94.93603628
* device instance clkb_clkb_bridge1_clkb_bridge2_clkb_mid_clkb_w_ctrl_ctrlb_inv_clk_y_tg_d_ctrlb_tg_fbm_ctrl_tg_fbs_ctrlb_tg_s_ctrl_y_dup3 r0 *1 0,0
Cclkb_clkb_bridge1_clkb_bridge2_clkb_mid_clkb_w_ctrl_ctrlb_inv_clk_y_tg_d_ctrlb_tg_fbm_ctrl_tg_fbs_ctrlb_tg_s_ctrl_y_dup3
+ clkb|clkb_bridge1|clkb_bridge2|clkb_mid|clkb_w|ctrl|ctrlb|inv_clk_y|tg_d_ctrlb|tg_fbm_ctrl|tg_fbs_ctrlb|tg_s_ctrl|y$3
+ vsubs 6.706821e-15
* device instance clkb_clkb_bridge1_clkb_bridge2_clkb_mid_clkb_w_ctrl_ctrlb_inv_clk_y_tg_d_ctrlb_tg_fbm_ctrl_tg_fbs_ctrlb_tg_s_ctrl_y_dup4_t0 r0 *1 0,0
Rclkb_clkb_bridge1_clkb_bridge2_clkb_mid_clkb_w_ctrl_ctrlb_inv_clk_y_tg_d_ctrlb_tg_fbm_ctrl_tg_fbs_ctrlb_tg_s_ctrl_y_dup4_t0
+ clkb\x7cclkb_bridge1\x7cclkb_bridge2\x7cclkb_mid\x7cclkb_w\x7cctrl\x7cctrlb\x7cinv_clk_y\x7ctg_d_ctrlb\x7ctg_fbm_ctrl\x7ctg_fbs_ctrlb\x7ctg_s_ctrl\x7cy__t05
+ clkb|clkb_bridge1|clkb_bridge2|clkb_mid|clkb_w|ctrl|ctrlb|inv_clk_y|tg_d_ctrlb|tg_fbm_ctrl|tg_fbs_ctrlb|tg_s_ctrl|y$4
+ 259.586366866
* device instance clkb_clkb_bridge1_clkb_bridge2_clkb_mid_clkb_w_ctrl_ctrlb_inv_clk_y_tg_d_ctrlb_tg_fbm_ctrl_tg_fbs_ctrlb_tg_s_ctrl_y_dup4_t1 r0 *1 0,0
Rclkb_clkb_bridge1_clkb_bridge2_clkb_mid_clkb_w_ctrl_ctrlb_inv_clk_y_tg_d_ctrlb_tg_fbm_ctrl_tg_fbs_ctrlb_tg_s_ctrl_y_dup4_t1
+ clkb\x7cclkb_bridge1\x7cclkb_bridge2\x7cclkb_mid\x7cclkb_w\x7cctrl\x7cctrlb\x7cinv_clk_y\x7ctg_d_ctrlb\x7ctg_fbm_ctrl\x7ctg_fbs_ctrlb\x7ctg_s_ctrl\x7cy__t15
+ clkb|clkb_bridge1|clkb_bridge2|clkb_mid|clkb_w|ctrl|ctrlb|inv_clk_y|tg_d_ctrlb|tg_fbm_ctrl|tg_fbs_ctrlb|tg_s_ctrl|y$4
+ 259.586366866
* device instance clkb_clkb_bridge1_clkb_bridge2_clkb_mid_clkb_w_ctrl_ctrlb_inv_clk_y_tg_d_ctrlb_tg_fbm_ctrl_tg_fbs_ctrlb_tg_s_ctrl_y_dup4_t2 r0 *1 0,0
Rclkb_clkb_bridge1_clkb_bridge2_clkb_mid_clkb_w_ctrl_ctrlb_inv_clk_y_tg_d_ctrlb_tg_fbm_ctrl_tg_fbs_ctrlb_tg_s_ctrl_y_dup4_t2
+ clkb\x7cclkb_bridge1\x7cclkb_bridge2\x7cclkb_mid\x7cclkb_w\x7cctrl\x7cctrlb\x7cinv_clk_y\x7ctg_d_ctrlb\x7ctg_fbm_ctrl\x7ctg_fbs_ctrlb\x7ctg_s_ctrl\x7cy__t25
+ clkb|clkb_bridge1|clkb_bridge2|clkb_mid|clkb_w|ctrl|ctrlb|inv_clk_y|tg_d_ctrlb|tg_fbm_ctrl|tg_fbs_ctrlb|tg_s_ctrl|y$4
+ 190.613947185
* device instance clkb_clkb_bridge1_clkb_bridge2_clkb_mid_clkb_w_ctrl_ctrlb_inv_clk_y_tg_d_ctrlb_tg_fbm_ctrl_tg_fbs_ctrlb_tg_s_ctrl_y_dup4_t3 r0 *1 0,0
Rclkb_clkb_bridge1_clkb_bridge2_clkb_mid_clkb_w_ctrl_ctrlb_inv_clk_y_tg_d_ctrlb_tg_fbm_ctrl_tg_fbs_ctrlb_tg_s_ctrl_y_dup4_t3
+ clkb\x7cclkb_bridge1\x7cclkb_bridge2\x7cclkb_mid\x7cclkb_w\x7cctrl\x7cctrlb\x7cinv_clk_y\x7ctg_d_ctrlb\x7ctg_fbm_ctrl\x7ctg_fbs_ctrlb\x7ctg_s_ctrl\x7cy__t35
+ clkb|clkb_bridge1|clkb_bridge2|clkb_mid|clkb_w|ctrl|ctrlb|inv_clk_y|tg_d_ctrlb|tg_fbm_ctrl|tg_fbs_ctrlb|tg_s_ctrl|y$4
+ 448.186014016
* device instance clkb_clkb_bridge1_clkb_bridge2_clkb_mid_clkb_w_ctrl_ctrlb_inv_clk_y_tg_d_ctrlb_tg_fbm_ctrl_tg_fbs_ctrlb_tg_s_ctrl_y_dup4_t4 r0 *1 0,0
Rclkb_clkb_bridge1_clkb_bridge2_clkb_mid_clkb_w_ctrl_ctrlb_inv_clk_y_tg_d_ctrlb_tg_fbm_ctrl_tg_fbs_ctrlb_tg_s_ctrl_y_dup4_t4
+ clkb\x7cclkb_bridge1\x7cclkb_bridge2\x7cclkb_mid\x7cclkb_w\x7cctrl\x7cctrlb\x7cinv_clk_y\x7ctg_d_ctrlb\x7ctg_fbm_ctrl\x7ctg_fbs_ctrlb\x7ctg_s_ctrl\x7cy__t45
+ clkb|clkb_bridge1|clkb_bridge2|clkb_mid|clkb_w|ctrl|ctrlb|inv_clk_y|tg_d_ctrlb|tg_fbm_ctrl|tg_fbs_ctrlb|tg_s_ctrl|y$4
+ 168.394968787
* device instance clkb_clkb_bridge1_clkb_bridge2_clkb_mid_clkb_w_ctrl_ctrlb_inv_clk_y_tg_d_ctrlb_tg_fbm_ctrl_tg_fbs_ctrlb_tg_s_ctrl_y_dup4_t5 r0 *1 0,0
Rclkb_clkb_bridge1_clkb_bridge2_clkb_mid_clkb_w_ctrl_ctrlb_inv_clk_y_tg_d_ctrlb_tg_fbm_ctrl_tg_fbs_ctrlb_tg_s_ctrl_y_dup4_t5
+ clkb\x7cclkb_bridge1\x7cclkb_bridge2\x7cclkb_mid\x7cclkb_w\x7cctrl\x7cctrlb\x7cinv_clk_y\x7ctg_d_ctrlb\x7ctg_fbm_ctrl\x7ctg_fbs_ctrlb\x7ctg_s_ctrl\x7cy__t55
+ clkb|clkb_bridge1|clkb_bridge2|clkb_mid|clkb_w|ctrl|ctrlb|inv_clk_y|tg_d_ctrlb|tg_fbm_ctrl|tg_fbs_ctrlb|tg_s_ctrl|y$4
+ 94.93603628
* device instance clkb_clkb_bridge1_clkb_bridge2_clkb_mid_clkb_w_ctrl_ctrlb_inv_clk_y_tg_d_ctrlb_tg_fbm_ctrl_tg_fbs_ctrlb_tg_s_ctrl_y_dup4 r0 *1 0,0
Cclkb_clkb_bridge1_clkb_bridge2_clkb_mid_clkb_w_ctrl_ctrlb_inv_clk_y_tg_d_ctrlb_tg_fbm_ctrl_tg_fbs_ctrlb_tg_s_ctrl_y_dup4
+ clkb|clkb_bridge1|clkb_bridge2|clkb_mid|clkb_w|ctrl|ctrlb|inv_clk_y|tg_d_ctrlb|tg_fbm_ctrl|tg_fbs_ctrlb|tg_s_ctrl|y$4
+ vsubs 6.706821e-15
* device instance clkb_clkb_bridge1_clkb_bridge2_clkb_mid_clkb_w_ctrl_ctrlb_inv_clk_y_tg_d_ctrlb_tg_fbm_ctrl_tg_fbs_ctrlb_tg_s_ctrl_y_dup5_t0 r0 *1 0,0
Rclkb_clkb_bridge1_clkb_bridge2_clkb_mid_clkb_w_ctrl_ctrlb_inv_clk_y_tg_d_ctrlb_tg_fbm_ctrl_tg_fbs_ctrlb_tg_s_ctrl_y_dup5_t0
+ clkb\x7cclkb_bridge1\x7cclkb_bridge2\x7cclkb_mid\x7cclkb_w\x7cctrl\x7cctrlb\x7cinv_clk_y\x7ctg_d_ctrlb\x7ctg_fbm_ctrl\x7ctg_fbs_ctrlb\x7ctg_s_ctrl\x7cy__t06
+ clkb|clkb_bridge1|clkb_bridge2|clkb_mid|clkb_w|ctrl|ctrlb|inv_clk_y|tg_d_ctrlb|tg_fbm_ctrl|tg_fbs_ctrlb|tg_s_ctrl|y$5
+ 259.586366866
* device instance clkb_clkb_bridge1_clkb_bridge2_clkb_mid_clkb_w_ctrl_ctrlb_inv_clk_y_tg_d_ctrlb_tg_fbm_ctrl_tg_fbs_ctrlb_tg_s_ctrl_y_dup5_t1 r0 *1 0,0
Rclkb_clkb_bridge1_clkb_bridge2_clkb_mid_clkb_w_ctrl_ctrlb_inv_clk_y_tg_d_ctrlb_tg_fbm_ctrl_tg_fbs_ctrlb_tg_s_ctrl_y_dup5_t1
+ clkb\x7cclkb_bridge1\x7cclkb_bridge2\x7cclkb_mid\x7cclkb_w\x7cctrl\x7cctrlb\x7cinv_clk_y\x7ctg_d_ctrlb\x7ctg_fbm_ctrl\x7ctg_fbs_ctrlb\x7ctg_s_ctrl\x7cy__t16
+ clkb|clkb_bridge1|clkb_bridge2|clkb_mid|clkb_w|ctrl|ctrlb|inv_clk_y|tg_d_ctrlb|tg_fbm_ctrl|tg_fbs_ctrlb|tg_s_ctrl|y$5
+ 259.586366866
* device instance clkb_clkb_bridge1_clkb_bridge2_clkb_mid_clkb_w_ctrl_ctrlb_inv_clk_y_tg_d_ctrlb_tg_fbm_ctrl_tg_fbs_ctrlb_tg_s_ctrl_y_dup5_t2 r0 *1 0,0
Rclkb_clkb_bridge1_clkb_bridge2_clkb_mid_clkb_w_ctrl_ctrlb_inv_clk_y_tg_d_ctrlb_tg_fbm_ctrl_tg_fbs_ctrlb_tg_s_ctrl_y_dup5_t2
+ clkb\x7cclkb_bridge1\x7cclkb_bridge2\x7cclkb_mid\x7cclkb_w\x7cctrl\x7cctrlb\x7cinv_clk_y\x7ctg_d_ctrlb\x7ctg_fbm_ctrl\x7ctg_fbs_ctrlb\x7ctg_s_ctrl\x7cy__t26
+ clkb|clkb_bridge1|clkb_bridge2|clkb_mid|clkb_w|ctrl|ctrlb|inv_clk_y|tg_d_ctrlb|tg_fbm_ctrl|tg_fbs_ctrlb|tg_s_ctrl|y$5
+ 190.613947185
* device instance clkb_clkb_bridge1_clkb_bridge2_clkb_mid_clkb_w_ctrl_ctrlb_inv_clk_y_tg_d_ctrlb_tg_fbm_ctrl_tg_fbs_ctrlb_tg_s_ctrl_y_dup5_t3 r0 *1 0,0
Rclkb_clkb_bridge1_clkb_bridge2_clkb_mid_clkb_w_ctrl_ctrlb_inv_clk_y_tg_d_ctrlb_tg_fbm_ctrl_tg_fbs_ctrlb_tg_s_ctrl_y_dup5_t3
+ clkb\x7cclkb_bridge1\x7cclkb_bridge2\x7cclkb_mid\x7cclkb_w\x7cctrl\x7cctrlb\x7cinv_clk_y\x7ctg_d_ctrlb\x7ctg_fbm_ctrl\x7ctg_fbs_ctrlb\x7ctg_s_ctrl\x7cy__t36
+ clkb|clkb_bridge1|clkb_bridge2|clkb_mid|clkb_w|ctrl|ctrlb|inv_clk_y|tg_d_ctrlb|tg_fbm_ctrl|tg_fbs_ctrlb|tg_s_ctrl|y$5
+ 448.186014016
* device instance clkb_clkb_bridge1_clkb_bridge2_clkb_mid_clkb_w_ctrl_ctrlb_inv_clk_y_tg_d_ctrlb_tg_fbm_ctrl_tg_fbs_ctrlb_tg_s_ctrl_y_dup5_t4 r0 *1 0,0
Rclkb_clkb_bridge1_clkb_bridge2_clkb_mid_clkb_w_ctrl_ctrlb_inv_clk_y_tg_d_ctrlb_tg_fbm_ctrl_tg_fbs_ctrlb_tg_s_ctrl_y_dup5_t4
+ clkb\x7cclkb_bridge1\x7cclkb_bridge2\x7cclkb_mid\x7cclkb_w\x7cctrl\x7cctrlb\x7cinv_clk_y\x7ctg_d_ctrlb\x7ctg_fbm_ctrl\x7ctg_fbs_ctrlb\x7ctg_s_ctrl\x7cy__t46
+ clkb|clkb_bridge1|clkb_bridge2|clkb_mid|clkb_w|ctrl|ctrlb|inv_clk_y|tg_d_ctrlb|tg_fbm_ctrl|tg_fbs_ctrlb|tg_s_ctrl|y$5
+ 168.394968787
* device instance clkb_clkb_bridge1_clkb_bridge2_clkb_mid_clkb_w_ctrl_ctrlb_inv_clk_y_tg_d_ctrlb_tg_fbm_ctrl_tg_fbs_ctrlb_tg_s_ctrl_y_dup5_t5 r0 *1 0,0
Rclkb_clkb_bridge1_clkb_bridge2_clkb_mid_clkb_w_ctrl_ctrlb_inv_clk_y_tg_d_ctrlb_tg_fbm_ctrl_tg_fbs_ctrlb_tg_s_ctrl_y_dup5_t5
+ clkb\x7cclkb_bridge1\x7cclkb_bridge2\x7cclkb_mid\x7cclkb_w\x7cctrl\x7cctrlb\x7cinv_clk_y\x7ctg_d_ctrlb\x7ctg_fbm_ctrl\x7ctg_fbs_ctrlb\x7ctg_s_ctrl\x7cy__t56
+ clkb|clkb_bridge1|clkb_bridge2|clkb_mid|clkb_w|ctrl|ctrlb|inv_clk_y|tg_d_ctrlb|tg_fbm_ctrl|tg_fbs_ctrlb|tg_s_ctrl|y$5
+ 94.93603628
* device instance clkb_clkb_bridge1_clkb_bridge2_clkb_mid_clkb_w_ctrl_ctrlb_inv_clk_y_tg_d_ctrlb_tg_fbm_ctrl_tg_fbs_ctrlb_tg_s_ctrl_y_dup5 r0 *1 0,0
Cclkb_clkb_bridge1_clkb_bridge2_clkb_mid_clkb_w_ctrl_ctrlb_inv_clk_y_tg_d_ctrlb_tg_fbm_ctrl_tg_fbs_ctrlb_tg_s_ctrl_y_dup5
+ clkb|clkb_bridge1|clkb_bridge2|clkb_mid|clkb_w|ctrl|ctrlb|inv_clk_y|tg_d_ctrlb|tg_fbm_ctrl|tg_fbs_ctrlb|tg_s_ctrl|y$5
+ vsubs 6.706821e-15
* device instance en_en1_g_en_t0 r0 *1 0,0
Ren_en1_g_en_t0 en\x7cen1\x7cg_en__t0 en|en1|g_en 236.31895
* device instance en_en1_g_en_t1 r0 *1 0,0
Ren_en1_g_en_t1 en\x7cen1\x7cg_en__t1 en|en1|g_en 236.31895
* device instance en_en1_g_en r0 *1 0,0
Cen_en1_g_en en|en1|g_en vsubs 5.93421e-16
* device instance en_en2_g_en_t0 r0 *1 0,0
Ren_en2_g_en_t0 en\x7cen2\x7cg_en__t0 en|en2|g_en 236.31895
* device instance en_en2_g_en_t1 r0 *1 0,0
Ren_en2_g_en_t1 en\x7cen2\x7cg_en__t1 en|en2|g_en 236.31895
* device instance en_en2_g_en r0 *1 0,0
Cen_en2_g_en en|en2|g_en vsubs 5.93421e-16
* device instance en_en3_g_en_t0 r0 *1 0,0
Ren_en3_g_en_t0 en\x7cen3\x7cg_en__t0 en|en3|g_en 236.31895
* device instance en_en3_g_en_t1 r0 *1 0,0
Ren_en3_g_en_t1 en\x7cen3\x7cg_en__t1 en|en3|g_en 236.31895
* device instance en_en3_g_en r0 *1 0,0
Cen_en3_g_en en|en3|g_en vsubs 5.93421e-16
* device instance en_en4_g_en_t0 r0 *1 0,0
Ren_en4_g_en_t0 en\x7cen4\x7cg_en__t0 en|en4|g_en 236.31895
* device instance en_en4_g_en_t1 r0 *1 0,0
Ren_en4_g_en_t1 en\x7cen4\x7cg_en__t1 en|en4|g_en 236.31895
* device instance en_en4_g_en r0 *1 0,0
Cen_en4_g_en en|en4|g_en vsubs 5.93421e-16
* device instance en_nand_m_en_nand_m_en_via_nand_s2_en_nand_s2_en_via_rst_n_t0 r0 *1 0,0
Ren_nand_m_en_nand_m_en_via_nand_s2_en_nand_s2_en_via_rst_n_t0
+ en\x7cnand_m_en\x7cnand_m_en_via\x7cnand_s2_en\x7cnand_s2_en_via\x7crst_n__t0
+ en|nand_m_en|nand_m_en_via|nand_s2_en|nand_s2_en_via|rst_n 563.15919404
* device instance en_nand_m_en_nand_m_en_via_nand_s2_en_nand_s2_en_via_rst_n_t1 r0 *1 0,0
Ren_nand_m_en_nand_m_en_via_nand_s2_en_nand_s2_en_via_rst_n_t1
+ en\x7cnand_m_en\x7cnand_m_en_via\x7cnand_s2_en\x7cnand_s2_en_via\x7crst_n__t1
+ en|nand_m_en|nand_m_en_via|nand_s2_en|nand_s2_en_via|rst_n 45.2961791404
* device instance en_nand_m_en_nand_m_en_via_nand_s2_en_nand_s2_en_via_rst_n_t2 r0 *1 0,0
Ren_nand_m_en_nand_m_en_via_nand_s2_en_nand_s2_en_via_rst_n_t2
+ en\x7cnand_m_en\x7cnand_m_en_via\x7cnand_s2_en\x7cnand_s2_en_via\x7crst_n__t2
+ en|nand_m_en|nand_m_en_via|nand_s2_en|nand_s2_en_via|rst_n 247.816580576
* device instance en_nand_m_en_nand_m_en_via_nand_s2_en_nand_s2_en_via_rst_n_t3 r0 *1 0,0
Ren_nand_m_en_nand_m_en_via_nand_s2_en_nand_s2_en_via_rst_n_t3
+ en\x7cnand_m_en\x7cnand_m_en_via\x7cnand_s2_en\x7cnand_s2_en_via\x7crst_n__t3
+ en|nand_m_en|nand_m_en_via|nand_s2_en|nand_s2_en_via|rst_n 157.461669466
* device instance en_nand_m_en_nand_m_en_via_nand_s2_en_nand_s2_en_via_rst_n_t4 r0 *1 0,0
Ren_nand_m_en_nand_m_en_via_nand_s2_en_nand_s2_en_via_rst_n_t4
+ en\x7cnand_m_en\x7cnand_m_en_via\x7cnand_s2_en\x7cnand_s2_en_via\x7crst_n__t4
+ en|nand_m_en|nand_m_en_via|nand_s2_en|nand_s2_en_via|rst_n 360.283757302
* device instance en_nand_m_en_nand_m_en_via_nand_s2_en_nand_s2_en_via_rst_n_t5 r0 *1 0,0
Ren_nand_m_en_nand_m_en_via_nand_s2_en_nand_s2_en_via_rst_n_t5
+ en\x7cnand_m_en\x7cnand_m_en_via\x7cnand_s2_en\x7cnand_s2_en_via\x7crst_n__t5
+ en|nand_m_en|nand_m_en_via|nand_s2_en|nand_s2_en_via|rst_n 450.675110254
* device instance en_nand_m_en_nand_m_en_via_nand_s2_en_nand_s2_en_via_rst_n_t6 r0 *1 0,0
Ren_nand_m_en_nand_m_en_via_nand_s2_en_nand_s2_en_via_rst_n_t6
+ en\x7cnand_m_en\x7cnand_m_en_via\x7cnand_s2_en\x7cnand_s2_en_via\x7crst_n__t6
+ en|nand_m_en|nand_m_en_via|nand_s2_en|nand_s2_en_via|rst_n 563.15919404
* device instance en_nand_m_en_nand_m_en_via_nand_s2_en_nand_s2_en_via_rst_n_t7 r0 *1 0,0
Ren_nand_m_en_nand_m_en_via_nand_s2_en_nand_s2_en_via_rst_n_t7
+ en\x7cnand_m_en\x7cnand_m_en_via\x7cnand_s2_en\x7cnand_s2_en_via\x7crst_n__t7
+ en|nand_m_en|nand_m_en_via|nand_s2_en|nand_s2_en_via|rst_n 248.545391011
* device instance en_nand_m_en_nand_m_en_via_nand_s2_en_nand_s2_en_via_rst_n_t8 r0 *1 0,0
Ren_nand_m_en_nand_m_en_via_nand_s2_en_nand_s2_en_via_rst_n_t8
+ en\x7cnand_m_en\x7cnand_m_en_via\x7cnand_s2_en\x7cnand_s2_en_via\x7crst_n__t8
+ en|nand_m_en|nand_m_en_via|nand_s2_en|nand_s2_en_via|rst_n 46.0179590648
* device instance en_nand_m_en_nand_m_en_via_nand_s2_en_nand_s2_en_via_rst_n_t9 r0 *1 0,0
Ren_nand_m_en_nand_m_en_via_nand_s2_en_nand_s2_en_via_rst_n_t9
+ en\x7cnand_m_en\x7cnand_m_en_via\x7cnand_s2_en\x7cnand_s2_en_via\x7crst_n__t9
+ en|nand_m_en|nand_m_en_via|nand_s2_en|nand_s2_en_via|rst_n 158.190118881
* device instance en_nand_m_en_nand_m_en_via_nand_s2_en_nand_s2_en_via_rst_n_t10 r0 *1 0,0
Ren_nand_m_en_nand_m_en_via_nand_s2_en_nand_s2_en_via_rst_n_t10
+ en\x7cnand_m_en\x7cnand_m_en_via\x7cnand_s2_en\x7cnand_s2_en_via\x7crst_n__t10
+ en|nand_m_en|nand_m_en_via|nand_s2_en|nand_s2_en_via|rst_n 563.888201984
* device instance en_nand_m_en_nand_m_en_via_nand_s2_en_nand_s2_en_via_rst_n_t11 r0 *1 0,0
Ren_nand_m_en_nand_m_en_via_nand_s2_en_nand_s2_en_via_rst_n_t11
+ en\x7cnand_m_en\x7cnand_m_en_via\x7cnand_s2_en\x7cnand_s2_en_via\x7crst_n__t11
+ en|nand_m_en|nand_m_en_via|nand_s2_en|nand_s2_en_via|rst_n 451.40409154
* device instance en_nand_m_en_nand_m_en_via_nand_s2_en_nand_s2_en_via_rst_n_t12 r0 *1 0,0
Ren_nand_m_en_nand_m_en_via_nand_s2_en_nand_s2_en_via_rst_n_t12
+ en\x7cnand_m_en\x7cnand_m_en_via\x7cnand_s2_en\x7cnand_s2_en_via\x7crst_n__t12
+ en|nand_m_en|nand_m_en_via|nand_s2_en|nand_s2_en_via|rst_n 361.012696742
* device instance en_nand_m_en_nand_m_en_via_nand_s2_en_nand_s2_en_via_rst_n_t13 r0 *1 0,0
Ren_nand_m_en_nand_m_en_via_nand_s2_en_nand_s2_en_via_rst_n_t13
+ en\x7cnand_m_en\x7cnand_m_en_via\x7cnand_s2_en\x7cnand_s2_en_via\x7crst_n__t13
+ en|nand_m_en|nand_m_en_via|nand_s2_en|nand_s2_en_via|rst_n 563.888201984
* device instance en_nand_m_en_nand_m_en_via_nand_s2_en_nand_s2_en_via_rst_n_t14 r0 *1 0,0
Ren_nand_m_en_nand_m_en_via_nand_s2_en_nand_s2_en_via_rst_n_t14
+ en\x7cnand_m_en\x7cnand_m_en_via\x7cnand_s2_en\x7cnand_s2_en_via\x7crst_n__t14
+ en|nand_m_en|nand_m_en_via|nand_s2_en|nand_s2_en_via|rst_n 451.40409154
* device instance en_nand_m_en_nand_m_en_via_nand_s2_en_nand_s2_en_via_rst_n_t15 r0 *1 0,0
Ren_nand_m_en_nand_m_en_via_nand_s2_en_nand_s2_en_via_rst_n_t15
+ en\x7cnand_m_en\x7cnand_m_en_via\x7cnand_s2_en\x7cnand_s2_en_via\x7crst_n__t15
+ en|nand_m_en|nand_m_en_via|nand_s2_en|nand_s2_en_via|rst_n 46.0179590648
* device instance en_nand_m_en_nand_m_en_via_nand_s2_en_nand_s2_en_via_rst_n_t16 r0 *1 0,0
Ren_nand_m_en_nand_m_en_via_nand_s2_en_nand_s2_en_via_rst_n_t16
+ en\x7cnand_m_en\x7cnand_m_en_via\x7cnand_s2_en\x7cnand_s2_en_via\x7crst_n__t16
+ en|nand_m_en|nand_m_en_via|nand_s2_en|nand_s2_en_via|rst_n 248.545391011
* device instance en_nand_m_en_nand_m_en_via_nand_s2_en_nand_s2_en_via_rst_n_t17 r0 *1 0,0
Ren_nand_m_en_nand_m_en_via_nand_s2_en_nand_s2_en_via_rst_n_t17
+ en\x7cnand_m_en\x7cnand_m_en_via\x7cnand_s2_en\x7cnand_s2_en_via\x7crst_n__t17
+ en|nand_m_en|nand_m_en_via|nand_s2_en|nand_s2_en_via|rst_n 158.190118881
* device instance en_nand_m_en_nand_m_en_via_nand_s2_en_nand_s2_en_via_rst_n_t18 r0 *1 0,0
Ren_nand_m_en_nand_m_en_via_nand_s2_en_nand_s2_en_via_rst_n_t18
+ en\x7cnand_m_en\x7cnand_m_en_via\x7cnand_s2_en\x7cnand_s2_en_via\x7crst_n__t18
+ en|nand_m_en|nand_m_en_via|nand_s2_en|nand_s2_en_via|rst_n 361.012696742
* device instance en_nand_m_en_nand_m_en_via_nand_s2_en_nand_s2_en_via_rst_n_t19 r0 *1 0,0
Ren_nand_m_en_nand_m_en_via_nand_s2_en_nand_s2_en_via_rst_n_t19
+ en\x7cnand_m_en\x7cnand_m_en_via\x7cnand_s2_en\x7cnand_s2_en_via\x7crst_n__t19
+ en|nand_m_en|nand_m_en_via|nand_s2_en|nand_s2_en_via|rst_n 45.2961791404
* device instance en_nand_m_en_nand_m_en_via_nand_s2_en_nand_s2_en_via_rst_n_t20 r0 *1 0,0
Ren_nand_m_en_nand_m_en_via_nand_s2_en_nand_s2_en_via_rst_n_t20
+ en\x7cnand_m_en\x7cnand_m_en_via\x7cnand_s2_en\x7cnand_s2_en_via\x7crst_n__t20
+ en|nand_m_en|nand_m_en_via|nand_s2_en|nand_s2_en_via|rst_n 157.461669466
* device instance en_nand_m_en_nand_m_en_via_nand_s2_en_nand_s2_en_via_rst_n_t21 r0 *1 0,0
Ren_nand_m_en_nand_m_en_via_nand_s2_en_nand_s2_en_via_rst_n_t21
+ en\x7cnand_m_en\x7cnand_m_en_via\x7cnand_s2_en\x7cnand_s2_en_via\x7crst_n__t21
+ en|nand_m_en|nand_m_en_via|nand_s2_en|nand_s2_en_via|rst_n 247.816580576
* device instance en_nand_m_en_nand_m_en_via_nand_s2_en_nand_s2_en_via_rst_n_t22 r0 *1 0,0
Ren_nand_m_en_nand_m_en_via_nand_s2_en_nand_s2_en_via_rst_n_t22
+ en\x7cnand_m_en\x7cnand_m_en_via\x7cnand_s2_en\x7cnand_s2_en_via\x7crst_n__t22
+ en|nand_m_en|nand_m_en_via|nand_s2_en|nand_s2_en_via|rst_n 450.675110254
* device instance en_nand_m_en_nand_m_en_via_nand_s2_en_nand_s2_en_via_rst_n_t23 r0 *1 0,0
Ren_nand_m_en_nand_m_en_via_nand_s2_en_nand_s2_en_via_rst_n_t23
+ en\x7cnand_m_en\x7cnand_m_en_via\x7cnand_s2_en\x7cnand_s2_en_via\x7crst_n__t23
+ en|nand_m_en|nand_m_en_via|nand_s2_en|nand_s2_en_via|rst_n 360.283757302
* device instance en_nand_m_en_nand_m_en_via_nand_s2_en_nand_s2_en_via_rst_n r0 *1 0,0
Cen_nand_m_en_nand_m_en_via_nand_s2_en_nand_s2_en_via_rst_n
+ en|nand_m_en|nand_m_en_via|nand_s2_en|nand_s2_en_via|rst_n vsubs 4.62094e-14
* device instance g_vddr_m1_mnt_g_s1_vddr_m1_s2_vddr_m1_s3_vddr_m1_s4_vddr_m1_vddr_vddr1_t0 r0 *1 0,0
Rg_vddr_m1_mnt_g_s1_vddr_m1_s2_vddr_m1_s3_vddr_m1_s4_vddr_m1_vddr_vddr1_t0
+ g_vddr_m1\x7cmnt_g\x7cs1_vddr_m1\x7cs2_vddr_m1\x7cs3_vddr_m1\x7cs4_vddr_m1\x7cvddr\x7cvddr1__t0
+ g_vddr_m1|mnt_g|s1_vddr_m1|s2_vddr_m1|s3_vddr_m1|s4_vddr_m1|vddr|vddr1
+ 176.705854837
* device instance g_vddr_m1_mnt_g_s1_vddr_m1_s2_vddr_m1_s3_vddr_m1_s4_vddr_m1_vddr_vddr1_t1 r0 *1 0,0
Rg_vddr_m1_mnt_g_s1_vddr_m1_s2_vddr_m1_s3_vddr_m1_s4_vddr_m1_vddr_vddr1_t1
+ g_vddr_m1\x7cmnt_g\x7cs1_vddr_m1\x7cs2_vddr_m1\x7cs3_vddr_m1\x7cs4_vddr_m1\x7cvddr\x7cvddr1__t1
+ g_vddr_m1|mnt_g|s1_vddr_m1|s2_vddr_m1|s3_vddr_m1|s4_vddr_m1|vddr|vddr1
+ 174.772567871
* device instance g_vddr_m1_mnt_g_s1_vddr_m1_s2_vddr_m1_s3_vddr_m1_s4_vddr_m1_vddr_vddr1_t2 r0 *1 0,0
Rg_vddr_m1_mnt_g_s1_vddr_m1_s2_vddr_m1_s3_vddr_m1_s4_vddr_m1_vddr_vddr1_t2
+ g_vddr_m1\x7cmnt_g\x7cs1_vddr_m1\x7cs2_vddr_m1\x7cs3_vddr_m1\x7cs4_vddr_m1\x7cvddr\x7cvddr1__t2
+ g_vddr_m1|mnt_g|s1_vddr_m1|s2_vddr_m1|s3_vddr_m1|s4_vddr_m1|vddr|vddr1
+ 174.772567871
* device instance g_vddr_m1_mnt_g_s1_vddr_m1_s2_vddr_m1_s3_vddr_m1_s4_vddr_m1_vddr_vddr1_t3 r0 *1 0,0
Rg_vddr_m1_mnt_g_s1_vddr_m1_s2_vddr_m1_s3_vddr_m1_s4_vddr_m1_vddr_vddr1_t3
+ g_vddr_m1\x7cmnt_g\x7cs1_vddr_m1\x7cs2_vddr_m1\x7cs3_vddr_m1\x7cs4_vddr_m1\x7cvddr\x7cvddr1__t3
+ g_vddr_m1|mnt_g|s1_vddr_m1|s2_vddr_m1|s3_vddr_m1|s4_vddr_m1|vddr|vddr1
+ 170.77639087
* device instance g_vddr_m1_mnt_g_s1_vddr_m1_s2_vddr_m1_s3_vddr_m1_s4_vddr_m1_vddr_vddr1_t4 r0 *1 0,0
Rg_vddr_m1_mnt_g_s1_vddr_m1_s2_vddr_m1_s3_vddr_m1_s4_vddr_m1_vddr_vddr1_t4
+ g_vddr_m1\x7cmnt_g\x7cs1_vddr_m1\x7cs2_vddr_m1\x7cs3_vddr_m1\x7cs4_vddr_m1\x7cvddr\x7cvddr1__t4
+ g_vddr_m1|mnt_g|s1_vddr_m1|s2_vddr_m1|s3_vddr_m1|s4_vddr_m1|vddr|vddr1
+ 87.5707429456
* device instance g_vddr_m1_mnt_g_s1_vddr_m1_s2_vddr_m1_s3_vddr_m1_s4_vddr_m1_vddr_vddr1_t5 r0 *1 0,0
Rg_vddr_m1_mnt_g_s1_vddr_m1_s2_vddr_m1_s3_vddr_m1_s4_vddr_m1_vddr_vddr1_t5
+ g_vddr_m1\x7cmnt_g\x7cs1_vddr_m1\x7cs2_vddr_m1\x7cs3_vddr_m1\x7cs4_vddr_m1\x7cvddr\x7cvddr1__t5
+ g_vddr_m1|mnt_g|s1_vddr_m1|s2_vddr_m1|s3_vddr_m1|s4_vddr_m1|vddr|vddr1
+ 9.35511008331
* device instance g_vddr_m1_mnt_g_s1_vddr_m1_s2_vddr_m1_s3_vddr_m1_s4_vddr_m1_vddr_vddr1_t6 r0 *1 0,0
Rg_vddr_m1_mnt_g_s1_vddr_m1_s2_vddr_m1_s3_vddr_m1_s4_vddr_m1_vddr_vddr1_t6
+ g_vddr_m1\x7cmnt_g\x7cs1_vddr_m1\x7cs2_vddr_m1\x7cs3_vddr_m1\x7cs4_vddr_m1\x7cvddr\x7cvddr1__t6
+ g_vddr_m1|mnt_g|s1_vddr_m1|s2_vddr_m1|s3_vddr_m1|s4_vddr_m1|vddr|vddr1
+ 80.1325456503
* device instance g_vddr_m1_mnt_g_s1_vddr_m1_s2_vddr_m1_s3_vddr_m1_s4_vddr_m1_vddr_vddr1_t7 r0 *1 0,0
Rg_vddr_m1_mnt_g_s1_vddr_m1_s2_vddr_m1_s3_vddr_m1_s4_vddr_m1_vddr_vddr1_t7
+ g_vddr_m1\x7cmnt_g\x7cs1_vddr_m1\x7cs2_vddr_m1\x7cs3_vddr_m1\x7cs4_vddr_m1\x7cvddr\x7cvddr1__t7
+ g_vddr_m1|mnt_g|s1_vddr_m1|s2_vddr_m1|s3_vddr_m1|s4_vddr_m1|vddr|vddr1
+ 170.77639087
* device instance g_vddr_m1_mnt_g_s1_vddr_m1_s2_vddr_m1_s3_vddr_m1_s4_vddr_m1_vddr_vddr1_t8 r0 *1 0,0
Rg_vddr_m1_mnt_g_s1_vddr_m1_s2_vddr_m1_s3_vddr_m1_s4_vddr_m1_vddr_vddr1_t8
+ g_vddr_m1\x7cmnt_g\x7cs1_vddr_m1\x7cs2_vddr_m1\x7cs3_vddr_m1\x7cs4_vddr_m1\x7cvddr\x7cvddr1__t8
+ g_vddr_m1|mnt_g|s1_vddr_m1|s2_vddr_m1|s3_vddr_m1|s4_vddr_m1|vddr|vddr1
+ 87.5707429456
* device instance g_vddr_m1_mnt_g_s1_vddr_m1_s2_vddr_m1_s3_vddr_m1_s4_vddr_m1_vddr_vddr1_t9 r0 *1 0,0
Rg_vddr_m1_mnt_g_s1_vddr_m1_s2_vddr_m1_s3_vddr_m1_s4_vddr_m1_vddr_vddr1_t9
+ g_vddr_m1\x7cmnt_g\x7cs1_vddr_m1\x7cs2_vddr_m1\x7cs3_vddr_m1\x7cs4_vddr_m1\x7cvddr\x7cvddr1__t9
+ g_vddr_m1|mnt_g|s1_vddr_m1|s2_vddr_m1|s3_vddr_m1|s4_vddr_m1|vddr|vddr1
+ 9.35511008331
* device instance g_vddr_m1_mnt_g_s1_vddr_m1_s2_vddr_m1_s3_vddr_m1_s4_vddr_m1_vddr_vddr1_t10 r0 *1 0,0
Rg_vddr_m1_mnt_g_s1_vddr_m1_s2_vddr_m1_s3_vddr_m1_s4_vddr_m1_vddr_vddr1_t10
+ g_vddr_m1\x7cmnt_g\x7cs1_vddr_m1\x7cs2_vddr_m1\x7cs3_vddr_m1\x7cs4_vddr_m1\x7cvddr\x7cvddr1__t10
+ g_vddr_m1|mnt_g|s1_vddr_m1|s2_vddr_m1|s3_vddr_m1|s4_vddr_m1|vddr|vddr1
+ 80.1325456503
* device instance g_vddr_m1_mnt_g_s1_vddr_m1_s2_vddr_m1_s3_vddr_m1_s4_vddr_m1_vddr_vddr1_t11 r0 *1 0,0
Rg_vddr_m1_mnt_g_s1_vddr_m1_s2_vddr_m1_s3_vddr_m1_s4_vddr_m1_vddr_vddr1_t11
+ g_vddr_m1\x7cmnt_g\x7cs1_vddr_m1\x7cs2_vddr_m1\x7cs3_vddr_m1\x7cs4_vddr_m1\x7cvddr\x7cvddr1__t11
+ g_vddr_m1|mnt_g|s1_vddr_m1|s2_vddr_m1|s3_vddr_m1|s4_vddr_m1|vddr|vddr1
+ 84.2658502947
* device instance g_vddr_m1_mnt_g_s1_vddr_m1_s2_vddr_m1_s3_vddr_m1_s4_vddr_m1_vddr_vddr1_t12 r0 *1 0,0
Rg_vddr_m1_mnt_g_s1_vddr_m1_s2_vddr_m1_s3_vddr_m1_s4_vddr_m1_vddr_vddr1_t12
+ g_vddr_m1\x7cmnt_g\x7cs1_vddr_m1\x7cs2_vddr_m1\x7cs3_vddr_m1\x7cs4_vddr_m1\x7cvddr\x7cvddr1__t12
+ g_vddr_m1|mnt_g|s1_vddr_m1|s2_vddr_m1|s3_vddr_m1|s4_vddr_m1|vddr|vddr1
+ 91.3681764814
* device instance g_vddr_m1_mnt_g_s1_vddr_m1_s2_vddr_m1_s3_vddr_m1_s4_vddr_m1_vddr_vddr1_t13 r0 *1 0,0
Rg_vddr_m1_mnt_g_s1_vddr_m1_s2_vddr_m1_s3_vddr_m1_s4_vddr_m1_vddr_vddr1_t13
+ g_vddr_m1\x7cmnt_g\x7cs1_vddr_m1\x7cs2_vddr_m1\x7cs3_vddr_m1\x7cs4_vddr_m1\x7cvddr\x7cvddr1__t13
+ g_vddr_m1|mnt_g|s1_vddr_m1|s2_vddr_m1|s3_vddr_m1|s4_vddr_m1|vddr|vddr1
+ 172.754404667
* device instance g_vddr_m1_mnt_g_s1_vddr_m1_s2_vddr_m1_s3_vddr_m1_s4_vddr_m1_vddr_vddr1_t14 r0 *1 0,0
Rg_vddr_m1_mnt_g_s1_vddr_m1_s2_vddr_m1_s3_vddr_m1_s4_vddr_m1_vddr_vddr1_t14
+ g_vddr_m1\x7cmnt_g\x7cs1_vddr_m1\x7cs2_vddr_m1\x7cs3_vddr_m1\x7cs4_vddr_m1\x7cvddr\x7cvddr1__t14
+ g_vddr_m1|mnt_g|s1_vddr_m1|s2_vddr_m1|s3_vddr_m1|s4_vddr_m1|vddr|vddr1
+ 27.6952475736
* device instance g_vddr_m1_mnt_g_s1_vddr_m1_s2_vddr_m1_s3_vddr_m1_s4_vddr_m1_vddr_vddr1_t15 r0 *1 0,0
Rg_vddr_m1_mnt_g_s1_vddr_m1_s2_vddr_m1_s3_vddr_m1_s4_vddr_m1_vddr_vddr1_t15
+ g_vddr_m1\x7cmnt_g\x7cs1_vddr_m1\x7cs2_vddr_m1\x7cs3_vddr_m1\x7cs4_vddr_m1\x7cvddr\x7cvddr1__t15
+ g_vddr_m1|mnt_g|s1_vddr_m1|s2_vddr_m1|s3_vddr_m1|s4_vddr_m1|vddr|vddr1
+ 109.575837063
* device instance g_vddr_m1_mnt_g_s1_vddr_m1_s2_vddr_m1_s3_vddr_m1_s4_vddr_m1_vddr_vddr1_t16 r0 *1 0,0
Rg_vddr_m1_mnt_g_s1_vddr_m1_s2_vddr_m1_s3_vddr_m1_s4_vddr_m1_vddr_vddr1_t16
+ g_vddr_m1\x7cmnt_g\x7cs1_vddr_m1\x7cs2_vddr_m1\x7cs3_vddr_m1\x7cs4_vddr_m1\x7cvddr\x7cvddr1__t16
+ g_vddr_m1|mnt_g|s1_vddr_m1|s2_vddr_m1|s3_vddr_m1|s4_vddr_m1|vddr|vddr1
+ 192.841625692
* device instance g_vddr_m1_mnt_g_s1_vddr_m1_s2_vddr_m1_s3_vddr_m1_s4_vddr_m1_vddr_vddr1_t17 r0 *1 0,0
Rg_vddr_m1_mnt_g_s1_vddr_m1_s2_vddr_m1_s3_vddr_m1_s4_vddr_m1_vddr_vddr1_t17
+ g_vddr_m1\x7cmnt_g\x7cs1_vddr_m1\x7cs2_vddr_m1\x7cs3_vddr_m1\x7cs4_vddr_m1\x7cvddr\x7cvddr1__t17
+ g_vddr_m1|mnt_g|s1_vddr_m1|s2_vddr_m1|s3_vddr_m1|s4_vddr_m1|vddr|vddr1
+ 27.2150557571
* device instance g_vddr_m1_mnt_g_s1_vddr_m1_s2_vddr_m1_s3_vddr_m1_s4_vddr_m1_vddr_vddr1_t18 r0 *1 0,0
Rg_vddr_m1_mnt_g_s1_vddr_m1_s2_vddr_m1_s3_vddr_m1_s4_vddr_m1_vddr_vddr1_t18
+ g_vddr_m1\x7cmnt_g\x7cs1_vddr_m1\x7cs2_vddr_m1\x7cs3_vddr_m1\x7cs4_vddr_m1\x7cvddr\x7cvddr1__t18
+ g_vddr_m1|mnt_g|s1_vddr_m1|s2_vddr_m1|s3_vddr_m1|s4_vddr_m1|vddr|vddr1
+ 58.217507459
* device instance g_vddr_m1_mnt_g_s1_vddr_m1_s2_vddr_m1_s3_vddr_m1_s4_vddr_m1_vddr_vddr1_t19 r0 *1 0,0
Rg_vddr_m1_mnt_g_s1_vddr_m1_s2_vddr_m1_s3_vddr_m1_s4_vddr_m1_vddr_vddr1_t19
+ g_vddr_m1\x7cmnt_g\x7cs1_vddr_m1\x7cs2_vddr_m1\x7cs3_vddr_m1\x7cs4_vddr_m1\x7cvddr\x7cvddr1__t19
+ g_vddr_m1|mnt_g|s1_vddr_m1|s2_vddr_m1|s3_vddr_m1|s4_vddr_m1|vddr|vddr1
+ 152.713109213
* device instance g_vddr_m1_mnt_g_s1_vddr_m1_s2_vddr_m1_s3_vddr_m1_s4_vddr_m1_vddr_vddr1_t20 r0 *1 0,0
Rg_vddr_m1_mnt_g_s1_vddr_m1_s2_vddr_m1_s3_vddr_m1_s4_vddr_m1_vddr_vddr1_t20
+ g_vddr_m1\x7cmnt_g\x7cs1_vddr_m1\x7cs2_vddr_m1\x7cs3_vddr_m1\x7cs4_vddr_m1\x7cvddr\x7cvddr1__t20
+ g_vddr_m1|mnt_g|s1_vddr_m1|s2_vddr_m1|s3_vddr_m1|s4_vddr_m1|vddr|vddr1
+ 139.573716122
* device instance g_vddr_m1_mnt_g_s1_vddr_m1_s2_vddr_m1_s3_vddr_m1_s4_vddr_m1_vddr_vddr1 r0 *1 0,0
Cg_vddr_m1_mnt_g_s1_vddr_m1_s2_vddr_m1_s3_vddr_m1_s4_vddr_m1_vddr_vddr1
+ g_vddr_m1|mnt_g|s1_vddr_m1|s2_vddr_m1|s3_vddr_m1|s4_vddr_m1|vddr|vddr1 vsubs
+ 1.2359482e-14
* device instance g_vddr_m1_mnt_g_s1_vddr_m1_s2_vddr_m1_s3_vddr_m1_s4_vddr_m1_vddr_vddr2_t0 r0 *1 0,0
Rg_vddr_m1_mnt_g_s1_vddr_m1_s2_vddr_m1_s3_vddr_m1_s4_vddr_m1_vddr_vddr2_t0
+ g_vddr_m1\x7cmnt_g\x7cs1_vddr_m1\x7cs2_vddr_m1\x7cs3_vddr_m1\x7cs4_vddr_m1\x7cvddr\x7cvddr2__t0
+ g_vddr_m1|mnt_g|s1_vddr_m1|s2_vddr_m1|s3_vddr_m1|s4_vddr_m1|vddr|vddr2
+ 176.936070155
* device instance g_vddr_m1_mnt_g_s1_vddr_m1_s2_vddr_m1_s3_vddr_m1_s4_vddr_m1_vddr_vddr2_t1 r0 *1 0,0
Rg_vddr_m1_mnt_g_s1_vddr_m1_s2_vddr_m1_s3_vddr_m1_s4_vddr_m1_vddr_vddr2_t1
+ g_vddr_m1\x7cmnt_g\x7cs1_vddr_m1\x7cs2_vddr_m1\x7cs3_vddr_m1\x7cs4_vddr_m1\x7cvddr\x7cvddr2__t1
+ g_vddr_m1|mnt_g|s1_vddr_m1|s2_vddr_m1|s3_vddr_m1|s4_vddr_m1|vddr|vddr2
+ 175.00026447
* device instance g_vddr_m1_mnt_g_s1_vddr_m1_s2_vddr_m1_s3_vddr_m1_s4_vddr_m1_vddr_vddr2_t2 r0 *1 0,0
Rg_vddr_m1_mnt_g_s1_vddr_m1_s2_vddr_m1_s3_vddr_m1_s4_vddr_m1_vddr_vddr2_t2
+ g_vddr_m1\x7cmnt_g\x7cs1_vddr_m1\x7cs2_vddr_m1\x7cs3_vddr_m1\x7cs4_vddr_m1\x7cvddr\x7cvddr2__t2
+ g_vddr_m1|mnt_g|s1_vddr_m1|s2_vddr_m1|s3_vddr_m1|s4_vddr_m1|vddr|vddr2
+ 175.00026447
* device instance g_vddr_m1_mnt_g_s1_vddr_m1_s2_vddr_m1_s3_vddr_m1_s4_vddr_m1_vddr_vddr2_t3 r0 *1 0,0
Rg_vddr_m1_mnt_g_s1_vddr_m1_s2_vddr_m1_s3_vddr_m1_s4_vddr_m1_vddr_vddr2_t3
+ g_vddr_m1\x7cmnt_g\x7cs1_vddr_m1\x7cs2_vddr_m1\x7cs3_vddr_m1\x7cs4_vddr_m1\x7cvddr\x7cvddr2__t3
+ g_vddr_m1|mnt_g|s1_vddr_m1|s2_vddr_m1|s3_vddr_m1|s4_vddr_m1|vddr|vddr2
+ 87.6848315616
* device instance g_vddr_m1_mnt_g_s1_vddr_m1_s2_vddr_m1_s3_vddr_m1_s4_vddr_m1_vddr_vddr2_t4 r0 *1 0,0
Rg_vddr_m1_mnt_g_s1_vddr_m1_s2_vddr_m1_s3_vddr_m1_s4_vddr_m1_vddr_vddr2_t4
+ g_vddr_m1\x7cmnt_g\x7cs1_vddr_m1\x7cs2_vddr_m1\x7cs3_vddr_m1\x7cs4_vddr_m1\x7cvddr\x7cvddr2__t4
+ g_vddr_m1|mnt_g|s1_vddr_m1|s2_vddr_m1|s3_vddr_m1|s4_vddr_m1|vddr|vddr2
+ 170.998881184
* device instance g_vddr_m1_mnt_g_s1_vddr_m1_s2_vddr_m1_s3_vddr_m1_s4_vddr_m1_vddr_vddr2_t5 r0 *1 0,0
Rg_vddr_m1_mnt_g_s1_vddr_m1_s2_vddr_m1_s3_vddr_m1_s4_vddr_m1_vddr_vddr2_t5
+ g_vddr_m1\x7cmnt_g\x7cs1_vddr_m1\x7cs2_vddr_m1\x7cs3_vddr_m1\x7cs4_vddr_m1\x7cvddr\x7cvddr2__t5
+ g_vddr_m1|mnt_g|s1_vddr_m1|s2_vddr_m1|s3_vddr_m1|s4_vddr_m1|vddr|vddr2
+ 80.2369436595
* device instance g_vddr_m1_mnt_g_s1_vddr_m1_s2_vddr_m1_s3_vddr_m1_s4_vddr_m1_vddr_vddr2_t6 r0 *1 0,0
Rg_vddr_m1_mnt_g_s1_vddr_m1_s2_vddr_m1_s3_vddr_m1_s4_vddr_m1_vddr_vddr2_t6
+ g_vddr_m1\x7cmnt_g\x7cs1_vddr_m1\x7cs2_vddr_m1\x7cs3_vddr_m1\x7cs4_vddr_m1\x7cvddr\x7cvddr2__t6
+ g_vddr_m1|mnt_g|s1_vddr_m1|s2_vddr_m1|s3_vddr_m1|s4_vddr_m1|vddr|vddr2
+ 9.36729807585
* device instance g_vddr_m1_mnt_g_s1_vddr_m1_s2_vddr_m1_s3_vddr_m1_s4_vddr_m1_vddr_vddr2_t7 r0 *1 0,0
Rg_vddr_m1_mnt_g_s1_vddr_m1_s2_vddr_m1_s3_vddr_m1_s4_vddr_m1_vddr_vddr2_t7
+ g_vddr_m1\x7cmnt_g\x7cs1_vddr_m1\x7cs2_vddr_m1\x7cs3_vddr_m1\x7cs4_vddr_m1\x7cvddr\x7cvddr2__t7
+ g_vddr_m1|mnt_g|s1_vddr_m1|s2_vddr_m1|s3_vddr_m1|s4_vddr_m1|vddr|vddr2
+ 87.6848315616
* device instance g_vddr_m1_mnt_g_s1_vddr_m1_s2_vddr_m1_s3_vddr_m1_s4_vddr_m1_vddr_vddr2_t8 r0 *1 0,0
Rg_vddr_m1_mnt_g_s1_vddr_m1_s2_vddr_m1_s3_vddr_m1_s4_vddr_m1_vddr_vddr2_t8
+ g_vddr_m1\x7cmnt_g\x7cs1_vddr_m1\x7cs2_vddr_m1\x7cs3_vddr_m1\x7cs4_vddr_m1\x7cvddr\x7cvddr2__t8
+ g_vddr_m1|mnt_g|s1_vddr_m1|s2_vddr_m1|s3_vddr_m1|s4_vddr_m1|vddr|vddr2
+ 170.998881184
* device instance g_vddr_m1_mnt_g_s1_vddr_m1_s2_vddr_m1_s3_vddr_m1_s4_vddr_m1_vddr_vddr2_t9 r0 *1 0,0
Rg_vddr_m1_mnt_g_s1_vddr_m1_s2_vddr_m1_s3_vddr_m1_s4_vddr_m1_vddr_vddr2_t9
+ g_vddr_m1\x7cmnt_g\x7cs1_vddr_m1\x7cs2_vddr_m1\x7cs3_vddr_m1\x7cs4_vddr_m1\x7cvddr\x7cvddr2__t9
+ g_vddr_m1|mnt_g|s1_vddr_m1|s2_vddr_m1|s3_vddr_m1|s4_vddr_m1|vddr|vddr2
+ 80.2369436595
* device instance g_vddr_m1_mnt_g_s1_vddr_m1_s2_vddr_m1_s3_vddr_m1_s4_vddr_m1_vddr_vddr2_t10 r0 *1 0,0
Rg_vddr_m1_mnt_g_s1_vddr_m1_s2_vddr_m1_s3_vddr_m1_s4_vddr_m1_vddr_vddr2_t10
+ g_vddr_m1\x7cmnt_g\x7cs1_vddr_m1\x7cs2_vddr_m1\x7cs3_vddr_m1\x7cs4_vddr_m1\x7cvddr\x7cvddr2__t10
+ g_vddr_m1|mnt_g|s1_vddr_m1|s2_vddr_m1|s3_vddr_m1|s4_vddr_m1|vddr|vddr2
+ 9.36729807585
* device instance g_vddr_m1_mnt_g_s1_vddr_m1_s2_vddr_m1_s3_vddr_m1_s4_vddr_m1_vddr_vddr2_t11 r0 *1 0,0
Rg_vddr_m1_mnt_g_s1_vddr_m1_s2_vddr_m1_s3_vddr_m1_s4_vddr_m1_vddr_vddr2_t11
+ g_vddr_m1\x7cmnt_g\x7cs1_vddr_m1\x7cs2_vddr_m1\x7cs3_vddr_m1\x7cs4_vddr_m1\x7cvddr\x7cvddr2__t11
+ g_vddr_m1|mnt_g|s1_vddr_m1|s2_vddr_m1|s3_vddr_m1|s4_vddr_m1|vddr|vddr2
+ 27.7313294014
* device instance g_vddr_m1_mnt_g_s1_vddr_m1_s2_vddr_m1_s3_vddr_m1_s4_vddr_m1_vddr_vddr2_t12 r0 *1 0,0
Rg_vddr_m1_mnt_g_s1_vddr_m1_s2_vddr_m1_s3_vddr_m1_s4_vddr_m1_vddr_vddr2_t12
+ g_vddr_m1\x7cmnt_g\x7cs1_vddr_m1\x7cs2_vddr_m1\x7cs3_vddr_m1\x7cs4_vddr_m1\x7cvddr\x7cvddr2__t12
+ g_vddr_m1|mnt_g|s1_vddr_m1|s2_vddr_m1|s3_vddr_m1|s4_vddr_m1|vddr|vddr2
+ 172.97947197
* device instance g_vddr_m1_mnt_g_s1_vddr_m1_s2_vddr_m1_s3_vddr_m1_s4_vddr_m1_vddr_vddr2_t13 r0 *1 0,0
Rg_vddr_m1_mnt_g_s1_vddr_m1_s2_vddr_m1_s3_vddr_m1_s4_vddr_m1_vddr_vddr2_t13
+ g_vddr_m1\x7cmnt_g\x7cs1_vddr_m1\x7cs2_vddr_m1\x7cs3_vddr_m1\x7cs4_vddr_m1\x7cvddr\x7cvddr2__t13
+ g_vddr_m1|mnt_g|s1_vddr_m1|s2_vddr_m1|s3_vddr_m1|s4_vddr_m1|vddr|vddr2
+ 91.4872124567
* device instance g_vddr_m1_mnt_g_s1_vddr_m1_s2_vddr_m1_s3_vddr_m1_s4_vddr_m1_vddr_vddr2_t14 r0 *1 0,0
Rg_vddr_m1_mnt_g_s1_vddr_m1_s2_vddr_m1_s3_vddr_m1_s4_vddr_m1_vddr_vddr2_t14
+ g_vddr_m1\x7cmnt_g\x7cs1_vddr_m1\x7cs2_vddr_m1\x7cs3_vddr_m1\x7cs4_vddr_m1\x7cvddr\x7cvddr2__t14
+ g_vddr_m1|mnt_g|s1_vddr_m1|s2_vddr_m1|s3_vddr_m1|s4_vddr_m1|vddr|vddr2
+ 84.3756332417
* device instance g_vddr_m1_mnt_g_s1_vddr_m1_s2_vddr_m1_s3_vddr_m1_s4_vddr_m1_vddr_vddr2_t15 r0 *1 0,0
Rg_vddr_m1_mnt_g_s1_vddr_m1_s2_vddr_m1_s3_vddr_m1_s4_vddr_m1_vddr_vddr2_t15
+ g_vddr_m1\x7cmnt_g\x7cs1_vddr_m1\x7cs2_vddr_m1\x7cs3_vddr_m1\x7cs4_vddr_m1\x7cvddr\x7cvddr2__t15
+ g_vddr_m1|mnt_g|s1_vddr_m1|s2_vddr_m1|s3_vddr_m1|s4_vddr_m1|vddr|vddr2
+ 193.092862959
* device instance g_vddr_m1_mnt_g_s1_vddr_m1_s2_vddr_m1_s3_vddr_m1_s4_vddr_m1_vddr_vddr2_t16 r0 *1 0,0
Rg_vddr_m1_mnt_g_s1_vddr_m1_s2_vddr_m1_s3_vddr_m1_s4_vddr_m1_vddr_vddr2_t16
+ g_vddr_m1\x7cmnt_g\x7cs1_vddr_m1\x7cs2_vddr_m1\x7cs3_vddr_m1\x7cs4_vddr_m1\x7cvddr\x7cvddr2__t16
+ g_vddr_m1|mnt_g|s1_vddr_m1|s2_vddr_m1|s3_vddr_m1|s4_vddr_m1|vddr|vddr2
+ 152.912066384
* device instance g_vddr_m1_mnt_g_s1_vddr_m1_s2_vddr_m1_s3_vddr_m1_s4_vddr_m1_vddr_vddr2_t17 r0 *1 0,0
Rg_vddr_m1_mnt_g_s1_vddr_m1_s2_vddr_m1_s3_vddr_m1_s4_vddr_m1_vddr_vddr2_t17
+ g_vddr_m1\x7cmnt_g\x7cs1_vddr_m1\x7cs2_vddr_m1\x7cs3_vddr_m1\x7cs4_vddr_m1\x7cvddr\x7cvddr2__t17
+ g_vddr_m1|mnt_g|s1_vddr_m1|s2_vddr_m1|s3_vddr_m1|s4_vddr_m1|vddr|vddr2
+ 139.755555074
* device instance g_vddr_m1_mnt_g_s1_vddr_m1_s2_vddr_m1_s3_vddr_m1_s4_vddr_m1_vddr_vddr2_t18 r0 *1 0,0
Rg_vddr_m1_mnt_g_s1_vddr_m1_s2_vddr_m1_s3_vddr_m1_s4_vddr_m1_vddr_vddr2_t18
+ g_vddr_m1\x7cmnt_g\x7cs1_vddr_m1\x7cs2_vddr_m1\x7cs3_vddr_m1\x7cs4_vddr_m1\x7cvddr\x7cvddr2__t18
+ g_vddr_m1|mnt_g|s1_vddr_m1|s2_vddr_m1|s3_vddr_m1|s4_vddr_m1|vddr|vddr2
+ 58.2933541931
* device instance g_vddr_m1_mnt_g_s1_vddr_m1_s2_vddr_m1_s3_vddr_m1_s4_vddr_m1_vddr_vddr2_t19 r0 *1 0,0
Rg_vddr_m1_mnt_g_s1_vddr_m1_s2_vddr_m1_s3_vddr_m1_s4_vddr_m1_vddr_vddr2_t19
+ g_vddr_m1\x7cmnt_g\x7cs1_vddr_m1\x7cs2_vddr_m1\x7cs3_vddr_m1\x7cs4_vddr_m1\x7cvddr\x7cvddr2__t19
+ g_vddr_m1|mnt_g|s1_vddr_m1|s2_vddr_m1|s3_vddr_m1|s4_vddr_m1|vddr|vddr2
+ 27.250511983
* device instance g_vddr_m1_mnt_g_s1_vddr_m1_s2_vddr_m1_s3_vddr_m1_s4_vddr_m1_vddr_vddr2_t20 r0 *1 0,0
Rg_vddr_m1_mnt_g_s1_vddr_m1_s2_vddr_m1_s3_vddr_m1_s4_vddr_m1_vddr_vddr2_t20
+ g_vddr_m1\x7cmnt_g\x7cs1_vddr_m1\x7cs2_vddr_m1\x7cs3_vddr_m1\x7cs4_vddr_m1\x7cvddr\x7cvddr2__t20
+ g_vddr_m1|mnt_g|s1_vddr_m1|s2_vddr_m1|s3_vddr_m1|s4_vddr_m1|vddr|vddr2
+ 109.718594281
* device instance g_vddr_m1_mnt_g_s1_vddr_m1_s2_vddr_m1_s3_vddr_m1_s4_vddr_m1_vddr_vddr2 r0 *1 0,0
Cg_vddr_m1_mnt_g_s1_vddr_m1_s2_vddr_m1_s3_vddr_m1_s4_vddr_m1_vddr_vddr2
+ g_vddr_m1|mnt_g|s1_vddr_m1|s2_vddr_m1|s3_vddr_m1|s4_vddr_m1|vddr|vddr2 vsubs
+ 1.2368661e-14
* device instance g_vddr_m1_mnt_g_s1_vddr_m1_s2_vddr_m1_s3_vddr_m1_s4_vddr_m1_vddr_vddr3_t0 r0 *1 0,0
Rg_vddr_m1_mnt_g_s1_vddr_m1_s2_vddr_m1_s3_vddr_m1_s4_vddr_m1_vddr_vddr3_t0
+ g_vddr_m1\x7cmnt_g\x7cs1_vddr_m1\x7cs2_vddr_m1\x7cs3_vddr_m1\x7cs4_vddr_m1\x7cvddr\x7cvddr3__t0
+ g_vddr_m1|mnt_g|s1_vddr_m1|s2_vddr_m1|s3_vddr_m1|s4_vddr_m1|vddr|vddr3
+ 177.166308742
* device instance g_vddr_m1_mnt_g_s1_vddr_m1_s2_vddr_m1_s3_vddr_m1_s4_vddr_m1_vddr_vddr3_t1 r0 *1 0,0
Rg_vddr_m1_mnt_g_s1_vddr_m1_s2_vddr_m1_s3_vddr_m1_s4_vddr_m1_vddr_vddr3_t1
+ g_vddr_m1\x7cmnt_g\x7cs1_vddr_m1\x7cs2_vddr_m1\x7cs3_vddr_m1\x7cs4_vddr_m1\x7cvddr\x7cvddr3__t1
+ g_vddr_m1|mnt_g|s1_vddr_m1|s2_vddr_m1|s3_vddr_m1|s4_vddr_m1|vddr|vddr3
+ 175.227984085
* device instance g_vddr_m1_mnt_g_s1_vddr_m1_s2_vddr_m1_s3_vddr_m1_s4_vddr_m1_vddr_vddr3_t2 r0 *1 0,0
Rg_vddr_m1_mnt_g_s1_vddr_m1_s2_vddr_m1_s3_vddr_m1_s4_vddr_m1_vddr_vddr3_t2
+ g_vddr_m1\x7cmnt_g\x7cs1_vddr_m1\x7cs2_vddr_m1\x7cs3_vddr_m1\x7cs4_vddr_m1\x7cvddr\x7cvddr3__t2
+ g_vddr_m1|mnt_g|s1_vddr_m1|s2_vddr_m1|s3_vddr_m1|s4_vddr_m1|vddr|vddr3
+ 175.227984085
* device instance g_vddr_m1_mnt_g_s1_vddr_m1_s2_vddr_m1_s3_vddr_m1_s4_vddr_m1_vddr_vddr3_t3 r0 *1 0,0
Rg_vddr_m1_mnt_g_s1_vddr_m1_s2_vddr_m1_s3_vddr_m1_s4_vddr_m1_vddr_vddr3_t3
+ g_vddr_m1\x7cmnt_g\x7cs1_vddr_m1\x7cs2_vddr_m1\x7cs3_vddr_m1\x7cs4_vddr_m1\x7cvddr\x7cvddr3__t3
+ g_vddr_m1|mnt_g|s1_vddr_m1|s2_vddr_m1|s3_vddr_m1|s4_vddr_m1|vddr|vddr3
+ 171.221393986
* device instance g_vddr_m1_mnt_g_s1_vddr_m1_s2_vddr_m1_s3_vddr_m1_s4_vddr_m1_vddr_vddr3_t4 r0 *1 0,0
Rg_vddr_m1_mnt_g_s1_vddr_m1_s2_vddr_m1_s3_vddr_m1_s4_vddr_m1_vddr_vddr3_t4
+ g_vddr_m1\x7cmnt_g\x7cs1_vddr_m1\x7cs2_vddr_m1\x7cs3_vddr_m1\x7cs4_vddr_m1\x7cvddr\x7cvddr3__t4
+ g_vddr_m1|mnt_g|s1_vddr_m1|s2_vddr_m1|s3_vddr_m1|s4_vddr_m1|vddr|vddr3
+ 87.7989317094
* device instance g_vddr_m1_mnt_g_s1_vddr_m1_s2_vddr_m1_s3_vddr_m1_s4_vddr_m1_vddr_vddr3_t5 r0 *1 0,0
Rg_vddr_m1_mnt_g_s1_vddr_m1_s2_vddr_m1_s3_vddr_m1_s4_vddr_m1_vddr_vddr3_t5
+ g_vddr_m1\x7cmnt_g\x7cs1_vddr_m1\x7cs2_vddr_m1\x7cs3_vddr_m1\x7cs4_vddr_m1\x7cvddr\x7cvddr3__t5
+ g_vddr_m1|mnt_g|s1_vddr_m1|s2_vddr_m1|s3_vddr_m1|s4_vddr_m1|vddr|vddr3
+ 9.37948730032
* device instance g_vddr_m1_mnt_g_s1_vddr_m1_s2_vddr_m1_s3_vddr_m1_s4_vddr_m1_vddr_vddr3_t6 r0 *1 0,0
Rg_vddr_m1_mnt_g_s1_vddr_m1_s2_vddr_m1_s3_vddr_m1_s4_vddr_m1_vddr_vddr3_t6
+ g_vddr_m1\x7cmnt_g\x7cs1_vddr_m1\x7cs2_vddr_m1\x7cs3_vddr_m1\x7cs4_vddr_m1\x7cvddr\x7cvddr3__t6
+ g_vddr_m1|mnt_g|s1_vddr_m1|s2_vddr_m1|s3_vddr_m1|s4_vddr_m1|vddr|vddr3
+ 80.341352221
* device instance g_vddr_m1_mnt_g_s1_vddr_m1_s2_vddr_m1_s3_vddr_m1_s4_vddr_m1_vddr_vddr3_t7 r0 *1 0,0
Rg_vddr_m1_mnt_g_s1_vddr_m1_s2_vddr_m1_s3_vddr_m1_s4_vddr_m1_vddr_vddr3_t7
+ g_vddr_m1\x7cmnt_g\x7cs1_vddr_m1\x7cs2_vddr_m1\x7cs3_vddr_m1\x7cs4_vddr_m1\x7cvddr\x7cvddr3__t7
+ g_vddr_m1|mnt_g|s1_vddr_m1|s2_vddr_m1|s3_vddr_m1|s4_vddr_m1|vddr|vddr3
+ 171.221393986
* device instance g_vddr_m1_mnt_g_s1_vddr_m1_s2_vddr_m1_s3_vddr_m1_s4_vddr_m1_vddr_vddr3_t8 r0 *1 0,0
Rg_vddr_m1_mnt_g_s1_vddr_m1_s2_vddr_m1_s3_vddr_m1_s4_vddr_m1_vddr_vddr3_t8
+ g_vddr_m1\x7cmnt_g\x7cs1_vddr_m1\x7cs2_vddr_m1\x7cs3_vddr_m1\x7cs4_vddr_m1\x7cvddr\x7cvddr3__t8
+ g_vddr_m1|mnt_g|s1_vddr_m1|s2_vddr_m1|s3_vddr_m1|s4_vddr_m1|vddr|vddr3
+ 87.7989317094
* device instance g_vddr_m1_mnt_g_s1_vddr_m1_s2_vddr_m1_s3_vddr_m1_s4_vddr_m1_vddr_vddr3_t9 r0 *1 0,0
Rg_vddr_m1_mnt_g_s1_vddr_m1_s2_vddr_m1_s3_vddr_m1_s4_vddr_m1_vddr_vddr3_t9
+ g_vddr_m1\x7cmnt_g\x7cs1_vddr_m1\x7cs2_vddr_m1\x7cs3_vddr_m1\x7cs4_vddr_m1\x7cvddr\x7cvddr3__t9
+ g_vddr_m1|mnt_g|s1_vddr_m1|s2_vddr_m1|s3_vddr_m1|s4_vddr_m1|vddr|vddr3
+ 9.37948730032
* device instance g_vddr_m1_mnt_g_s1_vddr_m1_s2_vddr_m1_s3_vddr_m1_s4_vddr_m1_vddr_vddr3_t10 r0 *1 0,0
Rg_vddr_m1_mnt_g_s1_vddr_m1_s2_vddr_m1_s3_vddr_m1_s4_vddr_m1_vddr_vddr3_t10
+ g_vddr_m1\x7cmnt_g\x7cs1_vddr_m1\x7cs2_vddr_m1\x7cs3_vddr_m1\x7cs4_vddr_m1\x7cvddr\x7cvddr3__t10
+ g_vddr_m1|mnt_g|s1_vddr_m1|s2_vddr_m1|s3_vddr_m1|s4_vddr_m1|vddr|vddr3
+ 80.341352221
* device instance g_vddr_m1_mnt_g_s1_vddr_m1_s2_vddr_m1_s3_vddr_m1_s4_vddr_m1_vddr_vddr3_t11 r0 *1 0,0
Rg_vddr_m1_mnt_g_s1_vddr_m1_s2_vddr_m1_s3_vddr_m1_s4_vddr_m1_vddr_vddr3_t11
+ g_vddr_m1\x7cmnt_g\x7cs1_vddr_m1\x7cs2_vddr_m1\x7cs3_vddr_m1\x7cs4_vddr_m1\x7cvddr\x7cvddr3__t11
+ g_vddr_m1|mnt_g|s1_vddr_m1|s2_vddr_m1|s3_vddr_m1|s4_vddr_m1|vddr|vddr3
+ 27.7674148762
* device instance g_vddr_m1_mnt_g_s1_vddr_m1_s2_vddr_m1_s3_vddr_m1_s4_vddr_m1_vddr_vddr3_t12 r0 *1 0,0
Rg_vddr_m1_mnt_g_s1_vddr_m1_s2_vddr_m1_s3_vddr_m1_s4_vddr_m1_vddr_vddr3_t12
+ g_vddr_m1\x7cmnt_g\x7cs1_vddr_m1\x7cs2_vddr_m1\x7cs3_vddr_m1\x7cs4_vddr_m1\x7cvddr\x7cvddr3__t12
+ g_vddr_m1|mnt_g|s1_vddr_m1|s2_vddr_m1|s3_vddr_m1|s4_vddr_m1|vddr|vddr3
+ 84.4854272854
* device instance g_vddr_m1_mnt_g_s1_vddr_m1_s2_vddr_m1_s3_vddr_m1_s4_vddr_m1_vddr_vddr3_t13 r0 *1 0,0
Rg_vddr_m1_mnt_g_s1_vddr_m1_s2_vddr_m1_s3_vddr_m1_s4_vddr_m1_vddr_vddr3_t13
+ g_vddr_m1\x7cmnt_g\x7cs1_vddr_m1\x7cs2_vddr_m1\x7cs3_vddr_m1\x7cs4_vddr_m1\x7cvddr\x7cvddr3__t13
+ g_vddr_m1|mnt_g|s1_vddr_m1|s2_vddr_m1|s3_vddr_m1|s4_vddr_m1|vddr|vddr3
+ 173.204562023
* device instance g_vddr_m1_mnt_g_s1_vddr_m1_s2_vddr_m1_s3_vddr_m1_s4_vddr_m1_vddr_vddr3_t14 r0 *1 0,0
Rg_vddr_m1_mnt_g_s1_vddr_m1_s2_vddr_m1_s3_vddr_m1_s4_vddr_m1_vddr_vddr3_t14
+ g_vddr_m1\x7cmnt_g\x7cs1_vddr_m1\x7cs2_vddr_m1\x7cs3_vddr_m1\x7cs4_vddr_m1\x7cvddr\x7cvddr3__t14
+ g_vddr_m1|mnt_g|s1_vddr_m1|s2_vddr_m1|s3_vddr_m1|s4_vddr_m1|vddr|vddr3
+ 91.606260464
* device instance g_vddr_m1_mnt_g_s1_vddr_m1_s2_vddr_m1_s3_vddr_m1_s4_vddr_m1_vddr_vddr3_t15 r0 *1 0,0
Rg_vddr_m1_mnt_g_s1_vddr_m1_s2_vddr_m1_s3_vddr_m1_s4_vddr_m1_vddr_vddr3_t15
+ g_vddr_m1\x7cmnt_g\x7cs1_vddr_m1\x7cs2_vddr_m1\x7cs3_vddr_m1\x7cs4_vddr_m1\x7cvddr\x7cvddr3__t15
+ g_vddr_m1|mnt_g|s1_vddr_m1|s2_vddr_m1|s3_vddr_m1|s4_vddr_m1|vddr|vddr3
+ 58.3692085936
* device instance g_vddr_m1_mnt_g_s1_vddr_m1_s2_vddr_m1_s3_vddr_m1_s4_vddr_m1_vddr_vddr3_t16 r0 *1 0,0
Rg_vddr_m1_mnt_g_s1_vddr_m1_s2_vddr_m1_s3_vddr_m1_s4_vddr_m1_vddr_vddr3_t16
+ g_vddr_m1\x7cmnt_g\x7cs1_vddr_m1\x7cs2_vddr_m1\x7cs3_vddr_m1\x7cs4_vddr_m1\x7cvddr\x7cvddr3__t16
+ g_vddr_m1|mnt_g|s1_vddr_m1|s2_vddr_m1|s3_vddr_m1|s4_vddr_m1|vddr|vddr3
+ 139.937412406
* device instance g_vddr_m1_mnt_g_s1_vddr_m1_s2_vddr_m1_s3_vddr_m1_s4_vddr_m1_vddr_vddr3_t17 r0 *1 0,0
Rg_vddr_m1_mnt_g_s1_vddr_m1_s2_vddr_m1_s3_vddr_m1_s4_vddr_m1_vddr_vddr3_t17
+ g_vddr_m1\x7cmnt_g\x7cs1_vddr_m1\x7cs2_vddr_m1\x7cs3_vddr_m1\x7cs4_vddr_m1\x7cvddr\x7cvddr3__t17
+ g_vddr_m1|mnt_g|s1_vddr_m1|s2_vddr_m1|s3_vddr_m1|s4_vddr_m1|vddr|vddr3
+ 153.111043665
* device instance g_vddr_m1_mnt_g_s1_vddr_m1_s2_vddr_m1_s3_vddr_m1_s4_vddr_m1_vddr_vddr3_t18 r0 *1 0,0
Rg_vddr_m1_mnt_g_s1_vddr_m1_s2_vddr_m1_s3_vddr_m1_s4_vddr_m1_vddr_vddr3_t18
+ g_vddr_m1\x7cmnt_g\x7cs1_vddr_m1\x7cs2_vddr_m1\x7cs3_vddr_m1\x7cs4_vddr_m1\x7cvddr\x7cvddr3__t18
+ g_vddr_m1|mnt_g|s1_vddr_m1|s2_vddr_m1|s3_vddr_m1|s4_vddr_m1|vddr|vddr3
+ 27.2859717928
* device instance g_vddr_m1_mnt_g_s1_vddr_m1_s2_vddr_m1_s3_vddr_m1_s4_vddr_m1_vddr_vddr3_t19 r0 *1 0,0
Rg_vddr_m1_mnt_g_s1_vddr_m1_s2_vddr_m1_s3_vddr_m1_s4_vddr_m1_vddr_vddr3_t19
+ g_vddr_m1\x7cmnt_g\x7cs1_vddr_m1\x7cs2_vddr_m1\x7cs3_vddr_m1\x7cs4_vddr_m1\x7cvddr\x7cvddr3__t19
+ g_vddr_m1|mnt_g|s1_vddr_m1|s2_vddr_m1|s3_vddr_m1|s4_vddr_m1|vddr|vddr3
+ 193.344125621
* device instance g_vddr_m1_mnt_g_s1_vddr_m1_s2_vddr_m1_s3_vddr_m1_s4_vddr_m1_vddr_vddr3_t20 r0 *1 0,0
Rg_vddr_m1_mnt_g_s1_vddr_m1_s2_vddr_m1_s3_vddr_m1_s4_vddr_m1_vddr_vddr3_t20
+ g_vddr_m1\x7cmnt_g\x7cs1_vddr_m1\x7cs2_vddr_m1\x7cs3_vddr_m1\x7cs4_vddr_m1\x7cvddr\x7cvddr3__t20
+ g_vddr_m1|mnt_g|s1_vddr_m1|s2_vddr_m1|s3_vddr_m1|s4_vddr_m1|vddr|vddr3
+ 109.861365928
* device instance g_vddr_m1_mnt_g_s1_vddr_m1_s2_vddr_m1_s3_vddr_m1_s4_vddr_m1_vddr_vddr3 r0 *1 0,0
Cg_vddr_m1_mnt_g_s1_vddr_m1_s2_vddr_m1_s3_vddr_m1_s4_vddr_m1_vddr_vddr3
+ g_vddr_m1|mnt_g|s1_vddr_m1|s2_vddr_m1|s3_vddr_m1|s4_vddr_m1|vddr|vddr3 vsubs
+ 1.2373945e-14
* device instance g_vddr_m1_mnt_g_s1_vddr_m1_s2_vddr_m1_s3_vddr_m1_s4_vddr_m1_vddr_vddr4_t0 r0 *1 0,0
Rg_vddr_m1_mnt_g_s1_vddr_m1_s2_vddr_m1_s3_vddr_m1_s4_vddr_m1_vddr_vddr4_t0
+ g_vddr_m1\x7cmnt_g\x7cs1_vddr_m1\x7cs2_vddr_m1\x7cs3_vddr_m1\x7cs4_vddr_m1\x7cvddr\x7cvddr4__t0
+ g_vddr_m1|mnt_g|s1_vddr_m1|s2_vddr_m1|s3_vddr_m1|s4_vddr_m1|vddr|vddr4
+ 177.3965706
* device instance g_vddr_m1_mnt_g_s1_vddr_m1_s2_vddr_m1_s3_vddr_m1_s4_vddr_m1_vddr_vddr4_t1 r0 *1 0,0
Rg_vddr_m1_mnt_g_s1_vddr_m1_s2_vddr_m1_s3_vddr_m1_s4_vddr_m1_vddr_vddr4_t1
+ g_vddr_m1\x7cmnt_g\x7cs1_vddr_m1\x7cs2_vddr_m1\x7cs3_vddr_m1\x7cs4_vddr_m1\x7cvddr\x7cvddr4__t1
+ g_vddr_m1|mnt_g|s1_vddr_m1|s2_vddr_m1|s3_vddr_m1|s4_vddr_m1|vddr|vddr4
+ 175.455726715
* device instance g_vddr_m1_mnt_g_s1_vddr_m1_s2_vddr_m1_s3_vddr_m1_s4_vddr_m1_vddr_vddr4_t2 r0 *1 0,0
Rg_vddr_m1_mnt_g_s1_vddr_m1_s2_vddr_m1_s3_vddr_m1_s4_vddr_m1_vddr_vddr4_t2
+ g_vddr_m1\x7cmnt_g\x7cs1_vddr_m1\x7cs2_vddr_m1\x7cs3_vddr_m1\x7cs4_vddr_m1\x7cvddr\x7cvddr4__t2
+ g_vddr_m1|mnt_g|s1_vddr_m1|s2_vddr_m1|s3_vddr_m1|s4_vddr_m1|vddr|vddr4
+ 175.455726715
* device instance g_vddr_m1_mnt_g_s1_vddr_m1_s2_vddr_m1_s3_vddr_m1_s4_vddr_m1_vddr_vddr4_t3 r0 *1 0,0
Rg_vddr_m1_mnt_g_s1_vddr_m1_s2_vddr_m1_s3_vddr_m1_s4_vddr_m1_vddr_vddr4_t3
+ g_vddr_m1\x7cmnt_g\x7cs1_vddr_m1\x7cs2_vddr_m1\x7cs3_vddr_m1\x7cs4_vddr_m1\x7cvddr\x7cvddr4__t3
+ g_vddr_m1|mnt_g|s1_vddr_m1|s2_vddr_m1|s3_vddr_m1|s4_vddr_m1|vddr|vddr4
+ 9.39167775674
* device instance g_vddr_m1_mnt_g_s1_vddr_m1_s2_vddr_m1_s3_vddr_m1_s4_vddr_m1_vddr_vddr4_t4 r0 *1 0,0
Rg_vddr_m1_mnt_g_s1_vddr_m1_s2_vddr_m1_s3_vddr_m1_s4_vddr_m1_vddr_vddr4_t4
+ g_vddr_m1\x7cmnt_g\x7cs1_vddr_m1\x7cs2_vddr_m1\x7cs3_vddr_m1\x7cs4_vddr_m1\x7cvddr\x7cvddr4__t4
+ g_vddr_m1|mnt_g|s1_vddr_m1|s2_vddr_m1|s3_vddr_m1|s4_vddr_m1|vddr|vddr4
+ 87.9130433891
* device instance g_vddr_m1_mnt_g_s1_vddr_m1_s2_vddr_m1_s3_vddr_m1_s4_vddr_m1_vddr_vddr4_t5 r0 *1 0,0
Rg_vddr_m1_mnt_g_s1_vddr_m1_s2_vddr_m1_s3_vddr_m1_s4_vddr_m1_vddr_vddr4_t5
+ g_vddr_m1\x7cmnt_g\x7cs1_vddr_m1\x7cs2_vddr_m1\x7cs3_vddr_m1\x7cs4_vddr_m1\x7cvddr\x7cvddr4__t5
+ g_vddr_m1|mnt_g|s1_vddr_m1|s2_vddr_m1|s3_vddr_m1|s4_vddr_m1|vddr|vddr4
+ 171.443929278
* device instance g_vddr_m1_mnt_g_s1_vddr_m1_s2_vddr_m1_s3_vddr_m1_s4_vddr_m1_vddr_vddr4_t6 r0 *1 0,0
Rg_vddr_m1_mnt_g_s1_vddr_m1_s2_vddr_m1_s3_vddr_m1_s4_vddr_m1_vddr_vddr4_t6
+ g_vddr_m1\x7cmnt_g\x7cs1_vddr_m1\x7cs2_vddr_m1\x7cs3_vddr_m1\x7cs4_vddr_m1\x7cvddr\x7cvddr4__t6
+ g_vddr_m1|mnt_g|s1_vddr_m1|s2_vddr_m1|s3_vddr_m1|s4_vddr_m1|vddr|vddr4
+ 80.4457713349
* device instance g_vddr_m1_mnt_g_s1_vddr_m1_s2_vddr_m1_s3_vddr_m1_s4_vddr_m1_vddr_vddr4_t7 r0 *1 0,0
Rg_vddr_m1_mnt_g_s1_vddr_m1_s2_vddr_m1_s3_vddr_m1_s4_vddr_m1_vddr_vddr4_t7
+ g_vddr_m1\x7cmnt_g\x7cs1_vddr_m1\x7cs2_vddr_m1\x7cs3_vddr_m1\x7cs4_vddr_m1\x7cvddr\x7cvddr4__t7
+ g_vddr_m1|mnt_g|s1_vddr_m1|s2_vddr_m1|s3_vddr_m1|s4_vddr_m1|vddr|vddr4
+ 9.39167775674
* device instance g_vddr_m1_mnt_g_s1_vddr_m1_s2_vddr_m1_s3_vddr_m1_s4_vddr_m1_vddr_vddr4_t8 r0 *1 0,0
Rg_vddr_m1_mnt_g_s1_vddr_m1_s2_vddr_m1_s3_vddr_m1_s4_vddr_m1_vddr_vddr4_t8
+ g_vddr_m1\x7cmnt_g\x7cs1_vddr_m1\x7cs2_vddr_m1\x7cs3_vddr_m1\x7cs4_vddr_m1\x7cvddr\x7cvddr4__t8
+ g_vddr_m1|mnt_g|s1_vddr_m1|s2_vddr_m1|s3_vddr_m1|s4_vddr_m1|vddr|vddr4
+ 87.9130433891
* device instance g_vddr_m1_mnt_g_s1_vddr_m1_s2_vddr_m1_s3_vddr_m1_s4_vddr_m1_vddr_vddr4_t9 r0 *1 0,0
Rg_vddr_m1_mnt_g_s1_vddr_m1_s2_vddr_m1_s3_vddr_m1_s4_vddr_m1_vddr_vddr4_t9
+ g_vddr_m1\x7cmnt_g\x7cs1_vddr_m1\x7cs2_vddr_m1\x7cs3_vddr_m1\x7cs4_vddr_m1\x7cvddr\x7cvddr4__t9
+ g_vddr_m1|mnt_g|s1_vddr_m1|s2_vddr_m1|s3_vddr_m1|s4_vddr_m1|vddr|vddr4
+ 171.443929278
* device instance g_vddr_m1_mnt_g_s1_vddr_m1_s2_vddr_m1_s3_vddr_m1_s4_vddr_m1_vddr_vddr4_t10 r0 *1 0,0
Rg_vddr_m1_mnt_g_s1_vddr_m1_s2_vddr_m1_s3_vddr_m1_s4_vddr_m1_vddr_vddr4_t10
+ g_vddr_m1\x7cmnt_g\x7cs1_vddr_m1\x7cs2_vddr_m1\x7cs3_vddr_m1\x7cs4_vddr_m1\x7cvddr\x7cvddr4__t10
+ g_vddr_m1|mnt_g|s1_vddr_m1|s2_vddr_m1|s3_vddr_m1|s4_vddr_m1|vddr|vddr4
+ 80.4457713349
* device instance g_vddr_m1_mnt_g_s1_vddr_m1_s2_vddr_m1_s3_vddr_m1_s4_vddr_m1_vddr_vddr4_t11 r0 *1 0,0
Rg_vddr_m1_mnt_g_s1_vddr_m1_s2_vddr_m1_s3_vddr_m1_s4_vddr_m1_vddr_vddr4_t11
+ g_vddr_m1\x7cmnt_g\x7cs1_vddr_m1\x7cs2_vddr_m1\x7cs3_vddr_m1\x7cs4_vddr_m1\x7cvddr\x7cvddr4__t11
+ g_vddr_m1|mnt_g|s1_vddr_m1|s2_vddr_m1|s3_vddr_m1|s4_vddr_m1|vddr|vddr4
+ 84.5952324257
* device instance g_vddr_m1_mnt_g_s1_vddr_m1_s2_vddr_m1_s3_vddr_m1_s4_vddr_m1_vddr_vddr4_t12 r0 *1 0,0
Rg_vddr_m1_mnt_g_s1_vddr_m1_s2_vddr_m1_s3_vddr_m1_s4_vddr_m1_vddr_vddr4_t12
+ g_vddr_m1\x7cmnt_g\x7cs1_vddr_m1\x7cs2_vddr_m1\x7cs3_vddr_m1\x7cs4_vddr_m1\x7cvddr\x7cvddr4__t12
+ g_vddr_m1|mnt_g|s1_vddr_m1|s2_vddr_m1|s3_vddr_m1|s4_vddr_m1|vddr|vddr4
+ 27.8035039982
* device instance g_vddr_m1_mnt_g_s1_vddr_m1_s2_vddr_m1_s3_vddr_m1_s4_vddr_m1_vddr_vddr4_t13 r0 *1 0,0
Rg_vddr_m1_mnt_g_s1_vddr_m1_s2_vddr_m1_s3_vddr_m1_s4_vddr_m1_vddr_vddr4_t13
+ g_vddr_m1\x7cmnt_g\x7cs1_vddr_m1\x7cs2_vddr_m1\x7cs3_vddr_m1\x7cs4_vddr_m1\x7cvddr\x7cvddr4__t13
+ g_vddr_m1|mnt_g|s1_vddr_m1|s2_vddr_m1|s3_vddr_m1|s4_vddr_m1|vddr|vddr4
+ 91.7253205032
* device instance g_vddr_m1_mnt_g_s1_vddr_m1_s2_vddr_m1_s3_vddr_m1_s4_vddr_m1_vddr_vddr4_t14 r0 *1 0,0
Rg_vddr_m1_mnt_g_s1_vddr_m1_s2_vddr_m1_s3_vddr_m1_s4_vddr_m1_vddr_vddr4_t14
+ g_vddr_m1\x7cmnt_g\x7cs1_vddr_m1\x7cs2_vddr_m1\x7cs3_vddr_m1\x7cs4_vddr_m1\x7cvddr\x7cvddr4__t14
+ g_vddr_m1|mnt_g|s1_vddr_m1|s2_vddr_m1|s3_vddr_m1|s4_vddr_m1|vddr|vddr4
+ 173.429674824
* device instance g_vddr_m1_mnt_g_s1_vddr_m1_s2_vddr_m1_s3_vddr_m1_s4_vddr_m1_vddr_vddr4_t15 r0 *1 0,0
Rg_vddr_m1_mnt_g_s1_vddr_m1_s2_vddr_m1_s3_vddr_m1_s4_vddr_m1_vddr_vddr4_t15
+ g_vddr_m1\x7cmnt_g\x7cs1_vddr_m1\x7cs2_vddr_m1\x7cs3_vddr_m1\x7cs4_vddr_m1\x7cvddr\x7cvddr4__t15
+ g_vddr_m1|mnt_g|s1_vddr_m1|s2_vddr_m1|s3_vddr_m1|s4_vddr_m1|vddr|vddr4
+ 140.119288117
* device instance g_vddr_m1_mnt_g_s1_vddr_m1_s2_vddr_m1_s3_vddr_m1_s4_vddr_m1_vddr_vddr4_t16 r0 *1 0,0
Rg_vddr_m1_mnt_g_s1_vddr_m1_s2_vddr_m1_s3_vddr_m1_s4_vddr_m1_vddr_vddr4_t16
+ g_vddr_m1\x7cmnt_g\x7cs1_vddr_m1\x7cs2_vddr_m1\x7cs3_vddr_m1\x7cs4_vddr_m1\x7cvddr\x7cvddr4__t16
+ g_vddr_m1|mnt_g|s1_vddr_m1|s2_vddr_m1|s3_vddr_m1|s4_vddr_m1|vddr|vddr4
+ 153.310041056
* device instance g_vddr_m1_mnt_g_s1_vddr_m1_s2_vddr_m1_s3_vddr_m1_s4_vddr_m1_vddr_vddr4_t17 r0 *1 0,0
Rg_vddr_m1_mnt_g_s1_vddr_m1_s2_vddr_m1_s3_vddr_m1_s4_vddr_m1_vddr_vddr4_t17
+ g_vddr_m1\x7cmnt_g\x7cs1_vddr_m1\x7cs2_vddr_m1\x7cs3_vddr_m1\x7cs4_vddr_m1\x7cvddr\x7cvddr4__t17
+ g_vddr_m1|mnt_g|s1_vddr_m1|s2_vddr_m1|s3_vddr_m1|s4_vddr_m1|vddr|vddr4
+ 58.4450706605
* device instance g_vddr_m1_mnt_g_s1_vddr_m1_s2_vddr_m1_s3_vddr_m1_s4_vddr_m1_vddr_vddr4_t18 r0 *1 0,0
Rg_vddr_m1_mnt_g_s1_vddr_m1_s2_vddr_m1_s3_vddr_m1_s4_vddr_m1_vddr_vddr4_t18
+ g_vddr_m1\x7cmnt_g\x7cs1_vddr_m1\x7cs2_vddr_m1\x7cs3_vddr_m1\x7cs4_vddr_m1\x7cvddr\x7cvddr4__t18
+ g_vddr_m1|mnt_g|s1_vddr_m1|s2_vddr_m1|s3_vddr_m1|s4_vddr_m1|vddr|vddr4
+ 193.595413678
* device instance g_vddr_m1_mnt_g_s1_vddr_m1_s2_vddr_m1_s3_vddr_m1_s4_vddr_m1_vddr_vddr4_t19 r0 *1 0,0
Rg_vddr_m1_mnt_g_s1_vddr_m1_s2_vddr_m1_s3_vddr_m1_s4_vddr_m1_vddr_vddr4_t19
+ g_vddr_m1\x7cmnt_g\x7cs1_vddr_m1\x7cs2_vddr_m1\x7cs3_vddr_m1\x7cs4_vddr_m1\x7cvddr\x7cvddr4__t19
+ g_vddr_m1|mnt_g|s1_vddr_m1|s2_vddr_m1|s3_vddr_m1|s4_vddr_m1|vddr|vddr4
+ 110.004152004
* device instance g_vddr_m1_mnt_g_s1_vddr_m1_s2_vddr_m1_s3_vddr_m1_s4_vddr_m1_vddr_vddr4_t20 r0 *1 0,0
Rg_vddr_m1_mnt_g_s1_vddr_m1_s2_vddr_m1_s3_vddr_m1_s4_vddr_m1_vddr_vddr4_t20
+ g_vddr_m1\x7cmnt_g\x7cs1_vddr_m1\x7cs2_vddr_m1\x7cs3_vddr_m1\x7cs4_vddr_m1\x7cvddr\x7cvddr4__t20
+ g_vddr_m1|mnt_g|s1_vddr_m1|s2_vddr_m1|s3_vddr_m1|s4_vddr_m1|vddr|vddr4
+ 27.3214351864
* device instance g_vddr_m1_mnt_g_s1_vddr_m1_s2_vddr_m1_s3_vddr_m1_s4_vddr_m1_vddr_vddr4 r0 *1 0,0
Cg_vddr_m1_mnt_g_s1_vddr_m1_s2_vddr_m1_s3_vddr_m1_s4_vddr_m1_vddr_vddr4
+ g_vddr_m1|mnt_g|s1_vddr_m1|s2_vddr_m1|s3_vddr_m1|s4_vddr_m1|vddr|vddr4 vsubs
+ 1.2379228e-14
* device instance g_vss_m1_inv_clk_vss_inv_mc_vss_inv_q_vss_mph_g_nand_m_vss_nand_s2_vss_s1_vss_m1_s2_vss_m1_s3_vss_m1_s4_vss_m1_sb_vss_sr1_vss_sr2_vss_sr3_vss_sr4_vss_sv_vss_tg_d_vss_tg_fbm_vss_tg_fbs_vss_tg_s_vss_vss_vss_link_vss_link_bridge_vss_link_dip_vss_link_m1_vss_x1_vss_x2_vss_x3_t0 r0 *1 0,0
Rg_vss_m1_inv_clk_vss_inv_mc_vss_inv_q_vss_mph_g_nand_m_vss_nand_s2_vss_s1_vss_m1_s2_vss_m1_s3_vss_m1_s4_vss_m1_sb_vss_sr1_vss_sr2_vss_sr3_vss_sr4_vss_sv_vss_tg_d_vss_tg_fbm_vss_tg_fbs_vss_tg_s_vss_vss_vss_link_vss_link_bridge_vss_link_dip_vss_link_m1_vss_x1_vss_x2_vss_x3_t0
+ g_vss_m1\x7cinv_clk_vss\x7cinv_mc_vss\x7cinv_q_vss\x7cmph_g\x7cnand_m_vss\x7cnand_s2_vss\x7cs1_vss_m1\x7cs2_vss_m1\x7cs3_vss_m1\x7cs4_vss_m1\x7csb_vss\x7csr1_vss\x7csr2_vss\x7csr3_vss\x7csr4_vss\x7csv_vss\x7ctg_d_vss\x7ctg_fbm_vss\x7ctg_fbs_vss\x7ctg_s_vss\x7cvss\x7cvss_link\x7cvss_link_bridge\x7cvss_link_dip\x7cvss_link_m1\x7cvss_x1\x7cvss_x2\x7cvss_x3__t0
+ g_vss_m1|inv_clk_vss|inv_mc_vss|inv_q_vss|mph_g|nand_m_vss|nand_s2_vss|s1_vss_m1|s2_vss_m1|s3_vss_m1|s4_vss_m1|sb_vss|sr1_vss|sr2_vss|sr3_vss|sr4_vss|sv_vss|tg_d_vss|tg_fbm_vss|tg_fbs_vss|tg_s_vss|vss|vss_link|vss_link_bridge|vss_link_dip|vss_link_m1|vss_x1|vss_x2|vss_x3
+ 188.091284607
* device instance g_vss_m1_inv_clk_vss_inv_mc_vss_inv_q_vss_mph_g_nand_m_vss_nand_s2_vss_s1_vss_m1_s2_vss_m1_s3_vss_m1_s4_vss_m1_sb_vss_sr1_vss_sr2_vss_sr3_vss_sr4_vss_sv_vss_tg_d_vss_tg_fbm_vss_tg_fbs_vss_tg_s_vss_vss_vss_link_vss_link_bridge_vss_link_dip_vss_link_m1_vss_x1_vss_x2_vss_x3_t1 r0 *1 0,0
Rg_vss_m1_inv_clk_vss_inv_mc_vss_inv_q_vss_mph_g_nand_m_vss_nand_s2_vss_s1_vss_m1_s2_vss_m1_s3_vss_m1_s4_vss_m1_sb_vss_sr1_vss_sr2_vss_sr3_vss_sr4_vss_sv_vss_tg_d_vss_tg_fbm_vss_tg_fbs_vss_tg_s_vss_vss_vss_link_vss_link_bridge_vss_link_dip_vss_link_m1_vss_x1_vss_x2_vss_x3_t1
+ g_vss_m1\x7cinv_clk_vss\x7cinv_mc_vss\x7cinv_q_vss\x7cmph_g\x7cnand_m_vss\x7cnand_s2_vss\x7cs1_vss_m1\x7cs2_vss_m1\x7cs3_vss_m1\x7cs4_vss_m1\x7csb_vss\x7csr1_vss\x7csr2_vss\x7csr3_vss\x7csr4_vss\x7csv_vss\x7ctg_d_vss\x7ctg_fbm_vss\x7ctg_fbs_vss\x7ctg_s_vss\x7cvss\x7cvss_link\x7cvss_link_bridge\x7cvss_link_dip\x7cvss_link_m1\x7cvss_x1\x7cvss_x2\x7cvss_x3__t1
+ g_vss_m1|inv_clk_vss|inv_mc_vss|inv_q_vss|mph_g|nand_m_vss|nand_s2_vss|s1_vss_m1|s2_vss_m1|s3_vss_m1|s4_vss_m1|sb_vss|sr1_vss|sr2_vss|sr3_vss|sr4_vss|sv_vss|tg_d_vss|tg_fbm_vss|tg_fbs_vss|tg_s_vss|vss|vss_link|vss_link_bridge|vss_link_dip|vss_link_m1|vss_x1|vss_x2|vss_x3
+ 207.805032601
* device instance g_vss_m1_inv_clk_vss_inv_mc_vss_inv_q_vss_mph_g_nand_m_vss_nand_s2_vss_s1_vss_m1_s2_vss_m1_s3_vss_m1_s4_vss_m1_sb_vss_sr1_vss_sr2_vss_sr3_vss_sr4_vss_sv_vss_tg_d_vss_tg_fbm_vss_tg_fbs_vss_tg_s_vss_vss_vss_link_vss_link_bridge_vss_link_dip_vss_link_m1_vss_x1_vss_x2_vss_x3_t2 r0 *1 0,0
Rg_vss_m1_inv_clk_vss_inv_mc_vss_inv_q_vss_mph_g_nand_m_vss_nand_s2_vss_s1_vss_m1_s2_vss_m1_s3_vss_m1_s4_vss_m1_sb_vss_sr1_vss_sr2_vss_sr3_vss_sr4_vss_sv_vss_tg_d_vss_tg_fbm_vss_tg_fbs_vss_tg_s_vss_vss_vss_link_vss_link_bridge_vss_link_dip_vss_link_m1_vss_x1_vss_x2_vss_x3_t2
+ g_vss_m1\x7cinv_clk_vss\x7cinv_mc_vss\x7cinv_q_vss\x7cmph_g\x7cnand_m_vss\x7cnand_s2_vss\x7cs1_vss_m1\x7cs2_vss_m1\x7cs3_vss_m1\x7cs4_vss_m1\x7csb_vss\x7csr1_vss\x7csr2_vss\x7csr3_vss\x7csr4_vss\x7csv_vss\x7ctg_d_vss\x7ctg_fbm_vss\x7ctg_fbs_vss\x7ctg_s_vss\x7cvss\x7cvss_link\x7cvss_link_bridge\x7cvss_link_dip\x7cvss_link_m1\x7cvss_x1\x7cvss_x2\x7cvss_x3__t2
+ g_vss_m1|inv_clk_vss|inv_mc_vss|inv_q_vss|mph_g|nand_m_vss|nand_s2_vss|s1_vss_m1|s2_vss_m1|s3_vss_m1|s4_vss_m1|sb_vss|sr1_vss|sr2_vss|sr3_vss|sr4_vss|sv_vss|tg_d_vss|tg_fbm_vss|tg_fbs_vss|tg_s_vss|vss|vss_link|vss_link_bridge|vss_link_dip|vss_link_m1|vss_x1|vss_x2|vss_x3
+ 201.338416883
* device instance g_vss_m1_inv_clk_vss_inv_mc_vss_inv_q_vss_mph_g_nand_m_vss_nand_s2_vss_s1_vss_m1_s2_vss_m1_s3_vss_m1_s4_vss_m1_sb_vss_sr1_vss_sr2_vss_sr3_vss_sr4_vss_sv_vss_tg_d_vss_tg_fbm_vss_tg_fbs_vss_tg_s_vss_vss_vss_link_vss_link_bridge_vss_link_dip_vss_link_m1_vss_x1_vss_x2_vss_x3_t3 r0 *1 0,0
Rg_vss_m1_inv_clk_vss_inv_mc_vss_inv_q_vss_mph_g_nand_m_vss_nand_s2_vss_s1_vss_m1_s2_vss_m1_s3_vss_m1_s4_vss_m1_sb_vss_sr1_vss_sr2_vss_sr3_vss_sr4_vss_sv_vss_tg_d_vss_tg_fbm_vss_tg_fbs_vss_tg_s_vss_vss_vss_link_vss_link_bridge_vss_link_dip_vss_link_m1_vss_x1_vss_x2_vss_x3_t3
+ g_vss_m1\x7cinv_clk_vss\x7cinv_mc_vss\x7cinv_q_vss\x7cmph_g\x7cnand_m_vss\x7cnand_s2_vss\x7cs1_vss_m1\x7cs2_vss_m1\x7cs3_vss_m1\x7cs4_vss_m1\x7csb_vss\x7csr1_vss\x7csr2_vss\x7csr3_vss\x7csr4_vss\x7csv_vss\x7ctg_d_vss\x7ctg_fbm_vss\x7ctg_fbs_vss\x7ctg_s_vss\x7cvss\x7cvss_link\x7cvss_link_bridge\x7cvss_link_dip\x7cvss_link_m1\x7cvss_x1\x7cvss_x2\x7cvss_x3__t3
+ g_vss_m1|inv_clk_vss|inv_mc_vss|inv_q_vss|mph_g|nand_m_vss|nand_s2_vss|s1_vss_m1|s2_vss_m1|s3_vss_m1|s4_vss_m1|sb_vss|sr1_vss|sr2_vss|sr3_vss|sr4_vss|sv_vss|tg_d_vss|tg_fbm_vss|tg_fbs_vss|tg_s_vss|vss|vss_link|vss_link_bridge|vss_link_dip|vss_link_m1|vss_x1|vss_x2|vss_x3
+ 108.237100896
* device instance g_vss_m1_inv_clk_vss_inv_mc_vss_inv_q_vss_mph_g_nand_m_vss_nand_s2_vss_s1_vss_m1_s2_vss_m1_s3_vss_m1_s4_vss_m1_sb_vss_sr1_vss_sr2_vss_sr3_vss_sr4_vss_sv_vss_tg_d_vss_tg_fbm_vss_tg_fbs_vss_tg_s_vss_vss_vss_link_vss_link_bridge_vss_link_dip_vss_link_m1_vss_x1_vss_x2_vss_x3_t4 r0 *1 0,0
Rg_vss_m1_inv_clk_vss_inv_mc_vss_inv_q_vss_mph_g_nand_m_vss_nand_s2_vss_s1_vss_m1_s2_vss_m1_s3_vss_m1_s4_vss_m1_sb_vss_sr1_vss_sr2_vss_sr3_vss_sr4_vss_sv_vss_tg_d_vss_tg_fbm_vss_tg_fbs_vss_tg_s_vss_vss_vss_link_vss_link_bridge_vss_link_dip_vss_link_m1_vss_x1_vss_x2_vss_x3_t4
+ g_vss_m1\x7cinv_clk_vss\x7cinv_mc_vss\x7cinv_q_vss\x7cmph_g\x7cnand_m_vss\x7cnand_s2_vss\x7cs1_vss_m1\x7cs2_vss_m1\x7cs3_vss_m1\x7cs4_vss_m1\x7csb_vss\x7csr1_vss\x7csr2_vss\x7csr3_vss\x7csr4_vss\x7csv_vss\x7ctg_d_vss\x7ctg_fbm_vss\x7ctg_fbs_vss\x7ctg_s_vss\x7cvss\x7cvss_link\x7cvss_link_bridge\x7cvss_link_dip\x7cvss_link_m1\x7cvss_x1\x7cvss_x2\x7cvss_x3__t4
+ g_vss_m1|inv_clk_vss|inv_mc_vss|inv_q_vss|mph_g|nand_m_vss|nand_s2_vss|s1_vss_m1|s2_vss_m1|s3_vss_m1|s4_vss_m1|sb_vss|sr1_vss|sr2_vss|sr3_vss|sr4_vss|sv_vss|tg_d_vss|tg_fbm_vss|tg_fbs_vss|tg_s_vss|vss|vss_link|vss_link_bridge|vss_link_dip|vss_link_m1|vss_x1|vss_x2|vss_x3
+ 19.2375769459
* device instance g_vss_m1_inv_clk_vss_inv_mc_vss_inv_q_vss_mph_g_nand_m_vss_nand_s2_vss_s1_vss_m1_s2_vss_m1_s3_vss_m1_s4_vss_m1_sb_vss_sr1_vss_sr2_vss_sr3_vss_sr4_vss_sv_vss_tg_d_vss_tg_fbm_vss_tg_fbs_vss_tg_s_vss_vss_vss_link_vss_link_bridge_vss_link_dip_vss_link_m1_vss_x1_vss_x2_vss_x3_t5 r0 *1 0,0
Rg_vss_m1_inv_clk_vss_inv_mc_vss_inv_q_vss_mph_g_nand_m_vss_nand_s2_vss_s1_vss_m1_s2_vss_m1_s3_vss_m1_s4_vss_m1_sb_vss_sr1_vss_sr2_vss_sr3_vss_sr4_vss_sv_vss_tg_d_vss_tg_fbm_vss_tg_fbs_vss_tg_s_vss_vss_vss_link_vss_link_bridge_vss_link_dip_vss_link_m1_vss_x1_vss_x2_vss_x3_t5
+ g_vss_m1\x7cinv_clk_vss\x7cinv_mc_vss\x7cinv_q_vss\x7cmph_g\x7cnand_m_vss\x7cnand_s2_vss\x7cs1_vss_m1\x7cs2_vss_m1\x7cs3_vss_m1\x7cs4_vss_m1\x7csb_vss\x7csr1_vss\x7csr2_vss\x7csr3_vss\x7csr4_vss\x7csv_vss\x7ctg_d_vss\x7ctg_fbm_vss\x7ctg_fbs_vss\x7ctg_s_vss\x7cvss\x7cvss_link\x7cvss_link_bridge\x7cvss_link_dip\x7cvss_link_m1\x7cvss_x1\x7cvss_x2\x7cvss_x3__t5
+ g_vss_m1|inv_clk_vss|inv_mc_vss|inv_q_vss|mph_g|nand_m_vss|nand_s2_vss|s1_vss_m1|s2_vss_m1|s3_vss_m1|s4_vss_m1|sb_vss|sr1_vss|sr2_vss|sr3_vss|sr4_vss|sv_vss|tg_d_vss|tg_fbm_vss|tg_fbs_vss|tg_s_vss|vss|vss_link|vss_link_bridge|vss_link_dip|vss_link_m1|vss_x1|vss_x2|vss_x3
+ 80.6325069824
* device instance g_vss_m1_inv_clk_vss_inv_mc_vss_inv_q_vss_mph_g_nand_m_vss_nand_s2_vss_s1_vss_m1_s2_vss_m1_s3_vss_m1_s4_vss_m1_sb_vss_sr1_vss_sr2_vss_sr3_vss_sr4_vss_sv_vss_tg_d_vss_tg_fbm_vss_tg_fbs_vss_tg_s_vss_vss_vss_link_vss_link_bridge_vss_link_dip_vss_link_m1_vss_x1_vss_x2_vss_x3_t6 r0 *1 0,0
Rg_vss_m1_inv_clk_vss_inv_mc_vss_inv_q_vss_mph_g_nand_m_vss_nand_s2_vss_s1_vss_m1_s2_vss_m1_s3_vss_m1_s4_vss_m1_sb_vss_sr1_vss_sr2_vss_sr3_vss_sr4_vss_sv_vss_tg_d_vss_tg_fbm_vss_tg_fbs_vss_tg_s_vss_vss_vss_link_vss_link_bridge_vss_link_dip_vss_link_m1_vss_x1_vss_x2_vss_x3_t6
+ g_vss_m1\x7cinv_clk_vss\x7cinv_mc_vss\x7cinv_q_vss\x7cmph_g\x7cnand_m_vss\x7cnand_s2_vss\x7cs1_vss_m1\x7cs2_vss_m1\x7cs3_vss_m1\x7cs4_vss_m1\x7csb_vss\x7csr1_vss\x7csr2_vss\x7csr3_vss\x7csr4_vss\x7csv_vss\x7ctg_d_vss\x7ctg_fbm_vss\x7ctg_fbs_vss\x7ctg_s_vss\x7cvss\x7cvss_link\x7cvss_link_bridge\x7cvss_link_dip\x7cvss_link_m1\x7cvss_x1\x7cvss_x2\x7cvss_x3__t6
+ g_vss_m1|inv_clk_vss|inv_mc_vss|inv_q_vss|mph_g|nand_m_vss|nand_s2_vss|s1_vss_m1|s2_vss_m1|s3_vss_m1|s4_vss_m1|sb_vss|sr1_vss|sr2_vss|sr3_vss|sr4_vss|sv_vss|tg_d_vss|tg_fbm_vss|tg_fbs_vss|tg_s_vss|vss|vss_link|vss_link_bridge|vss_link_dip|vss_link_m1|vss_x1|vss_x2|vss_x3
+ 201.819076547
* device instance g_vss_m1_inv_clk_vss_inv_mc_vss_inv_q_vss_mph_g_nand_m_vss_nand_s2_vss_s1_vss_m1_s2_vss_m1_s3_vss_m1_s4_vss_m1_sb_vss_sr1_vss_sr2_vss_sr3_vss_sr4_vss_sv_vss_tg_d_vss_tg_fbm_vss_tg_fbs_vss_tg_s_vss_vss_vss_link_vss_link_bridge_vss_link_dip_vss_link_m1_vss_x1_vss_x2_vss_x3_t7 r0 *1 0,0
Rg_vss_m1_inv_clk_vss_inv_mc_vss_inv_q_vss_mph_g_nand_m_vss_nand_s2_vss_s1_vss_m1_s2_vss_m1_s3_vss_m1_s4_vss_m1_sb_vss_sr1_vss_sr2_vss_sr3_vss_sr4_vss_sv_vss_tg_d_vss_tg_fbm_vss_tg_fbs_vss_tg_s_vss_vss_vss_link_vss_link_bridge_vss_link_dip_vss_link_m1_vss_x1_vss_x2_vss_x3_t7
+ g_vss_m1\x7cinv_clk_vss\x7cinv_mc_vss\x7cinv_q_vss\x7cmph_g\x7cnand_m_vss\x7cnand_s2_vss\x7cs1_vss_m1\x7cs2_vss_m1\x7cs3_vss_m1\x7cs4_vss_m1\x7csb_vss\x7csr1_vss\x7csr2_vss\x7csr3_vss\x7csr4_vss\x7csv_vss\x7ctg_d_vss\x7ctg_fbm_vss\x7ctg_fbs_vss\x7ctg_s_vss\x7cvss\x7cvss_link\x7cvss_link_bridge\x7cvss_link_dip\x7cvss_link_m1\x7cvss_x1\x7cvss_x2\x7cvss_x3__t7
+ g_vss_m1|inv_clk_vss|inv_mc_vss|inv_q_vss|mph_g|nand_m_vss|nand_s2_vss|s1_vss_m1|s2_vss_m1|s3_vss_m1|s4_vss_m1|sb_vss|sr1_vss|sr2_vss|sr3_vss|sr4_vss|sv_vss|tg_d_vss|tg_fbm_vss|tg_fbs_vss|tg_s_vss|vss|vss_link|vss_link_bridge|vss_link_dip|vss_link_m1|vss_x1|vss_x2|vss_x3
+ 109.128600997
* device instance g_vss_m1_inv_clk_vss_inv_mc_vss_inv_q_vss_mph_g_nand_m_vss_nand_s2_vss_s1_vss_m1_s2_vss_m1_s3_vss_m1_s4_vss_m1_sb_vss_sr1_vss_sr2_vss_sr3_vss_sr4_vss_sv_vss_tg_d_vss_tg_fbm_vss_tg_fbs_vss_tg_s_vss_vss_vss_link_vss_link_bridge_vss_link_dip_vss_link_m1_vss_x1_vss_x2_vss_x3_t8 r0 *1 0,0
Rg_vss_m1_inv_clk_vss_inv_mc_vss_inv_q_vss_mph_g_nand_m_vss_nand_s2_vss_s1_vss_m1_s2_vss_m1_s3_vss_m1_s4_vss_m1_sb_vss_sr1_vss_sr2_vss_sr3_vss_sr4_vss_sv_vss_tg_d_vss_tg_fbm_vss_tg_fbs_vss_tg_s_vss_vss_vss_link_vss_link_bridge_vss_link_dip_vss_link_m1_vss_x1_vss_x2_vss_x3_t8
+ g_vss_m1\x7cinv_clk_vss\x7cinv_mc_vss\x7cinv_q_vss\x7cmph_g\x7cnand_m_vss\x7cnand_s2_vss\x7cs1_vss_m1\x7cs2_vss_m1\x7cs3_vss_m1\x7cs4_vss_m1\x7csb_vss\x7csr1_vss\x7csr2_vss\x7csr3_vss\x7csr4_vss\x7csv_vss\x7ctg_d_vss\x7ctg_fbm_vss\x7ctg_fbs_vss\x7ctg_s_vss\x7cvss\x7cvss_link\x7cvss_link_bridge\x7cvss_link_dip\x7cvss_link_m1\x7cvss_x1\x7cvss_x2\x7cvss_x3__t8
+ g_vss_m1|inv_clk_vss|inv_mc_vss|inv_q_vss|mph_g|nand_m_vss|nand_s2_vss|s1_vss_m1|s2_vss_m1|s3_vss_m1|s4_vss_m1|sb_vss|sr1_vss|sr2_vss|sr3_vss|sr4_vss|sv_vss|tg_d_vss|tg_fbm_vss|tg_fbs_vss|tg_s_vss|vss|vss_link|vss_link_bridge|vss_link_dip|vss_link_m1|vss_x1|vss_x2|vss_x3
+ 23.7458609457
* device instance g_vss_m1_inv_clk_vss_inv_mc_vss_inv_q_vss_mph_g_nand_m_vss_nand_s2_vss_s1_vss_m1_s2_vss_m1_s3_vss_m1_s4_vss_m1_sb_vss_sr1_vss_sr2_vss_sr3_vss_sr4_vss_sv_vss_tg_d_vss_tg_fbm_vss_tg_fbs_vss_tg_s_vss_vss_vss_link_vss_link_bridge_vss_link_dip_vss_link_m1_vss_x1_vss_x2_vss_x3_t9 r0 *1 0,0
Rg_vss_m1_inv_clk_vss_inv_mc_vss_inv_q_vss_mph_g_nand_m_vss_nand_s2_vss_s1_vss_m1_s2_vss_m1_s3_vss_m1_s4_vss_m1_sb_vss_sr1_vss_sr2_vss_sr3_vss_sr4_vss_sv_vss_tg_d_vss_tg_fbm_vss_tg_fbs_vss_tg_s_vss_vss_vss_link_vss_link_bridge_vss_link_dip_vss_link_m1_vss_x1_vss_x2_vss_x3_t9
+ g_vss_m1\x7cinv_clk_vss\x7cinv_mc_vss\x7cinv_q_vss\x7cmph_g\x7cnand_m_vss\x7cnand_s2_vss\x7cs1_vss_m1\x7cs2_vss_m1\x7cs3_vss_m1\x7cs4_vss_m1\x7csb_vss\x7csr1_vss\x7csr2_vss\x7csr3_vss\x7csr4_vss\x7csv_vss\x7ctg_d_vss\x7ctg_fbm_vss\x7ctg_fbs_vss\x7ctg_s_vss\x7cvss\x7cvss_link\x7cvss_link_bridge\x7cvss_link_dip\x7cvss_link_m1\x7cvss_x1\x7cvss_x2\x7cvss_x3__t9
+ g_vss_m1|inv_clk_vss|inv_mc_vss|inv_q_vss|mph_g|nand_m_vss|nand_s2_vss|s1_vss_m1|s2_vss_m1|s3_vss_m1|s4_vss_m1|sb_vss|sr1_vss|sr2_vss|sr3_vss|sr4_vss|sv_vss|tg_d_vss|tg_fbm_vss|tg_fbs_vss|tg_s_vss|vss|vss_link|vss_link_bridge|vss_link_dip|vss_link_m1|vss_x1|vss_x2|vss_x3
+ 81.8253183774
* device instance g_vss_m1_inv_clk_vss_inv_mc_vss_inv_q_vss_mph_g_nand_m_vss_nand_s2_vss_s1_vss_m1_s2_vss_m1_s3_vss_m1_s4_vss_m1_sb_vss_sr1_vss_sr2_vss_sr3_vss_sr4_vss_sv_vss_tg_d_vss_tg_fbm_vss_tg_fbs_vss_tg_s_vss_vss_vss_link_vss_link_bridge_vss_link_dip_vss_link_m1_vss_x1_vss_x2_vss_x3_t10 r0 *1 0,0
Rg_vss_m1_inv_clk_vss_inv_mc_vss_inv_q_vss_mph_g_nand_m_vss_nand_s2_vss_s1_vss_m1_s2_vss_m1_s3_vss_m1_s4_vss_m1_sb_vss_sr1_vss_sr2_vss_sr3_vss_sr4_vss_sv_vss_tg_d_vss_tg_fbm_vss_tg_fbs_vss_tg_s_vss_vss_vss_link_vss_link_bridge_vss_link_dip_vss_link_m1_vss_x1_vss_x2_vss_x3_t10
+ g_vss_m1\x7cinv_clk_vss\x7cinv_mc_vss\x7cinv_q_vss\x7cmph_g\x7cnand_m_vss\x7cnand_s2_vss\x7cs1_vss_m1\x7cs2_vss_m1\x7cs3_vss_m1\x7cs4_vss_m1\x7csb_vss\x7csr1_vss\x7csr2_vss\x7csr3_vss\x7csr4_vss\x7csv_vss\x7ctg_d_vss\x7ctg_fbm_vss\x7ctg_fbs_vss\x7ctg_s_vss\x7cvss\x7cvss_link\x7cvss_link_bridge\x7cvss_link_dip\x7cvss_link_m1\x7cvss_x1\x7cvss_x2\x7cvss_x3__t10
+ g_vss_m1|inv_clk_vss|inv_mc_vss|inv_q_vss|mph_g|nand_m_vss|nand_s2_vss|s1_vss_m1|s2_vss_m1|s3_vss_m1|s4_vss_m1|sb_vss|sr1_vss|sr2_vss|sr3_vss|sr4_vss|sv_vss|tg_d_vss|tg_fbm_vss|tg_fbs_vss|tg_s_vss|vss|vss_link|vss_link_bridge|vss_link_dip|vss_link_m1|vss_x1|vss_x2|vss_x3
+ 110.756090499
* device instance g_vss_m1_inv_clk_vss_inv_mc_vss_inv_q_vss_mph_g_nand_m_vss_nand_s2_vss_s1_vss_m1_s2_vss_m1_s3_vss_m1_s4_vss_m1_sb_vss_sr1_vss_sr2_vss_sr3_vss_sr4_vss_sv_vss_tg_d_vss_tg_fbm_vss_tg_fbs_vss_tg_s_vss_vss_vss_link_vss_link_bridge_vss_link_dip_vss_link_m1_vss_x1_vss_x2_vss_x3_t11 r0 *1 0,0
Rg_vss_m1_inv_clk_vss_inv_mc_vss_inv_q_vss_mph_g_nand_m_vss_nand_s2_vss_s1_vss_m1_s2_vss_m1_s3_vss_m1_s4_vss_m1_sb_vss_sr1_vss_sr2_vss_sr3_vss_sr4_vss_sv_vss_tg_d_vss_tg_fbm_vss_tg_fbs_vss_tg_s_vss_vss_vss_link_vss_link_bridge_vss_link_dip_vss_link_m1_vss_x1_vss_x2_vss_x3_t11
+ g_vss_m1\x7cinv_clk_vss\x7cinv_mc_vss\x7cinv_q_vss\x7cmph_g\x7cnand_m_vss\x7cnand_s2_vss\x7cs1_vss_m1\x7cs2_vss_m1\x7cs3_vss_m1\x7cs4_vss_m1\x7csb_vss\x7csr1_vss\x7csr2_vss\x7csr3_vss\x7csr4_vss\x7csv_vss\x7ctg_d_vss\x7ctg_fbm_vss\x7ctg_fbs_vss\x7ctg_s_vss\x7cvss\x7cvss_link\x7cvss_link_bridge\x7cvss_link_dip\x7cvss_link_m1\x7cvss_x1\x7cvss_x2\x7cvss_x3__t11
+ g_vss_m1|inv_clk_vss|inv_mc_vss|inv_q_vss|mph_g|nand_m_vss|nand_s2_vss|s1_vss_m1|s2_vss_m1|s3_vss_m1|s4_vss_m1|sb_vss|sr1_vss|sr2_vss|sr3_vss|sr4_vss|sv_vss|tg_d_vss|tg_fbm_vss|tg_fbs_vss|tg_s_vss|vss|vss_link|vss_link_bridge|vss_link_dip|vss_link_m1|vss_x1|vss_x2|vss_x3
+ 124.388548071
* device instance g_vss_m1_inv_clk_vss_inv_mc_vss_inv_q_vss_mph_g_nand_m_vss_nand_s2_vss_s1_vss_m1_s2_vss_m1_s3_vss_m1_s4_vss_m1_sb_vss_sr1_vss_sr2_vss_sr3_vss_sr4_vss_sv_vss_tg_d_vss_tg_fbm_vss_tg_fbs_vss_tg_s_vss_vss_vss_link_vss_link_bridge_vss_link_dip_vss_link_m1_vss_x1_vss_x2_vss_x3_t12 r0 *1 0,0
Rg_vss_m1_inv_clk_vss_inv_mc_vss_inv_q_vss_mph_g_nand_m_vss_nand_s2_vss_s1_vss_m1_s2_vss_m1_s3_vss_m1_s4_vss_m1_sb_vss_sr1_vss_sr2_vss_sr3_vss_sr4_vss_sv_vss_tg_d_vss_tg_fbm_vss_tg_fbs_vss_tg_s_vss_vss_vss_link_vss_link_bridge_vss_link_dip_vss_link_m1_vss_x1_vss_x2_vss_x3_t12
+ g_vss_m1\x7cinv_clk_vss\x7cinv_mc_vss\x7cinv_q_vss\x7cmph_g\x7cnand_m_vss\x7cnand_s2_vss\x7cs1_vss_m1\x7cs2_vss_m1\x7cs3_vss_m1\x7cs4_vss_m1\x7csb_vss\x7csr1_vss\x7csr2_vss\x7csr3_vss\x7csr4_vss\x7csv_vss\x7ctg_d_vss\x7ctg_fbm_vss\x7ctg_fbs_vss\x7ctg_s_vss\x7cvss\x7cvss_link\x7cvss_link_bridge\x7cvss_link_dip\x7cvss_link_m1\x7cvss_x1\x7cvss_x2\x7cvss_x3__t12
+ g_vss_m1|inv_clk_vss|inv_mc_vss|inv_q_vss|mph_g|nand_m_vss|nand_s2_vss|s1_vss_m1|s2_vss_m1|s3_vss_m1|s4_vss_m1|sb_vss|sr1_vss|sr2_vss|sr3_vss|sr4_vss|sv_vss|tg_d_vss|tg_fbm_vss|tg_fbs_vss|tg_s_vss|vss|vss_link|vss_link_bridge|vss_link_dip|vss_link_m1|vss_x1|vss_x2|vss_x3
+ 138.058107554
* device instance g_vss_m1_inv_clk_vss_inv_mc_vss_inv_q_vss_mph_g_nand_m_vss_nand_s2_vss_s1_vss_m1_s2_vss_m1_s3_vss_m1_s4_vss_m1_sb_vss_sr1_vss_sr2_vss_sr3_vss_sr4_vss_sv_vss_tg_d_vss_tg_fbm_vss_tg_fbs_vss_tg_s_vss_vss_vss_link_vss_link_bridge_vss_link_dip_vss_link_m1_vss_x1_vss_x2_vss_x3_t13 r0 *1 0,0
Rg_vss_m1_inv_clk_vss_inv_mc_vss_inv_q_vss_mph_g_nand_m_vss_nand_s2_vss_s1_vss_m1_s2_vss_m1_s3_vss_m1_s4_vss_m1_sb_vss_sr1_vss_sr2_vss_sr3_vss_sr4_vss_sv_vss_tg_d_vss_tg_fbm_vss_tg_fbs_vss_tg_s_vss_vss_vss_link_vss_link_bridge_vss_link_dip_vss_link_m1_vss_x1_vss_x2_vss_x3_t13
+ g_vss_m1\x7cinv_clk_vss\x7cinv_mc_vss\x7cinv_q_vss\x7cmph_g\x7cnand_m_vss\x7cnand_s2_vss\x7cs1_vss_m1\x7cs2_vss_m1\x7cs3_vss_m1\x7cs4_vss_m1\x7csb_vss\x7csr1_vss\x7csr2_vss\x7csr3_vss\x7csr4_vss\x7csv_vss\x7ctg_d_vss\x7ctg_fbm_vss\x7ctg_fbs_vss\x7ctg_s_vss\x7cvss\x7cvss_link\x7cvss_link_bridge\x7cvss_link_dip\x7cvss_link_m1\x7cvss_x1\x7cvss_x2\x7cvss_x3__t13
+ g_vss_m1|inv_clk_vss|inv_mc_vss|inv_q_vss|mph_g|nand_m_vss|nand_s2_vss|s1_vss_m1|s2_vss_m1|s3_vss_m1|s4_vss_m1|sb_vss|sr1_vss|sr2_vss|sr3_vss|sr4_vss|sv_vss|tg_d_vss|tg_fbm_vss|tg_fbs_vss|tg_s_vss|vss|vss_link|vss_link_bridge|vss_link_dip|vss_link_m1|vss_x1|vss_x2|vss_x3
+ 97.1763507004
* device instance g_vss_m1_inv_clk_vss_inv_mc_vss_inv_q_vss_mph_g_nand_m_vss_nand_s2_vss_s1_vss_m1_s2_vss_m1_s3_vss_m1_s4_vss_m1_sb_vss_sr1_vss_sr2_vss_sr3_vss_sr4_vss_sv_vss_tg_d_vss_tg_fbm_vss_tg_fbs_vss_tg_s_vss_vss_vss_link_vss_link_bridge_vss_link_dip_vss_link_m1_vss_x1_vss_x2_vss_x3_t14 r0 *1 0,0
Rg_vss_m1_inv_clk_vss_inv_mc_vss_inv_q_vss_mph_g_nand_m_vss_nand_s2_vss_s1_vss_m1_s2_vss_m1_s3_vss_m1_s4_vss_m1_sb_vss_sr1_vss_sr2_vss_sr3_vss_sr4_vss_sv_vss_tg_d_vss_tg_fbm_vss_tg_fbs_vss_tg_s_vss_vss_vss_link_vss_link_bridge_vss_link_dip_vss_link_m1_vss_x1_vss_x2_vss_x3_t14
+ g_vss_m1\x7cinv_clk_vss\x7cinv_mc_vss\x7cinv_q_vss\x7cmph_g\x7cnand_m_vss\x7cnand_s2_vss\x7cs1_vss_m1\x7cs2_vss_m1\x7cs3_vss_m1\x7cs4_vss_m1\x7csb_vss\x7csr1_vss\x7csr2_vss\x7csr3_vss\x7csr4_vss\x7csv_vss\x7ctg_d_vss\x7ctg_fbm_vss\x7ctg_fbs_vss\x7ctg_s_vss\x7cvss\x7cvss_link\x7cvss_link_bridge\x7cvss_link_dip\x7cvss_link_m1\x7cvss_x1\x7cvss_x2\x7cvss_x3__t14
+ g_vss_m1|inv_clk_vss|inv_mc_vss|inv_q_vss|mph_g|nand_m_vss|nand_s2_vss|s1_vss_m1|s2_vss_m1|s3_vss_m1|s4_vss_m1|sb_vss|sr1_vss|sr2_vss|sr3_vss|sr4_vss|sv_vss|tg_d_vss|tg_fbm_vss|tg_fbs_vss|tg_s_vss|vss|vss_link|vss_link_bridge|vss_link_dip|vss_link_m1|vss_x1|vss_x2|vss_x3
+ 47.3144859508
* device instance g_vss_m1_inv_clk_vss_inv_mc_vss_inv_q_vss_mph_g_nand_m_vss_nand_s2_vss_s1_vss_m1_s2_vss_m1_s3_vss_m1_s4_vss_m1_sb_vss_sr1_vss_sr2_vss_sr3_vss_sr4_vss_sv_vss_tg_d_vss_tg_fbm_vss_tg_fbs_vss_tg_s_vss_vss_vss_link_vss_link_bridge_vss_link_dip_vss_link_m1_vss_x1_vss_x2_vss_x3_t15 r0 *1 0,0
Rg_vss_m1_inv_clk_vss_inv_mc_vss_inv_q_vss_mph_g_nand_m_vss_nand_s2_vss_s1_vss_m1_s2_vss_m1_s3_vss_m1_s4_vss_m1_sb_vss_sr1_vss_sr2_vss_sr3_vss_sr4_vss_sv_vss_tg_d_vss_tg_fbm_vss_tg_fbs_vss_tg_s_vss_vss_vss_link_vss_link_bridge_vss_link_dip_vss_link_m1_vss_x1_vss_x2_vss_x3_t15
+ g_vss_m1\x7cinv_clk_vss\x7cinv_mc_vss\x7cinv_q_vss\x7cmph_g\x7cnand_m_vss\x7cnand_s2_vss\x7cs1_vss_m1\x7cs2_vss_m1\x7cs3_vss_m1\x7cs4_vss_m1\x7csb_vss\x7csr1_vss\x7csr2_vss\x7csr3_vss\x7csr4_vss\x7csv_vss\x7ctg_d_vss\x7ctg_fbm_vss\x7ctg_fbs_vss\x7ctg_s_vss\x7cvss\x7cvss_link\x7cvss_link_bridge\x7cvss_link_dip\x7cvss_link_m1\x7cvss_x1\x7cvss_x2\x7cvss_x3__t15
+ g_vss_m1|inv_clk_vss|inv_mc_vss|inv_q_vss|mph_g|nand_m_vss|nand_s2_vss|s1_vss_m1|s2_vss_m1|s3_vss_m1|s4_vss_m1|sb_vss|sr1_vss|sr2_vss|sr3_vss|sr4_vss|sv_vss|tg_d_vss|tg_fbm_vss|tg_fbs_vss|tg_s_vss|vss|vss_link|vss_link_bridge|vss_link_dip|vss_link_m1|vss_x1|vss_x2|vss_x3
+ 35.1384639846
* device instance g_vss_m1_inv_clk_vss_inv_mc_vss_inv_q_vss_mph_g_nand_m_vss_nand_s2_vss_s1_vss_m1_s2_vss_m1_s3_vss_m1_s4_vss_m1_sb_vss_sr1_vss_sr2_vss_sr3_vss_sr4_vss_sv_vss_tg_d_vss_tg_fbm_vss_tg_fbs_vss_tg_s_vss_vss_vss_link_vss_link_bridge_vss_link_dip_vss_link_m1_vss_x1_vss_x2_vss_x3_t16 r0 *1 0,0
Rg_vss_m1_inv_clk_vss_inv_mc_vss_inv_q_vss_mph_g_nand_m_vss_nand_s2_vss_s1_vss_m1_s2_vss_m1_s3_vss_m1_s4_vss_m1_sb_vss_sr1_vss_sr2_vss_sr3_vss_sr4_vss_sv_vss_tg_d_vss_tg_fbm_vss_tg_fbs_vss_tg_s_vss_vss_vss_link_vss_link_bridge_vss_link_dip_vss_link_m1_vss_x1_vss_x2_vss_x3_t16
+ g_vss_m1\x7cinv_clk_vss\x7cinv_mc_vss\x7cinv_q_vss\x7cmph_g\x7cnand_m_vss\x7cnand_s2_vss\x7cs1_vss_m1\x7cs2_vss_m1\x7cs3_vss_m1\x7cs4_vss_m1\x7csb_vss\x7csr1_vss\x7csr2_vss\x7csr3_vss\x7csr4_vss\x7csv_vss\x7ctg_d_vss\x7ctg_fbm_vss\x7ctg_fbs_vss\x7ctg_s_vss\x7cvss\x7cvss_link\x7cvss_link_bridge\x7cvss_link_dip\x7cvss_link_m1\x7cvss_x1\x7cvss_x2\x7cvss_x3__t16
+ g_vss_m1|inv_clk_vss|inv_mc_vss|inv_q_vss|mph_g|nand_m_vss|nand_s2_vss|s1_vss_m1|s2_vss_m1|s3_vss_m1|s4_vss_m1|sb_vss|sr1_vss|sr2_vss|sr3_vss|sr4_vss|sv_vss|tg_d_vss|tg_fbm_vss|tg_fbs_vss|tg_s_vss|vss|vss_link|vss_link_bridge|vss_link_dip|vss_link_m1|vss_x1|vss_x2|vss_x3
+ 24.752648002
* device instance g_vss_m1_inv_clk_vss_inv_mc_vss_inv_q_vss_mph_g_nand_m_vss_nand_s2_vss_s1_vss_m1_s2_vss_m1_s3_vss_m1_s4_vss_m1_sb_vss_sr1_vss_sr2_vss_sr3_vss_sr4_vss_sv_vss_tg_d_vss_tg_fbm_vss_tg_fbs_vss_tg_s_vss_vss_vss_link_vss_link_bridge_vss_link_dip_vss_link_m1_vss_x1_vss_x2_vss_x3_t17 r0 *1 0,0
Rg_vss_m1_inv_clk_vss_inv_mc_vss_inv_q_vss_mph_g_nand_m_vss_nand_s2_vss_s1_vss_m1_s2_vss_m1_s3_vss_m1_s4_vss_m1_sb_vss_sr1_vss_sr2_vss_sr3_vss_sr4_vss_sv_vss_tg_d_vss_tg_fbm_vss_tg_fbs_vss_tg_s_vss_vss_vss_link_vss_link_bridge_vss_link_dip_vss_link_m1_vss_x1_vss_x2_vss_x3_t17
+ g_vss_m1\x7cinv_clk_vss\x7cinv_mc_vss\x7cinv_q_vss\x7cmph_g\x7cnand_m_vss\x7cnand_s2_vss\x7cs1_vss_m1\x7cs2_vss_m1\x7cs3_vss_m1\x7cs4_vss_m1\x7csb_vss\x7csr1_vss\x7csr2_vss\x7csr3_vss\x7csr4_vss\x7csv_vss\x7ctg_d_vss\x7ctg_fbm_vss\x7ctg_fbs_vss\x7ctg_s_vss\x7cvss\x7cvss_link\x7cvss_link_bridge\x7cvss_link_dip\x7cvss_link_m1\x7cvss_x1\x7cvss_x2\x7cvss_x3__t17
+ g_vss_m1|inv_clk_vss|inv_mc_vss|inv_q_vss|mph_g|nand_m_vss|nand_s2_vss|s1_vss_m1|s2_vss_m1|s3_vss_m1|s4_vss_m1|sb_vss|sr1_vss|sr2_vss|sr3_vss|sr4_vss|sv_vss|tg_d_vss|tg_fbm_vss|tg_fbs_vss|tg_s_vss|vss|vss_link|vss_link_bridge|vss_link_dip|vss_link_m1|vss_x1|vss_x2|vss_x3
+ 19.3030147009
* device instance g_vss_m1_inv_clk_vss_inv_mc_vss_inv_q_vss_mph_g_nand_m_vss_nand_s2_vss_s1_vss_m1_s2_vss_m1_s3_vss_m1_s4_vss_m1_sb_vss_sr1_vss_sr2_vss_sr3_vss_sr4_vss_sv_vss_tg_d_vss_tg_fbm_vss_tg_fbs_vss_tg_s_vss_vss_vss_link_vss_link_bridge_vss_link_dip_vss_link_m1_vss_x1_vss_x2_vss_x3_t18 r0 *1 0,0
Rg_vss_m1_inv_clk_vss_inv_mc_vss_inv_q_vss_mph_g_nand_m_vss_nand_s2_vss_s1_vss_m1_s2_vss_m1_s3_vss_m1_s4_vss_m1_sb_vss_sr1_vss_sr2_vss_sr3_vss_sr4_vss_sv_vss_tg_d_vss_tg_fbm_vss_tg_fbs_vss_tg_s_vss_vss_vss_link_vss_link_bridge_vss_link_dip_vss_link_m1_vss_x1_vss_x2_vss_x3_t18
+ g_vss_m1\x7cinv_clk_vss\x7cinv_mc_vss\x7cinv_q_vss\x7cmph_g\x7cnand_m_vss\x7cnand_s2_vss\x7cs1_vss_m1\x7cs2_vss_m1\x7cs3_vss_m1\x7cs4_vss_m1\x7csb_vss\x7csr1_vss\x7csr2_vss\x7csr3_vss\x7csr4_vss\x7csv_vss\x7ctg_d_vss\x7ctg_fbm_vss\x7ctg_fbs_vss\x7ctg_s_vss\x7cvss\x7cvss_link\x7cvss_link_bridge\x7cvss_link_dip\x7cvss_link_m1\x7cvss_x1\x7cvss_x2\x7cvss_x3__t18
+ g_vss_m1|inv_clk_vss|inv_mc_vss|inv_q_vss|mph_g|nand_m_vss|nand_s2_vss|s1_vss_m1|s2_vss_m1|s3_vss_m1|s4_vss_m1|sb_vss|sr1_vss|sr2_vss|sr3_vss|sr4_vss|sv_vss|tg_d_vss|tg_fbm_vss|tg_fbs_vss|tg_s_vss|vss|vss_link|vss_link_bridge|vss_link_dip|vss_link_m1|vss_x1|vss_x2|vss_x3
+ 66.8850870542
* device instance g_vss_m1_inv_clk_vss_inv_mc_vss_inv_q_vss_mph_g_nand_m_vss_nand_s2_vss_s1_vss_m1_s2_vss_m1_s3_vss_m1_s4_vss_m1_sb_vss_sr1_vss_sr2_vss_sr3_vss_sr4_vss_sv_vss_tg_d_vss_tg_fbm_vss_tg_fbs_vss_tg_s_vss_vss_vss_link_vss_link_bridge_vss_link_dip_vss_link_m1_vss_x1_vss_x2_vss_x3_t19 r0 *1 0,0
Rg_vss_m1_inv_clk_vss_inv_mc_vss_inv_q_vss_mph_g_nand_m_vss_nand_s2_vss_s1_vss_m1_s2_vss_m1_s3_vss_m1_s4_vss_m1_sb_vss_sr1_vss_sr2_vss_sr3_vss_sr4_vss_sv_vss_tg_d_vss_tg_fbm_vss_tg_fbs_vss_tg_s_vss_vss_vss_link_vss_link_bridge_vss_link_dip_vss_link_m1_vss_x1_vss_x2_vss_x3_t19
+ g_vss_m1\x7cinv_clk_vss\x7cinv_mc_vss\x7cinv_q_vss\x7cmph_g\x7cnand_m_vss\x7cnand_s2_vss\x7cs1_vss_m1\x7cs2_vss_m1\x7cs3_vss_m1\x7cs4_vss_m1\x7csb_vss\x7csr1_vss\x7csr2_vss\x7csr3_vss\x7csr4_vss\x7csv_vss\x7ctg_d_vss\x7ctg_fbm_vss\x7ctg_fbs_vss\x7ctg_s_vss\x7cvss\x7cvss_link\x7cvss_link_bridge\x7cvss_link_dip\x7cvss_link_m1\x7cvss_x1\x7cvss_x2\x7cvss_x3__t19
+ g_vss_m1|inv_clk_vss|inv_mc_vss|inv_q_vss|mph_g|nand_m_vss|nand_s2_vss|s1_vss_m1|s2_vss_m1|s3_vss_m1|s4_vss_m1|sb_vss|sr1_vss|sr2_vss|sr3_vss|sr4_vss|sv_vss|tg_d_vss|tg_fbm_vss|tg_fbs_vss|tg_s_vss|vss|vss_link|vss_link_bridge|vss_link_dip|vss_link_m1|vss_x1|vss_x2|vss_x3
+ 53.7957485243
* device instance g_vss_m1_inv_clk_vss_inv_mc_vss_inv_q_vss_mph_g_nand_m_vss_nand_s2_vss_s1_vss_m1_s2_vss_m1_s3_vss_m1_s4_vss_m1_sb_vss_sr1_vss_sr2_vss_sr3_vss_sr4_vss_sv_vss_tg_d_vss_tg_fbm_vss_tg_fbs_vss_tg_s_vss_vss_vss_link_vss_link_bridge_vss_link_dip_vss_link_m1_vss_x1_vss_x2_vss_x3_t20 r0 *1 0,0
Rg_vss_m1_inv_clk_vss_inv_mc_vss_inv_q_vss_mph_g_nand_m_vss_nand_s2_vss_s1_vss_m1_s2_vss_m1_s3_vss_m1_s4_vss_m1_sb_vss_sr1_vss_sr2_vss_sr3_vss_sr4_vss_sv_vss_tg_d_vss_tg_fbm_vss_tg_fbs_vss_tg_s_vss_vss_vss_link_vss_link_bridge_vss_link_dip_vss_link_m1_vss_x1_vss_x2_vss_x3_t20
+ g_vss_m1\x7cinv_clk_vss\x7cinv_mc_vss\x7cinv_q_vss\x7cmph_g\x7cnand_m_vss\x7cnand_s2_vss\x7cs1_vss_m1\x7cs2_vss_m1\x7cs3_vss_m1\x7cs4_vss_m1\x7csb_vss\x7csr1_vss\x7csr2_vss\x7csr3_vss\x7csr4_vss\x7csv_vss\x7ctg_d_vss\x7ctg_fbm_vss\x7ctg_fbs_vss\x7ctg_s_vss\x7cvss\x7cvss_link\x7cvss_link_bridge\x7cvss_link_dip\x7cvss_link_m1\x7cvss_x1\x7cvss_x2\x7cvss_x3__t20
+ g_vss_m1|inv_clk_vss|inv_mc_vss|inv_q_vss|mph_g|nand_m_vss|nand_s2_vss|s1_vss_m1|s2_vss_m1|s3_vss_m1|s4_vss_m1|sb_vss|sr1_vss|sr2_vss|sr3_vss|sr4_vss|sv_vss|tg_d_vss|tg_fbm_vss|tg_fbs_vss|tg_s_vss|vss|vss_link|vss_link_bridge|vss_link_dip|vss_link_m1|vss_x1|vss_x2|vss_x3
+ 93.6945680214
* device instance g_vss_m1_inv_clk_vss_inv_mc_vss_inv_q_vss_mph_g_nand_m_vss_nand_s2_vss_s1_vss_m1_s2_vss_m1_s3_vss_m1_s4_vss_m1_sb_vss_sr1_vss_sr2_vss_sr3_vss_sr4_vss_sv_vss_tg_d_vss_tg_fbm_vss_tg_fbs_vss_tg_s_vss_vss_vss_link_vss_link_bridge_vss_link_dip_vss_link_m1_vss_x1_vss_x2_vss_x3_t21 r0 *1 0,0
Rg_vss_m1_inv_clk_vss_inv_mc_vss_inv_q_vss_mph_g_nand_m_vss_nand_s2_vss_s1_vss_m1_s2_vss_m1_s3_vss_m1_s4_vss_m1_sb_vss_sr1_vss_sr2_vss_sr3_vss_sr4_vss_sv_vss_tg_d_vss_tg_fbm_vss_tg_fbs_vss_tg_s_vss_vss_vss_link_vss_link_bridge_vss_link_dip_vss_link_m1_vss_x1_vss_x2_vss_x3_t21
+ g_vss_m1\x7cinv_clk_vss\x7cinv_mc_vss\x7cinv_q_vss\x7cmph_g\x7cnand_m_vss\x7cnand_s2_vss\x7cs1_vss_m1\x7cs2_vss_m1\x7cs3_vss_m1\x7cs4_vss_m1\x7csb_vss\x7csr1_vss\x7csr2_vss\x7csr3_vss\x7csr4_vss\x7csv_vss\x7ctg_d_vss\x7ctg_fbm_vss\x7ctg_fbs_vss\x7ctg_s_vss\x7cvss\x7cvss_link\x7cvss_link_bridge\x7cvss_link_dip\x7cvss_link_m1\x7cvss_x1\x7cvss_x2\x7cvss_x3__t21
+ g_vss_m1|inv_clk_vss|inv_mc_vss|inv_q_vss|mph_g|nand_m_vss|nand_s2_vss|s1_vss_m1|s2_vss_m1|s3_vss_m1|s4_vss_m1|sb_vss|sr1_vss|sr2_vss|sr3_vss|sr4_vss|sv_vss|tg_d_vss|tg_fbm_vss|tg_fbs_vss|tg_s_vss|vss|vss_link|vss_link_bridge|vss_link_dip|vss_link_m1|vss_x1|vss_x2|vss_x3
+ 80.2195614718
* device instance g_vss_m1_inv_clk_vss_inv_mc_vss_inv_q_vss_mph_g_nand_m_vss_nand_s2_vss_s1_vss_m1_s2_vss_m1_s3_vss_m1_s4_vss_m1_sb_vss_sr1_vss_sr2_vss_sr3_vss_sr4_vss_sv_vss_tg_d_vss_tg_fbm_vss_tg_fbs_vss_tg_s_vss_vss_vss_link_vss_link_bridge_vss_link_dip_vss_link_m1_vss_x1_vss_x2_vss_x3_t22 r0 *1 0,0
Rg_vss_m1_inv_clk_vss_inv_mc_vss_inv_q_vss_mph_g_nand_m_vss_nand_s2_vss_s1_vss_m1_s2_vss_m1_s3_vss_m1_s4_vss_m1_sb_vss_sr1_vss_sr2_vss_sr3_vss_sr4_vss_sv_vss_tg_d_vss_tg_fbm_vss_tg_fbs_vss_tg_s_vss_vss_vss_link_vss_link_bridge_vss_link_dip_vss_link_m1_vss_x1_vss_x2_vss_x3_t22
+ g_vss_m1\x7cinv_clk_vss\x7cinv_mc_vss\x7cinv_q_vss\x7cmph_g\x7cnand_m_vss\x7cnand_s2_vss\x7cs1_vss_m1\x7cs2_vss_m1\x7cs3_vss_m1\x7cs4_vss_m1\x7csb_vss\x7csr1_vss\x7csr2_vss\x7csr3_vss\x7csr4_vss\x7csv_vss\x7ctg_d_vss\x7ctg_fbm_vss\x7ctg_fbs_vss\x7ctg_s_vss\x7cvss\x7cvss_link\x7cvss_link_bridge\x7cvss_link_dip\x7cvss_link_m1\x7cvss_x1\x7cvss_x2\x7cvss_x3__t22
+ g_vss_m1|inv_clk_vss|inv_mc_vss|inv_q_vss|mph_g|nand_m_vss|nand_s2_vss|s1_vss_m1|s2_vss_m1|s3_vss_m1|s4_vss_m1|sb_vss|sr1_vss|sr2_vss|sr3_vss|sr4_vss|sv_vss|tg_d_vss|tg_fbm_vss|tg_fbs_vss|tg_s_vss|vss|vss_link|vss_link_bridge|vss_link_dip|vss_link_m1|vss_x1|vss_x2|vss_x3
+ 145.003472361
* device instance g_vss_m1_inv_clk_vss_inv_mc_vss_inv_q_vss_mph_g_nand_m_vss_nand_s2_vss_s1_vss_m1_s2_vss_m1_s3_vss_m1_s4_vss_m1_sb_vss_sr1_vss_sr2_vss_sr3_vss_sr4_vss_sv_vss_tg_d_vss_tg_fbm_vss_tg_fbs_vss_tg_s_vss_vss_vss_link_vss_link_bridge_vss_link_dip_vss_link_m1_vss_x1_vss_x2_vss_x3_t23 r0 *1 0,0
Rg_vss_m1_inv_clk_vss_inv_mc_vss_inv_q_vss_mph_g_nand_m_vss_nand_s2_vss_s1_vss_m1_s2_vss_m1_s3_vss_m1_s4_vss_m1_sb_vss_sr1_vss_sr2_vss_sr3_vss_sr4_vss_sv_vss_tg_d_vss_tg_fbm_vss_tg_fbs_vss_tg_s_vss_vss_vss_link_vss_link_bridge_vss_link_dip_vss_link_m1_vss_x1_vss_x2_vss_x3_t23
+ g_vss_m1\x7cinv_clk_vss\x7cinv_mc_vss\x7cinv_q_vss\x7cmph_g\x7cnand_m_vss\x7cnand_s2_vss\x7cs1_vss_m1\x7cs2_vss_m1\x7cs3_vss_m1\x7cs4_vss_m1\x7csb_vss\x7csr1_vss\x7csr2_vss\x7csr3_vss\x7csr4_vss\x7csv_vss\x7ctg_d_vss\x7ctg_fbm_vss\x7ctg_fbs_vss\x7ctg_s_vss\x7cvss\x7cvss_link\x7cvss_link_bridge\x7cvss_link_dip\x7cvss_link_m1\x7cvss_x1\x7cvss_x2\x7cvss_x3__t23
+ g_vss_m1|inv_clk_vss|inv_mc_vss|inv_q_vss|mph_g|nand_m_vss|nand_s2_vss|s1_vss_m1|s2_vss_m1|s3_vss_m1|s4_vss_m1|sb_vss|sr1_vss|sr2_vss|sr3_vss|sr4_vss|sv_vss|tg_d_vss|tg_fbm_vss|tg_fbs_vss|tg_s_vss|vss|vss_link|vss_link_bridge|vss_link_dip|vss_link_m1|vss_x1|vss_x2|vss_x3
+ 158.711122951
* device instance g_vss_m1_inv_clk_vss_inv_mc_vss_inv_q_vss_mph_g_nand_m_vss_nand_s2_vss_s1_vss_m1_s2_vss_m1_s3_vss_m1_s4_vss_m1_sb_vss_sr1_vss_sr2_vss_sr3_vss_sr4_vss_sv_vss_tg_d_vss_tg_fbm_vss_tg_fbs_vss_tg_s_vss_vss_vss_link_vss_link_bridge_vss_link_dip_vss_link_m1_vss_x1_vss_x2_vss_x3_t24 r0 *1 0,0
Rg_vss_m1_inv_clk_vss_inv_mc_vss_inv_q_vss_mph_g_nand_m_vss_nand_s2_vss_s1_vss_m1_s2_vss_m1_s3_vss_m1_s4_vss_m1_sb_vss_sr1_vss_sr2_vss_sr3_vss_sr4_vss_sv_vss_tg_d_vss_tg_fbm_vss_tg_fbs_vss_tg_s_vss_vss_vss_link_vss_link_bridge_vss_link_dip_vss_link_m1_vss_x1_vss_x2_vss_x3_t24
+ g_vss_m1\x7cinv_clk_vss\x7cinv_mc_vss\x7cinv_q_vss\x7cmph_g\x7cnand_m_vss\x7cnand_s2_vss\x7cs1_vss_m1\x7cs2_vss_m1\x7cs3_vss_m1\x7cs4_vss_m1\x7csb_vss\x7csr1_vss\x7csr2_vss\x7csr3_vss\x7csr4_vss\x7csv_vss\x7ctg_d_vss\x7ctg_fbm_vss\x7ctg_fbs_vss\x7ctg_s_vss\x7cvss\x7cvss_link\x7cvss_link_bridge\x7cvss_link_dip\x7cvss_link_m1\x7cvss_x1\x7cvss_x2\x7cvss_x3__t24
+ g_vss_m1|inv_clk_vss|inv_mc_vss|inv_q_vss|mph_g|nand_m_vss|nand_s2_vss|s1_vss_m1|s2_vss_m1|s3_vss_m1|s4_vss_m1|sb_vss|sr1_vss|sr2_vss|sr3_vss|sr4_vss|sv_vss|tg_d_vss|tg_fbm_vss|tg_fbs_vss|tg_s_vss|vss|vss_link|vss_link_bridge|vss_link_dip|vss_link_m1|vss_x1|vss_x2|vss_x3
+ 172.436553438
* device instance g_vss_m1_inv_clk_vss_inv_mc_vss_inv_q_vss_mph_g_nand_m_vss_nand_s2_vss_s1_vss_m1_s2_vss_m1_s3_vss_m1_s4_vss_m1_sb_vss_sr1_vss_sr2_vss_sr3_vss_sr4_vss_sv_vss_tg_d_vss_tg_fbm_vss_tg_fbs_vss_tg_s_vss_vss_vss_link_vss_link_bridge_vss_link_dip_vss_link_m1_vss_x1_vss_x2_vss_x3_t25 r0 *1 0,0
Rg_vss_m1_inv_clk_vss_inv_mc_vss_inv_q_vss_mph_g_nand_m_vss_nand_s2_vss_s1_vss_m1_s2_vss_m1_s3_vss_m1_s4_vss_m1_sb_vss_sr1_vss_sr2_vss_sr3_vss_sr4_vss_sv_vss_tg_d_vss_tg_fbm_vss_tg_fbs_vss_tg_s_vss_vss_vss_link_vss_link_bridge_vss_link_dip_vss_link_m1_vss_x1_vss_x2_vss_x3_t25
+ g_vss_m1\x7cinv_clk_vss\x7cinv_mc_vss\x7cinv_q_vss\x7cmph_g\x7cnand_m_vss\x7cnand_s2_vss\x7cs1_vss_m1\x7cs2_vss_m1\x7cs3_vss_m1\x7cs4_vss_m1\x7csb_vss\x7csr1_vss\x7csr2_vss\x7csr3_vss\x7csr4_vss\x7csv_vss\x7ctg_d_vss\x7ctg_fbm_vss\x7ctg_fbs_vss\x7ctg_s_vss\x7cvss\x7cvss_link\x7cvss_link_bridge\x7cvss_link_dip\x7cvss_link_m1\x7cvss_x1\x7cvss_x2\x7cvss_x3__t25
+ g_vss_m1|inv_clk_vss|inv_mc_vss|inv_q_vss|mph_g|nand_m_vss|nand_s2_vss|s1_vss_m1|s2_vss_m1|s3_vss_m1|s4_vss_m1|sb_vss|sr1_vss|sr2_vss|sr3_vss|sr4_vss|sv_vss|tg_d_vss|tg_fbm_vss|tg_fbs_vss|tg_s_vss|vss|vss_link|vss_link_bridge|vss_link_dip|vss_link_m1|vss_x1|vss_x2|vss_x3
+ 186.175831503
* device instance g_vss_m1_inv_clk_vss_inv_mc_vss_inv_q_vss_mph_g_nand_m_vss_nand_s2_vss_s1_vss_m1_s2_vss_m1_s3_vss_m1_s4_vss_m1_sb_vss_sr1_vss_sr2_vss_sr3_vss_sr4_vss_sv_vss_tg_d_vss_tg_fbm_vss_tg_fbs_vss_tg_s_vss_vss_vss_link_vss_link_bridge_vss_link_dip_vss_link_m1_vss_x1_vss_x2_vss_x3_t26 r0 *1 0,0
Rg_vss_m1_inv_clk_vss_inv_mc_vss_inv_q_vss_mph_g_nand_m_vss_nand_s2_vss_s1_vss_m1_s2_vss_m1_s3_vss_m1_s4_vss_m1_sb_vss_sr1_vss_sr2_vss_sr3_vss_sr4_vss_sv_vss_tg_d_vss_tg_fbm_vss_tg_fbs_vss_tg_s_vss_vss_vss_link_vss_link_bridge_vss_link_dip_vss_link_m1_vss_x1_vss_x2_vss_x3_t26
+ g_vss_m1\x7cinv_clk_vss\x7cinv_mc_vss\x7cinv_q_vss\x7cmph_g\x7cnand_m_vss\x7cnand_s2_vss\x7cs1_vss_m1\x7cs2_vss_m1\x7cs3_vss_m1\x7cs4_vss_m1\x7csb_vss\x7csr1_vss\x7csr2_vss\x7csr3_vss\x7csr4_vss\x7csv_vss\x7ctg_d_vss\x7ctg_fbm_vss\x7ctg_fbs_vss\x7ctg_s_vss\x7cvss\x7cvss_link\x7cvss_link_bridge\x7cvss_link_dip\x7cvss_link_m1\x7cvss_x1\x7cvss_x2\x7cvss_x3__t26
+ g_vss_m1|inv_clk_vss|inv_mc_vss|inv_q_vss|mph_g|nand_m_vss|nand_s2_vss|s1_vss_m1|s2_vss_m1|s3_vss_m1|s4_vss_m1|sb_vss|sr1_vss|sr2_vss|sr3_vss|sr4_vss|sv_vss|tg_d_vss|tg_fbm_vss|tg_fbs_vss|tg_s_vss|vss|vss_link|vss_link_bridge|vss_link_dip|vss_link_m1|vss_x1|vss_x2|vss_x3
+ 96.174121208
* device instance g_vss_m1_inv_clk_vss_inv_mc_vss_inv_q_vss_mph_g_nand_m_vss_nand_s2_vss_s1_vss_m1_s2_vss_m1_s3_vss_m1_s4_vss_m1_sb_vss_sr1_vss_sr2_vss_sr3_vss_sr4_vss_sv_vss_tg_d_vss_tg_fbm_vss_tg_fbs_vss_tg_s_vss_vss_vss_link_vss_link_bridge_vss_link_dip_vss_link_m1_vss_x1_vss_x2_vss_x3_t27 r0 *1 0,0
Rg_vss_m1_inv_clk_vss_inv_mc_vss_inv_q_vss_mph_g_nand_m_vss_nand_s2_vss_s1_vss_m1_s2_vss_m1_s3_vss_m1_s4_vss_m1_sb_vss_sr1_vss_sr2_vss_sr3_vss_sr4_vss_sv_vss_tg_d_vss_tg_fbm_vss_tg_fbs_vss_tg_s_vss_vss_vss_link_vss_link_bridge_vss_link_dip_vss_link_m1_vss_x1_vss_x2_vss_x3_t27
+ g_vss_m1\x7cinv_clk_vss\x7cinv_mc_vss\x7cinv_q_vss\x7cmph_g\x7cnand_m_vss\x7cnand_s2_vss\x7cs1_vss_m1\x7cs2_vss_m1\x7cs3_vss_m1\x7cs4_vss_m1\x7csb_vss\x7csr1_vss\x7csr2_vss\x7csr3_vss\x7csr4_vss\x7csv_vss\x7ctg_d_vss\x7ctg_fbm_vss\x7ctg_fbs_vss\x7ctg_s_vss\x7cvss\x7cvss_link\x7cvss_link_bridge\x7cvss_link_dip\x7cvss_link_m1\x7cvss_x1\x7cvss_x2\x7cvss_x3__t27
+ g_vss_m1|inv_clk_vss|inv_mc_vss|inv_q_vss|mph_g|nand_m_vss|nand_s2_vss|s1_vss_m1|s2_vss_m1|s3_vss_m1|s4_vss_m1|sb_vss|sr1_vss|sr2_vss|sr3_vss|sr4_vss|sv_vss|tg_d_vss|tg_fbm_vss|tg_fbs_vss|tg_s_vss|vss|vss_link|vss_link_bridge|vss_link_dip|vss_link_m1|vss_x1|vss_x2|vss_x3
+ 109.877795925
* device instance g_vss_m1_inv_clk_vss_inv_mc_vss_inv_q_vss_mph_g_nand_m_vss_nand_s2_vss_s1_vss_m1_s2_vss_m1_s3_vss_m1_s4_vss_m1_sb_vss_sr1_vss_sr2_vss_sr3_vss_sr4_vss_sv_vss_tg_d_vss_tg_fbm_vss_tg_fbs_vss_tg_s_vss_vss_vss_link_vss_link_bridge_vss_link_dip_vss_link_m1_vss_x1_vss_x2_vss_x3_t28 r0 *1 0,0
Rg_vss_m1_inv_clk_vss_inv_mc_vss_inv_q_vss_mph_g_nand_m_vss_nand_s2_vss_s1_vss_m1_s2_vss_m1_s3_vss_m1_s4_vss_m1_sb_vss_sr1_vss_sr2_vss_sr3_vss_sr4_vss_sv_vss_tg_d_vss_tg_fbm_vss_tg_fbs_vss_tg_s_vss_vss_vss_link_vss_link_bridge_vss_link_dip_vss_link_m1_vss_x1_vss_x2_vss_x3_t28
+ g_vss_m1\x7cinv_clk_vss\x7cinv_mc_vss\x7cinv_q_vss\x7cmph_g\x7cnand_m_vss\x7cnand_s2_vss\x7cs1_vss_m1\x7cs2_vss_m1\x7cs3_vss_m1\x7cs4_vss_m1\x7csb_vss\x7csr1_vss\x7csr2_vss\x7csr3_vss\x7csr4_vss\x7csv_vss\x7ctg_d_vss\x7ctg_fbm_vss\x7ctg_fbs_vss\x7ctg_s_vss\x7cvss\x7cvss_link\x7cvss_link_bridge\x7cvss_link_dip\x7cvss_link_m1\x7cvss_x1\x7cvss_x2\x7cvss_x3__t28
+ g_vss_m1|inv_clk_vss|inv_mc_vss|inv_q_vss|mph_g|nand_m_vss|nand_s2_vss|s1_vss_m1|s2_vss_m1|s3_vss_m1|s4_vss_m1|sb_vss|sr1_vss|sr2_vss|sr3_vss|sr4_vss|sv_vss|tg_d_vss|tg_fbm_vss|tg_fbs_vss|tg_s_vss|vss|vss_link|vss_link_bridge|vss_link_dip|vss_link_m1|vss_x1|vss_x2|vss_x3
+ 123.607157341
* device instance g_vss_m1_inv_clk_vss_inv_mc_vss_inv_q_vss_mph_g_nand_m_vss_nand_s2_vss_s1_vss_m1_s2_vss_m1_s3_vss_m1_s4_vss_m1_sb_vss_sr1_vss_sr2_vss_sr3_vss_sr4_vss_sv_vss_tg_d_vss_tg_fbm_vss_tg_fbs_vss_tg_s_vss_vss_vss_link_vss_link_bridge_vss_link_dip_vss_link_m1_vss_x1_vss_x2_vss_x3_t29 r0 *1 0,0
Rg_vss_m1_inv_clk_vss_inv_mc_vss_inv_q_vss_mph_g_nand_m_vss_nand_s2_vss_s1_vss_m1_s2_vss_m1_s3_vss_m1_s4_vss_m1_sb_vss_sr1_vss_sr2_vss_sr3_vss_sr4_vss_sv_vss_tg_d_vss_tg_fbm_vss_tg_fbs_vss_tg_s_vss_vss_vss_link_vss_link_bridge_vss_link_dip_vss_link_m1_vss_x1_vss_x2_vss_x3_t29
+ g_vss_m1\x7cinv_clk_vss\x7cinv_mc_vss\x7cinv_q_vss\x7cmph_g\x7cnand_m_vss\x7cnand_s2_vss\x7cs1_vss_m1\x7cs2_vss_m1\x7cs3_vss_m1\x7cs4_vss_m1\x7csb_vss\x7csr1_vss\x7csr2_vss\x7csr3_vss\x7csr4_vss\x7csv_vss\x7ctg_d_vss\x7ctg_fbm_vss\x7ctg_fbs_vss\x7ctg_s_vss\x7cvss\x7cvss_link\x7cvss_link_bridge\x7cvss_link_dip\x7cvss_link_m1\x7cvss_x1\x7cvss_x2\x7cvss_x3__t29
+ g_vss_m1|inv_clk_vss|inv_mc_vss|inv_q_vss|mph_g|nand_m_vss|nand_s2_vss|s1_vss_m1|s2_vss_m1|s3_vss_m1|s4_vss_m1|sb_vss|sr1_vss|sr2_vss|sr3_vss|sr4_vss|sv_vss|tg_d_vss|tg_fbm_vss|tg_fbs_vss|tg_s_vss|vss|vss_link|vss_link_bridge|vss_link_dip|vss_link_m1|vss_x1|vss_x2|vss_x3
+ 137.354503079
* device instance g_vss_m1_inv_clk_vss_inv_mc_vss_inv_q_vss_mph_g_nand_m_vss_nand_s2_vss_s1_vss_m1_s2_vss_m1_s3_vss_m1_s4_vss_m1_sb_vss_sr1_vss_sr2_vss_sr3_vss_sr4_vss_sv_vss_tg_d_vss_tg_fbm_vss_tg_fbs_vss_tg_s_vss_vss_vss_link_vss_link_bridge_vss_link_dip_vss_link_m1_vss_x1_vss_x2_vss_x3_t30 r0 *1 0,0
Rg_vss_m1_inv_clk_vss_inv_mc_vss_inv_q_vss_mph_g_nand_m_vss_nand_s2_vss_s1_vss_m1_s2_vss_m1_s3_vss_m1_s4_vss_m1_sb_vss_sr1_vss_sr2_vss_sr3_vss_sr4_vss_sv_vss_tg_d_vss_tg_fbm_vss_tg_fbs_vss_tg_s_vss_vss_vss_link_vss_link_bridge_vss_link_dip_vss_link_m1_vss_x1_vss_x2_vss_x3_t30
+ g_vss_m1\x7cinv_clk_vss\x7cinv_mc_vss\x7cinv_q_vss\x7cmph_g\x7cnand_m_vss\x7cnand_s2_vss\x7cs1_vss_m1\x7cs2_vss_m1\x7cs3_vss_m1\x7cs4_vss_m1\x7csb_vss\x7csr1_vss\x7csr2_vss\x7csr3_vss\x7csr4_vss\x7csv_vss\x7ctg_d_vss\x7ctg_fbm_vss\x7ctg_fbs_vss\x7ctg_s_vss\x7cvss\x7cvss_link\x7cvss_link_bridge\x7cvss_link_dip\x7cvss_link_m1\x7cvss_x1\x7cvss_x2\x7cvss_x3__t30
+ g_vss_m1|inv_clk_vss|inv_mc_vss|inv_q_vss|mph_g|nand_m_vss|nand_s2_vss|s1_vss_m1|s2_vss_m1|s3_vss_m1|s4_vss_m1|sb_vss|sr1_vss|sr2_vss|sr3_vss|sr4_vss|sv_vss|tg_d_vss|tg_fbm_vss|tg_fbs_vss|tg_s_vss|vss|vss_link|vss_link_bridge|vss_link_dip|vss_link_m1|vss_x1|vss_x2|vss_x3
+ 20.4673407606
* device instance g_vss_m1_inv_clk_vss_inv_mc_vss_inv_q_vss_mph_g_nand_m_vss_nand_s2_vss_s1_vss_m1_s2_vss_m1_s3_vss_m1_s4_vss_m1_sb_vss_sr1_vss_sr2_vss_sr3_vss_sr4_vss_sv_vss_tg_d_vss_tg_fbm_vss_tg_fbs_vss_tg_s_vss_vss_vss_link_vss_link_bridge_vss_link_dip_vss_link_m1_vss_x1_vss_x2_vss_x3_t31 r0 *1 0,0
Rg_vss_m1_inv_clk_vss_inv_mc_vss_inv_q_vss_mph_g_nand_m_vss_nand_s2_vss_s1_vss_m1_s2_vss_m1_s3_vss_m1_s4_vss_m1_sb_vss_sr1_vss_sr2_vss_sr3_vss_sr4_vss_sv_vss_tg_d_vss_tg_fbm_vss_tg_fbs_vss_tg_s_vss_vss_vss_link_vss_link_bridge_vss_link_dip_vss_link_m1_vss_x1_vss_x2_vss_x3_t31
+ g_vss_m1\x7cinv_clk_vss\x7cinv_mc_vss\x7cinv_q_vss\x7cmph_g\x7cnand_m_vss\x7cnand_s2_vss\x7cs1_vss_m1\x7cs2_vss_m1\x7cs3_vss_m1\x7cs4_vss_m1\x7csb_vss\x7csr1_vss\x7csr2_vss\x7csr3_vss\x7csr4_vss\x7csv_vss\x7ctg_d_vss\x7ctg_fbm_vss\x7ctg_fbs_vss\x7ctg_s_vss\x7cvss\x7cvss_link\x7cvss_link_bridge\x7cvss_link_dip\x7cvss_link_m1\x7cvss_x1\x7cvss_x2\x7cvss_x3__t31
+ g_vss_m1|inv_clk_vss|inv_mc_vss|inv_q_vss|mph_g|nand_m_vss|nand_s2_vss|s1_vss_m1|s2_vss_m1|s3_vss_m1|s4_vss_m1|sb_vss|sr1_vss|sr2_vss|sr3_vss|sr4_vss|sv_vss|tg_d_vss|tg_fbm_vss|tg_fbs_vss|tg_s_vss|vss|vss_link|vss_link_bridge|vss_link_dip|vss_link_m1|vss_x1|vss_x2|vss_x3
+ 13.372540194
* device instance g_vss_m1_inv_clk_vss_inv_mc_vss_inv_q_vss_mph_g_nand_m_vss_nand_s2_vss_s1_vss_m1_s2_vss_m1_s3_vss_m1_s4_vss_m1_sb_vss_sr1_vss_sr2_vss_sr3_vss_sr4_vss_sv_vss_tg_d_vss_tg_fbm_vss_tg_fbs_vss_tg_s_vss_vss_vss_link_vss_link_bridge_vss_link_dip_vss_link_m1_vss_x1_vss_x2_vss_x3_t32 r0 *1 0,0
Rg_vss_m1_inv_clk_vss_inv_mc_vss_inv_q_vss_mph_g_nand_m_vss_nand_s2_vss_s1_vss_m1_s2_vss_m1_s3_vss_m1_s4_vss_m1_sb_vss_sr1_vss_sr2_vss_sr3_vss_sr4_vss_sv_vss_tg_d_vss_tg_fbm_vss_tg_fbs_vss_tg_s_vss_vss_vss_link_vss_link_bridge_vss_link_dip_vss_link_m1_vss_x1_vss_x2_vss_x3_t32
+ g_vss_m1\x7cinv_clk_vss\x7cinv_mc_vss\x7cinv_q_vss\x7cmph_g\x7cnand_m_vss\x7cnand_s2_vss\x7cs1_vss_m1\x7cs2_vss_m1\x7cs3_vss_m1\x7cs4_vss_m1\x7csb_vss\x7csr1_vss\x7csr2_vss\x7csr3_vss\x7csr4_vss\x7csv_vss\x7ctg_d_vss\x7ctg_fbm_vss\x7ctg_fbs_vss\x7ctg_s_vss\x7cvss\x7cvss_link\x7cvss_link_bridge\x7cvss_link_dip\x7cvss_link_m1\x7cvss_x1\x7cvss_x2\x7cvss_x3__t32
+ g_vss_m1|inv_clk_vss|inv_mc_vss|inv_q_vss|mph_g|nand_m_vss|nand_s2_vss|s1_vss_m1|s2_vss_m1|s3_vss_m1|s4_vss_m1|sb_vss|sr1_vss|sr2_vss|sr3_vss|sr4_vss|sv_vss|tg_d_vss|tg_fbm_vss|tg_fbs_vss|tg_s_vss|vss|vss_link|vss_link_bridge|vss_link_dip|vss_link_m1|vss_x1|vss_x2|vss_x3
+ 45.2203387369
* device instance g_vss_m1_inv_clk_vss_inv_mc_vss_inv_q_vss_mph_g_nand_m_vss_nand_s2_vss_s1_vss_m1_s2_vss_m1_s3_vss_m1_s4_vss_m1_sb_vss_sr1_vss_sr2_vss_sr3_vss_sr4_vss_sv_vss_tg_d_vss_tg_fbm_vss_tg_fbs_vss_tg_s_vss_vss_vss_link_vss_link_bridge_vss_link_dip_vss_link_m1_vss_x1_vss_x2_vss_x3_t33 r0 *1 0,0
Rg_vss_m1_inv_clk_vss_inv_mc_vss_inv_q_vss_mph_g_nand_m_vss_nand_s2_vss_s1_vss_m1_s2_vss_m1_s3_vss_m1_s4_vss_m1_sb_vss_sr1_vss_sr2_vss_sr3_vss_sr4_vss_sv_vss_tg_d_vss_tg_fbm_vss_tg_fbs_vss_tg_s_vss_vss_vss_link_vss_link_bridge_vss_link_dip_vss_link_m1_vss_x1_vss_x2_vss_x3_t33
+ g_vss_m1\x7cinv_clk_vss\x7cinv_mc_vss\x7cinv_q_vss\x7cmph_g\x7cnand_m_vss\x7cnand_s2_vss\x7cs1_vss_m1\x7cs2_vss_m1\x7cs3_vss_m1\x7cs4_vss_m1\x7csb_vss\x7csr1_vss\x7csr2_vss\x7csr3_vss\x7csr4_vss\x7csv_vss\x7ctg_d_vss\x7ctg_fbm_vss\x7ctg_fbs_vss\x7ctg_s_vss\x7cvss\x7cvss_link\x7cvss_link_bridge\x7cvss_link_dip\x7cvss_link_m1\x7cvss_x1\x7cvss_x2\x7cvss_x3__t33
+ g_vss_m1|inv_clk_vss|inv_mc_vss|inv_q_vss|mph_g|nand_m_vss|nand_s2_vss|s1_vss_m1|s2_vss_m1|s3_vss_m1|s4_vss_m1|sb_vss|sr1_vss|sr2_vss|sr3_vss|sr4_vss|sv_vss|tg_d_vss|tg_fbm_vss|tg_fbs_vss|tg_s_vss|vss|vss_link|vss_link_bridge|vss_link_dip|vss_link_m1|vss_x1|vss_x2|vss_x3
+ 32.2634484501
* device instance g_vss_m1_inv_clk_vss_inv_mc_vss_inv_q_vss_mph_g_nand_m_vss_nand_s2_vss_s1_vss_m1_s2_vss_m1_s3_vss_m1_s4_vss_m1_sb_vss_sr1_vss_sr2_vss_sr3_vss_sr4_vss_sv_vss_tg_d_vss_tg_fbm_vss_tg_fbs_vss_tg_s_vss_vss_vss_link_vss_link_bridge_vss_link_dip_vss_link_m1_vss_x1_vss_x2_vss_x3_t34 r0 *1 0,0
Rg_vss_m1_inv_clk_vss_inv_mc_vss_inv_q_vss_mph_g_nand_m_vss_nand_s2_vss_s1_vss_m1_s2_vss_m1_s3_vss_m1_s4_vss_m1_sb_vss_sr1_vss_sr2_vss_sr3_vss_sr4_vss_sv_vss_tg_d_vss_tg_fbm_vss_tg_fbs_vss_tg_s_vss_vss_vss_link_vss_link_bridge_vss_link_dip_vss_link_m1_vss_x1_vss_x2_vss_x3_t34
+ g_vss_m1\x7cinv_clk_vss\x7cinv_mc_vss\x7cinv_q_vss\x7cmph_g\x7cnand_m_vss\x7cnand_s2_vss\x7cs1_vss_m1\x7cs2_vss_m1\x7cs3_vss_m1\x7cs4_vss_m1\x7csb_vss\x7csr1_vss\x7csr2_vss\x7csr3_vss\x7csr4_vss\x7csv_vss\x7ctg_d_vss\x7ctg_fbm_vss\x7ctg_fbs_vss\x7ctg_s_vss\x7cvss\x7cvss_link\x7cvss_link_bridge\x7cvss_link_dip\x7cvss_link_m1\x7cvss_x1\x7cvss_x2\x7cvss_x3__t34
+ g_vss_m1|inv_clk_vss|inv_mc_vss|inv_q_vss|mph_g|nand_m_vss|nand_s2_vss|s1_vss_m1|s2_vss_m1|s3_vss_m1|s4_vss_m1|sb_vss|sr1_vss|sr2_vss|sr3_vss|sr4_vss|sv_vss|tg_d_vss|tg_fbm_vss|tg_fbs_vss|tg_s_vss|vss|vss_link|vss_link_bridge|vss_link_dip|vss_link_m1|vss_x1|vss_x2|vss_x3
+ 79.0025094375
* device instance g_vss_m1_inv_clk_vss_inv_mc_vss_inv_q_vss_mph_g_nand_m_vss_nand_s2_vss_s1_vss_m1_s2_vss_m1_s3_vss_m1_s4_vss_m1_sb_vss_sr1_vss_sr2_vss_sr3_vss_sr4_vss_sv_vss_tg_d_vss_tg_fbm_vss_tg_fbs_vss_tg_s_vss_vss_vss_link_vss_link_bridge_vss_link_dip_vss_link_m1_vss_x1_vss_x2_vss_x3_t35 r0 *1 0,0
Rg_vss_m1_inv_clk_vss_inv_mc_vss_inv_q_vss_mph_g_nand_m_vss_nand_s2_vss_s1_vss_m1_s2_vss_m1_s3_vss_m1_s4_vss_m1_sb_vss_sr1_vss_sr2_vss_sr3_vss_sr4_vss_sv_vss_tg_d_vss_tg_fbm_vss_tg_fbs_vss_tg_s_vss_vss_vss_link_vss_link_bridge_vss_link_dip_vss_link_m1_vss_x1_vss_x2_vss_x3_t35
+ g_vss_m1\x7cinv_clk_vss\x7cinv_mc_vss\x7cinv_q_vss\x7cmph_g\x7cnand_m_vss\x7cnand_s2_vss\x7cs1_vss_m1\x7cs2_vss_m1\x7cs3_vss_m1\x7cs4_vss_m1\x7csb_vss\x7csr1_vss\x7csr2_vss\x7csr3_vss\x7csr4_vss\x7csv_vss\x7ctg_d_vss\x7ctg_fbm_vss\x7ctg_fbs_vss\x7ctg_s_vss\x7cvss\x7cvss_link\x7cvss_link_bridge\x7cvss_link_dip\x7cvss_link_m1\x7cvss_x1\x7cvss_x2\x7cvss_x3__t35
+ g_vss_m1|inv_clk_vss|inv_mc_vss|inv_q_vss|mph_g|nand_m_vss|nand_s2_vss|s1_vss_m1|s2_vss_m1|s3_vss_m1|s4_vss_m1|sb_vss|sr1_vss|sr2_vss|sr3_vss|sr4_vss|sv_vss|tg_d_vss|tg_fbm_vss|tg_fbs_vss|tg_s_vss|vss|vss_link|vss_link_bridge|vss_link_dip|vss_link_m1|vss_x1|vss_x2|vss_x3
+ 51.963458449
* device instance g_vss_m1_inv_clk_vss_inv_mc_vss_inv_q_vss_mph_g_nand_m_vss_nand_s2_vss_s1_vss_m1_s2_vss_m1_s3_vss_m1_s4_vss_m1_sb_vss_sr1_vss_sr2_vss_sr3_vss_sr4_vss_sv_vss_tg_d_vss_tg_fbm_vss_tg_fbs_vss_tg_s_vss_vss_vss_link_vss_link_bridge_vss_link_dip_vss_link_m1_vss_x1_vss_x2_vss_x3_t36 r0 *1 0,0
Rg_vss_m1_inv_clk_vss_inv_mc_vss_inv_q_vss_mph_g_nand_m_vss_nand_s2_vss_s1_vss_m1_s2_vss_m1_s3_vss_m1_s4_vss_m1_sb_vss_sr1_vss_sr2_vss_sr3_vss_sr4_vss_sv_vss_tg_d_vss_tg_fbm_vss_tg_fbs_vss_tg_s_vss_vss_vss_link_vss_link_bridge_vss_link_dip_vss_link_m1_vss_x1_vss_x2_vss_x3_t36
+ g_vss_m1\x7cinv_clk_vss\x7cinv_mc_vss\x7cinv_q_vss\x7cmph_g\x7cnand_m_vss\x7cnand_s2_vss\x7cs1_vss_m1\x7cs2_vss_m1\x7cs3_vss_m1\x7cs4_vss_m1\x7csb_vss\x7csr1_vss\x7csr2_vss\x7csr3_vss\x7csr4_vss\x7csv_vss\x7ctg_d_vss\x7ctg_fbm_vss\x7ctg_fbs_vss\x7ctg_s_vss\x7cvss\x7cvss_link\x7cvss_link_bridge\x7cvss_link_dip\x7cvss_link_m1\x7cvss_x1\x7cvss_x2\x7cvss_x3__t36
+ g_vss_m1|inv_clk_vss|inv_mc_vss|inv_q_vss|mph_g|nand_m_vss|nand_s2_vss|s1_vss_m1|s2_vss_m1|s3_vss_m1|s4_vss_m1|sb_vss|sr1_vss|sr2_vss|sr3_vss|sr4_vss|sv_vss|tg_d_vss|tg_fbm_vss|tg_fbs_vss|tg_s_vss|vss|vss_link|vss_link_bridge|vss_link_dip|vss_link_m1|vss_x1|vss_x2|vss_x3
+ 65.4204350715
* device instance g_vss_m1_inv_clk_vss_inv_mc_vss_inv_q_vss_mph_g_nand_m_vss_nand_s2_vss_s1_vss_m1_s2_vss_m1_s3_vss_m1_s4_vss_m1_sb_vss_sr1_vss_sr2_vss_sr3_vss_sr4_vss_sv_vss_tg_d_vss_tg_fbm_vss_tg_fbs_vss_tg_s_vss_vss_vss_link_vss_link_bridge_vss_link_dip_vss_link_m1_vss_x1_vss_x2_vss_x3_t37 r0 *1 0,0
Rg_vss_m1_inv_clk_vss_inv_mc_vss_inv_q_vss_mph_g_nand_m_vss_nand_s2_vss_s1_vss_m1_s2_vss_m1_s3_vss_m1_s4_vss_m1_sb_vss_sr1_vss_sr2_vss_sr3_vss_sr4_vss_sv_vss_tg_d_vss_tg_fbm_vss_tg_fbs_vss_tg_s_vss_vss_vss_link_vss_link_bridge_vss_link_dip_vss_link_m1_vss_x1_vss_x2_vss_x3_t37
+ g_vss_m1\x7cinv_clk_vss\x7cinv_mc_vss\x7cinv_q_vss\x7cmph_g\x7cnand_m_vss\x7cnand_s2_vss\x7cs1_vss_m1\x7cs2_vss_m1\x7cs3_vss_m1\x7cs4_vss_m1\x7csb_vss\x7csr1_vss\x7csr2_vss\x7csr3_vss\x7csr4_vss\x7csv_vss\x7ctg_d_vss\x7ctg_fbm_vss\x7ctg_fbs_vss\x7ctg_s_vss\x7cvss\x7cvss_link\x7cvss_link_bridge\x7cvss_link_dip\x7cvss_link_m1\x7cvss_x1\x7cvss_x2\x7cvss_x3__t37
+ g_vss_m1|inv_clk_vss|inv_mc_vss|inv_q_vss|mph_g|nand_m_vss|nand_s2_vss|s1_vss_m1|s2_vss_m1|s3_vss_m1|s4_vss_m1|sb_vss|sr1_vss|sr2_vss|sr3_vss|sr4_vss|sv_vss|tg_d_vss|tg_fbm_vss|tg_fbs_vss|tg_s_vss|vss|vss_link|vss_link_bridge|vss_link_dip|vss_link_m1|vss_x1|vss_x2|vss_x3
+ 92.6546843469
* device instance g_vss_m1_inv_clk_vss_inv_mc_vss_inv_q_vss_mph_g_nand_m_vss_nand_s2_vss_s1_vss_m1_s2_vss_m1_s3_vss_m1_s4_vss_m1_sb_vss_sr1_vss_sr2_vss_sr3_vss_sr4_vss_sv_vss_tg_d_vss_tg_fbm_vss_tg_fbs_vss_tg_s_vss_vss_vss_link_vss_link_bridge_vss_link_dip_vss_link_m1_vss_x1_vss_x2_vss_x3_t38 r0 *1 0,0
Rg_vss_m1_inv_clk_vss_inv_mc_vss_inv_q_vss_mph_g_nand_m_vss_nand_s2_vss_s1_vss_m1_s2_vss_m1_s3_vss_m1_s4_vss_m1_sb_vss_sr1_vss_sr2_vss_sr3_vss_sr4_vss_sv_vss_tg_d_vss_tg_fbm_vss_tg_fbs_vss_tg_s_vss_vss_vss_link_vss_link_bridge_vss_link_dip_vss_link_m1_vss_x1_vss_x2_vss_x3_t38
+ g_vss_m1\x7cinv_clk_vss\x7cinv_mc_vss\x7cinv_q_vss\x7cmph_g\x7cnand_m_vss\x7cnand_s2_vss\x7cs1_vss_m1\x7cs2_vss_m1\x7cs3_vss_m1\x7cs4_vss_m1\x7csb_vss\x7csr1_vss\x7csr2_vss\x7csr3_vss\x7csr4_vss\x7csv_vss\x7ctg_d_vss\x7ctg_fbm_vss\x7ctg_fbs_vss\x7ctg_s_vss\x7cvss\x7cvss_link\x7cvss_link_bridge\x7cvss_link_dip\x7cvss_link_m1\x7cvss_x1\x7cvss_x2\x7cvss_x3__t38
+ g_vss_m1|inv_clk_vss|inv_mc_vss|inv_q_vss|mph_g|nand_m_vss|nand_s2_vss|s1_vss_m1|s2_vss_m1|s3_vss_m1|s4_vss_m1|sb_vss|sr1_vss|sr2_vss|sr3_vss|sr4_vss|sv_vss|tg_d_vss|tg_fbm_vss|tg_fbs_vss|tg_s_vss|vss|vss_link|vss_link_bridge|vss_link_dip|vss_link_m1|vss_x1|vss_x2|vss_x3
+ 185.654675919
* device instance g_vss_m1_inv_clk_vss_inv_mc_vss_inv_q_vss_mph_g_nand_m_vss_nand_s2_vss_s1_vss_m1_s2_vss_m1_s3_vss_m1_s4_vss_m1_sb_vss_sr1_vss_sr2_vss_sr3_vss_sr4_vss_sv_vss_tg_d_vss_tg_fbm_vss_tg_fbs_vss_tg_s_vss_vss_vss_link_vss_link_bridge_vss_link_dip_vss_link_m1_vss_x1_vss_x2_vss_x3_t39 r0 *1 0,0
Rg_vss_m1_inv_clk_vss_inv_mc_vss_inv_q_vss_mph_g_nand_m_vss_nand_s2_vss_s1_vss_m1_s2_vss_m1_s3_vss_m1_s4_vss_m1_sb_vss_sr1_vss_sr2_vss_sr3_vss_sr4_vss_sv_vss_tg_d_vss_tg_fbm_vss_tg_fbs_vss_tg_s_vss_vss_vss_link_vss_link_bridge_vss_link_dip_vss_link_m1_vss_x1_vss_x2_vss_x3_t39
+ g_vss_m1\x7cinv_clk_vss\x7cinv_mc_vss\x7cinv_q_vss\x7cmph_g\x7cnand_m_vss\x7cnand_s2_vss\x7cs1_vss_m1\x7cs2_vss_m1\x7cs3_vss_m1\x7cs4_vss_m1\x7csb_vss\x7csr1_vss\x7csr2_vss\x7csr3_vss\x7csr4_vss\x7csv_vss\x7ctg_d_vss\x7ctg_fbm_vss\x7ctg_fbs_vss\x7ctg_s_vss\x7cvss\x7cvss_link\x7cvss_link_bridge\x7cvss_link_dip\x7cvss_link_m1\x7cvss_x1\x7cvss_x2\x7cvss_x3__t39
+ g_vss_m1|inv_clk_vss|inv_mc_vss|inv_q_vss|mph_g|nand_m_vss|nand_s2_vss|s1_vss_m1|s2_vss_m1|s3_vss_m1|s4_vss_m1|sb_vss|sr1_vss|sr2_vss|sr3_vss|sr4_vss|sv_vss|tg_d_vss|tg_fbm_vss|tg_fbs_vss|tg_s_vss|vss|vss_link|vss_link_bridge|vss_link_dip|vss_link_m1|vss_x1|vss_x2|vss_x3
+ 158.099459212
* device instance g_vss_m1_inv_clk_vss_inv_mc_vss_inv_q_vss_mph_g_nand_m_vss_nand_s2_vss_s1_vss_m1_s2_vss_m1_s3_vss_m1_s4_vss_m1_sb_vss_sr1_vss_sr2_vss_sr3_vss_sr4_vss_sv_vss_tg_d_vss_tg_fbm_vss_tg_fbs_vss_tg_s_vss_vss_vss_link_vss_link_bridge_vss_link_dip_vss_link_m1_vss_x1_vss_x2_vss_x3_t40 r0 *1 0,0
Rg_vss_m1_inv_clk_vss_inv_mc_vss_inv_q_vss_mph_g_nand_m_vss_nand_s2_vss_s1_vss_m1_s2_vss_m1_s3_vss_m1_s4_vss_m1_sb_vss_sr1_vss_sr2_vss_sr3_vss_sr4_vss_sv_vss_tg_d_vss_tg_fbm_vss_tg_fbs_vss_tg_s_vss_vss_vss_link_vss_link_bridge_vss_link_dip_vss_link_m1_vss_x1_vss_x2_vss_x3_t40
+ g_vss_m1\x7cinv_clk_vss\x7cinv_mc_vss\x7cinv_q_vss\x7cmph_g\x7cnand_m_vss\x7cnand_s2_vss\x7cs1_vss_m1\x7cs2_vss_m1\x7cs3_vss_m1\x7cs4_vss_m1\x7csb_vss\x7csr1_vss\x7csr2_vss\x7csr3_vss\x7csr4_vss\x7csv_vss\x7ctg_d_vss\x7ctg_fbm_vss\x7ctg_fbs_vss\x7ctg_s_vss\x7cvss\x7cvss_link\x7cvss_link_bridge\x7cvss_link_dip\x7cvss_link_m1\x7cvss_x1\x7cvss_x2\x7cvss_x3__t40
+ g_vss_m1|inv_clk_vss|inv_mc_vss|inv_q_vss|mph_g|nand_m_vss|nand_s2_vss|s1_vss_m1|s2_vss_m1|s3_vss_m1|s4_vss_m1|sb_vss|sr1_vss|sr2_vss|sr3_vss|sr4_vss|sv_vss|tg_d_vss|tg_fbm_vss|tg_fbs_vss|tg_s_vss|vss|vss_link|vss_link_bridge|vss_link_dip|vss_link_m1|vss_x1|vss_x2|vss_x3
+ 144.333729431
* device instance g_vss_m1_inv_clk_vss_inv_mc_vss_inv_q_vss_mph_g_nand_m_vss_nand_s2_vss_s1_vss_m1_s2_vss_m1_s3_vss_m1_s4_vss_m1_sb_vss_sr1_vss_sr2_vss_sr3_vss_sr4_vss_sv_vss_tg_d_vss_tg_fbm_vss_tg_fbs_vss_tg_s_vss_vss_vss_link_vss_link_bridge_vss_link_dip_vss_link_m1_vss_x1_vss_x2_vss_x3_t41 r0 *1 0,0
Rg_vss_m1_inv_clk_vss_inv_mc_vss_inv_q_vss_mph_g_nand_m_vss_nand_s2_vss_s1_vss_m1_s2_vss_m1_s3_vss_m1_s4_vss_m1_sb_vss_sr1_vss_sr2_vss_sr3_vss_sr4_vss_sv_vss_tg_d_vss_tg_fbm_vss_tg_fbs_vss_tg_s_vss_vss_vss_link_vss_link_bridge_vss_link_dip_vss_link_m1_vss_x1_vss_x2_vss_x3_t41
+ g_vss_m1\x7cinv_clk_vss\x7cinv_mc_vss\x7cinv_q_vss\x7cmph_g\x7cnand_m_vss\x7cnand_s2_vss\x7cs1_vss_m1\x7cs2_vss_m1\x7cs3_vss_m1\x7cs4_vss_m1\x7csb_vss\x7csr1_vss\x7csr2_vss\x7csr3_vss\x7csr4_vss\x7csv_vss\x7ctg_d_vss\x7ctg_fbm_vss\x7ctg_fbs_vss\x7ctg_s_vss\x7cvss\x7cvss_link\x7cvss_link_bridge\x7cvss_link_dip\x7cvss_link_m1\x7cvss_x1\x7cvss_x2\x7cvss_x3__t41
+ g_vss_m1|inv_clk_vss|inv_mc_vss|inv_q_vss|mph_g|nand_m_vss|nand_s2_vss|s1_vss_m1|s2_vss_m1|s3_vss_m1|s4_vss_m1|sb_vss|sr1_vss|sr2_vss|sr3_vss|sr4_vss|sv_vss|tg_d_vss|tg_fbm_vss|tg_fbs_vss|tg_s_vss|vss|vss_link|vss_link_bridge|vss_link_dip|vss_link_m1|vss_x1|vss_x2|vss_x3
+ 171.873742661
* device instance g_vss_m1_inv_clk_vss_inv_mc_vss_inv_q_vss_mph_g_nand_m_vss_nand_s2_vss_s1_vss_m1_s2_vss_m1_s3_vss_m1_s4_vss_m1_sb_vss_sr1_vss_sr2_vss_sr3_vss_sr4_vss_sv_vss_tg_d_vss_tg_fbm_vss_tg_fbs_vss_tg_s_vss_vss_vss_link_vss_link_bridge_vss_link_dip_vss_link_m1_vss_x1_vss_x2_vss_x3_t42 r0 *1 0,0
Rg_vss_m1_inv_clk_vss_inv_mc_vss_inv_q_vss_mph_g_nand_m_vss_nand_s2_vss_s1_vss_m1_s2_vss_m1_s3_vss_m1_s4_vss_m1_sb_vss_sr1_vss_sr2_vss_sr3_vss_sr4_vss_sv_vss_tg_d_vss_tg_fbm_vss_tg_fbs_vss_tg_s_vss_vss_vss_link_vss_link_bridge_vss_link_dip_vss_link_m1_vss_x1_vss_x2_vss_x3_t42
+ g_vss_m1\x7cinv_clk_vss\x7cinv_mc_vss\x7cinv_q_vss\x7cmph_g\x7cnand_m_vss\x7cnand_s2_vss\x7cs1_vss_m1\x7cs2_vss_m1\x7cs3_vss_m1\x7cs4_vss_m1\x7csb_vss\x7csr1_vss\x7csr2_vss\x7csr3_vss\x7csr4_vss\x7csv_vss\x7ctg_d_vss\x7ctg_fbm_vss\x7ctg_fbs_vss\x7ctg_s_vss\x7cvss\x7cvss_link\x7cvss_link_bridge\x7cvss_link_dip\x7cvss_link_m1\x7cvss_x1\x7cvss_x2\x7cvss_x3__t42
+ g_vss_m1|inv_clk_vss|inv_mc_vss|inv_q_vss|mph_g|nand_m_vss|nand_s2_vss|s1_vss_m1|s2_vss_m1|s3_vss_m1|s4_vss_m1|sb_vss|sr1_vss|sr2_vss|sr3_vss|sr4_vss|sv_vss|tg_d_vss|tg_fbm_vss|tg_fbs_vss|tg_s_vss|vss|vss_link|vss_link_bridge|vss_link_dip|vss_link_m1|vss_x1|vss_x2|vss_x3
+ 204.625072758
* device instance g_vss_m1_inv_clk_vss_inv_mc_vss_inv_q_vss_mph_g_nand_m_vss_nand_s2_vss_s1_vss_m1_s2_vss_m1_s3_vss_m1_s4_vss_m1_sb_vss_sr1_vss_sr2_vss_sr3_vss_sr4_vss_sv_vss_tg_d_vss_tg_fbm_vss_tg_fbs_vss_tg_s_vss_vss_vss_link_vss_link_bridge_vss_link_dip_vss_link_m1_vss_x1_vss_x2_vss_x3_t43 r0 *1 0,0
Rg_vss_m1_inv_clk_vss_inv_mc_vss_inv_q_vss_mph_g_nand_m_vss_nand_s2_vss_s1_vss_m1_s2_vss_m1_s3_vss_m1_s4_vss_m1_sb_vss_sr1_vss_sr2_vss_sr3_vss_sr4_vss_sv_vss_tg_d_vss_tg_fbm_vss_tg_fbs_vss_tg_s_vss_vss_vss_link_vss_link_bridge_vss_link_dip_vss_link_m1_vss_x1_vss_x2_vss_x3_t43
+ g_vss_m1\x7cinv_clk_vss\x7cinv_mc_vss\x7cinv_q_vss\x7cmph_g\x7cnand_m_vss\x7cnand_s2_vss\x7cs1_vss_m1\x7cs2_vss_m1\x7cs3_vss_m1\x7cs4_vss_m1\x7csb_vss\x7csr1_vss\x7csr2_vss\x7csr3_vss\x7csr4_vss\x7csv_vss\x7ctg_d_vss\x7ctg_fbm_vss\x7ctg_fbs_vss\x7ctg_s_vss\x7cvss\x7cvss_link\x7cvss_link_bridge\x7cvss_link_dip\x7cvss_link_m1\x7cvss_x1\x7cvss_x2\x7cvss_x3__t43
+ g_vss_m1|inv_clk_vss|inv_mc_vss|inv_q_vss|mph_g|nand_m_vss|nand_s2_vss|s1_vss_m1|s2_vss_m1|s3_vss_m1|s4_vss_m1|sb_vss|sr1_vss|sr2_vss|sr3_vss|sr4_vss|sv_vss|tg_d_vss|tg_fbm_vss|tg_fbs_vss|tg_s_vss|vss|vss_link|vss_link_bridge|vss_link_dip|vss_link_m1|vss_x1|vss_x2|vss_x3
+ 172.348518182
* device instance g_vss_m1_inv_clk_vss_inv_mc_vss_inv_q_vss_mph_g_nand_m_vss_nand_s2_vss_s1_vss_m1_s2_vss_m1_s3_vss_m1_s4_vss_m1_sb_vss_sr1_vss_sr2_vss_sr3_vss_sr4_vss_sv_vss_tg_d_vss_tg_fbm_vss_tg_fbs_vss_tg_s_vss_vss_vss_link_vss_link_bridge_vss_link_dip_vss_link_m1_vss_x1_vss_x2_vss_x3_t44 r0 *1 0,0
Rg_vss_m1_inv_clk_vss_inv_mc_vss_inv_q_vss_mph_g_nand_m_vss_nand_s2_vss_s1_vss_m1_s2_vss_m1_s3_vss_m1_s4_vss_m1_sb_vss_sr1_vss_sr2_vss_sr3_vss_sr4_vss_sv_vss_tg_d_vss_tg_fbm_vss_tg_fbs_vss_tg_s_vss_vss_vss_link_vss_link_bridge_vss_link_dip_vss_link_m1_vss_x1_vss_x2_vss_x3_t44
+ g_vss_m1\x7cinv_clk_vss\x7cinv_mc_vss\x7cinv_q_vss\x7cmph_g\x7cnand_m_vss\x7cnand_s2_vss\x7cs1_vss_m1\x7cs2_vss_m1\x7cs3_vss_m1\x7cs4_vss_m1\x7csb_vss\x7csr1_vss\x7csr2_vss\x7csr3_vss\x7csr4_vss\x7csv_vss\x7ctg_d_vss\x7ctg_fbm_vss\x7ctg_fbs_vss\x7ctg_s_vss\x7cvss\x7cvss_link\x7cvss_link_bridge\x7cvss_link_dip\x7cvss_link_m1\x7cvss_x1\x7cvss_x2\x7cvss_x3__t44
+ g_vss_m1|inv_clk_vss|inv_mc_vss|inv_q_vss|mph_g|nand_m_vss|nand_s2_vss|s1_vss_m1|s2_vss_m1|s3_vss_m1|s4_vss_m1|sb_vss|sr1_vss|sr2_vss|sr3_vss|sr4_vss|sv_vss|tg_d_vss|tg_fbm_vss|tg_fbs_vss|tg_s_vss|vss|vss_link|vss_link_bridge|vss_link_dip|vss_link_m1|vss_x1|vss_x2|vss_x3
+ 139.611375776
* device instance g_vss_m1_inv_clk_vss_inv_mc_vss_inv_q_vss_mph_g_nand_m_vss_nand_s2_vss_s1_vss_m1_s2_vss_m1_s3_vss_m1_s4_vss_m1_sb_vss_sr1_vss_sr2_vss_sr3_vss_sr4_vss_sv_vss_tg_d_vss_tg_fbm_vss_tg_fbs_vss_tg_s_vss_vss_vss_link_vss_link_bridge_vss_link_dip_vss_link_m1_vss_x1_vss_x2_vss_x3_t45 r0 *1 0,0
Rg_vss_m1_inv_clk_vss_inv_mc_vss_inv_q_vss_mph_g_nand_m_vss_nand_s2_vss_s1_vss_m1_s2_vss_m1_s3_vss_m1_s4_vss_m1_sb_vss_sr1_vss_sr2_vss_sr3_vss_sr4_vss_sv_vss_tg_d_vss_tg_fbm_vss_tg_fbs_vss_tg_s_vss_vss_vss_link_vss_link_bridge_vss_link_dip_vss_link_m1_vss_x1_vss_x2_vss_x3_t45
+ g_vss_m1\x7cinv_clk_vss\x7cinv_mc_vss\x7cinv_q_vss\x7cmph_g\x7cnand_m_vss\x7cnand_s2_vss\x7cs1_vss_m1\x7cs2_vss_m1\x7cs3_vss_m1\x7cs4_vss_m1\x7csb_vss\x7csr1_vss\x7csr2_vss\x7csr3_vss\x7csr4_vss\x7csv_vss\x7ctg_d_vss\x7ctg_fbm_vss\x7ctg_fbs_vss\x7ctg_s_vss\x7cvss\x7cvss_link\x7cvss_link_bridge\x7cvss_link_dip\x7cvss_link_m1\x7cvss_x1\x7cvss_x2\x7cvss_x3__t45
+ g_vss_m1|inv_clk_vss|inv_mc_vss|inv_q_vss|mph_g|nand_m_vss|nand_s2_vss|s1_vss_m1|s2_vss_m1|s3_vss_m1|s4_vss_m1|sb_vss|sr1_vss|sr2_vss|sr3_vss|sr4_vss|sv_vss|tg_d_vss|tg_fbm_vss|tg_fbs_vss|tg_s_vss|vss|vss_link|vss_link_bridge|vss_link_dip|vss_link_m1|vss_x1|vss_x2|vss_x3
+ 112.016419837
* device instance g_vss_m1_inv_clk_vss_inv_mc_vss_inv_q_vss_mph_g_nand_m_vss_nand_s2_vss_s1_vss_m1_s2_vss_m1_s3_vss_m1_s4_vss_m1_sb_vss_sr1_vss_sr2_vss_sr3_vss_sr4_vss_sv_vss_tg_d_vss_tg_fbm_vss_tg_fbs_vss_tg_s_vss_vss_vss_link_vss_link_bridge_vss_link_dip_vss_link_m1_vss_x1_vss_x2_vss_x3_t46 r0 *1 0,0
Rg_vss_m1_inv_clk_vss_inv_mc_vss_inv_q_vss_mph_g_nand_m_vss_nand_s2_vss_s1_vss_m1_s2_vss_m1_s3_vss_m1_s4_vss_m1_sb_vss_sr1_vss_sr2_vss_sr3_vss_sr4_vss_sv_vss_tg_d_vss_tg_fbm_vss_tg_fbs_vss_tg_s_vss_vss_vss_link_vss_link_bridge_vss_link_dip_vss_link_m1_vss_x1_vss_x2_vss_x3_t46
+ g_vss_m1\x7cinv_clk_vss\x7cinv_mc_vss\x7cinv_q_vss\x7cmph_g\x7cnand_m_vss\x7cnand_s2_vss\x7cs1_vss_m1\x7cs2_vss_m1\x7cs3_vss_m1\x7cs4_vss_m1\x7csb_vss\x7csr1_vss\x7csr2_vss\x7csr3_vss\x7csr4_vss\x7csv_vss\x7ctg_d_vss\x7ctg_fbm_vss\x7ctg_fbs_vss\x7ctg_s_vss\x7cvss\x7cvss_link\x7cvss_link_bridge\x7cvss_link_dip\x7cvss_link_m1\x7cvss_x1\x7cvss_x2\x7cvss_x3__t46
+ g_vss_m1|inv_clk_vss|inv_mc_vss|inv_q_vss|mph_g|nand_m_vss|nand_s2_vss|s1_vss_m1|s2_vss_m1|s3_vss_m1|s4_vss_m1|sb_vss|sr1_vss|sr2_vss|sr3_vss|sr4_vss|sv_vss|tg_d_vss|tg_fbm_vss|tg_fbs_vss|tg_s_vss|vss|vss_link|vss_link_bridge|vss_link_dip|vss_link_m1|vss_x1|vss_x2|vss_x3
+ 156.588296422
* device instance g_vss_m1_inv_clk_vss_inv_mc_vss_inv_q_vss_mph_g_nand_m_vss_nand_s2_vss_s1_vss_m1_s2_vss_m1_s3_vss_m1_s4_vss_m1_sb_vss_sr1_vss_sr2_vss_sr3_vss_sr4_vss_sv_vss_tg_d_vss_tg_fbm_vss_tg_fbs_vss_tg_s_vss_vss_vss_link_vss_link_bridge_vss_link_dip_vss_link_m1_vss_x1_vss_x2_vss_x3_t47 r0 *1 0,0
Rg_vss_m1_inv_clk_vss_inv_mc_vss_inv_q_vss_mph_g_nand_m_vss_nand_s2_vss_s1_vss_m1_s2_vss_m1_s3_vss_m1_s4_vss_m1_sb_vss_sr1_vss_sr2_vss_sr3_vss_sr4_vss_sv_vss_tg_d_vss_tg_fbm_vss_tg_fbs_vss_tg_s_vss_vss_vss_link_vss_link_bridge_vss_link_dip_vss_link_m1_vss_x1_vss_x2_vss_x3_t47
+ g_vss_m1\x7cinv_clk_vss\x7cinv_mc_vss\x7cinv_q_vss\x7cmph_g\x7cnand_m_vss\x7cnand_s2_vss\x7cs1_vss_m1\x7cs2_vss_m1\x7cs3_vss_m1\x7cs4_vss_m1\x7csb_vss\x7csr1_vss\x7csr2_vss\x7csr3_vss\x7csr4_vss\x7csv_vss\x7ctg_d_vss\x7ctg_fbm_vss\x7ctg_fbs_vss\x7ctg_s_vss\x7cvss\x7cvss_link\x7cvss_link_bridge\x7cvss_link_dip\x7cvss_link_m1\x7cvss_x1\x7cvss_x2\x7cvss_x3__t47
+ g_vss_m1|inv_clk_vss|inv_mc_vss|inv_q_vss|mph_g|nand_m_vss|nand_s2_vss|s1_vss_m1|s2_vss_m1|s3_vss_m1|s4_vss_m1|sb_vss|sr1_vss|sr2_vss|sr3_vss|sr4_vss|sv_vss|tg_d_vss|tg_fbm_vss|tg_fbs_vss|tg_s_vss|vss|vss_link|vss_link_bridge|vss_link_dip|vss_link_m1|vss_x1|vss_x2|vss_x3
+ 232.659390096
* device instance g_vss_m1_inv_clk_vss_inv_mc_vss_inv_q_vss_mph_g_nand_m_vss_nand_s2_vss_s1_vss_m1_s2_vss_m1_s3_vss_m1_s4_vss_m1_sb_vss_sr1_vss_sr2_vss_sr3_vss_sr4_vss_sv_vss_tg_d_vss_tg_fbm_vss_tg_fbs_vss_tg_s_vss_vss_vss_link_vss_link_bridge_vss_link_dip_vss_link_m1_vss_x1_vss_x2_vss_x3_t48 r0 *1 0,0
Rg_vss_m1_inv_clk_vss_inv_mc_vss_inv_q_vss_mph_g_nand_m_vss_nand_s2_vss_s1_vss_m1_s2_vss_m1_s3_vss_m1_s4_vss_m1_sb_vss_sr1_vss_sr2_vss_sr3_vss_sr4_vss_sv_vss_tg_d_vss_tg_fbm_vss_tg_fbs_vss_tg_s_vss_vss_vss_link_vss_link_bridge_vss_link_dip_vss_link_m1_vss_x1_vss_x2_vss_x3_t48
+ g_vss_m1\x7cinv_clk_vss\x7cinv_mc_vss\x7cinv_q_vss\x7cmph_g\x7cnand_m_vss\x7cnand_s2_vss\x7cs1_vss_m1\x7cs2_vss_m1\x7cs3_vss_m1\x7cs4_vss_m1\x7csb_vss\x7csr1_vss\x7csr2_vss\x7csr3_vss\x7csr4_vss\x7csv_vss\x7ctg_d_vss\x7ctg_fbm_vss\x7ctg_fbs_vss\x7ctg_s_vss\x7cvss\x7cvss_link\x7cvss_link_bridge\x7cvss_link_dip\x7cvss_link_m1\x7cvss_x1\x7cvss_x2\x7cvss_x3__t48
+ g_vss_m1|inv_clk_vss|inv_mc_vss|inv_q_vss|mph_g|nand_m_vss|nand_s2_vss|s1_vss_m1|s2_vss_m1|s3_vss_m1|s4_vss_m1|sb_vss|sr1_vss|sr2_vss|sr3_vss|sr4_vss|sv_vss|tg_d_vss|tg_fbm_vss|tg_fbs_vss|tg_s_vss|vss|vss_link|vss_link_bridge|vss_link_dip|vss_link_m1|vss_x1|vss_x2|vss_x3
+ 265.700492017
* device instance g_vss_m1_inv_clk_vss_inv_mc_vss_inv_q_vss_mph_g_nand_m_vss_nand_s2_vss_s1_vss_m1_s2_vss_m1_s3_vss_m1_s4_vss_m1_sb_vss_sr1_vss_sr2_vss_sr3_vss_sr4_vss_sv_vss_tg_d_vss_tg_fbm_vss_tg_fbs_vss_tg_s_vss_vss_vss_link_vss_link_bridge_vss_link_dip_vss_link_m1_vss_x1_vss_x2_vss_x3_t49 r0 *1 0,0
Rg_vss_m1_inv_clk_vss_inv_mc_vss_inv_q_vss_mph_g_nand_m_vss_nand_s2_vss_s1_vss_m1_s2_vss_m1_s3_vss_m1_s4_vss_m1_sb_vss_sr1_vss_sr2_vss_sr3_vss_sr4_vss_sv_vss_tg_d_vss_tg_fbm_vss_tg_fbs_vss_tg_s_vss_vss_vss_link_vss_link_bridge_vss_link_dip_vss_link_m1_vss_x1_vss_x2_vss_x3_t49
+ g_vss_m1\x7cinv_clk_vss\x7cinv_mc_vss\x7cinv_q_vss\x7cmph_g\x7cnand_m_vss\x7cnand_s2_vss\x7cs1_vss_m1\x7cs2_vss_m1\x7cs3_vss_m1\x7cs4_vss_m1\x7csb_vss\x7csr1_vss\x7csr2_vss\x7csr3_vss\x7csr4_vss\x7csv_vss\x7ctg_d_vss\x7ctg_fbm_vss\x7ctg_fbs_vss\x7ctg_s_vss\x7cvss\x7cvss_link\x7cvss_link_bridge\x7cvss_link_dip\x7cvss_link_m1\x7cvss_x1\x7cvss_x2\x7cvss_x3__t49
+ g_vss_m1|inv_clk_vss|inv_mc_vss|inv_q_vss|mph_g|nand_m_vss|nand_s2_vss|s1_vss_m1|s2_vss_m1|s3_vss_m1|s4_vss_m1|sb_vss|sr1_vss|sr2_vss|sr3_vss|sr4_vss|sv_vss|tg_d_vss|tg_fbm_vss|tg_fbs_vss|tg_s_vss|vss|vss_link|vss_link_bridge|vss_link_dip|vss_link_m1|vss_x1|vss_x2|vss_x3
+ 298.16128248
* device instance g_vss_m1_inv_clk_vss_inv_mc_vss_inv_q_vss_mph_g_nand_m_vss_nand_s2_vss_s1_vss_m1_s2_vss_m1_s3_vss_m1_s4_vss_m1_sb_vss_sr1_vss_sr2_vss_sr3_vss_sr4_vss_sv_vss_tg_d_vss_tg_fbm_vss_tg_fbs_vss_tg_s_vss_vss_vss_link_vss_link_bridge_vss_link_dip_vss_link_m1_vss_x1_vss_x2_vss_x3_t50 r0 *1 0,0
Rg_vss_m1_inv_clk_vss_inv_mc_vss_inv_q_vss_mph_g_nand_m_vss_nand_s2_vss_s1_vss_m1_s2_vss_m1_s3_vss_m1_s4_vss_m1_sb_vss_sr1_vss_sr2_vss_sr3_vss_sr4_vss_sv_vss_tg_d_vss_tg_fbm_vss_tg_fbs_vss_tg_s_vss_vss_vss_link_vss_link_bridge_vss_link_dip_vss_link_m1_vss_x1_vss_x2_vss_x3_t50
+ g_vss_m1\x7cinv_clk_vss\x7cinv_mc_vss\x7cinv_q_vss\x7cmph_g\x7cnand_m_vss\x7cnand_s2_vss\x7cs1_vss_m1\x7cs2_vss_m1\x7cs3_vss_m1\x7cs4_vss_m1\x7csb_vss\x7csr1_vss\x7csr2_vss\x7csr3_vss\x7csr4_vss\x7csv_vss\x7ctg_d_vss\x7ctg_fbm_vss\x7ctg_fbs_vss\x7ctg_s_vss\x7cvss\x7cvss_link\x7cvss_link_bridge\x7cvss_link_dip\x7cvss_link_m1\x7cvss_x1\x7cvss_x2\x7cvss_x3__t50
+ g_vss_m1|inv_clk_vss|inv_mc_vss|inv_q_vss|mph_g|nand_m_vss|nand_s2_vss|s1_vss_m1|s2_vss_m1|s3_vss_m1|s4_vss_m1|sb_vss|sr1_vss|sr2_vss|sr3_vss|sr4_vss|sv_vss|tg_d_vss|tg_fbm_vss|tg_fbs_vss|tg_s_vss|vss|vss_link|vss_link_bridge|vss_link_dip|vss_link_m1|vss_x1|vss_x2|vss_x3
+ 326.304206584
* device instance g_vss_m1_inv_clk_vss_inv_mc_vss_inv_q_vss_mph_g_nand_m_vss_nand_s2_vss_s1_vss_m1_s2_vss_m1_s3_vss_m1_s4_vss_m1_sb_vss_sr1_vss_sr2_vss_sr3_vss_sr4_vss_sv_vss_tg_d_vss_tg_fbm_vss_tg_fbs_vss_tg_s_vss_vss_vss_link_vss_link_bridge_vss_link_dip_vss_link_m1_vss_x1_vss_x2_vss_x3_t51 r0 *1 0,0
Rg_vss_m1_inv_clk_vss_inv_mc_vss_inv_q_vss_mph_g_nand_m_vss_nand_s2_vss_s1_vss_m1_s2_vss_m1_s3_vss_m1_s4_vss_m1_sb_vss_sr1_vss_sr2_vss_sr3_vss_sr4_vss_sv_vss_tg_d_vss_tg_fbm_vss_tg_fbs_vss_tg_s_vss_vss_vss_link_vss_link_bridge_vss_link_dip_vss_link_m1_vss_x1_vss_x2_vss_x3_t51
+ g_vss_m1\x7cinv_clk_vss\x7cinv_mc_vss\x7cinv_q_vss\x7cmph_g\x7cnand_m_vss\x7cnand_s2_vss\x7cs1_vss_m1\x7cs2_vss_m1\x7cs3_vss_m1\x7cs4_vss_m1\x7csb_vss\x7csr1_vss\x7csr2_vss\x7csr3_vss\x7csr4_vss\x7csv_vss\x7ctg_d_vss\x7ctg_fbm_vss\x7ctg_fbs_vss\x7ctg_s_vss\x7cvss\x7cvss_link\x7cvss_link_bridge\x7cvss_link_dip\x7cvss_link_m1\x7cvss_x1\x7cvss_x2\x7cvss_x3__t51
+ g_vss_m1|inv_clk_vss|inv_mc_vss|inv_q_vss|mph_g|nand_m_vss|nand_s2_vss|s1_vss_m1|s2_vss_m1|s3_vss_m1|s4_vss_m1|sb_vss|sr1_vss|sr2_vss|sr3_vss|sr4_vss|sv_vss|tg_d_vss|tg_fbm_vss|tg_fbs_vss|tg_s_vss|vss|vss_link|vss_link_bridge|vss_link_dip|vss_link_m1|vss_x1|vss_x2|vss_x3
+ 80.7233538813
* device instance g_vss_m1_inv_clk_vss_inv_mc_vss_inv_q_vss_mph_g_nand_m_vss_nand_s2_vss_s1_vss_m1_s2_vss_m1_s3_vss_m1_s4_vss_m1_sb_vss_sr1_vss_sr2_vss_sr3_vss_sr4_vss_sv_vss_tg_d_vss_tg_fbm_vss_tg_fbs_vss_tg_s_vss_vss_vss_link_vss_link_bridge_vss_link_dip_vss_link_m1_vss_x1_vss_x2_vss_x3_t52 r0 *1 0,0
Rg_vss_m1_inv_clk_vss_inv_mc_vss_inv_q_vss_mph_g_nand_m_vss_nand_s2_vss_s1_vss_m1_s2_vss_m1_s3_vss_m1_s4_vss_m1_sb_vss_sr1_vss_sr2_vss_sr3_vss_sr4_vss_sv_vss_tg_d_vss_tg_fbm_vss_tg_fbs_vss_tg_s_vss_vss_vss_link_vss_link_bridge_vss_link_dip_vss_link_m1_vss_x1_vss_x2_vss_x3_t52
+ g_vss_m1\x7cinv_clk_vss\x7cinv_mc_vss\x7cinv_q_vss\x7cmph_g\x7cnand_m_vss\x7cnand_s2_vss\x7cs1_vss_m1\x7cs2_vss_m1\x7cs3_vss_m1\x7cs4_vss_m1\x7csb_vss\x7csr1_vss\x7csr2_vss\x7csr3_vss\x7csr4_vss\x7csv_vss\x7ctg_d_vss\x7ctg_fbm_vss\x7ctg_fbs_vss\x7ctg_s_vss\x7cvss\x7cvss_link\x7cvss_link_bridge\x7cvss_link_dip\x7cvss_link_m1\x7cvss_x1\x7cvss_x2\x7cvss_x3__t52
+ g_vss_m1|inv_clk_vss|inv_mc_vss|inv_q_vss|mph_g|nand_m_vss|nand_s2_vss|s1_vss_m1|s2_vss_m1|s3_vss_m1|s4_vss_m1|sb_vss|sr1_vss|sr2_vss|sr3_vss|sr4_vss|sv_vss|tg_d_vss|tg_fbm_vss|tg_fbs_vss|tg_s_vss|vss|vss_link|vss_link_bridge|vss_link_dip|vss_link_m1|vss_x1|vss_x2|vss_x3
+ 175.517461623
* device instance g_vss_m1_inv_clk_vss_inv_mc_vss_inv_q_vss_mph_g_nand_m_vss_nand_s2_vss_s1_vss_m1_s2_vss_m1_s3_vss_m1_s4_vss_m1_sb_vss_sr1_vss_sr2_vss_sr3_vss_sr4_vss_sv_vss_tg_d_vss_tg_fbm_vss_tg_fbs_vss_tg_s_vss_vss_vss_link_vss_link_bridge_vss_link_dip_vss_link_m1_vss_x1_vss_x2_vss_x3_t53 r0 *1 0,0
Rg_vss_m1_inv_clk_vss_inv_mc_vss_inv_q_vss_mph_g_nand_m_vss_nand_s2_vss_s1_vss_m1_s2_vss_m1_s3_vss_m1_s4_vss_m1_sb_vss_sr1_vss_sr2_vss_sr3_vss_sr4_vss_sv_vss_tg_d_vss_tg_fbm_vss_tg_fbs_vss_tg_s_vss_vss_vss_link_vss_link_bridge_vss_link_dip_vss_link_m1_vss_x1_vss_x2_vss_x3_t53
+ g_vss_m1\x7cinv_clk_vss\x7cinv_mc_vss\x7cinv_q_vss\x7cmph_g\x7cnand_m_vss\x7cnand_s2_vss\x7cs1_vss_m1\x7cs2_vss_m1\x7cs3_vss_m1\x7cs4_vss_m1\x7csb_vss\x7csr1_vss\x7csr2_vss\x7csr3_vss\x7csr4_vss\x7csv_vss\x7ctg_d_vss\x7ctg_fbm_vss\x7ctg_fbs_vss\x7ctg_s_vss\x7cvss\x7cvss_link\x7cvss_link_bridge\x7cvss_link_dip\x7cvss_link_m1\x7cvss_x1\x7cvss_x2\x7cvss_x3__t53
+ g_vss_m1|inv_clk_vss|inv_mc_vss|inv_q_vss|mph_g|nand_m_vss|nand_s2_vss|s1_vss_m1|s2_vss_m1|s3_vss_m1|s4_vss_m1|sb_vss|sr1_vss|sr2_vss|sr3_vss|sr4_vss|sv_vss|tg_d_vss|tg_fbm_vss|tg_fbs_vss|tg_s_vss|vss|vss_link|vss_link_bridge|vss_link_dip|vss_link_m1|vss_x1|vss_x2|vss_x3
+ 147.662103706
* device instance g_vss_m1_inv_clk_vss_inv_mc_vss_inv_q_vss_mph_g_nand_m_vss_nand_s2_vss_s1_vss_m1_s2_vss_m1_s3_vss_m1_s4_vss_m1_sb_vss_sr1_vss_sr2_vss_sr3_vss_sr4_vss_sv_vss_tg_d_vss_tg_fbm_vss_tg_fbs_vss_tg_s_vss_vss_vss_link_vss_link_bridge_vss_link_dip_vss_link_m1_vss_x1_vss_x2_vss_x3_t54 r0 *1 0,0
Rg_vss_m1_inv_clk_vss_inv_mc_vss_inv_q_vss_mph_g_nand_m_vss_nand_s2_vss_s1_vss_m1_s2_vss_m1_s3_vss_m1_s4_vss_m1_sb_vss_sr1_vss_sr2_vss_sr3_vss_sr4_vss_sv_vss_tg_d_vss_tg_fbm_vss_tg_fbs_vss_tg_s_vss_vss_vss_link_vss_link_bridge_vss_link_dip_vss_link_m1_vss_x1_vss_x2_vss_x3_t54
+ g_vss_m1\x7cinv_clk_vss\x7cinv_mc_vss\x7cinv_q_vss\x7cmph_g\x7cnand_m_vss\x7cnand_s2_vss\x7cs1_vss_m1\x7cs2_vss_m1\x7cs3_vss_m1\x7cs4_vss_m1\x7csb_vss\x7csr1_vss\x7csr2_vss\x7csr3_vss\x7csr4_vss\x7csv_vss\x7ctg_d_vss\x7ctg_fbm_vss\x7ctg_fbs_vss\x7ctg_s_vss\x7cvss\x7cvss_link\x7cvss_link_bridge\x7cvss_link_dip\x7cvss_link_m1\x7cvss_x1\x7cvss_x2\x7cvss_x3__t54
+ g_vss_m1|inv_clk_vss|inv_mc_vss|inv_q_vss|mph_g|nand_m_vss|nand_s2_vss|s1_vss_m1|s2_vss_m1|s3_vss_m1|s4_vss_m1|sb_vss|sr1_vss|sr2_vss|sr3_vss|sr4_vss|sv_vss|tg_d_vss|tg_fbm_vss|tg_fbs_vss|tg_s_vss|vss|vss_link|vss_link_bridge|vss_link_dip|vss_link_m1|vss_x1|vss_x2|vss_x3
+ 115.133486829
* device instance g_vss_m1_inv_clk_vss_inv_mc_vss_inv_q_vss_mph_g_nand_m_vss_nand_s2_vss_s1_vss_m1_s2_vss_m1_s3_vss_m1_s4_vss_m1_sb_vss_sr1_vss_sr2_vss_sr3_vss_sr4_vss_sv_vss_tg_d_vss_tg_fbm_vss_tg_fbs_vss_tg_s_vss_vss_vss_link_vss_link_bridge_vss_link_dip_vss_link_m1_vss_x1_vss_x2_vss_x3_t55 r0 *1 0,0
Rg_vss_m1_inv_clk_vss_inv_mc_vss_inv_q_vss_mph_g_nand_m_vss_nand_s2_vss_s1_vss_m1_s2_vss_m1_s3_vss_m1_s4_vss_m1_sb_vss_sr1_vss_sr2_vss_sr3_vss_sr4_vss_sv_vss_tg_d_vss_tg_fbm_vss_tg_fbs_vss_tg_s_vss_vss_vss_link_vss_link_bridge_vss_link_dip_vss_link_m1_vss_x1_vss_x2_vss_x3_t55
+ g_vss_m1\x7cinv_clk_vss\x7cinv_mc_vss\x7cinv_q_vss\x7cmph_g\x7cnand_m_vss\x7cnand_s2_vss\x7cs1_vss_m1\x7cs2_vss_m1\x7cs3_vss_m1\x7cs4_vss_m1\x7csb_vss\x7csr1_vss\x7csr2_vss\x7csr3_vss\x7csr4_vss\x7csv_vss\x7ctg_d_vss\x7ctg_fbm_vss\x7ctg_fbs_vss\x7ctg_s_vss\x7cvss\x7cvss_link\x7cvss_link_bridge\x7cvss_link_dip\x7cvss_link_m1\x7cvss_x1\x7cvss_x2\x7cvss_x3__t55
+ g_vss_m1|inv_clk_vss|inv_mc_vss|inv_q_vss|mph_g|nand_m_vss|nand_s2_vss|s1_vss_m1|s2_vss_m1|s3_vss_m1|s4_vss_m1|sb_vss|sr1_vss|sr2_vss|sr3_vss|sr4_vss|sv_vss|tg_d_vss|tg_fbm_vss|tg_fbs_vss|tg_s_vss|vss|vss_link|vss_link_bridge|vss_link_dip|vss_link_m1|vss_x1|vss_x2|vss_x3
+ 33.6518941029
* device instance g_vss_m1_inv_clk_vss_inv_mc_vss_inv_q_vss_mph_g_nand_m_vss_nand_s2_vss_s1_vss_m1_s2_vss_m1_s3_vss_m1_s4_vss_m1_sb_vss_sr1_vss_sr2_vss_sr3_vss_sr4_vss_sv_vss_tg_d_vss_tg_fbm_vss_tg_fbs_vss_tg_s_vss_vss_vss_link_vss_link_bridge_vss_link_dip_vss_link_m1_vss_x1_vss_x2_vss_x3_t56 r0 *1 0,0
Rg_vss_m1_inv_clk_vss_inv_mc_vss_inv_q_vss_mph_g_nand_m_vss_nand_s2_vss_s1_vss_m1_s2_vss_m1_s3_vss_m1_s4_vss_m1_sb_vss_sr1_vss_sr2_vss_sr3_vss_sr4_vss_sv_vss_tg_d_vss_tg_fbm_vss_tg_fbs_vss_tg_s_vss_vss_vss_link_vss_link_bridge_vss_link_dip_vss_link_m1_vss_x1_vss_x2_vss_x3_t56
+ g_vss_m1\x7cinv_clk_vss\x7cinv_mc_vss\x7cinv_q_vss\x7cmph_g\x7cnand_m_vss\x7cnand_s2_vss\x7cs1_vss_m1\x7cs2_vss_m1\x7cs3_vss_m1\x7cs4_vss_m1\x7csb_vss\x7csr1_vss\x7csr2_vss\x7csr3_vss\x7csr4_vss\x7csv_vss\x7ctg_d_vss\x7ctg_fbm_vss\x7ctg_fbs_vss\x7ctg_s_vss\x7cvss\x7cvss_link\x7cvss_link_bridge\x7cvss_link_dip\x7cvss_link_m1\x7cvss_x1\x7cvss_x2\x7cvss_x3__t56
+ g_vss_m1|inv_clk_vss|inv_mc_vss|inv_q_vss|mph_g|nand_m_vss|nand_s2_vss|s1_vss_m1|s2_vss_m1|s3_vss_m1|s4_vss_m1|sb_vss|sr1_vss|sr2_vss|sr3_vss|sr4_vss|sv_vss|tg_d_vss|tg_fbm_vss|tg_fbs_vss|tg_s_vss|vss|vss_link|vss_link_bridge|vss_link_dip|vss_link_m1|vss_x1|vss_x2|vss_x3
+ 30.478256281
* device instance g_vss_m1_inv_clk_vss_inv_mc_vss_inv_q_vss_mph_g_nand_m_vss_nand_s2_vss_s1_vss_m1_s2_vss_m1_s3_vss_m1_s4_vss_m1_sb_vss_sr1_vss_sr2_vss_sr3_vss_sr4_vss_sv_vss_tg_d_vss_tg_fbm_vss_tg_fbs_vss_tg_s_vss_vss_vss_link_vss_link_bridge_vss_link_dip_vss_link_m1_vss_x1_vss_x2_vss_x3_t57 r0 *1 0,0
Rg_vss_m1_inv_clk_vss_inv_mc_vss_inv_q_vss_mph_g_nand_m_vss_nand_s2_vss_s1_vss_m1_s2_vss_m1_s3_vss_m1_s4_vss_m1_sb_vss_sr1_vss_sr2_vss_sr3_vss_sr4_vss_sv_vss_tg_d_vss_tg_fbm_vss_tg_fbs_vss_tg_s_vss_vss_vss_link_vss_link_bridge_vss_link_dip_vss_link_m1_vss_x1_vss_x2_vss_x3_t57
+ g_vss_m1\x7cinv_clk_vss\x7cinv_mc_vss\x7cinv_q_vss\x7cmph_g\x7cnand_m_vss\x7cnand_s2_vss\x7cs1_vss_m1\x7cs2_vss_m1\x7cs3_vss_m1\x7cs4_vss_m1\x7csb_vss\x7csr1_vss\x7csr2_vss\x7csr3_vss\x7csr4_vss\x7csv_vss\x7ctg_d_vss\x7ctg_fbm_vss\x7ctg_fbs_vss\x7ctg_s_vss\x7cvss\x7cvss_link\x7cvss_link_bridge\x7cvss_link_dip\x7cvss_link_m1\x7cvss_x1\x7cvss_x2\x7cvss_x3__t57
+ g_vss_m1|inv_clk_vss|inv_mc_vss|inv_q_vss|mph_g|nand_m_vss|nand_s2_vss|s1_vss_m1|s2_vss_m1|s3_vss_m1|s4_vss_m1|sb_vss|sr1_vss|sr2_vss|sr3_vss|sr4_vss|sv_vss|tg_d_vss|tg_fbm_vss|tg_fbs_vss|tg_s_vss|vss|vss_link|vss_link_bridge|vss_link_dip|vss_link_m1|vss_x1|vss_x2|vss_x3
+ 83.7565387283
* device instance g_vss_m1_inv_clk_vss_inv_mc_vss_inv_q_vss_mph_g_nand_m_vss_nand_s2_vss_s1_vss_m1_s2_vss_m1_s3_vss_m1_s4_vss_m1_sb_vss_sr1_vss_sr2_vss_sr3_vss_sr4_vss_sv_vss_tg_d_vss_tg_fbm_vss_tg_fbs_vss_tg_s_vss_vss_vss_link_vss_link_bridge_vss_link_dip_vss_link_m1_vss_x1_vss_x2_vss_x3_t58 r0 *1 0,0
Rg_vss_m1_inv_clk_vss_inv_mc_vss_inv_q_vss_mph_g_nand_m_vss_nand_s2_vss_s1_vss_m1_s2_vss_m1_s3_vss_m1_s4_vss_m1_sb_vss_sr1_vss_sr2_vss_sr3_vss_sr4_vss_sv_vss_tg_d_vss_tg_fbm_vss_tg_fbs_vss_tg_s_vss_vss_vss_link_vss_link_bridge_vss_link_dip_vss_link_m1_vss_x1_vss_x2_vss_x3_t58
+ g_vss_m1\x7cinv_clk_vss\x7cinv_mc_vss\x7cinv_q_vss\x7cmph_g\x7cnand_m_vss\x7cnand_s2_vss\x7cs1_vss_m1\x7cs2_vss_m1\x7cs3_vss_m1\x7cs4_vss_m1\x7csb_vss\x7csr1_vss\x7csr2_vss\x7csr3_vss\x7csr4_vss\x7csv_vss\x7ctg_d_vss\x7ctg_fbm_vss\x7ctg_fbs_vss\x7ctg_s_vss\x7cvss\x7cvss_link\x7cvss_link_bridge\x7cvss_link_dip\x7cvss_link_m1\x7cvss_x1\x7cvss_x2\x7cvss_x3__t58
+ g_vss_m1|inv_clk_vss|inv_mc_vss|inv_q_vss|mph_g|nand_m_vss|nand_s2_vss|s1_vss_m1|s2_vss_m1|s3_vss_m1|s4_vss_m1|sb_vss|sr1_vss|sr2_vss|sr3_vss|sr4_vss|sv_vss|tg_d_vss|tg_fbm_vss|tg_fbs_vss|tg_s_vss|vss|vss_link|vss_link_bridge|vss_link_dip|vss_link_m1|vss_x1|vss_x2|vss_x3
+ 50.5694430799
* device instance g_vss_m1_inv_clk_vss_inv_mc_vss_inv_q_vss_mph_g_nand_m_vss_nand_s2_vss_s1_vss_m1_s2_vss_m1_s3_vss_m1_s4_vss_m1_sb_vss_sr1_vss_sr2_vss_sr3_vss_sr4_vss_sv_vss_tg_d_vss_tg_fbm_vss_tg_fbs_vss_tg_s_vss_vss_vss_link_vss_link_bridge_vss_link_dip_vss_link_m1_vss_x1_vss_x2_vss_x3_t59 r0 *1 0,0
Rg_vss_m1_inv_clk_vss_inv_mc_vss_inv_q_vss_mph_g_nand_m_vss_nand_s2_vss_s1_vss_m1_s2_vss_m1_s3_vss_m1_s4_vss_m1_sb_vss_sr1_vss_sr2_vss_sr3_vss_sr4_vss_sv_vss_tg_d_vss_tg_fbm_vss_tg_fbs_vss_tg_s_vss_vss_vss_link_vss_link_bridge_vss_link_dip_vss_link_m1_vss_x1_vss_x2_vss_x3_t59
+ g_vss_m1\x7cinv_clk_vss\x7cinv_mc_vss\x7cinv_q_vss\x7cmph_g\x7cnand_m_vss\x7cnand_s2_vss\x7cs1_vss_m1\x7cs2_vss_m1\x7cs3_vss_m1\x7cs4_vss_m1\x7csb_vss\x7csr1_vss\x7csr2_vss\x7csr3_vss\x7csr4_vss\x7csv_vss\x7ctg_d_vss\x7ctg_fbm_vss\x7ctg_fbs_vss\x7ctg_s_vss\x7cvss\x7cvss_link\x7cvss_link_bridge\x7cvss_link_dip\x7cvss_link_m1\x7cvss_x1\x7cvss_x2\x7cvss_x3__t59
+ g_vss_m1|inv_clk_vss|inv_mc_vss|inv_q_vss|mph_g|nand_m_vss|nand_s2_vss|s1_vss_m1|s2_vss_m1|s3_vss_m1|s4_vss_m1|sb_vss|sr1_vss|sr2_vss|sr3_vss|sr4_vss|sv_vss|tg_d_vss|tg_fbm_vss|tg_fbs_vss|tg_s_vss|vss|vss_link|vss_link_bridge|vss_link_dip|vss_link_m1|vss_x1|vss_x2|vss_x3
+ 125.115072496
* device instance g_vss_m1_inv_clk_vss_inv_mc_vss_inv_q_vss_mph_g_nand_m_vss_nand_s2_vss_s1_vss_m1_s2_vss_m1_s3_vss_m1_s4_vss_m1_sb_vss_sr1_vss_sr2_vss_sr3_vss_sr4_vss_sv_vss_tg_d_vss_tg_fbm_vss_tg_fbs_vss_tg_s_vss_vss_vss_link_vss_link_bridge_vss_link_dip_vss_link_m1_vss_x1_vss_x2_vss_x3_t60 r0 *1 0,0
Rg_vss_m1_inv_clk_vss_inv_mc_vss_inv_q_vss_mph_g_nand_m_vss_nand_s2_vss_s1_vss_m1_s2_vss_m1_s3_vss_m1_s4_vss_m1_sb_vss_sr1_vss_sr2_vss_sr3_vss_sr4_vss_sv_vss_tg_d_vss_tg_fbm_vss_tg_fbs_vss_tg_s_vss_vss_vss_link_vss_link_bridge_vss_link_dip_vss_link_m1_vss_x1_vss_x2_vss_x3_t60
+ g_vss_m1\x7cinv_clk_vss\x7cinv_mc_vss\x7cinv_q_vss\x7cmph_g\x7cnand_m_vss\x7cnand_s2_vss\x7cs1_vss_m1\x7cs2_vss_m1\x7cs3_vss_m1\x7cs4_vss_m1\x7csb_vss\x7csr1_vss\x7csr2_vss\x7csr3_vss\x7csr4_vss\x7csv_vss\x7ctg_d_vss\x7ctg_fbm_vss\x7ctg_fbs_vss\x7ctg_s_vss\x7cvss\x7cvss_link\x7cvss_link_bridge\x7cvss_link_dip\x7cvss_link_m1\x7cvss_x1\x7cvss_x2\x7cvss_x3__t60
+ g_vss_m1|inv_clk_vss|inv_mc_vss|inv_q_vss|mph_g|nand_m_vss|nand_s2_vss|s1_vss_m1|s2_vss_m1|s3_vss_m1|s4_vss_m1|sb_vss|sr1_vss|sr2_vss|sr3_vss|sr4_vss|sv_vss|tg_d_vss|tg_fbm_vss|tg_fbs_vss|tg_s_vss|vss|vss_link|vss_link_bridge|vss_link_dip|vss_link_m1|vss_x1|vss_x2|vss_x3
+ 57.6904565913
* device instance g_vss_m1_inv_clk_vss_inv_mc_vss_inv_q_vss_mph_g_nand_m_vss_nand_s2_vss_s1_vss_m1_s2_vss_m1_s3_vss_m1_s4_vss_m1_sb_vss_sr1_vss_sr2_vss_sr3_vss_sr4_vss_sv_vss_tg_d_vss_tg_fbm_vss_tg_fbs_vss_tg_s_vss_vss_vss_link_vss_link_bridge_vss_link_dip_vss_link_m1_vss_x1_vss_x2_vss_x3_t61 r0 *1 0,0
Rg_vss_m1_inv_clk_vss_inv_mc_vss_inv_q_vss_mph_g_nand_m_vss_nand_s2_vss_s1_vss_m1_s2_vss_m1_s3_vss_m1_s4_vss_m1_sb_vss_sr1_vss_sr2_vss_sr3_vss_sr4_vss_sv_vss_tg_d_vss_tg_fbm_vss_tg_fbs_vss_tg_s_vss_vss_vss_link_vss_link_bridge_vss_link_dip_vss_link_m1_vss_x1_vss_x2_vss_x3_t61
+ g_vss_m1\x7cinv_clk_vss\x7cinv_mc_vss\x7cinv_q_vss\x7cmph_g\x7cnand_m_vss\x7cnand_s2_vss\x7cs1_vss_m1\x7cs2_vss_m1\x7cs3_vss_m1\x7cs4_vss_m1\x7csb_vss\x7csr1_vss\x7csr2_vss\x7csr3_vss\x7csr4_vss\x7csv_vss\x7ctg_d_vss\x7ctg_fbm_vss\x7ctg_fbs_vss\x7ctg_s_vss\x7cvss\x7cvss_link\x7cvss_link_bridge\x7cvss_link_dip\x7cvss_link_m1\x7cvss_x1\x7cvss_x2\x7cvss_x3__t61
+ g_vss_m1|inv_clk_vss|inv_mc_vss|inv_q_vss|mph_g|nand_m_vss|nand_s2_vss|s1_vss_m1|s2_vss_m1|s3_vss_m1|s4_vss_m1|sb_vss|sr1_vss|sr2_vss|sr3_vss|sr4_vss|sv_vss|tg_d_vss|tg_fbm_vss|tg_fbs_vss|tg_s_vss|vss|vss_link|vss_link_bridge|vss_link_dip|vss_link_m1|vss_x1|vss_x2|vss_x3
+ 32.148030812
* device instance g_vss_m1_inv_clk_vss_inv_mc_vss_inv_q_vss_mph_g_nand_m_vss_nand_s2_vss_s1_vss_m1_s2_vss_m1_s3_vss_m1_s4_vss_m1_sb_vss_sr1_vss_sr2_vss_sr3_vss_sr4_vss_sv_vss_tg_d_vss_tg_fbm_vss_tg_fbs_vss_tg_s_vss_vss_vss_link_vss_link_bridge_vss_link_dip_vss_link_m1_vss_x1_vss_x2_vss_x3_t62 r0 *1 0,0
Rg_vss_m1_inv_clk_vss_inv_mc_vss_inv_q_vss_mph_g_nand_m_vss_nand_s2_vss_s1_vss_m1_s2_vss_m1_s3_vss_m1_s4_vss_m1_sb_vss_sr1_vss_sr2_vss_sr3_vss_sr4_vss_sv_vss_tg_d_vss_tg_fbm_vss_tg_fbs_vss_tg_s_vss_vss_vss_link_vss_link_bridge_vss_link_dip_vss_link_m1_vss_x1_vss_x2_vss_x3_t62
+ g_vss_m1\x7cinv_clk_vss\x7cinv_mc_vss\x7cinv_q_vss\x7cmph_g\x7cnand_m_vss\x7cnand_s2_vss\x7cs1_vss_m1\x7cs2_vss_m1\x7cs3_vss_m1\x7cs4_vss_m1\x7csb_vss\x7csr1_vss\x7csr2_vss\x7csr3_vss\x7csr4_vss\x7csv_vss\x7ctg_d_vss\x7ctg_fbm_vss\x7ctg_fbs_vss\x7ctg_s_vss\x7cvss\x7cvss_link\x7cvss_link_bridge\x7cvss_link_dip\x7cvss_link_m1\x7cvss_x1\x7cvss_x2\x7cvss_x3__t62
+ g_vss_m1|inv_clk_vss|inv_mc_vss|inv_q_vss|mph_g|nand_m_vss|nand_s2_vss|s1_vss_m1|s2_vss_m1|s3_vss_m1|s4_vss_m1|sb_vss|sr1_vss|sr2_vss|sr3_vss|sr4_vss|sv_vss|tg_d_vss|tg_fbm_vss|tg_fbs_vss|tg_s_vss|vss|vss_link|vss_link_bridge|vss_link_dip|vss_link_m1|vss_x1|vss_x2|vss_x3
+ 111.899576935
* device instance g_vss_m1_inv_clk_vss_inv_mc_vss_inv_q_vss_mph_g_nand_m_vss_nand_s2_vss_s1_vss_m1_s2_vss_m1_s3_vss_m1_s4_vss_m1_sb_vss_sr1_vss_sr2_vss_sr3_vss_sr4_vss_sv_vss_tg_d_vss_tg_fbm_vss_tg_fbs_vss_tg_s_vss_vss_vss_link_vss_link_bridge_vss_link_dip_vss_link_m1_vss_x1_vss_x2_vss_x3_t63 r0 *1 0,0
Rg_vss_m1_inv_clk_vss_inv_mc_vss_inv_q_vss_mph_g_nand_m_vss_nand_s2_vss_s1_vss_m1_s2_vss_m1_s3_vss_m1_s4_vss_m1_sb_vss_sr1_vss_sr2_vss_sr3_vss_sr4_vss_sv_vss_tg_d_vss_tg_fbm_vss_tg_fbs_vss_tg_s_vss_vss_vss_link_vss_link_bridge_vss_link_dip_vss_link_m1_vss_x1_vss_x2_vss_x3_t63
+ g_vss_m1\x7cinv_clk_vss\x7cinv_mc_vss\x7cinv_q_vss\x7cmph_g\x7cnand_m_vss\x7cnand_s2_vss\x7cs1_vss_m1\x7cs2_vss_m1\x7cs3_vss_m1\x7cs4_vss_m1\x7csb_vss\x7csr1_vss\x7csr2_vss\x7csr3_vss\x7csr4_vss\x7csv_vss\x7ctg_d_vss\x7ctg_fbm_vss\x7ctg_fbs_vss\x7ctg_s_vss\x7cvss\x7cvss_link\x7cvss_link_bridge\x7cvss_link_dip\x7cvss_link_m1\x7cvss_x1\x7cvss_x2\x7cvss_x3__t63
+ g_vss_m1|inv_clk_vss|inv_mc_vss|inv_q_vss|mph_g|nand_m_vss|nand_s2_vss|s1_vss_m1|s2_vss_m1|s3_vss_m1|s4_vss_m1|sb_vss|sr1_vss|sr2_vss|sr3_vss|sr4_vss|sv_vss|tg_d_vss|tg_fbm_vss|tg_fbs_vss|tg_s_vss|vss|vss_link|vss_link_bridge|vss_link_dip|vss_link_m1|vss_x1|vss_x2|vss_x3
+ 84.390769607
* device instance g_vss_m1_inv_clk_vss_inv_mc_vss_inv_q_vss_mph_g_nand_m_vss_nand_s2_vss_s1_vss_m1_s2_vss_m1_s3_vss_m1_s4_vss_m1_sb_vss_sr1_vss_sr2_vss_sr3_vss_sr4_vss_sv_vss_tg_d_vss_tg_fbm_vss_tg_fbs_vss_tg_s_vss_vss_vss_link_vss_link_bridge_vss_link_dip_vss_link_m1_vss_x1_vss_x2_vss_x3_t64 r0 *1 0,0
Rg_vss_m1_inv_clk_vss_inv_mc_vss_inv_q_vss_mph_g_nand_m_vss_nand_s2_vss_s1_vss_m1_s2_vss_m1_s3_vss_m1_s4_vss_m1_sb_vss_sr1_vss_sr2_vss_sr3_vss_sr4_vss_sv_vss_tg_d_vss_tg_fbm_vss_tg_fbs_vss_tg_s_vss_vss_vss_link_vss_link_bridge_vss_link_dip_vss_link_m1_vss_x1_vss_x2_vss_x3_t64
+ g_vss_m1\x7cinv_clk_vss\x7cinv_mc_vss\x7cinv_q_vss\x7cmph_g\x7cnand_m_vss\x7cnand_s2_vss\x7cs1_vss_m1\x7cs2_vss_m1\x7cs3_vss_m1\x7cs4_vss_m1\x7csb_vss\x7csr1_vss\x7csr2_vss\x7csr3_vss\x7csr4_vss\x7csv_vss\x7ctg_d_vss\x7ctg_fbm_vss\x7ctg_fbs_vss\x7ctg_s_vss\x7cvss\x7cvss_link\x7cvss_link_bridge\x7cvss_link_dip\x7cvss_link_m1\x7cvss_x1\x7cvss_x2\x7cvss_x3__t64
+ g_vss_m1|inv_clk_vss|inv_mc_vss|inv_q_vss|mph_g|nand_m_vss|nand_s2_vss|s1_vss_m1|s2_vss_m1|s3_vss_m1|s4_vss_m1|sb_vss|sr1_vss|sr2_vss|sr3_vss|sr4_vss|sv_vss|tg_d_vss|tg_fbm_vss|tg_fbs_vss|tg_s_vss|vss|vss_link|vss_link_bridge|vss_link_dip|vss_link_m1|vss_x1|vss_x2|vss_x3
+ 205.759333351
* device instance g_vss_m1_inv_clk_vss_inv_mc_vss_inv_q_vss_mph_g_nand_m_vss_nand_s2_vss_s1_vss_m1_s2_vss_m1_s3_vss_m1_s4_vss_m1_sb_vss_sr1_vss_sr2_vss_sr3_vss_sr4_vss_sv_vss_tg_d_vss_tg_fbm_vss_tg_fbs_vss_tg_s_vss_vss_vss_link_vss_link_bridge_vss_link_dip_vss_link_m1_vss_x1_vss_x2_vss_x3_t65 r0 *1 0,0
Rg_vss_m1_inv_clk_vss_inv_mc_vss_inv_q_vss_mph_g_nand_m_vss_nand_s2_vss_s1_vss_m1_s2_vss_m1_s3_vss_m1_s4_vss_m1_sb_vss_sr1_vss_sr2_vss_sr3_vss_sr4_vss_sv_vss_tg_d_vss_tg_fbm_vss_tg_fbs_vss_tg_s_vss_vss_vss_link_vss_link_bridge_vss_link_dip_vss_link_m1_vss_x1_vss_x2_vss_x3_t65
+ g_vss_m1\x7cinv_clk_vss\x7cinv_mc_vss\x7cinv_q_vss\x7cmph_g\x7cnand_m_vss\x7cnand_s2_vss\x7cs1_vss_m1\x7cs2_vss_m1\x7cs3_vss_m1\x7cs4_vss_m1\x7csb_vss\x7csr1_vss\x7csr2_vss\x7csr3_vss\x7csr4_vss\x7csv_vss\x7ctg_d_vss\x7ctg_fbm_vss\x7ctg_fbs_vss\x7ctg_s_vss\x7cvss\x7cvss_link\x7cvss_link_bridge\x7cvss_link_dip\x7cvss_link_m1\x7cvss_x1\x7cvss_x2\x7cvss_x3__t65
+ g_vss_m1|inv_clk_vss|inv_mc_vss|inv_q_vss|mph_g|nand_m_vss|nand_s2_vss|s1_vss_m1|s2_vss_m1|s3_vss_m1|s4_vss_m1|sb_vss|sr1_vss|sr2_vss|sr3_vss|sr4_vss|sv_vss|tg_d_vss|tg_fbm_vss|tg_fbs_vss|tg_s_vss|vss|vss_link|vss_link_bridge|vss_link_dip|vss_link_m1|vss_x1|vss_x2|vss_x3
+ 175.838141382
* device instance g_vss_m1_inv_clk_vss_inv_mc_vss_inv_q_vss_mph_g_nand_m_vss_nand_s2_vss_s1_vss_m1_s2_vss_m1_s3_vss_m1_s4_vss_m1_sb_vss_sr1_vss_sr2_vss_sr3_vss_sr4_vss_sv_vss_tg_d_vss_tg_fbm_vss_tg_fbs_vss_tg_s_vss_vss_vss_link_vss_link_bridge_vss_link_dip_vss_link_m1_vss_x1_vss_x2_vss_x3_t66 r0 *1 0,0
Rg_vss_m1_inv_clk_vss_inv_mc_vss_inv_q_vss_mph_g_nand_m_vss_nand_s2_vss_s1_vss_m1_s2_vss_m1_s3_vss_m1_s4_vss_m1_sb_vss_sr1_vss_sr2_vss_sr3_vss_sr4_vss_sv_vss_tg_d_vss_tg_fbm_vss_tg_fbs_vss_tg_s_vss_vss_vss_link_vss_link_bridge_vss_link_dip_vss_link_m1_vss_x1_vss_x2_vss_x3_t66
+ g_vss_m1\x7cinv_clk_vss\x7cinv_mc_vss\x7cinv_q_vss\x7cmph_g\x7cnand_m_vss\x7cnand_s2_vss\x7cs1_vss_m1\x7cs2_vss_m1\x7cs3_vss_m1\x7cs4_vss_m1\x7csb_vss\x7csr1_vss\x7csr2_vss\x7csr3_vss\x7csr4_vss\x7csv_vss\x7ctg_d_vss\x7ctg_fbm_vss\x7ctg_fbs_vss\x7ctg_s_vss\x7cvss\x7cvss_link\x7cvss_link_bridge\x7cvss_link_dip\x7cvss_link_m1\x7cvss_x1\x7cvss_x2\x7cvss_x3__t66
+ g_vss_m1|inv_clk_vss|inv_mc_vss|inv_q_vss|mph_g|nand_m_vss|nand_s2_vss|s1_vss_m1|s2_vss_m1|s3_vss_m1|s4_vss_m1|sb_vss|sr1_vss|sr2_vss|sr3_vss|sr4_vss|sv_vss|tg_d_vss|tg_fbm_vss|tg_fbs_vss|tg_s_vss|vss|vss_link|vss_link_bridge|vss_link_dip|vss_link_m1|vss_x1|vss_x2|vss_x3
+ 63.9360699992
* device instance g_vss_m1_inv_clk_vss_inv_mc_vss_inv_q_vss_mph_g_nand_m_vss_nand_s2_vss_s1_vss_m1_s2_vss_m1_s3_vss_m1_s4_vss_m1_sb_vss_sr1_vss_sr2_vss_sr3_vss_sr4_vss_sv_vss_tg_d_vss_tg_fbm_vss_tg_fbs_vss_tg_s_vss_vss_vss_link_vss_link_bridge_vss_link_dip_vss_link_m1_vss_x1_vss_x2_vss_x3_t67 r0 *1 0,0
Rg_vss_m1_inv_clk_vss_inv_mc_vss_inv_q_vss_mph_g_nand_m_vss_nand_s2_vss_s1_vss_m1_s2_vss_m1_s3_vss_m1_s4_vss_m1_sb_vss_sr1_vss_sr2_vss_sr3_vss_sr4_vss_sv_vss_tg_d_vss_tg_fbm_vss_tg_fbs_vss_tg_s_vss_vss_vss_link_vss_link_bridge_vss_link_dip_vss_link_m1_vss_x1_vss_x2_vss_x3_t67
+ g_vss_m1\x7cinv_clk_vss\x7cinv_mc_vss\x7cinv_q_vss\x7cmph_g\x7cnand_m_vss\x7cnand_s2_vss\x7cs1_vss_m1\x7cs2_vss_m1\x7cs3_vss_m1\x7cs4_vss_m1\x7csb_vss\x7csr1_vss\x7csr2_vss\x7csr3_vss\x7csr4_vss\x7csv_vss\x7ctg_d_vss\x7ctg_fbm_vss\x7ctg_fbs_vss\x7ctg_s_vss\x7cvss\x7cvss_link\x7cvss_link_bridge\x7cvss_link_dip\x7cvss_link_m1\x7cvss_x1\x7cvss_x2\x7cvss_x3__t67
+ g_vss_m1|inv_clk_vss|inv_mc_vss|inv_q_vss|mph_g|nand_m_vss|nand_s2_vss|s1_vss_m1|s2_vss_m1|s3_vss_m1|s4_vss_m1|sb_vss|sr1_vss|sr2_vss|sr3_vss|sr4_vss|sv_vss|tg_d_vss|tg_fbm_vss|tg_fbs_vss|tg_s_vss|vss|vss_link|vss_link_bridge|vss_link_dip|vss_link_m1|vss_x1|vss_x2|vss_x3
+ 158.212072703
* device instance g_vss_m1_inv_clk_vss_inv_mc_vss_inv_q_vss_mph_g_nand_m_vss_nand_s2_vss_s1_vss_m1_s2_vss_m1_s3_vss_m1_s4_vss_m1_sb_vss_sr1_vss_sr2_vss_sr3_vss_sr4_vss_sv_vss_tg_d_vss_tg_fbm_vss_tg_fbs_vss_tg_s_vss_vss_vss_link_vss_link_bridge_vss_link_dip_vss_link_m1_vss_x1_vss_x2_vss_x3_t68 r0 *1 0,0
Rg_vss_m1_inv_clk_vss_inv_mc_vss_inv_q_vss_mph_g_nand_m_vss_nand_s2_vss_s1_vss_m1_s2_vss_m1_s3_vss_m1_s4_vss_m1_sb_vss_sr1_vss_sr2_vss_sr3_vss_sr4_vss_sv_vss_tg_d_vss_tg_fbm_vss_tg_fbs_vss_tg_s_vss_vss_vss_link_vss_link_bridge_vss_link_dip_vss_link_m1_vss_x1_vss_x2_vss_x3_t68
+ g_vss_m1\x7cinv_clk_vss\x7cinv_mc_vss\x7cinv_q_vss\x7cmph_g\x7cnand_m_vss\x7cnand_s2_vss\x7cs1_vss_m1\x7cs2_vss_m1\x7cs3_vss_m1\x7cs4_vss_m1\x7csb_vss\x7csr1_vss\x7csr2_vss\x7csr3_vss\x7csr4_vss\x7csv_vss\x7ctg_d_vss\x7ctg_fbm_vss\x7ctg_fbs_vss\x7ctg_s_vss\x7cvss\x7cvss_link\x7cvss_link_bridge\x7cvss_link_dip\x7cvss_link_m1\x7cvss_x1\x7cvss_x2\x7cvss_x3__t68
+ g_vss_m1|inv_clk_vss|inv_mc_vss|inv_q_vss|mph_g|nand_m_vss|nand_s2_vss|s1_vss_m1|s2_vss_m1|s3_vss_m1|s4_vss_m1|sb_vss|sr1_vss|sr2_vss|sr3_vss|sr4_vss|sv_vss|tg_d_vss|tg_fbm_vss|tg_fbs_vss|tg_s_vss|vss|vss_link|vss_link_bridge|vss_link_dip|vss_link_m1|vss_x1|vss_x2|vss_x3
+ 128.927412287
* device instance g_vss_m1_inv_clk_vss_inv_mc_vss_inv_q_vss_mph_g_nand_m_vss_nand_s2_vss_s1_vss_m1_s2_vss_m1_s3_vss_m1_s4_vss_m1_sb_vss_sr1_vss_sr2_vss_sr3_vss_sr4_vss_sv_vss_tg_d_vss_tg_fbm_vss_tg_fbs_vss_tg_s_vss_vss_vss_link_vss_link_bridge_vss_link_dip_vss_link_m1_vss_x1_vss_x2_vss_x3_t69 r0 *1 0,0
Rg_vss_m1_inv_clk_vss_inv_mc_vss_inv_q_vss_mph_g_nand_m_vss_nand_s2_vss_s1_vss_m1_s2_vss_m1_s3_vss_m1_s4_vss_m1_sb_vss_sr1_vss_sr2_vss_sr3_vss_sr4_vss_sv_vss_tg_d_vss_tg_fbm_vss_tg_fbs_vss_tg_s_vss_vss_vss_link_vss_link_bridge_vss_link_dip_vss_link_m1_vss_x1_vss_x2_vss_x3_t69
+ g_vss_m1\x7cinv_clk_vss\x7cinv_mc_vss\x7cinv_q_vss\x7cmph_g\x7cnand_m_vss\x7cnand_s2_vss\x7cs1_vss_m1\x7cs2_vss_m1\x7cs3_vss_m1\x7cs4_vss_m1\x7csb_vss\x7csr1_vss\x7csr2_vss\x7csr3_vss\x7csr4_vss\x7csv_vss\x7ctg_d_vss\x7ctg_fbm_vss\x7ctg_fbs_vss\x7ctg_s_vss\x7cvss\x7cvss_link\x7cvss_link_bridge\x7cvss_link_dip\x7cvss_link_m1\x7cvss_x1\x7cvss_x2\x7cvss_x3__t69
+ g_vss_m1|inv_clk_vss|inv_mc_vss|inv_q_vss|mph_g|nand_m_vss|nand_s2_vss|s1_vss_m1|s2_vss_m1|s3_vss_m1|s4_vss_m1|sb_vss|sr1_vss|sr2_vss|sr3_vss|sr4_vss|sv_vss|tg_d_vss|tg_fbm_vss|tg_fbs_vss|tg_s_vss|vss|vss_link|vss_link_bridge|vss_link_dip|vss_link_m1|vss_x1|vss_x2|vss_x3
+ 196.675205596
* device instance g_vss_m1_inv_clk_vss_inv_mc_vss_inv_q_vss_mph_g_nand_m_vss_nand_s2_vss_s1_vss_m1_s2_vss_m1_s3_vss_m1_s4_vss_m1_sb_vss_sr1_vss_sr2_vss_sr3_vss_sr4_vss_sv_vss_tg_d_vss_tg_fbm_vss_tg_fbs_vss_tg_s_vss_vss_vss_link_vss_link_bridge_vss_link_dip_vss_link_m1_vss_x1_vss_x2_vss_x3_t70 r0 *1 0,0
Rg_vss_m1_inv_clk_vss_inv_mc_vss_inv_q_vss_mph_g_nand_m_vss_nand_s2_vss_s1_vss_m1_s2_vss_m1_s3_vss_m1_s4_vss_m1_sb_vss_sr1_vss_sr2_vss_sr3_vss_sr4_vss_sv_vss_tg_d_vss_tg_fbm_vss_tg_fbs_vss_tg_s_vss_vss_vss_link_vss_link_bridge_vss_link_dip_vss_link_m1_vss_x1_vss_x2_vss_x3_t70
+ g_vss_m1\x7cinv_clk_vss\x7cinv_mc_vss\x7cinv_q_vss\x7cmph_g\x7cnand_m_vss\x7cnand_s2_vss\x7cs1_vss_m1\x7cs2_vss_m1\x7cs3_vss_m1\x7cs4_vss_m1\x7csb_vss\x7csr1_vss\x7csr2_vss\x7csr3_vss\x7csr4_vss\x7csv_vss\x7ctg_d_vss\x7ctg_fbm_vss\x7ctg_fbs_vss\x7ctg_s_vss\x7cvss\x7cvss_link\x7cvss_link_bridge\x7cvss_link_dip\x7cvss_link_m1\x7cvss_x1\x7cvss_x2\x7cvss_x3__t70
+ g_vss_m1|inv_clk_vss|inv_mc_vss|inv_q_vss|mph_g|nand_m_vss|nand_s2_vss|s1_vss_m1|s2_vss_m1|s3_vss_m1|s4_vss_m1|sb_vss|sr1_vss|sr2_vss|sr3_vss|sr4_vss|sv_vss|tg_d_vss|tg_fbm_vss|tg_fbs_vss|tg_s_vss|vss|vss_link|vss_link_bridge|vss_link_dip|vss_link_m1|vss_x1|vss_x2|vss_x3
+ 185.095413611
* device instance g_vss_m1_inv_clk_vss_inv_mc_vss_inv_q_vss_mph_g_nand_m_vss_nand_s2_vss_s1_vss_m1_s2_vss_m1_s3_vss_m1_s4_vss_m1_sb_vss_sr1_vss_sr2_vss_sr3_vss_sr4_vss_sv_vss_tg_d_vss_tg_fbm_vss_tg_fbs_vss_tg_s_vss_vss_vss_link_vss_link_bridge_vss_link_dip_vss_link_m1_vss_x1_vss_x2_vss_x3_t71 r0 *1 0,0
Rg_vss_m1_inv_clk_vss_inv_mc_vss_inv_q_vss_mph_g_nand_m_vss_nand_s2_vss_s1_vss_m1_s2_vss_m1_s3_vss_m1_s4_vss_m1_sb_vss_sr1_vss_sr2_vss_sr3_vss_sr4_vss_sv_vss_tg_d_vss_tg_fbm_vss_tg_fbs_vss_tg_s_vss_vss_vss_link_vss_link_bridge_vss_link_dip_vss_link_m1_vss_x1_vss_x2_vss_x3_t71
+ g_vss_m1\x7cinv_clk_vss\x7cinv_mc_vss\x7cinv_q_vss\x7cmph_g\x7cnand_m_vss\x7cnand_s2_vss\x7cs1_vss_m1\x7cs2_vss_m1\x7cs3_vss_m1\x7cs4_vss_m1\x7csb_vss\x7csr1_vss\x7csr2_vss\x7csr3_vss\x7csr4_vss\x7csv_vss\x7ctg_d_vss\x7ctg_fbm_vss\x7ctg_fbs_vss\x7ctg_s_vss\x7cvss\x7cvss_link\x7cvss_link_bridge\x7cvss_link_dip\x7cvss_link_m1\x7cvss_x1\x7cvss_x2\x7cvss_x3__t71
+ g_vss_m1|inv_clk_vss|inv_mc_vss|inv_q_vss|mph_g|nand_m_vss|nand_s2_vss|s1_vss_m1|s2_vss_m1|s3_vss_m1|s4_vss_m1|sb_vss|sr1_vss|sr2_vss|sr3_vss|sr4_vss|sv_vss|tg_d_vss|tg_fbm_vss|tg_fbs_vss|tg_s_vss|vss|vss_link|vss_link_bridge|vss_link_dip|vss_link_m1|vss_x1|vss_x2|vss_x3
+ 102.581737937
* device instance g_vss_m1_inv_clk_vss_inv_mc_vss_inv_q_vss_mph_g_nand_m_vss_nand_s2_vss_s1_vss_m1_s2_vss_m1_s3_vss_m1_s4_vss_m1_sb_vss_sr1_vss_sr2_vss_sr3_vss_sr4_vss_sv_vss_tg_d_vss_tg_fbm_vss_tg_fbs_vss_tg_s_vss_vss_vss_link_vss_link_bridge_vss_link_dip_vss_link_m1_vss_x1_vss_x2_vss_x3_t72 r0 *1 0,0
Rg_vss_m1_inv_clk_vss_inv_mc_vss_inv_q_vss_mph_g_nand_m_vss_nand_s2_vss_s1_vss_m1_s2_vss_m1_s3_vss_m1_s4_vss_m1_sb_vss_sr1_vss_sr2_vss_sr3_vss_sr4_vss_sv_vss_tg_d_vss_tg_fbm_vss_tg_fbs_vss_tg_s_vss_vss_vss_link_vss_link_bridge_vss_link_dip_vss_link_m1_vss_x1_vss_x2_vss_x3_t72
+ g_vss_m1\x7cinv_clk_vss\x7cinv_mc_vss\x7cinv_q_vss\x7cmph_g\x7cnand_m_vss\x7cnand_s2_vss\x7cs1_vss_m1\x7cs2_vss_m1\x7cs3_vss_m1\x7cs4_vss_m1\x7csb_vss\x7csr1_vss\x7csr2_vss\x7csr3_vss\x7csr4_vss\x7csv_vss\x7ctg_d_vss\x7ctg_fbm_vss\x7ctg_fbs_vss\x7ctg_s_vss\x7cvss\x7cvss_link\x7cvss_link_bridge\x7cvss_link_dip\x7cvss_link_m1\x7cvss_x1\x7cvss_x2\x7cvss_x3__t72
+ g_vss_m1|inv_clk_vss|inv_mc_vss|inv_q_vss|mph_g|nand_m_vss|nand_s2_vss|s1_vss_m1|s2_vss_m1|s3_vss_m1|s4_vss_m1|sb_vss|sr1_vss|sr2_vss|sr3_vss|sr4_vss|sv_vss|tg_d_vss|tg_fbm_vss|tg_fbs_vss|tg_s_vss|vss|vss_link|vss_link_bridge|vss_link_dip|vss_link_m1|vss_x1|vss_x2|vss_x3
+ 91.7607809253
* device instance g_vss_m1_inv_clk_vss_inv_mc_vss_inv_q_vss_mph_g_nand_m_vss_nand_s2_vss_s1_vss_m1_s2_vss_m1_s3_vss_m1_s4_vss_m1_sb_vss_sr1_vss_sr2_vss_sr3_vss_sr4_vss_sv_vss_tg_d_vss_tg_fbm_vss_tg_fbs_vss_tg_s_vss_vss_vss_link_vss_link_bridge_vss_link_dip_vss_link_m1_vss_x1_vss_x2_vss_x3_t73 r0 *1 0,0
Rg_vss_m1_inv_clk_vss_inv_mc_vss_inv_q_vss_mph_g_nand_m_vss_nand_s2_vss_s1_vss_m1_s2_vss_m1_s3_vss_m1_s4_vss_m1_sb_vss_sr1_vss_sr2_vss_sr3_vss_sr4_vss_sv_vss_tg_d_vss_tg_fbm_vss_tg_fbs_vss_tg_s_vss_vss_vss_link_vss_link_bridge_vss_link_dip_vss_link_m1_vss_x1_vss_x2_vss_x3_t73
+ g_vss_m1\x7cinv_clk_vss\x7cinv_mc_vss\x7cinv_q_vss\x7cmph_g\x7cnand_m_vss\x7cnand_s2_vss\x7cs1_vss_m1\x7cs2_vss_m1\x7cs3_vss_m1\x7cs4_vss_m1\x7csb_vss\x7csr1_vss\x7csr2_vss\x7csr3_vss\x7csr4_vss\x7csv_vss\x7ctg_d_vss\x7ctg_fbm_vss\x7ctg_fbs_vss\x7ctg_s_vss\x7cvss\x7cvss_link\x7cvss_link_bridge\x7cvss_link_dip\x7cvss_link_m1\x7cvss_x1\x7cvss_x2\x7cvss_x3__t73
+ g_vss_m1|inv_clk_vss|inv_mc_vss|inv_q_vss|mph_g|nand_m_vss|nand_s2_vss|s1_vss_m1|s2_vss_m1|s3_vss_m1|s4_vss_m1|sb_vss|sr1_vss|sr2_vss|sr3_vss|sr4_vss|sv_vss|tg_d_vss|tg_fbm_vss|tg_fbs_vss|tg_s_vss|vss|vss_link|vss_link_bridge|vss_link_dip|vss_link_m1|vss_x1|vss_x2|vss_x3
+ 137.630037373
* device instance g_vss_m1_inv_clk_vss_inv_mc_vss_inv_q_vss_mph_g_nand_m_vss_nand_s2_vss_s1_vss_m1_s2_vss_m1_s3_vss_m1_s4_vss_m1_sb_vss_sr1_vss_sr2_vss_sr3_vss_sr4_vss_sv_vss_tg_d_vss_tg_fbm_vss_tg_fbs_vss_tg_s_vss_vss_vss_link_vss_link_bridge_vss_link_dip_vss_link_m1_vss_x1_vss_x2_vss_x3_t74 r0 *1 0,0
Rg_vss_m1_inv_clk_vss_inv_mc_vss_inv_q_vss_mph_g_nand_m_vss_nand_s2_vss_s1_vss_m1_s2_vss_m1_s3_vss_m1_s4_vss_m1_sb_vss_sr1_vss_sr2_vss_sr3_vss_sr4_vss_sv_vss_tg_d_vss_tg_fbm_vss_tg_fbs_vss_tg_s_vss_vss_vss_link_vss_link_bridge_vss_link_dip_vss_link_m1_vss_x1_vss_x2_vss_x3_t74
+ g_vss_m1\x7cinv_clk_vss\x7cinv_mc_vss\x7cinv_q_vss\x7cmph_g\x7cnand_m_vss\x7cnand_s2_vss\x7cs1_vss_m1\x7cs2_vss_m1\x7cs3_vss_m1\x7cs4_vss_m1\x7csb_vss\x7csr1_vss\x7csr2_vss\x7csr3_vss\x7csr4_vss\x7csv_vss\x7ctg_d_vss\x7ctg_fbm_vss\x7ctg_fbs_vss\x7ctg_s_vss\x7cvss\x7cvss_link\x7cvss_link_bridge\x7cvss_link_dip\x7cvss_link_m1\x7cvss_x1\x7cvss_x2\x7cvss_x3__t74
+ g_vss_m1|inv_clk_vss|inv_mc_vss|inv_q_vss|mph_g|nand_m_vss|nand_s2_vss|s1_vss_m1|s2_vss_m1|s3_vss_m1|s4_vss_m1|sb_vss|sr1_vss|sr2_vss|sr3_vss|sr4_vss|sv_vss|tg_d_vss|tg_fbm_vss|tg_fbs_vss|tg_s_vss|vss|vss_link|vss_link_bridge|vss_link_dip|vss_link_m1|vss_x1|vss_x2|vss_x3
+ 149.00981641
* device instance g_vss_m1_inv_clk_vss_inv_mc_vss_inv_q_vss_mph_g_nand_m_vss_nand_s2_vss_s1_vss_m1_s2_vss_m1_s3_vss_m1_s4_vss_m1_sb_vss_sr1_vss_sr2_vss_sr3_vss_sr4_vss_sv_vss_tg_d_vss_tg_fbm_vss_tg_fbs_vss_tg_s_vss_vss_vss_link_vss_link_bridge_vss_link_dip_vss_link_m1_vss_x1_vss_x2_vss_x3_t75 r0 *1 0,0
Rg_vss_m1_inv_clk_vss_inv_mc_vss_inv_q_vss_mph_g_nand_m_vss_nand_s2_vss_s1_vss_m1_s2_vss_m1_s3_vss_m1_s4_vss_m1_sb_vss_sr1_vss_sr2_vss_sr3_vss_sr4_vss_sv_vss_tg_d_vss_tg_fbm_vss_tg_fbs_vss_tg_s_vss_vss_vss_link_vss_link_bridge_vss_link_dip_vss_link_m1_vss_x1_vss_x2_vss_x3_t75
+ g_vss_m1\x7cinv_clk_vss\x7cinv_mc_vss\x7cinv_q_vss\x7cmph_g\x7cnand_m_vss\x7cnand_s2_vss\x7cs1_vss_m1\x7cs2_vss_m1\x7cs3_vss_m1\x7cs4_vss_m1\x7csb_vss\x7csr1_vss\x7csr2_vss\x7csr3_vss\x7csr4_vss\x7csv_vss\x7ctg_d_vss\x7ctg_fbm_vss\x7ctg_fbs_vss\x7ctg_s_vss\x7cvss\x7cvss_link\x7cvss_link_bridge\x7cvss_link_dip\x7cvss_link_m1\x7cvss_x1\x7cvss_x2\x7cvss_x3__t75
+ g_vss_m1|inv_clk_vss|inv_mc_vss|inv_q_vss|mph_g|nand_m_vss|nand_s2_vss|s1_vss_m1|s2_vss_m1|s3_vss_m1|s4_vss_m1|sb_vss|sr1_vss|sr2_vss|sr3_vss|sr4_vss|sv_vss|tg_d_vss|tg_fbm_vss|tg_fbs_vss|tg_s_vss|vss|vss_link|vss_link_bridge|vss_link_dip|vss_link_m1|vss_x1|vss_x2|vss_x3
+ 337.475229577
* device instance g_vss_m1_inv_clk_vss_inv_mc_vss_inv_q_vss_mph_g_nand_m_vss_nand_s2_vss_s1_vss_m1_s2_vss_m1_s3_vss_m1_s4_vss_m1_sb_vss_sr1_vss_sr2_vss_sr3_vss_sr4_vss_sv_vss_tg_d_vss_tg_fbm_vss_tg_fbs_vss_tg_s_vss_vss_vss_link_vss_link_bridge_vss_link_dip_vss_link_m1_vss_x1_vss_x2_vss_x3_t76 r0 *1 0,0
Rg_vss_m1_inv_clk_vss_inv_mc_vss_inv_q_vss_mph_g_nand_m_vss_nand_s2_vss_s1_vss_m1_s2_vss_m1_s3_vss_m1_s4_vss_m1_sb_vss_sr1_vss_sr2_vss_sr3_vss_sr4_vss_sv_vss_tg_d_vss_tg_fbm_vss_tg_fbs_vss_tg_s_vss_vss_vss_link_vss_link_bridge_vss_link_dip_vss_link_m1_vss_x1_vss_x2_vss_x3_t76
+ g_vss_m1\x7cinv_clk_vss\x7cinv_mc_vss\x7cinv_q_vss\x7cmph_g\x7cnand_m_vss\x7cnand_s2_vss\x7cs1_vss_m1\x7cs2_vss_m1\x7cs3_vss_m1\x7cs4_vss_m1\x7csb_vss\x7csr1_vss\x7csr2_vss\x7csr3_vss\x7csr4_vss\x7csv_vss\x7ctg_d_vss\x7ctg_fbm_vss\x7ctg_fbs_vss\x7ctg_s_vss\x7cvss\x7cvss_link\x7cvss_link_bridge\x7cvss_link_dip\x7cvss_link_m1\x7cvss_x1\x7cvss_x2\x7cvss_x3__t76
+ g_vss_m1|inv_clk_vss|inv_mc_vss|inv_q_vss|mph_g|nand_m_vss|nand_s2_vss|s1_vss_m1|s2_vss_m1|s3_vss_m1|s4_vss_m1|sb_vss|sr1_vss|sr2_vss|sr3_vss|sr4_vss|sv_vss|tg_d_vss|tg_fbm_vss|tg_fbs_vss|tg_s_vss|vss|vss_link|vss_link_bridge|vss_link_dip|vss_link_m1|vss_x1|vss_x2|vss_x3
+ 285.502805335
* device instance g_vss_m1_inv_clk_vss_inv_mc_vss_inv_q_vss_mph_g_nand_m_vss_nand_s2_vss_s1_vss_m1_s2_vss_m1_s3_vss_m1_s4_vss_m1_sb_vss_sr1_vss_sr2_vss_sr3_vss_sr4_vss_sv_vss_tg_d_vss_tg_fbm_vss_tg_fbs_vss_tg_s_vss_vss_vss_link_vss_link_bridge_vss_link_dip_vss_link_m1_vss_x1_vss_x2_vss_x3_t77 r0 *1 0,0
Rg_vss_m1_inv_clk_vss_inv_mc_vss_inv_q_vss_mph_g_nand_m_vss_nand_s2_vss_s1_vss_m1_s2_vss_m1_s3_vss_m1_s4_vss_m1_sb_vss_sr1_vss_sr2_vss_sr3_vss_sr4_vss_sv_vss_tg_d_vss_tg_fbm_vss_tg_fbs_vss_tg_s_vss_vss_vss_link_vss_link_bridge_vss_link_dip_vss_link_m1_vss_x1_vss_x2_vss_x3_t77
+ g_vss_m1\x7cinv_clk_vss\x7cinv_mc_vss\x7cinv_q_vss\x7cmph_g\x7cnand_m_vss\x7cnand_s2_vss\x7cs1_vss_m1\x7cs2_vss_m1\x7cs3_vss_m1\x7cs4_vss_m1\x7csb_vss\x7csr1_vss\x7csr2_vss\x7csr3_vss\x7csr4_vss\x7csv_vss\x7ctg_d_vss\x7ctg_fbm_vss\x7ctg_fbs_vss\x7ctg_s_vss\x7cvss\x7cvss_link\x7cvss_link_bridge\x7cvss_link_dip\x7cvss_link_m1\x7cvss_x1\x7cvss_x2\x7cvss_x3__t77
+ g_vss_m1|inv_clk_vss|inv_mc_vss|inv_q_vss|mph_g|nand_m_vss|nand_s2_vss|s1_vss_m1|s2_vss_m1|s3_vss_m1|s4_vss_m1|sb_vss|sr1_vss|sr2_vss|sr3_vss|sr4_vss|sv_vss|tg_d_vss|tg_fbm_vss|tg_fbs_vss|tg_s_vss|vss|vss_link|vss_link_bridge|vss_link_dip|vss_link_m1|vss_x1|vss_x2|vss_x3
+ 99.7169995926
* device instance g_vss_m1_inv_clk_vss_inv_mc_vss_inv_q_vss_mph_g_nand_m_vss_nand_s2_vss_s1_vss_m1_s2_vss_m1_s3_vss_m1_s4_vss_m1_sb_vss_sr1_vss_sr2_vss_sr3_vss_sr4_vss_sv_vss_tg_d_vss_tg_fbm_vss_tg_fbs_vss_tg_s_vss_vss_vss_link_vss_link_bridge_vss_link_dip_vss_link_m1_vss_x1_vss_x2_vss_x3_t78 r0 *1 0,0
Rg_vss_m1_inv_clk_vss_inv_mc_vss_inv_q_vss_mph_g_nand_m_vss_nand_s2_vss_s1_vss_m1_s2_vss_m1_s3_vss_m1_s4_vss_m1_sb_vss_sr1_vss_sr2_vss_sr3_vss_sr4_vss_sv_vss_tg_d_vss_tg_fbm_vss_tg_fbs_vss_tg_s_vss_vss_vss_link_vss_link_bridge_vss_link_dip_vss_link_m1_vss_x1_vss_x2_vss_x3_t78
+ g_vss_m1\x7cinv_clk_vss\x7cinv_mc_vss\x7cinv_q_vss\x7cmph_g\x7cnand_m_vss\x7cnand_s2_vss\x7cs1_vss_m1\x7cs2_vss_m1\x7cs3_vss_m1\x7cs4_vss_m1\x7csb_vss\x7csr1_vss\x7csr2_vss\x7csr3_vss\x7csr4_vss\x7csv_vss\x7ctg_d_vss\x7ctg_fbm_vss\x7ctg_fbs_vss\x7ctg_s_vss\x7cvss\x7cvss_link\x7cvss_link_bridge\x7cvss_link_dip\x7cvss_link_m1\x7cvss_x1\x7cvss_x2\x7cvss_x3__t78
+ g_vss_m1|inv_clk_vss|inv_mc_vss|inv_q_vss|mph_g|nand_m_vss|nand_s2_vss|s1_vss_m1|s2_vss_m1|s3_vss_m1|s4_vss_m1|sb_vss|sr1_vss|sr2_vss|sr3_vss|sr4_vss|sv_vss|tg_d_vss|tg_fbm_vss|tg_fbs_vss|tg_s_vss|vss|vss_link|vss_link_bridge|vss_link_dip|vss_link_m1|vss_x1|vss_x2|vss_x3
+ 192.029091521
* device instance g_vss_m1_inv_clk_vss_inv_mc_vss_inv_q_vss_mph_g_nand_m_vss_nand_s2_vss_s1_vss_m1_s2_vss_m1_s3_vss_m1_s4_vss_m1_sb_vss_sr1_vss_sr2_vss_sr3_vss_sr4_vss_sv_vss_tg_d_vss_tg_fbm_vss_tg_fbs_vss_tg_s_vss_vss_vss_link_vss_link_bridge_vss_link_dip_vss_link_m1_vss_x1_vss_x2_vss_x3_t79 r0 *1 0,0
Rg_vss_m1_inv_clk_vss_inv_mc_vss_inv_q_vss_mph_g_nand_m_vss_nand_s2_vss_s1_vss_m1_s2_vss_m1_s3_vss_m1_s4_vss_m1_sb_vss_sr1_vss_sr2_vss_sr3_vss_sr4_vss_sv_vss_tg_d_vss_tg_fbm_vss_tg_fbs_vss_tg_s_vss_vss_vss_link_vss_link_bridge_vss_link_dip_vss_link_m1_vss_x1_vss_x2_vss_x3_t79
+ g_vss_m1\x7cinv_clk_vss\x7cinv_mc_vss\x7cinv_q_vss\x7cmph_g\x7cnand_m_vss\x7cnand_s2_vss\x7cs1_vss_m1\x7cs2_vss_m1\x7cs3_vss_m1\x7cs4_vss_m1\x7csb_vss\x7csr1_vss\x7csr2_vss\x7csr3_vss\x7csr4_vss\x7csv_vss\x7ctg_d_vss\x7ctg_fbm_vss\x7ctg_fbs_vss\x7ctg_s_vss\x7cvss\x7cvss_link\x7cvss_link_bridge\x7cvss_link_dip\x7cvss_link_m1\x7cvss_x1\x7cvss_x2\x7cvss_x3__t79
+ g_vss_m1|inv_clk_vss|inv_mc_vss|inv_q_vss|mph_g|nand_m_vss|nand_s2_vss|s1_vss_m1|s2_vss_m1|s3_vss_m1|s4_vss_m1|sb_vss|sr1_vss|sr2_vss|sr3_vss|sr4_vss|sv_vss|tg_d_vss|tg_fbm_vss|tg_fbs_vss|tg_s_vss|vss|vss_link|vss_link_bridge|vss_link_dip|vss_link_m1|vss_x1|vss_x2|vss_x3
+ 150.627138088
* device instance g_vss_m1_inv_clk_vss_inv_mc_vss_inv_q_vss_mph_g_nand_m_vss_nand_s2_vss_s1_vss_m1_s2_vss_m1_s3_vss_m1_s4_vss_m1_sb_vss_sr1_vss_sr2_vss_sr3_vss_sr4_vss_sv_vss_tg_d_vss_tg_fbm_vss_tg_fbs_vss_tg_s_vss_vss_vss_link_vss_link_bridge_vss_link_dip_vss_link_m1_vss_x1_vss_x2_vss_x3_t80 r0 *1 0,0
Rg_vss_m1_inv_clk_vss_inv_mc_vss_inv_q_vss_mph_g_nand_m_vss_nand_s2_vss_s1_vss_m1_s2_vss_m1_s3_vss_m1_s4_vss_m1_sb_vss_sr1_vss_sr2_vss_sr3_vss_sr4_vss_sv_vss_tg_d_vss_tg_fbm_vss_tg_fbs_vss_tg_s_vss_vss_vss_link_vss_link_bridge_vss_link_dip_vss_link_m1_vss_x1_vss_x2_vss_x3_t80
+ g_vss_m1\x7cinv_clk_vss\x7cinv_mc_vss\x7cinv_q_vss\x7cmph_g\x7cnand_m_vss\x7cnand_s2_vss\x7cs1_vss_m1\x7cs2_vss_m1\x7cs3_vss_m1\x7cs4_vss_m1\x7csb_vss\x7csr1_vss\x7csr2_vss\x7csr3_vss\x7csr4_vss\x7csv_vss\x7ctg_d_vss\x7ctg_fbm_vss\x7ctg_fbs_vss\x7ctg_s_vss\x7cvss\x7cvss_link\x7cvss_link_bridge\x7cvss_link_dip\x7cvss_link_m1\x7cvss_x1\x7cvss_x2\x7cvss_x3__t80
+ g_vss_m1|inv_clk_vss|inv_mc_vss|inv_q_vss|mph_g|nand_m_vss|nand_s2_vss|s1_vss_m1|s2_vss_m1|s3_vss_m1|s4_vss_m1|sb_vss|sr1_vss|sr2_vss|sr3_vss|sr4_vss|sv_vss|tg_d_vss|tg_fbm_vss|tg_fbs_vss|tg_s_vss|vss|vss_link|vss_link_bridge|vss_link_dip|vss_link_m1|vss_x1|vss_x2|vss_x3
+ 243.796100693
* device instance g_vss_m1_inv_clk_vss_inv_mc_vss_inv_q_vss_mph_g_nand_m_vss_nand_s2_vss_s1_vss_m1_s2_vss_m1_s3_vss_m1_s4_vss_m1_sb_vss_sr1_vss_sr2_vss_sr3_vss_sr4_vss_sv_vss_tg_d_vss_tg_fbm_vss_tg_fbs_vss_tg_s_vss_vss_vss_link_vss_link_bridge_vss_link_dip_vss_link_m1_vss_x1_vss_x2_vss_x3_t81 r0 *1 0,0
Rg_vss_m1_inv_clk_vss_inv_mc_vss_inv_q_vss_mph_g_nand_m_vss_nand_s2_vss_s1_vss_m1_s2_vss_m1_s3_vss_m1_s4_vss_m1_sb_vss_sr1_vss_sr2_vss_sr3_vss_sr4_vss_sv_vss_tg_d_vss_tg_fbm_vss_tg_fbs_vss_tg_s_vss_vss_vss_link_vss_link_bridge_vss_link_dip_vss_link_m1_vss_x1_vss_x2_vss_x3_t81
+ g_vss_m1\x7cinv_clk_vss\x7cinv_mc_vss\x7cinv_q_vss\x7cmph_g\x7cnand_m_vss\x7cnand_s2_vss\x7cs1_vss_m1\x7cs2_vss_m1\x7cs3_vss_m1\x7cs4_vss_m1\x7csb_vss\x7csr1_vss\x7csr2_vss\x7csr3_vss\x7csr4_vss\x7csv_vss\x7ctg_d_vss\x7ctg_fbm_vss\x7ctg_fbs_vss\x7ctg_s_vss\x7cvss\x7cvss_link\x7cvss_link_bridge\x7cvss_link_dip\x7cvss_link_m1\x7cvss_x1\x7cvss_x2\x7cvss_x3__t81
+ g_vss_m1|inv_clk_vss|inv_mc_vss|inv_q_vss|mph_g|nand_m_vss|nand_s2_vss|s1_vss_m1|s2_vss_m1|s3_vss_m1|s4_vss_m1|sb_vss|sr1_vss|sr2_vss|sr3_vss|sr4_vss|sv_vss|tg_d_vss|tg_fbm_vss|tg_fbs_vss|tg_s_vss|vss|vss_link|vss_link_bridge|vss_link_dip|vss_link_m1|vss_x1|vss_x2|vss_x3
+ 60.3781303567
* device instance g_vss_m1_inv_clk_vss_inv_mc_vss_inv_q_vss_mph_g_nand_m_vss_nand_s2_vss_s1_vss_m1_s2_vss_m1_s3_vss_m1_s4_vss_m1_sb_vss_sr1_vss_sr2_vss_sr3_vss_sr4_vss_sv_vss_tg_d_vss_tg_fbm_vss_tg_fbs_vss_tg_s_vss_vss_vss_link_vss_link_bridge_vss_link_dip_vss_link_m1_vss_x1_vss_x2_vss_x3_t82 r0 *1 0,0
Rg_vss_m1_inv_clk_vss_inv_mc_vss_inv_q_vss_mph_g_nand_m_vss_nand_s2_vss_s1_vss_m1_s2_vss_m1_s3_vss_m1_s4_vss_m1_sb_vss_sr1_vss_sr2_vss_sr3_vss_sr4_vss_sv_vss_tg_d_vss_tg_fbm_vss_tg_fbs_vss_tg_s_vss_vss_vss_link_vss_link_bridge_vss_link_dip_vss_link_m1_vss_x1_vss_x2_vss_x3_t82
+ g_vss_m1\x7cinv_clk_vss\x7cinv_mc_vss\x7cinv_q_vss\x7cmph_g\x7cnand_m_vss\x7cnand_s2_vss\x7cs1_vss_m1\x7cs2_vss_m1\x7cs3_vss_m1\x7cs4_vss_m1\x7csb_vss\x7csr1_vss\x7csr2_vss\x7csr3_vss\x7csr4_vss\x7csv_vss\x7ctg_d_vss\x7ctg_fbm_vss\x7ctg_fbs_vss\x7ctg_s_vss\x7cvss\x7cvss_link\x7cvss_link_bridge\x7cvss_link_dip\x7cvss_link_m1\x7cvss_x1\x7cvss_x2\x7cvss_x3__t82
+ g_vss_m1|inv_clk_vss|inv_mc_vss|inv_q_vss|mph_g|nand_m_vss|nand_s2_vss|s1_vss_m1|s2_vss_m1|s3_vss_m1|s4_vss_m1|sb_vss|sr1_vss|sr2_vss|sr3_vss|sr4_vss|sv_vss|tg_d_vss|tg_fbm_vss|tg_fbs_vss|tg_s_vss|vss|vss_link|vss_link_bridge|vss_link_dip|vss_link_m1|vss_x1|vss_x2|vss_x3
+ 26.7726708787
* device instance g_vss_m1_inv_clk_vss_inv_mc_vss_inv_q_vss_mph_g_nand_m_vss_nand_s2_vss_s1_vss_m1_s2_vss_m1_s3_vss_m1_s4_vss_m1_sb_vss_sr1_vss_sr2_vss_sr3_vss_sr4_vss_sv_vss_tg_d_vss_tg_fbm_vss_tg_fbs_vss_tg_s_vss_vss_vss_link_vss_link_bridge_vss_link_dip_vss_link_m1_vss_x1_vss_x2_vss_x3_t83 r0 *1 0,0
Rg_vss_m1_inv_clk_vss_inv_mc_vss_inv_q_vss_mph_g_nand_m_vss_nand_s2_vss_s1_vss_m1_s2_vss_m1_s3_vss_m1_s4_vss_m1_sb_vss_sr1_vss_sr2_vss_sr3_vss_sr4_vss_sv_vss_tg_d_vss_tg_fbm_vss_tg_fbs_vss_tg_s_vss_vss_vss_link_vss_link_bridge_vss_link_dip_vss_link_m1_vss_x1_vss_x2_vss_x3_t83
+ g_vss_m1\x7cinv_clk_vss\x7cinv_mc_vss\x7cinv_q_vss\x7cmph_g\x7cnand_m_vss\x7cnand_s2_vss\x7cs1_vss_m1\x7cs2_vss_m1\x7cs3_vss_m1\x7cs4_vss_m1\x7csb_vss\x7csr1_vss\x7csr2_vss\x7csr3_vss\x7csr4_vss\x7csv_vss\x7ctg_d_vss\x7ctg_fbm_vss\x7ctg_fbs_vss\x7ctg_s_vss\x7cvss\x7cvss_link\x7cvss_link_bridge\x7cvss_link_dip\x7cvss_link_m1\x7cvss_x1\x7cvss_x2\x7cvss_x3__t83
+ g_vss_m1|inv_clk_vss|inv_mc_vss|inv_q_vss|mph_g|nand_m_vss|nand_s2_vss|s1_vss_m1|s2_vss_m1|s3_vss_m1|s4_vss_m1|sb_vss|sr1_vss|sr2_vss|sr3_vss|sr4_vss|sv_vss|tg_d_vss|tg_fbm_vss|tg_fbs_vss|tg_s_vss|vss|vss_link|vss_link_bridge|vss_link_dip|vss_link_m1|vss_x1|vss_x2|vss_x3
+ 48.0363446049
* device instance g_vss_m1_inv_clk_vss_inv_mc_vss_inv_q_vss_mph_g_nand_m_vss_nand_s2_vss_s1_vss_m1_s2_vss_m1_s3_vss_m1_s4_vss_m1_sb_vss_sr1_vss_sr2_vss_sr3_vss_sr4_vss_sv_vss_tg_d_vss_tg_fbm_vss_tg_fbs_vss_tg_s_vss_vss_vss_link_vss_link_bridge_vss_link_dip_vss_link_m1_vss_x1_vss_x2_vss_x3_t84 r0 *1 0,0
Rg_vss_m1_inv_clk_vss_inv_mc_vss_inv_q_vss_mph_g_nand_m_vss_nand_s2_vss_s1_vss_m1_s2_vss_m1_s3_vss_m1_s4_vss_m1_sb_vss_sr1_vss_sr2_vss_sr3_vss_sr4_vss_sv_vss_tg_d_vss_tg_fbm_vss_tg_fbs_vss_tg_s_vss_vss_vss_link_vss_link_bridge_vss_link_dip_vss_link_m1_vss_x1_vss_x2_vss_x3_t84
+ g_vss_m1\x7cinv_clk_vss\x7cinv_mc_vss\x7cinv_q_vss\x7cmph_g\x7cnand_m_vss\x7cnand_s2_vss\x7cs1_vss_m1\x7cs2_vss_m1\x7cs3_vss_m1\x7cs4_vss_m1\x7csb_vss\x7csr1_vss\x7csr2_vss\x7csr3_vss\x7csr4_vss\x7csv_vss\x7ctg_d_vss\x7ctg_fbm_vss\x7ctg_fbs_vss\x7ctg_s_vss\x7cvss\x7cvss_link\x7cvss_link_bridge\x7cvss_link_dip\x7cvss_link_m1\x7cvss_x1\x7cvss_x2\x7cvss_x3__t84
+ g_vss_m1|inv_clk_vss|inv_mc_vss|inv_q_vss|mph_g|nand_m_vss|nand_s2_vss|s1_vss_m1|s2_vss_m1|s3_vss_m1|s4_vss_m1|sb_vss|sr1_vss|sr2_vss|sr3_vss|sr4_vss|sv_vss|tg_d_vss|tg_fbm_vss|tg_fbs_vss|tg_s_vss|vss|vss_link|vss_link_bridge|vss_link_dip|vss_link_m1|vss_x1|vss_x2|vss_x3
+ 136.654491553
* device instance g_vss_m1_inv_clk_vss_inv_mc_vss_inv_q_vss_mph_g_nand_m_vss_nand_s2_vss_s1_vss_m1_s2_vss_m1_s3_vss_m1_s4_vss_m1_sb_vss_sr1_vss_sr2_vss_sr3_vss_sr4_vss_sv_vss_tg_d_vss_tg_fbm_vss_tg_fbs_vss_tg_s_vss_vss_vss_link_vss_link_bridge_vss_link_dip_vss_link_m1_vss_x1_vss_x2_vss_x3_t85 r0 *1 0,0
Rg_vss_m1_inv_clk_vss_inv_mc_vss_inv_q_vss_mph_g_nand_m_vss_nand_s2_vss_s1_vss_m1_s2_vss_m1_s3_vss_m1_s4_vss_m1_sb_vss_sr1_vss_sr2_vss_sr3_vss_sr4_vss_sv_vss_tg_d_vss_tg_fbm_vss_tg_fbs_vss_tg_s_vss_vss_vss_link_vss_link_bridge_vss_link_dip_vss_link_m1_vss_x1_vss_x2_vss_x3_t85
+ g_vss_m1\x7cinv_clk_vss\x7cinv_mc_vss\x7cinv_q_vss\x7cmph_g\x7cnand_m_vss\x7cnand_s2_vss\x7cs1_vss_m1\x7cs2_vss_m1\x7cs3_vss_m1\x7cs4_vss_m1\x7csb_vss\x7csr1_vss\x7csr2_vss\x7csr3_vss\x7csr4_vss\x7csv_vss\x7ctg_d_vss\x7ctg_fbm_vss\x7ctg_fbs_vss\x7ctg_s_vss\x7cvss\x7cvss_link\x7cvss_link_bridge\x7cvss_link_dip\x7cvss_link_m1\x7cvss_x1\x7cvss_x2\x7cvss_x3__t85
+ g_vss_m1|inv_clk_vss|inv_mc_vss|inv_q_vss|mph_g|nand_m_vss|nand_s2_vss|s1_vss_m1|s2_vss_m1|s3_vss_m1|s4_vss_m1|sb_vss|sr1_vss|sr2_vss|sr3_vss|sr4_vss|sv_vss|tg_d_vss|tg_fbm_vss|tg_fbs_vss|tg_s_vss|vss|vss_link|vss_link_bridge|vss_link_dip|vss_link_m1|vss_x1|vss_x2|vss_x3
+ 95.8908738367
* device instance g_vss_m1_inv_clk_vss_inv_mc_vss_inv_q_vss_mph_g_nand_m_vss_nand_s2_vss_s1_vss_m1_s2_vss_m1_s3_vss_m1_s4_vss_m1_sb_vss_sr1_vss_sr2_vss_sr3_vss_sr4_vss_sv_vss_tg_d_vss_tg_fbm_vss_tg_fbs_vss_tg_s_vss_vss_vss_link_vss_link_bridge_vss_link_dip_vss_link_m1_vss_x1_vss_x2_vss_x3_t86 r0 *1 0,0
Rg_vss_m1_inv_clk_vss_inv_mc_vss_inv_q_vss_mph_g_nand_m_vss_nand_s2_vss_s1_vss_m1_s2_vss_m1_s3_vss_m1_s4_vss_m1_sb_vss_sr1_vss_sr2_vss_sr3_vss_sr4_vss_sv_vss_tg_d_vss_tg_fbm_vss_tg_fbs_vss_tg_s_vss_vss_vss_link_vss_link_bridge_vss_link_dip_vss_link_m1_vss_x1_vss_x2_vss_x3_t86
+ g_vss_m1\x7cinv_clk_vss\x7cinv_mc_vss\x7cinv_q_vss\x7cmph_g\x7cnand_m_vss\x7cnand_s2_vss\x7cs1_vss_m1\x7cs2_vss_m1\x7cs3_vss_m1\x7cs4_vss_m1\x7csb_vss\x7csr1_vss\x7csr2_vss\x7csr3_vss\x7csr4_vss\x7csv_vss\x7ctg_d_vss\x7ctg_fbm_vss\x7ctg_fbs_vss\x7ctg_s_vss\x7cvss\x7cvss_link\x7cvss_link_bridge\x7cvss_link_dip\x7cvss_link_m1\x7cvss_x1\x7cvss_x2\x7cvss_x3__t86
+ g_vss_m1|inv_clk_vss|inv_mc_vss|inv_q_vss|mph_g|nand_m_vss|nand_s2_vss|s1_vss_m1|s2_vss_m1|s3_vss_m1|s4_vss_m1|sb_vss|sr1_vss|sr2_vss|sr3_vss|sr4_vss|sv_vss|tg_d_vss|tg_fbm_vss|tg_fbs_vss|tg_s_vss|vss|vss_link|vss_link_bridge|vss_link_dip|vss_link_m1|vss_x1|vss_x2|vss_x3
+ 188.091284607
* device instance g_vss_m1_inv_clk_vss_inv_mc_vss_inv_q_vss_mph_g_nand_m_vss_nand_s2_vss_s1_vss_m1_s2_vss_m1_s3_vss_m1_s4_vss_m1_sb_vss_sr1_vss_sr2_vss_sr3_vss_sr4_vss_sv_vss_tg_d_vss_tg_fbm_vss_tg_fbs_vss_tg_s_vss_vss_vss_link_vss_link_bridge_vss_link_dip_vss_link_m1_vss_x1_vss_x2_vss_x3_t87 r0 *1 0,0
Rg_vss_m1_inv_clk_vss_inv_mc_vss_inv_q_vss_mph_g_nand_m_vss_nand_s2_vss_s1_vss_m1_s2_vss_m1_s3_vss_m1_s4_vss_m1_sb_vss_sr1_vss_sr2_vss_sr3_vss_sr4_vss_sv_vss_tg_d_vss_tg_fbm_vss_tg_fbs_vss_tg_s_vss_vss_vss_link_vss_link_bridge_vss_link_dip_vss_link_m1_vss_x1_vss_x2_vss_x3_t87
+ g_vss_m1\x7cinv_clk_vss\x7cinv_mc_vss\x7cinv_q_vss\x7cmph_g\x7cnand_m_vss\x7cnand_s2_vss\x7cs1_vss_m1\x7cs2_vss_m1\x7cs3_vss_m1\x7cs4_vss_m1\x7csb_vss\x7csr1_vss\x7csr2_vss\x7csr3_vss\x7csr4_vss\x7csv_vss\x7ctg_d_vss\x7ctg_fbm_vss\x7ctg_fbs_vss\x7ctg_s_vss\x7cvss\x7cvss_link\x7cvss_link_bridge\x7cvss_link_dip\x7cvss_link_m1\x7cvss_x1\x7cvss_x2\x7cvss_x3__t87
+ g_vss_m1|inv_clk_vss|inv_mc_vss|inv_q_vss|mph_g|nand_m_vss|nand_s2_vss|s1_vss_m1|s2_vss_m1|s3_vss_m1|s4_vss_m1|sb_vss|sr1_vss|sr2_vss|sr3_vss|sr4_vss|sv_vss|tg_d_vss|tg_fbm_vss|tg_fbs_vss|tg_s_vss|vss|vss_link|vss_link_bridge|vss_link_dip|vss_link_m1|vss_x1|vss_x2|vss_x3
+ 136.654491553
* device instance g_vss_m1_inv_clk_vss_inv_mc_vss_inv_q_vss_mph_g_nand_m_vss_nand_s2_vss_s1_vss_m1_s2_vss_m1_s3_vss_m1_s4_vss_m1_sb_vss_sr1_vss_sr2_vss_sr3_vss_sr4_vss_sv_vss_tg_d_vss_tg_fbm_vss_tg_fbs_vss_tg_s_vss_vss_vss_link_vss_link_bridge_vss_link_dip_vss_link_m1_vss_x1_vss_x2_vss_x3_t88 r0 *1 0,0
Rg_vss_m1_inv_clk_vss_inv_mc_vss_inv_q_vss_mph_g_nand_m_vss_nand_s2_vss_s1_vss_m1_s2_vss_m1_s3_vss_m1_s4_vss_m1_sb_vss_sr1_vss_sr2_vss_sr3_vss_sr4_vss_sv_vss_tg_d_vss_tg_fbm_vss_tg_fbs_vss_tg_s_vss_vss_vss_link_vss_link_bridge_vss_link_dip_vss_link_m1_vss_x1_vss_x2_vss_x3_t88
+ g_vss_m1\x7cinv_clk_vss\x7cinv_mc_vss\x7cinv_q_vss\x7cmph_g\x7cnand_m_vss\x7cnand_s2_vss\x7cs1_vss_m1\x7cs2_vss_m1\x7cs3_vss_m1\x7cs4_vss_m1\x7csb_vss\x7csr1_vss\x7csr2_vss\x7csr3_vss\x7csr4_vss\x7csv_vss\x7ctg_d_vss\x7ctg_fbm_vss\x7ctg_fbs_vss\x7ctg_s_vss\x7cvss\x7cvss_link\x7cvss_link_bridge\x7cvss_link_dip\x7cvss_link_m1\x7cvss_x1\x7cvss_x2\x7cvss_x3__t88
+ g_vss_m1|inv_clk_vss|inv_mc_vss|inv_q_vss|mph_g|nand_m_vss|nand_s2_vss|s1_vss_m1|s2_vss_m1|s3_vss_m1|s4_vss_m1|sb_vss|sr1_vss|sr2_vss|sr3_vss|sr4_vss|sv_vss|tg_d_vss|tg_fbm_vss|tg_fbs_vss|tg_s_vss|vss|vss_link|vss_link_bridge|vss_link_dip|vss_link_m1|vss_x1|vss_x2|vss_x3
+ 95.8908738367
* device instance g_vss_m1_inv_clk_vss_inv_mc_vss_inv_q_vss_mph_g_nand_m_vss_nand_s2_vss_s1_vss_m1_s2_vss_m1_s3_vss_m1_s4_vss_m1_sb_vss_sr1_vss_sr2_vss_sr3_vss_sr4_vss_sv_vss_tg_d_vss_tg_fbm_vss_tg_fbs_vss_tg_s_vss_vss_vss_link_vss_link_bridge_vss_link_dip_vss_link_m1_vss_x1_vss_x2_vss_x3_t89 r0 *1 0,0
Rg_vss_m1_inv_clk_vss_inv_mc_vss_inv_q_vss_mph_g_nand_m_vss_nand_s2_vss_s1_vss_m1_s2_vss_m1_s3_vss_m1_s4_vss_m1_sb_vss_sr1_vss_sr2_vss_sr3_vss_sr4_vss_sv_vss_tg_d_vss_tg_fbm_vss_tg_fbs_vss_tg_s_vss_vss_vss_link_vss_link_bridge_vss_link_dip_vss_link_m1_vss_x1_vss_x2_vss_x3_t89
+ g_vss_m1\x7cinv_clk_vss\x7cinv_mc_vss\x7cinv_q_vss\x7cmph_g\x7cnand_m_vss\x7cnand_s2_vss\x7cs1_vss_m1\x7cs2_vss_m1\x7cs3_vss_m1\x7cs4_vss_m1\x7csb_vss\x7csr1_vss\x7csr2_vss\x7csr3_vss\x7csr4_vss\x7csv_vss\x7ctg_d_vss\x7ctg_fbm_vss\x7ctg_fbs_vss\x7ctg_s_vss\x7cvss\x7cvss_link\x7cvss_link_bridge\x7cvss_link_dip\x7cvss_link_m1\x7cvss_x1\x7cvss_x2\x7cvss_x3__t89
+ g_vss_m1|inv_clk_vss|inv_mc_vss|inv_q_vss|mph_g|nand_m_vss|nand_s2_vss|s1_vss_m1|s2_vss_m1|s3_vss_m1|s4_vss_m1|sb_vss|sr1_vss|sr2_vss|sr3_vss|sr4_vss|sv_vss|tg_d_vss|tg_fbm_vss|tg_fbs_vss|tg_s_vss|vss|vss_link|vss_link_bridge|vss_link_dip|vss_link_m1|vss_x1|vss_x2|vss_x3
+ 48.0363446049
* device instance g_vss_m1_inv_clk_vss_inv_mc_vss_inv_q_vss_mph_g_nand_m_vss_nand_s2_vss_s1_vss_m1_s2_vss_m1_s3_vss_m1_s4_vss_m1_sb_vss_sr1_vss_sr2_vss_sr3_vss_sr4_vss_sv_vss_tg_d_vss_tg_fbm_vss_tg_fbs_vss_tg_s_vss_vss_vss_link_vss_link_bridge_vss_link_dip_vss_link_m1_vss_x1_vss_x2_vss_x3_t90 r0 *1 0,0
Rg_vss_m1_inv_clk_vss_inv_mc_vss_inv_q_vss_mph_g_nand_m_vss_nand_s2_vss_s1_vss_m1_s2_vss_m1_s3_vss_m1_s4_vss_m1_sb_vss_sr1_vss_sr2_vss_sr3_vss_sr4_vss_sv_vss_tg_d_vss_tg_fbm_vss_tg_fbs_vss_tg_s_vss_vss_vss_link_vss_link_bridge_vss_link_dip_vss_link_m1_vss_x1_vss_x2_vss_x3_t90
+ g_vss_m1\x7cinv_clk_vss\x7cinv_mc_vss\x7cinv_q_vss\x7cmph_g\x7cnand_m_vss\x7cnand_s2_vss\x7cs1_vss_m1\x7cs2_vss_m1\x7cs3_vss_m1\x7cs4_vss_m1\x7csb_vss\x7csr1_vss\x7csr2_vss\x7csr3_vss\x7csr4_vss\x7csv_vss\x7ctg_d_vss\x7ctg_fbm_vss\x7ctg_fbs_vss\x7ctg_s_vss\x7cvss\x7cvss_link\x7cvss_link_bridge\x7cvss_link_dip\x7cvss_link_m1\x7cvss_x1\x7cvss_x2\x7cvss_x3__t90
+ g_vss_m1|inv_clk_vss|inv_mc_vss|inv_q_vss|mph_g|nand_m_vss|nand_s2_vss|s1_vss_m1|s2_vss_m1|s3_vss_m1|s4_vss_m1|sb_vss|sr1_vss|sr2_vss|sr3_vss|sr4_vss|sv_vss|tg_d_vss|tg_fbm_vss|tg_fbs_vss|tg_s_vss|vss|vss_link|vss_link_bridge|vss_link_dip|vss_link_m1|vss_x1|vss_x2|vss_x3
+ 26.7726708787
* device instance g_vss_m1_inv_clk_vss_inv_mc_vss_inv_q_vss_mph_g_nand_m_vss_nand_s2_vss_s1_vss_m1_s2_vss_m1_s3_vss_m1_s4_vss_m1_sb_vss_sr1_vss_sr2_vss_sr3_vss_sr4_vss_sv_vss_tg_d_vss_tg_fbm_vss_tg_fbs_vss_tg_s_vss_vss_vss_link_vss_link_bridge_vss_link_dip_vss_link_m1_vss_x1_vss_x2_vss_x3_t91 r0 *1 0,0
Rg_vss_m1_inv_clk_vss_inv_mc_vss_inv_q_vss_mph_g_nand_m_vss_nand_s2_vss_s1_vss_m1_s2_vss_m1_s3_vss_m1_s4_vss_m1_sb_vss_sr1_vss_sr2_vss_sr3_vss_sr4_vss_sv_vss_tg_d_vss_tg_fbm_vss_tg_fbs_vss_tg_s_vss_vss_vss_link_vss_link_bridge_vss_link_dip_vss_link_m1_vss_x1_vss_x2_vss_x3_t91
+ g_vss_m1\x7cinv_clk_vss\x7cinv_mc_vss\x7cinv_q_vss\x7cmph_g\x7cnand_m_vss\x7cnand_s2_vss\x7cs1_vss_m1\x7cs2_vss_m1\x7cs3_vss_m1\x7cs4_vss_m1\x7csb_vss\x7csr1_vss\x7csr2_vss\x7csr3_vss\x7csr4_vss\x7csv_vss\x7ctg_d_vss\x7ctg_fbm_vss\x7ctg_fbs_vss\x7ctg_s_vss\x7cvss\x7cvss_link\x7cvss_link_bridge\x7cvss_link_dip\x7cvss_link_m1\x7cvss_x1\x7cvss_x2\x7cvss_x3__t91
+ g_vss_m1|inv_clk_vss|inv_mc_vss|inv_q_vss|mph_g|nand_m_vss|nand_s2_vss|s1_vss_m1|s2_vss_m1|s3_vss_m1|s4_vss_m1|sb_vss|sr1_vss|sr2_vss|sr3_vss|sr4_vss|sv_vss|tg_d_vss|tg_fbm_vss|tg_fbs_vss|tg_s_vss|vss|vss_link|vss_link_bridge|vss_link_dip|vss_link_m1|vss_x1|vss_x2|vss_x3
+ 60.3781303567
* device instance g_vss_m1_inv_clk_vss_inv_mc_vss_inv_q_vss_mph_g_nand_m_vss_nand_s2_vss_s1_vss_m1_s2_vss_m1_s3_vss_m1_s4_vss_m1_sb_vss_sr1_vss_sr2_vss_sr3_vss_sr4_vss_sv_vss_tg_d_vss_tg_fbm_vss_tg_fbs_vss_tg_s_vss_vss_vss_link_vss_link_bridge_vss_link_dip_vss_link_m1_vss_x1_vss_x2_vss_x3_t92 r0 *1 0,0
Rg_vss_m1_inv_clk_vss_inv_mc_vss_inv_q_vss_mph_g_nand_m_vss_nand_s2_vss_s1_vss_m1_s2_vss_m1_s3_vss_m1_s4_vss_m1_sb_vss_sr1_vss_sr2_vss_sr3_vss_sr4_vss_sv_vss_tg_d_vss_tg_fbm_vss_tg_fbs_vss_tg_s_vss_vss_vss_link_vss_link_bridge_vss_link_dip_vss_link_m1_vss_x1_vss_x2_vss_x3_t92
+ g_vss_m1\x7cinv_clk_vss\x7cinv_mc_vss\x7cinv_q_vss\x7cmph_g\x7cnand_m_vss\x7cnand_s2_vss\x7cs1_vss_m1\x7cs2_vss_m1\x7cs3_vss_m1\x7cs4_vss_m1\x7csb_vss\x7csr1_vss\x7csr2_vss\x7csr3_vss\x7csr4_vss\x7csv_vss\x7ctg_d_vss\x7ctg_fbm_vss\x7ctg_fbs_vss\x7ctg_s_vss\x7cvss\x7cvss_link\x7cvss_link_bridge\x7cvss_link_dip\x7cvss_link_m1\x7cvss_x1\x7cvss_x2\x7cvss_x3__t92
+ g_vss_m1|inv_clk_vss|inv_mc_vss|inv_q_vss|mph_g|nand_m_vss|nand_s2_vss|s1_vss_m1|s2_vss_m1|s3_vss_m1|s4_vss_m1|sb_vss|sr1_vss|sr2_vss|sr3_vss|sr4_vss|sv_vss|tg_d_vss|tg_fbm_vss|tg_fbs_vss|tg_s_vss|vss|vss_link|vss_link_bridge|vss_link_dip|vss_link_m1|vss_x1|vss_x2|vss_x3
+ 99.7169995926
* device instance g_vss_m1_inv_clk_vss_inv_mc_vss_inv_q_vss_mph_g_nand_m_vss_nand_s2_vss_s1_vss_m1_s2_vss_m1_s3_vss_m1_s4_vss_m1_sb_vss_sr1_vss_sr2_vss_sr3_vss_sr4_vss_sv_vss_tg_d_vss_tg_fbm_vss_tg_fbs_vss_tg_s_vss_vss_vss_link_vss_link_bridge_vss_link_dip_vss_link_m1_vss_x1_vss_x2_vss_x3_t93 r0 *1 0,0
Rg_vss_m1_inv_clk_vss_inv_mc_vss_inv_q_vss_mph_g_nand_m_vss_nand_s2_vss_s1_vss_m1_s2_vss_m1_s3_vss_m1_s4_vss_m1_sb_vss_sr1_vss_sr2_vss_sr3_vss_sr4_vss_sv_vss_tg_d_vss_tg_fbm_vss_tg_fbs_vss_tg_s_vss_vss_vss_link_vss_link_bridge_vss_link_dip_vss_link_m1_vss_x1_vss_x2_vss_x3_t93
+ g_vss_m1\x7cinv_clk_vss\x7cinv_mc_vss\x7cinv_q_vss\x7cmph_g\x7cnand_m_vss\x7cnand_s2_vss\x7cs1_vss_m1\x7cs2_vss_m1\x7cs3_vss_m1\x7cs4_vss_m1\x7csb_vss\x7csr1_vss\x7csr2_vss\x7csr3_vss\x7csr4_vss\x7csv_vss\x7ctg_d_vss\x7ctg_fbm_vss\x7ctg_fbs_vss\x7ctg_s_vss\x7cvss\x7cvss_link\x7cvss_link_bridge\x7cvss_link_dip\x7cvss_link_m1\x7cvss_x1\x7cvss_x2\x7cvss_x3__t93
+ g_vss_m1|inv_clk_vss|inv_mc_vss|inv_q_vss|mph_g|nand_m_vss|nand_s2_vss|s1_vss_m1|s2_vss_m1|s3_vss_m1|s4_vss_m1|sb_vss|sr1_vss|sr2_vss|sr3_vss|sr4_vss|sv_vss|tg_d_vss|tg_fbm_vss|tg_fbs_vss|tg_s_vss|vss|vss_link|vss_link_bridge|vss_link_dip|vss_link_m1|vss_x1|vss_x2|vss_x3
+ 150.627138088
* device instance g_vss_m1_inv_clk_vss_inv_mc_vss_inv_q_vss_mph_g_nand_m_vss_nand_s2_vss_s1_vss_m1_s2_vss_m1_s3_vss_m1_s4_vss_m1_sb_vss_sr1_vss_sr2_vss_sr3_vss_sr4_vss_sv_vss_tg_d_vss_tg_fbm_vss_tg_fbs_vss_tg_s_vss_vss_vss_link_vss_link_bridge_vss_link_dip_vss_link_m1_vss_x1_vss_x2_vss_x3_t94 r0 *1 0,0
Rg_vss_m1_inv_clk_vss_inv_mc_vss_inv_q_vss_mph_g_nand_m_vss_nand_s2_vss_s1_vss_m1_s2_vss_m1_s3_vss_m1_s4_vss_m1_sb_vss_sr1_vss_sr2_vss_sr3_vss_sr4_vss_sv_vss_tg_d_vss_tg_fbm_vss_tg_fbs_vss_tg_s_vss_vss_vss_link_vss_link_bridge_vss_link_dip_vss_link_m1_vss_x1_vss_x2_vss_x3_t94
+ g_vss_m1\x7cinv_clk_vss\x7cinv_mc_vss\x7cinv_q_vss\x7cmph_g\x7cnand_m_vss\x7cnand_s2_vss\x7cs1_vss_m1\x7cs2_vss_m1\x7cs3_vss_m1\x7cs4_vss_m1\x7csb_vss\x7csr1_vss\x7csr2_vss\x7csr3_vss\x7csr4_vss\x7csv_vss\x7ctg_d_vss\x7ctg_fbm_vss\x7ctg_fbs_vss\x7ctg_s_vss\x7cvss\x7cvss_link\x7cvss_link_bridge\x7cvss_link_dip\x7cvss_link_m1\x7cvss_x1\x7cvss_x2\x7cvss_x3__t94
+ g_vss_m1|inv_clk_vss|inv_mc_vss|inv_q_vss|mph_g|nand_m_vss|nand_s2_vss|s1_vss_m1|s2_vss_m1|s3_vss_m1|s4_vss_m1|sb_vss|sr1_vss|sr2_vss|sr3_vss|sr4_vss|sv_vss|tg_d_vss|tg_fbm_vss|tg_fbs_vss|tg_s_vss|vss|vss_link|vss_link_bridge|vss_link_dip|vss_link_m1|vss_x1|vss_x2|vss_x3
+ 192.029091521
* device instance g_vss_m1_inv_clk_vss_inv_mc_vss_inv_q_vss_mph_g_nand_m_vss_nand_s2_vss_s1_vss_m1_s2_vss_m1_s3_vss_m1_s4_vss_m1_sb_vss_sr1_vss_sr2_vss_sr3_vss_sr4_vss_sv_vss_tg_d_vss_tg_fbm_vss_tg_fbs_vss_tg_s_vss_vss_vss_link_vss_link_bridge_vss_link_dip_vss_link_m1_vss_x1_vss_x2_vss_x3_t95 r0 *1 0,0
Rg_vss_m1_inv_clk_vss_inv_mc_vss_inv_q_vss_mph_g_nand_m_vss_nand_s2_vss_s1_vss_m1_s2_vss_m1_s3_vss_m1_s4_vss_m1_sb_vss_sr1_vss_sr2_vss_sr3_vss_sr4_vss_sv_vss_tg_d_vss_tg_fbm_vss_tg_fbs_vss_tg_s_vss_vss_vss_link_vss_link_bridge_vss_link_dip_vss_link_m1_vss_x1_vss_x2_vss_x3_t95
+ g_vss_m1\x7cinv_clk_vss\x7cinv_mc_vss\x7cinv_q_vss\x7cmph_g\x7cnand_m_vss\x7cnand_s2_vss\x7cs1_vss_m1\x7cs2_vss_m1\x7cs3_vss_m1\x7cs4_vss_m1\x7csb_vss\x7csr1_vss\x7csr2_vss\x7csr3_vss\x7csr4_vss\x7csv_vss\x7ctg_d_vss\x7ctg_fbm_vss\x7ctg_fbs_vss\x7ctg_s_vss\x7cvss\x7cvss_link\x7cvss_link_bridge\x7cvss_link_dip\x7cvss_link_m1\x7cvss_x1\x7cvss_x2\x7cvss_x3__t95
+ g_vss_m1|inv_clk_vss|inv_mc_vss|inv_q_vss|mph_g|nand_m_vss|nand_s2_vss|s1_vss_m1|s2_vss_m1|s3_vss_m1|s4_vss_m1|sb_vss|sr1_vss|sr2_vss|sr3_vss|sr4_vss|sv_vss|tg_d_vss|tg_fbm_vss|tg_fbs_vss|tg_s_vss|vss|vss_link|vss_link_bridge|vss_link_dip|vss_link_m1|vss_x1|vss_x2|vss_x3
+ 243.796100693
* device instance g_vss_m1_inv_clk_vss_inv_mc_vss_inv_q_vss_mph_g_nand_m_vss_nand_s2_vss_s1_vss_m1_s2_vss_m1_s3_vss_m1_s4_vss_m1_sb_vss_sr1_vss_sr2_vss_sr3_vss_sr4_vss_sv_vss_tg_d_vss_tg_fbm_vss_tg_fbs_vss_tg_s_vss_vss_vss_link_vss_link_bridge_vss_link_dip_vss_link_m1_vss_x1_vss_x2_vss_x3_t96 r0 *1 0,0
Rg_vss_m1_inv_clk_vss_inv_mc_vss_inv_q_vss_mph_g_nand_m_vss_nand_s2_vss_s1_vss_m1_s2_vss_m1_s3_vss_m1_s4_vss_m1_sb_vss_sr1_vss_sr2_vss_sr3_vss_sr4_vss_sv_vss_tg_d_vss_tg_fbm_vss_tg_fbs_vss_tg_s_vss_vss_vss_link_vss_link_bridge_vss_link_dip_vss_link_m1_vss_x1_vss_x2_vss_x3_t96
+ g_vss_m1\x7cinv_clk_vss\x7cinv_mc_vss\x7cinv_q_vss\x7cmph_g\x7cnand_m_vss\x7cnand_s2_vss\x7cs1_vss_m1\x7cs2_vss_m1\x7cs3_vss_m1\x7cs4_vss_m1\x7csb_vss\x7csr1_vss\x7csr2_vss\x7csr3_vss\x7csr4_vss\x7csv_vss\x7ctg_d_vss\x7ctg_fbm_vss\x7ctg_fbs_vss\x7ctg_s_vss\x7cvss\x7cvss_link\x7cvss_link_bridge\x7cvss_link_dip\x7cvss_link_m1\x7cvss_x1\x7cvss_x2\x7cvss_x3__t96
+ g_vss_m1|inv_clk_vss|inv_mc_vss|inv_q_vss|mph_g|nand_m_vss|nand_s2_vss|s1_vss_m1|s2_vss_m1|s3_vss_m1|s4_vss_m1|sb_vss|sr1_vss|sr2_vss|sr3_vss|sr4_vss|sv_vss|tg_d_vss|tg_fbm_vss|tg_fbs_vss|tg_s_vss|vss|vss_link|vss_link_bridge|vss_link_dip|vss_link_m1|vss_x1|vss_x2|vss_x3
+ 285.502805335
* device instance g_vss_m1_inv_clk_vss_inv_mc_vss_inv_q_vss_mph_g_nand_m_vss_nand_s2_vss_s1_vss_m1_s2_vss_m1_s3_vss_m1_s4_vss_m1_sb_vss_sr1_vss_sr2_vss_sr3_vss_sr4_vss_sv_vss_tg_d_vss_tg_fbm_vss_tg_fbs_vss_tg_s_vss_vss_vss_link_vss_link_bridge_vss_link_dip_vss_link_m1_vss_x1_vss_x2_vss_x3_t97 r0 *1 0,0
Rg_vss_m1_inv_clk_vss_inv_mc_vss_inv_q_vss_mph_g_nand_m_vss_nand_s2_vss_s1_vss_m1_s2_vss_m1_s3_vss_m1_s4_vss_m1_sb_vss_sr1_vss_sr2_vss_sr3_vss_sr4_vss_sv_vss_tg_d_vss_tg_fbm_vss_tg_fbs_vss_tg_s_vss_vss_vss_link_vss_link_bridge_vss_link_dip_vss_link_m1_vss_x1_vss_x2_vss_x3_t97
+ g_vss_m1\x7cinv_clk_vss\x7cinv_mc_vss\x7cinv_q_vss\x7cmph_g\x7cnand_m_vss\x7cnand_s2_vss\x7cs1_vss_m1\x7cs2_vss_m1\x7cs3_vss_m1\x7cs4_vss_m1\x7csb_vss\x7csr1_vss\x7csr2_vss\x7csr3_vss\x7csr4_vss\x7csv_vss\x7ctg_d_vss\x7ctg_fbm_vss\x7ctg_fbs_vss\x7ctg_s_vss\x7cvss\x7cvss_link\x7cvss_link_bridge\x7cvss_link_dip\x7cvss_link_m1\x7cvss_x1\x7cvss_x2\x7cvss_x3__t97
+ g_vss_m1|inv_clk_vss|inv_mc_vss|inv_q_vss|mph_g|nand_m_vss|nand_s2_vss|s1_vss_m1|s2_vss_m1|s3_vss_m1|s4_vss_m1|sb_vss|sr1_vss|sr2_vss|sr3_vss|sr4_vss|sv_vss|tg_d_vss|tg_fbm_vss|tg_fbs_vss|tg_s_vss|vss|vss_link|vss_link_bridge|vss_link_dip|vss_link_m1|vss_x1|vss_x2|vss_x3
+ 337.475229577
* device instance g_vss_m1_inv_clk_vss_inv_mc_vss_inv_q_vss_mph_g_nand_m_vss_nand_s2_vss_s1_vss_m1_s2_vss_m1_s3_vss_m1_s4_vss_m1_sb_vss_sr1_vss_sr2_vss_sr3_vss_sr4_vss_sv_vss_tg_d_vss_tg_fbm_vss_tg_fbs_vss_tg_s_vss_vss_vss_link_vss_link_bridge_vss_link_dip_vss_link_m1_vss_x1_vss_x2_vss_x3_t98 r0 *1 0,0
Rg_vss_m1_inv_clk_vss_inv_mc_vss_inv_q_vss_mph_g_nand_m_vss_nand_s2_vss_s1_vss_m1_s2_vss_m1_s3_vss_m1_s4_vss_m1_sb_vss_sr1_vss_sr2_vss_sr3_vss_sr4_vss_sv_vss_tg_d_vss_tg_fbm_vss_tg_fbs_vss_tg_s_vss_vss_vss_link_vss_link_bridge_vss_link_dip_vss_link_m1_vss_x1_vss_x2_vss_x3_t98
+ g_vss_m1\x7cinv_clk_vss\x7cinv_mc_vss\x7cinv_q_vss\x7cmph_g\x7cnand_m_vss\x7cnand_s2_vss\x7cs1_vss_m1\x7cs2_vss_m1\x7cs3_vss_m1\x7cs4_vss_m1\x7csb_vss\x7csr1_vss\x7csr2_vss\x7csr3_vss\x7csr4_vss\x7csv_vss\x7ctg_d_vss\x7ctg_fbm_vss\x7ctg_fbs_vss\x7ctg_s_vss\x7cvss\x7cvss_link\x7cvss_link_bridge\x7cvss_link_dip\x7cvss_link_m1\x7cvss_x1\x7cvss_x2\x7cvss_x3__t98
+ g_vss_m1|inv_clk_vss|inv_mc_vss|inv_q_vss|mph_g|nand_m_vss|nand_s2_vss|s1_vss_m1|s2_vss_m1|s3_vss_m1|s4_vss_m1|sb_vss|sr1_vss|sr2_vss|sr3_vss|sr4_vss|sv_vss|tg_d_vss|tg_fbm_vss|tg_fbs_vss|tg_s_vss|vss|vss_link|vss_link_bridge|vss_link_dip|vss_link_m1|vss_x1|vss_x2|vss_x3
+ 197.349466673
* device instance g_vss_m1_inv_clk_vss_inv_mc_vss_inv_q_vss_mph_g_nand_m_vss_nand_s2_vss_s1_vss_m1_s2_vss_m1_s3_vss_m1_s4_vss_m1_sb_vss_sr1_vss_sr2_vss_sr3_vss_sr4_vss_sv_vss_tg_d_vss_tg_fbm_vss_tg_fbs_vss_tg_s_vss_vss_vss_link_vss_link_bridge_vss_link_dip_vss_link_m1_vss_x1_vss_x2_vss_x3_t99 r0 *1 0,0
Rg_vss_m1_inv_clk_vss_inv_mc_vss_inv_q_vss_mph_g_nand_m_vss_nand_s2_vss_s1_vss_m1_s2_vss_m1_s3_vss_m1_s4_vss_m1_sb_vss_sr1_vss_sr2_vss_sr3_vss_sr4_vss_sv_vss_tg_d_vss_tg_fbm_vss_tg_fbs_vss_tg_s_vss_vss_vss_link_vss_link_bridge_vss_link_dip_vss_link_m1_vss_x1_vss_x2_vss_x3_t99
+ g_vss_m1\x7cinv_clk_vss\x7cinv_mc_vss\x7cinv_q_vss\x7cmph_g\x7cnand_m_vss\x7cnand_s2_vss\x7cs1_vss_m1\x7cs2_vss_m1\x7cs3_vss_m1\x7cs4_vss_m1\x7csb_vss\x7csr1_vss\x7csr2_vss\x7csr3_vss\x7csr4_vss\x7csv_vss\x7ctg_d_vss\x7ctg_fbm_vss\x7ctg_fbs_vss\x7ctg_s_vss\x7cvss\x7cvss_link\x7cvss_link_bridge\x7cvss_link_dip\x7cvss_link_m1\x7cvss_x1\x7cvss_x2\x7cvss_x3__t99
+ g_vss_m1|inv_clk_vss|inv_mc_vss|inv_q_vss|mph_g|nand_m_vss|nand_s2_vss|s1_vss_m1|s2_vss_m1|s3_vss_m1|s4_vss_m1|sb_vss|sr1_vss|sr2_vss|sr3_vss|sr4_vss|sv_vss|tg_d_vss|tg_fbm_vss|tg_fbs_vss|tg_s_vss|vss|vss_link|vss_link_bridge|vss_link_dip|vss_link_m1|vss_x1|vss_x2|vss_x3
+ 104.27053877
* device instance g_vss_m1_inv_clk_vss_inv_mc_vss_inv_q_vss_mph_g_nand_m_vss_nand_s2_vss_s1_vss_m1_s2_vss_m1_s3_vss_m1_s4_vss_m1_sb_vss_sr1_vss_sr2_vss_sr3_vss_sr4_vss_sv_vss_tg_d_vss_tg_fbm_vss_tg_fbs_vss_tg_s_vss_vss_vss_link_vss_link_bridge_vss_link_dip_vss_link_m1_vss_x1_vss_x2_vss_x3_t100 r0 *1 0,0
Rg_vss_m1_inv_clk_vss_inv_mc_vss_inv_q_vss_mph_g_nand_m_vss_nand_s2_vss_s1_vss_m1_s2_vss_m1_s3_vss_m1_s4_vss_m1_sb_vss_sr1_vss_sr2_vss_sr3_vss_sr4_vss_sv_vss_tg_d_vss_tg_fbm_vss_tg_fbs_vss_tg_s_vss_vss_vss_link_vss_link_bridge_vss_link_dip_vss_link_m1_vss_x1_vss_x2_vss_x3_t100
+ g_vss_m1\x7cinv_clk_vss\x7cinv_mc_vss\x7cinv_q_vss\x7cmph_g\x7cnand_m_vss\x7cnand_s2_vss\x7cs1_vss_m1\x7cs2_vss_m1\x7cs3_vss_m1\x7cs4_vss_m1\x7csb_vss\x7csr1_vss\x7csr2_vss\x7csr3_vss\x7csr4_vss\x7csv_vss\x7ctg_d_vss\x7ctg_fbm_vss\x7ctg_fbs_vss\x7ctg_s_vss\x7cvss\x7cvss_link\x7cvss_link_bridge\x7cvss_link_dip\x7cvss_link_m1\x7cvss_x1\x7cvss_x2\x7cvss_x3__t100
+ g_vss_m1|inv_clk_vss|inv_mc_vss|inv_q_vss|mph_g|nand_m_vss|nand_s2_vss|s1_vss_m1|s2_vss_m1|s3_vss_m1|s4_vss_m1|sb_vss|sr1_vss|sr2_vss|sr3_vss|sr4_vss|sv_vss|tg_d_vss|tg_fbm_vss|tg_fbs_vss|tg_s_vss|vss|vss_link|vss_link_bridge|vss_link_dip|vss_link_m1|vss_x1|vss_x2|vss_x3
+ 16.5704850208
* device instance g_vss_m1_inv_clk_vss_inv_mc_vss_inv_q_vss_mph_g_nand_m_vss_nand_s2_vss_s1_vss_m1_s2_vss_m1_s3_vss_m1_s4_vss_m1_sb_vss_sr1_vss_sr2_vss_sr3_vss_sr4_vss_sv_vss_tg_d_vss_tg_fbm_vss_tg_fbs_vss_tg_s_vss_vss_vss_link_vss_link_bridge_vss_link_dip_vss_link_m1_vss_x1_vss_x2_vss_x3_t101 r0 *1 0,0
Rg_vss_m1_inv_clk_vss_inv_mc_vss_inv_q_vss_mph_g_nand_m_vss_nand_s2_vss_s1_vss_m1_s2_vss_m1_s3_vss_m1_s4_vss_m1_sb_vss_sr1_vss_sr2_vss_sr3_vss_sr4_vss_sv_vss_tg_d_vss_tg_fbm_vss_tg_fbs_vss_tg_s_vss_vss_vss_link_vss_link_bridge_vss_link_dip_vss_link_m1_vss_x1_vss_x2_vss_x3_t101
+ g_vss_m1\x7cinv_clk_vss\x7cinv_mc_vss\x7cinv_q_vss\x7cmph_g\x7cnand_m_vss\x7cnand_s2_vss\x7cs1_vss_m1\x7cs2_vss_m1\x7cs3_vss_m1\x7cs4_vss_m1\x7csb_vss\x7csr1_vss\x7csr2_vss\x7csr3_vss\x7csr4_vss\x7csv_vss\x7ctg_d_vss\x7ctg_fbm_vss\x7ctg_fbs_vss\x7ctg_s_vss\x7cvss\x7cvss_link\x7cvss_link_bridge\x7cvss_link_dip\x7cvss_link_m1\x7cvss_x1\x7cvss_x2\x7cvss_x3__t101
+ g_vss_m1|inv_clk_vss|inv_mc_vss|inv_q_vss|mph_g|nand_m_vss|nand_s2_vss|s1_vss_m1|s2_vss_m1|s3_vss_m1|s4_vss_m1|sb_vss|sr1_vss|sr2_vss|sr3_vss|sr4_vss|sv_vss|tg_d_vss|tg_fbm_vss|tg_fbs_vss|tg_s_vss|vss|vss_link|vss_link_bridge|vss_link_dip|vss_link_m1|vss_x1|vss_x2|vss_x3
+ 84.5784792443
* device instance g_vss_m1_inv_clk_vss_inv_mc_vss_inv_q_vss_mph_g_nand_m_vss_nand_s2_vss_s1_vss_m1_s2_vss_m1_s3_vss_m1_s4_vss_m1_sb_vss_sr1_vss_sr2_vss_sr3_vss_sr4_vss_sv_vss_tg_d_vss_tg_fbm_vss_tg_fbs_vss_tg_s_vss_vss_vss_link_vss_link_bridge_vss_link_dip_vss_link_m1_vss_x1_vss_x2_vss_x3_t102 r0 *1 0,0
Rg_vss_m1_inv_clk_vss_inv_mc_vss_inv_q_vss_mph_g_nand_m_vss_nand_s2_vss_s1_vss_m1_s2_vss_m1_s3_vss_m1_s4_vss_m1_sb_vss_sr1_vss_sr2_vss_sr3_vss_sr4_vss_sv_vss_tg_d_vss_tg_fbm_vss_tg_fbs_vss_tg_s_vss_vss_vss_link_vss_link_bridge_vss_link_dip_vss_link_m1_vss_x1_vss_x2_vss_x3_t102
+ g_vss_m1\x7cinv_clk_vss\x7cinv_mc_vss\x7cinv_q_vss\x7cmph_g\x7cnand_m_vss\x7cnand_s2_vss\x7cs1_vss_m1\x7cs2_vss_m1\x7cs3_vss_m1\x7cs4_vss_m1\x7csb_vss\x7csr1_vss\x7csr2_vss\x7csr3_vss\x7csr4_vss\x7csv_vss\x7ctg_d_vss\x7ctg_fbm_vss\x7ctg_fbs_vss\x7ctg_s_vss\x7cvss\x7cvss_link\x7cvss_link_bridge\x7cvss_link_dip\x7cvss_link_m1\x7cvss_x1\x7cvss_x2\x7cvss_x3__t102
+ g_vss_m1|inv_clk_vss|inv_mc_vss|inv_q_vss|mph_g|nand_m_vss|nand_s2_vss|s1_vss_m1|s2_vss_m1|s3_vss_m1|s4_vss_m1|sb_vss|sr1_vss|sr2_vss|sr3_vss|sr4_vss|sv_vss|tg_d_vss|tg_fbm_vss|tg_fbs_vss|tg_s_vss|vss|vss_link|vss_link_bridge|vss_link_dip|vss_link_m1|vss_x1|vss_x2|vss_x3
+ 197.78512763
* device instance g_vss_m1_inv_clk_vss_inv_mc_vss_inv_q_vss_mph_g_nand_m_vss_nand_s2_vss_s1_vss_m1_s2_vss_m1_s3_vss_m1_s4_vss_m1_sb_vss_sr1_vss_sr2_vss_sr3_vss_sr4_vss_sv_vss_tg_d_vss_tg_fbm_vss_tg_fbs_vss_tg_s_vss_vss_vss_link_vss_link_bridge_vss_link_dip_vss_link_m1_vss_x1_vss_x2_vss_x3_t103 r0 *1 0,0
Rg_vss_m1_inv_clk_vss_inv_mc_vss_inv_q_vss_mph_g_nand_m_vss_nand_s2_vss_s1_vss_m1_s2_vss_m1_s3_vss_m1_s4_vss_m1_sb_vss_sr1_vss_sr2_vss_sr3_vss_sr4_vss_sv_vss_tg_d_vss_tg_fbm_vss_tg_fbs_vss_tg_s_vss_vss_vss_link_vss_link_bridge_vss_link_dip_vss_link_m1_vss_x1_vss_x2_vss_x3_t103
+ g_vss_m1\x7cinv_clk_vss\x7cinv_mc_vss\x7cinv_q_vss\x7cmph_g\x7cnand_m_vss\x7cnand_s2_vss\x7cs1_vss_m1\x7cs2_vss_m1\x7cs3_vss_m1\x7cs4_vss_m1\x7csb_vss\x7csr1_vss\x7csr2_vss\x7csr3_vss\x7csr4_vss\x7csv_vss\x7ctg_d_vss\x7ctg_fbm_vss\x7ctg_fbs_vss\x7ctg_s_vss\x7cvss\x7cvss_link\x7cvss_link_bridge\x7cvss_link_dip\x7cvss_link_m1\x7cvss_x1\x7cvss_x2\x7cvss_x3__t103
+ g_vss_m1|inv_clk_vss|inv_mc_vss|inv_q_vss|mph_g|nand_m_vss|nand_s2_vss|s1_vss_m1|s2_vss_m1|s3_vss_m1|s4_vss_m1|sb_vss|sr1_vss|sr2_vss|sr3_vss|sr4_vss|sv_vss|tg_d_vss|tg_fbm_vss|tg_fbs_vss|tg_s_vss|vss|vss_link|vss_link_bridge|vss_link_dip|vss_link_m1|vss_x1|vss_x2|vss_x3
+ 186.202388378
* device instance g_vss_m1_inv_clk_vss_inv_mc_vss_inv_q_vss_mph_g_nand_m_vss_nand_s2_vss_s1_vss_m1_s2_vss_m1_s3_vss_m1_s4_vss_m1_sb_vss_sr1_vss_sr2_vss_sr3_vss_sr4_vss_sv_vss_tg_d_vss_tg_fbm_vss_tg_fbs_vss_tg_s_vss_vss_vss_link_vss_link_bridge_vss_link_dip_vss_link_m1_vss_x1_vss_x2_vss_x3_t104 r0 *1 0,0
Rg_vss_m1_inv_clk_vss_inv_mc_vss_inv_q_vss_mph_g_nand_m_vss_nand_s2_vss_s1_vss_m1_s2_vss_m1_s3_vss_m1_s4_vss_m1_sb_vss_sr1_vss_sr2_vss_sr3_vss_sr4_vss_sv_vss_tg_d_vss_tg_fbm_vss_tg_fbs_vss_tg_s_vss_vss_vss_link_vss_link_bridge_vss_link_dip_vss_link_m1_vss_x1_vss_x2_vss_x3_t104
+ g_vss_m1\x7cinv_clk_vss\x7cinv_mc_vss\x7cinv_q_vss\x7cmph_g\x7cnand_m_vss\x7cnand_s2_vss\x7cs1_vss_m1\x7cs2_vss_m1\x7cs3_vss_m1\x7cs4_vss_m1\x7csb_vss\x7csr1_vss\x7csr2_vss\x7csr3_vss\x7csr4_vss\x7csv_vss\x7ctg_d_vss\x7ctg_fbm_vss\x7ctg_fbs_vss\x7ctg_s_vss\x7cvss\x7cvss_link\x7cvss_link_bridge\x7cvss_link_dip\x7cvss_link_m1\x7cvss_x1\x7cvss_x2\x7cvss_x3__t104
+ g_vss_m1|inv_clk_vss|inv_mc_vss|inv_q_vss|mph_g|nand_m_vss|nand_s2_vss|s1_vss_m1|s2_vss_m1|s3_vss_m1|s4_vss_m1|sb_vss|sr1_vss|sr2_vss|sr3_vss|sr4_vss|sv_vss|tg_d_vss|tg_fbm_vss|tg_fbs_vss|tg_s_vss|vss|vss_link|vss_link_bridge|vss_link_dip|vss_link_m1|vss_x1|vss_x2|vss_x3
+ 150.102697553
* device instance g_vss_m1_inv_clk_vss_inv_mc_vss_inv_q_vss_mph_g_nand_m_vss_nand_s2_vss_s1_vss_m1_s2_vss_m1_s3_vss_m1_s4_vss_m1_sb_vss_sr1_vss_sr2_vss_sr3_vss_sr4_vss_sv_vss_tg_d_vss_tg_fbm_vss_tg_fbs_vss_tg_s_vss_vss_vss_link_vss_link_bridge_vss_link_dip_vss_link_m1_vss_x1_vss_x2_vss_x3_t105 r0 *1 0,0
Rg_vss_m1_inv_clk_vss_inv_mc_vss_inv_q_vss_mph_g_nand_m_vss_nand_s2_vss_s1_vss_m1_s2_vss_m1_s3_vss_m1_s4_vss_m1_sb_vss_sr1_vss_sr2_vss_sr3_vss_sr4_vss_sv_vss_tg_d_vss_tg_fbm_vss_tg_fbs_vss_tg_s_vss_vss_vss_link_vss_link_bridge_vss_link_dip_vss_link_m1_vss_x1_vss_x2_vss_x3_t105
+ g_vss_m1\x7cinv_clk_vss\x7cinv_mc_vss\x7cinv_q_vss\x7cmph_g\x7cnand_m_vss\x7cnand_s2_vss\x7cs1_vss_m1\x7cs2_vss_m1\x7cs3_vss_m1\x7cs4_vss_m1\x7csb_vss\x7csr1_vss\x7csr2_vss\x7csr3_vss\x7csr4_vss\x7csv_vss\x7ctg_d_vss\x7ctg_fbm_vss\x7ctg_fbs_vss\x7ctg_s_vss\x7cvss\x7cvss_link\x7cvss_link_bridge\x7cvss_link_dip\x7cvss_link_m1\x7cvss_x1\x7cvss_x2\x7cvss_x3__t105
+ g_vss_m1|inv_clk_vss|inv_mc_vss|inv_q_vss|mph_g|nand_m_vss|nand_s2_vss|s1_vss_m1|s2_vss_m1|s3_vss_m1|s4_vss_m1|sb_vss|sr1_vss|sr2_vss|sr3_vss|sr4_vss|sv_vss|tg_d_vss|tg_fbm_vss|tg_fbs_vss|tg_s_vss|vss|vss_link|vss_link_bridge|vss_link_dip|vss_link_m1|vss_x1|vss_x2|vss_x3
+ 138.715964098
* device instance g_vss_m1_inv_clk_vss_inv_mc_vss_inv_q_vss_mph_g_nand_m_vss_nand_s2_vss_s1_vss_m1_s2_vss_m1_s3_vss_m1_s4_vss_m1_sb_vss_sr1_vss_sr2_vss_sr3_vss_sr4_vss_sv_vss_tg_d_vss_tg_fbm_vss_tg_fbs_vss_tg_s_vss_vss_vss_link_vss_link_bridge_vss_link_dip_vss_link_m1_vss_x1_vss_x2_vss_x3_t106 r0 *1 0,0
Rg_vss_m1_inv_clk_vss_inv_mc_vss_inv_q_vss_mph_g_nand_m_vss_nand_s2_vss_s1_vss_m1_s2_vss_m1_s3_vss_m1_s4_vss_m1_sb_vss_sr1_vss_sr2_vss_sr3_vss_sr4_vss_sv_vss_tg_d_vss_tg_fbm_vss_tg_fbs_vss_tg_s_vss_vss_vss_link_vss_link_bridge_vss_link_dip_vss_link_m1_vss_x1_vss_x2_vss_x3_t106
+ g_vss_m1\x7cinv_clk_vss\x7cinv_mc_vss\x7cinv_q_vss\x7cmph_g\x7cnand_m_vss\x7cnand_s2_vss\x7cs1_vss_m1\x7cs2_vss_m1\x7cs3_vss_m1\x7cs4_vss_m1\x7csb_vss\x7csr1_vss\x7csr2_vss\x7csr3_vss\x7csr4_vss\x7csv_vss\x7ctg_d_vss\x7ctg_fbm_vss\x7ctg_fbs_vss\x7ctg_s_vss\x7cvss\x7cvss_link\x7cvss_link_bridge\x7cvss_link_dip\x7cvss_link_m1\x7cvss_x1\x7cvss_x2\x7cvss_x3__t106
+ g_vss_m1|inv_clk_vss|inv_mc_vss|inv_q_vss|mph_g|nand_m_vss|nand_s2_vss|s1_vss_m1|s2_vss_m1|s3_vss_m1|s4_vss_m1|sb_vss|sr1_vss|sr2_vss|sr3_vss|sr4_vss|sv_vss|tg_d_vss|tg_fbm_vss|tg_fbs_vss|tg_s_vss|vss|vss_link|vss_link_bridge|vss_link_dip|vss_link_m1|vss_x1|vss_x2|vss_x3
+ 103.629057677
* device instance g_vss_m1_inv_clk_vss_inv_mc_vss_inv_q_vss_mph_g_nand_m_vss_nand_s2_vss_s1_vss_m1_s2_vss_m1_s3_vss_m1_s4_vss_m1_sb_vss_sr1_vss_sr2_vss_sr3_vss_sr4_vss_sv_vss_tg_d_vss_tg_fbm_vss_tg_fbs_vss_tg_s_vss_vss_vss_link_vss_link_bridge_vss_link_dip_vss_link_m1_vss_x1_vss_x2_vss_x3_t107 r0 *1 0,0
Rg_vss_m1_inv_clk_vss_inv_mc_vss_inv_q_vss_mph_g_nand_m_vss_nand_s2_vss_s1_vss_m1_s2_vss_m1_s3_vss_m1_s4_vss_m1_sb_vss_sr1_vss_sr2_vss_sr3_vss_sr4_vss_sv_vss_tg_d_vss_tg_fbm_vss_tg_fbs_vss_tg_s_vss_vss_vss_link_vss_link_bridge_vss_link_dip_vss_link_m1_vss_x1_vss_x2_vss_x3_t107
+ g_vss_m1\x7cinv_clk_vss\x7cinv_mc_vss\x7cinv_q_vss\x7cmph_g\x7cnand_m_vss\x7cnand_s2_vss\x7cs1_vss_m1\x7cs2_vss_m1\x7cs3_vss_m1\x7cs4_vss_m1\x7csb_vss\x7csr1_vss\x7csr2_vss\x7csr3_vss\x7csr4_vss\x7csv_vss\x7ctg_d_vss\x7ctg_fbm_vss\x7ctg_fbs_vss\x7ctg_s_vss\x7cvss\x7cvss_link\x7cvss_link_bridge\x7cvss_link_dip\x7cvss_link_m1\x7cvss_x1\x7cvss_x2\x7cvss_x3__t107
+ g_vss_m1|inv_clk_vss|inv_mc_vss|inv_q_vss|mph_g|nand_m_vss|nand_s2_vss|s1_vss_m1|s2_vss_m1|s3_vss_m1|s4_vss_m1|sb_vss|sr1_vss|sr2_vss|sr3_vss|sr4_vss|sv_vss|tg_d_vss|tg_fbm_vss|tg_fbs_vss|tg_s_vss|vss|vss_link|vss_link_bridge|vss_link_dip|vss_link_m1|vss_x1|vss_x2|vss_x3
+ 92.785810527
* device instance g_vss_m1_inv_clk_vss_inv_mc_vss_inv_q_vss_mph_g_nand_m_vss_nand_s2_vss_s1_vss_m1_s2_vss_m1_s3_vss_m1_s4_vss_m1_sb_vss_sr1_vss_sr2_vss_sr3_vss_sr4_vss_sv_vss_tg_d_vss_tg_fbm_vss_tg_fbs_vss_tg_s_vss_vss_vss_link_vss_link_bridge_vss_link_dip_vss_link_m1_vss_x1_vss_x2_vss_x3_t108 r0 *1 0,0
Rg_vss_m1_inv_clk_vss_inv_mc_vss_inv_q_vss_mph_g_nand_m_vss_nand_s2_vss_s1_vss_m1_s2_vss_m1_s3_vss_m1_s4_vss_m1_sb_vss_sr1_vss_sr2_vss_sr3_vss_sr4_vss_sv_vss_tg_d_vss_tg_fbm_vss_tg_fbs_vss_tg_s_vss_vss_vss_link_vss_link_bridge_vss_link_dip_vss_link_m1_vss_x1_vss_x2_vss_x3_t108
+ g_vss_m1\x7cinv_clk_vss\x7cinv_mc_vss\x7cinv_q_vss\x7cmph_g\x7cnand_m_vss\x7cnand_s2_vss\x7cs1_vss_m1\x7cs2_vss_m1\x7cs3_vss_m1\x7cs4_vss_m1\x7csb_vss\x7csr1_vss\x7csr2_vss\x7csr3_vss\x7csr4_vss\x7csv_vss\x7ctg_d_vss\x7ctg_fbm_vss\x7ctg_fbs_vss\x7ctg_s_vss\x7cvss\x7cvss_link\x7cvss_link_bridge\x7cvss_link_dip\x7cvss_link_m1\x7cvss_x1\x7cvss_x2\x7cvss_x3__t108
+ g_vss_m1|inv_clk_vss|inv_mc_vss|inv_q_vss|mph_g|nand_m_vss|nand_s2_vss|s1_vss_m1|s2_vss_m1|s3_vss_m1|s4_vss_m1|sb_vss|sr1_vss|sr2_vss|sr3_vss|sr4_vss|sv_vss|tg_d_vss|tg_fbm_vss|tg_fbs_vss|tg_s_vss|vss|vss_link|vss_link_bridge|vss_link_dip|vss_link_m1|vss_x1|vss_x2|vss_x3
+ 186.970253226
* device instance g_vss_m1_inv_clk_vss_inv_mc_vss_inv_q_vss_mph_g_nand_m_vss_nand_s2_vss_s1_vss_m1_s2_vss_m1_s3_vss_m1_s4_vss_m1_sb_vss_sr1_vss_sr2_vss_sr3_vss_sr4_vss_sv_vss_tg_d_vss_tg_fbm_vss_tg_fbs_vss_tg_s_vss_vss_vss_link_vss_link_bridge_vss_link_dip_vss_link_m1_vss_x1_vss_x2_vss_x3_t109 r0 *1 0,0
Rg_vss_m1_inv_clk_vss_inv_mc_vss_inv_q_vss_mph_g_nand_m_vss_nand_s2_vss_s1_vss_m1_s2_vss_m1_s3_vss_m1_s4_vss_m1_sb_vss_sr1_vss_sr2_vss_sr3_vss_sr4_vss_sv_vss_tg_d_vss_tg_fbm_vss_tg_fbs_vss_tg_s_vss_vss_vss_link_vss_link_bridge_vss_link_dip_vss_link_m1_vss_x1_vss_x2_vss_x3_t109
+ g_vss_m1\x7cinv_clk_vss\x7cinv_mc_vss\x7cinv_q_vss\x7cmph_g\x7cnand_m_vss\x7cnand_s2_vss\x7cs1_vss_m1\x7cs2_vss_m1\x7cs3_vss_m1\x7cs4_vss_m1\x7csb_vss\x7csr1_vss\x7csr2_vss\x7csr3_vss\x7csr4_vss\x7csv_vss\x7ctg_d_vss\x7ctg_fbm_vss\x7ctg_fbs_vss\x7ctg_s_vss\x7cvss\x7cvss_link\x7cvss_link_bridge\x7cvss_link_dip\x7cvss_link_m1\x7cvss_x1\x7cvss_x2\x7cvss_x3__t109
+ g_vss_m1|inv_clk_vss|inv_mc_vss|inv_q_vss|mph_g|nand_m_vss|nand_s2_vss|s1_vss_m1|s2_vss_m1|s3_vss_m1|s4_vss_m1|sb_vss|sr1_vss|sr2_vss|sr3_vss|sr4_vss|sv_vss|tg_d_vss|tg_fbm_vss|tg_fbs_vss|tg_s_vss|vss|vss_link|vss_link_bridge|vss_link_dip|vss_link_m1|vss_x1|vss_x2|vss_x3
+ 135.543929724
* device instance g_vss_m1_inv_clk_vss_inv_mc_vss_inv_q_vss_mph_g_nand_m_vss_nand_s2_vss_s1_vss_m1_s2_vss_m1_s3_vss_m1_s4_vss_m1_sb_vss_sr1_vss_sr2_vss_sr3_vss_sr4_vss_sv_vss_tg_d_vss_tg_fbm_vss_tg_fbs_vss_tg_s_vss_vss_vss_link_vss_link_bridge_vss_link_dip_vss_link_m1_vss_x1_vss_x2_vss_x3_t110 r0 *1 0,0
Rg_vss_m1_inv_clk_vss_inv_mc_vss_inv_q_vss_mph_g_nand_m_vss_nand_s2_vss_s1_vss_m1_s2_vss_m1_s3_vss_m1_s4_vss_m1_sb_vss_sr1_vss_sr2_vss_sr3_vss_sr4_vss_sv_vss_tg_d_vss_tg_fbm_vss_tg_fbs_vss_tg_s_vss_vss_vss_link_vss_link_bridge_vss_link_dip_vss_link_m1_vss_x1_vss_x2_vss_x3_t110
+ g_vss_m1\x7cinv_clk_vss\x7cinv_mc_vss\x7cinv_q_vss\x7cmph_g\x7cnand_m_vss\x7cnand_s2_vss\x7cs1_vss_m1\x7cs2_vss_m1\x7cs3_vss_m1\x7cs4_vss_m1\x7csb_vss\x7csr1_vss\x7csr2_vss\x7csr3_vss\x7csr4_vss\x7csv_vss\x7ctg_d_vss\x7ctg_fbm_vss\x7ctg_fbs_vss\x7ctg_s_vss\x7cvss\x7cvss_link\x7cvss_link_bridge\x7cvss_link_dip\x7cvss_link_m1\x7cvss_x1\x7cvss_x2\x7cvss_x3__t110
+ g_vss_m1|inv_clk_vss|inv_mc_vss|inv_q_vss|mph_g|nand_m_vss|nand_s2_vss|s1_vss_m1|s2_vss_m1|s3_vss_m1|s4_vss_m1|sb_vss|sr1_vss|sr2_vss|sr3_vss|sr4_vss|sv_vss|tg_d_vss|tg_fbm_vss|tg_fbs_vss|tg_s_vss|vss|vss_link|vss_link_bridge|vss_link_dip|vss_link_m1|vss_x1|vss_x2|vss_x3
+ 94.8036149988
* device instance g_vss_m1_inv_clk_vss_inv_mc_vss_inv_q_vss_mph_g_nand_m_vss_nand_s2_vss_s1_vss_m1_s2_vss_m1_s3_vss_m1_s4_vss_m1_sb_vss_sr1_vss_sr2_vss_sr3_vss_sr4_vss_sv_vss_tg_d_vss_tg_fbm_vss_tg_fbs_vss_tg_s_vss_vss_vss_link_vss_link_bridge_vss_link_dip_vss_link_m1_vss_x1_vss_x2_vss_x3_t111 r0 *1 0,0
Rg_vss_m1_inv_clk_vss_inv_mc_vss_inv_q_vss_mph_g_nand_m_vss_nand_s2_vss_s1_vss_m1_s2_vss_m1_s3_vss_m1_s4_vss_m1_sb_vss_sr1_vss_sr2_vss_sr3_vss_sr4_vss_sv_vss_tg_d_vss_tg_fbm_vss_tg_fbs_vss_tg_s_vss_vss_vss_link_vss_link_bridge_vss_link_dip_vss_link_m1_vss_x1_vss_x2_vss_x3_t111
+ g_vss_m1\x7cinv_clk_vss\x7cinv_mc_vss\x7cinv_q_vss\x7cmph_g\x7cnand_m_vss\x7cnand_s2_vss\x7cs1_vss_m1\x7cs2_vss_m1\x7cs3_vss_m1\x7cs4_vss_m1\x7csb_vss\x7csr1_vss\x7csr2_vss\x7csr3_vss\x7csr4_vss\x7csv_vss\x7ctg_d_vss\x7ctg_fbm_vss\x7ctg_fbs_vss\x7ctg_s_vss\x7cvss\x7cvss_link\x7cvss_link_bridge\x7cvss_link_dip\x7cvss_link_m1\x7cvss_x1\x7cvss_x2\x7cvss_x3__t111
+ g_vss_m1|inv_clk_vss|inv_mc_vss|inv_q_vss|mph_g|nand_m_vss|nand_s2_vss|s1_vss_m1|s2_vss_m1|s3_vss_m1|s4_vss_m1|sb_vss|sr1_vss|sr2_vss|sr3_vss|sr4_vss|sv_vss|tg_d_vss|tg_fbm_vss|tg_fbs_vss|tg_s_vss|vss|vss_link|vss_link_bridge|vss_link_dip|vss_link_m1|vss_x1|vss_x2|vss_x3
+ 47.0990309007
* device instance g_vss_m1_inv_clk_vss_inv_mc_vss_inv_q_vss_mph_g_nand_m_vss_nand_s2_vss_s1_vss_m1_s2_vss_m1_s3_vss_m1_s4_vss_m1_sb_vss_sr1_vss_sr2_vss_sr3_vss_sr4_vss_sv_vss_tg_d_vss_tg_fbm_vss_tg_fbs_vss_tg_s_vss_vss_vss_link_vss_link_bridge_vss_link_dip_vss_link_m1_vss_x1_vss_x2_vss_x3_t112 r0 *1 0,0
Rg_vss_m1_inv_clk_vss_inv_mc_vss_inv_q_vss_mph_g_nand_m_vss_nand_s2_vss_s1_vss_m1_s2_vss_m1_s3_vss_m1_s4_vss_m1_sb_vss_sr1_vss_sr2_vss_sr3_vss_sr4_vss_sv_vss_tg_d_vss_tg_fbm_vss_tg_fbs_vss_tg_s_vss_vss_vss_link_vss_link_bridge_vss_link_dip_vss_link_m1_vss_x1_vss_x2_vss_x3_t112
+ g_vss_m1\x7cinv_clk_vss\x7cinv_mc_vss\x7cinv_q_vss\x7cmph_g\x7cnand_m_vss\x7cnand_s2_vss\x7cs1_vss_m1\x7cs2_vss_m1\x7cs3_vss_m1\x7cs4_vss_m1\x7csb_vss\x7csr1_vss\x7csr2_vss\x7csr3_vss\x7csr4_vss\x7csv_vss\x7ctg_d_vss\x7ctg_fbm_vss\x7ctg_fbs_vss\x7ctg_s_vss\x7cvss\x7cvss_link\x7cvss_link_bridge\x7cvss_link_dip\x7cvss_link_m1\x7cvss_x1\x7cvss_x2\x7cvss_x3__t112
+ g_vss_m1|inv_clk_vss|inv_mc_vss|inv_q_vss|mph_g|nand_m_vss|nand_s2_vss|s1_vss_m1|s2_vss_m1|s3_vss_m1|s4_vss_m1|sb_vss|sr1_vss|sr2_vss|sr3_vss|sr4_vss|sv_vss|tg_d_vss|tg_fbm_vss|tg_fbs_vss|tg_s_vss|vss|vss_link|vss_link_bridge|vss_link_dip|vss_link_m1|vss_x1|vss_x2|vss_x3
+ 26.8805342788
* device instance g_vss_m1_inv_clk_vss_inv_mc_vss_inv_q_vss_mph_g_nand_m_vss_nand_s2_vss_s1_vss_m1_s2_vss_m1_s3_vss_m1_s4_vss_m1_sb_vss_sr1_vss_sr2_vss_sr3_vss_sr4_vss_sv_vss_tg_d_vss_tg_fbm_vss_tg_fbs_vss_tg_s_vss_vss_vss_link_vss_link_bridge_vss_link_dip_vss_link_m1_vss_x1_vss_x2_vss_x3_t113 r0 *1 0,0
Rg_vss_m1_inv_clk_vss_inv_mc_vss_inv_q_vss_mph_g_nand_m_vss_nand_s2_vss_s1_vss_m1_s2_vss_m1_s3_vss_m1_s4_vss_m1_sb_vss_sr1_vss_sr2_vss_sr3_vss_sr4_vss_sv_vss_tg_d_vss_tg_fbm_vss_tg_fbs_vss_tg_s_vss_vss_vss_link_vss_link_bridge_vss_link_dip_vss_link_m1_vss_x1_vss_x2_vss_x3_t113
+ g_vss_m1\x7cinv_clk_vss\x7cinv_mc_vss\x7cinv_q_vss\x7cmph_g\x7cnand_m_vss\x7cnand_s2_vss\x7cs1_vss_m1\x7cs2_vss_m1\x7cs3_vss_m1\x7cs4_vss_m1\x7csb_vss\x7csr1_vss\x7csr2_vss\x7csr3_vss\x7csr4_vss\x7csv_vss\x7ctg_d_vss\x7ctg_fbm_vss\x7ctg_fbs_vss\x7ctg_s_vss\x7cvss\x7cvss_link\x7cvss_link_bridge\x7cvss_link_dip\x7cvss_link_m1\x7cvss_x1\x7cvss_x2\x7cvss_x3__t113
+ g_vss_m1|inv_clk_vss|inv_mc_vss|inv_q_vss|mph_g|nand_m_vss|nand_s2_vss|s1_vss_m1|s2_vss_m1|s3_vss_m1|s4_vss_m1|sb_vss|sr1_vss|sr2_vss|sr3_vss|sr4_vss|sv_vss|tg_d_vss|tg_fbm_vss|tg_fbs_vss|tg_s_vss|vss|vss_link|vss_link_bridge|vss_link_dip|vss_link_m1|vss_x1|vss_x2|vss_x3
+ 61.3959967718
* device instance g_vss_m1_inv_clk_vss_inv_mc_vss_inv_q_vss_mph_g_nand_m_vss_nand_s2_vss_s1_vss_m1_s2_vss_m1_s3_vss_m1_s4_vss_m1_sb_vss_sr1_vss_sr2_vss_sr3_vss_sr4_vss_sv_vss_tg_d_vss_tg_fbm_vss_tg_fbs_vss_tg_s_vss_vss_vss_link_vss_link_bridge_vss_link_dip_vss_link_m1_vss_x1_vss_x2_vss_x3_t114 r0 *1 0,0
Rg_vss_m1_inv_clk_vss_inv_mc_vss_inv_q_vss_mph_g_nand_m_vss_nand_s2_vss_s1_vss_m1_s2_vss_m1_s3_vss_m1_s4_vss_m1_sb_vss_sr1_vss_sr2_vss_sr3_vss_sr4_vss_sv_vss_tg_d_vss_tg_fbm_vss_tg_fbs_vss_tg_s_vss_vss_vss_link_vss_link_bridge_vss_link_dip_vss_link_m1_vss_x1_vss_x2_vss_x3_t114
+ g_vss_m1\x7cinv_clk_vss\x7cinv_mc_vss\x7cinv_q_vss\x7cmph_g\x7cnand_m_vss\x7cnand_s2_vss\x7cs1_vss_m1\x7cs2_vss_m1\x7cs3_vss_m1\x7cs4_vss_m1\x7csb_vss\x7csr1_vss\x7csr2_vss\x7csr3_vss\x7csr4_vss\x7csv_vss\x7ctg_d_vss\x7ctg_fbm_vss\x7ctg_fbs_vss\x7ctg_s_vss\x7cvss\x7cvss_link\x7cvss_link_bridge\x7cvss_link_dip\x7cvss_link_m1\x7cvss_x1\x7cvss_x2\x7cvss_x3__t114
+ g_vss_m1|inv_clk_vss|inv_mc_vss|inv_q_vss|mph_g|nand_m_vss|nand_s2_vss|s1_vss_m1|s2_vss_m1|s3_vss_m1|s4_vss_m1|sb_vss|sr1_vss|sr2_vss|sr3_vss|sr4_vss|sv_vss|tg_d_vss|tg_fbm_vss|tg_fbs_vss|tg_s_vss|vss|vss_link|vss_link_bridge|vss_link_dip|vss_link_m1|vss_x1|vss_x2|vss_x3
+ 100.808673785
* device instance g_vss_m1_inv_clk_vss_inv_mc_vss_inv_q_vss_mph_g_nand_m_vss_nand_s2_vss_s1_vss_m1_s2_vss_m1_s3_vss_m1_s4_vss_m1_sb_vss_sr1_vss_sr2_vss_sr3_vss_sr4_vss_sv_vss_tg_d_vss_tg_fbm_vss_tg_fbs_vss_tg_s_vss_vss_vss_link_vss_link_bridge_vss_link_dip_vss_link_m1_vss_x1_vss_x2_vss_x3_t115 r0 *1 0,0
Rg_vss_m1_inv_clk_vss_inv_mc_vss_inv_q_vss_mph_g_nand_m_vss_nand_s2_vss_s1_vss_m1_s2_vss_m1_s3_vss_m1_s4_vss_m1_sb_vss_sr1_vss_sr2_vss_sr3_vss_sr4_vss_sv_vss_tg_d_vss_tg_fbm_vss_tg_fbs_vss_tg_s_vss_vss_vss_link_vss_link_bridge_vss_link_dip_vss_link_m1_vss_x1_vss_x2_vss_x3_t115
+ g_vss_m1\x7cinv_clk_vss\x7cinv_mc_vss\x7cinv_q_vss\x7cmph_g\x7cnand_m_vss\x7cnand_s2_vss\x7cs1_vss_m1\x7cs2_vss_m1\x7cs3_vss_m1\x7cs4_vss_m1\x7csb_vss\x7csr1_vss\x7csr2_vss\x7csr3_vss\x7csr4_vss\x7csv_vss\x7ctg_d_vss\x7ctg_fbm_vss\x7ctg_fbs_vss\x7ctg_s_vss\x7cvss\x7cvss_link\x7cvss_link_bridge\x7cvss_link_dip\x7cvss_link_m1\x7cvss_x1\x7cvss_x2\x7cvss_x3__t115
+ g_vss_m1|inv_clk_vss|inv_mc_vss|inv_q_vss|mph_g|nand_m_vss|nand_s2_vss|s1_vss_m1|s2_vss_m1|s3_vss_m1|s4_vss_m1|sb_vss|sr1_vss|sr2_vss|sr3_vss|sr4_vss|sv_vss|tg_d_vss|tg_fbm_vss|tg_fbs_vss|tg_s_vss|vss|vss_link|vss_link_bridge|vss_link_dip|vss_link_m1|vss_x1|vss_x2|vss_x3
+ 151.741905907
* device instance g_vss_m1_inv_clk_vss_inv_mc_vss_inv_q_vss_mph_g_nand_m_vss_nand_s2_vss_s1_vss_m1_s2_vss_m1_s3_vss_m1_s4_vss_m1_sb_vss_sr1_vss_sr2_vss_sr3_vss_sr4_vss_sv_vss_tg_d_vss_tg_fbm_vss_tg_fbs_vss_tg_s_vss_vss_vss_link_vss_link_bridge_vss_link_dip_vss_link_m1_vss_x1_vss_x2_vss_x3_t116 r0 *1 0,0
Rg_vss_m1_inv_clk_vss_inv_mc_vss_inv_q_vss_mph_g_nand_m_vss_nand_s2_vss_s1_vss_m1_s2_vss_m1_s3_vss_m1_s4_vss_m1_sb_vss_sr1_vss_sr2_vss_sr3_vss_sr4_vss_sv_vss_tg_d_vss_tg_fbm_vss_tg_fbs_vss_tg_s_vss_vss_vss_link_vss_link_bridge_vss_link_dip_vss_link_m1_vss_x1_vss_x2_vss_x3_t116
+ g_vss_m1\x7cinv_clk_vss\x7cinv_mc_vss\x7cinv_q_vss\x7cmph_g\x7cnand_m_vss\x7cnand_s2_vss\x7cs1_vss_m1\x7cs2_vss_m1\x7cs3_vss_m1\x7cs4_vss_m1\x7csb_vss\x7csr1_vss\x7csr2_vss\x7csr3_vss\x7csr4_vss\x7csv_vss\x7ctg_d_vss\x7ctg_fbm_vss\x7ctg_fbs_vss\x7ctg_s_vss\x7cvss\x7cvss_link\x7cvss_link_bridge\x7cvss_link_dip\x7cvss_link_m1\x7cvss_x1\x7cvss_x2\x7cvss_x3__t116
+ g_vss_m1|inv_clk_vss|inv_mc_vss|inv_q_vss|mph_g|nand_m_vss|nand_s2_vss|s1_vss_m1|s2_vss_m1|s3_vss_m1|s4_vss_m1|sb_vss|sr1_vss|sr2_vss|sr3_vss|sr4_vss|sv_vss|tg_d_vss|tg_fbm_vss|tg_fbs_vss|tg_s_vss|vss|vss_link|vss_link_bridge|vss_link_dip|vss_link_m1|vss_x1|vss_x2|vss_x3
+ 193.150723992
* device instance g_vss_m1_inv_clk_vss_inv_mc_vss_inv_q_vss_mph_g_nand_m_vss_nand_s2_vss_s1_vss_m1_s2_vss_m1_s3_vss_m1_s4_vss_m1_sb_vss_sr1_vss_sr2_vss_sr3_vss_sr4_vss_sv_vss_tg_d_vss_tg_fbm_vss_tg_fbs_vss_tg_s_vss_vss_vss_link_vss_link_bridge_vss_link_dip_vss_link_m1_vss_x1_vss_x2_vss_x3_t117 r0 *1 0,0
Rg_vss_m1_inv_clk_vss_inv_mc_vss_inv_q_vss_mph_g_nand_m_vss_nand_s2_vss_s1_vss_m1_s2_vss_m1_s3_vss_m1_s4_vss_m1_sb_vss_sr1_vss_sr2_vss_sr3_vss_sr4_vss_sv_vss_tg_d_vss_tg_fbm_vss_tg_fbs_vss_tg_s_vss_vss_vss_link_vss_link_bridge_vss_link_dip_vss_link_m1_vss_x1_vss_x2_vss_x3_t117
+ g_vss_m1\x7cinv_clk_vss\x7cinv_mc_vss\x7cinv_q_vss\x7cmph_g\x7cnand_m_vss\x7cnand_s2_vss\x7cs1_vss_m1\x7cs2_vss_m1\x7cs3_vss_m1\x7cs4_vss_m1\x7csb_vss\x7csr1_vss\x7csr2_vss\x7csr3_vss\x7csr4_vss\x7csv_vss\x7ctg_d_vss\x7ctg_fbm_vss\x7ctg_fbs_vss\x7ctg_s_vss\x7cvss\x7cvss_link\x7cvss_link_bridge\x7cvss_link_dip\x7cvss_link_m1\x7cvss_x1\x7cvss_x2\x7cvss_x3__t117
+ g_vss_m1|inv_clk_vss|inv_mc_vss|inv_q_vss|mph_g|nand_m_vss|nand_s2_vss|s1_vss_m1|s2_vss_m1|s3_vss_m1|s4_vss_m1|sb_vss|sr1_vss|sr2_vss|sr3_vss|sr4_vss|sv_vss|tg_d_vss|tg_fbm_vss|tg_fbs_vss|tg_s_vss|vss|vss_link|vss_link_bridge|vss_link_dip|vss_link_m1|vss_x1|vss_x2|vss_x3
+ 244.921888524
* device instance g_vss_m1_inv_clk_vss_inv_mc_vss_inv_q_vss_mph_g_nand_m_vss_nand_s2_vss_s1_vss_m1_s2_vss_m1_s3_vss_m1_s4_vss_m1_sb_vss_sr1_vss_sr2_vss_sr3_vss_sr4_vss_sv_vss_tg_d_vss_tg_fbm_vss_tg_fbs_vss_tg_s_vss_vss_vss_link_vss_link_bridge_vss_link_dip_vss_link_m1_vss_x1_vss_x2_vss_x3_t118 r0 *1 0,0
Rg_vss_m1_inv_clk_vss_inv_mc_vss_inv_q_vss_mph_g_nand_m_vss_nand_s2_vss_s1_vss_m1_s2_vss_m1_s3_vss_m1_s4_vss_m1_sb_vss_sr1_vss_sr2_vss_sr3_vss_sr4_vss_sv_vss_tg_d_vss_tg_fbm_vss_tg_fbs_vss_tg_s_vss_vss_vss_link_vss_link_bridge_vss_link_dip_vss_link_m1_vss_x1_vss_x2_vss_x3_t118
+ g_vss_m1\x7cinv_clk_vss\x7cinv_mc_vss\x7cinv_q_vss\x7cmph_g\x7cnand_m_vss\x7cnand_s2_vss\x7cs1_vss_m1\x7cs2_vss_m1\x7cs3_vss_m1\x7cs4_vss_m1\x7csb_vss\x7csr1_vss\x7csr2_vss\x7csr3_vss\x7csr4_vss\x7csv_vss\x7ctg_d_vss\x7ctg_fbm_vss\x7ctg_fbs_vss\x7ctg_s_vss\x7cvss\x7cvss_link\x7cvss_link_bridge\x7cvss_link_dip\x7cvss_link_m1\x7cvss_x1\x7cvss_x2\x7cvss_x3__t118
+ g_vss_m1|inv_clk_vss|inv_mc_vss|inv_q_vss|mph_g|nand_m_vss|nand_s2_vss|s1_vss_m1|s2_vss_m1|s3_vss_m1|s4_vss_m1|sb_vss|sr1_vss|sr2_vss|sr3_vss|sr4_vss|sv_vss|tg_d_vss|tg_fbm_vss|tg_fbs_vss|tg_s_vss|vss|vss_link|vss_link_bridge|vss_link_dip|vss_link_m1|vss_x1|vss_x2|vss_x3
+ 286.630430219
* device instance g_vss_m1_inv_clk_vss_inv_mc_vss_inv_q_vss_mph_g_nand_m_vss_nand_s2_vss_s1_vss_m1_s2_vss_m1_s3_vss_m1_s4_vss_m1_sb_vss_sr1_vss_sr2_vss_sr3_vss_sr4_vss_sv_vss_tg_d_vss_tg_fbm_vss_tg_fbs_vss_tg_s_vss_vss_vss_link_vss_link_bridge_vss_link_dip_vss_link_m1_vss_x1_vss_x2_vss_x3_t119 r0 *1 0,0
Rg_vss_m1_inv_clk_vss_inv_mc_vss_inv_q_vss_mph_g_nand_m_vss_nand_s2_vss_s1_vss_m1_s2_vss_m1_s3_vss_m1_s4_vss_m1_sb_vss_sr1_vss_sr2_vss_sr3_vss_sr4_vss_sv_vss_tg_d_vss_tg_fbm_vss_tg_fbs_vss_tg_s_vss_vss_vss_link_vss_link_bridge_vss_link_dip_vss_link_m1_vss_x1_vss_x2_vss_x3_t119
+ g_vss_m1\x7cinv_clk_vss\x7cinv_mc_vss\x7cinv_q_vss\x7cmph_g\x7cnand_m_vss\x7cnand_s2_vss\x7cs1_vss_m1\x7cs2_vss_m1\x7cs3_vss_m1\x7cs4_vss_m1\x7csb_vss\x7csr1_vss\x7csr2_vss\x7csr3_vss\x7csr4_vss\x7csv_vss\x7ctg_d_vss\x7ctg_fbm_vss\x7ctg_fbs_vss\x7ctg_s_vss\x7cvss\x7cvss_link\x7cvss_link_bridge\x7cvss_link_dip\x7cvss_link_m1\x7cvss_x1\x7cvss_x2\x7cvss_x3__t119
+ g_vss_m1|inv_clk_vss|inv_mc_vss|inv_q_vss|mph_g|nand_m_vss|nand_s2_vss|s1_vss_m1|s2_vss_m1|s3_vss_m1|s4_vss_m1|sb_vss|sr1_vss|sr2_vss|sr3_vss|sr4_vss|sv_vss|tg_d_vss|tg_fbm_vss|tg_fbs_vss|tg_s_vss|vss|vss_link|vss_link_bridge|vss_link_dip|vss_link_m1|vss_x1|vss_x2|vss_x3
+ 338.604259909
* device instance g_vss_m1_inv_clk_vss_inv_mc_vss_inv_q_vss_mph_g_nand_m_vss_nand_s2_vss_s1_vss_m1_s2_vss_m1_s3_vss_m1_s4_vss_m1_sb_vss_sr1_vss_sr2_vss_sr3_vss_sr4_vss_sv_vss_tg_d_vss_tg_fbm_vss_tg_fbs_vss_tg_s_vss_vss_vss_link_vss_link_bridge_vss_link_dip_vss_link_m1_vss_x1_vss_x2_vss_x3_t120 r0 *1 0,0
Rg_vss_m1_inv_clk_vss_inv_mc_vss_inv_q_vss_mph_g_nand_m_vss_nand_s2_vss_s1_vss_m1_s2_vss_m1_s3_vss_m1_s4_vss_m1_sb_vss_sr1_vss_sr2_vss_sr3_vss_sr4_vss_sv_vss_tg_d_vss_tg_fbm_vss_tg_fbs_vss_tg_s_vss_vss_vss_link_vss_link_bridge_vss_link_dip_vss_link_m1_vss_x1_vss_x2_vss_x3_t120
+ g_vss_m1\x7cinv_clk_vss\x7cinv_mc_vss\x7cinv_q_vss\x7cmph_g\x7cnand_m_vss\x7cnand_s2_vss\x7cs1_vss_m1\x7cs2_vss_m1\x7cs3_vss_m1\x7cs4_vss_m1\x7csb_vss\x7csr1_vss\x7csr2_vss\x7csr3_vss\x7csr4_vss\x7csv_vss\x7ctg_d_vss\x7ctg_fbm_vss\x7ctg_fbs_vss\x7ctg_s_vss\x7cvss\x7cvss_link\x7cvss_link_bridge\x7cvss_link_dip\x7cvss_link_m1\x7cvss_x1\x7cvss_x2\x7cvss_x3__t120
+ g_vss_m1|inv_clk_vss|inv_mc_vss|inv_q_vss|mph_g|nand_m_vss|nand_s2_vss|s1_vss_m1|s2_vss_m1|s3_vss_m1|s4_vss_m1|sb_vss|sr1_vss|sr2_vss|sr3_vss|sr4_vss|sv_vss|tg_d_vss|tg_fbm_vss|tg_fbs_vss|tg_s_vss|vss|vss_link|vss_link_bridge|vss_link_dip|vss_link_m1|vss_x1|vss_x2|vss_x3
+ 196.219470127
* device instance g_vss_m1_inv_clk_vss_inv_mc_vss_inv_q_vss_mph_g_nand_m_vss_nand_s2_vss_s1_vss_m1_s2_vss_m1_s3_vss_m1_s4_vss_m1_sb_vss_sr1_vss_sr2_vss_sr3_vss_sr4_vss_sv_vss_tg_d_vss_tg_fbm_vss_tg_fbs_vss_tg_s_vss_vss_vss_link_vss_link_bridge_vss_link_dip_vss_link_m1_vss_x1_vss_x2_vss_x3_t121 r0 *1 0,0
Rg_vss_m1_inv_clk_vss_inv_mc_vss_inv_q_vss_mph_g_nand_m_vss_nand_s2_vss_s1_vss_m1_s2_vss_m1_s3_vss_m1_s4_vss_m1_sb_vss_sr1_vss_sr2_vss_sr3_vss_sr4_vss_sv_vss_tg_d_vss_tg_fbm_vss_tg_fbs_vss_tg_s_vss_vss_vss_link_vss_link_bridge_vss_link_dip_vss_link_m1_vss_x1_vss_x2_vss_x3_t121
+ g_vss_m1\x7cinv_clk_vss\x7cinv_mc_vss\x7cinv_q_vss\x7cmph_g\x7cnand_m_vss\x7cnand_s2_vss\x7cs1_vss_m1\x7cs2_vss_m1\x7cs3_vss_m1\x7cs4_vss_m1\x7csb_vss\x7csr1_vss\x7csr2_vss\x7csr3_vss\x7csr4_vss\x7csv_vss\x7ctg_d_vss\x7ctg_fbm_vss\x7ctg_fbs_vss\x7ctg_s_vss\x7cvss\x7cvss_link\x7cvss_link_bridge\x7cvss_link_dip\x7cvss_link_m1\x7cvss_x1\x7cvss_x2\x7cvss_x3__t121
+ g_vss_m1|inv_clk_vss|inv_mc_vss|inv_q_vss|mph_g|nand_m_vss|nand_s2_vss|s1_vss_m1|s2_vss_m1|s3_vss_m1|s4_vss_m1|sb_vss|sr1_vss|sr2_vss|sr3_vss|sr4_vss|sv_vss|tg_d_vss|tg_fbm_vss|tg_fbs_vss|tg_s_vss|vss|vss_link|vss_link_bridge|vss_link_dip|vss_link_m1|vss_x1|vss_x2|vss_x3
+ 103.147257675
* device instance g_vss_m1_inv_clk_vss_inv_mc_vss_inv_q_vss_mph_g_nand_m_vss_nand_s2_vss_s1_vss_m1_s2_vss_m1_s3_vss_m1_s4_vss_m1_sb_vss_sr1_vss_sr2_vss_sr3_vss_sr4_vss_sv_vss_tg_d_vss_tg_fbm_vss_tg_fbs_vss_tg_s_vss_vss_vss_link_vss_link_bridge_vss_link_dip_vss_link_m1_vss_x1_vss_x2_vss_x3_t122 r0 *1 0,0
Rg_vss_m1_inv_clk_vss_inv_mc_vss_inv_q_vss_mph_g_nand_m_vss_nand_s2_vss_s1_vss_m1_s2_vss_m1_s3_vss_m1_s4_vss_m1_sb_vss_sr1_vss_sr2_vss_sr3_vss_sr4_vss_sv_vss_tg_d_vss_tg_fbm_vss_tg_fbs_vss_tg_s_vss_vss_vss_link_vss_link_bridge_vss_link_dip_vss_link_m1_vss_x1_vss_x2_vss_x3_t122
+ g_vss_m1\x7cinv_clk_vss\x7cinv_mc_vss\x7cinv_q_vss\x7cmph_g\x7cnand_m_vss\x7cnand_s2_vss\x7cs1_vss_m1\x7cs2_vss_m1\x7cs3_vss_m1\x7cs4_vss_m1\x7csb_vss\x7csr1_vss\x7csr2_vss\x7csr3_vss\x7csr4_vss\x7csv_vss\x7ctg_d_vss\x7ctg_fbm_vss\x7ctg_fbs_vss\x7ctg_s_vss\x7cvss\x7cvss_link\x7cvss_link_bridge\x7cvss_link_dip\x7cvss_link_m1\x7cvss_x1\x7cvss_x2\x7cvss_x3__t122
+ g_vss_m1|inv_clk_vss|inv_mc_vss|inv_q_vss|mph_g|nand_m_vss|nand_s2_vss|s1_vss_m1|s2_vss_m1|s3_vss_m1|s4_vss_m1|sb_vss|sr1_vss|sr2_vss|sr3_vss|sr4_vss|sv_vss|tg_d_vss|tg_fbm_vss|tg_fbs_vss|tg_s_vss|vss|vss_link|vss_link_bridge|vss_link_dip|vss_link_m1|vss_x1|vss_x2|vss_x3
+ 15.9165176463
* device instance g_vss_m1_inv_clk_vss_inv_mc_vss_inv_q_vss_mph_g_nand_m_vss_nand_s2_vss_s1_vss_m1_s2_vss_m1_s3_vss_m1_s4_vss_m1_sb_vss_sr1_vss_sr2_vss_sr3_vss_sr4_vss_sv_vss_tg_d_vss_tg_fbm_vss_tg_fbs_vss_tg_s_vss_vss_vss_link_vss_link_bridge_vss_link_dip_vss_link_m1_vss_x1_vss_x2_vss_x3_t123 r0 *1 0,0
Rg_vss_m1_inv_clk_vss_inv_mc_vss_inv_q_vss_mph_g_nand_m_vss_nand_s2_vss_s1_vss_m1_s2_vss_m1_s3_vss_m1_s4_vss_m1_sb_vss_sr1_vss_sr2_vss_sr3_vss_sr4_vss_sv_vss_tg_d_vss_tg_fbm_vss_tg_fbs_vss_tg_s_vss_vss_vss_link_vss_link_bridge_vss_link_dip_vss_link_m1_vss_x1_vss_x2_vss_x3_t123
+ g_vss_m1\x7cinv_clk_vss\x7cinv_mc_vss\x7cinv_q_vss\x7cmph_g\x7cnand_m_vss\x7cnand_s2_vss\x7cs1_vss_m1\x7cs2_vss_m1\x7cs3_vss_m1\x7cs4_vss_m1\x7csb_vss\x7csr1_vss\x7csr2_vss\x7csr3_vss\x7csr4_vss\x7csv_vss\x7ctg_d_vss\x7ctg_fbm_vss\x7ctg_fbs_vss\x7ctg_s_vss\x7cvss\x7cvss_link\x7cvss_link_bridge\x7cvss_link_dip\x7cvss_link_m1\x7cvss_x1\x7cvss_x2\x7cvss_x3__t123
+ g_vss_m1|inv_clk_vss|inv_mc_vss|inv_q_vss|mph_g|nand_m_vss|nand_s2_vss|s1_vss_m1|s2_vss_m1|s3_vss_m1|s4_vss_m1|sb_vss|sr1_vss|sr2_vss|sr3_vss|sr4_vss|sv_vss|tg_d_vss|tg_fbm_vss|tg_fbs_vss|tg_s_vss|vss|vss_link|vss_link_bridge|vss_link_dip|vss_link_m1|vss_x1|vss_x2|vss_x3
+ 85.6972389353
* device instance g_vss_m1_inv_clk_vss_inv_mc_vss_inv_q_vss_mph_g_nand_m_vss_nand_s2_vss_s1_vss_m1_s2_vss_m1_s3_vss_m1_s4_vss_m1_sb_vss_sr1_vss_sr2_vss_sr3_vss_sr4_vss_sv_vss_tg_d_vss_tg_fbm_vss_tg_fbs_vss_tg_s_vss_vss_vss_link_vss_link_bridge_vss_link_dip_vss_link_m1_vss_x1_vss_x2_vss_x3_t124 r0 *1 0,0
Rg_vss_m1_inv_clk_vss_inv_mc_vss_inv_q_vss_mph_g_nand_m_vss_nand_s2_vss_s1_vss_m1_s2_vss_m1_s3_vss_m1_s4_vss_m1_sb_vss_sr1_vss_sr2_vss_sr3_vss_sr4_vss_sv_vss_tg_d_vss_tg_fbm_vss_tg_fbs_vss_tg_s_vss_vss_vss_link_vss_link_bridge_vss_link_dip_vss_link_m1_vss_x1_vss_x2_vss_x3_t124
+ g_vss_m1\x7cinv_clk_vss\x7cinv_mc_vss\x7cinv_q_vss\x7cmph_g\x7cnand_m_vss\x7cnand_s2_vss\x7cs1_vss_m1\x7cs2_vss_m1\x7cs3_vss_m1\x7cs4_vss_m1\x7csb_vss\x7csr1_vss\x7csr2_vss\x7csr3_vss\x7csr4_vss\x7csv_vss\x7ctg_d_vss\x7ctg_fbm_vss\x7ctg_fbs_vss\x7ctg_s_vss\x7cvss\x7cvss_link\x7cvss_link_bridge\x7cvss_link_dip\x7cvss_link_m1\x7cvss_x1\x7cvss_x2\x7cvss_x3__t124
+ g_vss_m1|inv_clk_vss|inv_mc_vss|inv_q_vss|mph_g|nand_m_vss|nand_s2_vss|s1_vss_m1|s2_vss_m1|s3_vss_m1|s4_vss_m1|sb_vss|sr1_vss|sr2_vss|sr3_vss|sr4_vss|sv_vss|tg_d_vss|tg_fbm_vss|tg_fbs_vss|tg_s_vss|vss|vss_link|vss_link_bridge|vss_link_dip|vss_link_m1|vss_x1|vss_x2|vss_x3
+ 196.675205596
* device instance g_vss_m1_inv_clk_vss_inv_mc_vss_inv_q_vss_mph_g_nand_m_vss_nand_s2_vss_s1_vss_m1_s2_vss_m1_s3_vss_m1_s4_vss_m1_sb_vss_sr1_vss_sr2_vss_sr3_vss_sr4_vss_sv_vss_tg_d_vss_tg_fbm_vss_tg_fbs_vss_tg_s_vss_vss_vss_link_vss_link_bridge_vss_link_dip_vss_link_m1_vss_x1_vss_x2_vss_x3_t125 r0 *1 0,0
Rg_vss_m1_inv_clk_vss_inv_mc_vss_inv_q_vss_mph_g_nand_m_vss_nand_s2_vss_s1_vss_m1_s2_vss_m1_s3_vss_m1_s4_vss_m1_sb_vss_sr1_vss_sr2_vss_sr3_vss_sr4_vss_sv_vss_tg_d_vss_tg_fbm_vss_tg_fbs_vss_tg_s_vss_vss_vss_link_vss_link_bridge_vss_link_dip_vss_link_m1_vss_x1_vss_x2_vss_x3_t125
+ g_vss_m1\x7cinv_clk_vss\x7cinv_mc_vss\x7cinv_q_vss\x7cmph_g\x7cnand_m_vss\x7cnand_s2_vss\x7cs1_vss_m1\x7cs2_vss_m1\x7cs3_vss_m1\x7cs4_vss_m1\x7csb_vss\x7csr1_vss\x7csr2_vss\x7csr3_vss\x7csr4_vss\x7csv_vss\x7ctg_d_vss\x7ctg_fbm_vss\x7ctg_fbs_vss\x7ctg_s_vss\x7cvss\x7cvss_link\x7cvss_link_bridge\x7cvss_link_dip\x7cvss_link_m1\x7cvss_x1\x7cvss_x2\x7cvss_x3__t125
+ g_vss_m1|inv_clk_vss|inv_mc_vss|inv_q_vss|mph_g|nand_m_vss|nand_s2_vss|s1_vss_m1|s2_vss_m1|s3_vss_m1|s4_vss_m1|sb_vss|sr1_vss|sr2_vss|sr3_vss|sr4_vss|sv_vss|tg_d_vss|tg_fbm_vss|tg_fbs_vss|tg_s_vss|vss|vss_link|vss_link_bridge|vss_link_dip|vss_link_m1|vss_x1|vss_x2|vss_x3
+ 185.095413611
* device instance g_vss_m1_inv_clk_vss_inv_mc_vss_inv_q_vss_mph_g_nand_m_vss_nand_s2_vss_s1_vss_m1_s2_vss_m1_s3_vss_m1_s4_vss_m1_sb_vss_sr1_vss_sr2_vss_sr3_vss_sr4_vss_sv_vss_tg_d_vss_tg_fbm_vss_tg_fbs_vss_tg_s_vss_vss_vss_link_vss_link_bridge_vss_link_dip_vss_link_m1_vss_x1_vss_x2_vss_x3_t126 r0 *1 0,0
Rg_vss_m1_inv_clk_vss_inv_mc_vss_inv_q_vss_mph_g_nand_m_vss_nand_s2_vss_s1_vss_m1_s2_vss_m1_s3_vss_m1_s4_vss_m1_sb_vss_sr1_vss_sr2_vss_sr3_vss_sr4_vss_sv_vss_tg_d_vss_tg_fbm_vss_tg_fbs_vss_tg_s_vss_vss_vss_link_vss_link_bridge_vss_link_dip_vss_link_m1_vss_x1_vss_x2_vss_x3_t126
+ g_vss_m1\x7cinv_clk_vss\x7cinv_mc_vss\x7cinv_q_vss\x7cmph_g\x7cnand_m_vss\x7cnand_s2_vss\x7cs1_vss_m1\x7cs2_vss_m1\x7cs3_vss_m1\x7cs4_vss_m1\x7csb_vss\x7csr1_vss\x7csr2_vss\x7csr3_vss\x7csr4_vss\x7csv_vss\x7ctg_d_vss\x7ctg_fbm_vss\x7ctg_fbs_vss\x7ctg_s_vss\x7cvss\x7cvss_link\x7cvss_link_bridge\x7cvss_link_dip\x7cvss_link_m1\x7cvss_x1\x7cvss_x2\x7cvss_x3__t126
+ g_vss_m1|inv_clk_vss|inv_mc_vss|inv_q_vss|mph_g|nand_m_vss|nand_s2_vss|s1_vss_m1|s2_vss_m1|s3_vss_m1|s4_vss_m1|sb_vss|sr1_vss|sr2_vss|sr3_vss|sr4_vss|sv_vss|tg_d_vss|tg_fbm_vss|tg_fbs_vss|tg_s_vss|vss|vss_link|vss_link_bridge|vss_link_dip|vss_link_m1|vss_x1|vss_x2|vss_x3
+ 149.00981641
* device instance g_vss_m1_inv_clk_vss_inv_mc_vss_inv_q_vss_mph_g_nand_m_vss_nand_s2_vss_s1_vss_m1_s2_vss_m1_s3_vss_m1_s4_vss_m1_sb_vss_sr1_vss_sr2_vss_sr3_vss_sr4_vss_sv_vss_tg_d_vss_tg_fbm_vss_tg_fbs_vss_tg_s_vss_vss_vss_link_vss_link_bridge_vss_link_dip_vss_link_m1_vss_x1_vss_x2_vss_x3_t127 r0 *1 0,0
Rg_vss_m1_inv_clk_vss_inv_mc_vss_inv_q_vss_mph_g_nand_m_vss_nand_s2_vss_s1_vss_m1_s2_vss_m1_s3_vss_m1_s4_vss_m1_sb_vss_sr1_vss_sr2_vss_sr3_vss_sr4_vss_sv_vss_tg_d_vss_tg_fbm_vss_tg_fbs_vss_tg_s_vss_vss_vss_link_vss_link_bridge_vss_link_dip_vss_link_m1_vss_x1_vss_x2_vss_x3_t127
+ g_vss_m1\x7cinv_clk_vss\x7cinv_mc_vss\x7cinv_q_vss\x7cmph_g\x7cnand_m_vss\x7cnand_s2_vss\x7cs1_vss_m1\x7cs2_vss_m1\x7cs3_vss_m1\x7cs4_vss_m1\x7csb_vss\x7csr1_vss\x7csr2_vss\x7csr3_vss\x7csr4_vss\x7csv_vss\x7ctg_d_vss\x7ctg_fbm_vss\x7ctg_fbs_vss\x7ctg_s_vss\x7cvss\x7cvss_link\x7cvss_link_bridge\x7cvss_link_dip\x7cvss_link_m1\x7cvss_x1\x7cvss_x2\x7cvss_x3__t127
+ g_vss_m1|inv_clk_vss|inv_mc_vss|inv_q_vss|mph_g|nand_m_vss|nand_s2_vss|s1_vss_m1|s2_vss_m1|s3_vss_m1|s4_vss_m1|sb_vss|sr1_vss|sr2_vss|sr3_vss|sr4_vss|sv_vss|tg_d_vss|tg_fbm_vss|tg_fbs_vss|tg_s_vss|vss|vss_link|vss_link_bridge|vss_link_dip|vss_link_m1|vss_x1|vss_x2|vss_x3
+ 137.630037373
* device instance g_vss_m1_inv_clk_vss_inv_mc_vss_inv_q_vss_mph_g_nand_m_vss_nand_s2_vss_s1_vss_m1_s2_vss_m1_s3_vss_m1_s4_vss_m1_sb_vss_sr1_vss_sr2_vss_sr3_vss_sr4_vss_sv_vss_tg_d_vss_tg_fbm_vss_tg_fbs_vss_tg_s_vss_vss_vss_link_vss_link_bridge_vss_link_dip_vss_link_m1_vss_x1_vss_x2_vss_x3_t128 r0 *1 0,0
Rg_vss_m1_inv_clk_vss_inv_mc_vss_inv_q_vss_mph_g_nand_m_vss_nand_s2_vss_s1_vss_m1_s2_vss_m1_s3_vss_m1_s4_vss_m1_sb_vss_sr1_vss_sr2_vss_sr3_vss_sr4_vss_sv_vss_tg_d_vss_tg_fbm_vss_tg_fbs_vss_tg_s_vss_vss_vss_link_vss_link_bridge_vss_link_dip_vss_link_m1_vss_x1_vss_x2_vss_x3_t128
+ g_vss_m1\x7cinv_clk_vss\x7cinv_mc_vss\x7cinv_q_vss\x7cmph_g\x7cnand_m_vss\x7cnand_s2_vss\x7cs1_vss_m1\x7cs2_vss_m1\x7cs3_vss_m1\x7cs4_vss_m1\x7csb_vss\x7csr1_vss\x7csr2_vss\x7csr3_vss\x7csr4_vss\x7csv_vss\x7ctg_d_vss\x7ctg_fbm_vss\x7ctg_fbs_vss\x7ctg_s_vss\x7cvss\x7cvss_link\x7cvss_link_bridge\x7cvss_link_dip\x7cvss_link_m1\x7cvss_x1\x7cvss_x2\x7cvss_x3__t128
+ g_vss_m1|inv_clk_vss|inv_mc_vss|inv_q_vss|mph_g|nand_m_vss|nand_s2_vss|s1_vss_m1|s2_vss_m1|s3_vss_m1|s4_vss_m1|sb_vss|sr1_vss|sr2_vss|sr3_vss|sr4_vss|sv_vss|tg_d_vss|tg_fbm_vss|tg_fbs_vss|tg_s_vss|vss|vss_link|vss_link_bridge|vss_link_dip|vss_link_m1|vss_x1|vss_x2|vss_x3
+ 102.581737937
* device instance g_vss_m1_inv_clk_vss_inv_mc_vss_inv_q_vss_mph_g_nand_m_vss_nand_s2_vss_s1_vss_m1_s2_vss_m1_s3_vss_m1_s4_vss_m1_sb_vss_sr1_vss_sr2_vss_sr3_vss_sr4_vss_sv_vss_tg_d_vss_tg_fbm_vss_tg_fbs_vss_tg_s_vss_vss_vss_link_vss_link_bridge_vss_link_dip_vss_link_m1_vss_x1_vss_x2_vss_x3_t129 r0 *1 0,0
Rg_vss_m1_inv_clk_vss_inv_mc_vss_inv_q_vss_mph_g_nand_m_vss_nand_s2_vss_s1_vss_m1_s2_vss_m1_s3_vss_m1_s4_vss_m1_sb_vss_sr1_vss_sr2_vss_sr3_vss_sr4_vss_sv_vss_tg_d_vss_tg_fbm_vss_tg_fbs_vss_tg_s_vss_vss_vss_link_vss_link_bridge_vss_link_dip_vss_link_m1_vss_x1_vss_x2_vss_x3_t129
+ g_vss_m1\x7cinv_clk_vss\x7cinv_mc_vss\x7cinv_q_vss\x7cmph_g\x7cnand_m_vss\x7cnand_s2_vss\x7cs1_vss_m1\x7cs2_vss_m1\x7cs3_vss_m1\x7cs4_vss_m1\x7csb_vss\x7csr1_vss\x7csr2_vss\x7csr3_vss\x7csr4_vss\x7csv_vss\x7ctg_d_vss\x7ctg_fbm_vss\x7ctg_fbs_vss\x7ctg_s_vss\x7cvss\x7cvss_link\x7cvss_link_bridge\x7cvss_link_dip\x7cvss_link_m1\x7cvss_x1\x7cvss_x2\x7cvss_x3__t129
+ g_vss_m1|inv_clk_vss|inv_mc_vss|inv_q_vss|mph_g|nand_m_vss|nand_s2_vss|s1_vss_m1|s2_vss_m1|s3_vss_m1|s4_vss_m1|sb_vss|sr1_vss|sr2_vss|sr3_vss|sr4_vss|sv_vss|tg_d_vss|tg_fbm_vss|tg_fbs_vss|tg_s_vss|vss|vss_link|vss_link_bridge|vss_link_dip|vss_link_m1|vss_x1|vss_x2|vss_x3
+ 91.7607809253
* device instance g_vss_m1_inv_clk_vss_inv_mc_vss_inv_q_vss_mph_g_nand_m_vss_nand_s2_vss_s1_vss_m1_s2_vss_m1_s3_vss_m1_s4_vss_m1_sb_vss_sr1_vss_sr2_vss_sr3_vss_sr4_vss_sv_vss_tg_d_vss_tg_fbm_vss_tg_fbs_vss_tg_s_vss_vss_vss_link_vss_link_bridge_vss_link_dip_vss_link_m1_vss_x1_vss_x2_vss_x3_t130 r0 *1 0,0
Rg_vss_m1_inv_clk_vss_inv_mc_vss_inv_q_vss_mph_g_nand_m_vss_nand_s2_vss_s1_vss_m1_s2_vss_m1_s3_vss_m1_s4_vss_m1_sb_vss_sr1_vss_sr2_vss_sr3_vss_sr4_vss_sv_vss_tg_d_vss_tg_fbm_vss_tg_fbs_vss_tg_s_vss_vss_vss_link_vss_link_bridge_vss_link_dip_vss_link_m1_vss_x1_vss_x2_vss_x3_t130
+ g_vss_m1\x7cinv_clk_vss\x7cinv_mc_vss\x7cinv_q_vss\x7cmph_g\x7cnand_m_vss\x7cnand_s2_vss\x7cs1_vss_m1\x7cs2_vss_m1\x7cs3_vss_m1\x7cs4_vss_m1\x7csb_vss\x7csr1_vss\x7csr2_vss\x7csr3_vss\x7csr4_vss\x7csv_vss\x7ctg_d_vss\x7ctg_fbm_vss\x7ctg_fbs_vss\x7ctg_s_vss\x7cvss\x7cvss_link\x7cvss_link_bridge\x7cvss_link_dip\x7cvss_link_m1\x7cvss_x1\x7cvss_x2\x7cvss_x3__t130
+ g_vss_m1|inv_clk_vss|inv_mc_vss|inv_q_vss|mph_g|nand_m_vss|nand_s2_vss|s1_vss_m1|s2_vss_m1|s3_vss_m1|s4_vss_m1|sb_vss|sr1_vss|sr2_vss|sr3_vss|sr4_vss|sv_vss|tg_d_vss|tg_fbm_vss|tg_fbs_vss|tg_s_vss|vss|vss_link|vss_link_bridge|vss_link_dip|vss_link_m1|vss_x1|vss_x2|vss_x3
+ 207.805032601
* device instance g_vss_m1_inv_clk_vss_inv_mc_vss_inv_q_vss_mph_g_nand_m_vss_nand_s2_vss_s1_vss_m1_s2_vss_m1_s3_vss_m1_s4_vss_m1_sb_vss_sr1_vss_sr2_vss_sr3_vss_sr4_vss_sv_vss_tg_d_vss_tg_fbm_vss_tg_fbs_vss_tg_s_vss_vss_vss_link_vss_link_bridge_vss_link_dip_vss_link_m1_vss_x1_vss_x2_vss_x3_t131 r0 *1 0,0
Rg_vss_m1_inv_clk_vss_inv_mc_vss_inv_q_vss_mph_g_nand_m_vss_nand_s2_vss_s1_vss_m1_s2_vss_m1_s3_vss_m1_s4_vss_m1_sb_vss_sr1_vss_sr2_vss_sr3_vss_sr4_vss_sv_vss_tg_d_vss_tg_fbm_vss_tg_fbs_vss_tg_s_vss_vss_vss_link_vss_link_bridge_vss_link_dip_vss_link_m1_vss_x1_vss_x2_vss_x3_t131
+ g_vss_m1\x7cinv_clk_vss\x7cinv_mc_vss\x7cinv_q_vss\x7cmph_g\x7cnand_m_vss\x7cnand_s2_vss\x7cs1_vss_m1\x7cs2_vss_m1\x7cs3_vss_m1\x7cs4_vss_m1\x7csb_vss\x7csr1_vss\x7csr2_vss\x7csr3_vss\x7csr4_vss\x7csv_vss\x7ctg_d_vss\x7ctg_fbm_vss\x7ctg_fbs_vss\x7ctg_s_vss\x7cvss\x7cvss_link\x7cvss_link_bridge\x7cvss_link_dip\x7cvss_link_m1\x7cvss_x1\x7cvss_x2\x7cvss_x3__t131
+ g_vss_m1|inv_clk_vss|inv_mc_vss|inv_q_vss|mph_g|nand_m_vss|nand_s2_vss|s1_vss_m1|s2_vss_m1|s3_vss_m1|s4_vss_m1|sb_vss|sr1_vss|sr2_vss|sr3_vss|sr4_vss|sv_vss|tg_d_vss|tg_fbm_vss|tg_fbs_vss|tg_s_vss|vss|vss_link|vss_link_bridge|vss_link_dip|vss_link_m1|vss_x1|vss_x2|vss_x3
+ 199.819710612
* device instance g_vss_m1_inv_clk_vss_inv_mc_vss_inv_q_vss_mph_g_nand_m_vss_nand_s2_vss_s1_vss_m1_s2_vss_m1_s3_vss_m1_s4_vss_m1_sb_vss_sr1_vss_sr2_vss_sr3_vss_sr4_vss_sv_vss_tg_d_vss_tg_fbm_vss_tg_fbs_vss_tg_s_vss_vss_vss_link_vss_link_bridge_vss_link_dip_vss_link_m1_vss_x1_vss_x2_vss_x3_t132 r0 *1 0,0
Rg_vss_m1_inv_clk_vss_inv_mc_vss_inv_q_vss_mph_g_nand_m_vss_nand_s2_vss_s1_vss_m1_s2_vss_m1_s3_vss_m1_s4_vss_m1_sb_vss_sr1_vss_sr2_vss_sr3_vss_sr4_vss_sv_vss_tg_d_vss_tg_fbm_vss_tg_fbs_vss_tg_s_vss_vss_vss_link_vss_link_bridge_vss_link_dip_vss_link_m1_vss_x1_vss_x2_vss_x3_t132
+ g_vss_m1\x7cinv_clk_vss\x7cinv_mc_vss\x7cinv_q_vss\x7cmph_g\x7cnand_m_vss\x7cnand_s2_vss\x7cs1_vss_m1\x7cs2_vss_m1\x7cs3_vss_m1\x7cs4_vss_m1\x7csb_vss\x7csr1_vss\x7csr2_vss\x7csr3_vss\x7csr4_vss\x7csv_vss\x7ctg_d_vss\x7ctg_fbm_vss\x7ctg_fbs_vss\x7ctg_s_vss\x7cvss\x7cvss_link\x7cvss_link_bridge\x7cvss_link_dip\x7cvss_link_m1\x7cvss_x1\x7cvss_x2\x7cvss_x3__t132
+ g_vss_m1|inv_clk_vss|inv_mc_vss|inv_q_vss|mph_g|nand_m_vss|nand_s2_vss|s1_vss_m1|s2_vss_m1|s3_vss_m1|s4_vss_m1|sb_vss|sr1_vss|sr2_vss|sr3_vss|sr4_vss|sv_vss|tg_d_vss|tg_fbm_vss|tg_fbs_vss|tg_s_vss|vss|vss_link|vss_link_bridge|vss_link_dip|vss_link_m1|vss_x1|vss_x2|vss_x3
+ 175.517461623
* device instance g_vss_m1_inv_clk_vss_inv_mc_vss_inv_q_vss_mph_g_nand_m_vss_nand_s2_vss_s1_vss_m1_s2_vss_m1_s3_vss_m1_s4_vss_m1_sb_vss_sr1_vss_sr2_vss_sr3_vss_sr4_vss_sv_vss_tg_d_vss_tg_fbm_vss_tg_fbs_vss_tg_s_vss_vss_vss_link_vss_link_bridge_vss_link_dip_vss_link_m1_vss_x1_vss_x2_vss_x3_t133 r0 *1 0,0
Rg_vss_m1_inv_clk_vss_inv_mc_vss_inv_q_vss_mph_g_nand_m_vss_nand_s2_vss_s1_vss_m1_s2_vss_m1_s3_vss_m1_s4_vss_m1_sb_vss_sr1_vss_sr2_vss_sr3_vss_sr4_vss_sv_vss_tg_d_vss_tg_fbm_vss_tg_fbs_vss_tg_s_vss_vss_vss_link_vss_link_bridge_vss_link_dip_vss_link_m1_vss_x1_vss_x2_vss_x3_t133
+ g_vss_m1\x7cinv_clk_vss\x7cinv_mc_vss\x7cinv_q_vss\x7cmph_g\x7cnand_m_vss\x7cnand_s2_vss\x7cs1_vss_m1\x7cs2_vss_m1\x7cs3_vss_m1\x7cs4_vss_m1\x7csb_vss\x7csr1_vss\x7csr2_vss\x7csr3_vss\x7csr4_vss\x7csv_vss\x7ctg_d_vss\x7ctg_fbm_vss\x7ctg_fbs_vss\x7ctg_s_vss\x7cvss\x7cvss_link\x7cvss_link_bridge\x7cvss_link_dip\x7cvss_link_m1\x7cvss_x1\x7cvss_x2\x7cvss_x3__t133
+ g_vss_m1|inv_clk_vss|inv_mc_vss|inv_q_vss|mph_g|nand_m_vss|nand_s2_vss|s1_vss_m1|s2_vss_m1|s3_vss_m1|s4_vss_m1|sb_vss|sr1_vss|sr2_vss|sr3_vss|sr4_vss|sv_vss|tg_d_vss|tg_fbm_vss|tg_fbs_vss|tg_s_vss|vss|vss_link|vss_link_bridge|vss_link_dip|vss_link_m1|vss_x1|vss_x2|vss_x3
+ 167.560916785
* device instance g_vss_m1_inv_clk_vss_inv_mc_vss_inv_q_vss_mph_g_nand_m_vss_nand_s2_vss_s1_vss_m1_s2_vss_m1_s3_vss_m1_s4_vss_m1_sb_vss_sr1_vss_sr2_vss_sr3_vss_sr4_vss_sv_vss_tg_d_vss_tg_fbm_vss_tg_fbs_vss_tg_s_vss_vss_vss_link_vss_link_bridge_vss_link_dip_vss_link_m1_vss_x1_vss_x2_vss_x3_t134 r0 *1 0,0
Rg_vss_m1_inv_clk_vss_inv_mc_vss_inv_q_vss_mph_g_nand_m_vss_nand_s2_vss_s1_vss_m1_s2_vss_m1_s3_vss_m1_s4_vss_m1_sb_vss_sr1_vss_sr2_vss_sr3_vss_sr4_vss_sv_vss_tg_d_vss_tg_fbm_vss_tg_fbs_vss_tg_s_vss_vss_vss_link_vss_link_bridge_vss_link_dip_vss_link_m1_vss_x1_vss_x2_vss_x3_t134
+ g_vss_m1\x7cinv_clk_vss\x7cinv_mc_vss\x7cinv_q_vss\x7cmph_g\x7cnand_m_vss\x7cnand_s2_vss\x7cs1_vss_m1\x7cs2_vss_m1\x7cs3_vss_m1\x7cs4_vss_m1\x7csb_vss\x7csr1_vss\x7csr2_vss\x7csr3_vss\x7csr4_vss\x7csv_vss\x7ctg_d_vss\x7ctg_fbm_vss\x7ctg_fbs_vss\x7ctg_s_vss\x7cvss\x7cvss_link\x7cvss_link_bridge\x7cvss_link_dip\x7cvss_link_m1\x7cvss_x1\x7cvss_x2\x7cvss_x3__t134
+ g_vss_m1|inv_clk_vss|inv_mc_vss|inv_q_vss|mph_g|nand_m_vss|nand_s2_vss|s1_vss_m1|s2_vss_m1|s3_vss_m1|s4_vss_m1|sb_vss|sr1_vss|sr2_vss|sr3_vss|sr4_vss|sv_vss|tg_d_vss|tg_fbm_vss|tg_fbs_vss|tg_s_vss|vss|vss_link|vss_link_bridge|vss_link_dip|vss_link_m1|vss_x1|vss_x2|vss_x3
+ 158.98929044
* device instance g_vss_m1_inv_clk_vss_inv_mc_vss_inv_q_vss_mph_g_nand_m_vss_nand_s2_vss_s1_vss_m1_s2_vss_m1_s3_vss_m1_s4_vss_m1_sb_vss_sr1_vss_sr2_vss_sr3_vss_sr4_vss_sv_vss_tg_d_vss_tg_fbm_vss_tg_fbs_vss_tg_s_vss_vss_vss_link_vss_link_bridge_vss_link_dip_vss_link_m1_vss_x1_vss_x2_vss_x3_t135 r0 *1 0,0
Rg_vss_m1_inv_clk_vss_inv_mc_vss_inv_q_vss_mph_g_nand_m_vss_nand_s2_vss_s1_vss_m1_s2_vss_m1_s3_vss_m1_s4_vss_m1_sb_vss_sr1_vss_sr2_vss_sr3_vss_sr4_vss_sv_vss_tg_d_vss_tg_fbm_vss_tg_fbs_vss_tg_s_vss_vss_vss_link_vss_link_bridge_vss_link_dip_vss_link_m1_vss_x1_vss_x2_vss_x3_t135
+ g_vss_m1\x7cinv_clk_vss\x7cinv_mc_vss\x7cinv_q_vss\x7cmph_g\x7cnand_m_vss\x7cnand_s2_vss\x7cs1_vss_m1\x7cs2_vss_m1\x7cs3_vss_m1\x7cs4_vss_m1\x7csb_vss\x7csr1_vss\x7csr2_vss\x7csr3_vss\x7csr4_vss\x7csv_vss\x7ctg_d_vss\x7ctg_fbm_vss\x7ctg_fbs_vss\x7ctg_s_vss\x7cvss\x7cvss_link\x7cvss_link_bridge\x7cvss_link_dip\x7cvss_link_m1\x7cvss_x1\x7cvss_x2\x7cvss_x3__t135
+ g_vss_m1|inv_clk_vss|inv_mc_vss|inv_q_vss|mph_g|nand_m_vss|nand_s2_vss|s1_vss_m1|s2_vss_m1|s3_vss_m1|s4_vss_m1|sb_vss|sr1_vss|sr2_vss|sr3_vss|sr4_vss|sv_vss|tg_d_vss|tg_fbm_vss|tg_fbs_vss|tg_s_vss|vss|vss_link|vss_link_bridge|vss_link_dip|vss_link_m1|vss_x1|vss_x2|vss_x3
+ 147.662103706
* device instance g_vss_m1_inv_clk_vss_inv_mc_vss_inv_q_vss_mph_g_nand_m_vss_nand_s2_vss_s1_vss_m1_s2_vss_m1_s3_vss_m1_s4_vss_m1_sb_vss_sr1_vss_sr2_vss_sr3_vss_sr4_vss_sv_vss_tg_d_vss_tg_fbm_vss_tg_fbs_vss_tg_s_vss_vss_vss_link_vss_link_bridge_vss_link_dip_vss_link_m1_vss_x1_vss_x2_vss_x3_t136 r0 *1 0,0
Rg_vss_m1_inv_clk_vss_inv_mc_vss_inv_q_vss_mph_g_nand_m_vss_nand_s2_vss_s1_vss_m1_s2_vss_m1_s3_vss_m1_s4_vss_m1_sb_vss_sr1_vss_sr2_vss_sr3_vss_sr4_vss_sv_vss_tg_d_vss_tg_fbm_vss_tg_fbs_vss_tg_s_vss_vss_vss_link_vss_link_bridge_vss_link_dip_vss_link_m1_vss_x1_vss_x2_vss_x3_t136
+ g_vss_m1\x7cinv_clk_vss\x7cinv_mc_vss\x7cinv_q_vss\x7cmph_g\x7cnand_m_vss\x7cnand_s2_vss\x7cs1_vss_m1\x7cs2_vss_m1\x7cs3_vss_m1\x7cs4_vss_m1\x7csb_vss\x7csr1_vss\x7csr2_vss\x7csr3_vss\x7csr4_vss\x7csv_vss\x7ctg_d_vss\x7ctg_fbm_vss\x7ctg_fbs_vss\x7ctg_s_vss\x7cvss\x7cvss_link\x7cvss_link_bridge\x7cvss_link_dip\x7cvss_link_m1\x7cvss_x1\x7cvss_x2\x7cvss_x3__t136
+ g_vss_m1|inv_clk_vss|inv_mc_vss|inv_q_vss|mph_g|nand_m_vss|nand_s2_vss|s1_vss_m1|s2_vss_m1|s3_vss_m1|s4_vss_m1|sb_vss|sr1_vss|sr2_vss|sr3_vss|sr4_vss|sv_vss|tg_d_vss|tg_fbm_vss|tg_fbs_vss|tg_s_vss|vss|vss_link|vss_link_bridge|vss_link_dip|vss_link_m1|vss_x1|vss_x2|vss_x3
+ 126.962654865
* device instance g_vss_m1_inv_clk_vss_inv_mc_vss_inv_q_vss_mph_g_nand_m_vss_nand_s2_vss_s1_vss_m1_s2_vss_m1_s3_vss_m1_s4_vss_m1_sb_vss_sr1_vss_sr2_vss_sr3_vss_sr4_vss_sv_vss_tg_d_vss_tg_fbm_vss_tg_fbs_vss_tg_s_vss_vss_vss_link_vss_link_bridge_vss_link_dip_vss_link_m1_vss_x1_vss_x2_vss_x3_t137 r0 *1 0,0
Rg_vss_m1_inv_clk_vss_inv_mc_vss_inv_q_vss_mph_g_nand_m_vss_nand_s2_vss_s1_vss_m1_s2_vss_m1_s3_vss_m1_s4_vss_m1_sb_vss_sr1_vss_sr2_vss_sr3_vss_sr4_vss_sv_vss_tg_d_vss_tg_fbm_vss_tg_fbs_vss_tg_s_vss_vss_vss_link_vss_link_bridge_vss_link_dip_vss_link_m1_vss_x1_vss_x2_vss_x3_t137
+ g_vss_m1\x7cinv_clk_vss\x7cinv_mc_vss\x7cinv_q_vss\x7cmph_g\x7cnand_m_vss\x7cnand_s2_vss\x7cs1_vss_m1\x7cs2_vss_m1\x7cs3_vss_m1\x7cs4_vss_m1\x7csb_vss\x7csr1_vss\x7csr2_vss\x7csr3_vss\x7csr4_vss\x7csv_vss\x7ctg_d_vss\x7ctg_fbm_vss\x7ctg_fbs_vss\x7ctg_s_vss\x7cvss\x7cvss_link\x7cvss_link_bridge\x7cvss_link_dip\x7cvss_link_m1\x7cvss_x1\x7cvss_x2\x7cvss_x3__t137
+ g_vss_m1|inv_clk_vss|inv_mc_vss|inv_q_vss|mph_g|nand_m_vss|nand_s2_vss|s1_vss_m1|s2_vss_m1|s3_vss_m1|s4_vss_m1|sb_vss|sr1_vss|sr2_vss|sr3_vss|sr4_vss|sv_vss|tg_d_vss|tg_fbm_vss|tg_fbs_vss|tg_s_vss|vss|vss_link|vss_link_bridge|vss_link_dip|vss_link_m1|vss_x1|vss_x2|vss_x3
+ 115.133486829
* device instance g_vss_m1_inv_clk_vss_inv_mc_vss_inv_q_vss_mph_g_nand_m_vss_nand_s2_vss_s1_vss_m1_s2_vss_m1_s3_vss_m1_s4_vss_m1_sb_vss_sr1_vss_sr2_vss_sr3_vss_sr4_vss_sv_vss_tg_d_vss_tg_fbm_vss_tg_fbs_vss_tg_s_vss_vss_vss_link_vss_link_bridge_vss_link_dip_vss_link_m1_vss_x1_vss_x2_vss_x3_t138 r0 *1 0,0
Rg_vss_m1_inv_clk_vss_inv_mc_vss_inv_q_vss_mph_g_nand_m_vss_nand_s2_vss_s1_vss_m1_s2_vss_m1_s3_vss_m1_s4_vss_m1_sb_vss_sr1_vss_sr2_vss_sr3_vss_sr4_vss_sv_vss_tg_d_vss_tg_fbm_vss_tg_fbs_vss_tg_s_vss_vss_vss_link_vss_link_bridge_vss_link_dip_vss_link_m1_vss_x1_vss_x2_vss_x3_t138
+ g_vss_m1\x7cinv_clk_vss\x7cinv_mc_vss\x7cinv_q_vss\x7cmph_g\x7cnand_m_vss\x7cnand_s2_vss\x7cs1_vss_m1\x7cs2_vss_m1\x7cs3_vss_m1\x7cs4_vss_m1\x7csb_vss\x7csr1_vss\x7csr2_vss\x7csr3_vss\x7csr4_vss\x7csv_vss\x7ctg_d_vss\x7ctg_fbm_vss\x7ctg_fbs_vss\x7ctg_s_vss\x7cvss\x7cvss_link\x7cvss_link_bridge\x7cvss_link_dip\x7cvss_link_m1\x7cvss_x1\x7cvss_x2\x7cvss_x3__t138
+ g_vss_m1|inv_clk_vss|inv_mc_vss|inv_q_vss|mph_g|nand_m_vss|nand_s2_vss|s1_vss_m1|s2_vss_m1|s3_vss_m1|s4_vss_m1|sb_vss|sr1_vss|sr2_vss|sr3_vss|sr4_vss|sv_vss|tg_d_vss|tg_fbm_vss|tg_fbs_vss|tg_s_vss|vss|vss_link|vss_link_bridge|vss_link_dip|vss_link_m1|vss_x1|vss_x2|vss_x3
+ 107.31454815
* device instance g_vss_m1_inv_clk_vss_inv_mc_vss_inv_q_vss_mph_g_nand_m_vss_nand_s2_vss_s1_vss_m1_s2_vss_m1_s3_vss_m1_s4_vss_m1_sb_vss_sr1_vss_sr2_vss_sr3_vss_sr4_vss_sv_vss_tg_d_vss_tg_fbm_vss_tg_fbs_vss_tg_s_vss_vss_vss_link_vss_link_bridge_vss_link_dip_vss_link_m1_vss_x1_vss_x2_vss_x3_t139 r0 *1 0,0
Rg_vss_m1_inv_clk_vss_inv_mc_vss_inv_q_vss_mph_g_nand_m_vss_nand_s2_vss_s1_vss_m1_s2_vss_m1_s3_vss_m1_s4_vss_m1_sb_vss_sr1_vss_sr2_vss_sr3_vss_sr4_vss_sv_vss_tg_d_vss_tg_fbm_vss_tg_fbs_vss_tg_s_vss_vss_vss_link_vss_link_bridge_vss_link_dip_vss_link_m1_vss_x1_vss_x2_vss_x3_t139
+ g_vss_m1\x7cinv_clk_vss\x7cinv_mc_vss\x7cinv_q_vss\x7cmph_g\x7cnand_m_vss\x7cnand_s2_vss\x7cs1_vss_m1\x7cs2_vss_m1\x7cs3_vss_m1\x7cs4_vss_m1\x7csb_vss\x7csr1_vss\x7csr2_vss\x7csr3_vss\x7csr4_vss\x7csv_vss\x7ctg_d_vss\x7ctg_fbm_vss\x7ctg_fbs_vss\x7ctg_s_vss\x7cvss\x7cvss_link\x7cvss_link_bridge\x7cvss_link_dip\x7cvss_link_m1\x7cvss_x1\x7cvss_x2\x7cvss_x3__t139
+ g_vss_m1|inv_clk_vss|inv_mc_vss|inv_q_vss|mph_g|nand_m_vss|nand_s2_vss|s1_vss_m1|s2_vss_m1|s3_vss_m1|s4_vss_m1|sb_vss|sr1_vss|sr2_vss|sr3_vss|sr4_vss|sv_vss|tg_d_vss|tg_fbm_vss|tg_fbs_vss|tg_s_vss|vss|vss_link|vss_link_bridge|vss_link_dip|vss_link_m1|vss_x1|vss_x2|vss_x3
+ 83.7565387283
* device instance g_vss_m1_inv_clk_vss_inv_mc_vss_inv_q_vss_mph_g_nand_m_vss_nand_s2_vss_s1_vss_m1_s2_vss_m1_s3_vss_m1_s4_vss_m1_sb_vss_sr1_vss_sr2_vss_sr3_vss_sr4_vss_sv_vss_tg_d_vss_tg_fbm_vss_tg_fbs_vss_tg_s_vss_vss_vss_link_vss_link_bridge_vss_link_dip_vss_link_m1_vss_x1_vss_x2_vss_x3_t140 r0 *1 0,0
Rg_vss_m1_inv_clk_vss_inv_mc_vss_inv_q_vss_mph_g_nand_m_vss_nand_s2_vss_s1_vss_m1_s2_vss_m1_s3_vss_m1_s4_vss_m1_sb_vss_sr1_vss_sr2_vss_sr3_vss_sr4_vss_sv_vss_tg_d_vss_tg_fbm_vss_tg_fbs_vss_tg_s_vss_vss_vss_link_vss_link_bridge_vss_link_dip_vss_link_m1_vss_x1_vss_x2_vss_x3_t140
+ g_vss_m1\x7cinv_clk_vss\x7cinv_mc_vss\x7cinv_q_vss\x7cmph_g\x7cnand_m_vss\x7cnand_s2_vss\x7cs1_vss_m1\x7cs2_vss_m1\x7cs3_vss_m1\x7cs4_vss_m1\x7csb_vss\x7csr1_vss\x7csr2_vss\x7csr3_vss\x7csr4_vss\x7csv_vss\x7ctg_d_vss\x7ctg_fbm_vss\x7ctg_fbs_vss\x7ctg_s_vss\x7cvss\x7cvss_link\x7cvss_link_bridge\x7cvss_link_dip\x7cvss_link_m1\x7cvss_x1\x7cvss_x2\x7cvss_x3__t140
+ g_vss_m1|inv_clk_vss|inv_mc_vss|inv_q_vss|mph_g|nand_m_vss|nand_s2_vss|s1_vss_m1|s2_vss_m1|s3_vss_m1|s4_vss_m1|sb_vss|sr1_vss|sr2_vss|sr3_vss|sr4_vss|sv_vss|tg_d_vss|tg_fbm_vss|tg_fbs_vss|tg_s_vss|vss|vss_link|vss_link_bridge|vss_link_dip|vss_link_m1|vss_x1|vss_x2|vss_x3
+ 76.1652582225
* device instance g_vss_m1_inv_clk_vss_inv_mc_vss_inv_q_vss_mph_g_nand_m_vss_nand_s2_vss_s1_vss_m1_s2_vss_m1_s3_vss_m1_s4_vss_m1_sb_vss_sr1_vss_sr2_vss_sr3_vss_sr4_vss_sv_vss_tg_d_vss_tg_fbm_vss_tg_fbs_vss_tg_s_vss_vss_vss_link_vss_link_bridge_vss_link_dip_vss_link_m1_vss_x1_vss_x2_vss_x3_t141 r0 *1 0,0
Rg_vss_m1_inv_clk_vss_inv_mc_vss_inv_q_vss_mph_g_nand_m_vss_nand_s2_vss_s1_vss_m1_s2_vss_m1_s3_vss_m1_s4_vss_m1_sb_vss_sr1_vss_sr2_vss_sr3_vss_sr4_vss_sv_vss_tg_d_vss_tg_fbm_vss_tg_fbs_vss_tg_s_vss_vss_vss_link_vss_link_bridge_vss_link_dip_vss_link_m1_vss_x1_vss_x2_vss_x3_t141
+ g_vss_m1\x7cinv_clk_vss\x7cinv_mc_vss\x7cinv_q_vss\x7cmph_g\x7cnand_m_vss\x7cnand_s2_vss\x7cs1_vss_m1\x7cs2_vss_m1\x7cs3_vss_m1\x7cs4_vss_m1\x7csb_vss\x7csr1_vss\x7csr2_vss\x7csr3_vss\x7csr4_vss\x7csv_vss\x7ctg_d_vss\x7ctg_fbm_vss\x7ctg_fbs_vss\x7ctg_s_vss\x7cvss\x7cvss_link\x7cvss_link_bridge\x7cvss_link_dip\x7cvss_link_m1\x7cvss_x1\x7cvss_x2\x7cvss_x3__t141
+ g_vss_m1|inv_clk_vss|inv_mc_vss|inv_q_vss|mph_g|nand_m_vss|nand_s2_vss|s1_vss_m1|s2_vss_m1|s3_vss_m1|s4_vss_m1|sb_vss|sr1_vss|sr2_vss|sr3_vss|sr4_vss|sv_vss|tg_d_vss|tg_fbm_vss|tg_fbs_vss|tg_s_vss|vss|vss_link|vss_link_bridge|vss_link_dip|vss_link_m1|vss_x1|vss_x2|vss_x3
+ 68.096049041
* device instance g_vss_m1_inv_clk_vss_inv_mc_vss_inv_q_vss_mph_g_nand_m_vss_nand_s2_vss_s1_vss_m1_s2_vss_m1_s3_vss_m1_s4_vss_m1_sb_vss_sr1_vss_sr2_vss_sr3_vss_sr4_vss_sv_vss_tg_d_vss_tg_fbm_vss_tg_fbs_vss_tg_s_vss_vss_vss_link_vss_link_bridge_vss_link_dip_vss_link_m1_vss_x1_vss_x2_vss_x3_t142 r0 *1 0,0
Rg_vss_m1_inv_clk_vss_inv_mc_vss_inv_q_vss_mph_g_nand_m_vss_nand_s2_vss_s1_vss_m1_s2_vss_m1_s3_vss_m1_s4_vss_m1_sb_vss_sr1_vss_sr2_vss_sr3_vss_sr4_vss_sv_vss_tg_d_vss_tg_fbm_vss_tg_fbs_vss_tg_s_vss_vss_vss_link_vss_link_bridge_vss_link_dip_vss_link_m1_vss_x1_vss_x2_vss_x3_t142
+ g_vss_m1\x7cinv_clk_vss\x7cinv_mc_vss\x7cinv_q_vss\x7cmph_g\x7cnand_m_vss\x7cnand_s2_vss\x7cs1_vss_m1\x7cs2_vss_m1\x7cs3_vss_m1\x7cs4_vss_m1\x7csb_vss\x7csr1_vss\x7csr2_vss\x7csr3_vss\x7csr4_vss\x7csv_vss\x7ctg_d_vss\x7ctg_fbm_vss\x7ctg_fbs_vss\x7ctg_s_vss\x7cvss\x7cvss_link\x7cvss_link_bridge\x7cvss_link_dip\x7cvss_link_m1\x7cvss_x1\x7cvss_x2\x7cvss_x3__t142
+ g_vss_m1|inv_clk_vss|inv_mc_vss|inv_q_vss|mph_g|nand_m_vss|nand_s2_vss|s1_vss_m1|s2_vss_m1|s3_vss_m1|s4_vss_m1|sb_vss|sr1_vss|sr2_vss|sr3_vss|sr4_vss|sv_vss|tg_d_vss|tg_fbm_vss|tg_fbs_vss|tg_s_vss|vss|vss_link|vss_link_bridge|vss_link_dip|vss_link_m1|vss_x1|vss_x2|vss_x3
+ 57.6904565913
* device instance g_vss_m1_inv_clk_vss_inv_mc_vss_inv_q_vss_mph_g_nand_m_vss_nand_s2_vss_s1_vss_m1_s2_vss_m1_s3_vss_m1_s4_vss_m1_sb_vss_sr1_vss_sr2_vss_sr3_vss_sr4_vss_sv_vss_tg_d_vss_tg_fbm_vss_tg_fbs_vss_tg_s_vss_vss_vss_link_vss_link_bridge_vss_link_dip_vss_link_m1_vss_x1_vss_x2_vss_x3_t143 r0 *1 0,0
Rg_vss_m1_inv_clk_vss_inv_mc_vss_inv_q_vss_mph_g_nand_m_vss_nand_s2_vss_s1_vss_m1_s2_vss_m1_s3_vss_m1_s4_vss_m1_sb_vss_sr1_vss_sr2_vss_sr3_vss_sr4_vss_sv_vss_tg_d_vss_tg_fbm_vss_tg_fbs_vss_tg_s_vss_vss_vss_link_vss_link_bridge_vss_link_dip_vss_link_m1_vss_x1_vss_x2_vss_x3_t143
+ g_vss_m1\x7cinv_clk_vss\x7cinv_mc_vss\x7cinv_q_vss\x7cmph_g\x7cnand_m_vss\x7cnand_s2_vss\x7cs1_vss_m1\x7cs2_vss_m1\x7cs3_vss_m1\x7cs4_vss_m1\x7csb_vss\x7csr1_vss\x7csr2_vss\x7csr3_vss\x7csr4_vss\x7csv_vss\x7ctg_d_vss\x7ctg_fbm_vss\x7ctg_fbs_vss\x7ctg_s_vss\x7cvss\x7cvss_link\x7cvss_link_bridge\x7cvss_link_dip\x7cvss_link_m1\x7cvss_x1\x7cvss_x2\x7cvss_x3__t143
+ g_vss_m1|inv_clk_vss|inv_mc_vss|inv_q_vss|mph_g|nand_m_vss|nand_s2_vss|s1_vss_m1|s2_vss_m1|s3_vss_m1|s4_vss_m1|sb_vss|sr1_vss|sr2_vss|sr3_vss|sr4_vss|sv_vss|tg_d_vss|tg_fbm_vss|tg_fbs_vss|tg_s_vss|vss|vss_link|vss_link_bridge|vss_link_dip|vss_link_m1|vss_x1|vss_x2|vss_x3
+ 40.1868558268
* device instance g_vss_m1_inv_clk_vss_inv_mc_vss_inv_q_vss_mph_g_nand_m_vss_nand_s2_vss_s1_vss_m1_s2_vss_m1_s3_vss_m1_s4_vss_m1_sb_vss_sr1_vss_sr2_vss_sr3_vss_sr4_vss_sv_vss_tg_d_vss_tg_fbm_vss_tg_fbs_vss_tg_s_vss_vss_vss_link_vss_link_bridge_vss_link_dip_vss_link_m1_vss_x1_vss_x2_vss_x3_t144 r0 *1 0,0
Rg_vss_m1_inv_clk_vss_inv_mc_vss_inv_q_vss_mph_g_nand_m_vss_nand_s2_vss_s1_vss_m1_s2_vss_m1_s3_vss_m1_s4_vss_m1_sb_vss_sr1_vss_sr2_vss_sr3_vss_sr4_vss_sv_vss_tg_d_vss_tg_fbm_vss_tg_fbs_vss_tg_s_vss_vss_vss_link_vss_link_bridge_vss_link_dip_vss_link_m1_vss_x1_vss_x2_vss_x3_t144
+ g_vss_m1\x7cinv_clk_vss\x7cinv_mc_vss\x7cinv_q_vss\x7cmph_g\x7cnand_m_vss\x7cnand_s2_vss\x7cs1_vss_m1\x7cs2_vss_m1\x7cs3_vss_m1\x7cs4_vss_m1\x7csb_vss\x7csr1_vss\x7csr2_vss\x7csr3_vss\x7csr4_vss\x7csv_vss\x7ctg_d_vss\x7ctg_fbm_vss\x7ctg_fbs_vss\x7ctg_s_vss\x7cvss\x7cvss_link\x7cvss_link_bridge\x7cvss_link_dip\x7cvss_link_m1\x7cvss_x1\x7cvss_x2\x7cvss_x3__t144
+ g_vss_m1|inv_clk_vss|inv_mc_vss|inv_q_vss|mph_g|nand_m_vss|nand_s2_vss|s1_vss_m1|s2_vss_m1|s3_vss_m1|s4_vss_m1|sb_vss|sr1_vss|sr2_vss|sr3_vss|sr4_vss|sv_vss|tg_d_vss|tg_fbm_vss|tg_fbs_vss|tg_s_vss|vss|vss_link|vss_link_bridge|vss_link_dip|vss_link_m1|vss_x1|vss_x2|vss_x3
+ 32.148030812
* device instance g_vss_m1_inv_clk_vss_inv_mc_vss_inv_q_vss_mph_g_nand_m_vss_nand_s2_vss_s1_vss_m1_s2_vss_m1_s3_vss_m1_s4_vss_m1_sb_vss_sr1_vss_sr2_vss_sr3_vss_sr4_vss_sv_vss_tg_d_vss_tg_fbm_vss_tg_fbs_vss_tg_s_vss_vss_vss_link_vss_link_bridge_vss_link_dip_vss_link_m1_vss_x1_vss_x2_vss_x3_t145 r0 *1 0,0
Rg_vss_m1_inv_clk_vss_inv_mc_vss_inv_q_vss_mph_g_nand_m_vss_nand_s2_vss_s1_vss_m1_s2_vss_m1_s3_vss_m1_s4_vss_m1_sb_vss_sr1_vss_sr2_vss_sr3_vss_sr4_vss_sv_vss_tg_d_vss_tg_fbm_vss_tg_fbs_vss_tg_s_vss_vss_vss_link_vss_link_bridge_vss_link_dip_vss_link_m1_vss_x1_vss_x2_vss_x3_t145
+ g_vss_m1\x7cinv_clk_vss\x7cinv_mc_vss\x7cinv_q_vss\x7cmph_g\x7cnand_m_vss\x7cnand_s2_vss\x7cs1_vss_m1\x7cs2_vss_m1\x7cs3_vss_m1\x7cs4_vss_m1\x7csb_vss\x7csr1_vss\x7csr2_vss\x7csr3_vss\x7csr4_vss\x7csv_vss\x7ctg_d_vss\x7ctg_fbm_vss\x7ctg_fbs_vss\x7ctg_s_vss\x7cvss\x7cvss_link\x7cvss_link_bridge\x7cvss_link_dip\x7cvss_link_m1\x7cvss_x1\x7cvss_x2\x7cvss_x3__t145
+ g_vss_m1|inv_clk_vss|inv_mc_vss|inv_q_vss|mph_g|nand_m_vss|nand_s2_vss|s1_vss_m1|s2_vss_m1|s3_vss_m1|s4_vss_m1|sb_vss|sr1_vss|sr2_vss|sr3_vss|sr4_vss|sv_vss|tg_d_vss|tg_fbm_vss|tg_fbs_vss|tg_s_vss|vss|vss_link|vss_link_bridge|vss_link_dip|vss_link_m1|vss_x1|vss_x2|vss_x3
+ 28.4586651363
* device instance g_vss_m1_inv_clk_vss_inv_mc_vss_inv_q_vss_mph_g_nand_m_vss_nand_s2_vss_s1_vss_m1_s2_vss_m1_s3_vss_m1_s4_vss_m1_sb_vss_sr1_vss_sr2_vss_sr3_vss_sr4_vss_sv_vss_tg_d_vss_tg_fbm_vss_tg_fbs_vss_tg_s_vss_vss_vss_link_vss_link_bridge_vss_link_dip_vss_link_m1_vss_x1_vss_x2_vss_x3_t146 r0 *1 0,0
Rg_vss_m1_inv_clk_vss_inv_mc_vss_inv_q_vss_mph_g_nand_m_vss_nand_s2_vss_s1_vss_m1_s2_vss_m1_s3_vss_m1_s4_vss_m1_sb_vss_sr1_vss_sr2_vss_sr3_vss_sr4_vss_sv_vss_tg_d_vss_tg_fbm_vss_tg_fbs_vss_tg_s_vss_vss_vss_link_vss_link_bridge_vss_link_dip_vss_link_m1_vss_x1_vss_x2_vss_x3_t146
+ g_vss_m1\x7cinv_clk_vss\x7cinv_mc_vss\x7cinv_q_vss\x7cmph_g\x7cnand_m_vss\x7cnand_s2_vss\x7cs1_vss_m1\x7cs2_vss_m1\x7cs3_vss_m1\x7cs4_vss_m1\x7csb_vss\x7csr1_vss\x7csr2_vss\x7csr3_vss\x7csr4_vss\x7csv_vss\x7ctg_d_vss\x7ctg_fbm_vss\x7ctg_fbs_vss\x7ctg_s_vss\x7cvss\x7cvss_link\x7cvss_link_bridge\x7cvss_link_dip\x7cvss_link_m1\x7cvss_x1\x7cvss_x2\x7cvss_x3__t146
+ g_vss_m1|inv_clk_vss|inv_mc_vss|inv_q_vss|mph_g|nand_m_vss|nand_s2_vss|s1_vss_m1|s2_vss_m1|s3_vss_m1|s4_vss_m1|sb_vss|sr1_vss|sr2_vss|sr3_vss|sr4_vss|sv_vss|tg_d_vss|tg_fbm_vss|tg_fbs_vss|tg_s_vss|vss|vss_link|vss_link_bridge|vss_link_dip|vss_link_m1|vss_x1|vss_x2|vss_x3
+ 30.478256281
* device instance g_vss_m1_inv_clk_vss_inv_mc_vss_inv_q_vss_mph_g_nand_m_vss_nand_s2_vss_s1_vss_m1_s2_vss_m1_s3_vss_m1_s4_vss_m1_sb_vss_sr1_vss_sr2_vss_sr3_vss_sr4_vss_sv_vss_tg_d_vss_tg_fbm_vss_tg_fbs_vss_tg_s_vss_vss_vss_link_vss_link_bridge_vss_link_dip_vss_link_m1_vss_x1_vss_x2_vss_x3_t147 r0 *1 0,0
Rg_vss_m1_inv_clk_vss_inv_mc_vss_inv_q_vss_mph_g_nand_m_vss_nand_s2_vss_s1_vss_m1_s2_vss_m1_s3_vss_m1_s4_vss_m1_sb_vss_sr1_vss_sr2_vss_sr3_vss_sr4_vss_sv_vss_tg_d_vss_tg_fbm_vss_tg_fbs_vss_tg_s_vss_vss_vss_link_vss_link_bridge_vss_link_dip_vss_link_m1_vss_x1_vss_x2_vss_x3_t147
+ g_vss_m1\x7cinv_clk_vss\x7cinv_mc_vss\x7cinv_q_vss\x7cmph_g\x7cnand_m_vss\x7cnand_s2_vss\x7cs1_vss_m1\x7cs2_vss_m1\x7cs3_vss_m1\x7cs4_vss_m1\x7csb_vss\x7csr1_vss\x7csr2_vss\x7csr3_vss\x7csr4_vss\x7csv_vss\x7ctg_d_vss\x7ctg_fbm_vss\x7ctg_fbs_vss\x7ctg_s_vss\x7cvss\x7cvss_link\x7cvss_link_bridge\x7cvss_link_dip\x7cvss_link_m1\x7cvss_x1\x7cvss_x2\x7cvss_x3__t147
+ g_vss_m1|inv_clk_vss|inv_mc_vss|inv_q_vss|mph_g|nand_m_vss|nand_s2_vss|s1_vss_m1|s2_vss_m1|s3_vss_m1|s4_vss_m1|sb_vss|sr1_vss|sr2_vss|sr3_vss|sr4_vss|sv_vss|tg_d_vss|tg_fbm_vss|tg_fbs_vss|tg_s_vss|vss|vss_link|vss_link_bridge|vss_link_dip|vss_link_m1|vss_x1|vss_x2|vss_x3
+ 35.0801962244
* device instance g_vss_m1_inv_clk_vss_inv_mc_vss_inv_q_vss_mph_g_nand_m_vss_nand_s2_vss_s1_vss_m1_s2_vss_m1_s3_vss_m1_s4_vss_m1_sb_vss_sr1_vss_sr2_vss_sr3_vss_sr4_vss_sv_vss_tg_d_vss_tg_fbm_vss_tg_fbs_vss_tg_s_vss_vss_vss_link_vss_link_bridge_vss_link_dip_vss_link_m1_vss_x1_vss_x2_vss_x3_t148 r0 *1 0,0
Rg_vss_m1_inv_clk_vss_inv_mc_vss_inv_q_vss_mph_g_nand_m_vss_nand_s2_vss_s1_vss_m1_s2_vss_m1_s3_vss_m1_s4_vss_m1_sb_vss_sr1_vss_sr2_vss_sr3_vss_sr4_vss_sv_vss_tg_d_vss_tg_fbm_vss_tg_fbs_vss_tg_s_vss_vss_vss_link_vss_link_bridge_vss_link_dip_vss_link_m1_vss_x1_vss_x2_vss_x3_t148
+ g_vss_m1\x7cinv_clk_vss\x7cinv_mc_vss\x7cinv_q_vss\x7cmph_g\x7cnand_m_vss\x7cnand_s2_vss\x7cs1_vss_m1\x7cs2_vss_m1\x7cs3_vss_m1\x7cs4_vss_m1\x7csb_vss\x7csr1_vss\x7csr2_vss\x7csr3_vss\x7csr4_vss\x7csv_vss\x7ctg_d_vss\x7ctg_fbm_vss\x7ctg_fbs_vss\x7ctg_s_vss\x7cvss\x7cvss_link\x7cvss_link_bridge\x7cvss_link_dip\x7cvss_link_m1\x7cvss_x1\x7cvss_x2\x7cvss_x3__t148
+ g_vss_m1|inv_clk_vss|inv_mc_vss|inv_q_vss|mph_g|nand_m_vss|nand_s2_vss|s1_vss_m1|s2_vss_m1|s3_vss_m1|s4_vss_m1|sb_vss|sr1_vss|sr2_vss|sr3_vss|sr4_vss|sv_vss|tg_d_vss|tg_fbm_vss|tg_fbs_vss|tg_s_vss|vss|vss_link|vss_link_bridge|vss_link_dip|vss_link_m1|vss_x1|vss_x2|vss_x3
+ 41.2496932887
* device instance g_vss_m1_inv_clk_vss_inv_mc_vss_inv_q_vss_mph_g_nand_m_vss_nand_s2_vss_s1_vss_m1_s2_vss_m1_s3_vss_m1_s4_vss_m1_sb_vss_sr1_vss_sr2_vss_sr3_vss_sr4_vss_sv_vss_tg_d_vss_tg_fbm_vss_tg_fbs_vss_tg_s_vss_vss_vss_link_vss_link_bridge_vss_link_dip_vss_link_m1_vss_x1_vss_x2_vss_x3_t149 r0 *1 0,0
Rg_vss_m1_inv_clk_vss_inv_mc_vss_inv_q_vss_mph_g_nand_m_vss_nand_s2_vss_s1_vss_m1_s2_vss_m1_s3_vss_m1_s4_vss_m1_sb_vss_sr1_vss_sr2_vss_sr3_vss_sr4_vss_sv_vss_tg_d_vss_tg_fbm_vss_tg_fbs_vss_tg_s_vss_vss_vss_link_vss_link_bridge_vss_link_dip_vss_link_m1_vss_x1_vss_x2_vss_x3_t149
+ g_vss_m1\x7cinv_clk_vss\x7cinv_mc_vss\x7cinv_q_vss\x7cmph_g\x7cnand_m_vss\x7cnand_s2_vss\x7cs1_vss_m1\x7cs2_vss_m1\x7cs3_vss_m1\x7cs4_vss_m1\x7csb_vss\x7csr1_vss\x7csr2_vss\x7csr3_vss\x7csr4_vss\x7csv_vss\x7ctg_d_vss\x7ctg_fbm_vss\x7ctg_fbs_vss\x7ctg_s_vss\x7cvss\x7cvss_link\x7cvss_link_bridge\x7cvss_link_dip\x7cvss_link_m1\x7cvss_x1\x7cvss_x2\x7cvss_x3__t149
+ g_vss_m1|inv_clk_vss|inv_mc_vss|inv_q_vss|mph_g|nand_m_vss|nand_s2_vss|s1_vss_m1|s2_vss_m1|s3_vss_m1|s4_vss_m1|sb_vss|sr1_vss|sr2_vss|sr3_vss|sr4_vss|sv_vss|tg_d_vss|tg_fbm_vss|tg_fbs_vss|tg_s_vss|vss|vss_link|vss_link_bridge|vss_link_dip|vss_link_m1|vss_x1|vss_x2|vss_x3
+ 50.5694430799
* device instance g_vss_m1_inv_clk_vss_inv_mc_vss_inv_q_vss_mph_g_nand_m_vss_nand_s2_vss_s1_vss_m1_s2_vss_m1_s3_vss_m1_s4_vss_m1_sb_vss_sr1_vss_sr2_vss_sr3_vss_sr4_vss_sv_vss_tg_d_vss_tg_fbm_vss_tg_fbs_vss_tg_s_vss_vss_vss_link_vss_link_bridge_vss_link_dip_vss_link_m1_vss_x1_vss_x2_vss_x3_t150 r0 *1 0,0
Rg_vss_m1_inv_clk_vss_inv_mc_vss_inv_q_vss_mph_g_nand_m_vss_nand_s2_vss_s1_vss_m1_s2_vss_m1_s3_vss_m1_s4_vss_m1_sb_vss_sr1_vss_sr2_vss_sr3_vss_sr4_vss_sv_vss_tg_d_vss_tg_fbm_vss_tg_fbs_vss_tg_s_vss_vss_vss_link_vss_link_bridge_vss_link_dip_vss_link_m1_vss_x1_vss_x2_vss_x3_t150
+ g_vss_m1\x7cinv_clk_vss\x7cinv_mc_vss\x7cinv_q_vss\x7cmph_g\x7cnand_m_vss\x7cnand_s2_vss\x7cs1_vss_m1\x7cs2_vss_m1\x7cs3_vss_m1\x7cs4_vss_m1\x7csb_vss\x7csr1_vss\x7csr2_vss\x7csr3_vss\x7csr4_vss\x7csv_vss\x7ctg_d_vss\x7ctg_fbm_vss\x7ctg_fbs_vss\x7ctg_s_vss\x7cvss\x7cvss_link\x7cvss_link_bridge\x7cvss_link_dip\x7cvss_link_m1\x7cvss_x1\x7cvss_x2\x7cvss_x3__t150
+ g_vss_m1|inv_clk_vss|inv_mc_vss|inv_q_vss|mph_g|nand_m_vss|nand_s2_vss|s1_vss_m1|s2_vss_m1|s3_vss_m1|s4_vss_m1|sb_vss|sr1_vss|sr2_vss|sr3_vss|sr4_vss|sv_vss|tg_d_vss|tg_fbm_vss|tg_fbs_vss|tg_s_vss|vss|vss_link|vss_link_bridge|vss_link_dip|vss_link_m1|vss_x1|vss_x2|vss_x3
+ 69.3933636095
* device instance g_vss_m1_inv_clk_vss_inv_mc_vss_inv_q_vss_mph_g_nand_m_vss_nand_s2_vss_s1_vss_m1_s2_vss_m1_s3_vss_m1_s4_vss_m1_sb_vss_sr1_vss_sr2_vss_sr3_vss_sr4_vss_sv_vss_tg_d_vss_tg_fbm_vss_tg_fbs_vss_tg_s_vss_vss_vss_link_vss_link_bridge_vss_link_dip_vss_link_m1_vss_x1_vss_x2_vss_x3_t151 r0 *1 0,0
Rg_vss_m1_inv_clk_vss_inv_mc_vss_inv_q_vss_mph_g_nand_m_vss_nand_s2_vss_s1_vss_m1_s2_vss_m1_s3_vss_m1_s4_vss_m1_sb_vss_sr1_vss_sr2_vss_sr3_vss_sr4_vss_sv_vss_tg_d_vss_tg_fbm_vss_tg_fbs_vss_tg_s_vss_vss_vss_link_vss_link_bridge_vss_link_dip_vss_link_m1_vss_x1_vss_x2_vss_x3_t151
+ g_vss_m1\x7cinv_clk_vss\x7cinv_mc_vss\x7cinv_q_vss\x7cmph_g\x7cnand_m_vss\x7cnand_s2_vss\x7cs1_vss_m1\x7cs2_vss_m1\x7cs3_vss_m1\x7cs4_vss_m1\x7csb_vss\x7csr1_vss\x7csr2_vss\x7csr3_vss\x7csr4_vss\x7csv_vss\x7ctg_d_vss\x7ctg_fbm_vss\x7ctg_fbs_vss\x7ctg_s_vss\x7cvss\x7cvss_link\x7cvss_link_bridge\x7cvss_link_dip\x7cvss_link_m1\x7cvss_x1\x7cvss_x2\x7cvss_x3__t151
+ g_vss_m1|inv_clk_vss|inv_mc_vss|inv_q_vss|mph_g|nand_m_vss|nand_s2_vss|s1_vss_m1|s2_vss_m1|s3_vss_m1|s4_vss_m1|sb_vss|sr1_vss|sr2_vss|sr3_vss|sr4_vss|sv_vss|tg_d_vss|tg_fbm_vss|tg_fbs_vss|tg_s_vss|vss|vss_link|vss_link_bridge|vss_link_dip|vss_link_m1|vss_x1|vss_x2|vss_x3
+ 80.7233538813
* device instance g_vss_m1_inv_clk_vss_inv_mc_vss_inv_q_vss_mph_g_nand_m_vss_nand_s2_vss_s1_vss_m1_s2_vss_m1_s3_vss_m1_s4_vss_m1_sb_vss_sr1_vss_sr2_vss_sr3_vss_sr4_vss_sv_vss_tg_d_vss_tg_fbm_vss_tg_fbs_vss_tg_s_vss_vss_vss_link_vss_link_bridge_vss_link_dip_vss_link_m1_vss_x1_vss_x2_vss_x3_t152 r0 *1 0,0
Rg_vss_m1_inv_clk_vss_inv_mc_vss_inv_q_vss_mph_g_nand_m_vss_nand_s2_vss_s1_vss_m1_s2_vss_m1_s3_vss_m1_s4_vss_m1_sb_vss_sr1_vss_sr2_vss_sr3_vss_sr4_vss_sv_vss_tg_d_vss_tg_fbm_vss_tg_fbs_vss_tg_s_vss_vss_vss_link_vss_link_bridge_vss_link_dip_vss_link_m1_vss_x1_vss_x2_vss_x3_t152
+ g_vss_m1\x7cinv_clk_vss\x7cinv_mc_vss\x7cinv_q_vss\x7cmph_g\x7cnand_m_vss\x7cnand_s2_vss\x7cs1_vss_m1\x7cs2_vss_m1\x7cs3_vss_m1\x7cs4_vss_m1\x7csb_vss\x7csr1_vss\x7csr2_vss\x7csr3_vss\x7csr4_vss\x7csv_vss\x7ctg_d_vss\x7ctg_fbm_vss\x7ctg_fbs_vss\x7ctg_s_vss\x7cvss\x7cvss_link\x7cvss_link_bridge\x7cvss_link_dip\x7cvss_link_m1\x7cvss_x1\x7cvss_x2\x7cvss_x3__t152
+ g_vss_m1|inv_clk_vss|inv_mc_vss|inv_q_vss|mph_g|nand_m_vss|nand_s2_vss|s1_vss_m1|s2_vss_m1|s3_vss_m1|s4_vss_m1|sb_vss|sr1_vss|sr2_vss|sr3_vss|sr4_vss|sv_vss|tg_d_vss|tg_fbm_vss|tg_fbs_vss|tg_s_vss|vss|vss_link|vss_link_bridge|vss_link_dip|vss_link_m1|vss_x1|vss_x2|vss_x3
+ 88.3649640918
* device instance g_vss_m1_inv_clk_vss_inv_mc_vss_inv_q_vss_mph_g_nand_m_vss_nand_s2_vss_s1_vss_m1_s2_vss_m1_s3_vss_m1_s4_vss_m1_sb_vss_sr1_vss_sr2_vss_sr3_vss_sr4_vss_sv_vss_tg_d_vss_tg_fbm_vss_tg_fbs_vss_tg_s_vss_vss_vss_link_vss_link_bridge_vss_link_dip_vss_link_m1_vss_x1_vss_x2_vss_x3_t153 r0 *1 0,0
Rg_vss_m1_inv_clk_vss_inv_mc_vss_inv_q_vss_mph_g_nand_m_vss_nand_s2_vss_s1_vss_m1_s2_vss_m1_s3_vss_m1_s4_vss_m1_sb_vss_sr1_vss_sr2_vss_sr3_vss_sr4_vss_sv_vss_tg_d_vss_tg_fbm_vss_tg_fbs_vss_tg_s_vss_vss_vss_link_vss_link_bridge_vss_link_dip_vss_link_m1_vss_x1_vss_x2_vss_x3_t153
+ g_vss_m1\x7cinv_clk_vss\x7cinv_mc_vss\x7cinv_q_vss\x7cmph_g\x7cnand_m_vss\x7cnand_s2_vss\x7cs1_vss_m1\x7cs2_vss_m1\x7cs3_vss_m1\x7cs4_vss_m1\x7csb_vss\x7csr1_vss\x7csr2_vss\x7csr3_vss\x7csr4_vss\x7csv_vss\x7ctg_d_vss\x7ctg_fbm_vss\x7ctg_fbs_vss\x7ctg_s_vss\x7cvss\x7cvss_link\x7cvss_link_bridge\x7cvss_link_dip\x7cvss_link_m1\x7cvss_x1\x7cvss_x2\x7cvss_x3__t153
+ g_vss_m1|inv_clk_vss|inv_mc_vss|inv_q_vss|mph_g|nand_m_vss|nand_s2_vss|s1_vss_m1|s2_vss_m1|s3_vss_m1|s4_vss_m1|sb_vss|sr1_vss|sr2_vss|sr3_vss|sr4_vss|sv_vss|tg_d_vss|tg_fbm_vss|tg_fbs_vss|tg_s_vss|vss|vss_link|vss_link_bridge|vss_link_dip|vss_link_m1|vss_x1|vss_x2|vss_x3
+ 112.016419837
* device instance g_vss_m1_inv_clk_vss_inv_mc_vss_inv_q_vss_mph_g_nand_m_vss_nand_s2_vss_s1_vss_m1_s2_vss_m1_s3_vss_m1_s4_vss_m1_sb_vss_sr1_vss_sr2_vss_sr3_vss_sr4_vss_sv_vss_tg_d_vss_tg_fbm_vss_tg_fbs_vss_tg_s_vss_vss_vss_link_vss_link_bridge_vss_link_dip_vss_link_m1_vss_x1_vss_x2_vss_x3_t154 r0 *1 0,0
Rg_vss_m1_inv_clk_vss_inv_mc_vss_inv_q_vss_mph_g_nand_m_vss_nand_s2_vss_s1_vss_m1_s2_vss_m1_s3_vss_m1_s4_vss_m1_sb_vss_sr1_vss_sr2_vss_sr3_vss_sr4_vss_sv_vss_tg_d_vss_tg_fbm_vss_tg_fbs_vss_tg_s_vss_vss_vss_link_vss_link_bridge_vss_link_dip_vss_link_m1_vss_x1_vss_x2_vss_x3_t154
+ g_vss_m1\x7cinv_clk_vss\x7cinv_mc_vss\x7cinv_q_vss\x7cmph_g\x7cnand_m_vss\x7cnand_s2_vss\x7cs1_vss_m1\x7cs2_vss_m1\x7cs3_vss_m1\x7cs4_vss_m1\x7csb_vss\x7csr1_vss\x7csr2_vss\x7csr3_vss\x7csr4_vss\x7csv_vss\x7ctg_d_vss\x7ctg_fbm_vss\x7ctg_fbs_vss\x7ctg_s_vss\x7cvss\x7cvss_link\x7cvss_link_bridge\x7cvss_link_dip\x7cvss_link_m1\x7cvss_x1\x7cvss_x2\x7cvss_x3__t154
+ g_vss_m1|inv_clk_vss|inv_mc_vss|inv_q_vss|mph_g|nand_m_vss|nand_s2_vss|s1_vss_m1|s2_vss_m1|s3_vss_m1|s4_vss_m1|sb_vss|sr1_vss|sr2_vss|sr3_vss|sr4_vss|sv_vss|tg_d_vss|tg_fbm_vss|tg_fbs_vss|tg_s_vss|vss|vss_link|vss_link_bridge|vss_link_dip|vss_link_m1|vss_x1|vss_x2|vss_x3
+ 119.854418588
* device instance g_vss_m1_inv_clk_vss_inv_mc_vss_inv_q_vss_mph_g_nand_m_vss_nand_s2_vss_s1_vss_m1_s2_vss_m1_s3_vss_m1_s4_vss_m1_sb_vss_sr1_vss_sr2_vss_sr3_vss_sr4_vss_sv_vss_tg_d_vss_tg_fbm_vss_tg_fbs_vss_tg_s_vss_vss_vss_link_vss_link_bridge_vss_link_dip_vss_link_m1_vss_x1_vss_x2_vss_x3_t155 r0 *1 0,0
Rg_vss_m1_inv_clk_vss_inv_mc_vss_inv_q_vss_mph_g_nand_m_vss_nand_s2_vss_s1_vss_m1_s2_vss_m1_s3_vss_m1_s4_vss_m1_sb_vss_sr1_vss_sr2_vss_sr3_vss_sr4_vss_sv_vss_tg_d_vss_tg_fbm_vss_tg_fbs_vss_tg_s_vss_vss_vss_link_vss_link_bridge_vss_link_dip_vss_link_m1_vss_x1_vss_x2_vss_x3_t155
+ g_vss_m1\x7cinv_clk_vss\x7cinv_mc_vss\x7cinv_q_vss\x7cmph_g\x7cnand_m_vss\x7cnand_s2_vss\x7cs1_vss_m1\x7cs2_vss_m1\x7cs3_vss_m1\x7cs4_vss_m1\x7csb_vss\x7csr1_vss\x7csr2_vss\x7csr3_vss\x7csr4_vss\x7csv_vss\x7ctg_d_vss\x7ctg_fbm_vss\x7ctg_fbs_vss\x7ctg_s_vss\x7cvss\x7cvss_link\x7cvss_link_bridge\x7cvss_link_dip\x7cvss_link_m1\x7cvss_x1\x7cvss_x2\x7cvss_x3__t155
+ g_vss_m1|inv_clk_vss|inv_mc_vss|inv_q_vss|mph_g|nand_m_vss|nand_s2_vss|s1_vss_m1|s2_vss_m1|s3_vss_m1|s4_vss_m1|sb_vss|sr1_vss|sr2_vss|sr3_vss|sr4_vss|sv_vss|tg_d_vss|tg_fbm_vss|tg_fbs_vss|tg_s_vss|vss|vss_link|vss_link_bridge|vss_link_dip|vss_link_m1|vss_x1|vss_x2|vss_x3
+ 128.339356313
* device instance g_vss_m1_inv_clk_vss_inv_mc_vss_inv_q_vss_mph_g_nand_m_vss_nand_s2_vss_s1_vss_m1_s2_vss_m1_s3_vss_m1_s4_vss_m1_sb_vss_sr1_vss_sr2_vss_sr3_vss_sr4_vss_sv_vss_tg_d_vss_tg_fbm_vss_tg_fbs_vss_tg_s_vss_vss_vss_link_vss_link_bridge_vss_link_dip_vss_link_m1_vss_x1_vss_x2_vss_x3_t156 r0 *1 0,0
Rg_vss_m1_inv_clk_vss_inv_mc_vss_inv_q_vss_mph_g_nand_m_vss_nand_s2_vss_s1_vss_m1_s2_vss_m1_s3_vss_m1_s4_vss_m1_sb_vss_sr1_vss_sr2_vss_sr3_vss_sr4_vss_sv_vss_tg_d_vss_tg_fbm_vss_tg_fbs_vss_tg_s_vss_vss_vss_link_vss_link_bridge_vss_link_dip_vss_link_m1_vss_x1_vss_x2_vss_x3_t156
+ g_vss_m1\x7cinv_clk_vss\x7cinv_mc_vss\x7cinv_q_vss\x7cmph_g\x7cnand_m_vss\x7cnand_s2_vss\x7cs1_vss_m1\x7cs2_vss_m1\x7cs3_vss_m1\x7cs4_vss_m1\x7csb_vss\x7csr1_vss\x7csr2_vss\x7csr3_vss\x7csr4_vss\x7csv_vss\x7ctg_d_vss\x7ctg_fbm_vss\x7ctg_fbs_vss\x7ctg_s_vss\x7cvss\x7cvss_link\x7cvss_link_bridge\x7cvss_link_dip\x7cvss_link_m1\x7cvss_x1\x7cvss_x2\x7cvss_x3__t156
+ g_vss_m1|inv_clk_vss|inv_mc_vss|inv_q_vss|mph_g|nand_m_vss|nand_s2_vss|s1_vss_m1|s2_vss_m1|s3_vss_m1|s4_vss_m1|sb_vss|sr1_vss|sr2_vss|sr3_vss|sr4_vss|sv_vss|tg_d_vss|tg_fbm_vss|tg_fbs_vss|tg_s_vss|vss|vss_link|vss_link_bridge|vss_link_dip|vss_link_m1|vss_x1|vss_x2|vss_x3
+ 139.611375776
* device instance g_vss_m1_inv_clk_vss_inv_mc_vss_inv_q_vss_mph_g_nand_m_vss_nand_s2_vss_s1_vss_m1_s2_vss_m1_s3_vss_m1_s4_vss_m1_sb_vss_sr1_vss_sr2_vss_sr3_vss_sr4_vss_sv_vss_tg_d_vss_tg_fbm_vss_tg_fbs_vss_tg_s_vss_vss_vss_link_vss_link_bridge_vss_link_dip_vss_link_m1_vss_x1_vss_x2_vss_x3_t157 r0 *1 0,0
Rg_vss_m1_inv_clk_vss_inv_mc_vss_inv_q_vss_mph_g_nand_m_vss_nand_s2_vss_s1_vss_m1_s2_vss_m1_s3_vss_m1_s4_vss_m1_sb_vss_sr1_vss_sr2_vss_sr3_vss_sr4_vss_sv_vss_tg_d_vss_tg_fbm_vss_tg_fbs_vss_tg_s_vss_vss_vss_link_vss_link_bridge_vss_link_dip_vss_link_m1_vss_x1_vss_x2_vss_x3_t157
+ g_vss_m1\x7cinv_clk_vss\x7cinv_mc_vss\x7cinv_q_vss\x7cmph_g\x7cnand_m_vss\x7cnand_s2_vss\x7cs1_vss_m1\x7cs2_vss_m1\x7cs3_vss_m1\x7cs4_vss_m1\x7csb_vss\x7csr1_vss\x7csr2_vss\x7csr3_vss\x7csr4_vss\x7csv_vss\x7ctg_d_vss\x7ctg_fbm_vss\x7ctg_fbs_vss\x7ctg_s_vss\x7cvss\x7cvss_link\x7cvss_link_bridge\x7cvss_link_dip\x7cvss_link_m1\x7cvss_x1\x7cvss_x2\x7cvss_x3__t157
+ g_vss_m1|inv_clk_vss|inv_mc_vss|inv_q_vss|mph_g|nand_m_vss|nand_s2_vss|s1_vss_m1|s2_vss_m1|s3_vss_m1|s4_vss_m1|sb_vss|sr1_vss|sr2_vss|sr3_vss|sr4_vss|sv_vss|tg_d_vss|tg_fbm_vss|tg_fbs_vss|tg_s_vss|vss|vss_link|vss_link_bridge|vss_link_dip|vss_link_m1|vss_x1|vss_x2|vss_x3
+ 160.377312379
* device instance g_vss_m1_inv_clk_vss_inv_mc_vss_inv_q_vss_mph_g_nand_m_vss_nand_s2_vss_s1_vss_m1_s2_vss_m1_s3_vss_m1_s4_vss_m1_sb_vss_sr1_vss_sr2_vss_sr3_vss_sr4_vss_sv_vss_tg_d_vss_tg_fbm_vss_tg_fbs_vss_tg_s_vss_vss_vss_link_vss_link_bridge_vss_link_dip_vss_link_m1_vss_x1_vss_x2_vss_x3_t158 r0 *1 0,0
Rg_vss_m1_inv_clk_vss_inv_mc_vss_inv_q_vss_mph_g_nand_m_vss_nand_s2_vss_s1_vss_m1_s2_vss_m1_s3_vss_m1_s4_vss_m1_sb_vss_sr1_vss_sr2_vss_sr3_vss_sr4_vss_sv_vss_tg_d_vss_tg_fbm_vss_tg_fbs_vss_tg_s_vss_vss_vss_link_vss_link_bridge_vss_link_dip_vss_link_m1_vss_x1_vss_x2_vss_x3_t158
+ g_vss_m1\x7cinv_clk_vss\x7cinv_mc_vss\x7cinv_q_vss\x7cmph_g\x7cnand_m_vss\x7cnand_s2_vss\x7cs1_vss_m1\x7cs2_vss_m1\x7cs3_vss_m1\x7cs4_vss_m1\x7csb_vss\x7csr1_vss\x7csr2_vss\x7csr3_vss\x7csr4_vss\x7csv_vss\x7ctg_d_vss\x7ctg_fbm_vss\x7ctg_fbs_vss\x7ctg_s_vss\x7cvss\x7cvss_link\x7cvss_link_bridge\x7cvss_link_dip\x7cvss_link_m1\x7cvss_x1\x7cvss_x2\x7cvss_x3__t158
+ g_vss_m1|inv_clk_vss|inv_mc_vss|inv_q_vss|mph_g|nand_m_vss|nand_s2_vss|s1_vss_m1|s2_vss_m1|s3_vss_m1|s4_vss_m1|sb_vss|sr1_vss|sr2_vss|sr3_vss|sr4_vss|sv_vss|tg_d_vss|tg_fbm_vss|tg_fbs_vss|tg_s_vss|vss|vss_link|vss_link_bridge|vss_link_dip|vss_link_m1|vss_x1|vss_x2|vss_x3
+ 172.348518182
* device instance g_vss_m1_inv_clk_vss_inv_mc_vss_inv_q_vss_mph_g_nand_m_vss_nand_s2_vss_s1_vss_m1_s2_vss_m1_s3_vss_m1_s4_vss_m1_sb_vss_sr1_vss_sr2_vss_sr3_vss_sr4_vss_sv_vss_tg_d_vss_tg_fbm_vss_tg_fbs_vss_tg_s_vss_vss_vss_link_vss_link_bridge_vss_link_dip_vss_link_m1_vss_x1_vss_x2_vss_x3_t159 r0 *1 0,0
Rg_vss_m1_inv_clk_vss_inv_mc_vss_inv_q_vss_mph_g_nand_m_vss_nand_s2_vss_s1_vss_m1_s2_vss_m1_s3_vss_m1_s4_vss_m1_sb_vss_sr1_vss_sr2_vss_sr3_vss_sr4_vss_sv_vss_tg_d_vss_tg_fbm_vss_tg_fbs_vss_tg_s_vss_vss_vss_link_vss_link_bridge_vss_link_dip_vss_link_m1_vss_x1_vss_x2_vss_x3_t159
+ g_vss_m1\x7cinv_clk_vss\x7cinv_mc_vss\x7cinv_q_vss\x7cmph_g\x7cnand_m_vss\x7cnand_s2_vss\x7cs1_vss_m1\x7cs2_vss_m1\x7cs3_vss_m1\x7cs4_vss_m1\x7csb_vss\x7csr1_vss\x7csr2_vss\x7csr3_vss\x7csr4_vss\x7csv_vss\x7ctg_d_vss\x7ctg_fbm_vss\x7ctg_fbs_vss\x7ctg_s_vss\x7cvss\x7cvss_link\x7cvss_link_bridge\x7cvss_link_dip\x7cvss_link_m1\x7cvss_x1\x7cvss_x2\x7cvss_x3__t159
+ g_vss_m1|inv_clk_vss|inv_mc_vss|inv_q_vss|mph_g|nand_m_vss|nand_s2_vss|s1_vss_m1|s2_vss_m1|s3_vss_m1|s4_vss_m1|sb_vss|sr1_vss|sr2_vss|sr3_vss|sr4_vss|sv_vss|tg_d_vss|tg_fbm_vss|tg_fbs_vss|tg_s_vss|vss|vss_link|vss_link_bridge|vss_link_dip|vss_link_m1|vss_x1|vss_x2|vss_x3
+ 180.310360261
* device instance g_vss_m1_inv_clk_vss_inv_mc_vss_inv_q_vss_mph_g_nand_m_vss_nand_s2_vss_s1_vss_m1_s2_vss_m1_s3_vss_m1_s4_vss_m1_sb_vss_sr1_vss_sr2_vss_sr3_vss_sr4_vss_sv_vss_tg_d_vss_tg_fbm_vss_tg_fbs_vss_tg_s_vss_vss_vss_link_vss_link_bridge_vss_link_dip_vss_link_m1_vss_x1_vss_x2_vss_x3_t160 r0 *1 0,0
Rg_vss_m1_inv_clk_vss_inv_mc_vss_inv_q_vss_mph_g_nand_m_vss_nand_s2_vss_s1_vss_m1_s2_vss_m1_s3_vss_m1_s4_vss_m1_sb_vss_sr1_vss_sr2_vss_sr3_vss_sr4_vss_sv_vss_tg_d_vss_tg_fbm_vss_tg_fbs_vss_tg_s_vss_vss_vss_link_vss_link_bridge_vss_link_dip_vss_link_m1_vss_x1_vss_x2_vss_x3_t160
+ g_vss_m1\x7cinv_clk_vss\x7cinv_mc_vss\x7cinv_q_vss\x7cmph_g\x7cnand_m_vss\x7cnand_s2_vss\x7cs1_vss_m1\x7cs2_vss_m1\x7cs3_vss_m1\x7cs4_vss_m1\x7csb_vss\x7csr1_vss\x7csr2_vss\x7csr3_vss\x7csr4_vss\x7csv_vss\x7ctg_d_vss\x7ctg_fbm_vss\x7ctg_fbs_vss\x7ctg_s_vss\x7cvss\x7cvss_link\x7cvss_link_bridge\x7cvss_link_dip\x7cvss_link_m1\x7cvss_x1\x7cvss_x2\x7cvss_x3__t160
+ g_vss_m1|inv_clk_vss|inv_mc_vss|inv_q_vss|mph_g|nand_m_vss|nand_s2_vss|s1_vss_m1|s2_vss_m1|s3_vss_m1|s4_vss_m1|sb_vss|sr1_vss|sr2_vss|sr3_vss|sr4_vss|sv_vss|tg_d_vss|tg_fbm_vss|tg_fbs_vss|tg_s_vss|vss|vss_link|vss_link_bridge|vss_link_dip|vss_link_m1|vss_x1|vss_x2|vss_x3
+ 204.625072758
* device instance g_vss_m1_inv_clk_vss_inv_mc_vss_inv_q_vss_mph_g_nand_m_vss_nand_s2_vss_s1_vss_m1_s2_vss_m1_s3_vss_m1_s4_vss_m1_sb_vss_sr1_vss_sr2_vss_sr3_vss_sr4_vss_sv_vss_tg_d_vss_tg_fbm_vss_tg_fbs_vss_tg_s_vss_vss_vss_link_vss_link_bridge_vss_link_dip_vss_link_m1_vss_x1_vss_x2_vss_x3_t161 r0 *1 0,0
Rg_vss_m1_inv_clk_vss_inv_mc_vss_inv_q_vss_mph_g_nand_m_vss_nand_s2_vss_s1_vss_m1_s2_vss_m1_s3_vss_m1_s4_vss_m1_sb_vss_sr1_vss_sr2_vss_sr3_vss_sr4_vss_sv_vss_tg_d_vss_tg_fbm_vss_tg_fbs_vss_tg_s_vss_vss_vss_link_vss_link_bridge_vss_link_dip_vss_link_m1_vss_x1_vss_x2_vss_x3_t161
+ g_vss_m1\x7cinv_clk_vss\x7cinv_mc_vss\x7cinv_q_vss\x7cmph_g\x7cnand_m_vss\x7cnand_s2_vss\x7cs1_vss_m1\x7cs2_vss_m1\x7cs3_vss_m1\x7cs4_vss_m1\x7csb_vss\x7csr1_vss\x7csr2_vss\x7csr3_vss\x7csr4_vss\x7csv_vss\x7ctg_d_vss\x7ctg_fbm_vss\x7ctg_fbs_vss\x7ctg_s_vss\x7cvss\x7cvss_link\x7cvss_link_bridge\x7cvss_link_dip\x7cvss_link_m1\x7cvss_x1\x7cvss_x2\x7cvss_x3__t161
+ g_vss_m1|inv_clk_vss|inv_mc_vss|inv_q_vss|mph_g|nand_m_vss|nand_s2_vss|s1_vss_m1|s2_vss_m1|s3_vss_m1|s4_vss_m1|sb_vss|sr1_vss|sr2_vss|sr3_vss|sr4_vss|sv_vss|tg_d_vss|tg_fbm_vss|tg_fbs_vss|tg_s_vss|vss|vss_link|vss_link_bridge|vss_link_dip|vss_link_m1|vss_x1|vss_x2|vss_x3
+ 212.61357206
* device instance g_vss_m1_inv_clk_vss_inv_mc_vss_inv_q_vss_mph_g_nand_m_vss_nand_s2_vss_s1_vss_m1_s2_vss_m1_s3_vss_m1_s4_vss_m1_sb_vss_sr1_vss_sr2_vss_sr3_vss_sr4_vss_sv_vss_tg_d_vss_tg_fbm_vss_tg_fbs_vss_tg_s_vss_vss_vss_link_vss_link_bridge_vss_link_dip_vss_link_m1_vss_x1_vss_x2_vss_x3_t162 r0 *1 0,0
Rg_vss_m1_inv_clk_vss_inv_mc_vss_inv_q_vss_mph_g_nand_m_vss_nand_s2_vss_s1_vss_m1_s2_vss_m1_s3_vss_m1_s4_vss_m1_sb_vss_sr1_vss_sr2_vss_sr3_vss_sr4_vss_sv_vss_tg_d_vss_tg_fbm_vss_tg_fbs_vss_tg_s_vss_vss_vss_link_vss_link_bridge_vss_link_dip_vss_link_m1_vss_x1_vss_x2_vss_x3_t162
+ g_vss_m1\x7cinv_clk_vss\x7cinv_mc_vss\x7cinv_q_vss\x7cmph_g\x7cnand_m_vss\x7cnand_s2_vss\x7cs1_vss_m1\x7cs2_vss_m1\x7cs3_vss_m1\x7cs4_vss_m1\x7csb_vss\x7csr1_vss\x7csr2_vss\x7csr3_vss\x7csr4_vss\x7csv_vss\x7ctg_d_vss\x7ctg_fbm_vss\x7ctg_fbs_vss\x7ctg_s_vss\x7cvss\x7cvss_link\x7cvss_link_bridge\x7cvss_link_dip\x7cvss_link_m1\x7cvss_x1\x7cvss_x2\x7cvss_x3__t162
+ g_vss_m1|inv_clk_vss|inv_mc_vss|inv_q_vss|mph_g|nand_m_vss|nand_s2_vss|s1_vss_m1|s2_vss_m1|s3_vss_m1|s4_vss_m1|sb_vss|sr1_vss|sr2_vss|sr3_vss|sr4_vss|sv_vss|tg_d_vss|tg_fbm_vss|tg_fbs_vss|tg_s_vss|vss|vss_link|vss_link_bridge|vss_link_dip|vss_link_m1|vss_x1|vss_x2|vss_x3
+ 221.236144068
* device instance g_vss_m1_inv_clk_vss_inv_mc_vss_inv_q_vss_mph_g_nand_m_vss_nand_s2_vss_s1_vss_m1_s2_vss_m1_s3_vss_m1_s4_vss_m1_sb_vss_sr1_vss_sr2_vss_sr3_vss_sr4_vss_sv_vss_tg_d_vss_tg_fbm_vss_tg_fbs_vss_tg_s_vss_vss_vss_link_vss_link_bridge_vss_link_dip_vss_link_m1_vss_x1_vss_x2_vss_x3_t163 r0 *1 0,0
Rg_vss_m1_inv_clk_vss_inv_mc_vss_inv_q_vss_mph_g_nand_m_vss_nand_s2_vss_s1_vss_m1_s2_vss_m1_s3_vss_m1_s4_vss_m1_sb_vss_sr1_vss_sr2_vss_sr3_vss_sr4_vss_sv_vss_tg_d_vss_tg_fbm_vss_tg_fbs_vss_tg_s_vss_vss_vss_link_vss_link_bridge_vss_link_dip_vss_link_m1_vss_x1_vss_x2_vss_x3_t163
+ g_vss_m1\x7cinv_clk_vss\x7cinv_mc_vss\x7cinv_q_vss\x7cmph_g\x7cnand_m_vss\x7cnand_s2_vss\x7cs1_vss_m1\x7cs2_vss_m1\x7cs3_vss_m1\x7cs4_vss_m1\x7csb_vss\x7csr1_vss\x7csr2_vss\x7csr3_vss\x7csr4_vss\x7csv_vss\x7ctg_d_vss\x7ctg_fbm_vss\x7ctg_fbs_vss\x7ctg_s_vss\x7cvss\x7cvss_link\x7cvss_link_bridge\x7cvss_link_dip\x7cvss_link_m1\x7cvss_x1\x7cvss_x2\x7cvss_x3__t163
+ g_vss_m1|inv_clk_vss|inv_mc_vss|inv_q_vss|mph_g|nand_m_vss|nand_s2_vss|s1_vss_m1|s2_vss_m1|s3_vss_m1|s4_vss_m1|sb_vss|sr1_vss|sr2_vss|sr3_vss|sr4_vss|sv_vss|tg_d_vss|tg_fbm_vss|tg_fbs_vss|tg_s_vss|vss|vss_link|vss_link_bridge|vss_link_dip|vss_link_m1|vss_x1|vss_x2|vss_x3
+ 232.659390096
* device instance g_vss_m1_inv_clk_vss_inv_mc_vss_inv_q_vss_mph_g_nand_m_vss_nand_s2_vss_s1_vss_m1_s2_vss_m1_s3_vss_m1_s4_vss_m1_sb_vss_sr1_vss_sr2_vss_sr3_vss_sr4_vss_sv_vss_tg_d_vss_tg_fbm_vss_tg_fbs_vss_tg_s_vss_vss_vss_link_vss_link_bridge_vss_link_dip_vss_link_m1_vss_x1_vss_x2_vss_x3_t164 r0 *1 0,0
Rg_vss_m1_inv_clk_vss_inv_mc_vss_inv_q_vss_mph_g_nand_m_vss_nand_s2_vss_s1_vss_m1_s2_vss_m1_s3_vss_m1_s4_vss_m1_sb_vss_sr1_vss_sr2_vss_sr3_vss_sr4_vss_sv_vss_tg_d_vss_tg_fbm_vss_tg_fbs_vss_tg_s_vss_vss_vss_link_vss_link_bridge_vss_link_dip_vss_link_m1_vss_x1_vss_x2_vss_x3_t164
+ g_vss_m1\x7cinv_clk_vss\x7cinv_mc_vss\x7cinv_q_vss\x7cmph_g\x7cnand_m_vss\x7cnand_s2_vss\x7cs1_vss_m1\x7cs2_vss_m1\x7cs3_vss_m1\x7cs4_vss_m1\x7csb_vss\x7csr1_vss\x7csr2_vss\x7csr3_vss\x7csr4_vss\x7csv_vss\x7ctg_d_vss\x7ctg_fbm_vss\x7ctg_fbs_vss\x7ctg_s_vss\x7cvss\x7cvss_link\x7cvss_link_bridge\x7cvss_link_dip\x7cvss_link_m1\x7cvss_x1\x7cvss_x2\x7cvss_x3__t164
+ g_vss_m1|inv_clk_vss|inv_mc_vss|inv_q_vss|mph_g|nand_m_vss|nand_s2_vss|s1_vss_m1|s2_vss_m1|s3_vss_m1|s4_vss_m1|sb_vss|sr1_vss|sr2_vss|sr3_vss|sr4_vss|sv_vss|tg_d_vss|tg_fbm_vss|tg_fbs_vss|tg_s_vss|vss|vss_link|vss_link_bridge|vss_link_dip|vss_link_m1|vss_x1|vss_x2|vss_x3
+ 253.636183577
* device instance g_vss_m1_inv_clk_vss_inv_mc_vss_inv_q_vss_mph_g_nand_m_vss_nand_s2_vss_s1_vss_m1_s2_vss_m1_s3_vss_m1_s4_vss_m1_sb_vss_sr1_vss_sr2_vss_sr3_vss_sr4_vss_sv_vss_tg_d_vss_tg_fbm_vss_tg_fbs_vss_tg_s_vss_vss_vss_link_vss_link_bridge_vss_link_dip_vss_link_m1_vss_x1_vss_x2_vss_x3_t165 r0 *1 0,0
Rg_vss_m1_inv_clk_vss_inv_mc_vss_inv_q_vss_mph_g_nand_m_vss_nand_s2_vss_s1_vss_m1_s2_vss_m1_s3_vss_m1_s4_vss_m1_sb_vss_sr1_vss_sr2_vss_sr3_vss_sr4_vss_sv_vss_tg_d_vss_tg_fbm_vss_tg_fbs_vss_tg_s_vss_vss_vss_link_vss_link_bridge_vss_link_dip_vss_link_m1_vss_x1_vss_x2_vss_x3_t165
+ g_vss_m1\x7cinv_clk_vss\x7cinv_mc_vss\x7cinv_q_vss\x7cmph_g\x7cnand_m_vss\x7cnand_s2_vss\x7cs1_vss_m1\x7cs2_vss_m1\x7cs3_vss_m1\x7cs4_vss_m1\x7csb_vss\x7csr1_vss\x7csr2_vss\x7csr3_vss\x7csr4_vss\x7csv_vss\x7ctg_d_vss\x7ctg_fbm_vss\x7ctg_fbs_vss\x7ctg_s_vss\x7cvss\x7cvss_link\x7cvss_link_bridge\x7cvss_link_dip\x7cvss_link_m1\x7cvss_x1\x7cvss_x2\x7cvss_x3__t165
+ g_vss_m1|inv_clk_vss|inv_mc_vss|inv_q_vss|mph_g|nand_m_vss|nand_s2_vss|s1_vss_m1|s2_vss_m1|s3_vss_m1|s4_vss_m1|sb_vss|sr1_vss|sr2_vss|sr3_vss|sr4_vss|sv_vss|tg_d_vss|tg_fbm_vss|tg_fbs_vss|tg_s_vss|vss|vss_link|vss_link_bridge|vss_link_dip|vss_link_m1|vss_x1|vss_x2|vss_x3
+ 265.700492017
* device instance g_vss_m1_inv_clk_vss_inv_mc_vss_inv_q_vss_mph_g_nand_m_vss_nand_s2_vss_s1_vss_m1_s2_vss_m1_s3_vss_m1_s4_vss_m1_sb_vss_sr1_vss_sr2_vss_sr3_vss_sr4_vss_sv_vss_tg_d_vss_tg_fbm_vss_tg_fbs_vss_tg_s_vss_vss_vss_link_vss_link_bridge_vss_link_dip_vss_link_m1_vss_x1_vss_x2_vss_x3_t166 r0 *1 0,0
Rg_vss_m1_inv_clk_vss_inv_mc_vss_inv_q_vss_mph_g_nand_m_vss_nand_s2_vss_s1_vss_m1_s2_vss_m1_s3_vss_m1_s4_vss_m1_sb_vss_sr1_vss_sr2_vss_sr3_vss_sr4_vss_sv_vss_tg_d_vss_tg_fbm_vss_tg_fbs_vss_tg_s_vss_vss_vss_link_vss_link_bridge_vss_link_dip_vss_link_m1_vss_x1_vss_x2_vss_x3_t166
+ g_vss_m1\x7cinv_clk_vss\x7cinv_mc_vss\x7cinv_q_vss\x7cmph_g\x7cnand_m_vss\x7cnand_s2_vss\x7cs1_vss_m1\x7cs2_vss_m1\x7cs3_vss_m1\x7cs4_vss_m1\x7csb_vss\x7csr1_vss\x7csr2_vss\x7csr3_vss\x7csr4_vss\x7csv_vss\x7ctg_d_vss\x7ctg_fbm_vss\x7ctg_fbs_vss\x7ctg_s_vss\x7cvss\x7cvss_link\x7cvss_link_bridge\x7cvss_link_dip\x7cvss_link_m1\x7cvss_x1\x7cvss_x2\x7cvss_x3__t166
+ g_vss_m1|inv_clk_vss|inv_mc_vss|inv_q_vss|mph_g|nand_m_vss|nand_s2_vss|s1_vss_m1|s2_vss_m1|s3_vss_m1|s4_vss_m1|sb_vss|sr1_vss|sr2_vss|sr3_vss|sr4_vss|sv_vss|tg_d_vss|tg_fbm_vss|tg_fbs_vss|tg_s_vss|vss|vss_link|vss_link_bridge|vss_link_dip|vss_link_m1|vss_x1|vss_x2|vss_x3
+ 273.715679195
* device instance g_vss_m1_inv_clk_vss_inv_mc_vss_inv_q_vss_mph_g_nand_m_vss_nand_s2_vss_s1_vss_m1_s2_vss_m1_s3_vss_m1_s4_vss_m1_sb_vss_sr1_vss_sr2_vss_sr3_vss_sr4_vss_sv_vss_tg_d_vss_tg_fbm_vss_tg_fbs_vss_tg_s_vss_vss_vss_link_vss_link_bridge_vss_link_dip_vss_link_m1_vss_x1_vss_x2_vss_x3_t167 r0 *1 0,0
Rg_vss_m1_inv_clk_vss_inv_mc_vss_inv_q_vss_mph_g_nand_m_vss_nand_s2_vss_s1_vss_m1_s2_vss_m1_s3_vss_m1_s4_vss_m1_sb_vss_sr1_vss_sr2_vss_sr3_vss_sr4_vss_sv_vss_tg_d_vss_tg_fbm_vss_tg_fbs_vss_tg_s_vss_vss_vss_link_vss_link_bridge_vss_link_dip_vss_link_m1_vss_x1_vss_x2_vss_x3_t167
+ g_vss_m1\x7cinv_clk_vss\x7cinv_mc_vss\x7cinv_q_vss\x7cmph_g\x7cnand_m_vss\x7cnand_s2_vss\x7cs1_vss_m1\x7cs2_vss_m1\x7cs3_vss_m1\x7cs4_vss_m1\x7csb_vss\x7csr1_vss\x7csr2_vss\x7csr3_vss\x7csr4_vss\x7csv_vss\x7ctg_d_vss\x7ctg_fbm_vss\x7ctg_fbs_vss\x7ctg_s_vss\x7cvss\x7cvss_link\x7cvss_link_bridge\x7cvss_link_dip\x7cvss_link_m1\x7cvss_x1\x7cvss_x2\x7cvss_x3__t167
+ g_vss_m1|inv_clk_vss|inv_mc_vss|inv_q_vss|mph_g|nand_m_vss|nand_s2_vss|s1_vss_m1|s2_vss_m1|s3_vss_m1|s4_vss_m1|sb_vss|sr1_vss|sr2_vss|sr3_vss|sr4_vss|sv_vss|tg_d_vss|tg_fbm_vss|tg_fbs_vss|tg_s_vss|vss|vss_link|vss_link_bridge|vss_link_dip|vss_link_m1|vss_x1|vss_x2|vss_x3
+ 298.16128248
* device instance g_vss_m1_inv_clk_vss_inv_mc_vss_inv_q_vss_mph_g_nand_m_vss_nand_s2_vss_s1_vss_m1_s2_vss_m1_s3_vss_m1_s4_vss_m1_sb_vss_sr1_vss_sr2_vss_sr3_vss_sr4_vss_sv_vss_tg_d_vss_tg_fbm_vss_tg_fbs_vss_tg_s_vss_vss_vss_link_vss_link_bridge_vss_link_dip_vss_link_m1_vss_x1_vss_x2_vss_x3_t168 r0 *1 0,0
Rg_vss_m1_inv_clk_vss_inv_mc_vss_inv_q_vss_mph_g_nand_m_vss_nand_s2_vss_s1_vss_m1_s2_vss_m1_s3_vss_m1_s4_vss_m1_sb_vss_sr1_vss_sr2_vss_sr3_vss_sr4_vss_sv_vss_tg_d_vss_tg_fbm_vss_tg_fbs_vss_tg_s_vss_vss_vss_link_vss_link_bridge_vss_link_dip_vss_link_m1_vss_x1_vss_x2_vss_x3_t168
+ g_vss_m1\x7cinv_clk_vss\x7cinv_mc_vss\x7cinv_q_vss\x7cmph_g\x7cnand_m_vss\x7cnand_s2_vss\x7cs1_vss_m1\x7cs2_vss_m1\x7cs3_vss_m1\x7cs4_vss_m1\x7csb_vss\x7csr1_vss\x7csr2_vss\x7csr3_vss\x7csr4_vss\x7csv_vss\x7ctg_d_vss\x7ctg_fbm_vss\x7ctg_fbs_vss\x7ctg_s_vss\x7cvss\x7cvss_link\x7cvss_link_bridge\x7cvss_link_dip\x7cvss_link_m1\x7cvss_x1\x7cvss_x2\x7cvss_x3__t168
+ g_vss_m1|inv_clk_vss|inv_mc_vss|inv_q_vss|mph_g|nand_m_vss|nand_s2_vss|s1_vss_m1|s2_vss_m1|s3_vss_m1|s4_vss_m1|sb_vss|sr1_vss|sr2_vss|sr3_vss|sr4_vss|sv_vss|tg_d_vss|tg_fbm_vss|tg_fbs_vss|tg_s_vss|vss|vss_link|vss_link_bridge|vss_link_dip|vss_link_m1|vss_x1|vss_x2|vss_x3
+ 306.184533042
* device instance g_vss_m1_inv_clk_vss_inv_mc_vss_inv_q_vss_mph_g_nand_m_vss_nand_s2_vss_s1_vss_m1_s2_vss_m1_s3_vss_m1_s4_vss_m1_sb_vss_sr1_vss_sr2_vss_sr3_vss_sr4_vss_sv_vss_tg_d_vss_tg_fbm_vss_tg_fbs_vss_tg_s_vss_vss_vss_link_vss_link_bridge_vss_link_dip_vss_link_m1_vss_x1_vss_x2_vss_x3_t169 r0 *1 0,0
Rg_vss_m1_inv_clk_vss_inv_mc_vss_inv_q_vss_mph_g_nand_m_vss_nand_s2_vss_s1_vss_m1_s2_vss_m1_s3_vss_m1_s4_vss_m1_sb_vss_sr1_vss_sr2_vss_sr3_vss_sr4_vss_sv_vss_tg_d_vss_tg_fbm_vss_tg_fbs_vss_tg_s_vss_vss_vss_link_vss_link_bridge_vss_link_dip_vss_link_m1_vss_x1_vss_x2_vss_x3_t169
+ g_vss_m1\x7cinv_clk_vss\x7cinv_mc_vss\x7cinv_q_vss\x7cmph_g\x7cnand_m_vss\x7cnand_s2_vss\x7cs1_vss_m1\x7cs2_vss_m1\x7cs3_vss_m1\x7cs4_vss_m1\x7csb_vss\x7csr1_vss\x7csr2_vss\x7csr3_vss\x7csr4_vss\x7csv_vss\x7ctg_d_vss\x7ctg_fbm_vss\x7ctg_fbs_vss\x7ctg_s_vss\x7cvss\x7cvss_link\x7cvss_link_bridge\x7cvss_link_dip\x7cvss_link_m1\x7cvss_x1\x7cvss_x2\x7cvss_x3__t169
+ g_vss_m1|inv_clk_vss|inv_mc_vss|inv_q_vss|mph_g|nand_m_vss|nand_s2_vss|s1_vss_m1|s2_vss_m1|s3_vss_m1|s4_vss_m1|sb_vss|sr1_vss|sr2_vss|sr3_vss|sr4_vss|sv_vss|tg_d_vss|tg_fbm_vss|tg_fbs_vss|tg_s_vss|vss|vss_link|vss_link_bridge|vss_link_dip|vss_link_m1|vss_x1|vss_x2|vss_x3
+ 314.841008108
* device instance g_vss_m1_inv_clk_vss_inv_mc_vss_inv_q_vss_mph_g_nand_m_vss_nand_s2_vss_s1_vss_m1_s2_vss_m1_s3_vss_m1_s4_vss_m1_sb_vss_sr1_vss_sr2_vss_sr3_vss_sr4_vss_sv_vss_tg_d_vss_tg_fbm_vss_tg_fbs_vss_tg_s_vss_vss_vss_link_vss_link_bridge_vss_link_dip_vss_link_m1_vss_x1_vss_x2_vss_x3_t170 r0 *1 0,0
Rg_vss_m1_inv_clk_vss_inv_mc_vss_inv_q_vss_mph_g_nand_m_vss_nand_s2_vss_s1_vss_m1_s2_vss_m1_s3_vss_m1_s4_vss_m1_sb_vss_sr1_vss_sr2_vss_sr3_vss_sr4_vss_sv_vss_tg_d_vss_tg_fbm_vss_tg_fbs_vss_tg_s_vss_vss_vss_link_vss_link_bridge_vss_link_dip_vss_link_m1_vss_x1_vss_x2_vss_x3_t170
+ g_vss_m1\x7cinv_clk_vss\x7cinv_mc_vss\x7cinv_q_vss\x7cmph_g\x7cnand_m_vss\x7cnand_s2_vss\x7cs1_vss_m1\x7cs2_vss_m1\x7cs3_vss_m1\x7cs4_vss_m1\x7csb_vss\x7csr1_vss\x7csr2_vss\x7csr3_vss\x7csr4_vss\x7csv_vss\x7ctg_d_vss\x7ctg_fbm_vss\x7ctg_fbs_vss\x7ctg_s_vss\x7cvss\x7cvss_link\x7cvss_link_bridge\x7cvss_link_dip\x7cvss_link_m1\x7cvss_x1\x7cvss_x2\x7cvss_x3__t170
+ g_vss_m1|inv_clk_vss|inv_mc_vss|inv_q_vss|mph_g|nand_m_vss|nand_s2_vss|s1_vss_m1|s2_vss_m1|s3_vss_m1|s4_vss_m1|sb_vss|sr1_vss|sr2_vss|sr3_vss|sr4_vss|sv_vss|tg_d_vss|tg_fbm_vss|tg_fbs_vss|tg_s_vss|vss|vss_link|vss_link_bridge|vss_link_dip|vss_link_m1|vss_x1|vss_x2|vss_x3
+ 326.304206584
* device instance g_vss_m1_inv_clk_vss_inv_mc_vss_inv_q_vss_mph_g_nand_m_vss_nand_s2_vss_s1_vss_m1_s2_vss_m1_s3_vss_m1_s4_vss_m1_sb_vss_sr1_vss_sr2_vss_sr3_vss_sr4_vss_sv_vss_tg_d_vss_tg_fbm_vss_tg_fbs_vss_tg_s_vss_vss_vss_link_vss_link_bridge_vss_link_dip_vss_link_m1_vss_x1_vss_x2_vss_x3_t171 r0 *1 0,0
Rg_vss_m1_inv_clk_vss_inv_mc_vss_inv_q_vss_mph_g_nand_m_vss_nand_s2_vss_s1_vss_m1_s2_vss_m1_s3_vss_m1_s4_vss_m1_sb_vss_sr1_vss_sr2_vss_sr3_vss_sr4_vss_sv_vss_tg_d_vss_tg_fbm_vss_tg_fbs_vss_tg_s_vss_vss_vss_link_vss_link_bridge_vss_link_dip_vss_link_m1_vss_x1_vss_x2_vss_x3_t171
+ g_vss_m1\x7cinv_clk_vss\x7cinv_mc_vss\x7cinv_q_vss\x7cmph_g\x7cnand_m_vss\x7cnand_s2_vss\x7cs1_vss_m1\x7cs2_vss_m1\x7cs3_vss_m1\x7cs4_vss_m1\x7csb_vss\x7csr1_vss\x7csr2_vss\x7csr3_vss\x7csr4_vss\x7csv_vss\x7ctg_d_vss\x7ctg_fbm_vss\x7ctg_fbs_vss\x7ctg_s_vss\x7cvss\x7cvss_link\x7cvss_link_bridge\x7cvss_link_dip\x7cvss_link_m1\x7cvss_x1\x7cvss_x2\x7cvss_x3__t171
+ g_vss_m1|inv_clk_vss|inv_mc_vss|inv_q_vss|mph_g|nand_m_vss|nand_s2_vss|s1_vss_m1|s2_vss_m1|s3_vss_m1|s4_vss_m1|sb_vss|sr1_vss|sr2_vss|sr3_vss|sr4_vss|sv_vss|tg_d_vss|tg_fbm_vss|tg_fbs_vss|tg_s_vss|vss|vss_link|vss_link_bridge|vss_link_dip|vss_link_m1|vss_x1|vss_x2|vss_x3
+ 347.342385542
* device instance g_vss_m1_inv_clk_vss_inv_mc_vss_inv_q_vss_mph_g_nand_m_vss_nand_s2_vss_s1_vss_m1_s2_vss_m1_s3_vss_m1_s4_vss_m1_sb_vss_sr1_vss_sr2_vss_sr3_vss_sr4_vss_sv_vss_tg_d_vss_tg_fbm_vss_tg_fbs_vss_tg_s_vss_vss_vss_link_vss_link_bridge_vss_link_dip_vss_link_m1_vss_x1_vss_x2_vss_x3_t172 r0 *1 0,0
Rg_vss_m1_inv_clk_vss_inv_mc_vss_inv_q_vss_mph_g_nand_m_vss_nand_s2_vss_s1_vss_m1_s2_vss_m1_s3_vss_m1_s4_vss_m1_sb_vss_sr1_vss_sr2_vss_sr3_vss_sr4_vss_sv_vss_tg_d_vss_tg_fbm_vss_tg_fbs_vss_tg_s_vss_vss_vss_link_vss_link_bridge_vss_link_dip_vss_link_m1_vss_x1_vss_x2_vss_x3_t172
+ g_vss_m1\x7cinv_clk_vss\x7cinv_mc_vss\x7cinv_q_vss\x7cmph_g\x7cnand_m_vss\x7cnand_s2_vss\x7cs1_vss_m1\x7cs2_vss_m1\x7cs3_vss_m1\x7cs4_vss_m1\x7csb_vss\x7csr1_vss\x7csr2_vss\x7csr3_vss\x7csr4_vss\x7csv_vss\x7ctg_d_vss\x7ctg_fbm_vss\x7ctg_fbs_vss\x7ctg_s_vss\x7cvss\x7cvss_link\x7cvss_link_bridge\x7cvss_link_dip\x7cvss_link_m1\x7cvss_x1\x7cvss_x2\x7cvss_x3__t172
+ g_vss_m1|inv_clk_vss|inv_mc_vss|inv_q_vss|mph_g|nand_m_vss|nand_s2_vss|s1_vss_m1|s2_vss_m1|s3_vss_m1|s4_vss_m1|sb_vss|sr1_vss|sr2_vss|sr3_vss|sr4_vss|sv_vss|tg_d_vss|tg_fbm_vss|tg_fbs_vss|tg_s_vss|vss|vss_link|vss_link_bridge|vss_link_dip|vss_link_m1|vss_x1|vss_x2|vss_x3
+ 181.667303371
* device instance g_vss_m1_inv_clk_vss_inv_mc_vss_inv_q_vss_mph_g_nand_m_vss_nand_s2_vss_s1_vss_m1_s2_vss_m1_s3_vss_m1_s4_vss_m1_sb_vss_sr1_vss_sr2_vss_sr3_vss_sr4_vss_sv_vss_tg_d_vss_tg_fbm_vss_tg_fbs_vss_tg_s_vss_vss_vss_link_vss_link_bridge_vss_link_dip_vss_link_m1_vss_x1_vss_x2_vss_x3_t173 r0 *1 0,0
Rg_vss_m1_inv_clk_vss_inv_mc_vss_inv_q_vss_mph_g_nand_m_vss_nand_s2_vss_s1_vss_m1_s2_vss_m1_s3_vss_m1_s4_vss_m1_sb_vss_sr1_vss_sr2_vss_sr3_vss_sr4_vss_sv_vss_tg_d_vss_tg_fbm_vss_tg_fbs_vss_tg_s_vss_vss_vss_link_vss_link_bridge_vss_link_dip_vss_link_m1_vss_x1_vss_x2_vss_x3_t173
+ g_vss_m1\x7cinv_clk_vss\x7cinv_mc_vss\x7cinv_q_vss\x7cmph_g\x7cnand_m_vss\x7cnand_s2_vss\x7cs1_vss_m1\x7cs2_vss_m1\x7cs3_vss_m1\x7cs4_vss_m1\x7csb_vss\x7csr1_vss\x7csr2_vss\x7csr3_vss\x7csr4_vss\x7csv_vss\x7ctg_d_vss\x7ctg_fbm_vss\x7ctg_fbs_vss\x7ctg_s_vss\x7cvss\x7cvss_link\x7cvss_link_bridge\x7cvss_link_dip\x7cvss_link_m1\x7cvss_x1\x7cvss_x2\x7cvss_x3__t173
+ g_vss_m1|inv_clk_vss|inv_mc_vss|inv_q_vss|mph_g|nand_m_vss|nand_s2_vss|s1_vss_m1|s2_vss_m1|s3_vss_m1|s4_vss_m1|sb_vss|sr1_vss|sr2_vss|sr3_vss|sr4_vss|sv_vss|tg_d_vss|tg_fbm_vss|tg_fbs_vss|tg_s_vss|vss|vss_link|vss_link_bridge|vss_link_dip|vss_link_m1|vss_x1|vss_x2|vss_x3
+ 167.888132853
* device instance g_vss_m1_inv_clk_vss_inv_mc_vss_inv_q_vss_mph_g_nand_m_vss_nand_s2_vss_s1_vss_m1_s2_vss_m1_s3_vss_m1_s4_vss_m1_sb_vss_sr1_vss_sr2_vss_sr3_vss_sr4_vss_sv_vss_tg_d_vss_tg_fbm_vss_tg_fbs_vss_tg_s_vss_vss_vss_link_vss_link_bridge_vss_link_dip_vss_link_m1_vss_x1_vss_x2_vss_x3_t174 r0 *1 0,0
Rg_vss_m1_inv_clk_vss_inv_mc_vss_inv_q_vss_mph_g_nand_m_vss_nand_s2_vss_s1_vss_m1_s2_vss_m1_s3_vss_m1_s4_vss_m1_sb_vss_sr1_vss_sr2_vss_sr3_vss_sr4_vss_sv_vss_tg_d_vss_tg_fbm_vss_tg_fbs_vss_tg_s_vss_vss_vss_link_vss_link_bridge_vss_link_dip_vss_link_m1_vss_x1_vss_x2_vss_x3_t174
+ g_vss_m1\x7cinv_clk_vss\x7cinv_mc_vss\x7cinv_q_vss\x7cmph_g\x7cnand_m_vss\x7cnand_s2_vss\x7cs1_vss_m1\x7cs2_vss_m1\x7cs3_vss_m1\x7cs4_vss_m1\x7csb_vss\x7csr1_vss\x7csr2_vss\x7csr3_vss\x7csr4_vss\x7csv_vss\x7ctg_d_vss\x7ctg_fbm_vss\x7ctg_fbs_vss\x7ctg_s_vss\x7cvss\x7cvss_link\x7cvss_link_bridge\x7cvss_link_dip\x7cvss_link_m1\x7cvss_x1\x7cvss_x2\x7cvss_x3__t174
+ g_vss_m1|inv_clk_vss|inv_mc_vss|inv_q_vss|mph_g|nand_m_vss|nand_s2_vss|s1_vss_m1|s2_vss_m1|s3_vss_m1|s4_vss_m1|sb_vss|sr1_vss|sr2_vss|sr3_vss|sr4_vss|sv_vss|tg_d_vss|tg_fbm_vss|tg_fbs_vss|tg_s_vss|vss|vss_link|vss_link_bridge|vss_link_dip|vss_link_m1|vss_x1|vss_x2|vss_x3
+ 154.116099267
* device instance g_vss_m1_inv_clk_vss_inv_mc_vss_inv_q_vss_mph_g_nand_m_vss_nand_s2_vss_s1_vss_m1_s2_vss_m1_s3_vss_m1_s4_vss_m1_sb_vss_sr1_vss_sr2_vss_sr3_vss_sr4_vss_sv_vss_tg_d_vss_tg_fbm_vss_tg_fbs_vss_tg_s_vss_vss_vss_link_vss_link_bridge_vss_link_dip_vss_link_m1_vss_x1_vss_x2_vss_x3_t175 r0 *1 0,0
Rg_vss_m1_inv_clk_vss_inv_mc_vss_inv_q_vss_mph_g_nand_m_vss_nand_s2_vss_s1_vss_m1_s2_vss_m1_s3_vss_m1_s4_vss_m1_sb_vss_sr1_vss_sr2_vss_sr3_vss_sr4_vss_sv_vss_tg_d_vss_tg_fbm_vss_tg_fbs_vss_tg_s_vss_vss_vss_link_vss_link_bridge_vss_link_dip_vss_link_m1_vss_x1_vss_x2_vss_x3_t175
+ g_vss_m1\x7cinv_clk_vss\x7cinv_mc_vss\x7cinv_q_vss\x7cmph_g\x7cnand_m_vss\x7cnand_s2_vss\x7cs1_vss_m1\x7cs2_vss_m1\x7cs3_vss_m1\x7cs4_vss_m1\x7csb_vss\x7csr1_vss\x7csr2_vss\x7csr3_vss\x7csr4_vss\x7csv_vss\x7ctg_d_vss\x7ctg_fbm_vss\x7ctg_fbs_vss\x7ctg_s_vss\x7cvss\x7cvss_link\x7cvss_link_bridge\x7cvss_link_dip\x7cvss_link_m1\x7cvss_x1\x7cvss_x2\x7cvss_x3__t175
+ g_vss_m1|inv_clk_vss|inv_mc_vss|inv_q_vss|mph_g|nand_m_vss|nand_s2_vss|s1_vss_m1|s2_vss_m1|s3_vss_m1|s4_vss_m1|sb_vss|sr1_vss|sr2_vss|sr3_vss|sr4_vss|sv_vss|tg_d_vss|tg_fbm_vss|tg_fbs_vss|tg_s_vss|vss|vss_link|vss_link_bridge|vss_link_dip|vss_link_m1|vss_x1|vss_x2|vss_x3
+ 140.353303542
* device instance g_vss_m1_inv_clk_vss_inv_mc_vss_inv_q_vss_mph_g_nand_m_vss_nand_s2_vss_s1_vss_m1_s2_vss_m1_s3_vss_m1_s4_vss_m1_sb_vss_sr1_vss_sr2_vss_sr3_vss_sr4_vss_sv_vss_tg_d_vss_tg_fbm_vss_tg_fbs_vss_tg_s_vss_vss_vss_link_vss_link_bridge_vss_link_dip_vss_link_m1_vss_x1_vss_x2_vss_x3_t176 r0 *1 0,0
Rg_vss_m1_inv_clk_vss_inv_mc_vss_inv_q_vss_mph_g_nand_m_vss_nand_s2_vss_s1_vss_m1_s2_vss_m1_s3_vss_m1_s4_vss_m1_sb_vss_sr1_vss_sr2_vss_sr3_vss_sr4_vss_sv_vss_tg_d_vss_tg_fbm_vss_tg_fbs_vss_tg_s_vss_vss_vss_link_vss_link_bridge_vss_link_dip_vss_link_m1_vss_x1_vss_x2_vss_x3_t176
+ g_vss_m1\x7cinv_clk_vss\x7cinv_mc_vss\x7cinv_q_vss\x7cmph_g\x7cnand_m_vss\x7cnand_s2_vss\x7cs1_vss_m1\x7cs2_vss_m1\x7cs3_vss_m1\x7cs4_vss_m1\x7csb_vss\x7csr1_vss\x7csr2_vss\x7csr3_vss\x7csr4_vss\x7csv_vss\x7ctg_d_vss\x7ctg_fbm_vss\x7ctg_fbs_vss\x7ctg_s_vss\x7cvss\x7cvss_link\x7cvss_link_bridge\x7cvss_link_dip\x7cvss_link_m1\x7cvss_x1\x7cvss_x2\x7cvss_x3__t176
+ g_vss_m1|inv_clk_vss|inv_mc_vss|inv_q_vss|mph_g|nand_m_vss|nand_s2_vss|s1_vss_m1|s2_vss_m1|s3_vss_m1|s4_vss_m1|sb_vss|sr1_vss|sr2_vss|sr3_vss|sr4_vss|sv_vss|tg_d_vss|tg_fbm_vss|tg_fbs_vss|tg_s_vss|vss|vss_link|vss_link_bridge|vss_link_dip|vss_link_m1|vss_x1|vss_x2|vss_x3
+ 125.115072496
* device instance g_vss_m1_inv_clk_vss_inv_mc_vss_inv_q_vss_mph_g_nand_m_vss_nand_s2_vss_s1_vss_m1_s2_vss_m1_s3_vss_m1_s4_vss_m1_sb_vss_sr1_vss_sr2_vss_sr3_vss_sr4_vss_sv_vss_tg_d_vss_tg_fbm_vss_tg_fbs_vss_tg_s_vss_vss_vss_link_vss_link_bridge_vss_link_dip_vss_link_m1_vss_x1_vss_x2_vss_x3_t177 r0 *1 0,0
Rg_vss_m1_inv_clk_vss_inv_mc_vss_inv_q_vss_mph_g_nand_m_vss_nand_s2_vss_s1_vss_m1_s2_vss_m1_s3_vss_m1_s4_vss_m1_sb_vss_sr1_vss_sr2_vss_sr3_vss_sr4_vss_sv_vss_tg_d_vss_tg_fbm_vss_tg_fbs_vss_tg_s_vss_vss_vss_link_vss_link_bridge_vss_link_dip_vss_link_m1_vss_x1_vss_x2_vss_x3_t177
+ g_vss_m1\x7cinv_clk_vss\x7cinv_mc_vss\x7cinv_q_vss\x7cmph_g\x7cnand_m_vss\x7cnand_s2_vss\x7cs1_vss_m1\x7cs2_vss_m1\x7cs3_vss_m1\x7cs4_vss_m1\x7csb_vss\x7csr1_vss\x7csr2_vss\x7csr3_vss\x7csr4_vss\x7csv_vss\x7ctg_d_vss\x7ctg_fbm_vss\x7ctg_fbs_vss\x7ctg_s_vss\x7cvss\x7cvss_link\x7cvss_link_bridge\x7cvss_link_dip\x7cvss_link_m1\x7cvss_x1\x7cvss_x2\x7cvss_x3__t177
+ g_vss_m1|inv_clk_vss|inv_mc_vss|inv_q_vss|mph_g|nand_m_vss|nand_s2_vss|s1_vss_m1|s2_vss_m1|s3_vss_m1|s4_vss_m1|sb_vss|sr1_vss|sr2_vss|sr3_vss|sr4_vss|sv_vss|tg_d_vss|tg_fbm_vss|tg_fbs_vss|tg_s_vss|vss|vss_link|vss_link_bridge|vss_link_dip|vss_link_m1|vss_x1|vss_x2|vss_x3
+ 88.6998439493
* device instance g_vss_m1_inv_clk_vss_inv_mc_vss_inv_q_vss_mph_g_nand_m_vss_nand_s2_vss_s1_vss_m1_s2_vss_m1_s3_vss_m1_s4_vss_m1_sb_vss_sr1_vss_sr2_vss_sr3_vss_sr4_vss_sv_vss_tg_d_vss_tg_fbm_vss_tg_fbs_vss_tg_s_vss_vss_vss_link_vss_link_bridge_vss_link_dip_vss_link_m1_vss_x1_vss_x2_vss_x3_t178 r0 *1 0,0
Rg_vss_m1_inv_clk_vss_inv_mc_vss_inv_q_vss_mph_g_nand_m_vss_nand_s2_vss_s1_vss_m1_s2_vss_m1_s3_vss_m1_s4_vss_m1_sb_vss_sr1_vss_sr2_vss_sr3_vss_sr4_vss_sv_vss_tg_d_vss_tg_fbm_vss_tg_fbs_vss_tg_s_vss_vss_vss_link_vss_link_bridge_vss_link_dip_vss_link_m1_vss_x1_vss_x2_vss_x3_t178
+ g_vss_m1\x7cinv_clk_vss\x7cinv_mc_vss\x7cinv_q_vss\x7cmph_g\x7cnand_m_vss\x7cnand_s2_vss\x7cs1_vss_m1\x7cs2_vss_m1\x7cs3_vss_m1\x7cs4_vss_m1\x7csb_vss\x7csr1_vss\x7csr2_vss\x7csr3_vss\x7csr4_vss\x7csv_vss\x7ctg_d_vss\x7ctg_fbm_vss\x7ctg_fbs_vss\x7ctg_s_vss\x7cvss\x7cvss_link\x7cvss_link_bridge\x7cvss_link_dip\x7cvss_link_m1\x7cvss_x1\x7cvss_x2\x7cvss_x3__t178
+ g_vss_m1|inv_clk_vss|inv_mc_vss|inv_q_vss|mph_g|nand_m_vss|nand_s2_vss|s1_vss_m1|s2_vss_m1|s3_vss_m1|s4_vss_m1|sb_vss|sr1_vss|sr2_vss|sr3_vss|sr4_vss|sv_vss|tg_d_vss|tg_fbm_vss|tg_fbs_vss|tg_s_vss|vss|vss_link|vss_link_bridge|vss_link_dip|vss_link_m1|vss_x1|vss_x2|vss_x3
+ 75.0643696842
* device instance g_vss_m1_inv_clk_vss_inv_mc_vss_inv_q_vss_mph_g_nand_m_vss_nand_s2_vss_s1_vss_m1_s2_vss_m1_s3_vss_m1_s4_vss_m1_sb_vss_sr1_vss_sr2_vss_sr3_vss_sr4_vss_sv_vss_tg_d_vss_tg_fbm_vss_tg_fbs_vss_tg_s_vss_vss_vss_link_vss_link_bridge_vss_link_dip_vss_link_m1_vss_x1_vss_x2_vss_x3_t179 r0 *1 0,0
Rg_vss_m1_inv_clk_vss_inv_mc_vss_inv_q_vss_mph_g_nand_m_vss_nand_s2_vss_s1_vss_m1_s2_vss_m1_s3_vss_m1_s4_vss_m1_sb_vss_sr1_vss_sr2_vss_sr3_vss_sr4_vss_sv_vss_tg_d_vss_tg_fbm_vss_tg_fbs_vss_tg_s_vss_vss_vss_link_vss_link_bridge_vss_link_dip_vss_link_m1_vss_x1_vss_x2_vss_x3_t179
+ g_vss_m1\x7cinv_clk_vss\x7cinv_mc_vss\x7cinv_q_vss\x7cmph_g\x7cnand_m_vss\x7cnand_s2_vss\x7cs1_vss_m1\x7cs2_vss_m1\x7cs3_vss_m1\x7cs4_vss_m1\x7csb_vss\x7csr1_vss\x7csr2_vss\x7csr3_vss\x7csr4_vss\x7csv_vss\x7ctg_d_vss\x7ctg_fbm_vss\x7ctg_fbs_vss\x7ctg_s_vss\x7cvss\x7cvss_link\x7cvss_link_bridge\x7cvss_link_dip\x7cvss_link_m1\x7cvss_x1\x7cvss_x2\x7cvss_x3__t179
+ g_vss_m1|inv_clk_vss|inv_mc_vss|inv_q_vss|mph_g|nand_m_vss|nand_s2_vss|s1_vss_m1|s2_vss_m1|s3_vss_m1|s4_vss_m1|sb_vss|sr1_vss|sr2_vss|sr3_vss|sr4_vss|sv_vss|tg_d_vss|tg_fbm_vss|tg_fbs_vss|tg_s_vss|vss|vss_link|vss_link_bridge|vss_link_dip|vss_link_m1|vss_x1|vss_x2|vss_x3
+ 61.5108749495
* device instance g_vss_m1_inv_clk_vss_inv_mc_vss_inv_q_vss_mph_g_nand_m_vss_nand_s2_vss_s1_vss_m1_s2_vss_m1_s3_vss_m1_s4_vss_m1_sb_vss_sr1_vss_sr2_vss_sr3_vss_sr4_vss_sv_vss_tg_d_vss_tg_fbm_vss_tg_fbs_vss_tg_s_vss_vss_vss_link_vss_link_bridge_vss_link_dip_vss_link_m1_vss_x1_vss_x2_vss_x3_t180 r0 *1 0,0
Rg_vss_m1_inv_clk_vss_inv_mc_vss_inv_q_vss_mph_g_nand_m_vss_nand_s2_vss_s1_vss_m1_s2_vss_m1_s3_vss_m1_s4_vss_m1_sb_vss_sr1_vss_sr2_vss_sr3_vss_sr4_vss_sv_vss_tg_d_vss_tg_fbm_vss_tg_fbs_vss_tg_s_vss_vss_vss_link_vss_link_bridge_vss_link_dip_vss_link_m1_vss_x1_vss_x2_vss_x3_t180
+ g_vss_m1\x7cinv_clk_vss\x7cinv_mc_vss\x7cinv_q_vss\x7cmph_g\x7cnand_m_vss\x7cnand_s2_vss\x7cs1_vss_m1\x7cs2_vss_m1\x7cs3_vss_m1\x7cs4_vss_m1\x7csb_vss\x7csr1_vss\x7csr2_vss\x7csr3_vss\x7csr4_vss\x7csv_vss\x7ctg_d_vss\x7ctg_fbm_vss\x7ctg_fbs_vss\x7ctg_s_vss\x7cvss\x7cvss_link\x7cvss_link_bridge\x7cvss_link_dip\x7cvss_link_m1\x7cvss_x1\x7cvss_x2\x7cvss_x3__t180
+ g_vss_m1|inv_clk_vss|inv_mc_vss|inv_q_vss|mph_g|nand_m_vss|nand_s2_vss|s1_vss_m1|s2_vss_m1|s3_vss_m1|s4_vss_m1|sb_vss|sr1_vss|sr2_vss|sr3_vss|sr4_vss|sv_vss|tg_d_vss|tg_fbm_vss|tg_fbs_vss|tg_s_vss|vss|vss_link|vss_link_bridge|vss_link_dip|vss_link_m1|vss_x1|vss_x2|vss_x3
+ 48.10869713
* device instance g_vss_m1_inv_clk_vss_inv_mc_vss_inv_q_vss_mph_g_nand_m_vss_nand_s2_vss_s1_vss_m1_s2_vss_m1_s3_vss_m1_s4_vss_m1_sb_vss_sr1_vss_sr2_vss_sr3_vss_sr4_vss_sv_vss_tg_d_vss_tg_fbm_vss_tg_fbs_vss_tg_s_vss_vss_vss_link_vss_link_bridge_vss_link_dip_vss_link_m1_vss_x1_vss_x2_vss_x3_t181 r0 *1 0,0
Rg_vss_m1_inv_clk_vss_inv_mc_vss_inv_q_vss_mph_g_nand_m_vss_nand_s2_vss_s1_vss_m1_s2_vss_m1_s3_vss_m1_s4_vss_m1_sb_vss_sr1_vss_sr2_vss_sr3_vss_sr4_vss_sv_vss_tg_d_vss_tg_fbm_vss_tg_fbs_vss_tg_s_vss_vss_vss_link_vss_link_bridge_vss_link_dip_vss_link_m1_vss_x1_vss_x2_vss_x3_t181
+ g_vss_m1\x7cinv_clk_vss\x7cinv_mc_vss\x7cinv_q_vss\x7cmph_g\x7cnand_m_vss\x7cnand_s2_vss\x7cs1_vss_m1\x7cs2_vss_m1\x7cs3_vss_m1\x7cs4_vss_m1\x7csb_vss\x7csr1_vss\x7csr2_vss\x7csr3_vss\x7csr4_vss\x7csv_vss\x7ctg_d_vss\x7ctg_fbm_vss\x7ctg_fbs_vss\x7ctg_s_vss\x7cvss\x7cvss_link\x7cvss_link_bridge\x7cvss_link_dip\x7cvss_link_m1\x7cvss_x1\x7cvss_x2\x7cvss_x3__t181
+ g_vss_m1|inv_clk_vss|inv_mc_vss|inv_q_vss|mph_g|nand_m_vss|nand_s2_vss|s1_vss_m1|s2_vss_m1|s3_vss_m1|s4_vss_m1|sb_vss|sr1_vss|sr2_vss|sr3_vss|sr4_vss|sv_vss|tg_d_vss|tg_fbm_vss|tg_fbs_vss|tg_s_vss|vss|vss_link|vss_link_bridge|vss_link_dip|vss_link_m1|vss_x1|vss_x2|vss_x3
+ 33.6518941029
* device instance g_vss_m1_inv_clk_vss_inv_mc_vss_inv_q_vss_mph_g_nand_m_vss_nand_s2_vss_s1_vss_m1_s2_vss_m1_s3_vss_m1_s4_vss_m1_sb_vss_sr1_vss_sr2_vss_sr3_vss_sr4_vss_sv_vss_tg_d_vss_tg_fbm_vss_tg_fbs_vss_tg_s_vss_vss_vss_link_vss_link_bridge_vss_link_dip_vss_link_m1_vss_x1_vss_x2_vss_x3_t182 r0 *1 0,0
Rg_vss_m1_inv_clk_vss_inv_mc_vss_inv_q_vss_mph_g_nand_m_vss_nand_s2_vss_s1_vss_m1_s2_vss_m1_s3_vss_m1_s4_vss_m1_sb_vss_sr1_vss_sr2_vss_sr3_vss_sr4_vss_sv_vss_tg_d_vss_tg_fbm_vss_tg_fbs_vss_tg_s_vss_vss_vss_link_vss_link_bridge_vss_link_dip_vss_link_m1_vss_x1_vss_x2_vss_x3_t182
+ g_vss_m1\x7cinv_clk_vss\x7cinv_mc_vss\x7cinv_q_vss\x7cmph_g\x7cnand_m_vss\x7cnand_s2_vss\x7cs1_vss_m1\x7cs2_vss_m1\x7cs3_vss_m1\x7cs4_vss_m1\x7csb_vss\x7csr1_vss\x7csr2_vss\x7csr3_vss\x7csr4_vss\x7csv_vss\x7ctg_d_vss\x7ctg_fbm_vss\x7ctg_fbs_vss\x7ctg_s_vss\x7cvss\x7cvss_link\x7cvss_link_bridge\x7cvss_link_dip\x7cvss_link_m1\x7cvss_x1\x7cvss_x2\x7cvss_x3__t182
+ g_vss_m1|inv_clk_vss|inv_mc_vss|inv_q_vss|mph_g|nand_m_vss|nand_s2_vss|s1_vss_m1|s2_vss_m1|s3_vss_m1|s4_vss_m1|sb_vss|sr1_vss|sr2_vss|sr3_vss|sr4_vss|sv_vss|tg_d_vss|tg_fbm_vss|tg_fbs_vss|tg_s_vss|vss|vss_link|vss_link_bridge|vss_link_dip|vss_link_m1|vss_x1|vss_x2|vss_x3
+ 14.4574540771
* device instance g_vss_m1_inv_clk_vss_inv_mc_vss_inv_q_vss_mph_g_nand_m_vss_nand_s2_vss_s1_vss_m1_s2_vss_m1_s3_vss_m1_s4_vss_m1_sb_vss_sr1_vss_sr2_vss_sr3_vss_sr4_vss_sv_vss_tg_d_vss_tg_fbm_vss_tg_fbs_vss_tg_s_vss_vss_vss_link_vss_link_bridge_vss_link_dip_vss_link_m1_vss_x1_vss_x2_vss_x3_t183 r0 *1 0,0
Rg_vss_m1_inv_clk_vss_inv_mc_vss_inv_q_vss_mph_g_nand_m_vss_nand_s2_vss_s1_vss_m1_s2_vss_m1_s3_vss_m1_s4_vss_m1_sb_vss_sr1_vss_sr2_vss_sr3_vss_sr4_vss_sv_vss_tg_d_vss_tg_fbm_vss_tg_fbs_vss_tg_s_vss_vss_vss_link_vss_link_bridge_vss_link_dip_vss_link_m1_vss_x1_vss_x2_vss_x3_t183
+ g_vss_m1\x7cinv_clk_vss\x7cinv_mc_vss\x7cinv_q_vss\x7cmph_g\x7cnand_m_vss\x7cnand_s2_vss\x7cs1_vss_m1\x7cs2_vss_m1\x7cs3_vss_m1\x7cs4_vss_m1\x7csb_vss\x7csr1_vss\x7csr2_vss\x7csr3_vss\x7csr4_vss\x7csv_vss\x7ctg_d_vss\x7ctg_fbm_vss\x7ctg_fbs_vss\x7ctg_s_vss\x7cvss\x7cvss_link\x7cvss_link_bridge\x7cvss_link_dip\x7cvss_link_m1\x7cvss_x1\x7cvss_x2\x7cvss_x3__t183
+ g_vss_m1|inv_clk_vss|inv_mc_vss|inv_q_vss|mph_g|nand_m_vss|nand_s2_vss|s1_vss_m1|s2_vss_m1|s3_vss_m1|s4_vss_m1|sb_vss|sr1_vss|sr2_vss|sr3_vss|sr4_vss|sv_vss|tg_d_vss|tg_fbm_vss|tg_fbs_vss|tg_s_vss|vss|vss_link|vss_link_bridge|vss_link_dip|vss_link_m1|vss_x1|vss_x2|vss_x3
+ 23.655792069
* device instance g_vss_m1_inv_clk_vss_inv_mc_vss_inv_q_vss_mph_g_nand_m_vss_nand_s2_vss_s1_vss_m1_s2_vss_m1_s3_vss_m1_s4_vss_m1_sb_vss_sr1_vss_sr2_vss_sr3_vss_sr4_vss_sv_vss_tg_d_vss_tg_fbm_vss_tg_fbs_vss_tg_s_vss_vss_vss_link_vss_link_bridge_vss_link_dip_vss_link_m1_vss_x1_vss_x2_vss_x3_t184 r0 *1 0,0
Rg_vss_m1_inv_clk_vss_inv_mc_vss_inv_q_vss_mph_g_nand_m_vss_nand_s2_vss_s1_vss_m1_s2_vss_m1_s3_vss_m1_s4_vss_m1_sb_vss_sr1_vss_sr2_vss_sr3_vss_sr4_vss_sv_vss_tg_d_vss_tg_fbm_vss_tg_fbs_vss_tg_s_vss_vss_vss_link_vss_link_bridge_vss_link_dip_vss_link_m1_vss_x1_vss_x2_vss_x3_t184
+ g_vss_m1\x7cinv_clk_vss\x7cinv_mc_vss\x7cinv_q_vss\x7cmph_g\x7cnand_m_vss\x7cnand_s2_vss\x7cs1_vss_m1\x7cs2_vss_m1\x7cs3_vss_m1\x7cs4_vss_m1\x7csb_vss\x7csr1_vss\x7csr2_vss\x7csr3_vss\x7csr4_vss\x7csv_vss\x7ctg_d_vss\x7ctg_fbm_vss\x7ctg_fbs_vss\x7ctg_s_vss\x7cvss\x7cvss_link\x7cvss_link_bridge\x7cvss_link_dip\x7cvss_link_m1\x7cvss_x1\x7cvss_x2\x7cvss_x3__t184
+ g_vss_m1|inv_clk_vss|inv_mc_vss|inv_q_vss|mph_g|nand_m_vss|nand_s2_vss|s1_vss_m1|s2_vss_m1|s3_vss_m1|s4_vss_m1|sb_vss|sr1_vss|sr2_vss|sr3_vss|sr4_vss|sv_vss|tg_d_vss|tg_fbm_vss|tg_fbs_vss|tg_s_vss|vss|vss_link|vss_link_bridge|vss_link_dip|vss_link_m1|vss_x1|vss_x2|vss_x3
+ 35.9458743105
* device instance g_vss_m1_inv_clk_vss_inv_mc_vss_inv_q_vss_mph_g_nand_m_vss_nand_s2_vss_s1_vss_m1_s2_vss_m1_s3_vss_m1_s4_vss_m1_sb_vss_sr1_vss_sr2_vss_sr3_vss_sr4_vss_sv_vss_tg_d_vss_tg_fbm_vss_tg_fbs_vss_tg_s_vss_vss_vss_link_vss_link_bridge_vss_link_dip_vss_link_m1_vss_x1_vss_x2_vss_x3_t185 r0 *1 0,0
Rg_vss_m1_inv_clk_vss_inv_mc_vss_inv_q_vss_mph_g_nand_m_vss_nand_s2_vss_s1_vss_m1_s2_vss_m1_s3_vss_m1_s4_vss_m1_sb_vss_sr1_vss_sr2_vss_sr3_vss_sr4_vss_sv_vss_tg_d_vss_tg_fbm_vss_tg_fbs_vss_tg_s_vss_vss_vss_link_vss_link_bridge_vss_link_dip_vss_link_m1_vss_x1_vss_x2_vss_x3_t185
+ g_vss_m1\x7cinv_clk_vss\x7cinv_mc_vss\x7cinv_q_vss\x7cmph_g\x7cnand_m_vss\x7cnand_s2_vss\x7cs1_vss_m1\x7cs2_vss_m1\x7cs3_vss_m1\x7cs4_vss_m1\x7csb_vss\x7csr1_vss\x7csr2_vss\x7csr3_vss\x7csr4_vss\x7csv_vss\x7ctg_d_vss\x7ctg_fbm_vss\x7ctg_fbs_vss\x7ctg_s_vss\x7cvss\x7cvss_link\x7cvss_link_bridge\x7cvss_link_dip\x7cvss_link_m1\x7cvss_x1\x7cvss_x2\x7cvss_x3__t185
+ g_vss_m1|inv_clk_vss|inv_mc_vss|inv_q_vss|mph_g|nand_m_vss|nand_s2_vss|s1_vss_m1|s2_vss_m1|s3_vss_m1|s4_vss_m1|sb_vss|sr1_vss|sr2_vss|sr3_vss|sr4_vss|sv_vss|tg_d_vss|tg_fbm_vss|tg_fbs_vss|tg_s_vss|vss|vss_link|vss_link_bridge|vss_link_dip|vss_link_m1|vss_x1|vss_x2|vss_x3
+ 49.056560448
* device instance g_vss_m1_inv_clk_vss_inv_mc_vss_inv_q_vss_mph_g_nand_m_vss_nand_s2_vss_s1_vss_m1_s2_vss_m1_s3_vss_m1_s4_vss_m1_sb_vss_sr1_vss_sr2_vss_sr3_vss_sr4_vss_sv_vss_tg_d_vss_tg_fbm_vss_tg_fbs_vss_tg_s_vss_vss_vss_link_vss_link_bridge_vss_link_dip_vss_link_m1_vss_x1_vss_x2_vss_x3_t186 r0 *1 0,0
Rg_vss_m1_inv_clk_vss_inv_mc_vss_inv_q_vss_mph_g_nand_m_vss_nand_s2_vss_s1_vss_m1_s2_vss_m1_s3_vss_m1_s4_vss_m1_sb_vss_sr1_vss_sr2_vss_sr3_vss_sr4_vss_sv_vss_tg_d_vss_tg_fbm_vss_tg_fbs_vss_tg_s_vss_vss_vss_link_vss_link_bridge_vss_link_dip_vss_link_m1_vss_x1_vss_x2_vss_x3_t186
+ g_vss_m1\x7cinv_clk_vss\x7cinv_mc_vss\x7cinv_q_vss\x7cmph_g\x7cnand_m_vss\x7cnand_s2_vss\x7cs1_vss_m1\x7cs2_vss_m1\x7cs3_vss_m1\x7cs4_vss_m1\x7csb_vss\x7csr1_vss\x7csr2_vss\x7csr3_vss\x7csr4_vss\x7csv_vss\x7ctg_d_vss\x7ctg_fbm_vss\x7ctg_fbs_vss\x7ctg_s_vss\x7cvss\x7cvss_link\x7cvss_link_bridge\x7cvss_link_dip\x7cvss_link_m1\x7cvss_x1\x7cvss_x2\x7cvss_x3__t186
+ g_vss_m1|inv_clk_vss|inv_mc_vss|inv_q_vss|mph_g|nand_m_vss|nand_s2_vss|s1_vss_m1|s2_vss_m1|s3_vss_m1|s4_vss_m1|sb_vss|sr1_vss|sr2_vss|sr3_vss|sr4_vss|sv_vss|tg_d_vss|tg_fbm_vss|tg_fbs_vss|tg_s_vss|vss|vss_link|vss_link_bridge|vss_link_dip|vss_link_m1|vss_x1|vss_x2|vss_x3
+ 63.9360699992
* device instance g_vss_m1_inv_clk_vss_inv_mc_vss_inv_q_vss_mph_g_nand_m_vss_nand_s2_vss_s1_vss_m1_s2_vss_m1_s3_vss_m1_s4_vss_m1_sb_vss_sr1_vss_sr2_vss_sr3_vss_sr4_vss_sv_vss_tg_d_vss_tg_fbm_vss_tg_fbs_vss_tg_s_vss_vss_vss_link_vss_link_bridge_vss_link_dip_vss_link_m1_vss_x1_vss_x2_vss_x3_t187 r0 *1 0,0
Rg_vss_m1_inv_clk_vss_inv_mc_vss_inv_q_vss_mph_g_nand_m_vss_nand_s2_vss_s1_vss_m1_s2_vss_m1_s3_vss_m1_s4_vss_m1_sb_vss_sr1_vss_sr2_vss_sr3_vss_sr4_vss_sv_vss_tg_d_vss_tg_fbm_vss_tg_fbs_vss_tg_s_vss_vss_vss_link_vss_link_bridge_vss_link_dip_vss_link_m1_vss_x1_vss_x2_vss_x3_t187
+ g_vss_m1\x7cinv_clk_vss\x7cinv_mc_vss\x7cinv_q_vss\x7cmph_g\x7cnand_m_vss\x7cnand_s2_vss\x7cs1_vss_m1\x7cs2_vss_m1\x7cs3_vss_m1\x7cs4_vss_m1\x7csb_vss\x7csr1_vss\x7csr2_vss\x7csr3_vss\x7csr4_vss\x7csv_vss\x7ctg_d_vss\x7ctg_fbm_vss\x7ctg_fbs_vss\x7ctg_s_vss\x7cvss\x7cvss_link\x7cvss_link_bridge\x7cvss_link_dip\x7cvss_link_m1\x7cvss_x1\x7cvss_x2\x7cvss_x3__t187
+ g_vss_m1|inv_clk_vss|inv_mc_vss|inv_q_vss|mph_g|nand_m_vss|nand_s2_vss|s1_vss_m1|s2_vss_m1|s3_vss_m1|s4_vss_m1|sb_vss|sr1_vss|sr2_vss|sr3_vss|sr4_vss|sv_vss|tg_d_vss|tg_fbm_vss|tg_fbs_vss|tg_s_vss|vss|vss_link|vss_link_bridge|vss_link_dip|vss_link_m1|vss_x1|vss_x2|vss_x3
+ 100.135288981
* device instance g_vss_m1_inv_clk_vss_inv_mc_vss_inv_q_vss_mph_g_nand_m_vss_nand_s2_vss_s1_vss_m1_s2_vss_m1_s3_vss_m1_s4_vss_m1_sb_vss_sr1_vss_sr2_vss_sr3_vss_sr4_vss_sv_vss_tg_d_vss_tg_fbm_vss_tg_fbs_vss_tg_s_vss_vss_vss_link_vss_link_bridge_vss_link_dip_vss_link_m1_vss_x1_vss_x2_vss_x3_t188 r0 *1 0,0
Rg_vss_m1_inv_clk_vss_inv_mc_vss_inv_q_vss_mph_g_nand_m_vss_nand_s2_vss_s1_vss_m1_s2_vss_m1_s3_vss_m1_s4_vss_m1_sb_vss_sr1_vss_sr2_vss_sr3_vss_sr4_vss_sv_vss_tg_d_vss_tg_fbm_vss_tg_fbs_vss_tg_s_vss_vss_vss_link_vss_link_bridge_vss_link_dip_vss_link_m1_vss_x1_vss_x2_vss_x3_t188
+ g_vss_m1\x7cinv_clk_vss\x7cinv_mc_vss\x7cinv_q_vss\x7cmph_g\x7cnand_m_vss\x7cnand_s2_vss\x7cs1_vss_m1\x7cs2_vss_m1\x7cs3_vss_m1\x7cs4_vss_m1\x7csb_vss\x7csr1_vss\x7csr2_vss\x7csr3_vss\x7csr4_vss\x7csv_vss\x7ctg_d_vss\x7ctg_fbm_vss\x7ctg_fbs_vss\x7ctg_s_vss\x7cvss\x7cvss_link\x7cvss_link_bridge\x7cvss_link_dip\x7cvss_link_m1\x7cvss_x1\x7cvss_x2\x7cvss_x3__t188
+ g_vss_m1|inv_clk_vss|inv_mc_vss|inv_q_vss|mph_g|nand_m_vss|nand_s2_vss|s1_vss_m1|s2_vss_m1|s3_vss_m1|s4_vss_m1|sb_vss|sr1_vss|sr2_vss|sr3_vss|sr4_vss|sv_vss|tg_d_vss|tg_fbm_vss|tg_fbs_vss|tg_s_vss|vss|vss_link|vss_link_bridge|vss_link_dip|vss_link_m1|vss_x1|vss_x2|vss_x3
+ 113.847423598
* device instance g_vss_m1_inv_clk_vss_inv_mc_vss_inv_q_vss_mph_g_nand_m_vss_nand_s2_vss_s1_vss_m1_s2_vss_m1_s3_vss_m1_s4_vss_m1_sb_vss_sr1_vss_sr2_vss_sr3_vss_sr4_vss_sv_vss_tg_d_vss_tg_fbm_vss_tg_fbs_vss_tg_s_vss_vss_vss_link_vss_link_bridge_vss_link_dip_vss_link_m1_vss_x1_vss_x2_vss_x3_t189 r0 *1 0,0
Rg_vss_m1_inv_clk_vss_inv_mc_vss_inv_q_vss_mph_g_nand_m_vss_nand_s2_vss_s1_vss_m1_s2_vss_m1_s3_vss_m1_s4_vss_m1_sb_vss_sr1_vss_sr2_vss_sr3_vss_sr4_vss_sv_vss_tg_d_vss_tg_fbm_vss_tg_fbs_vss_tg_s_vss_vss_vss_link_vss_link_bridge_vss_link_dip_vss_link_m1_vss_x1_vss_x2_vss_x3_t189
+ g_vss_m1\x7cinv_clk_vss\x7cinv_mc_vss\x7cinv_q_vss\x7cmph_g\x7cnand_m_vss\x7cnand_s2_vss\x7cs1_vss_m1\x7cs2_vss_m1\x7cs3_vss_m1\x7cs4_vss_m1\x7csb_vss\x7csr1_vss\x7csr2_vss\x7csr3_vss\x7csr4_vss\x7csv_vss\x7ctg_d_vss\x7ctg_fbm_vss\x7ctg_fbs_vss\x7ctg_s_vss\x7cvss\x7cvss_link\x7cvss_link_bridge\x7cvss_link_dip\x7cvss_link_m1\x7cvss_x1\x7cvss_x2\x7cvss_x3__t189
+ g_vss_m1|inv_clk_vss|inv_mc_vss|inv_q_vss|mph_g|nand_m_vss|nand_s2_vss|s1_vss_m1|s2_vss_m1|s3_vss_m1|s4_vss_m1|sb_vss|sr1_vss|sr2_vss|sr3_vss|sr4_vss|sv_vss|tg_d_vss|tg_fbm_vss|tg_fbs_vss|tg_s_vss|vss|vss_link|vss_link_bridge|vss_link_dip|vss_link_m1|vss_x1|vss_x2|vss_x3
+ 127.582626097
* device instance g_vss_m1_inv_clk_vss_inv_mc_vss_inv_q_vss_mph_g_nand_m_vss_nand_s2_vss_s1_vss_m1_s2_vss_m1_s3_vss_m1_s4_vss_m1_sb_vss_sr1_vss_sr2_vss_sr3_vss_sr4_vss_sv_vss_tg_d_vss_tg_fbm_vss_tg_fbs_vss_tg_s_vss_vss_vss_link_vss_link_bridge_vss_link_dip_vss_link_m1_vss_x1_vss_x2_vss_x3_t190 r0 *1 0,0
Rg_vss_m1_inv_clk_vss_inv_mc_vss_inv_q_vss_mph_g_nand_m_vss_nand_s2_vss_s1_vss_m1_s2_vss_m1_s3_vss_m1_s4_vss_m1_sb_vss_sr1_vss_sr2_vss_sr3_vss_sr4_vss_sv_vss_tg_d_vss_tg_fbm_vss_tg_fbs_vss_tg_s_vss_vss_vss_link_vss_link_bridge_vss_link_dip_vss_link_m1_vss_x1_vss_x2_vss_x3_t190
+ g_vss_m1\x7cinv_clk_vss\x7cinv_mc_vss\x7cinv_q_vss\x7cmph_g\x7cnand_m_vss\x7cnand_s2_vss\x7cs1_vss_m1\x7cs2_vss_m1\x7cs3_vss_m1\x7cs4_vss_m1\x7csb_vss\x7csr1_vss\x7csr2_vss\x7csr3_vss\x7csr4_vss\x7csv_vss\x7ctg_d_vss\x7ctg_fbm_vss\x7ctg_fbs_vss\x7ctg_s_vss\x7cvss\x7cvss_link\x7cvss_link_bridge\x7cvss_link_dip\x7cvss_link_m1\x7cvss_x1\x7cvss_x2\x7cvss_x3__t190
+ g_vss_m1|inv_clk_vss|inv_mc_vss|inv_q_vss|mph_g|nand_m_vss|nand_s2_vss|s1_vss_m1|s2_vss_m1|s3_vss_m1|s4_vss_m1|sb_vss|sr1_vss|sr2_vss|sr3_vss|sr4_vss|sv_vss|tg_d_vss|tg_fbm_vss|tg_fbs_vss|tg_s_vss|vss|vss_link|vss_link_bridge|vss_link_dip|vss_link_m1|vss_x1|vss_x2|vss_x3
+ 141.334171259
* device instance g_vss_m1_inv_clk_vss_inv_mc_vss_inv_q_vss_mph_g_nand_m_vss_nand_s2_vss_s1_vss_m1_s2_vss_m1_s3_vss_m1_s4_vss_m1_sb_vss_sr1_vss_sr2_vss_sr3_vss_sr4_vss_sv_vss_tg_d_vss_tg_fbm_vss_tg_fbs_vss_tg_s_vss_vss_vss_link_vss_link_bridge_vss_link_dip_vss_link_m1_vss_x1_vss_x2_vss_x3_t191 r0 *1 0,0
Rg_vss_m1_inv_clk_vss_inv_mc_vss_inv_q_vss_mph_g_nand_m_vss_nand_s2_vss_s1_vss_m1_s2_vss_m1_s3_vss_m1_s4_vss_m1_sb_vss_sr1_vss_sr2_vss_sr3_vss_sr4_vss_sv_vss_tg_d_vss_tg_fbm_vss_tg_fbs_vss_tg_s_vss_vss_vss_link_vss_link_bridge_vss_link_dip_vss_link_m1_vss_x1_vss_x2_vss_x3_t191
+ g_vss_m1\x7cinv_clk_vss\x7cinv_mc_vss\x7cinv_q_vss\x7cmph_g\x7cnand_m_vss\x7cnand_s2_vss\x7cs1_vss_m1\x7cs2_vss_m1\x7cs3_vss_m1\x7cs4_vss_m1\x7csb_vss\x7csr1_vss\x7csr2_vss\x7csr3_vss\x7csr4_vss\x7csv_vss\x7ctg_d_vss\x7ctg_fbm_vss\x7ctg_fbs_vss\x7ctg_s_vss\x7cvss\x7cvss_link\x7cvss_link_bridge\x7cvss_link_dip\x7cvss_link_m1\x7cvss_x1\x7cvss_x2\x7cvss_x3__t191
+ g_vss_m1|inv_clk_vss|inv_mc_vss|inv_q_vss|mph_g|nand_m_vss|nand_s2_vss|s1_vss_m1|s2_vss_m1|s3_vss_m1|s4_vss_m1|sb_vss|sr1_vss|sr2_vss|sr3_vss|sr4_vss|sv_vss|tg_d_vss|tg_fbm_vss|tg_fbs_vss|tg_s_vss|vss|vss_link|vss_link_bridge|vss_link_dip|vss_link_m1|vss_x1|vss_x2|vss_x3
+ 156.588296422
* device instance g_vss_m1_inv_clk_vss_inv_mc_vss_inv_q_vss_mph_g_nand_m_vss_nand_s2_vss_s1_vss_m1_s2_vss_m1_s3_vss_m1_s4_vss_m1_sb_vss_sr1_vss_sr2_vss_sr3_vss_sr4_vss_sv_vss_tg_d_vss_tg_fbm_vss_tg_fbs_vss_tg_s_vss_vss_vss_link_vss_link_bridge_vss_link_dip_vss_link_m1_vss_x1_vss_x2_vss_x3_t192 r0 *1 0,0
Rg_vss_m1_inv_clk_vss_inv_mc_vss_inv_q_vss_mph_g_nand_m_vss_nand_s2_vss_s1_vss_m1_s2_vss_m1_s3_vss_m1_s4_vss_m1_sb_vss_sr1_vss_sr2_vss_sr3_vss_sr4_vss_sv_vss_tg_d_vss_tg_fbm_vss_tg_fbs_vss_tg_s_vss_vss_vss_link_vss_link_bridge_vss_link_dip_vss_link_m1_vss_x1_vss_x2_vss_x3_t192
+ g_vss_m1\x7cinv_clk_vss\x7cinv_mc_vss\x7cinv_q_vss\x7cmph_g\x7cnand_m_vss\x7cnand_s2_vss\x7cs1_vss_m1\x7cs2_vss_m1\x7cs3_vss_m1\x7cs4_vss_m1\x7csb_vss\x7csr1_vss\x7csr2_vss\x7csr3_vss\x7csr4_vss\x7csv_vss\x7ctg_d_vss\x7ctg_fbm_vss\x7ctg_fbs_vss\x7ctg_s_vss\x7cvss\x7cvss_link\x7cvss_link_bridge\x7cvss_link_dip\x7cvss_link_m1\x7cvss_x1\x7cvss_x2\x7cvss_x3__t192
+ g_vss_m1|inv_clk_vss|inv_mc_vss|inv_q_vss|mph_g|nand_m_vss|nand_s2_vss|s1_vss_m1|s2_vss_m1|s3_vss_m1|s4_vss_m1|sb_vss|sr1_vss|sr2_vss|sr3_vss|sr4_vss|sv_vss|tg_d_vss|tg_fbm_vss|tg_fbs_vss|tg_s_vss|vss|vss_link|vss_link_bridge|vss_link_dip|vss_link_m1|vss_x1|vss_x2|vss_x3
+ 205.759333351
* device instance g_vss_m1_inv_clk_vss_inv_mc_vss_inv_q_vss_mph_g_nand_m_vss_nand_s2_vss_s1_vss_m1_s2_vss_m1_s3_vss_m1_s4_vss_m1_sb_vss_sr1_vss_sr2_vss_sr3_vss_sr4_vss_sv_vss_tg_d_vss_tg_fbm_vss_tg_fbs_vss_tg_s_vss_vss_vss_link_vss_link_bridge_vss_link_dip_vss_link_m1_vss_x1_vss_x2_vss_x3_t193 r0 *1 0,0
Rg_vss_m1_inv_clk_vss_inv_mc_vss_inv_q_vss_mph_g_nand_m_vss_nand_s2_vss_s1_vss_m1_s2_vss_m1_s3_vss_m1_s4_vss_m1_sb_vss_sr1_vss_sr2_vss_sr3_vss_sr4_vss_sv_vss_tg_d_vss_tg_fbm_vss_tg_fbs_vss_tg_s_vss_vss_vss_link_vss_link_bridge_vss_link_dip_vss_link_m1_vss_x1_vss_x2_vss_x3_t193
+ g_vss_m1\x7cinv_clk_vss\x7cinv_mc_vss\x7cinv_q_vss\x7cmph_g\x7cnand_m_vss\x7cnand_s2_vss\x7cs1_vss_m1\x7cs2_vss_m1\x7cs3_vss_m1\x7cs4_vss_m1\x7csb_vss\x7csr1_vss\x7csr2_vss\x7csr3_vss\x7csr4_vss\x7csv_vss\x7ctg_d_vss\x7ctg_fbm_vss\x7ctg_fbs_vss\x7ctg_s_vss\x7cvss\x7cvss_link\x7cvss_link_bridge\x7cvss_link_dip\x7cvss_link_m1\x7cvss_x1\x7cvss_x2\x7cvss_x3__t193
+ g_vss_m1|inv_clk_vss|inv_mc_vss|inv_q_vss|mph_g|nand_m_vss|nand_s2_vss|s1_vss_m1|s2_vss_m1|s3_vss_m1|s4_vss_m1|sb_vss|sr1_vss|sr2_vss|sr3_vss|sr4_vss|sv_vss|tg_d_vss|tg_fbm_vss|tg_fbs_vss|tg_s_vss|vss|vss_link|vss_link_bridge|vss_link_dip|vss_link_m1|vss_x1|vss_x2|vss_x3
+ 175.838141382
* device instance g_vss_m1_inv_clk_vss_inv_mc_vss_inv_q_vss_mph_g_nand_m_vss_nand_s2_vss_s1_vss_m1_s2_vss_m1_s3_vss_m1_s4_vss_m1_sb_vss_sr1_vss_sr2_vss_sr3_vss_sr4_vss_sv_vss_tg_d_vss_tg_fbm_vss_tg_fbs_vss_tg_s_vss_vss_vss_link_vss_link_bridge_vss_link_dip_vss_link_m1_vss_x1_vss_x2_vss_x3_t194 r0 *1 0,0
Rg_vss_m1_inv_clk_vss_inv_mc_vss_inv_q_vss_mph_g_nand_m_vss_nand_s2_vss_s1_vss_m1_s2_vss_m1_s3_vss_m1_s4_vss_m1_sb_vss_sr1_vss_sr2_vss_sr3_vss_sr4_vss_sv_vss_tg_d_vss_tg_fbm_vss_tg_fbs_vss_tg_s_vss_vss_vss_link_vss_link_bridge_vss_link_dip_vss_link_m1_vss_x1_vss_x2_vss_x3_t194
+ g_vss_m1\x7cinv_clk_vss\x7cinv_mc_vss\x7cinv_q_vss\x7cmph_g\x7cnand_m_vss\x7cnand_s2_vss\x7cs1_vss_m1\x7cs2_vss_m1\x7cs3_vss_m1\x7cs4_vss_m1\x7csb_vss\x7csr1_vss\x7csr2_vss\x7csr3_vss\x7csr4_vss\x7csv_vss\x7ctg_d_vss\x7ctg_fbm_vss\x7ctg_fbs_vss\x7ctg_s_vss\x7cvss\x7cvss_link\x7cvss_link_bridge\x7cvss_link_dip\x7cvss_link_m1\x7cvss_x1\x7cvss_x2\x7cvss_x3__t194
+ g_vss_m1|inv_clk_vss|inv_mc_vss|inv_q_vss|mph_g|nand_m_vss|nand_s2_vss|s1_vss_m1|s2_vss_m1|s3_vss_m1|s4_vss_m1|sb_vss|sr1_vss|sr2_vss|sr3_vss|sr4_vss|sv_vss|tg_d_vss|tg_fbm_vss|tg_fbs_vss|tg_s_vss|vss|vss_link|vss_link_bridge|vss_link_dip|vss_link_m1|vss_x1|vss_x2|vss_x3
+ 158.212072703
* device instance g_vss_m1_inv_clk_vss_inv_mc_vss_inv_q_vss_mph_g_nand_m_vss_nand_s2_vss_s1_vss_m1_s2_vss_m1_s3_vss_m1_s4_vss_m1_sb_vss_sr1_vss_sr2_vss_sr3_vss_sr4_vss_sv_vss_tg_d_vss_tg_fbm_vss_tg_fbs_vss_tg_s_vss_vss_vss_link_vss_link_bridge_vss_link_dip_vss_link_m1_vss_x1_vss_x2_vss_x3_t195 r0 *1 0,0
Rg_vss_m1_inv_clk_vss_inv_mc_vss_inv_q_vss_mph_g_nand_m_vss_nand_s2_vss_s1_vss_m1_s2_vss_m1_s3_vss_m1_s4_vss_m1_sb_vss_sr1_vss_sr2_vss_sr3_vss_sr4_vss_sv_vss_tg_d_vss_tg_fbm_vss_tg_fbs_vss_tg_s_vss_vss_vss_link_vss_link_bridge_vss_link_dip_vss_link_m1_vss_x1_vss_x2_vss_x3_t195
+ g_vss_m1\x7cinv_clk_vss\x7cinv_mc_vss\x7cinv_q_vss\x7cmph_g\x7cnand_m_vss\x7cnand_s2_vss\x7cs1_vss_m1\x7cs2_vss_m1\x7cs3_vss_m1\x7cs4_vss_m1\x7csb_vss\x7csr1_vss\x7csr2_vss\x7csr3_vss\x7csr4_vss\x7csv_vss\x7ctg_d_vss\x7ctg_fbm_vss\x7ctg_fbs_vss\x7ctg_s_vss\x7cvss\x7cvss_link\x7cvss_link_bridge\x7cvss_link_dip\x7cvss_link_m1\x7cvss_x1\x7cvss_x2\x7cvss_x3__t195
+ g_vss_m1|inv_clk_vss|inv_mc_vss|inv_q_vss|mph_g|nand_m_vss|nand_s2_vss|s1_vss_m1|s2_vss_m1|s3_vss_m1|s4_vss_m1|sb_vss|sr1_vss|sr2_vss|sr3_vss|sr4_vss|sv_vss|tg_d_vss|tg_fbm_vss|tg_fbs_vss|tg_s_vss|vss|vss_link|vss_link_bridge|vss_link_dip|vss_link_m1|vss_x1|vss_x2|vss_x3
+ 128.927412287
* device instance g_vss_m1_inv_clk_vss_inv_mc_vss_inv_q_vss_mph_g_nand_m_vss_nand_s2_vss_s1_vss_m1_s2_vss_m1_s3_vss_m1_s4_vss_m1_sb_vss_sr1_vss_sr2_vss_sr3_vss_sr4_vss_sv_vss_tg_d_vss_tg_fbm_vss_tg_fbs_vss_tg_s_vss_vss_vss_link_vss_link_bridge_vss_link_dip_vss_link_m1_vss_x1_vss_x2_vss_x3_t196 r0 *1 0,0
Rg_vss_m1_inv_clk_vss_inv_mc_vss_inv_q_vss_mph_g_nand_m_vss_nand_s2_vss_s1_vss_m1_s2_vss_m1_s3_vss_m1_s4_vss_m1_sb_vss_sr1_vss_sr2_vss_sr3_vss_sr4_vss_sv_vss_tg_d_vss_tg_fbm_vss_tg_fbs_vss_tg_s_vss_vss_vss_link_vss_link_bridge_vss_link_dip_vss_link_m1_vss_x1_vss_x2_vss_x3_t196
+ g_vss_m1\x7cinv_clk_vss\x7cinv_mc_vss\x7cinv_q_vss\x7cmph_g\x7cnand_m_vss\x7cnand_s2_vss\x7cs1_vss_m1\x7cs2_vss_m1\x7cs3_vss_m1\x7cs4_vss_m1\x7csb_vss\x7csr1_vss\x7csr2_vss\x7csr3_vss\x7csr4_vss\x7csv_vss\x7ctg_d_vss\x7ctg_fbm_vss\x7ctg_fbs_vss\x7ctg_s_vss\x7cvss\x7cvss_link\x7cvss_link_bridge\x7cvss_link_dip\x7cvss_link_m1\x7cvss_x1\x7cvss_x2\x7cvss_x3__t196
+ g_vss_m1|inv_clk_vss|inv_mc_vss|inv_q_vss|mph_g|nand_m_vss|nand_s2_vss|s1_vss_m1|s2_vss_m1|s3_vss_m1|s4_vss_m1|sb_vss|sr1_vss|sr2_vss|sr3_vss|sr4_vss|sv_vss|tg_d_vss|tg_fbm_vss|tg_fbs_vss|tg_s_vss|vss|vss_link|vss_link_bridge|vss_link_dip|vss_link_m1|vss_x1|vss_x2|vss_x3
+ 111.899576935
* device instance g_vss_m1_inv_clk_vss_inv_mc_vss_inv_q_vss_mph_g_nand_m_vss_nand_s2_vss_s1_vss_m1_s2_vss_m1_s3_vss_m1_s4_vss_m1_sb_vss_sr1_vss_sr2_vss_sr3_vss_sr4_vss_sv_vss_tg_d_vss_tg_fbm_vss_tg_fbs_vss_tg_s_vss_vss_vss_link_vss_link_bridge_vss_link_dip_vss_link_m1_vss_x1_vss_x2_vss_x3_t197 r0 *1 0,0
Rg_vss_m1_inv_clk_vss_inv_mc_vss_inv_q_vss_mph_g_nand_m_vss_nand_s2_vss_s1_vss_m1_s2_vss_m1_s3_vss_m1_s4_vss_m1_sb_vss_sr1_vss_sr2_vss_sr3_vss_sr4_vss_sv_vss_tg_d_vss_tg_fbm_vss_tg_fbs_vss_tg_s_vss_vss_vss_link_vss_link_bridge_vss_link_dip_vss_link_m1_vss_x1_vss_x2_vss_x3_t197
+ g_vss_m1\x7cinv_clk_vss\x7cinv_mc_vss\x7cinv_q_vss\x7cmph_g\x7cnand_m_vss\x7cnand_s2_vss\x7cs1_vss_m1\x7cs2_vss_m1\x7cs3_vss_m1\x7cs4_vss_m1\x7csb_vss\x7csr1_vss\x7csr2_vss\x7csr3_vss\x7csr4_vss\x7csv_vss\x7ctg_d_vss\x7ctg_fbm_vss\x7ctg_fbs_vss\x7ctg_s_vss\x7cvss\x7cvss_link\x7cvss_link_bridge\x7cvss_link_dip\x7cvss_link_m1\x7cvss_x1\x7cvss_x2\x7cvss_x3__t197
+ g_vss_m1|inv_clk_vss|inv_mc_vss|inv_q_vss|mph_g|nand_m_vss|nand_s2_vss|s1_vss_m1|s2_vss_m1|s3_vss_m1|s4_vss_m1|sb_vss|sr1_vss|sr2_vss|sr3_vss|sr4_vss|sv_vss|tg_d_vss|tg_fbm_vss|tg_fbs_vss|tg_s_vss|vss|vss_link|vss_link_bridge|vss_link_dip|vss_link_m1|vss_x1|vss_x2|vss_x3
+ 84.390769607
* device instance g_vss_m1_inv_clk_vss_inv_mc_vss_inv_q_vss_mph_g_nand_m_vss_nand_s2_vss_s1_vss_m1_s2_vss_m1_s3_vss_m1_s4_vss_m1_sb_vss_sr1_vss_sr2_vss_sr3_vss_sr4_vss_sv_vss_tg_d_vss_tg_fbm_vss_tg_fbs_vss_tg_s_vss_vss_vss_link_vss_link_bridge_vss_link_dip_vss_link_m1_vss_x1_vss_x2_vss_x3_t198 r0 *1 0,0
Rg_vss_m1_inv_clk_vss_inv_mc_vss_inv_q_vss_mph_g_nand_m_vss_nand_s2_vss_s1_vss_m1_s2_vss_m1_s3_vss_m1_s4_vss_m1_sb_vss_sr1_vss_sr2_vss_sr3_vss_sr4_vss_sv_vss_tg_d_vss_tg_fbm_vss_tg_fbs_vss_tg_s_vss_vss_vss_link_vss_link_bridge_vss_link_dip_vss_link_m1_vss_x1_vss_x2_vss_x3_t198
+ g_vss_m1\x7cinv_clk_vss\x7cinv_mc_vss\x7cinv_q_vss\x7cmph_g\x7cnand_m_vss\x7cnand_s2_vss\x7cs1_vss_m1\x7cs2_vss_m1\x7cs3_vss_m1\x7cs4_vss_m1\x7csb_vss\x7csr1_vss\x7csr2_vss\x7csr3_vss\x7csr4_vss\x7csv_vss\x7ctg_d_vss\x7ctg_fbm_vss\x7ctg_fbs_vss\x7ctg_s_vss\x7cvss\x7cvss_link\x7cvss_link_bridge\x7cvss_link_dip\x7cvss_link_m1\x7cvss_x1\x7cvss_x2\x7cvss_x3__t198
+ g_vss_m1|inv_clk_vss|inv_mc_vss|inv_q_vss|mph_g|nand_m_vss|nand_s2_vss|s1_vss_m1|s2_vss_m1|s3_vss_m1|s4_vss_m1|sb_vss|sr1_vss|sr2_vss|sr3_vss|sr4_vss|sv_vss|tg_d_vss|tg_fbm_vss|tg_fbs_vss|tg_s_vss|vss|vss_link|vss_link_bridge|vss_link_dip|vss_link_m1|vss_x1|vss_x2|vss_x3
+ 201.338416883
* device instance g_vss_m1_inv_clk_vss_inv_mc_vss_inv_q_vss_mph_g_nand_m_vss_nand_s2_vss_s1_vss_m1_s2_vss_m1_s3_vss_m1_s4_vss_m1_sb_vss_sr1_vss_sr2_vss_sr3_vss_sr4_vss_sv_vss_tg_d_vss_tg_fbm_vss_tg_fbs_vss_tg_s_vss_vss_vss_link_vss_link_bridge_vss_link_dip_vss_link_m1_vss_x1_vss_x2_vss_x3_t199 r0 *1 0,0
Rg_vss_m1_inv_clk_vss_inv_mc_vss_inv_q_vss_mph_g_nand_m_vss_nand_s2_vss_s1_vss_m1_s2_vss_m1_s3_vss_m1_s4_vss_m1_sb_vss_sr1_vss_sr2_vss_sr3_vss_sr4_vss_sv_vss_tg_d_vss_tg_fbm_vss_tg_fbs_vss_tg_s_vss_vss_vss_link_vss_link_bridge_vss_link_dip_vss_link_m1_vss_x1_vss_x2_vss_x3_t199
+ g_vss_m1\x7cinv_clk_vss\x7cinv_mc_vss\x7cinv_q_vss\x7cmph_g\x7cnand_m_vss\x7cnand_s2_vss\x7cs1_vss_m1\x7cs2_vss_m1\x7cs3_vss_m1\x7cs4_vss_m1\x7csb_vss\x7csr1_vss\x7csr2_vss\x7csr3_vss\x7csr4_vss\x7csv_vss\x7ctg_d_vss\x7ctg_fbm_vss\x7ctg_fbs_vss\x7ctg_s_vss\x7cvss\x7cvss_link\x7cvss_link_bridge\x7cvss_link_dip\x7cvss_link_m1\x7cvss_x1\x7cvss_x2\x7cvss_x3__t199
+ g_vss_m1|inv_clk_vss|inv_mc_vss|inv_q_vss|mph_g|nand_m_vss|nand_s2_vss|s1_vss_m1|s2_vss_m1|s3_vss_m1|s4_vss_m1|sb_vss|sr1_vss|sr2_vss|sr3_vss|sr4_vss|sv_vss|tg_d_vss|tg_fbm_vss|tg_fbs_vss|tg_s_vss|vss|vss_link|vss_link_bridge|vss_link_dip|vss_link_m1|vss_x1|vss_x2|vss_x3
+ 185.654675919
* device instance g_vss_m1_inv_clk_vss_inv_mc_vss_inv_q_vss_mph_g_nand_m_vss_nand_s2_vss_s1_vss_m1_s2_vss_m1_s3_vss_m1_s4_vss_m1_sb_vss_sr1_vss_sr2_vss_sr3_vss_sr4_vss_sv_vss_tg_d_vss_tg_fbm_vss_tg_fbs_vss_tg_s_vss_vss_vss_link_vss_link_bridge_vss_link_dip_vss_link_m1_vss_x1_vss_x2_vss_x3_t200 r0 *1 0,0
Rg_vss_m1_inv_clk_vss_inv_mc_vss_inv_q_vss_mph_g_nand_m_vss_nand_s2_vss_s1_vss_m1_s2_vss_m1_s3_vss_m1_s4_vss_m1_sb_vss_sr1_vss_sr2_vss_sr3_vss_sr4_vss_sv_vss_tg_d_vss_tg_fbm_vss_tg_fbs_vss_tg_s_vss_vss_vss_link_vss_link_bridge_vss_link_dip_vss_link_m1_vss_x1_vss_x2_vss_x3_t200
+ g_vss_m1\x7cinv_clk_vss\x7cinv_mc_vss\x7cinv_q_vss\x7cmph_g\x7cnand_m_vss\x7cnand_s2_vss\x7cs1_vss_m1\x7cs2_vss_m1\x7cs3_vss_m1\x7cs4_vss_m1\x7csb_vss\x7csr1_vss\x7csr2_vss\x7csr3_vss\x7csr4_vss\x7csv_vss\x7ctg_d_vss\x7ctg_fbm_vss\x7ctg_fbs_vss\x7ctg_s_vss\x7cvss\x7cvss_link\x7cvss_link_bridge\x7cvss_link_dip\x7cvss_link_m1\x7cvss_x1\x7cvss_x2\x7cvss_x3__t200
+ g_vss_m1|inv_clk_vss|inv_mc_vss|inv_q_vss|mph_g|nand_m_vss|nand_s2_vss|s1_vss_m1|s2_vss_m1|s3_vss_m1|s4_vss_m1|sb_vss|sr1_vss|sr2_vss|sr3_vss|sr4_vss|sv_vss|tg_d_vss|tg_fbm_vss|tg_fbs_vss|tg_s_vss|vss|vss_link|vss_link_bridge|vss_link_dip|vss_link_m1|vss_x1|vss_x2|vss_x3
+ 171.873742661
* device instance g_vss_m1_inv_clk_vss_inv_mc_vss_inv_q_vss_mph_g_nand_m_vss_nand_s2_vss_s1_vss_m1_s2_vss_m1_s3_vss_m1_s4_vss_m1_sb_vss_sr1_vss_sr2_vss_sr3_vss_sr4_vss_sv_vss_tg_d_vss_tg_fbm_vss_tg_fbs_vss_tg_s_vss_vss_vss_link_vss_link_bridge_vss_link_dip_vss_link_m1_vss_x1_vss_x2_vss_x3_t201 r0 *1 0,0
Rg_vss_m1_inv_clk_vss_inv_mc_vss_inv_q_vss_mph_g_nand_m_vss_nand_s2_vss_s1_vss_m1_s2_vss_m1_s3_vss_m1_s4_vss_m1_sb_vss_sr1_vss_sr2_vss_sr3_vss_sr4_vss_sv_vss_tg_d_vss_tg_fbm_vss_tg_fbs_vss_tg_s_vss_vss_vss_link_vss_link_bridge_vss_link_dip_vss_link_m1_vss_x1_vss_x2_vss_x3_t201
+ g_vss_m1\x7cinv_clk_vss\x7cinv_mc_vss\x7cinv_q_vss\x7cmph_g\x7cnand_m_vss\x7cnand_s2_vss\x7cs1_vss_m1\x7cs2_vss_m1\x7cs3_vss_m1\x7cs4_vss_m1\x7csb_vss\x7csr1_vss\x7csr2_vss\x7csr3_vss\x7csr4_vss\x7csv_vss\x7ctg_d_vss\x7ctg_fbm_vss\x7ctg_fbs_vss\x7ctg_s_vss\x7cvss\x7cvss_link\x7cvss_link_bridge\x7cvss_link_dip\x7cvss_link_m1\x7cvss_x1\x7cvss_x2\x7cvss_x3__t201
+ g_vss_m1|inv_clk_vss|inv_mc_vss|inv_q_vss|mph_g|nand_m_vss|nand_s2_vss|s1_vss_m1|s2_vss_m1|s3_vss_m1|s4_vss_m1|sb_vss|sr1_vss|sr2_vss|sr3_vss|sr4_vss|sv_vss|tg_d_vss|tg_fbm_vss|tg_fbs_vss|tg_s_vss|vss|vss_link|vss_link_bridge|vss_link_dip|vss_link_m1|vss_x1|vss_x2|vss_x3
+ 158.099459212
* device instance g_vss_m1_inv_clk_vss_inv_mc_vss_inv_q_vss_mph_g_nand_m_vss_nand_s2_vss_s1_vss_m1_s2_vss_m1_s3_vss_m1_s4_vss_m1_sb_vss_sr1_vss_sr2_vss_sr3_vss_sr4_vss_sv_vss_tg_d_vss_tg_fbm_vss_tg_fbs_vss_tg_s_vss_vss_vss_link_vss_link_bridge_vss_link_dip_vss_link_m1_vss_x1_vss_x2_vss_x3_t202 r0 *1 0,0
Rg_vss_m1_inv_clk_vss_inv_mc_vss_inv_q_vss_mph_g_nand_m_vss_nand_s2_vss_s1_vss_m1_s2_vss_m1_s3_vss_m1_s4_vss_m1_sb_vss_sr1_vss_sr2_vss_sr3_vss_sr4_vss_sv_vss_tg_d_vss_tg_fbm_vss_tg_fbs_vss_tg_s_vss_vss_vss_link_vss_link_bridge_vss_link_dip_vss_link_m1_vss_x1_vss_x2_vss_x3_t202
+ g_vss_m1\x7cinv_clk_vss\x7cinv_mc_vss\x7cinv_q_vss\x7cmph_g\x7cnand_m_vss\x7cnand_s2_vss\x7cs1_vss_m1\x7cs2_vss_m1\x7cs3_vss_m1\x7cs4_vss_m1\x7csb_vss\x7csr1_vss\x7csr2_vss\x7csr3_vss\x7csr4_vss\x7csv_vss\x7ctg_d_vss\x7ctg_fbm_vss\x7ctg_fbs_vss\x7ctg_s_vss\x7cvss\x7cvss_link\x7cvss_link_bridge\x7cvss_link_dip\x7cvss_link_m1\x7cvss_x1\x7cvss_x2\x7cvss_x3__t202
+ g_vss_m1|inv_clk_vss|inv_mc_vss|inv_q_vss|mph_g|nand_m_vss|nand_s2_vss|s1_vss_m1|s2_vss_m1|s3_vss_m1|s4_vss_m1|sb_vss|sr1_vss|sr2_vss|sr3_vss|sr4_vss|sv_vss|tg_d_vss|tg_fbm_vss|tg_fbs_vss|tg_s_vss|vss|vss_link|vss_link_bridge|vss_link_dip|vss_link_m1|vss_x1|vss_x2|vss_x3
+ 144.333729431
* device instance g_vss_m1_inv_clk_vss_inv_mc_vss_inv_q_vss_mph_g_nand_m_vss_nand_s2_vss_s1_vss_m1_s2_vss_m1_s3_vss_m1_s4_vss_m1_sb_vss_sr1_vss_sr2_vss_sr3_vss_sr4_vss_sv_vss_tg_d_vss_tg_fbm_vss_tg_fbs_vss_tg_s_vss_vss_vss_link_vss_link_bridge_vss_link_dip_vss_link_m1_vss_x1_vss_x2_vss_x3_t203 r0 *1 0,0
Rg_vss_m1_inv_clk_vss_inv_mc_vss_inv_q_vss_mph_g_nand_m_vss_nand_s2_vss_s1_vss_m1_s2_vss_m1_s3_vss_m1_s4_vss_m1_sb_vss_sr1_vss_sr2_vss_sr3_vss_sr4_vss_sv_vss_tg_d_vss_tg_fbm_vss_tg_fbs_vss_tg_s_vss_vss_vss_link_vss_link_bridge_vss_link_dip_vss_link_m1_vss_x1_vss_x2_vss_x3_t203
+ g_vss_m1\x7cinv_clk_vss\x7cinv_mc_vss\x7cinv_q_vss\x7cmph_g\x7cnand_m_vss\x7cnand_s2_vss\x7cs1_vss_m1\x7cs2_vss_m1\x7cs3_vss_m1\x7cs4_vss_m1\x7csb_vss\x7csr1_vss\x7csr2_vss\x7csr3_vss\x7csr4_vss\x7csv_vss\x7ctg_d_vss\x7ctg_fbm_vss\x7ctg_fbs_vss\x7ctg_s_vss\x7cvss\x7cvss_link\x7cvss_link_bridge\x7cvss_link_dip\x7cvss_link_m1\x7cvss_x1\x7cvss_x2\x7cvss_x3__t203
+ g_vss_m1|inv_clk_vss|inv_mc_vss|inv_q_vss|mph_g|nand_m_vss|nand_s2_vss|s1_vss_m1|s2_vss_m1|s3_vss_m1|s4_vss_m1|sb_vss|sr1_vss|sr2_vss|sr3_vss|sr4_vss|sv_vss|tg_d_vss|tg_fbm_vss|tg_fbs_vss|tg_s_vss|vss|vss_link|vss_link_bridge|vss_link_dip|vss_link_m1|vss_x1|vss_x2|vss_x3
+ 108.237100896
* device instance g_vss_m1_inv_clk_vss_inv_mc_vss_inv_q_vss_mph_g_nand_m_vss_nand_s2_vss_s1_vss_m1_s2_vss_m1_s3_vss_m1_s4_vss_m1_sb_vss_sr1_vss_sr2_vss_sr3_vss_sr4_vss_sv_vss_tg_d_vss_tg_fbm_vss_tg_fbs_vss_tg_s_vss_vss_vss_link_vss_link_bridge_vss_link_dip_vss_link_m1_vss_x1_vss_x2_vss_x3_t204 r0 *1 0,0
Rg_vss_m1_inv_clk_vss_inv_mc_vss_inv_q_vss_mph_g_nand_m_vss_nand_s2_vss_s1_vss_m1_s2_vss_m1_s3_vss_m1_s4_vss_m1_sb_vss_sr1_vss_sr2_vss_sr3_vss_sr4_vss_sv_vss_tg_d_vss_tg_fbm_vss_tg_fbs_vss_tg_s_vss_vss_vss_link_vss_link_bridge_vss_link_dip_vss_link_m1_vss_x1_vss_x2_vss_x3_t204
+ g_vss_m1\x7cinv_clk_vss\x7cinv_mc_vss\x7cinv_q_vss\x7cmph_g\x7cnand_m_vss\x7cnand_s2_vss\x7cs1_vss_m1\x7cs2_vss_m1\x7cs3_vss_m1\x7cs4_vss_m1\x7csb_vss\x7csr1_vss\x7csr2_vss\x7csr3_vss\x7csr4_vss\x7csv_vss\x7ctg_d_vss\x7ctg_fbm_vss\x7ctg_fbs_vss\x7ctg_s_vss\x7cvss\x7cvss_link\x7cvss_link_bridge\x7cvss_link_dip\x7cvss_link_m1\x7cvss_x1\x7cvss_x2\x7cvss_x3__t204
+ g_vss_m1|inv_clk_vss|inv_mc_vss|inv_q_vss|mph_g|nand_m_vss|nand_s2_vss|s1_vss_m1|s2_vss_m1|s3_vss_m1|s4_vss_m1|sb_vss|sr1_vss|sr2_vss|sr3_vss|sr4_vss|sv_vss|tg_d_vss|tg_fbm_vss|tg_fbs_vss|tg_s_vss|vss|vss_link|vss_link_bridge|vss_link_dip|vss_link_m1|vss_x1|vss_x2|vss_x3
+ 92.6546843469
* device instance g_vss_m1_inv_clk_vss_inv_mc_vss_inv_q_vss_mph_g_nand_m_vss_nand_s2_vss_s1_vss_m1_s2_vss_m1_s3_vss_m1_s4_vss_m1_sb_vss_sr1_vss_sr2_vss_sr3_vss_sr4_vss_sv_vss_tg_d_vss_tg_fbm_vss_tg_fbs_vss_tg_s_vss_vss_vss_link_vss_link_bridge_vss_link_dip_vss_link_m1_vss_x1_vss_x2_vss_x3_t205 r0 *1 0,0
Rg_vss_m1_inv_clk_vss_inv_mc_vss_inv_q_vss_mph_g_nand_m_vss_nand_s2_vss_s1_vss_m1_s2_vss_m1_s3_vss_m1_s4_vss_m1_sb_vss_sr1_vss_sr2_vss_sr3_vss_sr4_vss_sv_vss_tg_d_vss_tg_fbm_vss_tg_fbs_vss_tg_s_vss_vss_vss_link_vss_link_bridge_vss_link_dip_vss_link_m1_vss_x1_vss_x2_vss_x3_t205
+ g_vss_m1\x7cinv_clk_vss\x7cinv_mc_vss\x7cinv_q_vss\x7cmph_g\x7cnand_m_vss\x7cnand_s2_vss\x7cs1_vss_m1\x7cs2_vss_m1\x7cs3_vss_m1\x7cs4_vss_m1\x7csb_vss\x7csr1_vss\x7csr2_vss\x7csr3_vss\x7csr4_vss\x7csv_vss\x7ctg_d_vss\x7ctg_fbm_vss\x7ctg_fbs_vss\x7ctg_s_vss\x7cvss\x7cvss_link\x7cvss_link_bridge\x7cvss_link_dip\x7cvss_link_m1\x7cvss_x1\x7cvss_x2\x7cvss_x3__t205
+ g_vss_m1|inv_clk_vss|inv_mc_vss|inv_q_vss|mph_g|nand_m_vss|nand_s2_vss|s1_vss_m1|s2_vss_m1|s3_vss_m1|s4_vss_m1|sb_vss|sr1_vss|sr2_vss|sr3_vss|sr4_vss|sv_vss|tg_d_vss|tg_fbm_vss|tg_fbs_vss|tg_s_vss|vss|vss_link|vss_link_bridge|vss_link_dip|vss_link_m1|vss_x1|vss_x2|vss_x3
+ 79.0025094375
* device instance g_vss_m1_inv_clk_vss_inv_mc_vss_inv_q_vss_mph_g_nand_m_vss_nand_s2_vss_s1_vss_m1_s2_vss_m1_s3_vss_m1_s4_vss_m1_sb_vss_sr1_vss_sr2_vss_sr3_vss_sr4_vss_sv_vss_tg_d_vss_tg_fbm_vss_tg_fbs_vss_tg_s_vss_vss_vss_link_vss_link_bridge_vss_link_dip_vss_link_m1_vss_x1_vss_x2_vss_x3_t206 r0 *1 0,0
Rg_vss_m1_inv_clk_vss_inv_mc_vss_inv_q_vss_mph_g_nand_m_vss_nand_s2_vss_s1_vss_m1_s2_vss_m1_s3_vss_m1_s4_vss_m1_sb_vss_sr1_vss_sr2_vss_sr3_vss_sr4_vss_sv_vss_tg_d_vss_tg_fbm_vss_tg_fbs_vss_tg_s_vss_vss_vss_link_vss_link_bridge_vss_link_dip_vss_link_m1_vss_x1_vss_x2_vss_x3_t206
+ g_vss_m1\x7cinv_clk_vss\x7cinv_mc_vss\x7cinv_q_vss\x7cmph_g\x7cnand_m_vss\x7cnand_s2_vss\x7cs1_vss_m1\x7cs2_vss_m1\x7cs3_vss_m1\x7cs4_vss_m1\x7csb_vss\x7csr1_vss\x7csr2_vss\x7csr3_vss\x7csr4_vss\x7csv_vss\x7ctg_d_vss\x7ctg_fbm_vss\x7ctg_fbs_vss\x7ctg_s_vss\x7cvss\x7cvss_link\x7cvss_link_bridge\x7cvss_link_dip\x7cvss_link_m1\x7cvss_x1\x7cvss_x2\x7cvss_x3__t206
+ g_vss_m1|inv_clk_vss|inv_mc_vss|inv_q_vss|mph_g|nand_m_vss|nand_s2_vss|s1_vss_m1|s2_vss_m1|s3_vss_m1|s4_vss_m1|sb_vss|sr1_vss|sr2_vss|sr3_vss|sr4_vss|sv_vss|tg_d_vss|tg_fbm_vss|tg_fbs_vss|tg_s_vss|vss|vss_link|vss_link_bridge|vss_link_dip|vss_link_m1|vss_x1|vss_x2|vss_x3
+ 65.4204350715
* device instance g_vss_m1_inv_clk_vss_inv_mc_vss_inv_q_vss_mph_g_nand_m_vss_nand_s2_vss_s1_vss_m1_s2_vss_m1_s3_vss_m1_s4_vss_m1_sb_vss_sr1_vss_sr2_vss_sr3_vss_sr4_vss_sv_vss_tg_d_vss_tg_fbm_vss_tg_fbs_vss_tg_s_vss_vss_vss_link_vss_link_bridge_vss_link_dip_vss_link_m1_vss_x1_vss_x2_vss_x3_t207 r0 *1 0,0
Rg_vss_m1_inv_clk_vss_inv_mc_vss_inv_q_vss_mph_g_nand_m_vss_nand_s2_vss_s1_vss_m1_s2_vss_m1_s3_vss_m1_s4_vss_m1_sb_vss_sr1_vss_sr2_vss_sr3_vss_sr4_vss_sv_vss_tg_d_vss_tg_fbm_vss_tg_fbs_vss_tg_s_vss_vss_vss_link_vss_link_bridge_vss_link_dip_vss_link_m1_vss_x1_vss_x2_vss_x3_t207
+ g_vss_m1\x7cinv_clk_vss\x7cinv_mc_vss\x7cinv_q_vss\x7cmph_g\x7cnand_m_vss\x7cnand_s2_vss\x7cs1_vss_m1\x7cs2_vss_m1\x7cs3_vss_m1\x7cs4_vss_m1\x7csb_vss\x7csr1_vss\x7csr2_vss\x7csr3_vss\x7csr4_vss\x7csv_vss\x7ctg_d_vss\x7ctg_fbm_vss\x7ctg_fbs_vss\x7ctg_s_vss\x7cvss\x7cvss_link\x7cvss_link_bridge\x7cvss_link_dip\x7cvss_link_m1\x7cvss_x1\x7cvss_x2\x7cvss_x3__t207
+ g_vss_m1|inv_clk_vss|inv_mc_vss|inv_q_vss|mph_g|nand_m_vss|nand_s2_vss|s1_vss_m1|s2_vss_m1|s3_vss_m1|s4_vss_m1|sb_vss|sr1_vss|sr2_vss|sr3_vss|sr4_vss|sv_vss|tg_d_vss|tg_fbm_vss|tg_fbs_vss|tg_s_vss|vss|vss_link|vss_link_bridge|vss_link_dip|vss_link_m1|vss_x1|vss_x2|vss_x3
+ 51.963458449
* device instance g_vss_m1_inv_clk_vss_inv_mc_vss_inv_q_vss_mph_g_nand_m_vss_nand_s2_vss_s1_vss_m1_s2_vss_m1_s3_vss_m1_s4_vss_m1_sb_vss_sr1_vss_sr2_vss_sr3_vss_sr4_vss_sv_vss_tg_d_vss_tg_fbm_vss_tg_fbs_vss_tg_s_vss_vss_vss_link_vss_link_bridge_vss_link_dip_vss_link_m1_vss_x1_vss_x2_vss_x3_t208 r0 *1 0,0
Rg_vss_m1_inv_clk_vss_inv_mc_vss_inv_q_vss_mph_g_nand_m_vss_nand_s2_vss_s1_vss_m1_s2_vss_m1_s3_vss_m1_s4_vss_m1_sb_vss_sr1_vss_sr2_vss_sr3_vss_sr4_vss_sv_vss_tg_d_vss_tg_fbm_vss_tg_fbs_vss_tg_s_vss_vss_vss_link_vss_link_bridge_vss_link_dip_vss_link_m1_vss_x1_vss_x2_vss_x3_t208
+ g_vss_m1\x7cinv_clk_vss\x7cinv_mc_vss\x7cinv_q_vss\x7cmph_g\x7cnand_m_vss\x7cnand_s2_vss\x7cs1_vss_m1\x7cs2_vss_m1\x7cs3_vss_m1\x7cs4_vss_m1\x7csb_vss\x7csr1_vss\x7csr2_vss\x7csr3_vss\x7csr4_vss\x7csv_vss\x7ctg_d_vss\x7ctg_fbm_vss\x7ctg_fbs_vss\x7ctg_s_vss\x7cvss\x7cvss_link\x7cvss_link_bridge\x7cvss_link_dip\x7cvss_link_m1\x7cvss_x1\x7cvss_x2\x7cvss_x3__t208
+ g_vss_m1|inv_clk_vss|inv_mc_vss|inv_q_vss|mph_g|nand_m_vss|nand_s2_vss|s1_vss_m1|s2_vss_m1|s3_vss_m1|s4_vss_m1|sb_vss|sr1_vss|sr2_vss|sr3_vss|sr4_vss|sv_vss|tg_d_vss|tg_fbm_vss|tg_fbs_vss|tg_s_vss|vss|vss_link|vss_link_bridge|vss_link_dip|vss_link_m1|vss_x1|vss_x2|vss_x3
+ 19.2375769459
* device instance g_vss_m1_inv_clk_vss_inv_mc_vss_inv_q_vss_mph_g_nand_m_vss_nand_s2_vss_s1_vss_m1_s2_vss_m1_s3_vss_m1_s4_vss_m1_sb_vss_sr1_vss_sr2_vss_sr3_vss_sr4_vss_sv_vss_tg_d_vss_tg_fbm_vss_tg_fbs_vss_tg_s_vss_vss_vss_link_vss_link_bridge_vss_link_dip_vss_link_m1_vss_x1_vss_x2_vss_x3_t209 r0 *1 0,0
Rg_vss_m1_inv_clk_vss_inv_mc_vss_inv_q_vss_mph_g_nand_m_vss_nand_s2_vss_s1_vss_m1_s2_vss_m1_s3_vss_m1_s4_vss_m1_sb_vss_sr1_vss_sr2_vss_sr3_vss_sr4_vss_sv_vss_tg_d_vss_tg_fbm_vss_tg_fbs_vss_tg_s_vss_vss_vss_link_vss_link_bridge_vss_link_dip_vss_link_m1_vss_x1_vss_x2_vss_x3_t209
+ g_vss_m1\x7cinv_clk_vss\x7cinv_mc_vss\x7cinv_q_vss\x7cmph_g\x7cnand_m_vss\x7cnand_s2_vss\x7cs1_vss_m1\x7cs2_vss_m1\x7cs3_vss_m1\x7cs4_vss_m1\x7csb_vss\x7csr1_vss\x7csr2_vss\x7csr3_vss\x7csr4_vss\x7csv_vss\x7ctg_d_vss\x7ctg_fbm_vss\x7ctg_fbs_vss\x7ctg_s_vss\x7cvss\x7cvss_link\x7cvss_link_bridge\x7cvss_link_dip\x7cvss_link_m1\x7cvss_x1\x7cvss_x2\x7cvss_x3__t209
+ g_vss_m1|inv_clk_vss|inv_mc_vss|inv_q_vss|mph_g|nand_m_vss|nand_s2_vss|s1_vss_m1|s2_vss_m1|s3_vss_m1|s4_vss_m1|sb_vss|sr1_vss|sr2_vss|sr3_vss|sr4_vss|sv_vss|tg_d_vss|tg_fbm_vss|tg_fbs_vss|tg_s_vss|vss|vss_link|vss_link_bridge|vss_link_dip|vss_link_m1|vss_x1|vss_x2|vss_x3
+ 13.372540194
* device instance g_vss_m1_inv_clk_vss_inv_mc_vss_inv_q_vss_mph_g_nand_m_vss_nand_s2_vss_s1_vss_m1_s2_vss_m1_s3_vss_m1_s4_vss_m1_sb_vss_sr1_vss_sr2_vss_sr3_vss_sr4_vss_sv_vss_tg_d_vss_tg_fbm_vss_tg_fbs_vss_tg_s_vss_vss_vss_link_vss_link_bridge_vss_link_dip_vss_link_m1_vss_x1_vss_x2_vss_x3_t210 r0 *1 0,0
Rg_vss_m1_inv_clk_vss_inv_mc_vss_inv_q_vss_mph_g_nand_m_vss_nand_s2_vss_s1_vss_m1_s2_vss_m1_s3_vss_m1_s4_vss_m1_sb_vss_sr1_vss_sr2_vss_sr3_vss_sr4_vss_sv_vss_tg_d_vss_tg_fbm_vss_tg_fbs_vss_tg_s_vss_vss_vss_link_vss_link_bridge_vss_link_dip_vss_link_m1_vss_x1_vss_x2_vss_x3_t210
+ g_vss_m1\x7cinv_clk_vss\x7cinv_mc_vss\x7cinv_q_vss\x7cmph_g\x7cnand_m_vss\x7cnand_s2_vss\x7cs1_vss_m1\x7cs2_vss_m1\x7cs3_vss_m1\x7cs4_vss_m1\x7csb_vss\x7csr1_vss\x7csr2_vss\x7csr3_vss\x7csr4_vss\x7csv_vss\x7ctg_d_vss\x7ctg_fbm_vss\x7ctg_fbs_vss\x7ctg_s_vss\x7cvss\x7cvss_link\x7cvss_link_bridge\x7cvss_link_dip\x7cvss_link_m1\x7cvss_x1\x7cvss_x2\x7cvss_x3__t210
+ g_vss_m1|inv_clk_vss|inv_mc_vss|inv_q_vss|mph_g|nand_m_vss|nand_s2_vss|s1_vss_m1|s2_vss_m1|s3_vss_m1|s4_vss_m1|sb_vss|sr1_vss|sr2_vss|sr3_vss|sr4_vss|sv_vss|tg_d_vss|tg_fbm_vss|tg_fbs_vss|tg_s_vss|vss|vss_link|vss_link_bridge|vss_link_dip|vss_link_m1|vss_x1|vss_x2|vss_x3
+ 20.4673407606
* device instance g_vss_m1_inv_clk_vss_inv_mc_vss_inv_q_vss_mph_g_nand_m_vss_nand_s2_vss_s1_vss_m1_s2_vss_m1_s3_vss_m1_s4_vss_m1_sb_vss_sr1_vss_sr2_vss_sr3_vss_sr4_vss_sv_vss_tg_d_vss_tg_fbm_vss_tg_fbs_vss_tg_s_vss_vss_vss_link_vss_link_bridge_vss_link_dip_vss_link_m1_vss_x1_vss_x2_vss_x3_t211 r0 *1 0,0
Rg_vss_m1_inv_clk_vss_inv_mc_vss_inv_q_vss_mph_g_nand_m_vss_nand_s2_vss_s1_vss_m1_s2_vss_m1_s3_vss_m1_s4_vss_m1_sb_vss_sr1_vss_sr2_vss_sr3_vss_sr4_vss_sv_vss_tg_d_vss_tg_fbm_vss_tg_fbs_vss_tg_s_vss_vss_vss_link_vss_link_bridge_vss_link_dip_vss_link_m1_vss_x1_vss_x2_vss_x3_t211
+ g_vss_m1\x7cinv_clk_vss\x7cinv_mc_vss\x7cinv_q_vss\x7cmph_g\x7cnand_m_vss\x7cnand_s2_vss\x7cs1_vss_m1\x7cs2_vss_m1\x7cs3_vss_m1\x7cs4_vss_m1\x7csb_vss\x7csr1_vss\x7csr2_vss\x7csr3_vss\x7csr4_vss\x7csv_vss\x7ctg_d_vss\x7ctg_fbm_vss\x7ctg_fbs_vss\x7ctg_s_vss\x7cvss\x7cvss_link\x7cvss_link_bridge\x7cvss_link_dip\x7cvss_link_m1\x7cvss_x1\x7cvss_x2\x7cvss_x3__t211
+ g_vss_m1|inv_clk_vss|inv_mc_vss|inv_q_vss|mph_g|nand_m_vss|nand_s2_vss|s1_vss_m1|s2_vss_m1|s3_vss_m1|s4_vss_m1|sb_vss|sr1_vss|sr2_vss|sr3_vss|sr4_vss|sv_vss|tg_d_vss|tg_fbm_vss|tg_fbs_vss|tg_s_vss|vss|vss_link|vss_link_bridge|vss_link_dip|vss_link_m1|vss_x1|vss_x2|vss_x3
+ 32.2634484501
* device instance g_vss_m1_inv_clk_vss_inv_mc_vss_inv_q_vss_mph_g_nand_m_vss_nand_s2_vss_s1_vss_m1_s2_vss_m1_s3_vss_m1_s4_vss_m1_sb_vss_sr1_vss_sr2_vss_sr3_vss_sr4_vss_sv_vss_tg_d_vss_tg_fbm_vss_tg_fbs_vss_tg_s_vss_vss_vss_link_vss_link_bridge_vss_link_dip_vss_link_m1_vss_x1_vss_x2_vss_x3_t212 r0 *1 0,0
Rg_vss_m1_inv_clk_vss_inv_mc_vss_inv_q_vss_mph_g_nand_m_vss_nand_s2_vss_s1_vss_m1_s2_vss_m1_s3_vss_m1_s4_vss_m1_sb_vss_sr1_vss_sr2_vss_sr3_vss_sr4_vss_sv_vss_tg_d_vss_tg_fbm_vss_tg_fbs_vss_tg_s_vss_vss_vss_link_vss_link_bridge_vss_link_dip_vss_link_m1_vss_x1_vss_x2_vss_x3_t212
+ g_vss_m1\x7cinv_clk_vss\x7cinv_mc_vss\x7cinv_q_vss\x7cmph_g\x7cnand_m_vss\x7cnand_s2_vss\x7cs1_vss_m1\x7cs2_vss_m1\x7cs3_vss_m1\x7cs4_vss_m1\x7csb_vss\x7csr1_vss\x7csr2_vss\x7csr3_vss\x7csr4_vss\x7csv_vss\x7ctg_d_vss\x7ctg_fbm_vss\x7ctg_fbs_vss\x7ctg_s_vss\x7cvss\x7cvss_link\x7cvss_link_bridge\x7cvss_link_dip\x7cvss_link_m1\x7cvss_x1\x7cvss_x2\x7cvss_x3__t212
+ g_vss_m1|inv_clk_vss|inv_mc_vss|inv_q_vss|mph_g|nand_m_vss|nand_s2_vss|s1_vss_m1|s2_vss_m1|s3_vss_m1|s4_vss_m1|sb_vss|sr1_vss|sr2_vss|sr3_vss|sr4_vss|sv_vss|tg_d_vss|tg_fbm_vss|tg_fbs_vss|tg_s_vss|vss|vss_link|vss_link_bridge|vss_link_dip|vss_link_m1|vss_x1|vss_x2|vss_x3
+ 45.2203387369
* device instance g_vss_m1_inv_clk_vss_inv_mc_vss_inv_q_vss_mph_g_nand_m_vss_nand_s2_vss_s1_vss_m1_s2_vss_m1_s3_vss_m1_s4_vss_m1_sb_vss_sr1_vss_sr2_vss_sr3_vss_sr4_vss_sv_vss_tg_d_vss_tg_fbm_vss_tg_fbs_vss_tg_s_vss_vss_vss_link_vss_link_bridge_vss_link_dip_vss_link_m1_vss_x1_vss_x2_vss_x3_t213 r0 *1 0,0
Rg_vss_m1_inv_clk_vss_inv_mc_vss_inv_q_vss_mph_g_nand_m_vss_nand_s2_vss_s1_vss_m1_s2_vss_m1_s3_vss_m1_s4_vss_m1_sb_vss_sr1_vss_sr2_vss_sr3_vss_sr4_vss_sv_vss_tg_d_vss_tg_fbm_vss_tg_fbs_vss_tg_s_vss_vss_vss_link_vss_link_bridge_vss_link_dip_vss_link_m1_vss_x1_vss_x2_vss_x3_t213
+ g_vss_m1\x7cinv_clk_vss\x7cinv_mc_vss\x7cinv_q_vss\x7cmph_g\x7cnand_m_vss\x7cnand_s2_vss\x7cs1_vss_m1\x7cs2_vss_m1\x7cs3_vss_m1\x7cs4_vss_m1\x7csb_vss\x7csr1_vss\x7csr2_vss\x7csr3_vss\x7csr4_vss\x7csv_vss\x7ctg_d_vss\x7ctg_fbm_vss\x7ctg_fbs_vss\x7ctg_s_vss\x7cvss\x7cvss_link\x7cvss_link_bridge\x7cvss_link_dip\x7cvss_link_m1\x7cvss_x1\x7cvss_x2\x7cvss_x3__t213
+ g_vss_m1|inv_clk_vss|inv_mc_vss|inv_q_vss|mph_g|nand_m_vss|nand_s2_vss|s1_vss_m1|s2_vss_m1|s3_vss_m1|s4_vss_m1|sb_vss|sr1_vss|sr2_vss|sr3_vss|sr4_vss|sv_vss|tg_d_vss|tg_fbm_vss|tg_fbs_vss|tg_s_vss|vss|vss_link|vss_link_bridge|vss_link_dip|vss_link_m1|vss_x1|vss_x2|vss_x3
+ 80.6325069824
* device instance g_vss_m1_inv_clk_vss_inv_mc_vss_inv_q_vss_mph_g_nand_m_vss_nand_s2_vss_s1_vss_m1_s2_vss_m1_s3_vss_m1_s4_vss_m1_sb_vss_sr1_vss_sr2_vss_sr3_vss_sr4_vss_sv_vss_tg_d_vss_tg_fbm_vss_tg_fbs_vss_tg_s_vss_vss_vss_link_vss_link_bridge_vss_link_dip_vss_link_m1_vss_x1_vss_x2_vss_x3_t214 r0 *1 0,0
Rg_vss_m1_inv_clk_vss_inv_mc_vss_inv_q_vss_mph_g_nand_m_vss_nand_s2_vss_s1_vss_m1_s2_vss_m1_s3_vss_m1_s4_vss_m1_sb_vss_sr1_vss_sr2_vss_sr3_vss_sr4_vss_sv_vss_tg_d_vss_tg_fbm_vss_tg_fbs_vss_tg_s_vss_vss_vss_link_vss_link_bridge_vss_link_dip_vss_link_m1_vss_x1_vss_x2_vss_x3_t214
+ g_vss_m1\x7cinv_clk_vss\x7cinv_mc_vss\x7cinv_q_vss\x7cmph_g\x7cnand_m_vss\x7cnand_s2_vss\x7cs1_vss_m1\x7cs2_vss_m1\x7cs3_vss_m1\x7cs4_vss_m1\x7csb_vss\x7csr1_vss\x7csr2_vss\x7csr3_vss\x7csr4_vss\x7csv_vss\x7ctg_d_vss\x7ctg_fbm_vss\x7ctg_fbs_vss\x7ctg_s_vss\x7cvss\x7cvss_link\x7cvss_link_bridge\x7cvss_link_dip\x7cvss_link_m1\x7cvss_x1\x7cvss_x2\x7cvss_x3__t214
+ g_vss_m1|inv_clk_vss|inv_mc_vss|inv_q_vss|mph_g|nand_m_vss|nand_s2_vss|s1_vss_m1|s2_vss_m1|s3_vss_m1|s4_vss_m1|sb_vss|sr1_vss|sr2_vss|sr3_vss|sr4_vss|sv_vss|tg_d_vss|tg_fbm_vss|tg_fbs_vss|tg_s_vss|vss|vss_link|vss_link_bridge|vss_link_dip|vss_link_m1|vss_x1|vss_x2|vss_x3
+ 96.174121208
* device instance g_vss_m1_inv_clk_vss_inv_mc_vss_inv_q_vss_mph_g_nand_m_vss_nand_s2_vss_s1_vss_m1_s2_vss_m1_s3_vss_m1_s4_vss_m1_sb_vss_sr1_vss_sr2_vss_sr3_vss_sr4_vss_sv_vss_tg_d_vss_tg_fbm_vss_tg_fbs_vss_tg_s_vss_vss_vss_link_vss_link_bridge_vss_link_dip_vss_link_m1_vss_x1_vss_x2_vss_x3_t215 r0 *1 0,0
Rg_vss_m1_inv_clk_vss_inv_mc_vss_inv_q_vss_mph_g_nand_m_vss_nand_s2_vss_s1_vss_m1_s2_vss_m1_s3_vss_m1_s4_vss_m1_sb_vss_sr1_vss_sr2_vss_sr3_vss_sr4_vss_sv_vss_tg_d_vss_tg_fbm_vss_tg_fbs_vss_tg_s_vss_vss_vss_link_vss_link_bridge_vss_link_dip_vss_link_m1_vss_x1_vss_x2_vss_x3_t215
+ g_vss_m1\x7cinv_clk_vss\x7cinv_mc_vss\x7cinv_q_vss\x7cmph_g\x7cnand_m_vss\x7cnand_s2_vss\x7cs1_vss_m1\x7cs2_vss_m1\x7cs3_vss_m1\x7cs4_vss_m1\x7csb_vss\x7csr1_vss\x7csr2_vss\x7csr3_vss\x7csr4_vss\x7csv_vss\x7ctg_d_vss\x7ctg_fbm_vss\x7ctg_fbs_vss\x7ctg_s_vss\x7cvss\x7cvss_link\x7cvss_link_bridge\x7cvss_link_dip\x7cvss_link_m1\x7cvss_x1\x7cvss_x2\x7cvss_x3__t215
+ g_vss_m1|inv_clk_vss|inv_mc_vss|inv_q_vss|mph_g|nand_m_vss|nand_s2_vss|s1_vss_m1|s2_vss_m1|s3_vss_m1|s4_vss_m1|sb_vss|sr1_vss|sr2_vss|sr3_vss|sr4_vss|sv_vss|tg_d_vss|tg_fbm_vss|tg_fbs_vss|tg_s_vss|vss|vss_link|vss_link_bridge|vss_link_dip|vss_link_m1|vss_x1|vss_x2|vss_x3
+ 109.877795925
* device instance g_vss_m1_inv_clk_vss_inv_mc_vss_inv_q_vss_mph_g_nand_m_vss_nand_s2_vss_s1_vss_m1_s2_vss_m1_s3_vss_m1_s4_vss_m1_sb_vss_sr1_vss_sr2_vss_sr3_vss_sr4_vss_sv_vss_tg_d_vss_tg_fbm_vss_tg_fbs_vss_tg_s_vss_vss_vss_link_vss_link_bridge_vss_link_dip_vss_link_m1_vss_x1_vss_x2_vss_x3_t216 r0 *1 0,0
Rg_vss_m1_inv_clk_vss_inv_mc_vss_inv_q_vss_mph_g_nand_m_vss_nand_s2_vss_s1_vss_m1_s2_vss_m1_s3_vss_m1_s4_vss_m1_sb_vss_sr1_vss_sr2_vss_sr3_vss_sr4_vss_sv_vss_tg_d_vss_tg_fbm_vss_tg_fbs_vss_tg_s_vss_vss_vss_link_vss_link_bridge_vss_link_dip_vss_link_m1_vss_x1_vss_x2_vss_x3_t216
+ g_vss_m1\x7cinv_clk_vss\x7cinv_mc_vss\x7cinv_q_vss\x7cmph_g\x7cnand_m_vss\x7cnand_s2_vss\x7cs1_vss_m1\x7cs2_vss_m1\x7cs3_vss_m1\x7cs4_vss_m1\x7csb_vss\x7csr1_vss\x7csr2_vss\x7csr3_vss\x7csr4_vss\x7csv_vss\x7ctg_d_vss\x7ctg_fbm_vss\x7ctg_fbs_vss\x7ctg_s_vss\x7cvss\x7cvss_link\x7cvss_link_bridge\x7cvss_link_dip\x7cvss_link_m1\x7cvss_x1\x7cvss_x2\x7cvss_x3__t216
+ g_vss_m1|inv_clk_vss|inv_mc_vss|inv_q_vss|mph_g|nand_m_vss|nand_s2_vss|s1_vss_m1|s2_vss_m1|s3_vss_m1|s4_vss_m1|sb_vss|sr1_vss|sr2_vss|sr3_vss|sr4_vss|sv_vss|tg_d_vss|tg_fbm_vss|tg_fbs_vss|tg_s_vss|vss|vss_link|vss_link_bridge|vss_link_dip|vss_link_m1|vss_x1|vss_x2|vss_x3
+ 123.607157341
* device instance g_vss_m1_inv_clk_vss_inv_mc_vss_inv_q_vss_mph_g_nand_m_vss_nand_s2_vss_s1_vss_m1_s2_vss_m1_s3_vss_m1_s4_vss_m1_sb_vss_sr1_vss_sr2_vss_sr3_vss_sr4_vss_sv_vss_tg_d_vss_tg_fbm_vss_tg_fbs_vss_tg_s_vss_vss_vss_link_vss_link_bridge_vss_link_dip_vss_link_m1_vss_x1_vss_x2_vss_x3_t217 r0 *1 0,0
Rg_vss_m1_inv_clk_vss_inv_mc_vss_inv_q_vss_mph_g_nand_m_vss_nand_s2_vss_s1_vss_m1_s2_vss_m1_s3_vss_m1_s4_vss_m1_sb_vss_sr1_vss_sr2_vss_sr3_vss_sr4_vss_sv_vss_tg_d_vss_tg_fbm_vss_tg_fbs_vss_tg_s_vss_vss_vss_link_vss_link_bridge_vss_link_dip_vss_link_m1_vss_x1_vss_x2_vss_x3_t217
+ g_vss_m1\x7cinv_clk_vss\x7cinv_mc_vss\x7cinv_q_vss\x7cmph_g\x7cnand_m_vss\x7cnand_s2_vss\x7cs1_vss_m1\x7cs2_vss_m1\x7cs3_vss_m1\x7cs4_vss_m1\x7csb_vss\x7csr1_vss\x7csr2_vss\x7csr3_vss\x7csr4_vss\x7csv_vss\x7ctg_d_vss\x7ctg_fbm_vss\x7ctg_fbs_vss\x7ctg_s_vss\x7cvss\x7cvss_link\x7cvss_link_bridge\x7cvss_link_dip\x7cvss_link_m1\x7cvss_x1\x7cvss_x2\x7cvss_x3__t217
+ g_vss_m1|inv_clk_vss|inv_mc_vss|inv_q_vss|mph_g|nand_m_vss|nand_s2_vss|s1_vss_m1|s2_vss_m1|s3_vss_m1|s4_vss_m1|sb_vss|sr1_vss|sr2_vss|sr3_vss|sr4_vss|sv_vss|tg_d_vss|tg_fbm_vss|tg_fbs_vss|tg_s_vss|vss|vss_link|vss_link_bridge|vss_link_dip|vss_link_m1|vss_x1|vss_x2|vss_x3
+ 137.354503079
* device instance g_vss_m1_inv_clk_vss_inv_mc_vss_inv_q_vss_mph_g_nand_m_vss_nand_s2_vss_s1_vss_m1_s2_vss_m1_s3_vss_m1_s4_vss_m1_sb_vss_sr1_vss_sr2_vss_sr3_vss_sr4_vss_sv_vss_tg_d_vss_tg_fbm_vss_tg_fbs_vss_tg_s_vss_vss_vss_link_vss_link_bridge_vss_link_dip_vss_link_m1_vss_x1_vss_x2_vss_x3 r0 *1 0,0
Cg_vss_m1_inv_clk_vss_inv_mc_vss_inv_q_vss_mph_g_nand_m_vss_nand_s2_vss_s1_vss_m1_s2_vss_m1_s3_vss_m1_s4_vss_m1_sb_vss_sr1_vss_sr2_vss_sr3_vss_sr4_vss_sv_vss_tg_d_vss_tg_fbm_vss_tg_fbs_vss_tg_s_vss_vss_vss_link_vss_link_bridge_vss_link_dip_vss_link_m1_vss_x1_vss_x2_vss_x3
+ g_vss_m1|inv_clk_vss|inv_mc_vss|inv_q_vss|mph_g|nand_m_vss|nand_s2_vss|s1_vss_m1|s2_vss_m1|s3_vss_m1|s4_vss_m1|sb_vss|sr1_vss|sr2_vss|sr3_vss|sr4_vss|sv_vss|tg_d_vss|tg_fbm_vss|tg_fbs_vss|tg_s_vss|vss|vss_link|vss_link_bridge|vss_link_dip|vss_link_m1|vss_x1|vss_x2|vss_x3
+ vsubs 1.79269212e-13
* device instance mid_t0 r0 *1 0,0
Rmid_t0 mid__t0 mid 149.893184895
* device instance mid_t1 r0 *1 0,0
Rmid_t1 mid__t1 mid 180.889615105
* device instance mid_t2 r0 *1 0,0
Rmid_t2 mid__t2 mid 149.893184895
* device instance mid_t3 r0 *1 0,0
Rmid_t3 mid__t3 mid 180.889615105
* device instance mid r0 *1 0,0
Cmid mid vsubs 1.103314e-15
* device instance mid_dup1_t0 r0 *1 0,0
Rmid_dup1_t0 mid__t02 mid$1 180.889615105
* device instance mid_dup1_t1 r0 *1 0,0
Rmid_dup1_t1 mid__t12 mid$1 149.893184895
* device instance mid_dup1_t2 r0 *1 0,0
Rmid_dup1_t2 mid__t22 mid$1 180.889615105
* device instance mid_dup1_t3 r0 *1 0,0
Rmid_dup1_t3 mid__t32 mid$1 149.893184895
* device instance mid_dup1 r0 *1 0,0
Cmid_dup1 mid$1 vsubs 1.101742e-15
* device instance mid_dup2_t0 r0 *1 0,0
Rmid_dup2_t0 mid__t03 mid$2 149.893184895
* device instance mid_dup2_t1 r0 *1 0,0
Rmid_dup2_t1 mid__t13 mid$2 180.889615105
* device instance mid_dup2_t2 r0 *1 0,0
Rmid_dup2_t2 mid__t23 mid$2 149.893184895
* device instance mid_dup2_t3 r0 *1 0,0
Rmid_dup2_t3 mid__t33 mid$2 180.889615105
* device instance mid_dup2 r0 *1 0,0
Cmid_dup2 mid$2 vsubs 1.101742e-15
* device instance mpa_py_mpb_py_mph_py_py_t0 r0 *1 0,0
Rmpa_py_mpb_py_mph_py_py_t0 mpa_py\x7cmpb_py\x7cmph_py\x7cpy__t0
+ mpa_py|mpb_py|mph_py|py 70.17055
* device instance mpa_py_mpb_py_mph_py_py_t1 r0 *1 0,0
Rmpa_py_mpb_py_mph_py_py_t1 mpa_py\x7cmpb_py\x7cmph_py\x7cpy__t1
+ mpa_py|mpb_py|mph_py|py 59.2454198843
* device instance mpa_py_mpb_py_mph_py_py_t2 r0 *1 0,0
Rmpa_py_mpb_py_mph_py_py_t2 mpa_py\x7cmpb_py\x7cmph_py\x7cpy__t2
+ mpa_py|mpb_py|mph_py|py 10.9251301157
* device instance mpa_py_mpb_py_mph_py_py r0 *1 0,0
Cmpa_py_mpb_py_mph_py_py mpa_py|mpb_py|mph_py|py vsubs 7.94002e-16
* device instance mpa_py_mpb_py_mph_py_py_dup1_t0 r0 *1 0,0
Rmpa_py_mpb_py_mph_py_py_dup1_t0 mpa_py\x7cmpb_py\x7cmph_py\x7cpy__t02
+ mpa_py|mpb_py|mph_py|py$1 70.3684
* device instance mpa_py_mpb_py_mph_py_py_dup1_t1 r0 *1 0,0
Rmpa_py_mpb_py_mph_py_py_dup1_t1 mpa_py\x7cmpb_py\x7cmph_py\x7cpy__t12
+ mpa_py|mpb_py|mph_py|py$1 59.4124658363
* device instance mpa_py_mpb_py_mph_py_py_dup1_t2 r0 *1 0,0
Rmpa_py_mpb_py_mph_py_py_dup1_t2 mpa_py\x7cmpb_py\x7cmph_py\x7cpy__t22
+ mpa_py|mpb_py|mph_py|py$1 10.9559341637
* device instance mpa_py_mpb_py_mph_py_py_dup1 r0 *1 0,0
Cmpa_py_mpb_py_mph_py_py_dup1 mpa_py|mpb_py|mph_py|py$1 vsubs 7.95941e-16
* device instance mpa_py_mpb_py_mph_py_py_dup2_t0 r0 *1 0,0
Rmpa_py_mpb_py_mph_py_py_dup2_t0 mpa_py\x7cmpb_py\x7cmph_py\x7cpy__t03
+ mpa_py|mpb_py|mph_py|py$2 70.5682
* device instance mpa_py_mpb_py_mph_py_py_dup2_t1 r0 *1 0,0
Rmpa_py_mpb_py_mph_py_py_dup2_t1 mpa_py\x7cmpb_py\x7cmph_py\x7cpy__t13
+ mpa_py|mpb_py|mph_py|py$2 59.5811581851
* device instance mpa_py_mpb_py_mph_py_py_dup2_t2 r0 *1 0,0
Rmpa_py_mpb_py_mph_py_py_dup2_t2 mpa_py\x7cmpb_py\x7cmph_py\x7cpy__t23
+ mpa_py|mpb_py|mph_py|py$2 10.9870418149
* device instance mpa_py_mpb_py_mph_py_py_dup2 r0 *1 0,0
Cmpa_py_mpb_py_mph_py_py_dup2 mpa_py|mpb_py|mph_py|py$2 vsubs 7.9788e-16
* device instance mpa_py_mpb_py_mph_py_py_dup3_t0 r0 *1 0,0
Rmpa_py_mpb_py_mph_py_py_dup3_t0 mpa_py\x7cmpb_py\x7cmph_py\x7cpy__t04
+ mpa_py|mpb_py|mph_py|py$3 70.77005
* device instance mpa_py_mpb_py_mph_py_py_dup3_t1 r0 *1 0,0
Rmpa_py_mpb_py_mph_py_py_dup3_t1 mpa_py\x7cmpb_py\x7cmph_py\x7cpy__t14
+ mpa_py|mpb_py|mph_py|py$3 59.7515813612
* device instance mpa_py_mpb_py_mph_py_py_dup3_t2 r0 *1 0,0
Rmpa_py_mpb_py_mph_py_py_dup3_t2 mpa_py\x7cmpb_py\x7cmph_py\x7cpy__t24
+ mpa_py|mpb_py|mph_py|py$3 11.0184686388
* device instance mpa_py_mpb_py_mph_py_py_dup3 r0 *1 0,0
Cmpa_py_mpb_py_mph_py_py_dup3 mpa_py|mpb_py|mph_py|py$3 vsubs 7.99818e-16
* device instance ny_t0 r0 *1 0,0
Rny_t0 ny__t0 ny 44.45845
* device instance ny_t1 r0 *1 0,0
Rny_t1 ny__t1 ny 44.45845
* device instance ny r0 *1 0,0
Cny ny vsubs 2.11758e-16
* device instance ny_dup1_t0 r0 *1 0,0
Rny_dup1_t0 ny__t02 ny$1 41.7022
* device instance ny_dup1_t1 r0 *1 0,0
Rny_dup1_t1 ny__t12 ny$1 41.7022
* device instance ny_dup1 r0 *1 0,0
Cny_dup1 ny$1 vsubs 1.70111e-16
* device instance ny_dup2_t0 r0 *1 0,0
Rny_dup2_t0 ny__t03 ny$2 41.7022
* device instance ny_dup2_t1 r0 *1 0,0
Rny_dup2_t1 ny__t13 ny$2 41.7022
* device instance ny_dup2 r0 *1 0,0
Cny_dup2 ny$2 vsubs 1.70111e-16
* device instance ny_dup3_t0 r0 *1 0,0
Rny_dup3_t0 ny__t04 ny$3 41.7022
* device instance ny_dup3_t1 r0 *1 0,0
Rny_dup3_t1 ny__t14 ny$3 41.7022
* device instance ny_dup3 r0 *1 0,0
Cny_dup3 ny$3 vsubs 1.70111e-16
* device instance ny_dup4_t0 r0 *1 0,0
Rny_dup4_t0 ny__t05 ny$4 41.7022
* device instance ny_dup4_t1 r0 *1 0,0
Rny_dup4_t1 ny__t15 ny$4 41.7022
* device instance ny_dup4 r0 *1 0,0
Cny_dup4 ny$4 vsubs 1.70111e-16
* device instance ny_dup5_t0 r0 *1 0,0
Rny_dup5_t0 ny__t06 ny$5 44.6445
* device instance ny_dup5_t1 r0 *1 0,0
Rny_dup5_t1 ny__t16 ny$5 44.6445
* device instance ny_dup5 r0 *1 0,0
Cny_dup5 ny$5 vsubs 2.13697e-16
* device instance ny_dup6_t0 r0 *1 0,0
Rny_dup6_t0 ny__t07 ny$6 41.76295
* device instance ny_dup6_t1 r0 *1 0,0
Rny_dup6_t1 ny__t17 ny$6 41.76295
* device instance ny_dup6 r0 *1 0,0
Cny_dup6 ny$6 vsubs 1.7205e-16
* device instance ny_dup7_t0 r0 *1 0,0
Rny_dup7_t0 ny__t08 ny$7 41.76295
* device instance ny_dup7_t1 r0 *1 0,0
Rny_dup7_t1 ny__t18 ny$7 41.76295
* device instance ny_dup7 r0 *1 0,0
Cny_dup7 ny$7 vsubs 1.7205e-16
* device instance ny_dup8_t0 r0 *1 0,0
Rny_dup8_t0 ny__t09 ny$8 41.76295
* device instance ny_dup8_t1 r0 *1 0,0
Rny_dup8_t1 ny__t19 ny$8 41.76295
* device instance ny_dup8 r0 *1 0,0
Cny_dup8 ny$8 vsubs 1.7205e-16
* device instance ny_dup9_t0 r0 *1 0,0
Rny_dup9_t0 ny__t010 ny$9 41.76295
* device instance ny_dup9_t1 r0 *1 0,0
Rny_dup9_t1 ny__t110 ny$9 41.76295
* device instance ny_dup9 r0 *1 0,0
Cny_dup9 ny$9 vsubs 1.7205e-16
* device instance ny_dup10_t0 r0 *1 0,0
Rny_dup10_t0 ny__t011 ny$10 44.8339
* device instance ny_dup10_t1 r0 *1 0,0
Rny_dup10_t1 ny__t111 ny$10 44.8339
* device instance ny_dup10 r0 *1 0,0
Cny_dup10 ny$10 vsubs 2.15636e-16
* device instance ny_dup11_t0 r0 *1 0,0
Rny_dup11_t0 ny__t012 ny$11 41.8333
* device instance ny_dup11_t1 r0 *1 0,0
Rny_dup11_t1 ny__t112 ny$11 41.8333
* device instance ny_dup11 r0 *1 0,0
Cny_dup11 ny$11 vsubs 1.73989e-16
* device instance ny_dup12_t0 r0 *1 0,0
Rny_dup12_t0 ny__t013 ny$12 41.8333
* device instance ny_dup12_t1 r0 *1 0,0
Rny_dup12_t1 ny__t113 ny$12 41.8333
* device instance ny_dup12 r0 *1 0,0
Cny_dup12 ny$12 vsubs 1.73989e-16
* device instance ny_dup13_t0 r0 *1 0,0
Rny_dup13_t0 ny__t014 ny$13 41.8333
* device instance ny_dup13_t1 r0 *1 0,0
Rny_dup13_t1 ny__t114 ny$13 41.8333
* device instance ny_dup13 r0 *1 0,0
Cny_dup13 ny$13 vsubs 1.73989e-16
* device instance ny_dup14_t0 r0 *1 0,0
Rny_dup14_t0 ny__t015 ny$14 41.8333
* device instance ny_dup14_t1 r0 *1 0,0
Rny_dup14_t1 ny__t115 ny$14 41.8333
* device instance ny_dup14 r0 *1 0,0
Cny_dup14 ny$14 vsubs 1.73989e-16
* device instance ny_dup15_t0 r0 *1 0,0
Rny_dup15_t0 ny__t016 ny$15 45.02655
* device instance ny_dup15_t1 r0 *1 0,0
Rny_dup15_t1 ny__t116 ny$15 45.02655
* device instance ny_dup15 r0 *1 0,0
Cny_dup15 ny$15 vsubs 2.17575e-16
* device instance ny_dup16_t0 r0 *1 0,0
Rny_dup16_t0 ny__t017 ny$16 41.9128
* device instance ny_dup16_t1 r0 *1 0,0
Rny_dup16_t1 ny__t117 ny$16 41.9128
* device instance ny_dup16 r0 *1 0,0
Cny_dup16 ny$16 vsubs 1.75928e-16
* device instance ny_dup17_t0 r0 *1 0,0
Rny_dup17_t0 ny__t018 ny$17 41.9128
* device instance ny_dup17_t1 r0 *1 0,0
Rny_dup17_t1 ny__t118 ny$17 41.9128
* device instance ny_dup17 r0 *1 0,0
Cny_dup17 ny$17 vsubs 1.75928e-16
* device instance ny_dup18_t0 r0 *1 0,0
Rny_dup18_t0 ny__t019 ny$18 41.9128
* device instance ny_dup18_t1 r0 *1 0,0
Rny_dup18_t1 ny__t119 ny$18 41.9128
* device instance ny_dup18 r0 *1 0,0
Cny_dup18 ny$18 vsubs 1.75928e-16
* device instance ny_dup19_t0 r0 *1 0,0
Rny_dup19_t0 ny__t020 ny$19 41.9128
* device instance ny_dup19_t1 r0 *1 0,0
Rny_dup19_t1 ny__t120 ny$19 41.9128
* device instance ny_dup19 r0 *1 0,0
Cny_dup19 ny$19 vsubs 1.75928e-16
* device instance py_t0 r0 *1 0,0
Rpy_t0 py__t0 py 37.6683
* device instance py_t1 r0 *1 0,0
Rpy_t1 py__t1 py 37.6683
* device instance py r0 *1 0,0
Cpy py vsubs 1.9321e-16
* device instance py_dup1_t0 r0 *1 0,0
Rpy_dup1_t0 py__t02 py$1 37.6683
* device instance py_dup1_t1 r0 *1 0,0
Rpy_dup1_t1 py__t12 py$1 37.6683
* device instance py_dup1 r0 *1 0,0
Cpy_dup1 py$1 vsubs 1.9321e-16
* device instance py_dup2_t0 r0 *1 0,0
Rpy_dup2_t0 py__t03 py$2 37.6683
* device instance py_dup2_t1 r0 *1 0,0
Rpy_dup2_t1 py__t13 py$2 37.6683
* device instance py_dup2 r0 *1 0,0
Cpy_dup2 py$2 vsubs 1.9321e-16
* device instance py_dup3_t0 r0 *1 0,0
Rpy_dup3_t0 py__t04 py$3 37.6683
* device instance py_dup3_t1 r0 *1 0,0
Rpy_dup3_t1 py__t14 py$3 37.6683
* device instance py_dup3 r0 *1 0,0
Cpy_dup3 py$3 vsubs 1.9321e-16
* device instance py_dup4_t0 r0 *1 0,0
Rpy_dup4_t0 py__t05 py$4 37.875
* device instance py_dup4_t1 r0 *1 0,0
Rpy_dup4_t1 py__t15 py$4 37.875
* device instance py_dup4 r0 *1 0,0
Cpy_dup4 py$4 vsubs 1.95101e-16
* device instance py_dup5_t0 r0 *1 0,0
Rpy_dup5_t0 py__t06 py$5 37.875
* device instance py_dup5_t1 r0 *1 0,0
Rpy_dup5_t1 py__t16 py$5 37.875
* device instance py_dup5 r0 *1 0,0
Cpy_dup5 py$5 vsubs 1.95101e-16
* device instance py_dup6_t0 r0 *1 0,0
Rpy_dup6_t0 py__t07 py$6 37.875
* device instance py_dup6_t1 r0 *1 0,0
Rpy_dup6_t1 py__t17 py$6 37.875
* device instance py_dup6 r0 *1 0,0
Cpy_dup6 py$6 vsubs 1.95101e-16
* device instance py_dup7_t0 r0 *1 0,0
Rpy_dup7_t0 py__t08 py$7 37.875
* device instance py_dup7_t1 r0 *1 0,0
Rpy_dup7_t1 py__t18 py$7 37.875
* device instance py_dup7 r0 *1 0,0
Cpy_dup7 py$7 vsubs 1.95101e-16
* device instance py_dup8_t0 r0 *1 0,0
Rpy_dup8_t0 py__t09 py$8 38.0848
* device instance py_dup8_t1 r0 *1 0,0
Rpy_dup8_t1 py__t19 py$8 38.0848
* device instance py_dup8 r0 *1 0,0
Cpy_dup8 py$8 vsubs 1.96992e-16
* device instance py_dup9_t0 r0 *1 0,0
Rpy_dup9_t0 py__t010 py$9 38.0848
* device instance py_dup9_t1 r0 *1 0,0
Rpy_dup9_t1 py__t110 py$9 38.0848
* device instance py_dup9 r0 *1 0,0
Cpy_dup9 py$9 vsubs 1.96992e-16
* device instance py_dup10_t0 r0 *1 0,0
Rpy_dup10_t0 py__t011 py$10 38.0848
* device instance py_dup10_t1 r0 *1 0,0
Rpy_dup10_t1 py__t111 py$10 38.0848
* device instance py_dup10 r0 *1 0,0
Cpy_dup10 py$10 vsubs 1.96992e-16
* device instance py_dup11_t0 r0 *1 0,0
Rpy_dup11_t0 py__t012 py$11 38.0848
* device instance py_dup11_t1 r0 *1 0,0
Rpy_dup11_t1 py__t112 py$11 38.0848
* device instance py_dup11 r0 *1 0,0
Cpy_dup11 py$11 vsubs 1.96992e-16
* device instance py_dup12_t0 r0 *1 0,0
Rpy_dup12_t0 py__t013 py$12 38.29745
* device instance py_dup12_t1 r0 *1 0,0
Rpy_dup12_t1 py__t113 py$12 38.29745
* device instance py_dup12 r0 *1 0,0
Cpy_dup12 py$12 vsubs 1.98882e-16
* device instance py_dup13_t0 r0 *1 0,0
Rpy_dup13_t0 py__t014 py$13 38.29745
* device instance py_dup13_t1 r0 *1 0,0
Rpy_dup13_t1 py__t114 py$13 38.29745
* device instance py_dup13 r0 *1 0,0
Cpy_dup13 py$13 vsubs 1.98882e-16
* device instance py_dup14_t0 r0 *1 0,0
Rpy_dup14_t0 py__t015 py$14 38.29745
* device instance py_dup14_t1 r0 *1 0,0
Rpy_dup14_t1 py__t115 py$14 38.29745
* device instance py_dup14 r0 *1 0,0
Cpy_dup14 py$14 vsubs 1.98882e-16
* device instance py_dup15_t0 r0 *1 0,0
Rpy_dup15_t0 py__t016 py$15 38.29745
* device instance py_dup15_t1 r0 *1 0,0
Rpy_dup15_t1 py__t116 py$15 38.29745
* device instance py_dup15 r0 *1 0,0
Cpy_dup15 py$15 vsubs 1.98882e-16
* device instance cc_an_inva_y_mn34_g0_mp13_g1_y_a_b_b3_invb_a_mn12_g1_mp24_g0_t2_y r0 *1 0,0
Ccc_an_inva_y_mn34_g0_mp13_g1_y_a_b_b3_invb_a_mn12_g1_mp24_g0_t2_y
+ an|inva_y|mn34_g0|mp13_g1|y$2 a|b|b3|invb_a|mn12_g1|mp24_g0|t2|y 3.3e-18
* device instance cc_an_inva_y_mn34_g0_mp13_g1_y_a_d_inv_clk_vdd_inv_mc_vdd_inv_q_vdd_mpa_py_mpb_py_nand_m_vdd_nand_s2_vdd_nwell_vdd_sb_vdd_sr1_vdd_sr2_vdd_sr3_vdd_sr4_vdd_sv_d_vdd_tie_sv_vdd_tg_d_a_tg_d_vdd_tg_fbm_vdd_tg_fbs_vdd_tg_s_vdd_vdd_vdd_b1_vdd_b2_vdd_b3_vdd_b4_vdd_link_vdd_link_dip_vdd_x1_vdd_x2_vdd_x3 r0 *1 0,0
Ccc_an_inva_y_mn34_g0_mp13_g1_y_a_d_inv_clk_vdd_inv_mc_vdd_inv_q_vdd_mpa_py_mpb_py_nand_m_vdd_nand_s2_vdd_nwell_vdd_sb_vdd_sr1_vdd_sr2_vdd_sr3_vdd_sr4_vdd_sv_d_vdd_tie_sv_vdd_tg_d_a_tg_d_vdd_tg_fbm_vdd_tg_fbs_vdd_tg_s_vdd_vdd_vdd_b1_vdd_b2_vdd_b3_vdd_b4_vdd_link_vdd_link_dip_vdd_x1_vdd_x2_vdd_x3
+ an|inva_y|mn34_g0|mp13_g1|y$2
+ a|d|inv_clk_vdd|inv_mc_vdd|inv_q_vdd|mpa_py|mpb_py|nand_m_vdd|nand_s2_vdd|nwell_vdd|sb_vdd|sr1_vdd|sr2_vdd|sr3_vdd|sr4_vdd|sv_d_vdd_tie|sv_vdd|tg_d_a|tg_d_vdd|tg_fbm_vdd|tg_fbs_vdd|tg_s_vdd|vdd|vdd_b1|vdd_b2|vdd_b3|vdd_b4|vdd_link|vdd_link_dip|vdd_x1|vdd_x2|vdd_x3
+ 2.8673e-17
* device instance cc_an_inva_y_mn34_g0_mp13_g1_y_a_d_sb_d_stub_tg_d_a_xo_xo_dip_xo_hop_xo_stub_y r0 *1 0,0
Ccc_an_inva_y_mn34_g0_mp13_g1_y_a_d_sb_d_stub_tg_d_a_xo_xo_dip_xo_hop_xo_stub_y
+ an|inva_y|mn34_g0|mp13_g1|y$2 a|d|sb_d_stub|tg_d_a|xo|xo_dip|xo_hop|xo_stub|y
+ 3.3e-18
* device instance cc_an_inva_y_mn34_g0_mp13_g1_y_a_inva_a_mn12_g0_mp13_g0_t1_y r0 *1 0,0
Ccc_an_inva_y_mn34_g0_mp13_g1_y_a_inva_a_mn12_g0_mp13_g0_t1_y
+ an|inva_y|mn34_g0|mp13_g1|y$2 a|inva_a|mn12_g0|mp13_g0|t1|y 3.3e-18
* device instance cc_a_b_b3_invb_a_mn12_g1_mp24_g0_t2_y_a_d_inva_a_mn12_g0_mp13_g0_ro3_ro3_esc_e_ro3_esc_w_ro3_hop_sr3_d_stub_tg_d_a_y r0 *1 0,0
Ccc_a_b_b3_invb_a_mn12_g1_mp24_g0_t2_y_a_d_inva_a_mn12_g0_mp13_g0_ro3_ro3_esc_e_ro3_esc_w_ro3_hop_sr3_d_stub_tg_d_a_y
+ a|b|b3|invb_a|mn12_g1|mp24_g0|t2|y
+ a|d|inva_a|mn12_g0|mp13_g0|ro3|ro3_esc_e|ro3_esc_w|ro3_hop|sr3_d_stub|tg_d_a|y
+ 3.3e-18
* device instance cc_a_b_b3_invb_a_mn12_g1_mp24_g0_t2_y_a_d_sb_d_stub_tg_d_a_xo_xo_dip_xo_hop_xo_stub_y r0 *1 0,0
Ccc_a_b_b3_invb_a_mn12_g1_mp24_g0_t2_y_a_d_sb_d_stub_tg_d_a_xo_xo_dip_xo_hop_xo_stub_y
+ a|b|b3|invb_a|mn12_g1|mp24_g0|t2|y
+ a|d|sb_d_stub|tg_d_a|xo|xo_dip|xo_hop|xo_stub|y 3.869e-18
* device instance cc_a_b_b3_invb_a_mn12_g1_mp24_g0_t2_y_a_inva_a_mn12_g0_mp13_g0_t1_y r0 *1 0,0
Ccc_a_b_b3_invb_a_mn12_g1_mp24_g0_t2_y_a_inva_a_mn12_g0_mp13_g0_t1_y
+ a|b|b3|invb_a|mn12_g1|mp24_g0|t2|y a|inva_a|mn12_g0|mp13_g0|t1|y 3.869e-18
* device instance cc_a_b_b3_invb_a_mn12_g1_mp24_g0_t2_y_bn_invb_y_mn34_g1_mp24_g1_y r0 *1 0,0
Ccc_a_b_b3_invb_a_mn12_g1_mp24_g0_t2_y_bn_invb_y_mn34_g1_mp24_g1_y
+ a|b|b3|invb_a|mn12_g1|mp24_g0|t2|y bn|invb_y|mn34_g1|mp24_g1|y$2 1.377e-17
* device instance cc_a_b_b3_invb_a_mn12_g1_mp24_g0_t2_y_mid r0 *1 0,0
Ccc_a_b_b3_invb_a_mn12_g1_mp24_g0_t2_y_mid a|b|b3|invb_a|mn12_g1|mp24_g0|t2|y
+ mid$2 8.154e-18
* device instance cc_a_b_d_invb_a_mn12_g1_mp24_g0_ro2_ro2_esc_sr2_d_stub_tg_d_a_y_a_b_m_east_m_west_nand_m_a_nand_m_a_ext_via_nand_m_a_ext_via2_nand_m_a_stub_tg_d_b_tg_d_b_via_tg_d_b_via2_tg_fbm_b_tg_fbm_b_alt_via_tg_fbm_b_alt_via2 r0 *1 0,0
Ccc_a_b_d_invb_a_mn12_g1_mp24_g0_ro2_ro2_esc_sr2_d_stub_tg_d_a_y_a_b_m_east_m_west_nand_m_a_nand_m_a_ext_via_nand_m_a_ext_via2_nand_m_a_stub_tg_d_b_tg_d_b_via_tg_d_b_via2_tg_fbm_b_tg_fbm_b_alt_via_tg_fbm_b_alt_via2
+ a|b|d|invb_a|mn12_g1|mp24_g0|ro2|ro2_esc|sr2_d_stub|tg_d_a|y
+ a|b|m_east|m_west|nand_m_a|nand_m_a_ext_via|nand_m_a_ext_via2|nand_m_a_stub|tg_d_b|tg_d_b_via|tg_d_b_via2|tg_fbm_b|tg_fbm_b_alt_via|tg_fbm_b_alt_via2$5
+ 3.869e-18
* device instance cc_a_b_d_invb_a_mn12_g1_mp24_g0_ro2_ro2_esc_sr2_d_stub_tg_d_a_y_a_d_inv_clk_vdd_inv_mc_vdd_inv_q_vdd_mpa_py_mpb_py_nand_m_vdd_nand_s2_vdd_nwell_vdd_sb_vdd_sr1_vdd_sr2_vdd_sr3_vdd_sr4_vdd_sv_d_vdd_tie_sv_vdd_tg_d_a_tg_d_vdd_tg_fbm_vdd_tg_fbs_vdd_tg_s_vdd_vdd_vdd_b1_vdd_b2_vdd_b3_vdd_b4_vdd_link_vdd_link_dip_vdd_x1_vdd_x2_vdd_x3 r0 *1 0,0
Ccc_a_b_d_invb_a_mn12_g1_mp24_g0_ro2_ro2_esc_sr2_d_stub_tg_d_a_y_a_d_inv_clk_vdd_inv_mc_vdd_inv_q_vdd_mpa_py_mpb_py_nand_m_vdd_nand_s2_vdd_nwell_vdd_sb_vdd_sr1_vdd_sr2_vdd_sr3_vdd_sr4_vdd_sv_d_vdd_tie_sv_vdd_tg_d_a_tg_d_vdd_tg_fbm_vdd_tg_fbs_vdd_tg_s_vdd_vdd_vdd_b1_vdd_b2_vdd_b3_vdd_b4_vdd_link_vdd_link_dip_vdd_x1_vdd_x2_vdd_x3
+ a|b|d|invb_a|mn12_g1|mp24_g0|ro2|ro2_esc|sr2_d_stub|tg_d_a|y
+ a|d|inv_clk_vdd|inv_mc_vdd|inv_q_vdd|mpa_py|mpb_py|nand_m_vdd|nand_s2_vdd|nwell_vdd|sb_vdd|sr1_vdd|sr2_vdd|sr3_vdd|sr4_vdd|sv_d_vdd_tie|sv_vdd|tg_d_a|tg_d_vdd|tg_fbm_vdd|tg_fbs_vdd|tg_s_vdd|vdd|vdd_b1|vdd_b2|vdd_b3|vdd_b4|vdd_link|vdd_link_dip|vdd_x1|vdd_x2|vdd_x3
+ 2.2984e-17
* device instance cc_a_b_d_invb_a_mn12_g1_mp24_g0_ro2_ro2_esc_sr2_d_stub_tg_d_a_y_a_d_inva_a_mn12_g0_mp13_g0_ro1_ro1_esc_sr1_d_stub_tg_d_a_y r0 *1 0,0
Ccc_a_b_d_invb_a_mn12_g1_mp24_g0_ro2_ro2_esc_sr2_d_stub_tg_d_a_y_a_d_inva_a_mn12_g0_mp13_g0_ro1_ro1_esc_sr1_d_stub_tg_d_a_y
+ a|b|d|invb_a|mn12_g1|mp24_g0|ro2|ro2_esc|sr2_d_stub|tg_d_a|y
+ a|d|inva_a|mn12_g0|mp13_g0|ro1|ro1_esc|sr1_d_stub|tg_d_a|y 3.869e-18
* device instance cc_a_b_d_invb_a_mn12_g1_mp24_g0_ro2_ro2_esc_sr2_d_stub_tg_d_a_y_a_d_inva_a_mn12_g0_mp13_g0_ro3_ro3_esc_e_ro3_esc_w_ro3_hop_sr3_d_stub_tg_d_a_y r0 *1 0,0
Ccc_a_b_d_invb_a_mn12_g1_mp24_g0_ro2_ro2_esc_sr2_d_stub_tg_d_a_y_a_d_inva_a_mn12_g0_mp13_g0_ro3_ro3_esc_e_ro3_esc_w_ro3_hop_sr3_d_stub_tg_d_a_y
+ a|b|d|invb_a|mn12_g1|mp24_g0|ro2|ro2_esc|sr2_d_stub|tg_d_a|y
+ a|d|inva_a|mn12_g0|mp13_g0|ro3|ro3_esc_e|ro3_esc_w|ro3_hop|sr3_d_stub|tg_d_a|y
+ 7.737e-18
* device instance cc_a_b_d_invb_a_mn12_g1_mp24_g0_ro2_ro2_esc_sr2_d_stub_tg_d_a_y_clkb_clkb_bridge1_clkb_bridge2_clkb_mid_clkb_w_ctrl_ctrlb_inv_clk_y_tg_d_ctrlb_tg_fbm_ctrl_tg_fbs_ctrlb_tg_s_ctrl_y r0 *1 0,0
Ccc_a_b_d_invb_a_mn12_g1_mp24_g0_ro2_ro2_esc_sr2_d_stub_tg_d_a_y_clkb_clkb_bridge1_clkb_bridge2_clkb_mid_clkb_w_ctrl_ctrlb_inv_clk_y_tg_d_ctrlb_tg_fbm_ctrl_tg_fbs_ctrlb_tg_s_ctrl_y
+ a|b|d|invb_a|mn12_g1|mp24_g0|ro2|ro2_esc|sr2_d_stub|tg_d_a|y
+ clkb|clkb_bridge1|clkb_bridge2|clkb_mid|clkb_w|ctrl|ctrlb|inv_clk_y|tg_d_ctrlb|tg_fbm_ctrl|tg_fbs_ctrlb|tg_s_ctrl|y$5
+ 8.337e-18
* device instance cc_a_b_d_invb_a_mn12_g1_mp24_g0_ro2_ro2_esc_sr2_d_stub_tg_d_a_y_en_nand_m_en_nand_m_en_via_nand_s2_en_nand_s2_en_via_rst_n r0 *1 0,0
Ccc_a_b_d_invb_a_mn12_g1_mp24_g0_ro2_ro2_esc_sr2_d_stub_tg_d_a_y_en_nand_m_en_nand_m_en_via_nand_s2_en_nand_s2_en_via_rst_n
+ a|b|d|invb_a|mn12_g1|mp24_g0|ro2|ro2_esc|sr2_d_stub|tg_d_a|y
+ en|nand_m_en|nand_m_en_via|nand_s2_en|nand_s2_en_via|rst_n 3.869e-18
* device instance cc_a_b_d_invb_a_mn12_g1_mp24_g0_ro2_ro2_esc_sr2_d_stub_tg_d_a_y_g_vddr_m1_mnt_g_s1_vddr_m1_s2_vddr_m1_s3_vddr_m1_s4_vddr_m1_vddr_vddr1 r0 *1 0,0
Ccc_a_b_d_invb_a_mn12_g1_mp24_g0_ro2_ro2_esc_sr2_d_stub_tg_d_a_y_g_vddr_m1_mnt_g_s1_vddr_m1_s2_vddr_m1_s3_vddr_m1_s4_vddr_m1_vddr_vddr1
+ a|b|d|invb_a|mn12_g1|mp24_g0|ro2|ro2_esc|sr2_d_stub|tg_d_a|y
+ g_vddr_m1|mnt_g|s1_vddr_m1|s2_vddr_m1|s3_vddr_m1|s4_vddr_m1|vddr|vddr1
+ 1.6358e-17
* device instance cc_a_b_d_invb_a_mn12_g1_mp24_g0_ro2_ro2_esc_sr2_d_stub_tg_d_a_y_g_vss_m1_inv_clk_vss_inv_mc_vss_inv_q_vss_mph_g_nand_m_vss_nand_s2_vss_s1_vss_m1_s2_vss_m1_s3_vss_m1_s4_vss_m1_sb_vss_sr1_vss_sr2_vss_sr3_vss_sr4_vss_sv_vss_tg_d_vss_tg_fbm_vss_tg_fbs_vss_tg_s_vss_vss_vss_link_vss_link_bridge_vss_link_dip_vss_link_m1_vss_x1_vss_x2_vss_x3 r0 *1 0,0
Ccc_a_b_d_invb_a_mn12_g1_mp24_g0_ro2_ro2_esc_sr2_d_stub_tg_d_a_y_g_vss_m1_inv_clk_vss_inv_mc_vss_inv_q_vss_mph_g_nand_m_vss_nand_s2_vss_s1_vss_m1_s2_vss_m1_s3_vss_m1_s4_vss_m1_sb_vss_sr1_vss_sr2_vss_sr3_vss_sr4_vss_sv_vss_tg_d_vss_tg_fbm_vss_tg_fbs_vss_tg_s_vss_vss_vss_link_vss_link_bridge_vss_link_dip_vss_link_m1_vss_x1_vss_x2_vss_x3
+ a|b|d|invb_a|mn12_g1|mp24_g0|ro2|ro2_esc|sr2_d_stub|tg_d_a|y
+ g_vss_m1|inv_clk_vss|inv_mc_vss|inv_q_vss|mph_g|nand_m_vss|nand_s2_vss|s1_vss_m1|s2_vss_m1|s3_vss_m1|s4_vss_m1|sb_vss|sr1_vss|sr2_vss|sr3_vss|sr4_vss|sv_vss|tg_d_vss|tg_fbm_vss|tg_fbs_vss|tg_s_vss|vss|vss_link|vss_link_bridge|vss_link_dip|vss_link_m1|vss_x1|vss_x2|vss_x3
+ 4.5279e-17
* device instance cc_a_b_d_invb_a_mn12_g1_mp24_g0_ro4_ro4_esc_sr4_d_stub_tg_d_a_y_a_b_m_east_m_west_nand_m_a_nand_m_a_ext_via_nand_m_a_ext_via2_nand_m_a_stub_tg_d_b_tg_d_b_via_tg_d_b_via2_tg_fbm_b_tg_fbm_b_alt_via_tg_fbm_b_alt_via2 r0 *1 0,0
Ccc_a_b_d_invb_a_mn12_g1_mp24_g0_ro4_ro4_esc_sr4_d_stub_tg_d_a_y_a_b_m_east_m_west_nand_m_a_nand_m_a_ext_via_nand_m_a_ext_via2_nand_m_a_stub_tg_d_b_tg_d_b_via_tg_d_b_via2_tg_fbm_b_tg_fbm_b_alt_via_tg_fbm_b_alt_via2
+ a|b|d|invb_a|mn12_g1|mp24_g0|ro4|ro4_esc|sr4_d_stub|tg_d_a|y
+ a|b|m_east|m_west|nand_m_a|nand_m_a_ext_via|nand_m_a_ext_via2|nand_m_a_stub|tg_d_b|tg_d_b_via|tg_d_b_via2|tg_fbm_b|tg_fbm_b_alt_via|tg_fbm_b_alt_via2$5
+ 3.869e-18
* device instance cc_a_b_d_invb_a_mn12_g1_mp24_g0_ro4_ro4_esc_sr4_d_stub_tg_d_a_y_a_d_inv_clk_vdd_inv_mc_vdd_inv_q_vdd_mpa_py_mpb_py_nand_m_vdd_nand_s2_vdd_nwell_vdd_sb_vdd_sr1_vdd_sr2_vdd_sr3_vdd_sr4_vdd_sv_d_vdd_tie_sv_vdd_tg_d_a_tg_d_vdd_tg_fbm_vdd_tg_fbs_vdd_tg_s_vdd_vdd_vdd_b1_vdd_b2_vdd_b3_vdd_b4_vdd_link_vdd_link_dip_vdd_x1_vdd_x2_vdd_x3 r0 *1 0,0
Ccc_a_b_d_invb_a_mn12_g1_mp24_g0_ro4_ro4_esc_sr4_d_stub_tg_d_a_y_a_d_inv_clk_vdd_inv_mc_vdd_inv_q_vdd_mpa_py_mpb_py_nand_m_vdd_nand_s2_vdd_nwell_vdd_sb_vdd_sr1_vdd_sr2_vdd_sr3_vdd_sr4_vdd_sv_d_vdd_tie_sv_vdd_tg_d_a_tg_d_vdd_tg_fbm_vdd_tg_fbs_vdd_tg_s_vdd_vdd_vdd_b1_vdd_b2_vdd_b3_vdd_b4_vdd_link_vdd_link_dip_vdd_x1_vdd_x2_vdd_x3
+ a|b|d|invb_a|mn12_g1|mp24_g0|ro4|ro4_esc|sr4_d_stub|tg_d_a|y
+ a|d|inv_clk_vdd|inv_mc_vdd|inv_q_vdd|mpa_py|mpb_py|nand_m_vdd|nand_s2_vdd|nwell_vdd|sb_vdd|sr1_vdd|sr2_vdd|sr3_vdd|sr4_vdd|sv_d_vdd_tie|sv_vdd|tg_d_a|tg_d_vdd|tg_fbm_vdd|tg_fbs_vdd|tg_s_vdd|vdd|vdd_b1|vdd_b2|vdd_b3|vdd_b4|vdd_link|vdd_link_dip|vdd_x1|vdd_x2|vdd_x3
+ 1.3426e-17
* device instance cc_a_b_d_invb_a_mn12_g1_mp24_g0_ro4_ro4_esc_sr4_d_stub_tg_d_a_y_clkb_clkb_bridge1_clkb_bridge2_clkb_mid_clkb_w_ctrl_ctrlb_inv_clk_y_tg_d_ctrlb_tg_fbm_ctrl_tg_fbs_ctrlb_tg_s_ctrl_y r0 *1 0,0
Ccc_a_b_d_invb_a_mn12_g1_mp24_g0_ro4_ro4_esc_sr4_d_stub_tg_d_a_y_clkb_clkb_bridge1_clkb_bridge2_clkb_mid_clkb_w_ctrl_ctrlb_inv_clk_y_tg_d_ctrlb_tg_fbm_ctrl_tg_fbs_ctrlb_tg_s_ctrl_y
+ a|b|d|invb_a|mn12_g1|mp24_g0|ro4|ro4_esc|sr4_d_stub|tg_d_a|y
+ clkb|clkb_bridge1|clkb_bridge2|clkb_mid|clkb_w|ctrl|ctrlb|inv_clk_y|tg_d_ctrlb|tg_fbm_ctrl|tg_fbs_ctrlb|tg_s_ctrl|y$5
+ 8.337e-18
* device instance cc_a_b_d_invb_a_mn12_g1_mp24_g0_ro4_ro4_esc_sr4_d_stub_tg_d_a_y_en_nand_m_en_nand_m_en_via_nand_s2_en_nand_s2_en_via_rst_n r0 *1 0,0
Ccc_a_b_d_invb_a_mn12_g1_mp24_g0_ro4_ro4_esc_sr4_d_stub_tg_d_a_y_en_nand_m_en_nand_m_en_via_nand_s2_en_nand_s2_en_via_rst_n
+ a|b|d|invb_a|mn12_g1|mp24_g0|ro4|ro4_esc|sr4_d_stub|tg_d_a|y
+ en|nand_m_en|nand_m_en_via|nand_s2_en|nand_s2_en_via|rst_n 3.869e-18
* device instance cc_a_b_d_invb_a_mn12_g1_mp24_g0_ro4_ro4_esc_sr4_d_stub_tg_d_a_y_g_vss_m1_inv_clk_vss_inv_mc_vss_inv_q_vss_mph_g_nand_m_vss_nand_s2_vss_s1_vss_m1_s2_vss_m1_s3_vss_m1_s4_vss_m1_sb_vss_sr1_vss_sr2_vss_sr3_vss_sr4_vss_sv_vss_tg_d_vss_tg_fbm_vss_tg_fbs_vss_tg_s_vss_vss_vss_link_vss_link_bridge_vss_link_dip_vss_link_m1_vss_x1_vss_x2_vss_x3 r0 *1 0,0
Ccc_a_b_d_invb_a_mn12_g1_mp24_g0_ro4_ro4_esc_sr4_d_stub_tg_d_a_y_g_vss_m1_inv_clk_vss_inv_mc_vss_inv_q_vss_mph_g_nand_m_vss_nand_s2_vss_s1_vss_m1_s2_vss_m1_s3_vss_m1_s4_vss_m1_sb_vss_sr1_vss_sr2_vss_sr3_vss_sr4_vss_sv_vss_tg_d_vss_tg_fbm_vss_tg_fbs_vss_tg_s_vss_vss_vss_link_vss_link_bridge_vss_link_dip_vss_link_m1_vss_x1_vss_x2_vss_x3
+ a|b|d|invb_a|mn12_g1|mp24_g0|ro4|ro4_esc|sr4_d_stub|tg_d_a|y
+ g_vss_m1|inv_clk_vss|inv_mc_vss|inv_q_vss|mph_g|nand_m_vss|nand_s2_vss|s1_vss_m1|s2_vss_m1|s3_vss_m1|s4_vss_m1|sb_vss|sr1_vss|sr2_vss|sr3_vss|sr4_vss|sv_vss|tg_d_vss|tg_fbm_vss|tg_fbs_vss|tg_s_vss|vss|vss_link|vss_link_bridge|vss_link_dip|vss_link_m1|vss_x1|vss_x2|vss_x3
+ 7.3577e-17
* device instance cc_a_b_inv_q_a_inv_q_a_via_s_tg_fbs_b_tg_fbs_b_via_tg_s_b_tg_s_b_via_a_inv_mc_a_mb_mnab_y_mpa_y_mpb_y_nand_m_y_tg_s_a_y r0 *1 0,0
Ccc_a_b_inv_q_a_inv_q_a_via_s_tg_fbs_b_tg_fbs_b_via_tg_s_b_tg_s_b_via_a_inv_mc_a_mb_mnab_y_mpa_y_mpb_y_nand_m_y_tg_s_a_y
+ a|b|inv_q_a|inv_q_a_via|s|tg_fbs_b|tg_fbs_b_via|tg_s_b|tg_s_b_via$5
+ a|inv_mc_a|mb|mnab_y|mpa_y|mpb_y|nand_m_y|tg_s_a|y$5 9.1937e-17
* device instance cc_a_b_inv_q_a_inv_q_a_via_s_tg_fbs_b_tg_fbs_b_via_tg_s_b_tg_s_b_via_a_mnab_y_mpa_y_mpb_y_nand_s2_y_qb_tg_fbs_a_y r0 *1 0,0
Ccc_a_b_inv_q_a_inv_q_a_via_s_tg_fbs_b_tg_fbs_b_via_tg_s_b_tg_s_b_via_a_mnab_y_mpa_y_mpb_y_nand_s2_y_qb_tg_fbs_a_y
+ a|b|inv_q_a|inv_q_a_via|s|tg_fbs_b|tg_fbs_b_via|tg_s_b|tg_s_b_via$5
+ a|mnab_y|mpa_y|mpb_y|nand_s2_y|qb|tg_fbs_a|y$5 2.00754e-16
* device instance cc_a_b_inv_q_a_inv_q_a_via_s_tg_fbs_b_tg_fbs_b_via_tg_s_b_tg_s_b_via_clkb_clkb_bridge1_clkb_bridge2_clkb_mid_clkb_w_ctrl_ctrlb_inv_clk_y_tg_d_ctrlb_tg_fbm_ctrl_tg_fbs_ctrlb_tg_s_ctrl_y r0 *1 0,0
Ccc_a_b_inv_q_a_inv_q_a_via_s_tg_fbs_b_tg_fbs_b_via_tg_s_b_tg_s_b_via_clkb_clkb_bridge1_clkb_bridge2_clkb_mid_clkb_w_ctrl_ctrlb_inv_clk_y_tg_d_ctrlb_tg_fbm_ctrl_tg_fbs_ctrlb_tg_s_ctrl_y
+ a|b|inv_q_a|inv_q_a_via|s|tg_fbs_b|tg_fbs_b_via|tg_s_b|tg_s_b_via$5
+ clkb|clkb_bridge1|clkb_bridge2|clkb_mid|clkb_w|ctrl|ctrlb|inv_clk_y|tg_d_ctrlb|tg_fbm_ctrl|tg_fbs_ctrlb|tg_s_ctrl|y$5
+ 9.3033e-17
* device instance cc_a_b_m_east_m_west_nand_m_a_nand_m_a_ext_via_nand_m_a_ext_via2_nand_m_a_stub_tg_d_b_tg_d_b_via_tg_d_b_via2_tg_fbm_b_tg_fbm_b_alt_via_tg_fbm_b_alt_via2_a_d_inv_clk_vdd_inv_mc_vdd_inv_q_vdd_mpa_py_mpb_py_nand_m_vdd_nand_s2_vdd_nwell_vdd_sb_vdd_sr1_vdd_sr2_vdd_sr3_vdd_sr4_vdd_sv_d_vdd_tie_sv_vdd_tg_d_a_tg_d_vdd_tg_fbm_vdd_tg_fbs_vdd_tg_s_vdd_vdd_vdd_b1_vdd_b2_vdd_b3_vdd_b4_vdd_link_vdd_link_dip_vdd_x1_vdd_x2_vdd_x3 r0 *1 0,0
Ccc_a_b_m_east_m_west_nand_m_a_nand_m_a_ext_via_nand_m_a_ext_via2_nand_m_a_stub_tg_d_b_tg_d_b_via_tg_d_b_via2_tg_fbm_b_tg_fbm_b_alt_via_tg_fbm_b_alt_via2_a_d_inv_clk_vdd_inv_mc_vdd_inv_q_vdd_mpa_py_mpb_py_nand_m_vdd_nand_s2_vdd_nwell_vdd_sb_vdd_sr1_vdd_sr2_vdd_sr3_vdd_sr4_vdd_sv_d_vdd_tie_sv_vdd_tg_d_a_tg_d_vdd_tg_fbm_vdd_tg_fbs_vdd_tg_s_vdd_vdd_vdd_b1_vdd_b2_vdd_b3_vdd_b4_vdd_link_vdd_link_dip_vdd_x1_vdd_x2_vdd_x3
+ a|b|m_east|m_west|nand_m_a|nand_m_a_ext_via|nand_m_a_ext_via2|nand_m_a_stub|tg_d_b|tg_d_b_via|tg_d_b_via2|tg_fbm_b|tg_fbm_b_alt_via|tg_fbm_b_alt_via2$5
+ a|d|inv_clk_vdd|inv_mc_vdd|inv_q_vdd|mpa_py|mpb_py|nand_m_vdd|nand_s2_vdd|nwell_vdd|sb_vdd|sr1_vdd|sr2_vdd|sr3_vdd|sr4_vdd|sv_d_vdd_tie|sv_vdd|tg_d_a|tg_d_vdd|tg_fbm_vdd|tg_fbs_vdd|tg_s_vdd|vdd|vdd_b1|vdd_b2|vdd_b3|vdd_b4|vdd_link|vdd_link_dip|vdd_x1|vdd_x2|vdd_x3
+ 3.869e-18
* device instance cc_a_b_m_east_m_west_nand_m_a_nand_m_a_ext_via_nand_m_a_ext_via2_nand_m_a_stub_tg_d_b_tg_d_b_via_tg_d_b_via2_tg_fbm_b_tg_fbm_b_alt_via_tg_fbm_b_alt_via2_a_d_inva_a_mn12_g0_mp13_g0_ro1_ro1_esc_sr1_d_stub_tg_d_a_y r0 *1 0,0
Ccc_a_b_m_east_m_west_nand_m_a_nand_m_a_ext_via_nand_m_a_ext_via2_nand_m_a_stub_tg_d_b_tg_d_b_via_tg_d_b_via2_tg_fbm_b_tg_fbm_b_alt_via_tg_fbm_b_alt_via2_a_d_inva_a_mn12_g0_mp13_g0_ro1_ro1_esc_sr1_d_stub_tg_d_a_y
+ a|b|m_east|m_west|nand_m_a|nand_m_a_ext_via|nand_m_a_ext_via2|nand_m_a_stub|tg_d_b|tg_d_b_via|tg_d_b_via2|tg_fbm_b|tg_fbm_b_alt_via|tg_fbm_b_alt_via2$5
+ a|d|inva_a|mn12_g0|mp13_g0|ro1|ro1_esc|sr1_d_stub|tg_d_a|y 3.869e-18
* device instance cc_a_b_m_east_m_west_nand_m_a_nand_m_a_ext_via_nand_m_a_ext_via2_nand_m_a_stub_tg_d_b_tg_d_b_via_tg_d_b_via2_tg_fbm_b_tg_fbm_b_alt_via_tg_fbm_b_alt_via2_a_d_inva_a_mn12_g0_mp13_g0_ro3_ro3_esc_e_ro3_esc_w_ro3_hop_sr3_d_stub_tg_d_a_y r0 *1 0,0
Ccc_a_b_m_east_m_west_nand_m_a_nand_m_a_ext_via_nand_m_a_ext_via2_nand_m_a_stub_tg_d_b_tg_d_b_via_tg_d_b_via2_tg_fbm_b_tg_fbm_b_alt_via_tg_fbm_b_alt_via2_a_d_inva_a_mn12_g0_mp13_g0_ro3_ro3_esc_e_ro3_esc_w_ro3_hop_sr3_d_stub_tg_d_a_y
+ a|b|m_east|m_west|nand_m_a|nand_m_a_ext_via|nand_m_a_ext_via2|nand_m_a_stub|tg_d_b|tg_d_b_via|tg_d_b_via2|tg_fbm_b|tg_fbm_b_alt_via|tg_fbm_b_alt_via2$5
+ a|d|inva_a|mn12_g0|mp13_g0|ro3|ro3_esc_e|ro3_esc_w|ro3_hop|sr3_d_stub|tg_d_a|y
+ 3.869e-18
* device instance cc_a_b_m_east_m_west_nand_m_a_nand_m_a_ext_via_nand_m_a_ext_via2_nand_m_a_stub_tg_d_b_tg_d_b_via_tg_d_b_via2_tg_fbm_b_tg_fbm_b_alt_via_tg_fbm_b_alt_via2_a_d_sb_d_stub_tg_d_a_xo_xo_dip_xo_hop_xo_stub_y r0 *1 0,0
Ccc_a_b_m_east_m_west_nand_m_a_nand_m_a_ext_via_nand_m_a_ext_via2_nand_m_a_stub_tg_d_b_tg_d_b_via_tg_d_b_via2_tg_fbm_b_tg_fbm_b_alt_via_tg_fbm_b_alt_via2_a_d_sb_d_stub_tg_d_a_xo_xo_dip_xo_hop_xo_stub_y
+ a|b|m_east|m_west|nand_m_a|nand_m_a_ext_via|nand_m_a_ext_via2|nand_m_a_stub|tg_d_b|tg_d_b_via|tg_d_b_via2|tg_fbm_b|tg_fbm_b_alt_via|tg_fbm_b_alt_via2$5
+ a|d|sb_d_stub|tg_d_a|xo|xo_dip|xo_hop|xo_stub|y 3.869e-18
* device instance cc_a_b_m_east_m_west_nand_m_a_nand_m_a_ext_via_nand_m_a_ext_via2_nand_m_a_stub_tg_d_b_tg_d_b_via_tg_d_b_via2_tg_fbm_b_tg_fbm_b_alt_via_tg_fbm_b_alt_via2_a_inv_mc_a_mb_mnab_y_mpa_y_mpb_y_nand_m_y_tg_s_a_y r0 *1 0,0
Ccc_a_b_m_east_m_west_nand_m_a_nand_m_a_ext_via_nand_m_a_ext_via2_nand_m_a_stub_tg_d_b_tg_d_b_via_tg_d_b_via2_tg_fbm_b_tg_fbm_b_alt_via_tg_fbm_b_alt_via2_a_inv_mc_a_mb_mnab_y_mpa_y_mpb_y_nand_m_y_tg_s_a_y
+ a|b|m_east|m_west|nand_m_a|nand_m_a_ext_via|nand_m_a_ext_via2|nand_m_a_stub|tg_d_b|tg_d_b_via|tg_d_b_via2|tg_fbm_b|tg_fbm_b_alt_via|tg_fbm_b_alt_via2$5
+ a|inv_mc_a|mb|mnab_y|mpa_y|mpb_y|nand_m_y|tg_s_a|y$5 2.11008e-16
* device instance cc_a_b_m_east_m_west_nand_m_a_nand_m_a_ext_via_nand_m_a_ext_via2_nand_m_a_stub_tg_d_b_tg_d_b_via_tg_d_b_via2_tg_fbm_b_tg_fbm_b_alt_via_tg_fbm_b_alt_via2_clkb_clkb_bridge1_clkb_bridge2_clkb_mid_clkb_w_ctrl_ctrlb_inv_clk_y_tg_d_ctrlb_tg_fbm_ctrl_tg_fbs_ctrlb_tg_s_ctrl_y r0 *1 0,0
Ccc_a_b_m_east_m_west_nand_m_a_nand_m_a_ext_via_nand_m_a_ext_via2_nand_m_a_stub_tg_d_b_tg_d_b_via_tg_d_b_via2_tg_fbm_b_tg_fbm_b_alt_via_tg_fbm_b_alt_via2_clkb_clkb_bridge1_clkb_bridge2_clkb_mid_clkb_w_ctrl_ctrlb_inv_clk_y_tg_d_ctrlb_tg_fbm_ctrl_tg_fbs_ctrlb_tg_s_ctrl_y
+ a|b|m_east|m_west|nand_m_a|nand_m_a_ext_via|nand_m_a_ext_via2|nand_m_a_stub|tg_d_b|tg_d_b_via|tg_d_b_via2|tg_fbm_b|tg_fbm_b_alt_via|tg_fbm_b_alt_via2$5
+ clkb|clkb_bridge1|clkb_bridge2|clkb_mid|clkb_w|ctrl|ctrlb|inv_clk_y|tg_d_ctrlb|tg_fbm_ctrl|tg_fbs_ctrlb|tg_s_ctrl|y$5
+ 1.00039e-16
* device instance cc_a_clk_ctrl_ctrlb_inv_clk_a_inv_clk_clk_via_tg_d_ctrl_tg_d_ctrl_via_tg_fbm_ctrlb_tg_fbm_ctrlb_via_tg_fbs_ctrl_tg_fbs_ctrl_via_tg_s_ctrlb_tg_s_ctrlb_via_a_mnab_y_mpa_y_mpb_y_nand_s2_y_qb_tg_fbs_a_y r0 *1 0,0
Ccc_a_clk_ctrl_ctrlb_inv_clk_a_inv_clk_clk_via_tg_d_ctrl_tg_d_ctrl_via_tg_fbm_ctrlb_tg_fbm_ctrlb_via_tg_fbs_ctrl_tg_fbs_ctrl_via_tg_s_ctrlb_tg_s_ctrlb_via_a_mnab_y_mpa_y_mpb_y_nand_s2_y_qb_tg_fbs_a_y
+ a|clk|ctrl|ctrlb|inv_clk_a|inv_clk_clk_via|tg_d_ctrl|tg_d_ctrl_via|tg_fbm_ctrlb|tg_fbm_ctrlb_via|tg_fbs_ctrl|tg_fbs_ctrl_via|tg_s_ctrlb|tg_s_ctrlb_via
+ a|mnab_y|mpa_y|mpb_y|nand_s2_y|qb|tg_fbs_a|y$5 2.3211e-17
* device instance cc_a_clk_ctrl_ctrlb_inv_clk_a_inv_clk_clk_via_tg_d_ctrl_tg_d_ctrl_via_tg_fbm_ctrlb_tg_fbm_ctrlb_via_tg_fbs_ctrl_tg_fbs_ctrl_via_tg_s_ctrlb_tg_s_ctrlb_via_clkb_clkb_bridge1_clkb_bridge2_clkb_mid_clkb_w_ctrl_ctrlb_inv_clk_y_tg_d_ctrlb_tg_fbm_ctrl_tg_fbs_ctrlb_tg_s_ctrl_y r0 *1 0,0
Ccc_a_clk_ctrl_ctrlb_inv_clk_a_inv_clk_clk_via_tg_d_ctrl_tg_d_ctrl_via_tg_fbm_ctrlb_tg_fbm_ctrlb_via_tg_fbs_ctrl_tg_fbs_ctrl_via_tg_s_ctrlb_tg_s_ctrlb_via_clkb_clkb_bridge1_clkb_bridge2_clkb_mid_clkb_w_ctrl_ctrlb_inv_clk_y_tg_d_ctrlb_tg_fbm_ctrl_tg_fbs_ctrlb_tg_s_ctrl_y
+ a|clk|ctrl|ctrlb|inv_clk_a|inv_clk_clk_via|tg_d_ctrl|tg_d_ctrl_via|tg_fbm_ctrlb|tg_fbm_ctrlb_via|tg_fbs_ctrl|tg_fbs_ctrl_via|tg_s_ctrlb|tg_s_ctrlb_via
+ clkb|clkb_bridge1|clkb_bridge2|clkb_mid|clkb_w|ctrl|ctrlb|inv_clk_y|tg_d_ctrlb|tg_fbm_ctrl|tg_fbs_ctrlb|tg_s_ctrl|y$5
+ 2.75805e-16
* device instance cc_a_clk_ctrl_ctrlb_inv_clk_a_inv_clk_clk_via_tg_d_ctrl_tg_d_ctrl_via_tg_fbm_ctrlb_tg_fbm_ctrlb_via_tg_fbs_ctrl_tg_fbs_ctrl_via_tg_s_ctrlb_tg_s_ctrlb_via_g_vss_m1_inv_clk_vss_inv_mc_vss_inv_q_vss_mph_g_nand_m_vss_nand_s2_vss_s1_vss_m1_s2_vss_m1_s3_vss_m1_s4_vss_m1_sb_vss_sr1_vss_sr2_vss_sr3_vss_sr4_vss_sv_vss_tg_d_vss_tg_fbm_vss_tg_fbs_vss_tg_s_vss_vss_vss_link_vss_link_bridge_vss_link_dip_vss_link_m1_vss_x1_vss_x2_vss_x3 r0 *1 0,0
Ccc_a_clk_ctrl_ctrlb_inv_clk_a_inv_clk_clk_via_tg_d_ctrl_tg_d_ctrl_via_tg_fbm_ctrlb_tg_fbm_ctrlb_via_tg_fbs_ctrl_tg_fbs_ctrl_via_tg_s_ctrlb_tg_s_ctrlb_via_g_vss_m1_inv_clk_vss_inv_mc_vss_inv_q_vss_mph_g_nand_m_vss_nand_s2_vss_s1_vss_m1_s2_vss_m1_s3_vss_m1_s4_vss_m1_sb_vss_sr1_vss_sr2_vss_sr3_vss_sr4_vss_sv_vss_tg_d_vss_tg_fbm_vss_tg_fbs_vss_tg_s_vss_vss_vss_link_vss_link_bridge_vss_link_dip_vss_link_m1_vss_x1_vss_x2_vss_x3
+ a|clk|ctrl|ctrlb|inv_clk_a|inv_clk_clk_via|tg_d_ctrl|tg_d_ctrl_via|tg_fbm_ctrlb|tg_fbm_ctrlb_via|tg_fbs_ctrl|tg_fbs_ctrl_via|tg_s_ctrlb|tg_s_ctrlb_via
+ g_vss_m1|inv_clk_vss|inv_mc_vss|inv_q_vss|mph_g|nand_m_vss|nand_s2_vss|s1_vss_m1|s2_vss_m1|s3_vss_m1|s4_vss_m1|sb_vss|sr1_vss|sr2_vss|sr3_vss|sr4_vss|sv_vss|tg_d_vss|tg_fbm_vss|tg_fbs_vss|tg_s_vss|vss|vss_link|vss_link_bridge|vss_link_dip|vss_link_m1|vss_x1|vss_x2|vss_x3
+ 1.16057e-16
* device instance cc_a_d_inv_clk_vdd_inv_mc_vdd_inv_q_vdd_mpa_py_mpb_py_nand_m_vdd_nand_s2_vdd_nwell_vdd_sb_vdd_sr1_vdd_sr2_vdd_sr3_vdd_sr4_vdd_sv_d_vdd_tie_sv_vdd_tg_d_a_tg_d_vdd_tg_fbm_vdd_tg_fbs_vdd_tg_s_vdd_vdd_vdd_b1_vdd_b2_vdd_b3_vdd_b4_vdd_link_vdd_link_dip_vdd_x1_vdd_x2_vdd_x3_a_d_inva_a_mn12_g0_mp13_g0_ro1_ro1_esc_sr1_d_stub_tg_d_a_y r0 *1 0,0
Ccc_a_d_inv_clk_vdd_inv_mc_vdd_inv_q_vdd_mpa_py_mpb_py_nand_m_vdd_nand_s2_vdd_nwell_vdd_sb_vdd_sr1_vdd_sr2_vdd_sr3_vdd_sr4_vdd_sv_d_vdd_tie_sv_vdd_tg_d_a_tg_d_vdd_tg_fbm_vdd_tg_fbs_vdd_tg_s_vdd_vdd_vdd_b1_vdd_b2_vdd_b3_vdd_b4_vdd_link_vdd_link_dip_vdd_x1_vdd_x2_vdd_x3_a_d_inva_a_mn12_g0_mp13_g0_ro1_ro1_esc_sr1_d_stub_tg_d_a_y
+ a|d|inv_clk_vdd|inv_mc_vdd|inv_q_vdd|mpa_py|mpb_py|nand_m_vdd|nand_s2_vdd|nwell_vdd|sb_vdd|sr1_vdd|sr2_vdd|sr3_vdd|sr4_vdd|sv_d_vdd_tie|sv_vdd|tg_d_a|tg_d_vdd|tg_fbm_vdd|tg_fbs_vdd|tg_s_vdd|vdd|vdd_b1|vdd_b2|vdd_b3|vdd_b4|vdd_link|vdd_link_dip|vdd_x1|vdd_x2|vdd_x3
+ a|d|inva_a|mn12_g0|mp13_g0|ro1|ro1_esc|sr1_d_stub|tg_d_a|y 4.5399e-17
* device instance cc_a_d_inv_clk_vdd_inv_mc_vdd_inv_q_vdd_mpa_py_mpb_py_nand_m_vdd_nand_s2_vdd_nwell_vdd_sb_vdd_sr1_vdd_sr2_vdd_sr3_vdd_sr4_vdd_sv_d_vdd_tie_sv_vdd_tg_d_a_tg_d_vdd_tg_fbm_vdd_tg_fbs_vdd_tg_s_vdd_vdd_vdd_b1_vdd_b2_vdd_b3_vdd_b4_vdd_link_vdd_link_dip_vdd_x1_vdd_x2_vdd_x3_a_d_inva_a_mn12_g0_mp13_g0_ro3_ro3_esc_e_ro3_esc_w_ro3_hop_sr3_d_stub_tg_d_a_y r0 *1 0,0
Ccc_a_d_inv_clk_vdd_inv_mc_vdd_inv_q_vdd_mpa_py_mpb_py_nand_m_vdd_nand_s2_vdd_nwell_vdd_sb_vdd_sr1_vdd_sr2_vdd_sr3_vdd_sr4_vdd_sv_d_vdd_tie_sv_vdd_tg_d_a_tg_d_vdd_tg_fbm_vdd_tg_fbs_vdd_tg_s_vdd_vdd_vdd_b1_vdd_b2_vdd_b3_vdd_b4_vdd_link_vdd_link_dip_vdd_x1_vdd_x2_vdd_x3_a_d_inva_a_mn12_g0_mp13_g0_ro3_ro3_esc_e_ro3_esc_w_ro3_hop_sr3_d_stub_tg_d_a_y
+ a|d|inv_clk_vdd|inv_mc_vdd|inv_q_vdd|mpa_py|mpb_py|nand_m_vdd|nand_s2_vdd|nwell_vdd|sb_vdd|sr1_vdd|sr2_vdd|sr3_vdd|sr4_vdd|sv_d_vdd_tie|sv_vdd|tg_d_a|tg_d_vdd|tg_fbm_vdd|tg_fbs_vdd|tg_s_vdd|vdd|vdd_b1|vdd_b2|vdd_b3|vdd_b4|vdd_link|vdd_link_dip|vdd_x1|vdd_x2|vdd_x3
+ a|d|inva_a|mn12_g0|mp13_g0|ro3|ro3_esc_e|ro3_esc_w|ro3_hop|sr3_d_stub|tg_d_a|y
+ 4.9268e-17
* device instance cc_a_d_inv_clk_vdd_inv_mc_vdd_inv_q_vdd_mpa_py_mpb_py_nand_m_vdd_nand_s2_vdd_nwell_vdd_sb_vdd_sr1_vdd_sr2_vdd_sr3_vdd_sr4_vdd_sv_d_vdd_tie_sv_vdd_tg_d_a_tg_d_vdd_tg_fbm_vdd_tg_fbs_vdd_tg_s_vdd_vdd_vdd_b1_vdd_b2_vdd_b3_vdd_b4_vdd_link_vdd_link_dip_vdd_x1_vdd_x2_vdd_x3_a_d_sb_d_stub_tg_d_a_xo_xo_dip_xo_hop_xo_stub_y r0 *1 0,0
Ccc_a_d_inv_clk_vdd_inv_mc_vdd_inv_q_vdd_mpa_py_mpb_py_nand_m_vdd_nand_s2_vdd_nwell_vdd_sb_vdd_sr1_vdd_sr2_vdd_sr3_vdd_sr4_vdd_sv_d_vdd_tie_sv_vdd_tg_d_a_tg_d_vdd_tg_fbm_vdd_tg_fbs_vdd_tg_s_vdd_vdd_vdd_b1_vdd_b2_vdd_b3_vdd_b4_vdd_link_vdd_link_dip_vdd_x1_vdd_x2_vdd_x3_a_d_sb_d_stub_tg_d_a_xo_xo_dip_xo_hop_xo_stub_y
+ a|d|inv_clk_vdd|inv_mc_vdd|inv_q_vdd|mpa_py|mpb_py|nand_m_vdd|nand_s2_vdd|nwell_vdd|sb_vdd|sr1_vdd|sr2_vdd|sr3_vdd|sr4_vdd|sv_d_vdd_tie|sv_vdd|tg_d_a|tg_d_vdd|tg_fbm_vdd|tg_fbs_vdd|tg_s_vdd|vdd|vdd_b1|vdd_b2|vdd_b3|vdd_b4|vdd_link|vdd_link_dip|vdd_x1|vdd_x2|vdd_x3
+ a|d|sb_d_stub|tg_d_a|xo|xo_dip|xo_hop|xo_stub|y 3.869e-18
* device instance cc_a_d_inv_clk_vdd_inv_mc_vdd_inv_q_vdd_mpa_py_mpb_py_nand_m_vdd_nand_s2_vdd_nwell_vdd_sb_vdd_sr1_vdd_sr2_vdd_sr3_vdd_sr4_vdd_sv_d_vdd_tie_sv_vdd_tg_d_a_tg_d_vdd_tg_fbm_vdd_tg_fbs_vdd_tg_s_vdd_vdd_vdd_b1_vdd_b2_vdd_b3_vdd_b4_vdd_link_vdd_link_dip_vdd_x1_vdd_x2_vdd_x3_a_g_a_rn4_ro_s4_y_y r0 *1 0,0
Ccc_a_d_inv_clk_vdd_inv_mc_vdd_inv_q_vdd_mpa_py_mpb_py_nand_m_vdd_nand_s2_vdd_nwell_vdd_sb_vdd_sr1_vdd_sr2_vdd_sr3_vdd_sr4_vdd_sv_d_vdd_tie_sv_vdd_tg_d_a_tg_d_vdd_tg_fbm_vdd_tg_fbs_vdd_tg_s_vdd_vdd_vdd_b1_vdd_b2_vdd_b3_vdd_b4_vdd_link_vdd_link_dip_vdd_x1_vdd_x2_vdd_x3_a_g_a_rn4_ro_s4_y_y
+ a|d|inv_clk_vdd|inv_mc_vdd|inv_q_vdd|mpa_py|mpb_py|nand_m_vdd|nand_s2_vdd|nwell_vdd|sb_vdd|sr1_vdd|sr2_vdd|sr3_vdd|sr4_vdd|sv_d_vdd_tie|sv_vdd|tg_d_a|tg_d_vdd|tg_fbm_vdd|tg_fbs_vdd|tg_s_vdd|vdd|vdd_b1|vdd_b2|vdd_b3|vdd_b4|vdd_link|vdd_link_dip|vdd_x1|vdd_x2|vdd_x3
+ a|g_a|rn4|ro|s4_y|y 3.869e-18
* device instance cc_a_d_inv_clk_vdd_inv_mc_vdd_inv_q_vdd_mpa_py_mpb_py_nand_m_vdd_nand_s2_vdd_nwell_vdd_sb_vdd_sr1_vdd_sr2_vdd_sr3_vdd_sr4_vdd_sv_d_vdd_tie_sv_vdd_tg_d_a_tg_d_vdd_tg_fbm_vdd_tg_fbs_vdd_tg_s_vdd_vdd_vdd_b1_vdd_b2_vdd_b3_vdd_b4_vdd_link_vdd_link_dip_vdd_x1_vdd_x2_vdd_x3_a_inva_a_mn12_g0_mp13_g0_t1_y r0 *1 0,0
Ccc_a_d_inv_clk_vdd_inv_mc_vdd_inv_q_vdd_mpa_py_mpb_py_nand_m_vdd_nand_s2_vdd_nwell_vdd_sb_vdd_sr1_vdd_sr2_vdd_sr3_vdd_sr4_vdd_sv_d_vdd_tie_sv_vdd_tg_d_a_tg_d_vdd_tg_fbm_vdd_tg_fbs_vdd_tg_s_vdd_vdd_vdd_b1_vdd_b2_vdd_b3_vdd_b4_vdd_link_vdd_link_dip_vdd_x1_vdd_x2_vdd_x3_a_inva_a_mn12_g0_mp13_g0_t1_y
+ a|d|inv_clk_vdd|inv_mc_vdd|inv_q_vdd|mpa_py|mpb_py|nand_m_vdd|nand_s2_vdd|nwell_vdd|sb_vdd|sr1_vdd|sr2_vdd|sr3_vdd|sr4_vdd|sv_d_vdd_tie|sv_vdd|tg_d_a|tg_d_vdd|tg_fbm_vdd|tg_fbs_vdd|tg_s_vdd|vdd|vdd_b1|vdd_b2|vdd_b3|vdd_b4|vdd_link|vdd_link_dip|vdd_x1|vdd_x2|vdd_x3
+ a|inva_a|mn12_g0|mp13_g0|t1|y 3.5274e-17
* device instance cc_a_d_inv_clk_vdd_inv_mc_vdd_inv_q_vdd_mpa_py_mpb_py_nand_m_vdd_nand_s2_vdd_nwell_vdd_sb_vdd_sr1_vdd_sr2_vdd_sr3_vdd_sr4_vdd_sv_d_vdd_tie_sv_vdd_tg_d_a_tg_d_vdd_tg_fbm_vdd_tg_fbs_vdd_tg_s_vdd_vdd_vdd_b1_vdd_b2_vdd_b3_vdd_b4_vdd_link_vdd_link_dip_vdd_x1_vdd_x2_vdd_x3_bn_invb_y_mn34_g1_mp24_g1_y r0 *1 0,0
Ccc_a_d_inv_clk_vdd_inv_mc_vdd_inv_q_vdd_mpa_py_mpb_py_nand_m_vdd_nand_s2_vdd_nwell_vdd_sb_vdd_sr1_vdd_sr2_vdd_sr3_vdd_sr4_vdd_sv_d_vdd_tie_sv_vdd_tg_d_a_tg_d_vdd_tg_fbm_vdd_tg_fbs_vdd_tg_s_vdd_vdd_vdd_b1_vdd_b2_vdd_b3_vdd_b4_vdd_link_vdd_link_dip_vdd_x1_vdd_x2_vdd_x3_bn_invb_y_mn34_g1_mp24_g1_y
+ a|d|inv_clk_vdd|inv_mc_vdd|inv_q_vdd|mpa_py|mpb_py|nand_m_vdd|nand_s2_vdd|nwell_vdd|sb_vdd|sr1_vdd|sr2_vdd|sr3_vdd|sr4_vdd|sv_d_vdd_tie|sv_vdd|tg_d_a|tg_d_vdd|tg_fbm_vdd|tg_fbs_vdd|tg_s_vdd|vdd|vdd_b1|vdd_b2|vdd_b3|vdd_b4|vdd_link|vdd_link_dip|vdd_x1|vdd_x2|vdd_x3
+ bn|invb_y|mn34_g1|mp24_g1|y$2 9.901e-18
* device instance cc_a_d_inv_clk_vdd_inv_mc_vdd_inv_q_vdd_mpa_py_mpb_py_nand_m_vdd_nand_s2_vdd_nwell_vdd_sb_vdd_sr1_vdd_sr2_vdd_sr3_vdd_sr4_vdd_sv_d_vdd_tie_sv_vdd_tg_d_a_tg_d_vdd_tg_fbm_vdd_tg_fbs_vdd_tg_s_vdd_vdd_vdd_b1_vdd_b2_vdd_b3_vdd_b4_vdd_link_vdd_link_dip_vdd_x1_vdd_x2_vdd_x3_clkb_clkb_bridge1_clkb_bridge2_clkb_mid_clkb_w_ctrl_ctrlb_inv_clk_y_tg_d_ctrlb_tg_fbm_ctrl_tg_fbs_ctrlb_tg_s_ctrl_y r0 *1 0,0
Ccc_a_d_inv_clk_vdd_inv_mc_vdd_inv_q_vdd_mpa_py_mpb_py_nand_m_vdd_nand_s2_vdd_nwell_vdd_sb_vdd_sr1_vdd_sr2_vdd_sr3_vdd_sr4_vdd_sv_d_vdd_tie_sv_vdd_tg_d_a_tg_d_vdd_tg_fbm_vdd_tg_fbs_vdd_tg_s_vdd_vdd_vdd_b1_vdd_b2_vdd_b3_vdd_b4_vdd_link_vdd_link_dip_vdd_x1_vdd_x2_vdd_x3_clkb_clkb_bridge1_clkb_bridge2_clkb_mid_clkb_w_ctrl_ctrlb_inv_clk_y_tg_d_ctrlb_tg_fbm_ctrl_tg_fbs_ctrlb_tg_s_ctrl_y
+ a|d|inv_clk_vdd|inv_mc_vdd|inv_q_vdd|mpa_py|mpb_py|nand_m_vdd|nand_s2_vdd|nwell_vdd|sb_vdd|sr1_vdd|sr2_vdd|sr3_vdd|sr4_vdd|sv_d_vdd_tie|sv_vdd|tg_d_a|tg_d_vdd|tg_fbm_vdd|tg_fbs_vdd|tg_s_vdd|vdd|vdd_b1|vdd_b2|vdd_b3|vdd_b4|vdd_link|vdd_link_dip|vdd_x1|vdd_x2|vdd_x3
+ clkb|clkb_bridge1|clkb_bridge2|clkb_mid|clkb_w|ctrl|ctrlb|inv_clk_y|tg_d_ctrlb|tg_fbm_ctrl|tg_fbs_ctrlb|tg_s_ctrl|y$5
+ 8.337e-18
* device instance cc_a_d_inv_clk_vdd_inv_mc_vdd_inv_q_vdd_mpa_py_mpb_py_nand_m_vdd_nand_s2_vdd_nwell_vdd_sb_vdd_sr1_vdd_sr2_vdd_sr3_vdd_sr4_vdd_sv_d_vdd_tie_sv_vdd_tg_d_a_tg_d_vdd_tg_fbm_vdd_tg_fbs_vdd_tg_s_vdd_vdd_vdd_b1_vdd_b2_vdd_b3_vdd_b4_vdd_link_vdd_link_dip_vdd_x1_vdd_x2_vdd_x3_en_nand_m_en_nand_m_en_via_nand_s2_en_nand_s2_en_via_rst_n r0 *1 0,0
Ccc_a_d_inv_clk_vdd_inv_mc_vdd_inv_q_vdd_mpa_py_mpb_py_nand_m_vdd_nand_s2_vdd_nwell_vdd_sb_vdd_sr1_vdd_sr2_vdd_sr3_vdd_sr4_vdd_sv_d_vdd_tie_sv_vdd_tg_d_a_tg_d_vdd_tg_fbm_vdd_tg_fbs_vdd_tg_s_vdd_vdd_vdd_b1_vdd_b2_vdd_b3_vdd_b4_vdd_link_vdd_link_dip_vdd_x1_vdd_x2_vdd_x3_en_nand_m_en_nand_m_en_via_nand_s2_en_nand_s2_en_via_rst_n
+ a|d|inv_clk_vdd|inv_mc_vdd|inv_q_vdd|mpa_py|mpb_py|nand_m_vdd|nand_s2_vdd|nwell_vdd|sb_vdd|sr1_vdd|sr2_vdd|sr3_vdd|sr4_vdd|sv_d_vdd_tie|sv_vdd|tg_d_a|tg_d_vdd|tg_fbm_vdd|tg_fbs_vdd|tg_s_vdd|vdd|vdd_b1|vdd_b2|vdd_b3|vdd_b4|vdd_link|vdd_link_dip|vdd_x1|vdd_x2|vdd_x3
+ en|nand_m_en|nand_m_en_via|nand_s2_en|nand_s2_en_via|rst_n 1.00582e-16
* device instance cc_a_d_inv_clk_vdd_inv_mc_vdd_inv_q_vdd_mpa_py_mpb_py_nand_m_vdd_nand_s2_vdd_nwell_vdd_sb_vdd_sr1_vdd_sr2_vdd_sr3_vdd_sr4_vdd_sv_d_vdd_tie_sv_vdd_tg_d_a_tg_d_vdd_tg_fbm_vdd_tg_fbs_vdd_tg_s_vdd_vdd_vdd_b1_vdd_b2_vdd_b3_vdd_b4_vdd_link_vdd_link_dip_vdd_x1_vdd_x2_vdd_x3_g_vss_m1_inv_clk_vss_inv_mc_vss_inv_q_vss_mph_g_nand_m_vss_nand_s2_vss_s1_vss_m1_s2_vss_m1_s3_vss_m1_s4_vss_m1_sb_vss_sr1_vss_sr2_vss_sr3_vss_sr4_vss_sv_vss_tg_d_vss_tg_fbm_vss_tg_fbs_vss_tg_s_vss_vss_vss_link_vss_link_bridge_vss_link_dip_vss_link_m1_vss_x1_vss_x2_vss_x3 r0 *1 0,0
Ccc_a_d_inv_clk_vdd_inv_mc_vdd_inv_q_vdd_mpa_py_mpb_py_nand_m_vdd_nand_s2_vdd_nwell_vdd_sb_vdd_sr1_vdd_sr2_vdd_sr3_vdd_sr4_vdd_sv_d_vdd_tie_sv_vdd_tg_d_a_tg_d_vdd_tg_fbm_vdd_tg_fbs_vdd_tg_s_vdd_vdd_vdd_b1_vdd_b2_vdd_b3_vdd_b4_vdd_link_vdd_link_dip_vdd_x1_vdd_x2_vdd_x3_g_vss_m1_inv_clk_vss_inv_mc_vss_inv_q_vss_mph_g_nand_m_vss_nand_s2_vss_s1_vss_m1_s2_vss_m1_s3_vss_m1_s4_vss_m1_sb_vss_sr1_vss_sr2_vss_sr3_vss_sr4_vss_sv_vss_tg_d_vss_tg_fbm_vss_tg_fbs_vss_tg_s_vss_vss_vss_link_vss_link_bridge_vss_link_dip_vss_link_m1_vss_x1_vss_x2_vss_x3
+ a|d|inv_clk_vdd|inv_mc_vdd|inv_q_vdd|mpa_py|mpb_py|nand_m_vdd|nand_s2_vdd|nwell_vdd|sb_vdd|sr1_vdd|sr2_vdd|sr3_vdd|sr4_vdd|sv_d_vdd_tie|sv_vdd|tg_d_a|tg_d_vdd|tg_fbm_vdd|tg_fbs_vdd|tg_s_vdd|vdd|vdd_b1|vdd_b2|vdd_b3|vdd_b4|vdd_link|vdd_link_dip|vdd_x1|vdd_x2|vdd_x3
+ g_vss_m1|inv_clk_vss|inv_mc_vss|inv_q_vss|mph_g|nand_m_vss|nand_s2_vss|s1_vss_m1|s2_vss_m1|s3_vss_m1|s4_vss_m1|sb_vss|sr1_vss|sr2_vss|sr3_vss|sr4_vss|sv_vss|tg_d_vss|tg_fbm_vss|tg_fbs_vss|tg_s_vss|vss|vss_link|vss_link_bridge|vss_link_dip|vss_link_m1|vss_x1|vss_x2|vss_x3
+ 7.7757e-17
* device instance cc_a_d_inva_a_mn12_g0_mp13_g0_ro1_ro1_esc_sr1_d_stub_tg_d_a_y_a_d_inva_a_mn12_g0_mp13_g0_ro3_ro3_esc_e_ro3_esc_w_ro3_hop_sr3_d_stub_tg_d_a_y r0 *1 0,0
Ccc_a_d_inva_a_mn12_g0_mp13_g0_ro1_ro1_esc_sr1_d_stub_tg_d_a_y_a_d_inva_a_mn12_g0_mp13_g0_ro3_ro3_esc_e_ro3_esc_w_ro3_hop_sr3_d_stub_tg_d_a_y
+ a|d|inva_a|mn12_g0|mp13_g0|ro1|ro1_esc|sr1_d_stub|tg_d_a|y
+ a|d|inva_a|mn12_g0|mp13_g0|ro3|ro3_esc_e|ro3_esc_w|ro3_hop|sr3_d_stub|tg_d_a|y
+ 3.869e-18
* device instance cc_a_d_inva_a_mn12_g0_mp13_g0_ro1_ro1_esc_sr1_d_stub_tg_d_a_y_a_inva_a_mn12_g0_mp13_g0_t1_y r0 *1 0,0
Ccc_a_d_inva_a_mn12_g0_mp13_g0_ro1_ro1_esc_sr1_d_stub_tg_d_a_y_a_inva_a_mn12_g0_mp13_g0_t1_y
+ a|d|inva_a|mn12_g0|mp13_g0|ro1|ro1_esc|sr1_d_stub|tg_d_a|y
+ a|inva_a|mn12_g0|mp13_g0|t1|y 3.3e-18
* device instance cc_a_d_inva_a_mn12_g0_mp13_g0_ro1_ro1_esc_sr1_d_stub_tg_d_a_y_clkb_clkb_bridge1_clkb_bridge2_clkb_mid_clkb_w_ctrl_ctrlb_inv_clk_y_tg_d_ctrlb_tg_fbm_ctrl_tg_fbs_ctrlb_tg_s_ctrl_y r0 *1 0,0
Ccc_a_d_inva_a_mn12_g0_mp13_g0_ro1_ro1_esc_sr1_d_stub_tg_d_a_y_clkb_clkb_bridge1_clkb_bridge2_clkb_mid_clkb_w_ctrl_ctrlb_inv_clk_y_tg_d_ctrlb_tg_fbm_ctrl_tg_fbs_ctrlb_tg_s_ctrl_y
+ a|d|inva_a|mn12_g0|mp13_g0|ro1|ro1_esc|sr1_d_stub|tg_d_a|y
+ clkb|clkb_bridge1|clkb_bridge2|clkb_mid|clkb_w|ctrl|ctrlb|inv_clk_y|tg_d_ctrlb|tg_fbm_ctrl|tg_fbs_ctrlb|tg_s_ctrl|y$5
+ 8.337e-18
* device instance cc_a_d_inva_a_mn12_g0_mp13_g0_ro1_ro1_esc_sr1_d_stub_tg_d_a_y_en_nand_m_en_nand_m_en_via_nand_s2_en_nand_s2_en_via_rst_n r0 *1 0,0
Ccc_a_d_inva_a_mn12_g0_mp13_g0_ro1_ro1_esc_sr1_d_stub_tg_d_a_y_en_nand_m_en_nand_m_en_via_nand_s2_en_nand_s2_en_via_rst_n
+ a|d|inva_a|mn12_g0|mp13_g0|ro1|ro1_esc|sr1_d_stub|tg_d_a|y
+ en|nand_m_en|nand_m_en_via|nand_s2_en|nand_s2_en_via|rst_n 3.869e-18
* device instance cc_a_d_inva_a_mn12_g0_mp13_g0_ro1_ro1_esc_sr1_d_stub_tg_d_a_y_g_vss_m1_inv_clk_vss_inv_mc_vss_inv_q_vss_mph_g_nand_m_vss_nand_s2_vss_s1_vss_m1_s2_vss_m1_s3_vss_m1_s4_vss_m1_sb_vss_sr1_vss_sr2_vss_sr3_vss_sr4_vss_sv_vss_tg_d_vss_tg_fbm_vss_tg_fbs_vss_tg_s_vss_vss_vss_link_vss_link_bridge_vss_link_dip_vss_link_m1_vss_x1_vss_x2_vss_x3 r0 *1 0,0
Ccc_a_d_inva_a_mn12_g0_mp13_g0_ro1_ro1_esc_sr1_d_stub_tg_d_a_y_g_vss_m1_inv_clk_vss_inv_mc_vss_inv_q_vss_mph_g_nand_m_vss_nand_s2_vss_s1_vss_m1_s2_vss_m1_s3_vss_m1_s4_vss_m1_sb_vss_sr1_vss_sr2_vss_sr3_vss_sr4_vss_sv_vss_tg_d_vss_tg_fbm_vss_tg_fbs_vss_tg_s_vss_vss_vss_link_vss_link_bridge_vss_link_dip_vss_link_m1_vss_x1_vss_x2_vss_x3
+ a|d|inva_a|mn12_g0|mp13_g0|ro1|ro1_esc|sr1_d_stub|tg_d_a|y
+ g_vss_m1|inv_clk_vss|inv_mc_vss|inv_q_vss|mph_g|nand_m_vss|nand_s2_vss|s1_vss_m1|s2_vss_m1|s3_vss_m1|s4_vss_m1|sb_vss|sr1_vss|sr2_vss|sr3_vss|sr4_vss|sv_vss|tg_d_vss|tg_fbm_vss|tg_fbs_vss|tg_s_vss|vss|vss_link|vss_link_bridge|vss_link_dip|vss_link_m1|vss_x1|vss_x2|vss_x3
+ 6.601e-18
* device instance cc_a_d_inva_a_mn12_g0_mp13_g0_ro3_ro3_esc_e_ro3_esc_w_ro3_hop_sr3_d_stub_tg_d_a_y_clkb_clkb_bridge1_clkb_bridge2_clkb_mid_clkb_w_ctrl_ctrlb_inv_clk_y_tg_d_ctrlb_tg_fbm_ctrl_tg_fbs_ctrlb_tg_s_ctrl_y r0 *1 0,0
Ccc_a_d_inva_a_mn12_g0_mp13_g0_ro3_ro3_esc_e_ro3_esc_w_ro3_hop_sr3_d_stub_tg_d_a_y_clkb_clkb_bridge1_clkb_bridge2_clkb_mid_clkb_w_ctrl_ctrlb_inv_clk_y_tg_d_ctrlb_tg_fbm_ctrl_tg_fbs_ctrlb_tg_s_ctrl_y
+ a|d|inva_a|mn12_g0|mp13_g0|ro3|ro3_esc_e|ro3_esc_w|ro3_hop|sr3_d_stub|tg_d_a|y
+ clkb|clkb_bridge1|clkb_bridge2|clkb_mid|clkb_w|ctrl|ctrlb|inv_clk_y|tg_d_ctrlb|tg_fbm_ctrl|tg_fbs_ctrlb|tg_s_ctrl|y$5
+ 8.337e-18
* device instance cc_a_d_inva_a_mn12_g0_mp13_g0_ro3_ro3_esc_e_ro3_esc_w_ro3_hop_sr3_d_stub_tg_d_a_y_en_nand_m_en_nand_m_en_via_nand_s2_en_nand_s2_en_via_rst_n r0 *1 0,0
Ccc_a_d_inva_a_mn12_g0_mp13_g0_ro3_ro3_esc_e_ro3_esc_w_ro3_hop_sr3_d_stub_tg_d_a_y_en_nand_m_en_nand_m_en_via_nand_s2_en_nand_s2_en_via_rst_n
+ a|d|inva_a|mn12_g0|mp13_g0|ro3|ro3_esc_e|ro3_esc_w|ro3_hop|sr3_d_stub|tg_d_a|y
+ en|nand_m_en|nand_m_en_via|nand_s2_en|nand_s2_en_via|rst_n 3.869e-18
* device instance cc_a_d_inva_a_mn12_g0_mp13_g0_ro3_ro3_esc_e_ro3_esc_w_ro3_hop_sr3_d_stub_tg_d_a_y_g_vddr_m1_mnt_g_s1_vddr_m1_s2_vddr_m1_s3_vddr_m1_s4_vddr_m1_vddr_vddr1 r0 *1 0,0
Ccc_a_d_inva_a_mn12_g0_mp13_g0_ro3_ro3_esc_e_ro3_esc_w_ro3_hop_sr3_d_stub_tg_d_a_y_g_vddr_m1_mnt_g_s1_vddr_m1_s2_vddr_m1_s3_vddr_m1_s4_vddr_m1_vddr_vddr1
+ a|d|inva_a|mn12_g0|mp13_g0|ro3|ro3_esc_e|ro3_esc_w|ro3_hop|sr3_d_stub|tg_d_a|y
+ g_vddr_m1|mnt_g|s1_vddr_m1|s2_vddr_m1|s3_vddr_m1|s4_vddr_m1|vddr|vddr1
+ 3.869e-18
* device instance cc_a_d_inva_a_mn12_g0_mp13_g0_ro3_ro3_esc_e_ro3_esc_w_ro3_hop_sr3_d_stub_tg_d_a_y_g_vss_m1_inv_clk_vss_inv_mc_vss_inv_q_vss_mph_g_nand_m_vss_nand_s2_vss_s1_vss_m1_s2_vss_m1_s3_vss_m1_s4_vss_m1_sb_vss_sr1_vss_sr2_vss_sr3_vss_sr4_vss_sv_vss_tg_d_vss_tg_fbm_vss_tg_fbs_vss_tg_s_vss_vss_vss_link_vss_link_bridge_vss_link_dip_vss_link_m1_vss_x1_vss_x2_vss_x3 r0 *1 0,0
Ccc_a_d_inva_a_mn12_g0_mp13_g0_ro3_ro3_esc_e_ro3_esc_w_ro3_hop_sr3_d_stub_tg_d_a_y_g_vss_m1_inv_clk_vss_inv_mc_vss_inv_q_vss_mph_g_nand_m_vss_nand_s2_vss_s1_vss_m1_s2_vss_m1_s3_vss_m1_s4_vss_m1_sb_vss_sr1_vss_sr2_vss_sr3_vss_sr4_vss_sv_vss_tg_d_vss_tg_fbm_vss_tg_fbs_vss_tg_s_vss_vss_vss_link_vss_link_bridge_vss_link_dip_vss_link_m1_vss_x1_vss_x2_vss_x3
+ a|d|inva_a|mn12_g0|mp13_g0|ro3|ro3_esc_e|ro3_esc_w|ro3_hop|sr3_d_stub|tg_d_a|y
+ g_vss_m1|inv_clk_vss|inv_mc_vss|inv_q_vss|mph_g|nand_m_vss|nand_s2_vss|s1_vss_m1|s2_vss_m1|s3_vss_m1|s4_vss_m1|sb_vss|sr1_vss|sr2_vss|sr3_vss|sr4_vss|sv_vss|tg_d_vss|tg_fbm_vss|tg_fbs_vss|tg_s_vss|vss|vss_link|vss_link_bridge|vss_link_dip|vss_link_m1|vss_x1|vss_x2|vss_x3
+ 2.3895e-17
* device instance cc_a_d_sb_d_stub_tg_d_a_xo_xo_dip_xo_hop_xo_stub_y_a_inva_a_mn12_g0_mp13_g0_t1_y r0 *1 0,0
Ccc_a_d_sb_d_stub_tg_d_a_xo_xo_dip_xo_hop_xo_stub_y_a_inva_a_mn12_g0_mp13_g0_t1_y
+ a|d|sb_d_stub|tg_d_a|xo|xo_dip|xo_hop|xo_stub|y a|inva_a|mn12_g0|mp13_g0|t1|y
+ 1.1037e-17
* device instance cc_a_d_sb_d_stub_tg_d_a_xo_xo_dip_xo_hop_xo_stub_y_bn_invb_y_mn34_g1_mp24_g1_y r0 *1 0,0
Ccc_a_d_sb_d_stub_tg_d_a_xo_xo_dip_xo_hop_xo_stub_y_bn_invb_y_mn34_g1_mp24_g1_y
+ a|d|sb_d_stub|tg_d_a|xo|xo_dip|xo_hop|xo_stub|y bn|invb_y|mn34_g1|mp24_g1|y$2
+ 9.901e-18
* device instance cc_a_d_sb_d_stub_tg_d_a_xo_xo_dip_xo_hop_xo_stub_y_clkb_clkb_bridge1_clkb_bridge2_clkb_mid_clkb_w_ctrl_ctrlb_inv_clk_y_tg_d_ctrlb_tg_fbm_ctrl_tg_fbs_ctrlb_tg_s_ctrl_y r0 *1 0,0
Ccc_a_d_sb_d_stub_tg_d_a_xo_xo_dip_xo_hop_xo_stub_y_clkb_clkb_bridge1_clkb_bridge2_clkb_mid_clkb_w_ctrl_ctrlb_inv_clk_y_tg_d_ctrlb_tg_fbm_ctrl_tg_fbs_ctrlb_tg_s_ctrl_y
+ a|d|sb_d_stub|tg_d_a|xo|xo_dip|xo_hop|xo_stub|y
+ clkb|clkb_bridge1|clkb_bridge2|clkb_mid|clkb_w|ctrl|ctrlb|inv_clk_y|tg_d_ctrlb|tg_fbm_ctrl|tg_fbs_ctrlb|tg_s_ctrl|y$5
+ 8.337e-18
* device instance cc_a_d_sb_d_stub_tg_d_a_xo_xo_dip_xo_hop_xo_stub_y_mid r0 *1 0,0
Ccc_a_d_sb_d_stub_tg_d_a_xo_xo_dip_xo_hop_xo_stub_y_mid
+ a|d|sb_d_stub|tg_d_a|xo|xo_dip|xo_hop|xo_stub|y mid$2 8.154e-18
* device instance cc_a_g_a_rn1_ro_s4_y_y_a_g_y_mnab_y_mpa_y_mpb_y_n1_s1_a_y r0 *1 0,0
Ccc_a_g_a_rn1_ro_s4_y_y_a_g_y_mnab_y_mpa_y_mpb_y_n1_s1_a_y a|g_a|rn1|ro|s4_y|y
+ a|g_y|mnab_y|mpa_y|mpb_y|n1|s1_a|y$3 1.5977e-17
* device instance cc_a_g_a_rn1_ro_s4_y_y_g_vddr_m1_mnt_g_s1_vddr_m1_s2_vddr_m1_s3_vddr_m1_s4_vddr_m1_vddr_vddr1 r0 *1 0,0
Ccc_a_g_a_rn1_ro_s4_y_y_g_vddr_m1_mnt_g_s1_vddr_m1_s2_vddr_m1_s3_vddr_m1_s4_vddr_m1_vddr_vddr1
+ a|g_a|rn1|ro|s4_y|y
+ g_vddr_m1|mnt_g|s1_vddr_m1|s2_vddr_m1|s3_vddr_m1|s4_vddr_m1|vddr|vddr1
+ 1.5474e-17
* device instance cc_a_g_a_rn2_ro_s4_y_y_a_g_y_mnab_y_mpa_y_mpb_y_n1_s1_a_y r0 *1 0,0
Ccc_a_g_a_rn2_ro_s4_y_y_a_g_y_mnab_y_mpa_y_mpb_y_n1_s1_a_y a|g_a|rn2|ro|s4_y|y
+ a|g_y|mnab_y|mpa_y|mpb_y|n1|s1_a|y$3 1.5977e-17
* device instance cc_a_g_a_rn2_ro_s4_y_y_g_vddr_m1_mnt_g_s1_vddr_m1_s2_vddr_m1_s3_vddr_m1_s4_vddr_m1_vddr_vddr2 r0 *1 0,0
Ccc_a_g_a_rn2_ro_s4_y_y_g_vddr_m1_mnt_g_s1_vddr_m1_s2_vddr_m1_s3_vddr_m1_s4_vddr_m1_vddr_vddr2
+ a|g_a|rn2|ro|s4_y|y
+ g_vddr_m1|mnt_g|s1_vddr_m1|s2_vddr_m1|s3_vddr_m1|s4_vddr_m1|vddr|vddr2
+ 1.5474e-17
* device instance cc_a_g_a_rn3_ro_s4_y_y_a_g_y_mnab_y_mpa_y_mpb_y_n1_s1_a_y r0 *1 0,0
Ccc_a_g_a_rn3_ro_s4_y_y_a_g_y_mnab_y_mpa_y_mpb_y_n1_s1_a_y a|g_a|rn3|ro|s4_y|y
+ a|g_y|mnab_y|mpa_y|mpb_y|n1|s1_a|y$3 1.5977e-17
* device instance cc_a_g_a_rn3_ro_s4_y_y_g_vddr_m1_mnt_g_s1_vddr_m1_s2_vddr_m1_s3_vddr_m1_s4_vddr_m1_vddr_vddr3 r0 *1 0,0
Ccc_a_g_a_rn3_ro_s4_y_y_g_vddr_m1_mnt_g_s1_vddr_m1_s2_vddr_m1_s3_vddr_m1_s4_vddr_m1_vddr_vddr3
+ a|g_a|rn3|ro|s4_y|y
+ g_vddr_m1|mnt_g|s1_vddr_m1|s2_vddr_m1|s3_vddr_m1|s4_vddr_m1|vddr|vddr3
+ 1.5474e-17
* device instance cc_a_g_a_rn4_ro_s4_y_y_a_g_y_mnab_y_mpa_y_mpb_y_n1_s1_a_y r0 *1 0,0
Ccc_a_g_a_rn4_ro_s4_y_y_a_g_y_mnab_y_mpa_y_mpb_y_n1_s1_a_y a|g_a|rn4|ro|s4_y|y
+ a|g_y|mnab_y|mpa_y|mpb_y|n1|s1_a|y$3 1.5977e-17
* device instance cc_a_g_a_rn4_ro_s4_y_y_g_vddr_m1_mnt_g_s1_vddr_m1_s2_vddr_m1_s3_vddr_m1_s4_vddr_m1_vddr_vddr4 r0 *1 0,0
Ccc_a_g_a_rn4_ro_s4_y_y_g_vddr_m1_mnt_g_s1_vddr_m1_s2_vddr_m1_s3_vddr_m1_s4_vddr_m1_vddr_vddr4
+ a|g_a|rn4|ro|s4_y|y
+ g_vddr_m1|mnt_g|s1_vddr_m1|s2_vddr_m1|s3_vddr_m1|s4_vddr_m1|vddr|vddr4
+ 1.5474e-17
* device instance cc_a_g_a_rn4_ro_s4_y_y_g_vss_m1_inv_clk_vss_inv_mc_vss_inv_q_vss_mph_g_nand_m_vss_nand_s2_vss_s1_vss_m1_s2_vss_m1_s3_vss_m1_s4_vss_m1_sb_vss_sr1_vss_sr2_vss_sr3_vss_sr4_vss_sv_vss_tg_d_vss_tg_fbm_vss_tg_fbs_vss_tg_s_vss_vss_vss_link_vss_link_bridge_vss_link_dip_vss_link_m1_vss_x1_vss_x2_vss_x3 r0 *1 0,0
Ccc_a_g_a_rn4_ro_s4_y_y_g_vss_m1_inv_clk_vss_inv_mc_vss_inv_q_vss_mph_g_nand_m_vss_nand_s2_vss_s1_vss_m1_s2_vss_m1_s3_vss_m1_s4_vss_m1_sb_vss_sr1_vss_sr2_vss_sr3_vss_sr4_vss_sv_vss_tg_d_vss_tg_fbm_vss_tg_fbs_vss_tg_s_vss_vss_vss_link_vss_link_bridge_vss_link_dip_vss_link_m1_vss_x1_vss_x2_vss_x3
+ a|g_a|rn4|ro|s4_y|y
+ g_vss_m1|inv_clk_vss|inv_mc_vss|inv_q_vss|mph_g|nand_m_vss|nand_s2_vss|s1_vss_m1|s2_vss_m1|s3_vss_m1|s4_vss_m1|sb_vss|sr1_vss|sr2_vss|sr3_vss|sr4_vss|sv_vss|tg_d_vss|tg_fbm_vss|tg_fbs_vss|tg_s_vss|vss|vss_link|vss_link_bridge|vss_link_dip|vss_link_m1|vss_x1|vss_x2|vss_x3
+ 1.4912e-17
* device instance cc_a_g_y_mnab_y_mpa_y_mpb_y_n1_s1_a_y_g_vss_m1_inv_clk_vss_inv_mc_vss_inv_q_vss_mph_g_nand_m_vss_nand_s2_vss_s1_vss_m1_s2_vss_m1_s3_vss_m1_s4_vss_m1_sb_vss_sr1_vss_sr2_vss_sr3_vss_sr4_vss_sv_vss_tg_d_vss_tg_fbm_vss_tg_fbs_vss_tg_s_vss_vss_vss_link_vss_link_bridge_vss_link_dip_vss_link_m1_vss_x1_vss_x2_vss_x3 r0 *1 0,0
Ccc_a_g_y_mnab_y_mpa_y_mpb_y_n1_s1_a_y_g_vss_m1_inv_clk_vss_inv_mc_vss_inv_q_vss_mph_g_nand_m_vss_nand_s2_vss_s1_vss_m1_s2_vss_m1_s3_vss_m1_s4_vss_m1_sb_vss_sr1_vss_sr2_vss_sr3_vss_sr4_vss_sv_vss_tg_d_vss_tg_fbm_vss_tg_fbs_vss_tg_s_vss_vss_vss_link_vss_link_bridge_vss_link_dip_vss_link_m1_vss_x1_vss_x2_vss_x3
+ a|g_y|mnab_y|mpa_y|mpb_y|n1|s1_a|y$3
+ g_vss_m1|inv_clk_vss|inv_mc_vss|inv_q_vss|mph_g|nand_m_vss|nand_s2_vss|s1_vss_m1|s2_vss_m1|s3_vss_m1|s4_vss_m1|sb_vss|sr1_vss|sr2_vss|sr3_vss|sr4_vss|sv_vss|tg_d_vss|tg_fbm_vss|tg_fbs_vss|tg_s_vss|vss|vss_link|vss_link_bridge|vss_link_dip|vss_link_m1|vss_x1|vss_x2|vss_x3
+ 1.5474e-17
* device instance cc_a_g_y_mnab_y_mpa_y_mpb_y_n1_s1_a_y_ny r0 *1 0,0
Ccc_a_g_y_mnab_y_mpa_y_mpb_y_n1_s1_a_y_ny a|g_y|mnab_y|mpa_y|mpb_y|n1|s1_a|y$3
+ ny$19 1.1511e-17
* device instance cc_a_inv_mc_a_mb_mnab_y_mpa_y_mpb_y_nand_m_y_tg_s_a_y_a_inv_mc_y_inv_mc_y_via_mc_tg_fbm_a_tg_fbm_a_via_y r0 *1 0,0
Ccc_a_inv_mc_a_mb_mnab_y_mpa_y_mpb_y_nand_m_y_tg_s_a_y_a_inv_mc_y_inv_mc_y_via_mc_tg_fbm_a_tg_fbm_a_via_y
+ a|inv_mc_a|mb|mnab_y|mpa_y|mpb_y|nand_m_y|tg_s_a|y$5
+ a|inv_mc_y|inv_mc_y_via|mc|tg_fbm_a|tg_fbm_a_via|y$5 1.37451e-16
* device instance cc_a_inv_mc_a_mb_mnab_y_mpa_y_mpb_y_nand_m_y_tg_s_a_y_clkb_clkb_bridge1_clkb_bridge2_clkb_mid_clkb_w_ctrl_ctrlb_inv_clk_y_tg_d_ctrlb_tg_fbm_ctrl_tg_fbs_ctrlb_tg_s_ctrl_y r0 *1 0,0
Ccc_a_inv_mc_a_mb_mnab_y_mpa_y_mpb_y_nand_m_y_tg_s_a_y_clkb_clkb_bridge1_clkb_bridge2_clkb_mid_clkb_w_ctrl_ctrlb_inv_clk_y_tg_d_ctrlb_tg_fbm_ctrl_tg_fbs_ctrlb_tg_s_ctrl_y
+ a|inv_mc_a|mb|mnab_y|mpa_y|mpb_y|nand_m_y|tg_s_a|y$5
+ clkb|clkb_bridge1|clkb_bridge2|clkb_mid|clkb_w|ctrl|ctrlb|inv_clk_y|tg_d_ctrlb|tg_fbm_ctrl|tg_fbs_ctrlb|tg_s_ctrl|y$5
+ 7.6194e-17
* device instance cc_a_inv_mc_a_mb_mnab_y_mpa_y_mpb_y_nand_m_y_tg_s_a_y_en_nand_m_en_nand_m_en_via_nand_s2_en_nand_s2_en_via_rst_n r0 *1 0,0
Ccc_a_inv_mc_a_mb_mnab_y_mpa_y_mpb_y_nand_m_y_tg_s_a_y_en_nand_m_en_nand_m_en_via_nand_s2_en_nand_s2_en_via_rst_n
+ a|inv_mc_a|mb|mnab_y|mpa_y|mpb_y|nand_m_y|tg_s_a|y$5
+ en|nand_m_en|nand_m_en_via|nand_s2_en|nand_s2_en_via|rst_n 9.2845e-17
* device instance cc_a_inv_mc_y_inv_mc_y_via_mc_tg_fbm_a_tg_fbm_a_via_y_clkb_clkb_bridge1_clkb_bridge2_clkb_mid_clkb_w_ctrl_ctrlb_inv_clk_y_tg_d_ctrlb_tg_fbm_ctrl_tg_fbs_ctrlb_tg_s_ctrl_y r0 *1 0,0
Ccc_a_inv_mc_y_inv_mc_y_via_mc_tg_fbm_a_tg_fbm_a_via_y_clkb_clkb_bridge1_clkb_bridge2_clkb_mid_clkb_w_ctrl_ctrlb_inv_clk_y_tg_d_ctrlb_tg_fbm_ctrl_tg_fbs_ctrlb_tg_s_ctrl_y
+ a|inv_mc_y|inv_mc_y_via|mc|tg_fbm_a|tg_fbm_a_via|y$5
+ clkb|clkb_bridge1|clkb_bridge2|clkb_mid|clkb_w|ctrl|ctrlb|inv_clk_y|tg_d_ctrlb|tg_fbm_ctrl|tg_fbs_ctrlb|tg_s_ctrl|y$5
+ 1.23251e-16
* device instance cc_a_inv_q_y_inv_q_y_via_inv_q_y_via2_nand_s2_a_nand_s2_a_stub_nand_s2_a_via_nand_s2_a_via2_q_y_a_mnab_y_mpa_y_mpb_y_nand_s2_y_qb_tg_fbs_a_y r0 *1 0,0
Ccc_a_inv_q_y_inv_q_y_via_inv_q_y_via2_nand_s2_a_nand_s2_a_stub_nand_s2_a_via_nand_s2_a_via2_q_y_a_mnab_y_mpa_y_mpb_y_nand_s2_y_qb_tg_fbs_a_y
+ a|inv_q_y|inv_q_y_via|inv_q_y_via2|nand_s2_a|nand_s2_a_stub|nand_s2_a_via|nand_s2_a_via2|q|y$5
+ a|mnab_y|mpa_y|mpb_y|nand_s2_y|qb|tg_fbs_a|y$5 1.76851e-16
* device instance cc_a_inv_q_y_inv_q_y_via_inv_q_y_via2_nand_s2_a_nand_s2_a_stub_nand_s2_a_via_nand_s2_a_via2_q_y_clkb_clkb_bridge1_clkb_bridge2_clkb_mid_clkb_w_ctrl_ctrlb_inv_clk_y_tg_d_ctrlb_tg_fbm_ctrl_tg_fbs_ctrlb_tg_s_ctrl_y r0 *1 0,0
Ccc_a_inv_q_y_inv_q_y_via_inv_q_y_via2_nand_s2_a_nand_s2_a_stub_nand_s2_a_via_nand_s2_a_via2_q_y_clkb_clkb_bridge1_clkb_bridge2_clkb_mid_clkb_w_ctrl_ctrlb_inv_clk_y_tg_d_ctrlb_tg_fbm_ctrl_tg_fbs_ctrlb_tg_s_ctrl_y
+ a|inv_q_y|inv_q_y_via|inv_q_y_via2|nand_s2_a|nand_s2_a_stub|nand_s2_a_via|nand_s2_a_via2|q|y$5
+ clkb|clkb_bridge1|clkb_bridge2|clkb_mid|clkb_w|ctrl|ctrlb|inv_clk_y|tg_d_ctrlb|tg_fbm_ctrl|tg_fbs_ctrlb|tg_s_ctrl|y$5
+ 5.002e-17
* device instance cc_a_inva_a_mn12_g0_mp13_g0_t1_y_bn_invb_y_mn34_g1_mp24_g1_y r0 *1 0,0
Ccc_a_inva_a_mn12_g0_mp13_g0_t1_y_bn_invb_y_mn34_g1_mp24_g1_y
+ a|inva_a|mn12_g0|mp13_g0|t1|y bn|invb_y|mn34_g1|mp24_g1|y$2 9.901e-18
* device instance cc_a_inva_a_mn12_g0_mp13_g0_t1_y_g_vss_m1_inv_clk_vss_inv_mc_vss_inv_q_vss_mph_g_nand_m_vss_nand_s2_vss_s1_vss_m1_s2_vss_m1_s3_vss_m1_s4_vss_m1_sb_vss_sr1_vss_sr2_vss_sr3_vss_sr4_vss_sv_vss_tg_d_vss_tg_fbm_vss_tg_fbs_vss_tg_s_vss_vss_vss_link_vss_link_bridge_vss_link_dip_vss_link_m1_vss_x1_vss_x2_vss_x3 r0 *1 0,0
Ccc_a_inva_a_mn12_g0_mp13_g0_t1_y_g_vss_m1_inv_clk_vss_inv_mc_vss_inv_q_vss_mph_g_nand_m_vss_nand_s2_vss_s1_vss_m1_s2_vss_m1_s3_vss_m1_s4_vss_m1_sb_vss_sr1_vss_sr2_vss_sr3_vss_sr4_vss_sv_vss_tg_d_vss_tg_fbm_vss_tg_fbs_vss_tg_s_vss_vss_vss_link_vss_link_bridge_vss_link_dip_vss_link_m1_vss_x1_vss_x2_vss_x3
+ a|inva_a|mn12_g0|mp13_g0|t1|y
+ g_vss_m1|inv_clk_vss|inv_mc_vss|inv_q_vss|mph_g|nand_m_vss|nand_s2_vss|s1_vss_m1|s2_vss_m1|s3_vss_m1|s4_vss_m1|sb_vss|sr1_vss|sr2_vss|sr3_vss|sr4_vss|sv_vss|tg_d_vss|tg_fbm_vss|tg_fbs_vss|tg_s_vss|vss|vss_link|vss_link_bridge|vss_link_dip|vss_link_m1|vss_x1|vss_x2|vss_x3
+ 6.601e-18
* device instance cc_a_inva_a_mn12_g0_mp13_g0_t1_y_mid r0 *1 0,0
Ccc_a_inva_a_mn12_g0_mp13_g0_t1_y_mid a|inva_a|mn12_g0|mp13_g0|t1|y mid$2
+ 3.3e-18
* device instance cc_a_mnab_y_mpa_y_mpb_y_nand_s2_y_qb_tg_fbs_a_y_clkb_clkb_bridge1_clkb_bridge2_clkb_mid_clkb_w_ctrl_ctrlb_inv_clk_y_tg_d_ctrlb_tg_fbm_ctrl_tg_fbs_ctrlb_tg_s_ctrl_y r0 *1 0,0
Ccc_a_mnab_y_mpa_y_mpb_y_nand_s2_y_qb_tg_fbs_a_y_clkb_clkb_bridge1_clkb_bridge2_clkb_mid_clkb_w_ctrl_ctrlb_inv_clk_y_tg_d_ctrlb_tg_fbm_ctrl_tg_fbs_ctrlb_tg_s_ctrl_y
+ a|mnab_y|mpa_y|mpb_y|nand_s2_y|qb|tg_fbs_a|y$5
+ clkb|clkb_bridge1|clkb_bridge2|clkb_mid|clkb_w|ctrl|ctrlb|inv_clk_y|tg_d_ctrlb|tg_fbm_ctrl|tg_fbs_ctrlb|tg_s_ctrl|y$5
+ 4.8089e-17
* device instance cc_a_n2_s1_y_s2_a_y_g_vss_m1_inv_clk_vss_inv_mc_vss_inv_q_vss_mph_g_nand_m_vss_nand_s2_vss_s1_vss_m1_s2_vss_m1_s3_vss_m1_s4_vss_m1_sb_vss_sr1_vss_sr2_vss_sr3_vss_sr4_vss_sv_vss_tg_d_vss_tg_fbm_vss_tg_fbs_vss_tg_s_vss_vss_vss_link_vss_link_bridge_vss_link_dip_vss_link_m1_vss_x1_vss_x2_vss_x3 r0 *1 0,0
Ccc_a_n2_s1_y_s2_a_y_g_vss_m1_inv_clk_vss_inv_mc_vss_inv_q_vss_mph_g_nand_m_vss_nand_s2_vss_s1_vss_m1_s2_vss_m1_s3_vss_m1_s4_vss_m1_sb_vss_sr1_vss_sr2_vss_sr3_vss_sr4_vss_sv_vss_tg_d_vss_tg_fbm_vss_tg_fbs_vss_tg_s_vss_vss_vss_link_vss_link_bridge_vss_link_dip_vss_link_m1_vss_x1_vss_x2_vss_x3
+ a|n2|s1_y|s2_a|y$3
+ g_vss_m1|inv_clk_vss|inv_mc_vss|inv_q_vss|mph_g|nand_m_vss|nand_s2_vss|s1_vss_m1|s2_vss_m1|s3_vss_m1|s4_vss_m1|sb_vss|sr1_vss|sr2_vss|sr3_vss|sr4_vss|sv_vss|tg_d_vss|tg_fbm_vss|tg_fbs_vss|tg_s_vss|vss|vss_link|vss_link_bridge|vss_link_dip|vss_link_m1|vss_x1|vss_x2|vss_x3
+ 1.5474e-17
* device instance cc_a_n2_s1_y_s2_a_y_ny r0 *1 0,0
Ccc_a_n2_s1_y_s2_a_y_ny a|n2|s1_y|s2_a|y$3 ny$19 1.1511e-17
* device instance cc_a_n3_s2_y_s3_a_y_g_vss_m1_inv_clk_vss_inv_mc_vss_inv_q_vss_mph_g_nand_m_vss_nand_s2_vss_s1_vss_m1_s2_vss_m1_s3_vss_m1_s4_vss_m1_sb_vss_sr1_vss_sr2_vss_sr3_vss_sr4_vss_sv_vss_tg_d_vss_tg_fbm_vss_tg_fbs_vss_tg_s_vss_vss_vss_link_vss_link_bridge_vss_link_dip_vss_link_m1_vss_x1_vss_x2_vss_x3 r0 *1 0,0
Ccc_a_n3_s2_y_s3_a_y_g_vss_m1_inv_clk_vss_inv_mc_vss_inv_q_vss_mph_g_nand_m_vss_nand_s2_vss_s1_vss_m1_s2_vss_m1_s3_vss_m1_s4_vss_m1_sb_vss_sr1_vss_sr2_vss_sr3_vss_sr4_vss_sv_vss_tg_d_vss_tg_fbm_vss_tg_fbs_vss_tg_s_vss_vss_vss_link_vss_link_bridge_vss_link_dip_vss_link_m1_vss_x1_vss_x2_vss_x3
+ a|n3|s2_y|s3_a|y$3
+ g_vss_m1|inv_clk_vss|inv_mc_vss|inv_q_vss|mph_g|nand_m_vss|nand_s2_vss|s1_vss_m1|s2_vss_m1|s3_vss_m1|s4_vss_m1|sb_vss|sr1_vss|sr2_vss|sr3_vss|sr4_vss|sv_vss|tg_d_vss|tg_fbm_vss|tg_fbs_vss|tg_s_vss|vss|vss_link|vss_link_bridge|vss_link_dip|vss_link_m1|vss_x1|vss_x2|vss_x3
+ 1.5474e-17
* device instance cc_a_n3_s2_y_s3_a_y_ny r0 *1 0,0
Ccc_a_n3_s2_y_s3_a_y_ny a|n3|s2_y|s3_a|y$3 ny$19 1.1511e-17
* device instance cc_a_n4_s3_y_s4_a_y_g_vss_m1_inv_clk_vss_inv_mc_vss_inv_q_vss_mph_g_nand_m_vss_nand_s2_vss_s1_vss_m1_s2_vss_m1_s3_vss_m1_s4_vss_m1_sb_vss_sr1_vss_sr2_vss_sr3_vss_sr4_vss_sv_vss_tg_d_vss_tg_fbm_vss_tg_fbs_vss_tg_s_vss_vss_vss_link_vss_link_bridge_vss_link_dip_vss_link_m1_vss_x1_vss_x2_vss_x3 r0 *1 0,0
Ccc_a_n4_s3_y_s4_a_y_g_vss_m1_inv_clk_vss_inv_mc_vss_inv_q_vss_mph_g_nand_m_vss_nand_s2_vss_s1_vss_m1_s2_vss_m1_s3_vss_m1_s4_vss_m1_sb_vss_sr1_vss_sr2_vss_sr3_vss_sr4_vss_sv_vss_tg_d_vss_tg_fbm_vss_tg_fbs_vss_tg_s_vss_vss_vss_link_vss_link_bridge_vss_link_dip_vss_link_m1_vss_x1_vss_x2_vss_x3
+ a|n4|s3_y|s4_a|y$3
+ g_vss_m1|inv_clk_vss|inv_mc_vss|inv_q_vss|mph_g|nand_m_vss|nand_s2_vss|s1_vss_m1|s2_vss_m1|s3_vss_m1|s4_vss_m1|sb_vss|sr1_vss|sr2_vss|sr3_vss|sr4_vss|sv_vss|tg_d_vss|tg_fbm_vss|tg_fbs_vss|tg_s_vss|vss|vss_link|vss_link_bridge|vss_link_dip|vss_link_m1|vss_x1|vss_x2|vss_x3
+ 1.5474e-17
* device instance cc_a_n4_s3_y_s4_a_y_ny r0 *1 0,0
Ccc_a_n4_s3_y_s4_a_y_ny a|n4|s3_y|s4_a|y$3 ny$19 1.1511e-17
* device instance cc_bn_invb_y_mn34_g1_mp24_g1_y_mid r0 *1 0,0
Ccc_bn_invb_y_mn34_g1_mp24_g1_y_mid bn|invb_y|mn34_g1|mp24_g1|y$2 mid$2
+ 9.901e-18
* device instance cc_clkb_clkb_bridge1_clkb_bridge2_clkb_mid_clkb_w_ctrl_ctrlb_inv_clk_y_tg_d_ctrlb_tg_fbm_ctrl_tg_fbs_ctrlb_tg_s_ctrl_y_en_nand_m_en_nand_m_en_via_nand_s2_en_nand_s2_en_via_rst_n r0 *1 0,0
Ccc_clkb_clkb_bridge1_clkb_bridge2_clkb_mid_clkb_w_ctrl_ctrlb_inv_clk_y_tg_d_ctrlb_tg_fbm_ctrl_tg_fbs_ctrlb_tg_s_ctrl_y_en_nand_m_en_nand_m_en_via_nand_s2_en_nand_s2_en_via_rst_n
+ clkb|clkb_bridge1|clkb_bridge2|clkb_mid|clkb_w|ctrl|ctrlb|inv_clk_y|tg_d_ctrlb|tg_fbm_ctrl|tg_fbs_ctrlb|tg_s_ctrl|y$5
+ en|nand_m_en|nand_m_en_via|nand_s2_en|nand_s2_en_via|rst_n 1.83763e-16
* device instance cc_clkb_clkb_bridge1_clkb_bridge2_clkb_mid_clkb_w_ctrl_ctrlb_inv_clk_y_tg_d_ctrlb_tg_fbm_ctrl_tg_fbs_ctrlb_tg_s_ctrl_y_g_vss_m1_inv_clk_vss_inv_mc_vss_inv_q_vss_mph_g_nand_m_vss_nand_s2_vss_s1_vss_m1_s2_vss_m1_s3_vss_m1_s4_vss_m1_sb_vss_sr1_vss_sr2_vss_sr3_vss_sr4_vss_sv_vss_tg_d_vss_tg_fbm_vss_tg_fbs_vss_tg_s_vss_vss_vss_link_vss_link_bridge_vss_link_dip_vss_link_m1_vss_x1_vss_x2_vss_x3 r0 *1 0,0
Ccc_clkb_clkb_bridge1_clkb_bridge2_clkb_mid_clkb_w_ctrl_ctrlb_inv_clk_y_tg_d_ctrlb_tg_fbm_ctrl_tg_fbs_ctrlb_tg_s_ctrl_y_g_vss_m1_inv_clk_vss_inv_mc_vss_inv_q_vss_mph_g_nand_m_vss_nand_s2_vss_s1_vss_m1_s2_vss_m1_s3_vss_m1_s4_vss_m1_sb_vss_sr1_vss_sr2_vss_sr3_vss_sr4_vss_sv_vss_tg_d_vss_tg_fbm_vss_tg_fbs_vss_tg_s_vss_vss_vss_link_vss_link_bridge_vss_link_dip_vss_link_m1_vss_x1_vss_x2_vss_x3
+ clkb|clkb_bridge1|clkb_bridge2|clkb_mid|clkb_w|ctrl|ctrlb|inv_clk_y|tg_d_ctrlb|tg_fbm_ctrl|tg_fbs_ctrlb|tg_s_ctrl|y$5
+ g_vss_m1|inv_clk_vss|inv_mc_vss|inv_q_vss|mph_g|nand_m_vss|nand_s2_vss|s1_vss_m1|s2_vss_m1|s3_vss_m1|s4_vss_m1|sb_vss|sr1_vss|sr2_vss|sr3_vss|sr4_vss|sv_vss|tg_d_vss|tg_fbm_vss|tg_fbs_vss|tg_s_vss|vss|vss_link|vss_link_bridge|vss_link_dip|vss_link_m1|vss_x1|vss_x2|vss_x3
+ 6.13699e-16
* device instance cc_en_nand_m_en_nand_m_en_via_nand_s2_en_nand_s2_en_via_rst_n_g_vss_m1_inv_clk_vss_inv_mc_vss_inv_q_vss_mph_g_nand_m_vss_nand_s2_vss_s1_vss_m1_s2_vss_m1_s3_vss_m1_s4_vss_m1_sb_vss_sr1_vss_sr2_vss_sr3_vss_sr4_vss_sv_vss_tg_d_vss_tg_fbm_vss_tg_fbs_vss_tg_s_vss_vss_vss_link_vss_link_bridge_vss_link_dip_vss_link_m1_vss_x1_vss_x2_vss_x3 r0 *1 0,0
Ccc_en_nand_m_en_nand_m_en_via_nand_s2_en_nand_s2_en_via_rst_n_g_vss_m1_inv_clk_vss_inv_mc_vss_inv_q_vss_mph_g_nand_m_vss_nand_s2_vss_s1_vss_m1_s2_vss_m1_s3_vss_m1_s4_vss_m1_sb_vss_sr1_vss_sr2_vss_sr3_vss_sr4_vss_sv_vss_tg_d_vss_tg_fbm_vss_tg_fbs_vss_tg_s_vss_vss_vss_link_vss_link_bridge_vss_link_dip_vss_link_m1_vss_x1_vss_x2_vss_x3
+ en|nand_m_en|nand_m_en_via|nand_s2_en|nand_s2_en_via|rst_n
+ g_vss_m1|inv_clk_vss|inv_mc_vss|inv_q_vss|mph_g|nand_m_vss|nand_s2_vss|s1_vss_m1|s2_vss_m1|s3_vss_m1|s4_vss_m1|sb_vss|sr1_vss|sr2_vss|sr3_vss|sr4_vss|sv_vss|tg_d_vss|tg_fbm_vss|tg_fbs_vss|tg_s_vss|vss|vss_link|vss_link_bridge|vss_link_dip|vss_link_m1|vss_x1|vss_x2|vss_x3
+ 3.869e-18
* device instance cc_g_vddr_m1_mnt_g_s1_vddr_m1_s2_vddr_m1_s3_vddr_m1_s4_vddr_m1_vddr_vddr1_py r0 *1 0,0
Ccc_g_vddr_m1_mnt_g_s1_vddr_m1_s2_vddr_m1_s3_vddr_m1_s4_vddr_m1_vddr_vddr1_py
+ g_vddr_m1|mnt_g|s1_vddr_m1|s2_vddr_m1|s3_vddr_m1|s4_vddr_m1|vddr|vddr1 py$15
+ 1.2471e-17
* device instance cc_g_vddr_m1_mnt_g_s1_vddr_m1_s2_vddr_m1_s3_vddr_m1_s4_vddr_m1_vddr_vddr2_py r0 *1 0,0
Ccc_g_vddr_m1_mnt_g_s1_vddr_m1_s2_vddr_m1_s3_vddr_m1_s4_vddr_m1_vddr_vddr2_py
+ g_vddr_m1|mnt_g|s1_vddr_m1|s2_vddr_m1|s3_vddr_m1|s4_vddr_m1|vddr|vddr2 py$15
+ 1.3064e-17
* device instance cc_g_vddr_m1_mnt_g_s1_vddr_m1_s2_vddr_m1_s3_vddr_m1_s4_vddr_m1_vddr_vddr3_py r0 *1 0,0
Ccc_g_vddr_m1_mnt_g_s1_vddr_m1_s2_vddr_m1_s3_vddr_m1_s4_vddr_m1_vddr_vddr3_py
+ g_vddr_m1|mnt_g|s1_vddr_m1|s2_vddr_m1|s3_vddr_m1|s4_vddr_m1|vddr|vddr3 py$15
+ 1.3658e-17
* device instance cc_g_vddr_m1_mnt_g_s1_vddr_m1_s2_vddr_m1_s3_vddr_m1_s4_vddr_m1_vddr_vddr4_py r0 *1 0,0
Ccc_g_vddr_m1_mnt_g_s1_vddr_m1_s2_vddr_m1_s3_vddr_m1_s4_vddr_m1_vddr_vddr4_py
+ g_vddr_m1|mnt_g|s1_vddr_m1|s2_vddr_m1|s3_vddr_m1|s4_vddr_m1|vddr|vddr4 py$15
+ 1.4252e-17
* device instance vsubs_dctie r0 *1 0,0
Rvsubs_dctie vsubs 0 1e+12
.ENDS sampler_core
