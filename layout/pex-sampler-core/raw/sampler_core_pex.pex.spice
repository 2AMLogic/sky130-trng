* extracted by klt extract --deck sky130
* parasitic model (--parasitics):
* - capacitance: net-to-ground for every net's own (non-coupled) area/perimeter, plus net-to-net for the vertical-overlap coupling `coupling` describes below -- a coupled net pair gets a direct capacitor between their two hub nodes, not just capacitors to the deck's ground/substrate net
* - coupling: vertical overlap (crossover) unconditionally -- where one net's conductor on an adjacent metal level sits directly over another *distinct* net's conductor, that overlap area is charged between the two nets instead of to ground (issue #760) -- plus lateral (same-layer, sidewall) coupling, but only for a net pair naming one of the caller's declared `--critical-net` nets (issue #976): facing-edge length within that layer's own minimum-spacing lookback is charged between the two nets, *additively* (not deducted from either net's substrate fringe term, unlike the vertical case -- a known simplification). Any same-layer pair with neither side named `--critical-net`, and fringe shielding in general, are still not modelled
* - resistance: single lumped series resistance per net, distributed as a star across that net's device terminals (issue #592) -- not a per-segment, distributed RC ladder, *unless* `--distributed-rc` names this net via `--critical-net` (issue #977, Epic #709 Phase 2b): then the net's terminals are ordered along their approximate physical spread and its total R/C is broken into a chain of per-segment resistors (segment length proportional to inter-terminal distance) with a ground capacitor at each terminal node (proportional to its adjacent segment length/2), instead of one star hub -- still an approximation (terminal position is a device-placement proxy, not true per-segment routing geometry), but a strictly finer-grained one than the single-hub star
* - frequency: quasi-static -- one frequency-independent R and C per net; no skin effect, no distributed transmission-line behavior
* - substrate tie: 1e+12 ohm to ground -- the substrate is capacitively floating in transient analysis (DC reference only); see --substrate-tie-ohms
.GLOBAL vsubs

* cell sampler_core
* pin a,b,b3,invb_a,mn12_g1,mp24_g0,t2,y
* pin a,b,d,invb_a,mn12_g1,mp24_g0,ro2,ro2_esc,sr2_d_stub,tg_d_a,y
* pin a,b,d,invb_a,mn12_g1,mp24_g0,ro4,ro4_esc,sr4_d_stub,tg_d_a,y
* pin a,b,inv_q_a,inv_q_a_via,s,tg_fbs_b,tg_fbs_b_via,tg_s_b,tg_s_b_via
* pin a,b,inv_q_a,inv_q_a_via,s,tg_fbs_b,tg_fbs_b_via,tg_s_b,tg_s_b_via
* pin a,b,inv_q_a,inv_q_a_via,s,tg_fbs_b,tg_fbs_b_via,tg_s_b,tg_s_b_via
* pin a,b,inv_q_a,inv_q_a_via,s,tg_fbs_b,tg_fbs_b_via,tg_s_b,tg_s_b_via
* pin a,b,inv_q_a,inv_q_a_via,s,tg_fbs_b,tg_fbs_b_via,tg_s_b,tg_s_b_via
* pin a,b,inv_q_a,inv_q_a_via,s,tg_fbs_b,tg_fbs_b_via,tg_s_b,tg_s_b_via
* pin a,b,m_east,m_west,nand_m_a,nand_m_a_ext_via,nand_m_a_ext_via2,nand_m_a_stub,tg_d_b,tg_d_b_via,tg_d_b_via2,tg_fbm_b,tg_fbm_b_alt_via,tg_fbm_b_alt_via2
* pin a,b,m_east,m_west,nand_m_a,nand_m_a_ext_via,nand_m_a_ext_via2,nand_m_a_stub,tg_d_b,tg_d_b_via,tg_d_b_via2,tg_fbm_b,tg_fbm_b_alt_via,tg_fbm_b_alt_via2
* pin a,b,m_east,m_west,nand_m_a,nand_m_a_ext_via,nand_m_a_ext_via2,nand_m_a_stub,tg_d_b,tg_d_b_via,tg_d_b_via2,tg_fbm_b,tg_fbm_b_alt_via,tg_fbm_b_alt_via2
* pin a,b,m_east,m_west,nand_m_a,nand_m_a_ext_via,nand_m_a_ext_via2,nand_m_a_stub,tg_d_b,tg_d_b_via,tg_d_b_via2,tg_fbm_b,tg_fbm_b_alt_via,tg_fbm_b_alt_via2
* pin a,b,m_east,m_west,nand_m_a,nand_m_a_ext_via,nand_m_a_ext_via2,nand_m_a_stub,tg_d_b,tg_d_b_via,tg_d_b_via2,tg_fbm_b,tg_fbm_b_alt_via,tg_fbm_b_alt_via2
* pin a,b,m_east,m_west,nand_m_a,nand_m_a_ext_via,nand_m_a_ext_via2,nand_m_a_stub,tg_d_b,tg_d_b_via,tg_d_b_via2,tg_fbm_b,tg_fbm_b_alt_via,tg_fbm_b_alt_via2
* pin a,clk,ctrl,ctrlb,inv_clk_a,inv_clk_clk_via,tg_d_ctrl,tg_d_ctrl_via,tg_fbm_ctrlb,tg_fbm_ctrlb_via,tg_fbs_ctrl,tg_fbs_ctrl_via,tg_s_ctrlb,tg_s_ctrlb_via
* pin a,d,inv_clk_vdd,inv_mc_vdd,inv_q_vdd,mpa_py,mpb_py,nand_m_vdd,nand_s2_vdd,nwell_vdd,sb_vdd,sr1_vdd,sr2_vdd,sr3_vdd,sr4_vdd,sv_d_vdd_tie,sv_vdd,tg_d_a,tg_d_vdd,tg_fbm_vdd,tg_fbs_vdd,tg_s_vdd,vdd,vdd_b1,vdd_b2,vdd_b3,vdd_b4,vdd_link,vdd_link_dip,vdd_x1,vdd_x2,vdd_x3
* pin a,d,inva_a,mn12_g0,mp13_g0,ro1,ro1_esc,sr1_d_stub,tg_d_a,y
* pin a,d,inva_a,mn12_g0,mp13_g0,ro3,ro3_esc_e,ro3_esc_w,ro3_hop,sr3_d_stub,tg_d_a,y
* pin a,d,sb_d_stub,tg_d_a,xo,xo_dip,xo_hop,xo_stub,y
* pin a,g_a,rn1,ro,s4_y,y
* pin a,g_a,rn2,ro,s4_y,y
* pin a,g_a,rn3,ro,s4_y,y
* pin a,g_a,rn4,ro,s4_y,y
* pin a,g_y,mnab_y,mpa_y,mpb_y,n1,s1_a,y
* pin a,g_y,mnab_y,mpa_y,mpb_y,n1,s1_a,y
* pin a,g_y,mnab_y,mpa_y,mpb_y,n1,s1_a,y
* pin a,g_y,mnab_y,mpa_y,mpb_y,n1,s1_a,y
* pin a,inv_mc_a,mb,mnab_y,mpa_y,mpb_y,nand_m_y,tg_s_a,y
* pin a,inv_mc_a,mb,mnab_y,mpa_y,mpb_y,nand_m_y,tg_s_a,y
* pin a,inv_mc_a,mb,mnab_y,mpa_y,mpb_y,nand_m_y,tg_s_a,y
* pin a,inv_mc_a,mb,mnab_y,mpa_y,mpb_y,nand_m_y,tg_s_a,y
* pin a,inv_mc_a,mb,mnab_y,mpa_y,mpb_y,nand_m_y,tg_s_a,y
* pin a,inv_mc_a,mb,mnab_y,mpa_y,mpb_y,nand_m_y,tg_s_a,y
* pin a,inv_mc_y,inv_mc_y_via,mc,tg_fbm_a,tg_fbm_a_via,y
* pin a,inv_mc_y,inv_mc_y_via,mc,tg_fbm_a,tg_fbm_a_via,y
* pin a,inv_mc_y,inv_mc_y_via,mc,tg_fbm_a,tg_fbm_a_via,y
* pin a,inv_mc_y,inv_mc_y_via,mc,tg_fbm_a,tg_fbm_a_via,y
* pin a,inv_mc_y,inv_mc_y_via,mc,tg_fbm_a,tg_fbm_a_via,y
* pin a,inv_mc_y,inv_mc_y_via,mc,tg_fbm_a,tg_fbm_a_via,y
* pin a,inv_q_y,inv_q_y_via,inv_q_y_via2,nand_s2_a,nand_s2_a_stub,nand_s2_a_via,nand_s2_a_via2,q,y
* pin a,inv_q_y,inv_q_y_via,inv_q_y_via2,nand_s2_a,nand_s2_a_stub,nand_s2_a_via,nand_s2_a_via2,q,y
* pin a,inv_q_y,inv_q_y_via,inv_q_y_via2,nand_s2_a,nand_s2_a_stub,nand_s2_a_via,nand_s2_a_via2,q,y
* pin a,inv_q_y,inv_q_y_via,inv_q_y_via2,nand_s2_a,nand_s2_a_stub,nand_s2_a_via,nand_s2_a_via2,q,y
* pin a,inv_q_y,inv_q_y_via,inv_q_y_via2,nand_s2_a,nand_s2_a_stub,nand_s2_a_via,nand_s2_a_via2,q,y
* pin a,inv_q_y,inv_q_y_via,inv_q_y_via2,nand_s2_a,nand_s2_a_stub,nand_s2_a_via,nand_s2_a_via2,q,y
* pin a,inva_a,mn12_g0,mp13_g0,t1,y
* pin a,mnab_y,mpa_y,mpb_y,nand_s2_y,qb,tg_fbs_a,y
* pin a,mnab_y,mpa_y,mpb_y,nand_s2_y,qb,tg_fbs_a,y
* pin a,mnab_y,mpa_y,mpb_y,nand_s2_y,qb,tg_fbs_a,y
* pin a,mnab_y,mpa_y,mpb_y,nand_s2_y,qb,tg_fbs_a,y
* pin a,mnab_y,mpa_y,mpb_y,nand_s2_y,qb,tg_fbs_a,y
* pin a,mnab_y,mpa_y,mpb_y,nand_s2_y,qb,tg_fbs_a,y
* pin a,n2,s1_y,s2_a,y
* pin a,n2,s1_y,s2_a,y
* pin a,n2,s1_y,s2_a,y
* pin a,n2,s1_y,s2_a,y
* pin a,n3,s2_y,s3_a,y
* pin a,n3,s2_y,s3_a,y
* pin a,n3,s2_y,s3_a,y
* pin a,n3,s2_y,s3_a,y
* pin a,n4,s3_y,s4_a,y
* pin a,n4,s3_y,s4_a,y
* pin a,n4,s3_y,s4_a,y
* pin a,n4,s3_y,s4_a,y
* pin an,inva_y,mn34_g0,mp13_g1,y
* pin an,inva_y,mn34_g0,mp13_g1,y
* pin an,inva_y,mn34_g0,mp13_g1,y
* pin bn,invb_y,mn34_g1,mp24_g1,y
* pin bn,invb_y,mn34_g1,mp24_g1,y
* pin bn,invb_y,mn34_g1,mp24_g1,y
* pin clkb,clkb_bridge1,clkb_bridge2,clkb_mid,clkb_w,ctrl,ctrlb,inv_clk_y,tg_d_ctrlb,tg_fbm_ctrl,tg_fbs_ctrlb,tg_s_ctrl,y
* pin clkb,clkb_bridge1,clkb_bridge2,clkb_mid,clkb_w,ctrl,ctrlb,inv_clk_y,tg_d_ctrlb,tg_fbm_ctrl,tg_fbs_ctrlb,tg_s_ctrl,y
* pin clkb,clkb_bridge1,clkb_bridge2,clkb_mid,clkb_w,ctrl,ctrlb,inv_clk_y,tg_d_ctrlb,tg_fbm_ctrl,tg_fbs_ctrlb,tg_s_ctrl,y
* pin clkb,clkb_bridge1,clkb_bridge2,clkb_mid,clkb_w,ctrl,ctrlb,inv_clk_y,tg_d_ctrlb,tg_fbm_ctrl,tg_fbs_ctrlb,tg_s_ctrl,y
* pin clkb,clkb_bridge1,clkb_bridge2,clkb_mid,clkb_w,ctrl,ctrlb,inv_clk_y,tg_d_ctrlb,tg_fbm_ctrl,tg_fbs_ctrlb,tg_s_ctrl,y
* pin clkb,clkb_bridge1,clkb_bridge2,clkb_mid,clkb_w,ctrl,ctrlb,inv_clk_y,tg_d_ctrlb,tg_fbm_ctrl,tg_fbs_ctrlb,tg_s_ctrl,y
* pin en,en1,g_en
* pin en,en2,g_en
* pin en,en3,g_en
* pin en,en4,g_en
* pin en,nand_m_en,nand_m_en_via,nand_s2_en,nand_s2_en_via,rst_n
* pin g_vddr_m1,mnt_g,s1_vddr_m1,s2_vddr_m1,s3_vddr_m1,s4_vddr_m1,vddr,vddr1
* pin g_vddr_m1,mnt_g,s1_vddr_m1,s2_vddr_m1,s3_vddr_m1,s4_vddr_m1,vddr,vddr2
* pin g_vddr_m1,mnt_g,s1_vddr_m1,s2_vddr_m1,s3_vddr_m1,s4_vddr_m1,vddr,vddr3
* pin g_vddr_m1,mnt_g,s1_vddr_m1,s2_vddr_m1,s3_vddr_m1,s4_vddr_m1,vddr,vddr4
* pin g_vss_m1,inv_clk_vss,inv_mc_vss,inv_q_vss,mph_g,nand_m_vss,nand_s2_vss,s1_vss_m1,s2_vss_m1,s3_vss_m1,s4_vss_m1,sb_vss,sr1_vss,sr2_vss,sr3_vss,sr4_vss,sv_vss,tg_d_vss,tg_fbm_vss,tg_fbs_vss,tg_s_vss,vss,vss_link,vss_link_bridge,vss_link_dip,vss_link_m1,vss_x1,vss_x2,vss_x3
* pin mid
* pin mid
* pin mid
* pin mpa_py,mpb_py,mph_py,py
* pin mpa_py,mpb_py,mph_py,py
* pin mpa_py,mpb_py,mph_py,py
* pin mpa_py,mpb_py,mph_py,py
* pin ny
* pin ny
* pin ny
* pin ny
* pin ny
* pin ny
* pin ny
* pin ny
* pin ny
* pin ny
* pin ny
* pin ny
* pin ny
* pin ny
* pin ny
* pin ny
* pin ny
* pin ny
* pin ny
* pin ny
* pin py
* pin py
* pin py
* pin py
* pin py
* pin py
* pin py
* pin py
* pin py
* pin py
* pin py
* pin py
* pin py
* pin py
* pin py
* pin py
.SUBCKT sampler_core a|b|b3|invb_a|mn12_g1|mp24_g0|t2|y
+ a|b|d|invb_a|mn12_g1|mp24_g0|ro2|ro2_esc|sr2_d_stub|tg_d_a|y
+ a|b|d|invb_a|mn12_g1|mp24_g0|ro4|ro4_esc|sr4_d_stub|tg_d_a|y
+ a|b|inv_q_a|inv_q_a_via|s|tg_fbs_b|tg_fbs_b_via|tg_s_b|tg_s_b_via
+ a|b|inv_q_a|inv_q_a_via|s|tg_fbs_b|tg_fbs_b_via|tg_s_b|tg_s_b_via$1
+ a|b|inv_q_a|inv_q_a_via|s|tg_fbs_b|tg_fbs_b_via|tg_s_b|tg_s_b_via$2
+ a|b|inv_q_a|inv_q_a_via|s|tg_fbs_b|tg_fbs_b_via|tg_s_b|tg_s_b_via$3
+ a|b|inv_q_a|inv_q_a_via|s|tg_fbs_b|tg_fbs_b_via|tg_s_b|tg_s_b_via$4
+ a|b|inv_q_a|inv_q_a_via|s|tg_fbs_b|tg_fbs_b_via|tg_s_b|tg_s_b_via$5
+ a|b|m_east|m_west|nand_m_a|nand_m_a_ext_via|nand_m_a_ext_via2|nand_m_a_stub|tg_d_b|tg_d_b_via|tg_d_b_via2|tg_fbm_b|tg_fbm_b_alt_via|tg_fbm_b_alt_via2
+ a|b|m_east|m_west|nand_m_a|nand_m_a_ext_via|nand_m_a_ext_via2|nand_m_a_stub|tg_d_b|tg_d_b_via|tg_d_b_via2|tg_fbm_b|tg_fbm_b_alt_via|tg_fbm_b_alt_via2$1
+ a|b|m_east|m_west|nand_m_a|nand_m_a_ext_via|nand_m_a_ext_via2|nand_m_a_stub|tg_d_b|tg_d_b_via|tg_d_b_via2|tg_fbm_b|tg_fbm_b_alt_via|tg_fbm_b_alt_via2$2
+ a|b|m_east|m_west|nand_m_a|nand_m_a_ext_via|nand_m_a_ext_via2|nand_m_a_stub|tg_d_b|tg_d_b_via|tg_d_b_via2|tg_fbm_b|tg_fbm_b_alt_via|tg_fbm_b_alt_via2$3
+ a|b|m_east|m_west|nand_m_a|nand_m_a_ext_via|nand_m_a_ext_via2|nand_m_a_stub|tg_d_b|tg_d_b_via|tg_d_b_via2|tg_fbm_b|tg_fbm_b_alt_via|tg_fbm_b_alt_via2$4
+ a|b|m_east|m_west|nand_m_a|nand_m_a_ext_via|nand_m_a_ext_via2|nand_m_a_stub|tg_d_b|tg_d_b_via|tg_d_b_via2|tg_fbm_b|tg_fbm_b_alt_via|tg_fbm_b_alt_via2$5
+ a|clk|ctrl|ctrlb|inv_clk_a|inv_clk_clk_via|tg_d_ctrl|tg_d_ctrl_via|tg_fbm_ctrlb|tg_fbm_ctrlb_via|tg_fbs_ctrl|tg_fbs_ctrl_via|tg_s_ctrlb|tg_s_ctrlb_via
+ a|d|inv_clk_vdd|inv_mc_vdd|inv_q_vdd|mpa_py|mpb_py|nand_m_vdd|nand_s2_vdd|nwell_vdd|sb_vdd|sr1_vdd|sr2_vdd|sr3_vdd|sr4_vdd|sv_d_vdd_tie|sv_vdd|tg_d_a|tg_d_vdd|tg_fbm_vdd|tg_fbs_vdd|tg_s_vdd|vdd|vdd_b1|vdd_b2|vdd_b3|vdd_b4|vdd_link|vdd_link_dip|vdd_x1|vdd_x2|vdd_x3
+ a|d|inva_a|mn12_g0|mp13_g0|ro1|ro1_esc|sr1_d_stub|tg_d_a|y
+ a|d|inva_a|mn12_g0|mp13_g0|ro3|ro3_esc_e|ro3_esc_w|ro3_hop|sr3_d_stub|tg_d_a|y
+ a|d|sb_d_stub|tg_d_a|xo|xo_dip|xo_hop|xo_stub|y a|g_a|rn1|ro|s4_y|y
+ a|g_a|rn2|ro|s4_y|y a|g_a|rn3|ro|s4_y|y a|g_a|rn4|ro|s4_y|y
+ a|g_y|mnab_y|mpa_y|mpb_y|n1|s1_a|y a|g_y|mnab_y|mpa_y|mpb_y|n1|s1_a|y$1
+ a|g_y|mnab_y|mpa_y|mpb_y|n1|s1_a|y$2 a|g_y|mnab_y|mpa_y|mpb_y|n1|s1_a|y$3
+ a|inv_mc_a|mb|mnab_y|mpa_y|mpb_y|nand_m_y|tg_s_a|y
+ a|inv_mc_a|mb|mnab_y|mpa_y|mpb_y|nand_m_y|tg_s_a|y$1
+ a|inv_mc_a|mb|mnab_y|mpa_y|mpb_y|nand_m_y|tg_s_a|y$2
+ a|inv_mc_a|mb|mnab_y|mpa_y|mpb_y|nand_m_y|tg_s_a|y$3
+ a|inv_mc_a|mb|mnab_y|mpa_y|mpb_y|nand_m_y|tg_s_a|y$4
+ a|inv_mc_a|mb|mnab_y|mpa_y|mpb_y|nand_m_y|tg_s_a|y$5
+ a|inv_mc_y|inv_mc_y_via|mc|tg_fbm_a|tg_fbm_a_via|y
+ a|inv_mc_y|inv_mc_y_via|mc|tg_fbm_a|tg_fbm_a_via|y$1
+ a|inv_mc_y|inv_mc_y_via|mc|tg_fbm_a|tg_fbm_a_via|y$2
+ a|inv_mc_y|inv_mc_y_via|mc|tg_fbm_a|tg_fbm_a_via|y$3
+ a|inv_mc_y|inv_mc_y_via|mc|tg_fbm_a|tg_fbm_a_via|y$4
+ a|inv_mc_y|inv_mc_y_via|mc|tg_fbm_a|tg_fbm_a_via|y$5
+ a|inv_q_y|inv_q_y_via|inv_q_y_via2|nand_s2_a|nand_s2_a_stub|nand_s2_a_via|nand_s2_a_via2|q|y
+ a|inv_q_y|inv_q_y_via|inv_q_y_via2|nand_s2_a|nand_s2_a_stub|nand_s2_a_via|nand_s2_a_via2|q|y$1
+ a|inv_q_y|inv_q_y_via|inv_q_y_via2|nand_s2_a|nand_s2_a_stub|nand_s2_a_via|nand_s2_a_via2|q|y$2
+ a|inv_q_y|inv_q_y_via|inv_q_y_via2|nand_s2_a|nand_s2_a_stub|nand_s2_a_via|nand_s2_a_via2|q|y$3
+ a|inv_q_y|inv_q_y_via|inv_q_y_via2|nand_s2_a|nand_s2_a_stub|nand_s2_a_via|nand_s2_a_via2|q|y$4
+ a|inv_q_y|inv_q_y_via|inv_q_y_via2|nand_s2_a|nand_s2_a_stub|nand_s2_a_via|nand_s2_a_via2|q|y$5
+ a|inva_a|mn12_g0|mp13_g0|t1|y a|mnab_y|mpa_y|mpb_y|nand_s2_y|qb|tg_fbs_a|y
+ a|mnab_y|mpa_y|mpb_y|nand_s2_y|qb|tg_fbs_a|y$1
+ a|mnab_y|mpa_y|mpb_y|nand_s2_y|qb|tg_fbs_a|y$2
+ a|mnab_y|mpa_y|mpb_y|nand_s2_y|qb|tg_fbs_a|y$3
+ a|mnab_y|mpa_y|mpb_y|nand_s2_y|qb|tg_fbs_a|y$4
+ a|mnab_y|mpa_y|mpb_y|nand_s2_y|qb|tg_fbs_a|y$5 a|n2|s1_y|s2_a|y
+ a|n2|s1_y|s2_a|y$1 a|n2|s1_y|s2_a|y$2 a|n2|s1_y|s2_a|y$3 a|n3|s2_y|s3_a|y
+ a|n3|s2_y|s3_a|y$1 a|n3|s2_y|s3_a|y$2 a|n3|s2_y|s3_a|y$3 a|n4|s3_y|s4_a|y
+ a|n4|s3_y|s4_a|y$1 a|n4|s3_y|s4_a|y$2 a|n4|s3_y|s4_a|y$3
+ an|inva_y|mn34_g0|mp13_g1|y an|inva_y|mn34_g0|mp13_g1|y$1
+ an|inva_y|mn34_g0|mp13_g1|y$2 bn|invb_y|mn34_g1|mp24_g1|y
+ bn|invb_y|mn34_g1|mp24_g1|y$1 bn|invb_y|mn34_g1|mp24_g1|y$2
+ clkb|clkb_bridge1|clkb_bridge2|clkb_mid|clkb_w|ctrl|ctrlb|inv_clk_y|tg_d_ctrlb|tg_fbm_ctrl|tg_fbs_ctrlb|tg_s_ctrl|y
+ clkb|clkb_bridge1|clkb_bridge2|clkb_mid|clkb_w|ctrl|ctrlb|inv_clk_y|tg_d_ctrlb|tg_fbm_ctrl|tg_fbs_ctrlb|tg_s_ctrl|y$1
+ clkb|clkb_bridge1|clkb_bridge2|clkb_mid|clkb_w|ctrl|ctrlb|inv_clk_y|tg_d_ctrlb|tg_fbm_ctrl|tg_fbs_ctrlb|tg_s_ctrl|y$2
+ clkb|clkb_bridge1|clkb_bridge2|clkb_mid|clkb_w|ctrl|ctrlb|inv_clk_y|tg_d_ctrlb|tg_fbm_ctrl|tg_fbs_ctrlb|tg_s_ctrl|y$3
+ clkb|clkb_bridge1|clkb_bridge2|clkb_mid|clkb_w|ctrl|ctrlb|inv_clk_y|tg_d_ctrlb|tg_fbm_ctrl|tg_fbs_ctrlb|tg_s_ctrl|y$4
+ clkb|clkb_bridge1|clkb_bridge2|clkb_mid|clkb_w|ctrl|ctrlb|inv_clk_y|tg_d_ctrlb|tg_fbm_ctrl|tg_fbs_ctrlb|tg_s_ctrl|y$5
+ en|en1|g_en en|en2|g_en en|en3|g_en en|en4|g_en
+ en|nand_m_en|nand_m_en_via|nand_s2_en|nand_s2_en_via|rst_n
+ g_vddr_m1|mnt_g|s1_vddr_m1|s2_vddr_m1|s3_vddr_m1|s4_vddr_m1|vddr|vddr1
+ g_vddr_m1|mnt_g|s1_vddr_m1|s2_vddr_m1|s3_vddr_m1|s4_vddr_m1|vddr|vddr2
+ g_vddr_m1|mnt_g|s1_vddr_m1|s2_vddr_m1|s3_vddr_m1|s4_vddr_m1|vddr|vddr3
+ g_vddr_m1|mnt_g|s1_vddr_m1|s2_vddr_m1|s3_vddr_m1|s4_vddr_m1|vddr|vddr4
+ g_vss_m1|inv_clk_vss|inv_mc_vss|inv_q_vss|mph_g|nand_m_vss|nand_s2_vss|s1_vss_m1|s2_vss_m1|s3_vss_m1|s4_vss_m1|sb_vss|sr1_vss|sr2_vss|sr3_vss|sr4_vss|sv_vss|tg_d_vss|tg_fbm_vss|tg_fbs_vss|tg_s_vss|vss|vss_link|vss_link_bridge|vss_link_dip|vss_link_m1|vss_x1|vss_x2|vss_x3
+ mid mid$1 mid$2 mpa_py|mpb_py|mph_py|py mpa_py|mpb_py|mph_py|py$1
+ mpa_py|mpb_py|mph_py|py$2 mpa_py|mpb_py|mph_py|py$3 ny ny$1 ny$2 ny$3 ny$4
+ ny$5 ny$6 ny$7 ny$8 ny$9 ny$10 ny$11 ny$12 ny$13 ny$14 ny$15 ny$16 ny$17
+ ny$18 ny$19 py py$1 py$2 py$3 py$4 py$5 py$6 py$7 py$8 py$9 py$10 py$11 py$12
+ py$13 py$14 py$15
* device instance $1 r0 *1 12.565,0.21 nfet
X$1 \$12__t1 en|nand_m_en|nand_m_en_via|nand_s2_en|nand_s2_en_via|rst_n__t0
+ g_vss_m1|inv_clk_vss|inv_mc_vss|inv_q_vss|mph_g|nand_m_vss|nand_s2_vss|s1_vss_m1|s2_vss_m1|s3_vss_m1|s4_vss_m1|sb_vss|sr1_vss|sr2_vss|sr3_vss|sr4_vss|sv_vss|tg_d_vss|tg_fbm_vss|tg_fbs_vss|tg_s_vss|vss|vss_link|vss_link_bridge|vss_link_dip|vss_link_m1|vss_x1|vss_x2|vss_x3__t0
+ g_vss_m1|inv_clk_vss|inv_mc_vss|inv_q_vss|mph_g|nand_m_vss|nand_s2_vss|s1_vss_m1|s2_vss_m1|s3_vss_m1|s4_vss_m1|sb_vss|sr1_vss|sr2_vss|sr3_vss|sr4_vss|sv_vss|tg_d_vss|tg_fbm_vss|tg_fbs_vss|tg_s_vss|vss|vss_link|vss_link_bridge|vss_link_dip|vss_link_m1|vss_x1|vss_x2|vss_x3__t86
+ sky130_fd_pr__nfet_01v8 L=0.15 W=0.84 AS=0.3948 AD=0.2184 PS=2.62 PD=1.36
* device instance $2 r0 *1 13.235,0.21 nfet
X$2 a|inv_mc_a|mb|mnab_y|mpa_y|mpb_y|nand_m_y|tg_s_a|y__t0
+ a|b|m_east|m_west|nand_m_a|nand_m_a_ext_via|nand_m_a_ext_via2|nand_m_a_stub|tg_d_b|tg_d_b_via|tg_d_b_via2|tg_fbm_b|tg_fbm_b_alt_via|tg_fbm_b_alt_via2__t02
+ \$12__t0
+ g_vss_m1|inv_clk_vss|inv_mc_vss|inv_q_vss|mph_g|nand_m_vss|nand_s2_vss|s1_vss_m1|s2_vss_m1|s3_vss_m1|s4_vss_m1|sb_vss|sr1_vss|sr2_vss|sr3_vss|sr4_vss|sv_vss|tg_d_vss|tg_fbm_vss|tg_fbs_vss|tg_s_vss|vss|vss_link|vss_link_bridge|vss_link_dip|vss_link_m1|vss_x1|vss_x2|vss_x3__t108
+ sky130_fd_pr__nfet_01v8 L=0.15 W=0.84 AS=0.2184 AD=0.3948 PS=1.36 PD=2.62
* device instance $3 r0 *1 43.425,0.21 nfet
X$3 \$14__t0 en|nand_m_en|nand_m_en_via|nand_s2_en|nand_s2_en_via|rst_n__t22
+ g_vss_m1|inv_clk_vss|inv_mc_vss|inv_q_vss|mph_g|nand_m_vss|nand_s2_vss|s1_vss_m1|s2_vss_m1|s3_vss_m1|s4_vss_m1|sb_vss|sr1_vss|sr2_vss|sr3_vss|sr4_vss|sv_vss|tg_d_vss|tg_fbm_vss|tg_fbs_vss|tg_s_vss|vss|vss_link|vss_link_bridge|vss_link_dip|vss_link_m1|vss_x1|vss_x2|vss_x3__t84
+ g_vss_m1|inv_clk_vss|inv_mc_vss|inv_q_vss|mph_g|nand_m_vss|nand_s2_vss|s1_vss_m1|s2_vss_m1|s3_vss_m1|s4_vss_m1|sb_vss|sr1_vss|sr2_vss|sr3_vss|sr4_vss|sv_vss|tg_d_vss|tg_fbm_vss|tg_fbs_vss|tg_s_vss|vss|vss_link|vss_link_bridge|vss_link_dip|vss_link_m1|vss_x1|vss_x2|vss_x3__t87
+ sky130_fd_pr__nfet_01v8 L=0.15 W=0.84 AS=0.3948 AD=0.2184 PS=2.62 PD=1.36
* device instance $4 r0 *1 44.095,0.21 nfet
X$4 a|mnab_y|mpa_y|mpb_y|nand_s2_y|qb|tg_fbs_a|y__t4
+ a|inv_q_y|inv_q_y_via|inv_q_y_via2|nand_s2_a|nand_s2_a_stub|nand_s2_a_via|nand_s2_a_via2|q|y__t3
+ \$14__t1
+ g_vss_m1|inv_clk_vss|inv_mc_vss|inv_q_vss|mph_g|nand_m_vss|nand_s2_vss|s1_vss_m1|s2_vss_m1|s3_vss_m1|s4_vss_m1|sb_vss|sr1_vss|sr2_vss|sr3_vss|sr4_vss|sv_vss|tg_d_vss|tg_fbm_vss|tg_fbs_vss|tg_s_vss|vss|vss_link|vss_link_bridge|vss_link_dip|vss_link_m1|vss_x1|vss_x2|vss_x3__t109
+ sky130_fd_pr__nfet_01v8 L=0.15 W=0.84 AS=0.2184 AD=0.3948 PS=1.36 PD=2.62
* device instance $5 r0 *1 68.225,0.21 nfet
X$5 \$16__t0 en|nand_m_en|nand_m_en_via|nand_s2_en|nand_s2_en_via|rst_n__t23
+ g_vss_m1|inv_clk_vss|inv_mc_vss|inv_q_vss|mph_g|nand_m_vss|nand_s2_vss|s1_vss_m1|s2_vss_m1|s3_vss_m1|s4_vss_m1|sb_vss|sr1_vss|sr2_vss|sr3_vss|sr4_vss|sv_vss|tg_d_vss|tg_fbm_vss|tg_fbs_vss|tg_s_vss|vss|vss_link|vss_link_bridge|vss_link_dip|vss_link_m1|vss_x1|vss_x2|vss_x3__t85
+ g_vss_m1|inv_clk_vss|inv_mc_vss|inv_q_vss|mph_g|nand_m_vss|nand_s2_vss|s1_vss_m1|s2_vss_m1|s3_vss_m1|s4_vss_m1|sb_vss|sr1_vss|sr2_vss|sr3_vss|sr4_vss|sv_vss|tg_d_vss|tg_fbm_vss|tg_fbs_vss|tg_s_vss|vss|vss_link|vss_link_bridge|vss_link_dip|vss_link_m1|vss_x1|vss_x2|vss_x3__t88
+ sky130_fd_pr__nfet_01v8 L=0.15 W=0.84 AS=0.3948 AD=0.2184 PS=2.62 PD=1.36
* device instance $6 r0 *1 68.895,0.21 nfet
X$6 a|inv_mc_a|mb|mnab_y|mpa_y|mpb_y|nand_m_y|tg_s_a|y__t62
+ a|b|m_east|m_west|nand_m_a|nand_m_a_ext_via|nand_m_a_ext_via2|nand_m_a_stub|tg_d_b|tg_d_b_via|tg_d_b_via2|tg_fbm_b|tg_fbm_b_alt_via|tg_fbm_b_alt_via2__t53
+ \$16__t1
+ g_vss_m1|inv_clk_vss|inv_mc_vss|inv_q_vss|mph_g|nand_m_vss|nand_s2_vss|s1_vss_m1|s2_vss_m1|s3_vss_m1|s4_vss_m1|sb_vss|sr1_vss|sr2_vss|sr3_vss|sr4_vss|sv_vss|tg_d_vss|tg_fbm_vss|tg_fbs_vss|tg_s_vss|vss|vss_link|vss_link_bridge|vss_link_dip|vss_link_m1|vss_x1|vss_x2|vss_x3__t110
+ sky130_fd_pr__nfet_01v8 L=0.15 W=0.84 AS=0.2184 AD=0.3948 PS=1.36 PD=2.62
* device instance $7 r0 *1 99.085,0.21 nfet
X$7 \$18__t0 en|nand_m_en|nand_m_en_via|nand_s2_en|nand_s2_en_via|rst_n__t21
+ g_vss_m1|inv_clk_vss|inv_mc_vss|inv_q_vss|mph_g|nand_m_vss|nand_s2_vss|s1_vss_m1|s2_vss_m1|s3_vss_m1|s4_vss_m1|sb_vss|sr1_vss|sr2_vss|sr3_vss|sr4_vss|sv_vss|tg_d_vss|tg_fbm_vss|tg_fbs_vss|tg_s_vss|vss|vss_link|vss_link_bridge|vss_link_dip|vss_link_m1|vss_x1|vss_x2|vss_x3__t83
+ g_vss_m1|inv_clk_vss|inv_mc_vss|inv_q_vss|mph_g|nand_m_vss|nand_s2_vss|s1_vss_m1|s2_vss_m1|s3_vss_m1|s4_vss_m1|sb_vss|sr1_vss|sr2_vss|sr3_vss|sr4_vss|sv_vss|tg_d_vss|tg_fbm_vss|tg_fbs_vss|tg_s_vss|vss|vss_link|vss_link_bridge|vss_link_dip|vss_link_m1|vss_x1|vss_x2|vss_x3__t89
+ sky130_fd_pr__nfet_01v8 L=0.15 W=0.84 AS=0.3948 AD=0.2184 PS=2.62 PD=1.36
* device instance $8 r0 *1 99.755,0.21 nfet
X$8 a|mnab_y|mpa_y|mpb_y|nand_s2_y|qb|tg_fbs_a|y__t42
+ a|inv_q_y|inv_q_y_via|inv_q_y_via2|nand_s2_a|nand_s2_a_stub|nand_s2_a_via|nand_s2_a_via2|q|y__t32
+ \$18__t1
+ g_vss_m1|inv_clk_vss|inv_mc_vss|inv_q_vss|mph_g|nand_m_vss|nand_s2_vss|s1_vss_m1|s2_vss_m1|s3_vss_m1|s4_vss_m1|sb_vss|sr1_vss|sr2_vss|sr3_vss|sr4_vss|sv_vss|tg_d_vss|tg_fbm_vss|tg_fbs_vss|tg_s_vss|vss|vss_link|vss_link_bridge|vss_link_dip|vss_link_m1|vss_x1|vss_x2|vss_x3__t111
+ sky130_fd_pr__nfet_01v8 L=0.15 W=0.84 AS=0.2184 AD=0.3948 PS=1.36 PD=2.62
* device instance $9 r0 *1 123.885,0.21 nfet
X$9 \$21__t0 en|nand_m_en|nand_m_en_via|nand_s2_en|nand_s2_en_via|rst_n__t20
+ g_vss_m1|inv_clk_vss|inv_mc_vss|inv_q_vss|mph_g|nand_m_vss|nand_s2_vss|s1_vss_m1|s2_vss_m1|s3_vss_m1|s4_vss_m1|sb_vss|sr1_vss|sr2_vss|sr3_vss|sr4_vss|sv_vss|tg_d_vss|tg_fbm_vss|tg_fbs_vss|tg_s_vss|vss|vss_link|vss_link_bridge|vss_link_dip|vss_link_m1|vss_x1|vss_x2|vss_x3__t82
+ g_vss_m1|inv_clk_vss|inv_mc_vss|inv_q_vss|mph_g|nand_m_vss|nand_s2_vss|s1_vss_m1|s2_vss_m1|s3_vss_m1|s4_vss_m1|sb_vss|sr1_vss|sr2_vss|sr3_vss|sr4_vss|sv_vss|tg_d_vss|tg_fbm_vss|tg_fbs_vss|tg_s_vss|vss|vss_link|vss_link_bridge|vss_link_dip|vss_link_m1|vss_x1|vss_x2|vss_x3__t90
+ sky130_fd_pr__nfet_01v8 L=0.15 W=0.84 AS=0.3948 AD=0.2184 PS=2.62 PD=1.36
* device instance $10 r0 *1 124.555,0.21 nfet
X$10 a|inv_mc_a|mb|mnab_y|mpa_y|mpb_y|nand_m_y|tg_s_a|y__t63
+ a|b|m_east|m_west|nand_m_a|nand_m_a_ext_via|nand_m_a_ext_via2|nand_m_a_stub|tg_d_b|tg_d_b_via|tg_d_b_via2|tg_fbm_b|tg_fbm_b_alt_via|tg_fbm_b_alt_via2__t54
+ \$21__t1
+ g_vss_m1|inv_clk_vss|inv_mc_vss|inv_q_vss|mph_g|nand_m_vss|nand_s2_vss|s1_vss_m1|s2_vss_m1|s3_vss_m1|s4_vss_m1|sb_vss|sr1_vss|sr2_vss|sr3_vss|sr4_vss|sv_vss|tg_d_vss|tg_fbm_vss|tg_fbs_vss|tg_s_vss|vss|vss_link|vss_link_bridge|vss_link_dip|vss_link_m1|vss_x1|vss_x2|vss_x3__t112
+ sky130_fd_pr__nfet_01v8 L=0.15 W=0.84 AS=0.2184 AD=0.3948 PS=1.36 PD=2.62
* device instance $11 r0 *1 154.745,0.21 nfet
X$11 \$23__t0 en|nand_m_en|nand_m_en_via|nand_s2_en|nand_s2_en_via|rst_n__t19
+ g_vss_m1|inv_clk_vss|inv_mc_vss|inv_q_vss|mph_g|nand_m_vss|nand_s2_vss|s1_vss_m1|s2_vss_m1|s3_vss_m1|s4_vss_m1|sb_vss|sr1_vss|sr2_vss|sr3_vss|sr4_vss|sv_vss|tg_d_vss|tg_fbm_vss|tg_fbs_vss|tg_s_vss|vss|vss_link|vss_link_bridge|vss_link_dip|vss_link_m1|vss_x1|vss_x2|vss_x3__t81
+ g_vss_m1|inv_clk_vss|inv_mc_vss|inv_q_vss|mph_g|nand_m_vss|nand_s2_vss|s1_vss_m1|s2_vss_m1|s3_vss_m1|s4_vss_m1|sb_vss|sr1_vss|sr2_vss|sr3_vss|sr4_vss|sv_vss|tg_d_vss|tg_fbm_vss|tg_fbs_vss|tg_s_vss|vss|vss_link|vss_link_bridge|vss_link_dip|vss_link_m1|vss_x1|vss_x2|vss_x3__t91
+ sky130_fd_pr__nfet_01v8 L=0.15 W=0.84 AS=0.3948 AD=0.2184 PS=2.62 PD=1.36
* device instance $12 r0 *1 155.415,0.21 nfet
X$12 a|mnab_y|mpa_y|mpb_y|nand_s2_y|qb|tg_fbs_a|y__t43
+ a|inv_q_y|inv_q_y_via|inv_q_y_via2|nand_s2_a|nand_s2_a_stub|nand_s2_a_via|nand_s2_a_via2|q|y__t33
+ \$23__t1
+ g_vss_m1|inv_clk_vss|inv_mc_vss|inv_q_vss|mph_g|nand_m_vss|nand_s2_vss|s1_vss_m1|s2_vss_m1|s3_vss_m1|s4_vss_m1|sb_vss|sr1_vss|sr2_vss|sr3_vss|sr4_vss|sv_vss|tg_d_vss|tg_fbm_vss|tg_fbs_vss|tg_s_vss|vss|vss_link|vss_link_bridge|vss_link_dip|vss_link_m1|vss_x1|vss_x2|vss_x3__t113
+ sky130_fd_pr__nfet_01v8 L=0.15 W=0.84 AS=0.2184 AD=0.3948 PS=1.36 PD=2.62
* device instance $13 r0 *1 179.545,0.21 nfet
X$13 \$26__t0 en|nand_m_en|nand_m_en_via|nand_s2_en|nand_s2_en_via|rst_n__t18
+ g_vss_m1|inv_clk_vss|inv_mc_vss|inv_q_vss|mph_g|nand_m_vss|nand_s2_vss|s1_vss_m1|s2_vss_m1|s3_vss_m1|s4_vss_m1|sb_vss|sr1_vss|sr2_vss|sr3_vss|sr4_vss|sv_vss|tg_d_vss|tg_fbm_vss|tg_fbs_vss|tg_s_vss|vss|vss_link|vss_link_bridge|vss_link_dip|vss_link_m1|vss_x1|vss_x2|vss_x3__t80
+ g_vss_m1|inv_clk_vss|inv_mc_vss|inv_q_vss|mph_g|nand_m_vss|nand_s2_vss|s1_vss_m1|s2_vss_m1|s3_vss_m1|s4_vss_m1|sb_vss|sr1_vss|sr2_vss|sr3_vss|sr4_vss|sv_vss|tg_d_vss|tg_fbm_vss|tg_fbs_vss|tg_s_vss|vss|vss_link|vss_link_bridge|vss_link_dip|vss_link_m1|vss_x1|vss_x2|vss_x3__t92
+ sky130_fd_pr__nfet_01v8 L=0.15 W=0.84 AS=0.3948 AD=0.2184 PS=2.62 PD=1.36
* device instance $14 r0 *1 180.215,0.21 nfet
X$14 a|inv_mc_a|mb|mnab_y|mpa_y|mpb_y|nand_m_y|tg_s_a|y__t64
+ a|b|m_east|m_west|nand_m_a|nand_m_a_ext_via|nand_m_a_ext_via2|nand_m_a_stub|tg_d_b|tg_d_b_via|tg_d_b_via2|tg_fbm_b|tg_fbm_b_alt_via|tg_fbm_b_alt_via2__t55
+ \$26__t1
+ g_vss_m1|inv_clk_vss|inv_mc_vss|inv_q_vss|mph_g|nand_m_vss|nand_s2_vss|s1_vss_m1|s2_vss_m1|s3_vss_m1|s4_vss_m1|sb_vss|sr1_vss|sr2_vss|sr3_vss|sr4_vss|sv_vss|tg_d_vss|tg_fbm_vss|tg_fbs_vss|tg_s_vss|vss|vss_link|vss_link_bridge|vss_link_dip|vss_link_m1|vss_x1|vss_x2|vss_x3__t114
+ sky130_fd_pr__nfet_01v8 L=0.15 W=0.84 AS=0.2184 AD=0.3948 PS=1.36 PD=2.62
* device instance $15 r0 *1 210.405,0.21 nfet
X$15 \$28__t0 en|nand_m_en|nand_m_en_via|nand_s2_en|nand_s2_en_via|rst_n__t13
+ g_vss_m1|inv_clk_vss|inv_mc_vss|inv_q_vss|mph_g|nand_m_vss|nand_s2_vss|s1_vss_m1|s2_vss_m1|s3_vss_m1|s4_vss_m1|sb_vss|sr1_vss|sr2_vss|sr3_vss|sr4_vss|sv_vss|tg_d_vss|tg_fbm_vss|tg_fbs_vss|tg_s_vss|vss|vss_link|vss_link_bridge|vss_link_dip|vss_link_m1|vss_x1|vss_x2|vss_x3__t75
+ g_vss_m1|inv_clk_vss|inv_mc_vss|inv_q_vss|mph_g|nand_m_vss|nand_s2_vss|s1_vss_m1|s2_vss_m1|s3_vss_m1|s4_vss_m1|sb_vss|sr1_vss|sr2_vss|sr3_vss|sr4_vss|sv_vss|tg_d_vss|tg_fbm_vss|tg_fbs_vss|tg_s_vss|vss|vss_link|vss_link_bridge|vss_link_dip|vss_link_m1|vss_x1|vss_x2|vss_x3__t93
+ sky130_fd_pr__nfet_01v8 L=0.15 W=0.84 AS=0.3948 AD=0.2184 PS=2.62 PD=1.36
* device instance $16 r0 *1 211.075,0.21 nfet
X$16 a|mnab_y|mpa_y|mpb_y|nand_s2_y|qb|tg_fbs_a|y__t44
+ a|inv_q_y|inv_q_y_via|inv_q_y_via2|nand_s2_a|nand_s2_a_stub|nand_s2_a_via|nand_s2_a_via2|q|y__t34
+ \$28__t1
+ g_vss_m1|inv_clk_vss|inv_mc_vss|inv_q_vss|mph_g|nand_m_vss|nand_s2_vss|s1_vss_m1|s2_vss_m1|s3_vss_m1|s4_vss_m1|sb_vss|sr1_vss|sr2_vss|sr3_vss|sr4_vss|sv_vss|tg_d_vss|tg_fbm_vss|tg_fbs_vss|tg_s_vss|vss|vss_link|vss_link_bridge|vss_link_dip|vss_link_m1|vss_x1|vss_x2|vss_x3__t115
+ sky130_fd_pr__nfet_01v8 L=0.15 W=0.84 AS=0.2184 AD=0.3948 PS=1.36 PD=2.62
* device instance $17 r0 *1 235.205,0.21 nfet
X$17 \$31__t0 en|nand_m_en|nand_m_en_via|nand_s2_en|nand_s2_en_via|rst_n__t14
+ g_vss_m1|inv_clk_vss|inv_mc_vss|inv_q_vss|mph_g|nand_m_vss|nand_s2_vss|s1_vss_m1|s2_vss_m1|s3_vss_m1|s4_vss_m1|sb_vss|sr1_vss|sr2_vss|sr3_vss|sr4_vss|sv_vss|tg_d_vss|tg_fbm_vss|tg_fbs_vss|tg_s_vss|vss|vss_link|vss_link_bridge|vss_link_dip|vss_link_m1|vss_x1|vss_x2|vss_x3__t76
+ g_vss_m1|inv_clk_vss|inv_mc_vss|inv_q_vss|mph_g|nand_m_vss|nand_s2_vss|s1_vss_m1|s2_vss_m1|s3_vss_m1|s4_vss_m1|sb_vss|sr1_vss|sr2_vss|sr3_vss|sr4_vss|sv_vss|tg_d_vss|tg_fbm_vss|tg_fbs_vss|tg_s_vss|vss|vss_link|vss_link_bridge|vss_link_dip|vss_link_m1|vss_x1|vss_x2|vss_x3__t94
+ sky130_fd_pr__nfet_01v8 L=0.15 W=0.84 AS=0.3948 AD=0.2184 PS=2.62 PD=1.36
* device instance $18 r0 *1 235.875,0.21 nfet
X$18 a|inv_mc_a|mb|mnab_y|mpa_y|mpb_y|nand_m_y|tg_s_a|y__t65
+ a|b|m_east|m_west|nand_m_a|nand_m_a_ext_via|nand_m_a_ext_via2|nand_m_a_stub|tg_d_b|tg_d_b_via|tg_d_b_via2|tg_fbm_b|tg_fbm_b_alt_via|tg_fbm_b_alt_via2__t56
+ \$31__t1
+ g_vss_m1|inv_clk_vss|inv_mc_vss|inv_q_vss|mph_g|nand_m_vss|nand_s2_vss|s1_vss_m1|s2_vss_m1|s3_vss_m1|s4_vss_m1|sb_vss|sr1_vss|sr2_vss|sr3_vss|sr4_vss|sv_vss|tg_d_vss|tg_fbm_vss|tg_fbs_vss|tg_s_vss|vss|vss_link|vss_link_bridge|vss_link_dip|vss_link_m1|vss_x1|vss_x2|vss_x3__t116
+ sky130_fd_pr__nfet_01v8 L=0.15 W=0.84 AS=0.2184 AD=0.3948 PS=1.36 PD=2.62
* device instance $19 r0 *1 266.065,0.21 nfet
X$19 \$33__t0 en|nand_m_en|nand_m_en_via|nand_s2_en|nand_s2_en_via|rst_n__t15
+ g_vss_m1|inv_clk_vss|inv_mc_vss|inv_q_vss|mph_g|nand_m_vss|nand_s2_vss|s1_vss_m1|s2_vss_m1|s3_vss_m1|s4_vss_m1|sb_vss|sr1_vss|sr2_vss|sr3_vss|sr4_vss|sv_vss|tg_d_vss|tg_fbm_vss|tg_fbs_vss|tg_s_vss|vss|vss_link|vss_link_bridge|vss_link_dip|vss_link_m1|vss_x1|vss_x2|vss_x3__t77
+ g_vss_m1|inv_clk_vss|inv_mc_vss|inv_q_vss|mph_g|nand_m_vss|nand_s2_vss|s1_vss_m1|s2_vss_m1|s3_vss_m1|s4_vss_m1|sb_vss|sr1_vss|sr2_vss|sr3_vss|sr4_vss|sv_vss|tg_d_vss|tg_fbm_vss|tg_fbs_vss|tg_s_vss|vss|vss_link|vss_link_bridge|vss_link_dip|vss_link_m1|vss_x1|vss_x2|vss_x3__t95
+ sky130_fd_pr__nfet_01v8 L=0.15 W=0.84 AS=0.3948 AD=0.2184 PS=2.62 PD=1.36
* device instance $20 r0 *1 266.735,0.21 nfet
X$20 a|mnab_y|mpa_y|mpb_y|nand_s2_y|qb|tg_fbs_a|y__t45
+ a|inv_q_y|inv_q_y_via|inv_q_y_via2|nand_s2_a|nand_s2_a_stub|nand_s2_a_via|nand_s2_a_via2|q|y__t35
+ \$33__t1
+ g_vss_m1|inv_clk_vss|inv_mc_vss|inv_q_vss|mph_g|nand_m_vss|nand_s2_vss|s1_vss_m1|s2_vss_m1|s3_vss_m1|s4_vss_m1|sb_vss|sr1_vss|sr2_vss|sr3_vss|sr4_vss|sv_vss|tg_d_vss|tg_fbm_vss|tg_fbs_vss|tg_s_vss|vss|vss_link|vss_link_bridge|vss_link_dip|vss_link_m1|vss_x1|vss_x2|vss_x3__t117
+ sky130_fd_pr__nfet_01v8 L=0.15 W=0.84 AS=0.2184 AD=0.3948 PS=1.36 PD=2.62
* device instance $21 r0 *1 290.865,0.21 nfet
X$21 \$36__t0 en|nand_m_en|nand_m_en_via|nand_s2_en|nand_s2_en_via|rst_n__t16
+ g_vss_m1|inv_clk_vss|inv_mc_vss|inv_q_vss|mph_g|nand_m_vss|nand_s2_vss|s1_vss_m1|s2_vss_m1|s3_vss_m1|s4_vss_m1|sb_vss|sr1_vss|sr2_vss|sr3_vss|sr4_vss|sv_vss|tg_d_vss|tg_fbm_vss|tg_fbs_vss|tg_s_vss|vss|vss_link|vss_link_bridge|vss_link_dip|vss_link_m1|vss_x1|vss_x2|vss_x3__t78
+ g_vss_m1|inv_clk_vss|inv_mc_vss|inv_q_vss|mph_g|nand_m_vss|nand_s2_vss|s1_vss_m1|s2_vss_m1|s3_vss_m1|s4_vss_m1|sb_vss|sr1_vss|sr2_vss|sr3_vss|sr4_vss|sv_vss|tg_d_vss|tg_fbm_vss|tg_fbs_vss|tg_s_vss|vss|vss_link|vss_link_bridge|vss_link_dip|vss_link_m1|vss_x1|vss_x2|vss_x3__t96
+ sky130_fd_pr__nfet_01v8 L=0.15 W=0.84 AS=0.3948 AD=0.2184 PS=2.62 PD=1.36
* device instance $22 r0 *1 291.535,0.21 nfet
X$22 a|inv_mc_a|mb|mnab_y|mpa_y|mpb_y|nand_m_y|tg_s_a|y__t66
+ a|b|m_east|m_west|nand_m_a|nand_m_a_ext_via|nand_m_a_ext_via2|nand_m_a_stub|tg_d_b|tg_d_b_via|tg_d_b_via2|tg_fbm_b|tg_fbm_b_alt_via|tg_fbm_b_alt_via2__t5
+ \$36__t1
+ g_vss_m1|inv_clk_vss|inv_mc_vss|inv_q_vss|mph_g|nand_m_vss|nand_s2_vss|s1_vss_m1|s2_vss_m1|s3_vss_m1|s4_vss_m1|sb_vss|sr1_vss|sr2_vss|sr3_vss|sr4_vss|sv_vss|tg_d_vss|tg_fbm_vss|tg_fbs_vss|tg_s_vss|vss|vss_link|vss_link_bridge|vss_link_dip|vss_link_m1|vss_x1|vss_x2|vss_x3__t118
+ sky130_fd_pr__nfet_01v8 L=0.15 W=0.84 AS=0.2184 AD=0.3948 PS=1.36 PD=2.62
* device instance $23 r0 *1 321.725,0.21 nfet
X$23 \$38__t0 en|nand_m_en|nand_m_en_via|nand_s2_en|nand_s2_en_via|rst_n__t17
+ g_vss_m1|inv_clk_vss|inv_mc_vss|inv_q_vss|mph_g|nand_m_vss|nand_s2_vss|s1_vss_m1|s2_vss_m1|s3_vss_m1|s4_vss_m1|sb_vss|sr1_vss|sr2_vss|sr3_vss|sr4_vss|sv_vss|tg_d_vss|tg_fbm_vss|tg_fbs_vss|tg_s_vss|vss|vss_link|vss_link_bridge|vss_link_dip|vss_link_m1|vss_x1|vss_x2|vss_x3__t79
+ g_vss_m1|inv_clk_vss|inv_mc_vss|inv_q_vss|mph_g|nand_m_vss|nand_s2_vss|s1_vss_m1|s2_vss_m1|s3_vss_m1|s4_vss_m1|sb_vss|sr1_vss|sr2_vss|sr3_vss|sr4_vss|sv_vss|tg_d_vss|tg_fbm_vss|tg_fbs_vss|tg_s_vss|vss|vss_link|vss_link_bridge|vss_link_dip|vss_link_m1|vss_x1|vss_x2|vss_x3__t97
+ sky130_fd_pr__nfet_01v8 L=0.15 W=0.84 AS=0.3948 AD=0.2184 PS=2.62 PD=1.36
* device instance $24 r0 *1 322.395,0.21 nfet
X$24 a|mnab_y|mpa_y|mpb_y|nand_s2_y|qb|tg_fbs_a|y__t46
+ a|inv_q_y|inv_q_y_via|inv_q_y_via2|nand_s2_a|nand_s2_a_stub|nand_s2_a_via|nand_s2_a_via2|q|y__t36
+ \$38__t1
+ g_vss_m1|inv_clk_vss|inv_mc_vss|inv_q_vss|mph_g|nand_m_vss|nand_s2_vss|s1_vss_m1|s2_vss_m1|s3_vss_m1|s4_vss_m1|sb_vss|sr1_vss|sr2_vss|sr3_vss|sr4_vss|sv_vss|tg_d_vss|tg_fbm_vss|tg_fbs_vss|tg_s_vss|vss|vss_link|vss_link_bridge|vss_link_dip|vss_link_m1|vss_x1|vss_x2|vss_x3__t119
+ sky130_fd_pr__nfet_01v8 L=0.15 W=0.84 AS=0.2184 AD=0.3948 PS=1.36 PD=2.62
* device instance $25 r0 *1 0.545,0.21 nfet
X$25
+ clkb|clkb_bridge1|clkb_bridge2|clkb_mid|clkb_w|ctrl|ctrlb|inv_clk_y|tg_d_ctrlb|tg_fbm_ctrl|tg_fbs_ctrlb|tg_s_ctrl|y__t0
+ a|clk|ctrl|ctrlb|inv_clk_a|inv_clk_clk_via|tg_d_ctrl|tg_d_ctrl_via|tg_fbm_ctrlb|tg_fbm_ctrlb_via|tg_fbs_ctrl|tg_fbs_ctrl_via|tg_s_ctrlb|tg_s_ctrlb_via__t0
+ g_vss_m1|inv_clk_vss|inv_mc_vss|inv_q_vss|mph_g|nand_m_vss|nand_s2_vss|s1_vss_m1|s2_vss_m1|s3_vss_m1|s4_vss_m1|sb_vss|sr1_vss|sr2_vss|sr3_vss|sr4_vss|sv_vss|tg_d_vss|tg_fbm_vss|tg_fbs_vss|tg_s_vss|vss|vss_link|vss_link_bridge|vss_link_dip|vss_link_m1|vss_x1|vss_x2|vss_x3__t1
+ g_vss_m1|inv_clk_vss|inv_mc_vss|inv_q_vss|mph_g|nand_m_vss|nand_s2_vss|s1_vss_m1|s2_vss_m1|s3_vss_m1|s4_vss_m1|sb_vss|sr1_vss|sr2_vss|sr3_vss|sr4_vss|sv_vss|tg_d_vss|tg_fbm_vss|tg_fbs_vss|tg_s_vss|vss|vss_link|vss_link_bridge|vss_link_dip|vss_link_m1|vss_x1|vss_x2|vss_x3__t130
+ sky130_fd_pr__nfet_01v8 L=0.15 W=0.42 AS=0.1974 AD=0.1974 PS=1.78 PD=1.78
* device instance $26 r0 *1 5.31,0.21 nfet
X$26 a|d|sb_d_stub|tg_d_a|xo|xo_dip|xo_hop|xo_stub|y__t3
+ clkb|clkb_bridge1|clkb_bridge2|clkb_mid|clkb_w|ctrl|ctrlb|inv_clk_y|tg_d_ctrlb|tg_fbm_ctrl|tg_fbs_ctrlb|tg_s_ctrl|y__t4
+ a|b|m_east|m_west|nand_m_a|nand_m_a_ext_via|nand_m_a_ext_via2|nand_m_a_stub|tg_d_b|tg_d_b_via|tg_d_b_via2|tg_fbm_b|tg_fbm_b_alt_via|tg_fbm_b_alt_via2__t22
+ g_vss_m1|inv_clk_vss|inv_mc_vss|inv_q_vss|mph_g|nand_m_vss|nand_s2_vss|s1_vss_m1|s2_vss_m1|s3_vss_m1|s4_vss_m1|sb_vss|sr1_vss|sr2_vss|sr3_vss|sr4_vss|sv_vss|tg_d_vss|tg_fbm_vss|tg_fbs_vss|tg_s_vss|vss|vss_link|vss_link_bridge|vss_link_dip|vss_link_m1|vss_x1|vss_x2|vss_x3__t131
+ sky130_fd_pr__nfet_01v8 L=0.15 W=0.42 AS=0.1974 AD=0.1974 PS=1.78 PD=1.78
* device instance $27 r0 *1 19.835,0.21 nfet
X$27 a|inv_mc_y|inv_mc_y_via|mc|tg_fbm_a|tg_fbm_a_via|y__t2
+ a|inv_mc_a|mb|mnab_y|mpa_y|mpb_y|nand_m_y|tg_s_a|y__t5
+ g_vss_m1|inv_clk_vss|inv_mc_vss|inv_q_vss|mph_g|nand_m_vss|nand_s2_vss|s1_vss_m1|s2_vss_m1|s3_vss_m1|s4_vss_m1|sb_vss|sr1_vss|sr2_vss|sr3_vss|sr4_vss|sv_vss|tg_d_vss|tg_fbm_vss|tg_fbs_vss|tg_s_vss|vss|vss_link|vss_link_bridge|vss_link_dip|vss_link_m1|vss_x1|vss_x2|vss_x3__t52
+ g_vss_m1|inv_clk_vss|inv_mc_vss|inv_q_vss|mph_g|nand_m_vss|nand_s2_vss|s1_vss_m1|s2_vss_m1|s3_vss_m1|s4_vss_m1|sb_vss|sr1_vss|sr2_vss|sr3_vss|sr4_vss|sv_vss|tg_d_vss|tg_fbm_vss|tg_fbs_vss|tg_s_vss|vss|vss_link|vss_link_bridge|vss_link_dip|vss_link_m1|vss_x1|vss_x2|vss_x3__t132
+ sky130_fd_pr__nfet_01v8 L=0.15 W=0.42 AS=0.1974 AD=0.1974 PS=1.78 PD=1.78
* device instance $28 r0 *1 24.6,0.21 nfet
X$28 a|inv_mc_y|inv_mc_y_via|mc|tg_fbm_a|tg_fbm_a_via|y__t3
+ a|clk|ctrl|ctrlb|inv_clk_a|inv_clk_clk_via|tg_d_ctrl|tg_d_ctrl_via|tg_fbm_ctrlb|tg_fbm_ctrlb_via|tg_fbs_ctrl|tg_fbs_ctrl_via|tg_s_ctrlb|tg_s_ctrlb_via__t28
+ a|b|m_east|m_west|nand_m_a|nand_m_a_ext_via|nand_m_a_ext_via2|nand_m_a_stub|tg_d_b|tg_d_b_via|tg_d_b_via2|tg_fbm_b|tg_fbm_b_alt_via|tg_fbm_b_alt_via2__t32
+ g_vss_m1|inv_clk_vss|inv_mc_vss|inv_q_vss|mph_g|nand_m_vss|nand_s2_vss|s1_vss_m1|s2_vss_m1|s3_vss_m1|s4_vss_m1|sb_vss|sr1_vss|sr2_vss|sr3_vss|sr4_vss|sv_vss|tg_d_vss|tg_fbm_vss|tg_fbs_vss|tg_s_vss|vss|vss_link|vss_link_bridge|vss_link_dip|vss_link_m1|vss_x1|vss_x2|vss_x3__t133
+ sky130_fd_pr__nfet_01v8 L=0.15 W=0.42 AS=0.1974 AD=0.1974 PS=1.78 PD=1.78
* device instance $29 r0 *1 29.74,0.21 nfet
X$29 a|inv_mc_a|mb|mnab_y|mpa_y|mpb_y|nand_m_y|tg_s_a|y__t3
+ a|clk|ctrl|ctrlb|inv_clk_a|inv_clk_clk_via|tg_d_ctrl|tg_d_ctrl_via|tg_fbm_ctrlb|tg_fbm_ctrlb_via|tg_fbs_ctrl|tg_fbs_ctrl_via|tg_s_ctrlb|tg_s_ctrlb_via__t29
+ a|b|inv_q_a|inv_q_a_via|s|tg_fbs_b|tg_fbs_b_via|tg_s_b|tg_s_b_via__t2
+ g_vss_m1|inv_clk_vss|inv_mc_vss|inv_q_vss|mph_g|nand_m_vss|nand_s2_vss|s1_vss_m1|s2_vss_m1|s3_vss_m1|s4_vss_m1|sb_vss|sr1_vss|sr2_vss|sr3_vss|sr4_vss|sv_vss|tg_d_vss|tg_fbm_vss|tg_fbs_vss|tg_s_vss|vss|vss_link|vss_link_bridge|vss_link_dip|vss_link_m1|vss_x1|vss_x2|vss_x3__t134
+ sky130_fd_pr__nfet_01v8 L=0.15 W=0.42 AS=0.1974 AD=0.1974 PS=1.78 PD=1.78
* device instance $30 r0 *1 36.545,0.21 nfet
X$30
+ a|inv_q_y|inv_q_y_via|inv_q_y_via2|nand_s2_a|nand_s2_a_stub|nand_s2_a_via|nand_s2_a_via2|q|y__t1
+ a|b|inv_q_a|inv_q_a_via|s|tg_fbs_b|tg_fbs_b_via|tg_s_b|tg_s_b_via__t1
+ g_vss_m1|inv_clk_vss|inv_mc_vss|inv_q_vss|mph_g|nand_m_vss|nand_s2_vss|s1_vss_m1|s2_vss_m1|s3_vss_m1|s4_vss_m1|sb_vss|sr1_vss|sr2_vss|sr3_vss|sr4_vss|sv_vss|tg_d_vss|tg_fbm_vss|tg_fbs_vss|tg_s_vss|vss|vss_link|vss_link_bridge|vss_link_dip|vss_link_m1|vss_x1|vss_x2|vss_x3__t53
+ g_vss_m1|inv_clk_vss|inv_mc_vss|inv_q_vss|mph_g|nand_m_vss|nand_s2_vss|s1_vss_m1|s2_vss_m1|s3_vss_m1|s4_vss_m1|sb_vss|sr1_vss|sr2_vss|sr3_vss|sr4_vss|sv_vss|tg_d_vss|tg_fbm_vss|tg_fbs_vss|tg_s_vss|vss|vss_link|vss_link_bridge|vss_link_dip|vss_link_m1|vss_x1|vss_x2|vss_x3__t135
+ sky130_fd_pr__nfet_01v8 L=0.15 W=0.42 AS=0.1974 AD=0.1974 PS=1.78 PD=1.78
* device instance $31 r0 *1 49.03,0.21 nfet
X$31 a|mnab_y|mpa_y|mpb_y|nand_s2_y|qb|tg_fbs_a|y__t2
+ clkb|clkb_bridge1|clkb_bridge2|clkb_mid|clkb_w|ctrl|ctrlb|inv_clk_y|tg_d_ctrlb|tg_fbm_ctrl|tg_fbs_ctrlb|tg_s_ctrl|y__t5
+ a|b|inv_q_a|inv_q_a_via|s|tg_fbs_b|tg_fbs_b_via|tg_s_b|tg_s_b_via__t3
+ g_vss_m1|inv_clk_vss|inv_mc_vss|inv_q_vss|mph_g|nand_m_vss|nand_s2_vss|s1_vss_m1|s2_vss_m1|s3_vss_m1|s4_vss_m1|sb_vss|sr1_vss|sr2_vss|sr3_vss|sr4_vss|sv_vss|tg_d_vss|tg_fbm_vss|tg_fbs_vss|tg_s_vss|vss|vss_link|vss_link_bridge|vss_link_dip|vss_link_m1|vss_x1|vss_x2|vss_x3__t136
+ sky130_fd_pr__nfet_01v8 L=0.15 W=0.42 AS=0.1974 AD=0.1974 PS=1.78 PD=1.78
* device instance $32 r0 *1 56.205,0.21 nfet
X$32
+ clkb|clkb_bridge1|clkb_bridge2|clkb_mid|clkb_w|ctrl|ctrlb|inv_clk_y|tg_d_ctrlb|tg_fbm_ctrl|tg_fbs_ctrlb|tg_s_ctrl|y__t12
+ a|clk|ctrl|ctrlb|inv_clk_a|inv_clk_clk_via|tg_d_ctrl|tg_d_ctrl_via|tg_fbm_ctrlb|tg_fbm_ctrlb_via|tg_fbs_ctrl|tg_fbs_ctrl_via|tg_s_ctrlb|tg_s_ctrlb_via__t30
+ g_vss_m1|inv_clk_vss|inv_mc_vss|inv_q_vss|mph_g|nand_m_vss|nand_s2_vss|s1_vss_m1|s2_vss_m1|s3_vss_m1|s4_vss_m1|sb_vss|sr1_vss|sr2_vss|sr3_vss|sr4_vss|sv_vss|tg_d_vss|tg_fbm_vss|tg_fbs_vss|tg_s_vss|vss|vss_link|vss_link_bridge|vss_link_dip|vss_link_m1|vss_x1|vss_x2|vss_x3__t54
+ g_vss_m1|inv_clk_vss|inv_mc_vss|inv_q_vss|mph_g|nand_m_vss|nand_s2_vss|s1_vss_m1|s2_vss_m1|s3_vss_m1|s4_vss_m1|sb_vss|sr1_vss|sr2_vss|sr3_vss|sr4_vss|sv_vss|tg_d_vss|tg_fbm_vss|tg_fbs_vss|tg_s_vss|vss|vss_link|vss_link_bridge|vss_link_dip|vss_link_m1|vss_x1|vss_x2|vss_x3__t137
+ sky130_fd_pr__nfet_01v8 L=0.15 W=0.42 AS=0.1974 AD=0.1974 PS=1.78 PD=1.78
* device instance $33 r0 *1 60.97,0.21 nfet
X$33
+ a|d|inv_clk_vdd|inv_mc_vdd|inv_q_vdd|mpa_py|mpb_py|nand_m_vdd|nand_s2_vdd|nwell_vdd|sb_vdd|sr1_vdd|sr2_vdd|sr3_vdd|sr4_vdd|sv_d_vdd_tie|sv_vdd|tg_d_a|tg_d_vdd|tg_fbm_vdd|tg_fbs_vdd|tg_s_vdd|vdd|vdd_b1|vdd_b2|vdd_b3|vdd_b4|vdd_link|vdd_link_dip|vdd_x1|vdd_x2|vdd_x3__t33
+ clkb|clkb_bridge1|clkb_bridge2|clkb_mid|clkb_w|ctrl|ctrlb|inv_clk_y|tg_d_ctrlb|tg_fbm_ctrl|tg_fbs_ctrlb|tg_s_ctrl|y__t42
+ a|b|m_east|m_west|nand_m_a|nand_m_a_ext_via|nand_m_a_ext_via2|nand_m_a_stub|tg_d_b|tg_d_b_via|tg_d_b_via2|tg_fbm_b|tg_fbm_b_alt_via|tg_fbm_b_alt_via2__t13
+ g_vss_m1|inv_clk_vss|inv_mc_vss|inv_q_vss|mph_g|nand_m_vss|nand_s2_vss|s1_vss_m1|s2_vss_m1|s3_vss_m1|s4_vss_m1|sb_vss|sr1_vss|sr2_vss|sr3_vss|sr4_vss|sv_vss|tg_d_vss|tg_fbm_vss|tg_fbs_vss|tg_s_vss|vss|vss_link|vss_link_bridge|vss_link_dip|vss_link_m1|vss_x1|vss_x2|vss_x3__t138
+ sky130_fd_pr__nfet_01v8 L=0.15 W=0.42 AS=0.1974 AD=0.1974 PS=1.78 PD=1.78
* device instance $34 r0 *1 75.495,0.21 nfet
X$34 a|inv_mc_y|inv_mc_y_via|mc|tg_fbm_a|tg_fbm_a_via|y__t22
+ a|inv_mc_a|mb|mnab_y|mpa_y|mpb_y|nand_m_y|tg_s_a|y__t42
+ g_vss_m1|inv_clk_vss|inv_mc_vss|inv_q_vss|mph_g|nand_m_vss|nand_s2_vss|s1_vss_m1|s2_vss_m1|s3_vss_m1|s4_vss_m1|sb_vss|sr1_vss|sr2_vss|sr3_vss|sr4_vss|sv_vss|tg_d_vss|tg_fbm_vss|tg_fbs_vss|tg_s_vss|vss|vss_link|vss_link_bridge|vss_link_dip|vss_link_m1|vss_x1|vss_x2|vss_x3__t58
+ g_vss_m1|inv_clk_vss|inv_mc_vss|inv_q_vss|mph_g|nand_m_vss|nand_s2_vss|s1_vss_m1|s2_vss_m1|s3_vss_m1|s4_vss_m1|sb_vss|sr1_vss|sr2_vss|sr3_vss|sr4_vss|sv_vss|tg_d_vss|tg_fbm_vss|tg_fbs_vss|tg_s_vss|vss|vss_link|vss_link_bridge|vss_link_dip|vss_link_m1|vss_x1|vss_x2|vss_x3__t139
+ sky130_fd_pr__nfet_01v8 L=0.15 W=0.42 AS=0.1974 AD=0.1974 PS=1.78 PD=1.78
* device instance $35 r0 *1 80.26,0.21 nfet
X$35 a|inv_mc_y|inv_mc_y_via|mc|tg_fbm_a|tg_fbm_a_via|y__t32
+ a|clk|ctrl|ctrlb|inv_clk_a|inv_clk_clk_via|tg_d_ctrl|tg_d_ctrl_via|tg_fbm_ctrlb|tg_fbm_ctrlb_via|tg_fbs_ctrl|tg_fbs_ctrl_via|tg_s_ctrlb|tg_s_ctrlb_via__t31
+ a|b|m_east|m_west|nand_m_a|nand_m_a_ext_via|nand_m_a_ext_via2|nand_m_a_stub|tg_d_b|tg_d_b_via|tg_d_b_via2|tg_fbm_b|tg_fbm_b_alt_via|tg_fbm_b_alt_via2__t23
+ g_vss_m1|inv_clk_vss|inv_mc_vss|inv_q_vss|mph_g|nand_m_vss|nand_s2_vss|s1_vss_m1|s2_vss_m1|s3_vss_m1|s4_vss_m1|sb_vss|sr1_vss|sr2_vss|sr3_vss|sr4_vss|sv_vss|tg_d_vss|tg_fbm_vss|tg_fbs_vss|tg_s_vss|vss|vss_link|vss_link_bridge|vss_link_dip|vss_link_m1|vss_x1|vss_x2|vss_x3__t140
+ sky130_fd_pr__nfet_01v8 L=0.15 W=0.42 AS=0.1974 AD=0.1974 PS=1.78 PD=1.78
* device instance $36 r0 *1 85.4,0.21 nfet
X$36 a|inv_mc_a|mb|mnab_y|mpa_y|mpb_y|nand_m_y|tg_s_a|y__t22
+ a|clk|ctrl|ctrlb|inv_clk_a|inv_clk_clk_via|tg_d_ctrl|tg_d_ctrl_via|tg_fbm_ctrlb|tg_fbm_ctrlb_via|tg_fbs_ctrl|tg_fbs_ctrl_via|tg_s_ctrlb|tg_s_ctrlb_via__t35
+ a|b|inv_q_a|inv_q_a_via|s|tg_fbs_b|tg_fbs_b_via|tg_s_b|tg_s_b_via__t32
+ g_vss_m1|inv_clk_vss|inv_mc_vss|inv_q_vss|mph_g|nand_m_vss|nand_s2_vss|s1_vss_m1|s2_vss_m1|s3_vss_m1|s4_vss_m1|sb_vss|sr1_vss|sr2_vss|sr3_vss|sr4_vss|sv_vss|tg_d_vss|tg_fbm_vss|tg_fbs_vss|tg_s_vss|vss|vss_link|vss_link_bridge|vss_link_dip|vss_link_m1|vss_x1|vss_x2|vss_x3__t141
+ sky130_fd_pr__nfet_01v8 L=0.15 W=0.42 AS=0.1974 AD=0.1974 PS=1.78 PD=1.78
* device instance $37 r0 *1 92.205,0.21 nfet
X$37
+ a|inv_q_y|inv_q_y_via|inv_q_y_via2|nand_s2_a|nand_s2_a_stub|nand_s2_a_via|nand_s2_a_via2|q|y__t12
+ a|b|inv_q_a|inv_q_a_via|s|tg_fbs_b|tg_fbs_b_via|tg_s_b|tg_s_b_via__t12
+ g_vss_m1|inv_clk_vss|inv_mc_vss|inv_q_vss|mph_g|nand_m_vss|nand_s2_vss|s1_vss_m1|s2_vss_m1|s3_vss_m1|s4_vss_m1|sb_vss|sr1_vss|sr2_vss|sr3_vss|sr4_vss|sv_vss|tg_d_vss|tg_fbm_vss|tg_fbs_vss|tg_s_vss|vss|vss_link|vss_link_bridge|vss_link_dip|vss_link_m1|vss_x1|vss_x2|vss_x3__t59
+ g_vss_m1|inv_clk_vss|inv_mc_vss|inv_q_vss|mph_g|nand_m_vss|nand_s2_vss|s1_vss_m1|s2_vss_m1|s3_vss_m1|s4_vss_m1|sb_vss|sr1_vss|sr2_vss|sr3_vss|sr4_vss|sv_vss|tg_d_vss|tg_fbm_vss|tg_fbs_vss|tg_s_vss|vss|vss_link|vss_link_bridge|vss_link_dip|vss_link_m1|vss_x1|vss_x2|vss_x3__t142
+ sky130_fd_pr__nfet_01v8 L=0.15 W=0.42 AS=0.1974 AD=0.1974 PS=1.78 PD=1.78
* device instance $38 r0 *1 104.69,0.21 nfet
X$38 a|mnab_y|mpa_y|mpb_y|nand_s2_y|qb|tg_fbs_a|y__t22
+ clkb|clkb_bridge1|clkb_bridge2|clkb_mid|clkb_w|ctrl|ctrlb|inv_clk_y|tg_d_ctrlb|tg_fbm_ctrl|tg_fbs_ctrlb|tg_s_ctrl|y__t52
+ a|b|inv_q_a|inv_q_a_via|s|tg_fbs_b|tg_fbs_b_via|tg_s_b|tg_s_b_via__t22
+ g_vss_m1|inv_clk_vss|inv_mc_vss|inv_q_vss|mph_g|nand_m_vss|nand_s2_vss|s1_vss_m1|s2_vss_m1|s3_vss_m1|s4_vss_m1|sb_vss|sr1_vss|sr2_vss|sr3_vss|sr4_vss|sv_vss|tg_d_vss|tg_fbm_vss|tg_fbs_vss|tg_s_vss|vss|vss_link|vss_link_bridge|vss_link_dip|vss_link_m1|vss_x1|vss_x2|vss_x3__t143
+ sky130_fd_pr__nfet_01v8 L=0.15 W=0.42 AS=0.1974 AD=0.1974 PS=1.78 PD=1.78
* device instance $39 r0 *1 111.865,0.21 nfet
X$39
+ clkb|clkb_bridge1|clkb_bridge2|clkb_mid|clkb_w|ctrl|ctrlb|inv_clk_y|tg_d_ctrlb|tg_fbm_ctrl|tg_fbs_ctrlb|tg_s_ctrl|y__t13
+ a|clk|ctrl|ctrlb|inv_clk_a|inv_clk_clk_via|tg_d_ctrl|tg_d_ctrl_via|tg_fbm_ctrlb|tg_fbm_ctrlb_via|tg_fbs_ctrl|tg_fbs_ctrl_via|tg_s_ctrlb|tg_s_ctrlb_via__t34
+ g_vss_m1|inv_clk_vss|inv_mc_vss|inv_q_vss|mph_g|nand_m_vss|nand_s2_vss|s1_vss_m1|s2_vss_m1|s3_vss_m1|s4_vss_m1|sb_vss|sr1_vss|sr2_vss|sr3_vss|sr4_vss|sv_vss|tg_d_vss|tg_fbm_vss|tg_fbs_vss|tg_s_vss|vss|vss_link|vss_link_bridge|vss_link_dip|vss_link_m1|vss_x1|vss_x2|vss_x3__t60
+ g_vss_m1|inv_clk_vss|inv_mc_vss|inv_q_vss|mph_g|nand_m_vss|nand_s2_vss|s1_vss_m1|s2_vss_m1|s3_vss_m1|s4_vss_m1|sb_vss|sr1_vss|sr2_vss|sr3_vss|sr4_vss|sv_vss|tg_d_vss|tg_fbm_vss|tg_fbs_vss|tg_s_vss|vss|vss_link|vss_link_bridge|vss_link_dip|vss_link_m1|vss_x1|vss_x2|vss_x3__t144
+ sky130_fd_pr__nfet_01v8 L=0.15 W=0.42 AS=0.1974 AD=0.1974 PS=1.78 PD=1.78
* device instance $40 r0 *1 116.63,0.21 nfet
X$40 a|d|inva_a|mn12_g0|mp13_g0|ro1|ro1_esc|sr1_d_stub|tg_d_a|y__t4
+ clkb|clkb_bridge1|clkb_bridge2|clkb_mid|clkb_w|ctrl|ctrlb|inv_clk_y|tg_d_ctrlb|tg_fbm_ctrl|tg_fbs_ctrlb|tg_s_ctrl|y__t53
+ a|b|m_east|m_west|nand_m_a|nand_m_a_ext_via|nand_m_a_ext_via2|nand_m_a_stub|tg_d_b|tg_d_b_via|tg_d_b_via2|tg_fbm_b|tg_fbm_b_alt_via|tg_fbm_b_alt_via2__t24
+ g_vss_m1|inv_clk_vss|inv_mc_vss|inv_q_vss|mph_g|nand_m_vss|nand_s2_vss|s1_vss_m1|s2_vss_m1|s3_vss_m1|s4_vss_m1|sb_vss|sr1_vss|sr2_vss|sr3_vss|sr4_vss|sv_vss|tg_d_vss|tg_fbm_vss|tg_fbs_vss|tg_s_vss|vss|vss_link|vss_link_bridge|vss_link_dip|vss_link_m1|vss_x1|vss_x2|vss_x3__t145
+ sky130_fd_pr__nfet_01v8 L=0.15 W=0.42 AS=0.1974 AD=0.1974 PS=1.78 PD=1.78
* device instance $41 r0 *1 131.155,0.21 nfet
X$41 a|inv_mc_y|inv_mc_y_via|mc|tg_fbm_a|tg_fbm_a_via|y__t23
+ a|inv_mc_a|mb|mnab_y|mpa_y|mpb_y|nand_m_y|tg_s_a|y__t43
+ g_vss_m1|inv_clk_vss|inv_mc_vss|inv_q_vss|mph_g|nand_m_vss|nand_s2_vss|s1_vss_m1|s2_vss_m1|s3_vss_m1|s4_vss_m1|sb_vss|sr1_vss|sr2_vss|sr3_vss|sr4_vss|sv_vss|tg_d_vss|tg_fbm_vss|tg_fbs_vss|tg_s_vss|vss|vss_link|vss_link_bridge|vss_link_dip|vss_link_m1|vss_x1|vss_x2|vss_x3__t55
+ g_vss_m1|inv_clk_vss|inv_mc_vss|inv_q_vss|mph_g|nand_m_vss|nand_s2_vss|s1_vss_m1|s2_vss_m1|s3_vss_m1|s4_vss_m1|sb_vss|sr1_vss|sr2_vss|sr3_vss|sr4_vss|sv_vss|tg_d_vss|tg_fbm_vss|tg_fbs_vss|tg_s_vss|vss|vss_link|vss_link_bridge|vss_link_dip|vss_link_m1|vss_x1|vss_x2|vss_x3__t146
+ sky130_fd_pr__nfet_01v8 L=0.15 W=0.42 AS=0.1974 AD=0.1974 PS=1.78 PD=1.78
* device instance $42 r0 *1 135.92,0.21 nfet
X$42 a|inv_mc_y|inv_mc_y_via|mc|tg_fbm_a|tg_fbm_a_via|y__t33
+ a|clk|ctrl|ctrlb|inv_clk_a|inv_clk_clk_via|tg_d_ctrl|tg_d_ctrl_via|tg_fbm_ctrlb|tg_fbm_ctrlb_via|tg_fbs_ctrl|tg_fbs_ctrl_via|tg_s_ctrlb|tg_s_ctrlb_via__t33
+ a|b|m_east|m_west|nand_m_a|nand_m_a_ext_via|nand_m_a_ext_via2|nand_m_a_stub|tg_d_b|tg_d_b_via|tg_d_b_via2|tg_fbm_b|tg_fbm_b_alt_via|tg_fbm_b_alt_via2__t14
+ g_vss_m1|inv_clk_vss|inv_mc_vss|inv_q_vss|mph_g|nand_m_vss|nand_s2_vss|s1_vss_m1|s2_vss_m1|s3_vss_m1|s4_vss_m1|sb_vss|sr1_vss|sr2_vss|sr3_vss|sr4_vss|sv_vss|tg_d_vss|tg_fbm_vss|tg_fbs_vss|tg_s_vss|vss|vss_link|vss_link_bridge|vss_link_dip|vss_link_m1|vss_x1|vss_x2|vss_x3__t147
+ sky130_fd_pr__nfet_01v8 L=0.15 W=0.42 AS=0.1974 AD=0.1974 PS=1.78 PD=1.78
* device instance $43 r0 *1 141.06,0.21 nfet
X$43 a|inv_mc_a|mb|mnab_y|mpa_y|mpb_y|nand_m_y|tg_s_a|y__t23
+ a|clk|ctrl|ctrlb|inv_clk_a|inv_clk_clk_via|tg_d_ctrl|tg_d_ctrl_via|tg_fbm_ctrlb|tg_fbm_ctrlb_via|tg_fbs_ctrl|tg_fbs_ctrl_via|tg_s_ctrlb|tg_s_ctrlb_via__t32
+ a|b|inv_q_a|inv_q_a_via|s|tg_fbs_b|tg_fbs_b_via|tg_s_b|tg_s_b_via__t33
+ g_vss_m1|inv_clk_vss|inv_mc_vss|inv_q_vss|mph_g|nand_m_vss|nand_s2_vss|s1_vss_m1|s2_vss_m1|s3_vss_m1|s4_vss_m1|sb_vss|sr1_vss|sr2_vss|sr3_vss|sr4_vss|sv_vss|tg_d_vss|tg_fbm_vss|tg_fbs_vss|tg_s_vss|vss|vss_link|vss_link_bridge|vss_link_dip|vss_link_m1|vss_x1|vss_x2|vss_x3__t148
+ sky130_fd_pr__nfet_01v8 L=0.15 W=0.42 AS=0.1974 AD=0.1974 PS=1.78 PD=1.78
* device instance $44 r0 *1 147.865,0.21 nfet
X$44
+ a|inv_q_y|inv_q_y_via|inv_q_y_via2|nand_s2_a|nand_s2_a_stub|nand_s2_a_via|nand_s2_a_via2|q|y__t13
+ a|b|inv_q_a|inv_q_a_via|s|tg_fbs_b|tg_fbs_b_via|tg_s_b|tg_s_b_via__t13
+ g_vss_m1|inv_clk_vss|inv_mc_vss|inv_q_vss|mph_g|nand_m_vss|nand_s2_vss|s1_vss_m1|s2_vss_m1|s3_vss_m1|s4_vss_m1|sb_vss|sr1_vss|sr2_vss|sr3_vss|sr4_vss|sv_vss|tg_d_vss|tg_fbm_vss|tg_fbs_vss|tg_s_vss|vss|vss_link|vss_link_bridge|vss_link_dip|vss_link_m1|vss_x1|vss_x2|vss_x3__t57
+ g_vss_m1|inv_clk_vss|inv_mc_vss|inv_q_vss|mph_g|nand_m_vss|nand_s2_vss|s1_vss_m1|s2_vss_m1|s3_vss_m1|s4_vss_m1|sb_vss|sr1_vss|sr2_vss|sr3_vss|sr4_vss|sv_vss|tg_d_vss|tg_fbm_vss|tg_fbs_vss|tg_s_vss|vss|vss_link|vss_link_bridge|vss_link_dip|vss_link_m1|vss_x1|vss_x2|vss_x3__t149
+ sky130_fd_pr__nfet_01v8 L=0.15 W=0.42 AS=0.1974 AD=0.1974 PS=1.78 PD=1.78
* device instance $45 r0 *1 160.35,0.21 nfet
X$45 a|mnab_y|mpa_y|mpb_y|nand_s2_y|qb|tg_fbs_a|y__t23
+ clkb|clkb_bridge1|clkb_bridge2|clkb_mid|clkb_w|ctrl|ctrlb|inv_clk_y|tg_d_ctrlb|tg_fbm_ctrl|tg_fbs_ctrlb|tg_s_ctrl|y__t43
+ a|b|inv_q_a|inv_q_a_via|s|tg_fbs_b|tg_fbs_b_via|tg_s_b|tg_s_b_via__t23
+ g_vss_m1|inv_clk_vss|inv_mc_vss|inv_q_vss|mph_g|nand_m_vss|nand_s2_vss|s1_vss_m1|s2_vss_m1|s3_vss_m1|s4_vss_m1|sb_vss|sr1_vss|sr2_vss|sr3_vss|sr4_vss|sv_vss|tg_d_vss|tg_fbm_vss|tg_fbs_vss|tg_s_vss|vss|vss_link|vss_link_bridge|vss_link_dip|vss_link_m1|vss_x1|vss_x2|vss_x3__t150
+ sky130_fd_pr__nfet_01v8 L=0.15 W=0.42 AS=0.1974 AD=0.1974 PS=1.78 PD=1.78
* device instance $46 r0 *1 167.525,0.21 nfet
X$46
+ clkb|clkb_bridge1|clkb_bridge2|clkb_mid|clkb_w|ctrl|ctrlb|inv_clk_y|tg_d_ctrlb|tg_fbm_ctrl|tg_fbs_ctrlb|tg_s_ctrl|y__t14
+ a|clk|ctrl|ctrlb|inv_clk_a|inv_clk_clk_via|tg_d_ctrl|tg_d_ctrl_via|tg_fbm_ctrlb|tg_fbm_ctrlb_via|tg_fbs_ctrl|tg_fbs_ctrl_via|tg_s_ctrlb|tg_s_ctrlb_via__t23
+ g_vss_m1|inv_clk_vss|inv_mc_vss|inv_q_vss|mph_g|nand_m_vss|nand_s2_vss|s1_vss_m1|s2_vss_m1|s3_vss_m1|s4_vss_m1|sb_vss|sr1_vss|sr2_vss|sr3_vss|sr4_vss|sv_vss|tg_d_vss|tg_fbm_vss|tg_fbs_vss|tg_s_vss|vss|vss_link|vss_link_bridge|vss_link_dip|vss_link_m1|vss_x1|vss_x2|vss_x3__t46
+ g_vss_m1|inv_clk_vss|inv_mc_vss|inv_q_vss|mph_g|nand_m_vss|nand_s2_vss|s1_vss_m1|s2_vss_m1|s3_vss_m1|s4_vss_m1|sb_vss|sr1_vss|sr2_vss|sr3_vss|sr4_vss|sv_vss|tg_d_vss|tg_fbm_vss|tg_fbs_vss|tg_s_vss|vss|vss_link|vss_link_bridge|vss_link_dip|vss_link_m1|vss_x1|vss_x2|vss_x3__t151
+ sky130_fd_pr__nfet_01v8 L=0.15 W=0.42 AS=0.1974 AD=0.1974 PS=1.78 PD=1.78
* device instance $47 r0 *1 172.29,0.21 nfet
X$47 a|b|d|invb_a|mn12_g1|mp24_g0|ro2|ro2_esc|sr2_d_stub|tg_d_a|y__t3
+ clkb|clkb_bridge1|clkb_bridge2|clkb_mid|clkb_w|ctrl|ctrlb|inv_clk_y|tg_d_ctrlb|tg_fbm_ctrl|tg_fbs_ctrlb|tg_s_ctrl|y__t54
+ a|b|m_east|m_west|nand_m_a|nand_m_a_ext_via|nand_m_a_ext_via2|nand_m_a_stub|tg_d_b|tg_d_b_via|tg_d_b_via2|tg_fbm_b|tg_fbm_b_alt_via|tg_fbm_b_alt_via2__t25
+ g_vss_m1|inv_clk_vss|inv_mc_vss|inv_q_vss|mph_g|nand_m_vss|nand_s2_vss|s1_vss_m1|s2_vss_m1|s3_vss_m1|s4_vss_m1|sb_vss|sr1_vss|sr2_vss|sr3_vss|sr4_vss|sv_vss|tg_d_vss|tg_fbm_vss|tg_fbs_vss|tg_s_vss|vss|vss_link|vss_link_bridge|vss_link_dip|vss_link_m1|vss_x1|vss_x2|vss_x3__t152
+ sky130_fd_pr__nfet_01v8 L=0.15 W=0.42 AS=0.1974 AD=0.1974 PS=1.78 PD=1.78
* device instance $48 r0 *1 186.815,0.21 nfet
X$48 a|inv_mc_y|inv_mc_y_via|mc|tg_fbm_a|tg_fbm_a_via|y__t34
+ a|inv_mc_a|mb|mnab_y|mpa_y|mpb_y|nand_m_y|tg_s_a|y__t44
+ g_vss_m1|inv_clk_vss|inv_mc_vss|inv_q_vss|mph_g|nand_m_vss|nand_s2_vss|s1_vss_m1|s2_vss_m1|s3_vss_m1|s4_vss_m1|sb_vss|sr1_vss|sr2_vss|sr3_vss|sr4_vss|sv_vss|tg_d_vss|tg_fbm_vss|tg_fbs_vss|tg_s_vss|vss|vss_link|vss_link_bridge|vss_link_dip|vss_link_m1|vss_x1|vss_x2|vss_x3__t45
+ g_vss_m1|inv_clk_vss|inv_mc_vss|inv_q_vss|mph_g|nand_m_vss|nand_s2_vss|s1_vss_m1|s2_vss_m1|s3_vss_m1|s4_vss_m1|sb_vss|sr1_vss|sr2_vss|sr3_vss|sr4_vss|sv_vss|tg_d_vss|tg_fbm_vss|tg_fbs_vss|tg_s_vss|vss|vss_link|vss_link_bridge|vss_link_dip|vss_link_m1|vss_x1|vss_x2|vss_x3__t153
+ sky130_fd_pr__nfet_01v8 L=0.15 W=0.42 AS=0.1974 AD=0.1974 PS=1.78 PD=1.78
* device instance $49 r0 *1 191.58,0.21 nfet
X$49 a|inv_mc_y|inv_mc_y_via|mc|tg_fbm_a|tg_fbm_a_via|y__t24
+ a|clk|ctrl|ctrlb|inv_clk_a|inv_clk_clk_via|tg_d_ctrl|tg_d_ctrl_via|tg_fbm_ctrlb|tg_fbm_ctrlb_via|tg_fbs_ctrl|tg_fbs_ctrl_via|tg_s_ctrlb|tg_s_ctrlb_via__t22
+ a|b|m_east|m_west|nand_m_a|nand_m_a_ext_via|nand_m_a_ext_via2|nand_m_a_stub|tg_d_b|tg_d_b_via|tg_d_b_via2|tg_fbm_b|tg_fbm_b_alt_via|tg_fbm_b_alt_via2__t15
+ g_vss_m1|inv_clk_vss|inv_mc_vss|inv_q_vss|mph_g|nand_m_vss|nand_s2_vss|s1_vss_m1|s2_vss_m1|s3_vss_m1|s4_vss_m1|sb_vss|sr1_vss|sr2_vss|sr3_vss|sr4_vss|sv_vss|tg_d_vss|tg_fbm_vss|tg_fbs_vss|tg_s_vss|vss|vss_link|vss_link_bridge|vss_link_dip|vss_link_m1|vss_x1|vss_x2|vss_x3__t154
+ sky130_fd_pr__nfet_01v8 L=0.15 W=0.42 AS=0.1974 AD=0.1974 PS=1.78 PD=1.78
* device instance $50 r0 *1 196.72,0.21 nfet
X$50 a|inv_mc_a|mb|mnab_y|mpa_y|mpb_y|nand_m_y|tg_s_a|y__t24
+ a|clk|ctrl|ctrlb|inv_clk_a|inv_clk_clk_via|tg_d_ctrl|tg_d_ctrl_via|tg_fbm_ctrlb|tg_fbm_ctrlb_via|tg_fbs_ctrl|tg_fbs_ctrl_via|tg_s_ctrlb|tg_s_ctrlb_via__t21
+ a|b|inv_q_a|inv_q_a_via|s|tg_fbs_b|tg_fbs_b_via|tg_s_b|tg_s_b_via__t34
+ g_vss_m1|inv_clk_vss|inv_mc_vss|inv_q_vss|mph_g|nand_m_vss|nand_s2_vss|s1_vss_m1|s2_vss_m1|s3_vss_m1|s4_vss_m1|sb_vss|sr1_vss|sr2_vss|sr3_vss|sr4_vss|sv_vss|tg_d_vss|tg_fbm_vss|tg_fbs_vss|tg_s_vss|vss|vss_link|vss_link_bridge|vss_link_dip|vss_link_m1|vss_x1|vss_x2|vss_x3__t155
+ sky130_fd_pr__nfet_01v8 L=0.15 W=0.42 AS=0.1974 AD=0.1974 PS=1.78 PD=1.78
* device instance $51 r0 *1 203.525,0.21 nfet
X$51
+ a|inv_q_y|inv_q_y_via|inv_q_y_via2|nand_s2_a|nand_s2_a_stub|nand_s2_a_via|nand_s2_a_via2|q|y__t14
+ a|b|inv_q_a|inv_q_a_via|s|tg_fbs_b|tg_fbs_b_via|tg_s_b|tg_s_b_via__t14
+ g_vss_m1|inv_clk_vss|inv_mc_vss|inv_q_vss|mph_g|nand_m_vss|nand_s2_vss|s1_vss_m1|s2_vss_m1|s3_vss_m1|s4_vss_m1|sb_vss|sr1_vss|sr2_vss|sr3_vss|sr4_vss|sv_vss|tg_d_vss|tg_fbm_vss|tg_fbs_vss|tg_s_vss|vss|vss_link|vss_link_bridge|vss_link_dip|vss_link_m1|vss_x1|vss_x2|vss_x3__t44
+ g_vss_m1|inv_clk_vss|inv_mc_vss|inv_q_vss|mph_g|nand_m_vss|nand_s2_vss|s1_vss_m1|s2_vss_m1|s3_vss_m1|s4_vss_m1|sb_vss|sr1_vss|sr2_vss|sr3_vss|sr4_vss|sv_vss|tg_d_vss|tg_fbm_vss|tg_fbs_vss|tg_s_vss|vss|vss_link|vss_link_bridge|vss_link_dip|vss_link_m1|vss_x1|vss_x2|vss_x3__t156
+ sky130_fd_pr__nfet_01v8 L=0.15 W=0.42 AS=0.1974 AD=0.1974 PS=1.78 PD=1.78
* device instance $52 r0 *1 216.01,0.21 nfet
X$52 a|mnab_y|mpa_y|mpb_y|nand_s2_y|qb|tg_fbs_a|y__t24
+ clkb|clkb_bridge1|clkb_bridge2|clkb_mid|clkb_w|ctrl|ctrlb|inv_clk_y|tg_d_ctrlb|tg_fbm_ctrl|tg_fbs_ctrlb|tg_s_ctrl|y__t44
+ a|b|inv_q_a|inv_q_a_via|s|tg_fbs_b|tg_fbs_b_via|tg_s_b|tg_s_b_via__t24
+ g_vss_m1|inv_clk_vss|inv_mc_vss|inv_q_vss|mph_g|nand_m_vss|nand_s2_vss|s1_vss_m1|s2_vss_m1|s3_vss_m1|s4_vss_m1|sb_vss|sr1_vss|sr2_vss|sr3_vss|sr4_vss|sv_vss|tg_d_vss|tg_fbm_vss|tg_fbs_vss|tg_s_vss|vss|vss_link|vss_link_bridge|vss_link_dip|vss_link_m1|vss_x1|vss_x2|vss_x3__t157
+ sky130_fd_pr__nfet_01v8 L=0.15 W=0.42 AS=0.1974 AD=0.1974 PS=1.78 PD=1.78
* device instance $53 r0 *1 223.185,0.21 nfet
X$53
+ clkb|clkb_bridge1|clkb_bridge2|clkb_mid|clkb_w|ctrl|ctrlb|inv_clk_y|tg_d_ctrlb|tg_fbm_ctrl|tg_fbs_ctrlb|tg_s_ctrl|y__t15
+ a|clk|ctrl|ctrlb|inv_clk_a|inv_clk_clk_via|tg_d_ctrl|tg_d_ctrl_via|tg_fbm_ctrlb|tg_fbm_ctrlb_via|tg_fbs_ctrl|tg_fbs_ctrl_via|tg_s_ctrlb|tg_s_ctrlb_via__t20
+ g_vss_m1|inv_clk_vss|inv_mc_vss|inv_q_vss|mph_g|nand_m_vss|nand_s2_vss|s1_vss_m1|s2_vss_m1|s3_vss_m1|s4_vss_m1|sb_vss|sr1_vss|sr2_vss|sr3_vss|sr4_vss|sv_vss|tg_d_vss|tg_fbm_vss|tg_fbs_vss|tg_s_vss|vss|vss_link|vss_link_bridge|vss_link_dip|vss_link_m1|vss_x1|vss_x2|vss_x3__t43
+ g_vss_m1|inv_clk_vss|inv_mc_vss|inv_q_vss|mph_g|nand_m_vss|nand_s2_vss|s1_vss_m1|s2_vss_m1|s3_vss_m1|s4_vss_m1|sb_vss|sr1_vss|sr2_vss|sr3_vss|sr4_vss|sv_vss|tg_d_vss|tg_fbm_vss|tg_fbs_vss|tg_s_vss|vss|vss_link|vss_link_bridge|vss_link_dip|vss_link_m1|vss_x1|vss_x2|vss_x3__t158
+ sky130_fd_pr__nfet_01v8 L=0.15 W=0.42 AS=0.1974 AD=0.1974 PS=1.78 PD=1.78
* device instance $54 r0 *1 227.95,0.21 nfet
X$54
+ a|d|inva_a|mn12_g0|mp13_g0|ro3|ro3_esc_e|ro3_esc_w|ro3_hop|sr3_d_stub|tg_d_a|y__t3
+ clkb|clkb_bridge1|clkb_bridge2|clkb_mid|clkb_w|ctrl|ctrlb|inv_clk_y|tg_d_ctrlb|tg_fbm_ctrl|tg_fbs_ctrlb|tg_s_ctrl|y__t45
+ a|b|m_east|m_west|nand_m_a|nand_m_a_ext_via|nand_m_a_ext_via2|nand_m_a_stub|tg_d_b|tg_d_b_via|tg_d_b_via2|tg_fbm_b|tg_fbm_b_alt_via|tg_fbm_b_alt_via2__t16
+ g_vss_m1|inv_clk_vss|inv_mc_vss|inv_q_vss|mph_g|nand_m_vss|nand_s2_vss|s1_vss_m1|s2_vss_m1|s3_vss_m1|s4_vss_m1|sb_vss|sr1_vss|sr2_vss|sr3_vss|sr4_vss|sv_vss|tg_d_vss|tg_fbm_vss|tg_fbs_vss|tg_s_vss|vss|vss_link|vss_link_bridge|vss_link_dip|vss_link_m1|vss_x1|vss_x2|vss_x3__t159
+ sky130_fd_pr__nfet_01v8 L=0.15 W=0.42 AS=0.1974 AD=0.1974 PS=1.78 PD=1.78
* device instance $55 r0 *1 242.475,0.21 nfet
X$55 a|inv_mc_y|inv_mc_y_via|mc|tg_fbm_a|tg_fbm_a_via|y__t25
+ a|inv_mc_a|mb|mnab_y|mpa_y|mpb_y|nand_m_y|tg_s_a|y__t45
+ g_vss_m1|inv_clk_vss|inv_mc_vss|inv_q_vss|mph_g|nand_m_vss|nand_s2_vss|s1_vss_m1|s2_vss_m1|s3_vss_m1|s4_vss_m1|sb_vss|sr1_vss|sr2_vss|sr3_vss|sr4_vss|sv_vss|tg_d_vss|tg_fbm_vss|tg_fbs_vss|tg_s_vss|vss|vss_link|vss_link_bridge|vss_link_dip|vss_link_m1|vss_x1|vss_x2|vss_x3__t42
+ g_vss_m1|inv_clk_vss|inv_mc_vss|inv_q_vss|mph_g|nand_m_vss|nand_s2_vss|s1_vss_m1|s2_vss_m1|s3_vss_m1|s4_vss_m1|sb_vss|sr1_vss|sr2_vss|sr3_vss|sr4_vss|sv_vss|tg_d_vss|tg_fbm_vss|tg_fbs_vss|tg_s_vss|vss|vss_link|vss_link_bridge|vss_link_dip|vss_link_m1|vss_x1|vss_x2|vss_x3__t160
+ sky130_fd_pr__nfet_01v8 L=0.15 W=0.42 AS=0.1974 AD=0.1974 PS=1.78 PD=1.78
* device instance $56 r0 *1 247.24,0.21 nfet
X$56 a|inv_mc_y|inv_mc_y_via|mc|tg_fbm_a|tg_fbm_a_via|y__t35
+ a|clk|ctrl|ctrlb|inv_clk_a|inv_clk_clk_via|tg_d_ctrl|tg_d_ctrl_via|tg_fbm_ctrlb|tg_fbm_ctrlb_via|tg_fbs_ctrl|tg_fbs_ctrl_via|tg_s_ctrlb|tg_s_ctrlb_via__t19
+ a|b|m_east|m_west|nand_m_a|nand_m_a_ext_via|nand_m_a_ext_via2|nand_m_a_stub|tg_d_b|tg_d_b_via|tg_d_b_via2|tg_fbm_b|tg_fbm_b_alt_via|tg_fbm_b_alt_via2__t26
+ g_vss_m1|inv_clk_vss|inv_mc_vss|inv_q_vss|mph_g|nand_m_vss|nand_s2_vss|s1_vss_m1|s2_vss_m1|s3_vss_m1|s4_vss_m1|sb_vss|sr1_vss|sr2_vss|sr3_vss|sr4_vss|sv_vss|tg_d_vss|tg_fbm_vss|tg_fbs_vss|tg_s_vss|vss|vss_link|vss_link_bridge|vss_link_dip|vss_link_m1|vss_x1|vss_x2|vss_x3__t161
+ sky130_fd_pr__nfet_01v8 L=0.15 W=0.42 AS=0.1974 AD=0.1974 PS=1.78 PD=1.78
* device instance $57 r0 *1 252.38,0.21 nfet
X$57 a|inv_mc_a|mb|mnab_y|mpa_y|mpb_y|nand_m_y|tg_s_a|y__t25
+ a|clk|ctrl|ctrlb|inv_clk_a|inv_clk_clk_via|tg_d_ctrl|tg_d_ctrl_via|tg_fbm_ctrlb|tg_fbm_ctrlb_via|tg_fbs_ctrl|tg_fbs_ctrl_via|tg_s_ctrlb|tg_s_ctrlb_via__t24
+ a|b|inv_q_a|inv_q_a_via|s|tg_fbs_b|tg_fbs_b_via|tg_s_b|tg_s_b_via__t25
+ g_vss_m1|inv_clk_vss|inv_mc_vss|inv_q_vss|mph_g|nand_m_vss|nand_s2_vss|s1_vss_m1|s2_vss_m1|s3_vss_m1|s4_vss_m1|sb_vss|sr1_vss|sr2_vss|sr3_vss|sr4_vss|sv_vss|tg_d_vss|tg_fbm_vss|tg_fbs_vss|tg_s_vss|vss|vss_link|vss_link_bridge|vss_link_dip|vss_link_m1|vss_x1|vss_x2|vss_x3__t162
+ sky130_fd_pr__nfet_01v8 L=0.15 W=0.42 AS=0.1974 AD=0.1974 PS=1.78 PD=1.78
* device instance $58 r0 *1 259.185,0.21 nfet
X$58
+ a|inv_q_y|inv_q_y_via|inv_q_y_via2|nand_s2_a|nand_s2_a_stub|nand_s2_a_via|nand_s2_a_via2|q|y__t15
+ a|b|inv_q_a|inv_q_a_via|s|tg_fbs_b|tg_fbs_b_via|tg_s_b|tg_s_b_via__t15
+ g_vss_m1|inv_clk_vss|inv_mc_vss|inv_q_vss|mph_g|nand_m_vss|nand_s2_vss|s1_vss_m1|s2_vss_m1|s3_vss_m1|s4_vss_m1|sb_vss|sr1_vss|sr2_vss|sr3_vss|sr4_vss|sv_vss|tg_d_vss|tg_fbm_vss|tg_fbs_vss|tg_s_vss|vss|vss_link|vss_link_bridge|vss_link_dip|vss_link_m1|vss_x1|vss_x2|vss_x3__t49
+ g_vss_m1|inv_clk_vss|inv_mc_vss|inv_q_vss|mph_g|nand_m_vss|nand_s2_vss|s1_vss_m1|s2_vss_m1|s3_vss_m1|s4_vss_m1|sb_vss|sr1_vss|sr2_vss|sr3_vss|sr4_vss|sv_vss|tg_d_vss|tg_fbm_vss|tg_fbs_vss|tg_s_vss|vss|vss_link|vss_link_bridge|vss_link_dip|vss_link_m1|vss_x1|vss_x2|vss_x3__t163
+ sky130_fd_pr__nfet_01v8 L=0.15 W=0.42 AS=0.1974 AD=0.1974 PS=1.78 PD=1.78
* device instance $59 r0 *1 271.67,0.21 nfet
X$59 a|mnab_y|mpa_y|mpb_y|nand_s2_y|qb|tg_fbs_a|y__t25
+ clkb|clkb_bridge1|clkb_bridge2|clkb_mid|clkb_w|ctrl|ctrlb|inv_clk_y|tg_d_ctrlb|tg_fbm_ctrl|tg_fbs_ctrlb|tg_s_ctrl|y__t55
+ a|b|inv_q_a|inv_q_a_via|s|tg_fbs_b|tg_fbs_b_via|tg_s_b|tg_s_b_via__t35
+ g_vss_m1|inv_clk_vss|inv_mc_vss|inv_q_vss|mph_g|nand_m_vss|nand_s2_vss|s1_vss_m1|s2_vss_m1|s3_vss_m1|s4_vss_m1|sb_vss|sr1_vss|sr2_vss|sr3_vss|sr4_vss|sv_vss|tg_d_vss|tg_fbm_vss|tg_fbs_vss|tg_s_vss|vss|vss_link|vss_link_bridge|vss_link_dip|vss_link_m1|vss_x1|vss_x2|vss_x3__t164
+ sky130_fd_pr__nfet_01v8 L=0.15 W=0.42 AS=0.1974 AD=0.1974 PS=1.78 PD=1.78
* device instance $60 r0 *1 278.845,0.21 nfet
X$60
+ clkb|clkb_bridge1|clkb_bridge2|clkb_mid|clkb_w|ctrl|ctrlb|inv_clk_y|tg_d_ctrlb|tg_fbm_ctrl|tg_fbs_ctrlb|tg_s_ctrl|y__t16
+ a|clk|ctrl|ctrlb|inv_clk_a|inv_clk_clk_via|tg_d_ctrl|tg_d_ctrl_via|tg_fbm_ctrlb|tg_fbm_ctrlb_via|tg_fbs_ctrl|tg_fbs_ctrl_via|tg_s_ctrlb|tg_s_ctrlb_via__t25
+ g_vss_m1|inv_clk_vss|inv_mc_vss|inv_q_vss|mph_g|nand_m_vss|nand_s2_vss|s1_vss_m1|s2_vss_m1|s3_vss_m1|s4_vss_m1|sb_vss|sr1_vss|sr2_vss|sr3_vss|sr4_vss|sv_vss|tg_d_vss|tg_fbm_vss|tg_fbs_vss|tg_s_vss|vss|vss_link|vss_link_bridge|vss_link_dip|vss_link_m1|vss_x1|vss_x2|vss_x3__t50
+ g_vss_m1|inv_clk_vss|inv_mc_vss|inv_q_vss|mph_g|nand_m_vss|nand_s2_vss|s1_vss_m1|s2_vss_m1|s3_vss_m1|s4_vss_m1|sb_vss|sr1_vss|sr2_vss|sr3_vss|sr4_vss|sv_vss|tg_d_vss|tg_fbm_vss|tg_fbs_vss|tg_s_vss|vss|vss_link|vss_link_bridge|vss_link_dip|vss_link_m1|vss_x1|vss_x2|vss_x3__t165
+ sky130_fd_pr__nfet_01v8 L=0.15 W=0.42 AS=0.1974 AD=0.1974 PS=1.78 PD=1.78
* device instance $61 r0 *1 283.61,0.21 nfet
X$61 a|b|d|invb_a|mn12_g1|mp24_g0|ro4|ro4_esc|sr4_d_stub|tg_d_a|y__t4
+ clkb|clkb_bridge1|clkb_bridge2|clkb_mid|clkb_w|ctrl|ctrlb|inv_clk_y|tg_d_ctrlb|tg_fbm_ctrl|tg_fbs_ctrlb|tg_s_ctrl|y__t56
+ a|b|m_east|m_west|nand_m_a|nand_m_a_ext_via|nand_m_a_ext_via2|nand_m_a_stub|tg_d_b|tg_d_b_via|tg_d_b_via2|tg_fbm_b|tg_fbm_b_alt_via|tg_fbm_b_alt_via2__t1
+ g_vss_m1|inv_clk_vss|inv_mc_vss|inv_q_vss|mph_g|nand_m_vss|nand_s2_vss|s1_vss_m1|s2_vss_m1|s3_vss_m1|s4_vss_m1|sb_vss|sr1_vss|sr2_vss|sr3_vss|sr4_vss|sv_vss|tg_d_vss|tg_fbm_vss|tg_fbs_vss|tg_s_vss|vss|vss_link|vss_link_bridge|vss_link_dip|vss_link_m1|vss_x1|vss_x2|vss_x3__t166
+ sky130_fd_pr__nfet_01v8 L=0.15 W=0.42 AS=0.1974 AD=0.1974 PS=1.78 PD=1.78
* device instance $62 r0 *1 298.135,0.21 nfet
X$62 a|inv_mc_y|inv_mc_y_via|mc|tg_fbm_a|tg_fbm_a_via|y__t26
+ a|inv_mc_a|mb|mnab_y|mpa_y|mpb_y|nand_m_y|tg_s_a|y__t46
+ g_vss_m1|inv_clk_vss|inv_mc_vss|inv_q_vss|mph_g|nand_m_vss|nand_s2_vss|s1_vss_m1|s2_vss_m1|s3_vss_m1|s4_vss_m1|sb_vss|sr1_vss|sr2_vss|sr3_vss|sr4_vss|sv_vss|tg_d_vss|tg_fbm_vss|tg_fbs_vss|tg_s_vss|vss|vss_link|vss_link_bridge|vss_link_dip|vss_link_m1|vss_x1|vss_x2|vss_x3__t51
+ g_vss_m1|inv_clk_vss|inv_mc_vss|inv_q_vss|mph_g|nand_m_vss|nand_s2_vss|s1_vss_m1|s2_vss_m1|s3_vss_m1|s4_vss_m1|sb_vss|sr1_vss|sr2_vss|sr3_vss|sr4_vss|sv_vss|tg_d_vss|tg_fbm_vss|tg_fbs_vss|tg_s_vss|vss|vss_link|vss_link_bridge|vss_link_dip|vss_link_m1|vss_x1|vss_x2|vss_x3__t167
+ sky130_fd_pr__nfet_01v8 L=0.15 W=0.42 AS=0.1974 AD=0.1974 PS=1.78 PD=1.78
* device instance $63 r0 *1 302.9,0.21 nfet
X$63 a|inv_mc_y|inv_mc_y_via|mc|tg_fbm_a|tg_fbm_a_via|y__t36
+ a|clk|ctrl|ctrlb|inv_clk_a|inv_clk_clk_via|tg_d_ctrl|tg_d_ctrl_via|tg_fbm_ctrlb|tg_fbm_ctrlb_via|tg_fbs_ctrl|tg_fbs_ctrl_via|tg_s_ctrlb|tg_s_ctrlb_via__t26
+ a|b|m_east|m_west|nand_m_a|nand_m_a_ext_via|nand_m_a_ext_via2|nand_m_a_stub|tg_d_b|tg_d_b_via|tg_d_b_via2|tg_fbm_b|tg_fbm_b_alt_via|tg_fbm_b_alt_via2__t2
+ g_vss_m1|inv_clk_vss|inv_mc_vss|inv_q_vss|mph_g|nand_m_vss|nand_s2_vss|s1_vss_m1|s2_vss_m1|s3_vss_m1|s4_vss_m1|sb_vss|sr1_vss|sr2_vss|sr3_vss|sr4_vss|sv_vss|tg_d_vss|tg_fbm_vss|tg_fbs_vss|tg_s_vss|vss|vss_link|vss_link_bridge|vss_link_dip|vss_link_m1|vss_x1|vss_x2|vss_x3__t168
+ sky130_fd_pr__nfet_01v8 L=0.15 W=0.42 AS=0.1974 AD=0.1974 PS=1.78 PD=1.78
* device instance $64 r0 *1 308.04,0.21 nfet
X$64 a|inv_mc_a|mb|mnab_y|mpa_y|mpb_y|nand_m_y|tg_s_a|y__t26
+ a|clk|ctrl|ctrlb|inv_clk_a|inv_clk_clk_via|tg_d_ctrl|tg_d_ctrl_via|tg_fbm_ctrlb|tg_fbm_ctrlb_via|tg_fbs_ctrl|tg_fbs_ctrl_via|tg_s_ctrlb|tg_s_ctrlb_via__t27
+ a|b|inv_q_a|inv_q_a_via|s|tg_fbs_b|tg_fbs_b_via|tg_s_b|tg_s_b_via__t36
+ g_vss_m1|inv_clk_vss|inv_mc_vss|inv_q_vss|mph_g|nand_m_vss|nand_s2_vss|s1_vss_m1|s2_vss_m1|s3_vss_m1|s4_vss_m1|sb_vss|sr1_vss|sr2_vss|sr3_vss|sr4_vss|sv_vss|tg_d_vss|tg_fbm_vss|tg_fbs_vss|tg_s_vss|vss|vss_link|vss_link_bridge|vss_link_dip|vss_link_m1|vss_x1|vss_x2|vss_x3__t169
+ sky130_fd_pr__nfet_01v8 L=0.15 W=0.42 AS=0.1974 AD=0.1974 PS=1.78 PD=1.78
* device instance $65 r0 *1 314.845,0.21 nfet
X$65
+ a|inv_q_y|inv_q_y_via|inv_q_y_via2|nand_s2_a|nand_s2_a_stub|nand_s2_a_via|nand_s2_a_via2|q|y__t16
+ a|b|inv_q_a|inv_q_a_via|s|tg_fbs_b|tg_fbs_b_via|tg_s_b|tg_s_b_via__t16
+ g_vss_m1|inv_clk_vss|inv_mc_vss|inv_q_vss|mph_g|nand_m_vss|nand_s2_vss|s1_vss_m1|s2_vss_m1|s3_vss_m1|s4_vss_m1|sb_vss|sr1_vss|sr2_vss|sr3_vss|sr4_vss|sv_vss|tg_d_vss|tg_fbm_vss|tg_fbs_vss|tg_s_vss|vss|vss_link|vss_link_bridge|vss_link_dip|vss_link_m1|vss_x1|vss_x2|vss_x3__t48
+ g_vss_m1|inv_clk_vss|inv_mc_vss|inv_q_vss|mph_g|nand_m_vss|nand_s2_vss|s1_vss_m1|s2_vss_m1|s3_vss_m1|s4_vss_m1|sb_vss|sr1_vss|sr2_vss|sr3_vss|sr4_vss|sv_vss|tg_d_vss|tg_fbm_vss|tg_fbs_vss|tg_s_vss|vss|vss_link|vss_link_bridge|vss_link_dip|vss_link_m1|vss_x1|vss_x2|vss_x3__t170
+ sky130_fd_pr__nfet_01v8 L=0.15 W=0.42 AS=0.1974 AD=0.1974 PS=1.78 PD=1.78
* device instance $66 r0 *1 327.33,0.21 nfet
X$66 a|mnab_y|mpa_y|mpb_y|nand_s2_y|qb|tg_fbs_a|y__t26
+ clkb|clkb_bridge1|clkb_bridge2|clkb_mid|clkb_w|ctrl|ctrlb|inv_clk_y|tg_d_ctrlb|tg_fbm_ctrl|tg_fbs_ctrlb|tg_s_ctrl|y__t46
+ a|b|inv_q_a|inv_q_a_via|s|tg_fbs_b|tg_fbs_b_via|tg_s_b|tg_s_b_via__t26
+ g_vss_m1|inv_clk_vss|inv_mc_vss|inv_q_vss|mph_g|nand_m_vss|nand_s2_vss|s1_vss_m1|s2_vss_m1|s3_vss_m1|s4_vss_m1|sb_vss|sr1_vss|sr2_vss|sr3_vss|sr4_vss|sv_vss|tg_d_vss|tg_fbm_vss|tg_fbs_vss|tg_s_vss|vss|vss_link|vss_link_bridge|vss_link_dip|vss_link_m1|vss_x1|vss_x2|vss_x3__t171
+ sky130_fd_pr__nfet_01v8 L=0.15 W=0.42 AS=0.1974 AD=0.1974 PS=1.78 PD=1.78
* device instance $67 r0 *1 3.61,23.845 nfet
X$67 ny__t0
+ g_vddr_m1|mnt_g|s1_vddr_m1|s2_vddr_m1|s3_vddr_m1|s4_vddr_m1|vddr|vddr1__t0
+ g_vss_m1|inv_clk_vss|inv_mc_vss|inv_q_vss|mph_g|nand_m_vss|nand_s2_vss|s1_vss_m1|s2_vss_m1|s3_vss_m1|s4_vss_m1|sb_vss|sr1_vss|sr2_vss|sr3_vss|sr4_vss|sv_vss|tg_d_vss|tg_fbm_vss|tg_fbs_vss|tg_s_vss|vss|vss_link|vss_link_bridge|vss_link_dip|vss_link_m1|vss_x1|vss_x2|vss_x3__t2
+ g_vss_m1|inv_clk_vss|inv_mc_vss|inv_q_vss|mph_g|nand_m_vss|nand_s2_vss|s1_vss_m1|s2_vss_m1|s3_vss_m1|s4_vss_m1|sb_vss|sr1_vss|sr2_vss|sr3_vss|sr4_vss|sv_vss|tg_d_vss|tg_fbm_vss|tg_fbs_vss|tg_s_vss|vss|vss_link|vss_link_bridge|vss_link_dip|vss_link_m1|vss_x1|vss_x2|vss_x3__t198
+ sky130_fd_pr__nfet_01v8 L=2 W=0.42 AS=0.1764 AD=0.1764 PS=1.68 PD=1.68
* device instance $68 r0 *1 3.445,41.54 nfet
X$68 an|inva_y|mn34_g0|mp13_g1|y__t2
+ a|d|inva_a|mn12_g0|mp13_g0|ro1|ro1_esc|sr1_d_stub|tg_d_a|y__t6
+ g_vss_m1|inv_clk_vss|inv_mc_vss|inv_q_vss|mph_g|nand_m_vss|nand_s2_vss|s1_vss_m1|s2_vss_m1|s3_vss_m1|s4_vss_m1|sb_vss|sr1_vss|sr2_vss|sr3_vss|sr4_vss|sv_vss|tg_d_vss|tg_fbm_vss|tg_fbs_vss|tg_s_vss|vss|vss_link|vss_link_bridge|vss_link_dip|vss_link_m1|vss_x1|vss_x2|vss_x3__t62
+ g_vss_m1|inv_clk_vss|inv_mc_vss|inv_q_vss|mph_g|nand_m_vss|nand_s2_vss|s1_vss_m1|s2_vss_m1|s3_vss_m1|s4_vss_m1|sb_vss|sr1_vss|sr2_vss|sr3_vss|sr4_vss|sv_vss|tg_d_vss|tg_fbm_vss|tg_fbs_vss|tg_s_vss|vss|vss_link|vss_link_bridge|vss_link_dip|vss_link_m1|vss_x1|vss_x2|vss_x3__t192
+ sky130_fd_pr__nfet_01v8 L=0.15 W=0.42 AS=0.1974 AD=0.1974 PS=1.78 PD=1.78
* device instance $69 r0 *1 6.225,23.845 nfet
X$69 \$72__t0 en|en1|g_en__t1 ny__t1
+ g_vss_m1|inv_clk_vss|inv_mc_vss|inv_q_vss|mph_g|nand_m_vss|nand_s2_vss|s1_vss_m1|s2_vss_m1|s3_vss_m1|s4_vss_m1|sb_vss|sr1_vss|sr2_vss|sr3_vss|sr4_vss|sv_vss|tg_d_vss|tg_fbm_vss|tg_fbs_vss|tg_s_vss|vss|vss_link|vss_link_bridge|vss_link_dip|vss_link_m1|vss_x1|vss_x2|vss_x3__t98
+ sky130_fd_pr__nfet_01v8 L=0.15 W=0.84 AS=0.3948 AD=0.2184 PS=2.62 PD=1.36
* device instance $70 r0 *1 6.895,23.845 nfet
X$70 a|g_y|mnab_y|mpa_y|mpb_y|n1|s1_a|y__t42 a|g_a|rn1|ro|s4_y|y__t5 \$72__t1
+ g_vss_m1|inv_clk_vss|inv_mc_vss|inv_q_vss|mph_g|nand_m_vss|nand_s2_vss|s1_vss_m1|s2_vss_m1|s3_vss_m1|s4_vss_m1|sb_vss|sr1_vss|sr2_vss|sr3_vss|sr4_vss|sv_vss|tg_d_vss|tg_fbm_vss|tg_fbs_vss|tg_s_vss|vss|vss_link|vss_link_bridge|vss_link_dip|vss_link_m1|vss_x1|vss_x2|vss_x3__t120
+ sky130_fd_pr__nfet_01v8 L=0.15 W=0.84 AS=0.2184 AD=0.3948 PS=1.36 PD=2.62
* device instance $71 r0 *1 7.78,39.22 nfet
X$71 \$138__t0 an|inva_y|mn34_g0|mp13_g1|y__t3
+ a|inva_a|mn12_g0|mp13_g0|t1|y__t6
+ g_vss_m1|inv_clk_vss|inv_mc_vss|inv_q_vss|mph_g|nand_m_vss|nand_s2_vss|s1_vss_m1|s2_vss_m1|s3_vss_m1|s4_vss_m1|sb_vss|sr1_vss|sr2_vss|sr3_vss|sr4_vss|sv_vss|tg_d_vss|tg_fbm_vss|tg_fbs_vss|tg_s_vss|vss|vss_link|vss_link_bridge|vss_link_dip|vss_link_m1|vss_x1|vss_x2|vss_x3__t102
+ sky130_fd_pr__nfet_01v8 L=0.15 W=0.84 AS=0.3948 AD=0.2184 PS=2.62 PD=1.36
* device instance $72 r0 *1 8.45,39.22 nfet
X$72
+ g_vss_m1|inv_clk_vss|inv_mc_vss|inv_q_vss|mph_g|nand_m_vss|nand_s2_vss|s1_vss_m1|s2_vss_m1|s3_vss_m1|s4_vss_m1|sb_vss|sr1_vss|sr2_vss|sr3_vss|sr4_vss|sv_vss|tg_d_vss|tg_fbm_vss|tg_fbs_vss|tg_s_vss|vss|vss_link|vss_link_bridge|vss_link_dip|vss_link_m1|vss_x1|vss_x2|vss_x3__t70
+ bn|invb_y|mn34_g1|mp24_g1|y__t3 \$138__t1
+ g_vss_m1|inv_clk_vss|inv_mc_vss|inv_q_vss|mph_g|nand_m_vss|nand_s2_vss|s1_vss_m1|s2_vss_m1|s3_vss_m1|s4_vss_m1|sb_vss|sr1_vss|sr2_vss|sr3_vss|sr4_vss|sv_vss|tg_d_vss|tg_fbm_vss|tg_fbs_vss|tg_s_vss|vss|vss_link|vss_link_bridge|vss_link_dip|vss_link_m1|vss_x1|vss_x2|vss_x3__t124
+ sky130_fd_pr__nfet_01v8 L=0.15 W=0.84 AS=0.2184 AD=0.3948 PS=1.36 PD=2.62
* device instance $73 r0 *1 12.91,23.845 nfet
X$73 ny__t02
+ g_vddr_m1|mnt_g|s1_vddr_m1|s2_vddr_m1|s3_vddr_m1|s4_vddr_m1|vddr|vddr1__t13
+ g_vss_m1|inv_clk_vss|inv_mc_vss|inv_q_vss|mph_g|nand_m_vss|nand_s2_vss|s1_vss_m1|s2_vss_m1|s3_vss_m1|s4_vss_m1|sb_vss|sr1_vss|sr2_vss|sr3_vss|sr4_vss|sv_vss|tg_d_vss|tg_fbm_vss|tg_fbs_vss|tg_s_vss|vss|vss_link|vss_link_bridge|vss_link_dip|vss_link_m1|vss_x1|vss_x2|vss_x3__t40
+ g_vss_m1|inv_clk_vss|inv_mc_vss|inv_q_vss|mph_g|nand_m_vss|nand_s2_vss|s1_vss_m1|s2_vss_m1|s3_vss_m1|s4_vss_m1|sb_vss|sr1_vss|sr2_vss|sr3_vss|sr4_vss|sv_vss|tg_d_vss|tg_fbm_vss|tg_fbs_vss|tg_s_vss|vss|vss_link|vss_link_bridge|vss_link_dip|vss_link_m1|vss_x1|vss_x2|vss_x3__t199
+ sky130_fd_pr__nfet_01v8 L=2 W=0.42 AS=0.1764 AD=0.1764 PS=1.68 PD=1.68
* device instance $74 r0 *1 14.78,39.22 nfet
X$74 \$139__t0 a|d|inva_a|mn12_g0|mp13_g0|ro1|ro1_esc|sr1_d_stub|tg_d_a|y__t7
+ a|inva_a|mn12_g0|mp13_g0|t1|y__t7
+ g_vss_m1|inv_clk_vss|inv_mc_vss|inv_q_vss|mph_g|nand_m_vss|nand_s2_vss|s1_vss_m1|s2_vss_m1|s3_vss_m1|s4_vss_m1|sb_vss|sr1_vss|sr2_vss|sr3_vss|sr4_vss|sv_vss|tg_d_vss|tg_fbm_vss|tg_fbs_vss|tg_s_vss|vss|vss_link|vss_link_bridge|vss_link_dip|vss_link_m1|vss_x1|vss_x2|vss_x3__t103
+ sky130_fd_pr__nfet_01v8 L=0.15 W=0.84 AS=0.3948 AD=0.2184 PS=2.62 PD=1.36
* device instance $75 r0 *1 15.45,39.22 nfet
X$75
+ g_vss_m1|inv_clk_vss|inv_mc_vss|inv_q_vss|mph_g|nand_m_vss|nand_s2_vss|s1_vss_m1|s2_vss_m1|s3_vss_m1|s4_vss_m1|sb_vss|sr1_vss|sr2_vss|sr3_vss|sr4_vss|sv_vss|tg_d_vss|tg_fbm_vss|tg_fbs_vss|tg_s_vss|vss|vss_link|vss_link_bridge|vss_link_dip|vss_link_m1|vss_x1|vss_x2|vss_x3__t71
+ a|b|d|invb_a|mn12_g1|mp24_g0|ro2|ro2_esc|sr2_d_stub|tg_d_a|y__t7 \$139__t1
+ g_vss_m1|inv_clk_vss|inv_mc_vss|inv_q_vss|mph_g|nand_m_vss|nand_s2_vss|s1_vss_m1|s2_vss_m1|s3_vss_m1|s4_vss_m1|sb_vss|sr1_vss|sr2_vss|sr3_vss|sr4_vss|sv_vss|tg_d_vss|tg_fbm_vss|tg_fbs_vss|tg_s_vss|vss|vss_link|vss_link_bridge|vss_link_dip|vss_link_m1|vss_x1|vss_x2|vss_x3__t125
+ sky130_fd_pr__nfet_01v8 L=0.15 W=0.84 AS=0.2184 AD=0.3948 PS=1.36 PD=2.62
* device instance $76 r0 *1 15.515,23.845 nfet
X$76 a|n2|s1_y|s2_a|y__t1 a|g_y|mnab_y|mpa_y|mpb_y|n1|s1_a|y__t22 ny__t12
+ g_vss_m1|inv_clk_vss|inv_mc_vss|inv_q_vss|mph_g|nand_m_vss|nand_s2_vss|s1_vss_m1|s2_vss_m1|s3_vss_m1|s4_vss_m1|sb_vss|sr1_vss|sr2_vss|sr3_vss|sr4_vss|sv_vss|tg_d_vss|tg_fbm_vss|tg_fbs_vss|tg_s_vss|vss|vss_link|vss_link_bridge|vss_link_dip|vss_link_m1|vss_x1|vss_x2|vss_x3__t172
+ sky130_fd_pr__nfet_01v8 L=0.15 W=0.42 AS=0.1974 AD=0.1974 PS=1.78 PD=1.78
* device instance $77 r0 *1 21.085,23.845 nfet
X$77 ny__t03
+ g_vddr_m1|mnt_g|s1_vddr_m1|s2_vddr_m1|s3_vddr_m1|s4_vddr_m1|vddr|vddr1__t12
+ g_vss_m1|inv_clk_vss|inv_mc_vss|inv_q_vss|mph_g|nand_m_vss|nand_s2_vss|s1_vss_m1|s2_vss_m1|s3_vss_m1|s4_vss_m1|sb_vss|sr1_vss|sr2_vss|sr3_vss|sr4_vss|sv_vss|tg_d_vss|tg_fbm_vss|tg_fbs_vss|tg_s_vss|vss|vss_link|vss_link_bridge|vss_link_dip|vss_link_m1|vss_x1|vss_x2|vss_x3__t39
+ g_vss_m1|inv_clk_vss|inv_mc_vss|inv_q_vss|mph_g|nand_m_vss|nand_s2_vss|s1_vss_m1|s2_vss_m1|s3_vss_m1|s4_vss_m1|sb_vss|sr1_vss|sr2_vss|sr3_vss|sr4_vss|sv_vss|tg_d_vss|tg_fbm_vss|tg_fbs_vss|tg_s_vss|vss|vss_link|vss_link_bridge|vss_link_dip|vss_link_m1|vss_x1|vss_x2|vss_x3__t200
+ sky130_fd_pr__nfet_01v8 L=2 W=0.42 AS=0.1764 AD=0.1764 PS=1.68 PD=1.68
* device instance $78 r0 *1 21.62,41.54 nfet
X$78 bn|invb_y|mn34_g1|mp24_g1|y__t2
+ a|b|d|invb_a|mn12_g1|mp24_g0|ro2|ro2_esc|sr2_d_stub|tg_d_a|y__t6
+ g_vss_m1|inv_clk_vss|inv_mc_vss|inv_q_vss|mph_g|nand_m_vss|nand_s2_vss|s1_vss_m1|s2_vss_m1|s3_vss_m1|s4_vss_m1|sb_vss|sr1_vss|sr2_vss|sr3_vss|sr4_vss|sv_vss|tg_d_vss|tg_fbm_vss|tg_fbs_vss|tg_s_vss|vss|vss_link|vss_link_bridge|vss_link_dip|vss_link_m1|vss_x1|vss_x2|vss_x3__t63
+ g_vss_m1|inv_clk_vss|inv_mc_vss|inv_q_vss|mph_g|nand_m_vss|nand_s2_vss|s1_vss_m1|s2_vss_m1|s3_vss_m1|s4_vss_m1|sb_vss|sr1_vss|sr2_vss|sr3_vss|sr4_vss|sv_vss|tg_d_vss|tg_fbm_vss|tg_fbs_vss|tg_s_vss|vss|vss_link|vss_link_bridge|vss_link_dip|vss_link_m1|vss_x1|vss_x2|vss_x3__t193
+ sky130_fd_pr__nfet_01v8 L=0.15 W=0.42 AS=0.1974 AD=0.1974 PS=1.78 PD=1.78
* device instance $79 r0 *1 23.69,23.845 nfet
X$79 a|n3|s2_y|s3_a|y__t1 a|n2|s1_y|s2_a|y__t3 ny__t13
+ g_vss_m1|inv_clk_vss|inv_mc_vss|inv_q_vss|mph_g|nand_m_vss|nand_s2_vss|s1_vss_m1|s2_vss_m1|s3_vss_m1|s4_vss_m1|sb_vss|sr1_vss|sr2_vss|sr3_vss|sr4_vss|sv_vss|tg_d_vss|tg_fbm_vss|tg_fbs_vss|tg_s_vss|vss|vss_link|vss_link_bridge|vss_link_dip|vss_link_m1|vss_x1|vss_x2|vss_x3__t173
+ sky130_fd_pr__nfet_01v8 L=0.15 W=0.42 AS=0.1974 AD=0.1974 PS=1.78 PD=1.78
* device instance $80 r0 *1 29.26,23.845 nfet
X$80 ny__t04
+ g_vddr_m1|mnt_g|s1_vddr_m1|s2_vddr_m1|s3_vddr_m1|s4_vddr_m1|vddr|vddr1__t14
+ g_vss_m1|inv_clk_vss|inv_mc_vss|inv_q_vss|mph_g|nand_m_vss|nand_s2_vss|s1_vss_m1|s2_vss_m1|s3_vss_m1|s4_vss_m1|sb_vss|sr1_vss|sr2_vss|sr3_vss|sr4_vss|sv_vss|tg_d_vss|tg_fbm_vss|tg_fbs_vss|tg_s_vss|vss|vss_link|vss_link_bridge|vss_link_dip|vss_link_m1|vss_x1|vss_x2|vss_x3__t41
+ g_vss_m1|inv_clk_vss|inv_mc_vss|inv_q_vss|mph_g|nand_m_vss|nand_s2_vss|s1_vss_m1|s2_vss_m1|s3_vss_m1|s4_vss_m1|sb_vss|sr1_vss|sr2_vss|sr3_vss|sr4_vss|sv_vss|tg_d_vss|tg_fbm_vss|tg_fbs_vss|tg_s_vss|vss|vss_link|vss_link_bridge|vss_link_dip|vss_link_m1|vss_x1|vss_x2|vss_x3__t201
+ sky130_fd_pr__nfet_01v8 L=2 W=0.42 AS=0.1764 AD=0.1764 PS=1.68 PD=1.68
* device instance $81 r0 *1 31.865,23.845 nfet
X$81 a|n4|s3_y|s4_a|y__t1 a|n3|s2_y|s3_a|y__t3 ny__t14
+ g_vss_m1|inv_clk_vss|inv_mc_vss|inv_q_vss|mph_g|nand_m_vss|nand_s2_vss|s1_vss_m1|s2_vss_m1|s3_vss_m1|s4_vss_m1|sb_vss|sr1_vss|sr2_vss|sr3_vss|sr4_vss|sv_vss|tg_d_vss|tg_fbm_vss|tg_fbs_vss|tg_s_vss|vss|vss_link|vss_link_bridge|vss_link_dip|vss_link_m1|vss_x1|vss_x2|vss_x3__t174
+ sky130_fd_pr__nfet_01v8 L=0.15 W=0.42 AS=0.1974 AD=0.1974 PS=1.78 PD=1.78
* device instance $82 r0 *1 32.415,41.54 nfet
X$82 an|inva_y|mn34_g0|mp13_g1|y__t22
+ a|d|inva_a|mn12_g0|mp13_g0|ro3|ro3_esc_e|ro3_esc_w|ro3_hop|sr3_d_stub|tg_d_a|y__t6
+ g_vss_m1|inv_clk_vss|inv_mc_vss|inv_q_vss|mph_g|nand_m_vss|nand_s2_vss|s1_vss_m1|s2_vss_m1|s3_vss_m1|s4_vss_m1|sb_vss|sr1_vss|sr2_vss|sr3_vss|sr4_vss|sv_vss|tg_d_vss|tg_fbm_vss|tg_fbs_vss|tg_s_vss|vss|vss_link|vss_link_bridge|vss_link_dip|vss_link_m1|vss_x1|vss_x2|vss_x3__t64
+ g_vss_m1|inv_clk_vss|inv_mc_vss|inv_q_vss|mph_g|nand_m_vss|nand_s2_vss|s1_vss_m1|s2_vss_m1|s3_vss_m1|s4_vss_m1|sb_vss|sr1_vss|sr2_vss|sr3_vss|sr4_vss|sv_vss|tg_d_vss|tg_fbm_vss|tg_fbs_vss|tg_s_vss|vss|vss_link|vss_link_bridge|vss_link_dip|vss_link_m1|vss_x1|vss_x2|vss_x3__t194
+ sky130_fd_pr__nfet_01v8 L=0.15 W=0.42 AS=0.1974 AD=0.1974 PS=1.78 PD=1.78
* device instance $83 r0 *1 37.435,23.845 nfet
X$83 ny__t05
+ g_vddr_m1|mnt_g|s1_vddr_m1|s2_vddr_m1|s3_vddr_m1|s4_vddr_m1|vddr|vddr1__t11
+ g_vss_m1|inv_clk_vss|inv_mc_vss|inv_q_vss|mph_g|nand_m_vss|nand_s2_vss|s1_vss_m1|s2_vss_m1|s3_vss_m1|s4_vss_m1|sb_vss|sr1_vss|sr2_vss|sr3_vss|sr4_vss|sv_vss|tg_d_vss|tg_fbm_vss|tg_fbs_vss|tg_s_vss|vss|vss_link|vss_link_bridge|vss_link_dip|vss_link_m1|vss_x1|vss_x2|vss_x3__t38
+ g_vss_m1|inv_clk_vss|inv_mc_vss|inv_q_vss|mph_g|nand_m_vss|nand_s2_vss|s1_vss_m1|s2_vss_m1|s3_vss_m1|s4_vss_m1|sb_vss|sr1_vss|sr2_vss|sr3_vss|sr4_vss|sv_vss|tg_d_vss|tg_fbm_vss|tg_fbs_vss|tg_s_vss|vss|vss_link|vss_link_bridge|vss_link_dip|vss_link_m1|vss_x1|vss_x2|vss_x3__t202
+ sky130_fd_pr__nfet_01v8 L=2 W=0.42 AS=0.1764 AD=0.1764 PS=1.68 PD=1.68
* device instance $84 r0 *1 36.75,39.22 nfet
X$84 \$140__t0 an|inva_y|mn34_g0|mp13_g1|y__t32
+ a|b|b3|invb_a|mn12_g1|mp24_g0|t2|y__t6
+ g_vss_m1|inv_clk_vss|inv_mc_vss|inv_q_vss|mph_g|nand_m_vss|nand_s2_vss|s1_vss_m1|s2_vss_m1|s3_vss_m1|s4_vss_m1|sb_vss|sr1_vss|sr2_vss|sr3_vss|sr4_vss|sv_vss|tg_d_vss|tg_fbm_vss|tg_fbs_vss|tg_s_vss|vss|vss_link|vss_link_bridge|vss_link_dip|vss_link_m1|vss_x1|vss_x2|vss_x3__t104
+ sky130_fd_pr__nfet_01v8 L=0.15 W=0.84 AS=0.3948 AD=0.2184 PS=2.62 PD=1.36
* device instance $85 r0 *1 37.42,39.22 nfet
X$85
+ g_vss_m1|inv_clk_vss|inv_mc_vss|inv_q_vss|mph_g|nand_m_vss|nand_s2_vss|s1_vss_m1|s2_vss_m1|s3_vss_m1|s4_vss_m1|sb_vss|sr1_vss|sr2_vss|sr3_vss|sr4_vss|sv_vss|tg_d_vss|tg_fbm_vss|tg_fbs_vss|tg_s_vss|vss|vss_link|vss_link_bridge|vss_link_dip|vss_link_m1|vss_x1|vss_x2|vss_x3__t74
+ bn|invb_y|mn34_g1|mp24_g1|y__t32 \$140__t1
+ g_vss_m1|inv_clk_vss|inv_mc_vss|inv_q_vss|mph_g|nand_m_vss|nand_s2_vss|s1_vss_m1|s2_vss_m1|s3_vss_m1|s4_vss_m1|sb_vss|sr1_vss|sr2_vss|sr3_vss|sr4_vss|sv_vss|tg_d_vss|tg_fbm_vss|tg_fbs_vss|tg_s_vss|vss|vss_link|vss_link_bridge|vss_link_dip|vss_link_m1|vss_x1|vss_x2|vss_x3__t126
+ sky130_fd_pr__nfet_01v8 L=0.15 W=0.84 AS=0.2184 AD=0.3948 PS=1.36 PD=2.62
* device instance $86 r0 *1 40.04,23.845 nfet
X$86 a|g_a|rn1|ro|s4_y|y__t1 a|n4|s3_y|s4_a|y__t3 ny__t15
+ g_vss_m1|inv_clk_vss|inv_mc_vss|inv_q_vss|mph_g|nand_m_vss|nand_s2_vss|s1_vss_m1|s2_vss_m1|s3_vss_m1|s4_vss_m1|sb_vss|sr1_vss|sr2_vss|sr3_vss|sr4_vss|sv_vss|tg_d_vss|tg_fbm_vss|tg_fbs_vss|tg_s_vss|vss|vss_link|vss_link_bridge|vss_link_dip|vss_link_m1|vss_x1|vss_x2|vss_x3__t175
+ sky130_fd_pr__nfet_01v8 L=0.15 W=0.42 AS=0.1974 AD=0.1974 PS=1.78 PD=1.78
* device instance $87 r0 *1 43.75,39.22 nfet
X$87 \$142__t0
+ a|d|inva_a|mn12_g0|mp13_g0|ro3|ro3_esc_e|ro3_esc_w|ro3_hop|sr3_d_stub|tg_d_a|y__t7
+ a|b|b3|invb_a|mn12_g1|mp24_g0|t2|y__t7
+ g_vss_m1|inv_clk_vss|inv_mc_vss|inv_q_vss|mph_g|nand_m_vss|nand_s2_vss|s1_vss_m1|s2_vss_m1|s3_vss_m1|s4_vss_m1|sb_vss|sr1_vss|sr2_vss|sr3_vss|sr4_vss|sv_vss|tg_d_vss|tg_fbm_vss|tg_fbs_vss|tg_s_vss|vss|vss_link|vss_link_bridge|vss_link_dip|vss_link_m1|vss_x1|vss_x2|vss_x3__t105
+ sky130_fd_pr__nfet_01v8 L=0.15 W=0.84 AS=0.3948 AD=0.2184 PS=2.62 PD=1.36
* device instance $88 r0 *1 44.42,39.22 nfet
X$88
+ g_vss_m1|inv_clk_vss|inv_mc_vss|inv_q_vss|mph_g|nand_m_vss|nand_s2_vss|s1_vss_m1|s2_vss_m1|s3_vss_m1|s4_vss_m1|sb_vss|sr1_vss|sr2_vss|sr3_vss|sr4_vss|sv_vss|tg_d_vss|tg_fbm_vss|tg_fbs_vss|tg_s_vss|vss|vss_link|vss_link_bridge|vss_link_dip|vss_link_m1|vss_x1|vss_x2|vss_x3__t73
+ a|b|d|invb_a|mn12_g1|mp24_g0|ro4|ro4_esc|sr4_d_stub|tg_d_a|y__t7 \$142__t1
+ g_vss_m1|inv_clk_vss|inv_mc_vss|inv_q_vss|mph_g|nand_m_vss|nand_s2_vss|s1_vss_m1|s2_vss_m1|s3_vss_m1|s4_vss_m1|sb_vss|sr1_vss|sr2_vss|sr3_vss|sr4_vss|sv_vss|tg_d_vss|tg_fbm_vss|tg_fbs_vss|tg_s_vss|vss|vss_link|vss_link_bridge|vss_link_dip|vss_link_m1|vss_x1|vss_x2|vss_x3__t127
+ sky130_fd_pr__nfet_01v8 L=0.15 W=0.84 AS=0.2184 AD=0.3948 PS=1.36 PD=2.62
* device instance $89 r0 *1 48.86,23.845 nfet
X$89 a|d|inva_a|mn12_g0|mp13_g0|ro1|ro1_esc|sr1_d_stub|tg_d_a|y__t3
+ a|g_a|rn1|ro|s4_y|y__t4
+ g_vss_m1|inv_clk_vss|inv_mc_vss|inv_q_vss|mph_g|nand_m_vss|nand_s2_vss|s1_vss_m1|s2_vss_m1|s3_vss_m1|s4_vss_m1|sb_vss|sr1_vss|sr2_vss|sr3_vss|sr4_vss|sv_vss|tg_d_vss|tg_fbm_vss|tg_fbs_vss|tg_s_vss|vss|vss_link|vss_link_bridge|vss_link_dip|vss_link_m1|vss_x1|vss_x2|vss_x3__t56
+ g_vss_m1|inv_clk_vss|inv_mc_vss|inv_q_vss|mph_g|nand_m_vss|nand_s2_vss|s1_vss_m1|s2_vss_m1|s3_vss_m1|s4_vss_m1|sb_vss|sr1_vss|sr2_vss|sr3_vss|sr4_vss|sv_vss|tg_d_vss|tg_fbm_vss|tg_fbs_vss|tg_s_vss|vss|vss_link|vss_link_bridge|vss_link_dip|vss_link_m1|vss_x1|vss_x2|vss_x3__t176
+ sky130_fd_pr__nfet_01v8 L=0.15 W=0.42 AS=0.1974 AD=0.1974 PS=1.78 PD=1.78
* device instance $90 r0 *1 50.59,41.54 nfet
X$90 bn|invb_y|mn34_g1|mp24_g1|y__t22
+ a|b|d|invb_a|mn12_g1|mp24_g0|ro4|ro4_esc|sr4_d_stub|tg_d_a|y__t6
+ g_vss_m1|inv_clk_vss|inv_mc_vss|inv_q_vss|mph_g|nand_m_vss|nand_s2_vss|s1_vss_m1|s2_vss_m1|s3_vss_m1|s4_vss_m1|sb_vss|sr1_vss|sr2_vss|sr3_vss|sr4_vss|sv_vss|tg_d_vss|tg_fbm_vss|tg_fbs_vss|tg_s_vss|vss|vss_link|vss_link_bridge|vss_link_dip|vss_link_m1|vss_x1|vss_x2|vss_x3__t68
+ g_vss_m1|inv_clk_vss|inv_mc_vss|inv_q_vss|mph_g|nand_m_vss|nand_s2_vss|s1_vss_m1|s2_vss_m1|s3_vss_m1|s4_vss_m1|sb_vss|sr1_vss|sr2_vss|sr3_vss|sr4_vss|sv_vss|tg_d_vss|tg_fbm_vss|tg_fbs_vss|tg_s_vss|vss|vss_link|vss_link_bridge|vss_link_dip|vss_link_m1|vss_x1|vss_x2|vss_x3__t195
+ sky130_fd_pr__nfet_01v8 L=0.15 W=0.42 AS=0.1974 AD=0.1974 PS=1.78 PD=1.78
* device instance $91 r0 *1 58.91,23.845 nfet
X$91 ny__t06
+ g_vddr_m1|mnt_g|s1_vddr_m1|s2_vddr_m1|s3_vddr_m1|s4_vddr_m1|vddr|vddr2__t0
+ g_vss_m1|inv_clk_vss|inv_mc_vss|inv_q_vss|mph_g|nand_m_vss|nand_s2_vss|s1_vss_m1|s2_vss_m1|s3_vss_m1|s4_vss_m1|sb_vss|sr1_vss|sr2_vss|sr3_vss|sr4_vss|sv_vss|tg_d_vss|tg_fbm_vss|tg_fbs_vss|tg_s_vss|vss|vss_link|vss_link_bridge|vss_link_dip|vss_link_m1|vss_x1|vss_x2|vss_x3__t3
+ g_vss_m1|inv_clk_vss|inv_mc_vss|inv_q_vss|mph_g|nand_m_vss|nand_s2_vss|s1_vss_m1|s2_vss_m1|s3_vss_m1|s4_vss_m1|sb_vss|sr1_vss|sr2_vss|sr3_vss|sr4_vss|sv_vss|tg_d_vss|tg_fbm_vss|tg_fbs_vss|tg_s_vss|vss|vss_link|vss_link_bridge|vss_link_dip|vss_link_m1|vss_x1|vss_x2|vss_x3__t203
+ sky130_fd_pr__nfet_01v8 L=2 W=0.44 AS=0.1848 AD=0.1848 PS=1.72 PD=1.72
* device instance $92 r0 *1 61.385,41.54 nfet
X$92 an|inva_y|mn34_g0|mp13_g1|y__t23 a|inva_a|mn12_g0|mp13_g0|t1|y__t4
+ g_vss_m1|inv_clk_vss|inv_mc_vss|inv_q_vss|mph_g|nand_m_vss|nand_s2_vss|s1_vss_m1|s2_vss_m1|s3_vss_m1|s4_vss_m1|sb_vss|sr1_vss|sr2_vss|sr3_vss|sr4_vss|sv_vss|tg_d_vss|tg_fbm_vss|tg_fbs_vss|tg_s_vss|vss|vss_link|vss_link_bridge|vss_link_dip|vss_link_m1|vss_x1|vss_x2|vss_x3__t65
+ g_vss_m1|inv_clk_vss|inv_mc_vss|inv_q_vss|mph_g|nand_m_vss|nand_s2_vss|s1_vss_m1|s2_vss_m1|s3_vss_m1|s4_vss_m1|sb_vss|sr1_vss|sr2_vss|sr3_vss|sr4_vss|sv_vss|tg_d_vss|tg_fbm_vss|tg_fbs_vss|tg_s_vss|vss|vss_link|vss_link_bridge|vss_link_dip|vss_link_m1|vss_x1|vss_x2|vss_x3__t196
+ sky130_fd_pr__nfet_01v8 L=0.15 W=0.42 AS=0.1974 AD=0.1974 PS=1.78 PD=1.78
* device instance $93 r0 *1 61.525,23.845 nfet
X$93 \$79__t0 en|en2|g_en__t1 ny__t16
+ g_vss_m1|inv_clk_vss|inv_mc_vss|inv_q_vss|mph_g|nand_m_vss|nand_s2_vss|s1_vss_m1|s2_vss_m1|s3_vss_m1|s4_vss_m1|sb_vss|sr1_vss|sr2_vss|sr3_vss|sr4_vss|sv_vss|tg_d_vss|tg_fbm_vss|tg_fbs_vss|tg_s_vss|vss|vss_link|vss_link_bridge|vss_link_dip|vss_link_m1|vss_x1|vss_x2|vss_x3__t99
+ sky130_fd_pr__nfet_01v8 L=0.15 W=0.84 AS=0.3948 AD=0.2184 PS=2.62 PD=1.36
* device instance $94 r0 *1 62.195,23.845 nfet
X$94 a|g_y|mnab_y|mpa_y|mpb_y|n1|s1_a|y__t4 a|g_a|rn2|ro|s4_y|y__t5 \$79__t1
+ g_vss_m1|inv_clk_vss|inv_mc_vss|inv_q_vss|mph_g|nand_m_vss|nand_s2_vss|s1_vss_m1|s2_vss_m1|s3_vss_m1|s4_vss_m1|sb_vss|sr1_vss|sr2_vss|sr3_vss|sr4_vss|sv_vss|tg_d_vss|tg_fbm_vss|tg_fbs_vss|tg_s_vss|vss|vss_link|vss_link_bridge|vss_link_dip|vss_link_m1|vss_x1|vss_x2|vss_x3__t121
+ sky130_fd_pr__nfet_01v8 L=0.15 W=0.84 AS=0.2184 AD=0.3948 PS=1.36 PD=2.62
* device instance $95 r0 *1 65.72,39.22 nfet
X$95 \$143__t0 an|inva_y|mn34_g0|mp13_g1|y__t33
+ a|d|sb_d_stub|tg_d_a|xo|xo_dip|xo_hop|xo_stub|y__t4
+ g_vss_m1|inv_clk_vss|inv_mc_vss|inv_q_vss|mph_g|nand_m_vss|nand_s2_vss|s1_vss_m1|s2_vss_m1|s3_vss_m1|s4_vss_m1|sb_vss|sr1_vss|sr2_vss|sr3_vss|sr4_vss|sv_vss|tg_d_vss|tg_fbm_vss|tg_fbs_vss|tg_s_vss|vss|vss_link|vss_link_bridge|vss_link_dip|vss_link_m1|vss_x1|vss_x2|vss_x3__t106
+ sky130_fd_pr__nfet_01v8 L=0.15 W=0.84 AS=0.3948 AD=0.2184 PS=2.62 PD=1.36
* device instance $96 r0 *1 66.39,39.22 nfet
X$96
+ g_vss_m1|inv_clk_vss|inv_mc_vss|inv_q_vss|mph_g|nand_m_vss|nand_s2_vss|s1_vss_m1|s2_vss_m1|s3_vss_m1|s4_vss_m1|sb_vss|sr1_vss|sr2_vss|sr3_vss|sr4_vss|sv_vss|tg_d_vss|tg_fbm_vss|tg_fbs_vss|tg_s_vss|vss|vss_link|vss_link_bridge|vss_link_dip|vss_link_m1|vss_x1|vss_x2|vss_x3__t72
+ bn|invb_y|mn34_g1|mp24_g1|y__t33 \$143__t1
+ g_vss_m1|inv_clk_vss|inv_mc_vss|inv_q_vss|mph_g|nand_m_vss|nand_s2_vss|s1_vss_m1|s2_vss_m1|s3_vss_m1|s4_vss_m1|sb_vss|sr1_vss|sr2_vss|sr3_vss|sr4_vss|sv_vss|tg_d_vss|tg_fbm_vss|tg_fbs_vss|tg_s_vss|vss|vss_link|vss_link_bridge|vss_link_dip|vss_link_m1|vss_x1|vss_x2|vss_x3__t128
+ sky130_fd_pr__nfet_01v8 L=0.15 W=0.84 AS=0.2184 AD=0.3948 PS=1.36 PD=2.62
* device instance $97 r0 *1 68.21,23.845 nfet
X$97 ny__t07
+ g_vddr_m1|mnt_g|s1_vddr_m1|s2_vddr_m1|s3_vddr_m1|s4_vddr_m1|vddr|vddr2__t13
+ g_vss_m1|inv_clk_vss|inv_mc_vss|inv_q_vss|mph_g|nand_m_vss|nand_s2_vss|s1_vss_m1|s2_vss_m1|s3_vss_m1|s4_vss_m1|sb_vss|sr1_vss|sr2_vss|sr3_vss|sr4_vss|sv_vss|tg_d_vss|tg_fbm_vss|tg_fbs_vss|tg_s_vss|vss|vss_link|vss_link_bridge|vss_link_dip|vss_link_m1|vss_x1|vss_x2|vss_x3__t36
+ g_vss_m1|inv_clk_vss|inv_mc_vss|inv_q_vss|mph_g|nand_m_vss|nand_s2_vss|s1_vss_m1|s2_vss_m1|s3_vss_m1|s4_vss_m1|sb_vss|sr1_vss|sr2_vss|sr3_vss|sr4_vss|sv_vss|tg_d_vss|tg_fbm_vss|tg_fbs_vss|tg_s_vss|vss|vss_link|vss_link_bridge|vss_link_dip|vss_link_m1|vss_x1|vss_x2|vss_x3__t204
+ sky130_fd_pr__nfet_01v8 L=2 W=0.44 AS=0.1848 AD=0.1848 PS=1.72 PD=1.72
* device instance $98 r0 *1 70.815,23.845 nfet
X$98 a|n2|s1_y|s2_a|y__t12 a|g_y|mnab_y|mpa_y|mpb_y|n1|s1_a|y__t2 ny__t17
+ g_vss_m1|inv_clk_vss|inv_mc_vss|inv_q_vss|mph_g|nand_m_vss|nand_s2_vss|s1_vss_m1|s2_vss_m1|s3_vss_m1|s4_vss_m1|sb_vss|sr1_vss|sr2_vss|sr3_vss|sr4_vss|sv_vss|tg_d_vss|tg_fbm_vss|tg_fbs_vss|tg_s_vss|vss|vss_link|vss_link_bridge|vss_link_dip|vss_link_m1|vss_x1|vss_x2|vss_x3__t177
+ sky130_fd_pr__nfet_01v8 L=0.15 W=0.42 AS=0.1974 AD=0.1974 PS=1.78 PD=1.78
* device instance $99 r0 *1 72.72,39.22 nfet
X$99 \$146__t0 a|inva_a|mn12_g0|mp13_g0|t1|y__t5
+ a|d|sb_d_stub|tg_d_a|xo|xo_dip|xo_hop|xo_stub|y__t5
+ g_vss_m1|inv_clk_vss|inv_mc_vss|inv_q_vss|mph_g|nand_m_vss|nand_s2_vss|s1_vss_m1|s2_vss_m1|s3_vss_m1|s4_vss_m1|sb_vss|sr1_vss|sr2_vss|sr3_vss|sr4_vss|sv_vss|tg_d_vss|tg_fbm_vss|tg_fbs_vss|tg_s_vss|vss|vss_link|vss_link_bridge|vss_link_dip|vss_link_m1|vss_x1|vss_x2|vss_x3__t107
+ sky130_fd_pr__nfet_01v8 L=0.15 W=0.84 AS=0.3948 AD=0.2184 PS=2.62 PD=1.36
* device instance $100 r0 *1 73.39,39.22 nfet
X$100
+ g_vss_m1|inv_clk_vss|inv_mc_vss|inv_q_vss|mph_g|nand_m_vss|nand_s2_vss|s1_vss_m1|s2_vss_m1|s3_vss_m1|s4_vss_m1|sb_vss|sr1_vss|sr2_vss|sr3_vss|sr4_vss|sv_vss|tg_d_vss|tg_fbm_vss|tg_fbs_vss|tg_s_vss|vss|vss_link|vss_link_bridge|vss_link_dip|vss_link_m1|vss_x1|vss_x2|vss_x3__t69
+ a|b|b3|invb_a|mn12_g1|mp24_g0|t2|y__t5 \$146__t1
+ g_vss_m1|inv_clk_vss|inv_mc_vss|inv_q_vss|mph_g|nand_m_vss|nand_s2_vss|s1_vss_m1|s2_vss_m1|s3_vss_m1|s4_vss_m1|sb_vss|sr1_vss|sr2_vss|sr3_vss|sr4_vss|sv_vss|tg_d_vss|tg_fbm_vss|tg_fbs_vss|tg_s_vss|vss|vss_link|vss_link_bridge|vss_link_dip|vss_link_m1|vss_x1|vss_x2|vss_x3__t129
+ sky130_fd_pr__nfet_01v8 L=0.15 W=0.84 AS=0.2184 AD=0.3948 PS=1.36 PD=2.62
* device instance $101 r0 *1 76.385,23.845 nfet
X$101 ny__t08
+ g_vddr_m1|mnt_g|s1_vddr_m1|s2_vddr_m1|s3_vddr_m1|s4_vddr_m1|vddr|vddr2__t12
+ g_vss_m1|inv_clk_vss|inv_mc_vss|inv_q_vss|mph_g|nand_m_vss|nand_s2_vss|s1_vss_m1|s2_vss_m1|s3_vss_m1|s4_vss_m1|sb_vss|sr1_vss|sr2_vss|sr3_vss|sr4_vss|sv_vss|tg_d_vss|tg_fbm_vss|tg_fbs_vss|tg_s_vss|vss|vss_link|vss_link_bridge|vss_link_dip|vss_link_m1|vss_x1|vss_x2|vss_x3__t35
+ g_vss_m1|inv_clk_vss|inv_mc_vss|inv_q_vss|mph_g|nand_m_vss|nand_s2_vss|s1_vss_m1|s2_vss_m1|s3_vss_m1|s4_vss_m1|sb_vss|sr1_vss|sr2_vss|sr3_vss|sr4_vss|sv_vss|tg_d_vss|tg_fbm_vss|tg_fbs_vss|tg_s_vss|vss|vss_link|vss_link_bridge|vss_link_dip|vss_link_m1|vss_x1|vss_x2|vss_x3__t205
+ sky130_fd_pr__nfet_01v8 L=2 W=0.44 AS=0.1848 AD=0.1848 PS=1.72 PD=1.72
* device instance $102 r0 *1 78.99,23.845 nfet
X$102 a|n3|s2_y|s3_a|y__t14 a|n2|s1_y|s2_a|y__t32 ny__t18
+ g_vss_m1|inv_clk_vss|inv_mc_vss|inv_q_vss|mph_g|nand_m_vss|nand_s2_vss|s1_vss_m1|s2_vss_m1|s3_vss_m1|s4_vss_m1|sb_vss|sr1_vss|sr2_vss|sr3_vss|sr4_vss|sv_vss|tg_d_vss|tg_fbm_vss|tg_fbs_vss|tg_s_vss|vss|vss_link|vss_link_bridge|vss_link_dip|vss_link_m1|vss_x1|vss_x2|vss_x3__t178
+ sky130_fd_pr__nfet_01v8 L=0.15 W=0.42 AS=0.1974 AD=0.1974 PS=1.78 PD=1.78
* device instance $103 r0 *1 79.56,41.54 nfet
X$103 bn|invb_y|mn34_g1|mp24_g1|y__t23 a|b|b3|invb_a|mn12_g1|mp24_g0|t2|y__t4
+ g_vss_m1|inv_clk_vss|inv_mc_vss|inv_q_vss|mph_g|nand_m_vss|nand_s2_vss|s1_vss_m1|s2_vss_m1|s3_vss_m1|s4_vss_m1|sb_vss|sr1_vss|sr2_vss|sr3_vss|sr4_vss|sv_vss|tg_d_vss|tg_fbm_vss|tg_fbs_vss|tg_s_vss|vss|vss_link|vss_link_bridge|vss_link_dip|vss_link_m1|vss_x1|vss_x2|vss_x3__t61
+ g_vss_m1|inv_clk_vss|inv_mc_vss|inv_q_vss|mph_g|nand_m_vss|nand_s2_vss|s1_vss_m1|s2_vss_m1|s3_vss_m1|s4_vss_m1|sb_vss|sr1_vss|sr2_vss|sr3_vss|sr4_vss|sv_vss|tg_d_vss|tg_fbm_vss|tg_fbs_vss|tg_s_vss|vss|vss_link|vss_link_bridge|vss_link_dip|vss_link_m1|vss_x1|vss_x2|vss_x3__t197
+ sky130_fd_pr__nfet_01v8 L=0.15 W=0.42 AS=0.1974 AD=0.1974 PS=1.78 PD=1.78
* device instance $104 r0 *1 84.56,23.845 nfet
X$104 ny__t09
+ g_vddr_m1|mnt_g|s1_vddr_m1|s2_vddr_m1|s3_vddr_m1|s4_vddr_m1|vddr|vddr2__t14
+ g_vss_m1|inv_clk_vss|inv_mc_vss|inv_q_vss|mph_g|nand_m_vss|nand_s2_vss|s1_vss_m1|s2_vss_m1|s3_vss_m1|s4_vss_m1|sb_vss|sr1_vss|sr2_vss|sr3_vss|sr4_vss|sv_vss|tg_d_vss|tg_fbm_vss|tg_fbs_vss|tg_s_vss|vss|vss_link|vss_link_bridge|vss_link_dip|vss_link_m1|vss_x1|vss_x2|vss_x3__t37
+ g_vss_m1|inv_clk_vss|inv_mc_vss|inv_q_vss|mph_g|nand_m_vss|nand_s2_vss|s1_vss_m1|s2_vss_m1|s3_vss_m1|s4_vss_m1|sb_vss|sr1_vss|sr2_vss|sr3_vss|sr4_vss|sv_vss|tg_d_vss|tg_fbm_vss|tg_fbs_vss|tg_s_vss|vss|vss_link|vss_link_bridge|vss_link_dip|vss_link_m1|vss_x1|vss_x2|vss_x3__t206
+ sky130_fd_pr__nfet_01v8 L=2 W=0.44 AS=0.1848 AD=0.1848 PS=1.72 PD=1.72
* device instance $105 r0 *1 87.165,23.845 nfet
X$105 a|n4|s3_y|s4_a|y__t13 a|n3|s2_y|s3_a|y__t34 ny__t19
+ g_vss_m1|inv_clk_vss|inv_mc_vss|inv_q_vss|mph_g|nand_m_vss|nand_s2_vss|s1_vss_m1|s2_vss_m1|s3_vss_m1|s4_vss_m1|sb_vss|sr1_vss|sr2_vss|sr3_vss|sr4_vss|sv_vss|tg_d_vss|tg_fbm_vss|tg_fbs_vss|tg_s_vss|vss|vss_link|vss_link_bridge|vss_link_dip|vss_link_m1|vss_x1|vss_x2|vss_x3__t179
+ sky130_fd_pr__nfet_01v8 L=0.15 W=0.42 AS=0.1974 AD=0.1974 PS=1.78 PD=1.78
* device instance $106 r0 *1 92.735,23.845 nfet
X$106 ny__t010
+ g_vddr_m1|mnt_g|s1_vddr_m1|s2_vddr_m1|s3_vddr_m1|s4_vddr_m1|vddr|vddr2__t11
+ g_vss_m1|inv_clk_vss|inv_mc_vss|inv_q_vss|mph_g|nand_m_vss|nand_s2_vss|s1_vss_m1|s2_vss_m1|s3_vss_m1|s4_vss_m1|sb_vss|sr1_vss|sr2_vss|sr3_vss|sr4_vss|sv_vss|tg_d_vss|tg_fbm_vss|tg_fbs_vss|tg_s_vss|vss|vss_link|vss_link_bridge|vss_link_dip|vss_link_m1|vss_x1|vss_x2|vss_x3__t34
+ g_vss_m1|inv_clk_vss|inv_mc_vss|inv_q_vss|mph_g|nand_m_vss|nand_s2_vss|s1_vss_m1|s2_vss_m1|s3_vss_m1|s4_vss_m1|sb_vss|sr1_vss|sr2_vss|sr3_vss|sr4_vss|sv_vss|tg_d_vss|tg_fbm_vss|tg_fbs_vss|tg_s_vss|vss|vss_link|vss_link_bridge|vss_link_dip|vss_link_m1|vss_x1|vss_x2|vss_x3__t207
+ sky130_fd_pr__nfet_01v8 L=2 W=0.44 AS=0.1848 AD=0.1848 PS=1.72 PD=1.72
* device instance $107 r0 *1 95.34,23.845 nfet
X$107 a|g_a|rn2|ro|s4_y|y__t1 a|n4|s3_y|s4_a|y__t33 ny__t110
+ g_vss_m1|inv_clk_vss|inv_mc_vss|inv_q_vss|mph_g|nand_m_vss|nand_s2_vss|s1_vss_m1|s2_vss_m1|s3_vss_m1|s4_vss_m1|sb_vss|sr1_vss|sr2_vss|sr3_vss|sr4_vss|sv_vss|tg_d_vss|tg_fbm_vss|tg_fbs_vss|tg_s_vss|vss|vss_link|vss_link_bridge|vss_link_dip|vss_link_m1|vss_x1|vss_x2|vss_x3__t180
+ sky130_fd_pr__nfet_01v8 L=0.15 W=0.42 AS=0.1974 AD=0.1974 PS=1.78 PD=1.78
* device instance $108 r0 *1 104.16,23.845 nfet
X$108 a|b|d|invb_a|mn12_g1|mp24_g0|ro2|ro2_esc|sr2_d_stub|tg_d_a|y__t4
+ a|g_a|rn2|ro|s4_y|y__t4
+ g_vss_m1|inv_clk_vss|inv_mc_vss|inv_q_vss|mph_g|nand_m_vss|nand_s2_vss|s1_vss_m1|s2_vss_m1|s3_vss_m1|s4_vss_m1|sb_vss|sr1_vss|sr2_vss|sr3_vss|sr4_vss|sv_vss|tg_d_vss|tg_fbm_vss|tg_fbs_vss|tg_s_vss|vss|vss_link|vss_link_bridge|vss_link_dip|vss_link_m1|vss_x1|vss_x2|vss_x3__t67
+ g_vss_m1|inv_clk_vss|inv_mc_vss|inv_q_vss|mph_g|nand_m_vss|nand_s2_vss|s1_vss_m1|s2_vss_m1|s3_vss_m1|s4_vss_m1|sb_vss|sr1_vss|sr2_vss|sr3_vss|sr4_vss|sv_vss|tg_d_vss|tg_fbm_vss|tg_fbs_vss|tg_s_vss|vss|vss_link|vss_link_bridge|vss_link_dip|vss_link_m1|vss_x1|vss_x2|vss_x3__t181
+ sky130_fd_pr__nfet_01v8 L=0.15 W=0.42 AS=0.1974 AD=0.1974 PS=1.78 PD=1.78
* device instance $109 r0 *1 114.21,23.845 nfet
X$109 ny__t011
+ g_vddr_m1|mnt_g|s1_vddr_m1|s2_vddr_m1|s3_vddr_m1|s4_vddr_m1|vddr|vddr3__t0
+ g_vss_m1|inv_clk_vss|inv_mc_vss|inv_q_vss|mph_g|nand_m_vss|nand_s2_vss|s1_vss_m1|s2_vss_m1|s3_vss_m1|s4_vss_m1|sb_vss|sr1_vss|sr2_vss|sr3_vss|sr4_vss|sv_vss|tg_d_vss|tg_fbm_vss|tg_fbs_vss|tg_s_vss|vss|vss_link|vss_link_bridge|vss_link_dip|vss_link_m1|vss_x1|vss_x2|vss_x3__t4
+ g_vss_m1|inv_clk_vss|inv_mc_vss|inv_q_vss|mph_g|nand_m_vss|nand_s2_vss|s1_vss_m1|s2_vss_m1|s3_vss_m1|s4_vss_m1|sb_vss|sr1_vss|sr2_vss|sr3_vss|sr4_vss|sv_vss|tg_d_vss|tg_fbm_vss|tg_fbs_vss|tg_s_vss|vss|vss_link|vss_link_bridge|vss_link_dip|vss_link_m1|vss_x1|vss_x2|vss_x3__t208
+ sky130_fd_pr__nfet_01v8 L=2 W=0.46 AS=0.1932 AD=0.1932 PS=1.76 PD=1.76
* device instance $110 r0 *1 116.825,23.845 nfet
X$110 \$88__t0 en|en3|g_en__t1 ny__t111
+ g_vss_m1|inv_clk_vss|inv_mc_vss|inv_q_vss|mph_g|nand_m_vss|nand_s2_vss|s1_vss_m1|s2_vss_m1|s3_vss_m1|s4_vss_m1|sb_vss|sr1_vss|sr2_vss|sr3_vss|sr4_vss|sv_vss|tg_d_vss|tg_fbm_vss|tg_fbs_vss|tg_s_vss|vss|vss_link|vss_link_bridge|vss_link_dip|vss_link_m1|vss_x1|vss_x2|vss_x3__t100
+ sky130_fd_pr__nfet_01v8 L=0.15 W=0.84 AS=0.3948 AD=0.2184 PS=2.62 PD=1.36
* device instance $111 r0 *1 117.495,23.845 nfet
X$111 a|g_y|mnab_y|mpa_y|mpb_y|n1|s1_a|y__t43 a|g_a|rn3|ro|s4_y|y__t5 \$88__t1
+ g_vss_m1|inv_clk_vss|inv_mc_vss|inv_q_vss|mph_g|nand_m_vss|nand_s2_vss|s1_vss_m1|s2_vss_m1|s3_vss_m1|s4_vss_m1|sb_vss|sr1_vss|sr2_vss|sr3_vss|sr4_vss|sv_vss|tg_d_vss|tg_fbm_vss|tg_fbs_vss|tg_s_vss|vss|vss_link|vss_link_bridge|vss_link_dip|vss_link_m1|vss_x1|vss_x2|vss_x3__t122
+ sky130_fd_pr__nfet_01v8 L=0.15 W=0.84 AS=0.2184 AD=0.3948 PS=1.36 PD=2.62
* device instance $112 r0 *1 123.51,23.845 nfet
X$112 ny__t012
+ g_vddr_m1|mnt_g|s1_vddr_m1|s2_vddr_m1|s3_vddr_m1|s4_vddr_m1|vddr|vddr3__t11
+ g_vss_m1|inv_clk_vss|inv_mc_vss|inv_q_vss|mph_g|nand_m_vss|nand_s2_vss|s1_vss_m1|s2_vss_m1|s3_vss_m1|s4_vss_m1|sb_vss|sr1_vss|sr2_vss|sr3_vss|sr4_vss|sv_vss|tg_d_vss|tg_fbm_vss|tg_fbs_vss|tg_s_vss|vss|vss_link|vss_link_bridge|vss_link_dip|vss_link_m1|vss_x1|vss_x2|vss_x3__t30
+ g_vss_m1|inv_clk_vss|inv_mc_vss|inv_q_vss|mph_g|nand_m_vss|nand_s2_vss|s1_vss_m1|s2_vss_m1|s3_vss_m1|s4_vss_m1|sb_vss|sr1_vss|sr2_vss|sr3_vss|sr4_vss|sv_vss|tg_d_vss|tg_fbm_vss|tg_fbs_vss|tg_s_vss|vss|vss_link|vss_link_bridge|vss_link_dip|vss_link_m1|vss_x1|vss_x2|vss_x3__t209
+ sky130_fd_pr__nfet_01v8 L=2 W=0.46 AS=0.1932 AD=0.1932 PS=1.76 PD=1.76
* device instance $113 r0 *1 126.115,23.845 nfet
X$113 a|n2|s1_y|s2_a|y__t13 a|g_y|mnab_y|mpa_y|mpb_y|n1|s1_a|y__t23 ny__t112
+ g_vss_m1|inv_clk_vss|inv_mc_vss|inv_q_vss|mph_g|nand_m_vss|nand_s2_vss|s1_vss_m1|s2_vss_m1|s3_vss_m1|s4_vss_m1|sb_vss|sr1_vss|sr2_vss|sr3_vss|sr4_vss|sv_vss|tg_d_vss|tg_fbm_vss|tg_fbs_vss|tg_s_vss|vss|vss_link|vss_link_bridge|vss_link_dip|vss_link_m1|vss_x1|vss_x2|vss_x3__t182
+ sky130_fd_pr__nfet_01v8 L=0.15 W=0.42 AS=0.1974 AD=0.1974 PS=1.78 PD=1.78
* device instance $114 r0 *1 131.685,23.845 nfet
X$114 ny__t013
+ g_vddr_m1|mnt_g|s1_vddr_m1|s2_vddr_m1|s3_vddr_m1|s4_vddr_m1|vddr|vddr3__t12
+ g_vss_m1|inv_clk_vss|inv_mc_vss|inv_q_vss|mph_g|nand_m_vss|nand_s2_vss|s1_vss_m1|s2_vss_m1|s3_vss_m1|s4_vss_m1|sb_vss|sr1_vss|sr2_vss|sr3_vss|sr4_vss|sv_vss|tg_d_vss|tg_fbm_vss|tg_fbs_vss|tg_s_vss|vss|vss_link|vss_link_bridge|vss_link_dip|vss_link_m1|vss_x1|vss_x2|vss_x3__t31
+ g_vss_m1|inv_clk_vss|inv_mc_vss|inv_q_vss|mph_g|nand_m_vss|nand_s2_vss|s1_vss_m1|s2_vss_m1|s3_vss_m1|s4_vss_m1|sb_vss|sr1_vss|sr2_vss|sr3_vss|sr4_vss|sv_vss|tg_d_vss|tg_fbm_vss|tg_fbs_vss|tg_s_vss|vss|vss_link|vss_link_bridge|vss_link_dip|vss_link_m1|vss_x1|vss_x2|vss_x3__t210
+ sky130_fd_pr__nfet_01v8 L=2 W=0.46 AS=0.1932 AD=0.1932 PS=1.76 PD=1.76
* device instance $115 r0 *1 134.29,23.845 nfet
X$115 a|n3|s2_y|s3_a|y__t12 a|n2|s1_y|s2_a|y__t33 ny__t113
+ g_vss_m1|inv_clk_vss|inv_mc_vss|inv_q_vss|mph_g|nand_m_vss|nand_s2_vss|s1_vss_m1|s2_vss_m1|s3_vss_m1|s4_vss_m1|sb_vss|sr1_vss|sr2_vss|sr3_vss|sr4_vss|sv_vss|tg_d_vss|tg_fbm_vss|tg_fbs_vss|tg_s_vss|vss|vss_link|vss_link_bridge|vss_link_dip|vss_link_m1|vss_x1|vss_x2|vss_x3__t183
+ sky130_fd_pr__nfet_01v8 L=0.15 W=0.42 AS=0.1974 AD=0.1974 PS=1.78 PD=1.78
* device instance $116 r0 *1 139.86,23.845 nfet
X$116 ny__t014
+ g_vddr_m1|mnt_g|s1_vddr_m1|s2_vddr_m1|s3_vddr_m1|s4_vddr_m1|vddr|vddr3__t13
+ g_vss_m1|inv_clk_vss|inv_mc_vss|inv_q_vss|mph_g|nand_m_vss|nand_s2_vss|s1_vss_m1|s2_vss_m1|s3_vss_m1|s4_vss_m1|sb_vss|sr1_vss|sr2_vss|sr3_vss|sr4_vss|sv_vss|tg_d_vss|tg_fbm_vss|tg_fbs_vss|tg_s_vss|vss|vss_link|vss_link_bridge|vss_link_dip|vss_link_m1|vss_x1|vss_x2|vss_x3__t32
+ g_vss_m1|inv_clk_vss|inv_mc_vss|inv_q_vss|mph_g|nand_m_vss|nand_s2_vss|s1_vss_m1|s2_vss_m1|s3_vss_m1|s4_vss_m1|sb_vss|sr1_vss|sr2_vss|sr3_vss|sr4_vss|sv_vss|tg_d_vss|tg_fbm_vss|tg_fbs_vss|tg_s_vss|vss|vss_link|vss_link_bridge|vss_link_dip|vss_link_m1|vss_x1|vss_x2|vss_x3__t211
+ sky130_fd_pr__nfet_01v8 L=2 W=0.46 AS=0.1932 AD=0.1932 PS=1.76 PD=1.76
* device instance $117 r0 *1 142.465,23.845 nfet
X$117 a|n4|s3_y|s4_a|y__t12 a|n3|s2_y|s3_a|y__t32 ny__t114
+ g_vss_m1|inv_clk_vss|inv_mc_vss|inv_q_vss|mph_g|nand_m_vss|nand_s2_vss|s1_vss_m1|s2_vss_m1|s3_vss_m1|s4_vss_m1|sb_vss|sr1_vss|sr2_vss|sr3_vss|sr4_vss|sv_vss|tg_d_vss|tg_fbm_vss|tg_fbs_vss|tg_s_vss|vss|vss_link|vss_link_bridge|vss_link_dip|vss_link_m1|vss_x1|vss_x2|vss_x3__t184
+ sky130_fd_pr__nfet_01v8 L=0.15 W=0.42 AS=0.1974 AD=0.1974 PS=1.78 PD=1.78
* device instance $118 r0 *1 148.035,23.845 nfet
X$118 ny__t015
+ g_vddr_m1|mnt_g|s1_vddr_m1|s2_vddr_m1|s3_vddr_m1|s4_vddr_m1|vddr|vddr3__t14
+ g_vss_m1|inv_clk_vss|inv_mc_vss|inv_q_vss|mph_g|nand_m_vss|nand_s2_vss|s1_vss_m1|s2_vss_m1|s3_vss_m1|s4_vss_m1|sb_vss|sr1_vss|sr2_vss|sr3_vss|sr4_vss|sv_vss|tg_d_vss|tg_fbm_vss|tg_fbs_vss|tg_s_vss|vss|vss_link|vss_link_bridge|vss_link_dip|vss_link_m1|vss_x1|vss_x2|vss_x3__t33
+ g_vss_m1|inv_clk_vss|inv_mc_vss|inv_q_vss|mph_g|nand_m_vss|nand_s2_vss|s1_vss_m1|s2_vss_m1|s3_vss_m1|s4_vss_m1|sb_vss|sr1_vss|sr2_vss|sr3_vss|sr4_vss|sv_vss|tg_d_vss|tg_fbm_vss|tg_fbs_vss|tg_s_vss|vss|vss_link|vss_link_bridge|vss_link_dip|vss_link_m1|vss_x1|vss_x2|vss_x3__t212
+ sky130_fd_pr__nfet_01v8 L=2 W=0.46 AS=0.1932 AD=0.1932 PS=1.76 PD=1.76
* device instance $119 r0 *1 150.64,23.845 nfet
X$119 a|g_a|rn3|ro|s4_y|y__t1 a|n4|s3_y|s4_a|y__t32 ny__t115
+ g_vss_m1|inv_clk_vss|inv_mc_vss|inv_q_vss|mph_g|nand_m_vss|nand_s2_vss|s1_vss_m1|s2_vss_m1|s3_vss_m1|s4_vss_m1|sb_vss|sr1_vss|sr2_vss|sr3_vss|sr4_vss|sv_vss|tg_d_vss|tg_fbm_vss|tg_fbs_vss|tg_s_vss|vss|vss_link|vss_link_bridge|vss_link_dip|vss_link_m1|vss_x1|vss_x2|vss_x3__t185
+ sky130_fd_pr__nfet_01v8 L=0.15 W=0.42 AS=0.1974 AD=0.1974 PS=1.78 PD=1.78
* device instance $120 r0 *1 159.46,23.845 nfet
X$120
+ a|d|inva_a|mn12_g0|mp13_g0|ro3|ro3_esc_e|ro3_esc_w|ro3_hop|sr3_d_stub|tg_d_a|y__t4
+ a|g_a|rn3|ro|s4_y|y__t4
+ g_vss_m1|inv_clk_vss|inv_mc_vss|inv_q_vss|mph_g|nand_m_vss|nand_s2_vss|s1_vss_m1|s2_vss_m1|s3_vss_m1|s4_vss_m1|sb_vss|sr1_vss|sr2_vss|sr3_vss|sr4_vss|sv_vss|tg_d_vss|tg_fbm_vss|tg_fbs_vss|tg_s_vss|vss|vss_link|vss_link_bridge|vss_link_dip|vss_link_m1|vss_x1|vss_x2|vss_x3__t66
+ g_vss_m1|inv_clk_vss|inv_mc_vss|inv_q_vss|mph_g|nand_m_vss|nand_s2_vss|s1_vss_m1|s2_vss_m1|s3_vss_m1|s4_vss_m1|sb_vss|sr1_vss|sr2_vss|sr3_vss|sr4_vss|sv_vss|tg_d_vss|tg_fbm_vss|tg_fbs_vss|tg_s_vss|vss|vss_link|vss_link_bridge|vss_link_dip|vss_link_m1|vss_x1|vss_x2|vss_x3__t186
+ sky130_fd_pr__nfet_01v8 L=0.15 W=0.42 AS=0.1974 AD=0.1974 PS=1.78 PD=1.78
* device instance $121 r0 *1 169.51,23.845 nfet
X$121 ny__t016
+ g_vddr_m1|mnt_g|s1_vddr_m1|s2_vddr_m1|s3_vddr_m1|s4_vddr_m1|vddr|vddr4__t0
+ g_vss_m1|inv_clk_vss|inv_mc_vss|inv_q_vss|mph_g|nand_m_vss|nand_s2_vss|s1_vss_m1|s2_vss_m1|s3_vss_m1|s4_vss_m1|sb_vss|sr1_vss|sr2_vss|sr3_vss|sr4_vss|sv_vss|tg_d_vss|tg_fbm_vss|tg_fbs_vss|tg_s_vss|vss|vss_link|vss_link_bridge|vss_link_dip|vss_link_m1|vss_x1|vss_x2|vss_x3__t5
+ g_vss_m1|inv_clk_vss|inv_mc_vss|inv_q_vss|mph_g|nand_m_vss|nand_s2_vss|s1_vss_m1|s2_vss_m1|s3_vss_m1|s4_vss_m1|sb_vss|sr1_vss|sr2_vss|sr3_vss|sr4_vss|sv_vss|tg_d_vss|tg_fbm_vss|tg_fbs_vss|tg_s_vss|vss|vss_link|vss_link_bridge|vss_link_dip|vss_link_m1|vss_x1|vss_x2|vss_x3__t213
+ sky130_fd_pr__nfet_01v8 L=2 W=0.48 AS=0.2016 AD=0.2016 PS=1.8 PD=1.8
* device instance $122 r0 *1 172.125,23.845 nfet
X$122 \$96__t0 en|en4|g_en__t1 ny__t116
+ g_vss_m1|inv_clk_vss|inv_mc_vss|inv_q_vss|mph_g|nand_m_vss|nand_s2_vss|s1_vss_m1|s2_vss_m1|s3_vss_m1|s4_vss_m1|sb_vss|sr1_vss|sr2_vss|sr3_vss|sr4_vss|sv_vss|tg_d_vss|tg_fbm_vss|tg_fbs_vss|tg_s_vss|vss|vss_link|vss_link_bridge|vss_link_dip|vss_link_m1|vss_x1|vss_x2|vss_x3__t101
+ sky130_fd_pr__nfet_01v8 L=0.15 W=0.84 AS=0.3948 AD=0.2184 PS=2.62 PD=1.36
* device instance $123 r0 *1 172.795,23.845 nfet
X$123 a|g_y|mnab_y|mpa_y|mpb_y|n1|s1_a|y__t44 a|g_a|rn4|ro|s4_y|y__t5 \$96__t1
+ g_vss_m1|inv_clk_vss|inv_mc_vss|inv_q_vss|mph_g|nand_m_vss|nand_s2_vss|s1_vss_m1|s2_vss_m1|s3_vss_m1|s4_vss_m1|sb_vss|sr1_vss|sr2_vss|sr3_vss|sr4_vss|sv_vss|tg_d_vss|tg_fbm_vss|tg_fbs_vss|tg_s_vss|vss|vss_link|vss_link_bridge|vss_link_dip|vss_link_m1|vss_x1|vss_x2|vss_x3__t123
+ sky130_fd_pr__nfet_01v8 L=0.15 W=0.84 AS=0.2184 AD=0.3948 PS=1.36 PD=2.62
* device instance $124 r0 *1 178.81,23.845 nfet
X$124 ny__t017
+ g_vddr_m1|mnt_g|s1_vddr_m1|s2_vddr_m1|s3_vddr_m1|s4_vddr_m1|vddr|vddr4__t14
+ g_vss_m1|inv_clk_vss|inv_mc_vss|inv_q_vss|mph_g|nand_m_vss|nand_s2_vss|s1_vss_m1|s2_vss_m1|s3_vss_m1|s4_vss_m1|sb_vss|sr1_vss|sr2_vss|sr3_vss|sr4_vss|sv_vss|tg_d_vss|tg_fbm_vss|tg_fbs_vss|tg_s_vss|vss|vss_link|vss_link_bridge|vss_link_dip|vss_link_m1|vss_x1|vss_x2|vss_x3__t29
+ g_vss_m1|inv_clk_vss|inv_mc_vss|inv_q_vss|mph_g|nand_m_vss|nand_s2_vss|s1_vss_m1|s2_vss_m1|s3_vss_m1|s4_vss_m1|sb_vss|sr1_vss|sr2_vss|sr3_vss|sr4_vss|sv_vss|tg_d_vss|tg_fbm_vss|tg_fbs_vss|tg_s_vss|vss|vss_link|vss_link_bridge|vss_link_dip|vss_link_m1|vss_x1|vss_x2|vss_x3__t214
+ sky130_fd_pr__nfet_01v8 L=2 W=0.48 AS=0.2016 AD=0.2016 PS=1.8 PD=1.8
* device instance $125 r0 *1 181.415,23.845 nfet
X$125 a|n2|s1_y|s2_a|y__t14 a|g_y|mnab_y|mpa_y|mpb_y|n1|s1_a|y__t24 ny__t117
+ g_vss_m1|inv_clk_vss|inv_mc_vss|inv_q_vss|mph_g|nand_m_vss|nand_s2_vss|s1_vss_m1|s2_vss_m1|s3_vss_m1|s4_vss_m1|sb_vss|sr1_vss|sr2_vss|sr3_vss|sr4_vss|sv_vss|tg_d_vss|tg_fbm_vss|tg_fbs_vss|tg_s_vss|vss|vss_link|vss_link_bridge|vss_link_dip|vss_link_m1|vss_x1|vss_x2|vss_x3__t187
+ sky130_fd_pr__nfet_01v8 L=0.15 W=0.42 AS=0.1974 AD=0.1974 PS=1.78 PD=1.78
* device instance $126 r0 *1 186.985,23.845 nfet
X$126 ny__t018
+ g_vddr_m1|mnt_g|s1_vddr_m1|s2_vddr_m1|s3_vddr_m1|s4_vddr_m1|vddr|vddr4__t13
+ g_vss_m1|inv_clk_vss|inv_mc_vss|inv_q_vss|mph_g|nand_m_vss|nand_s2_vss|s1_vss_m1|s2_vss_m1|s3_vss_m1|s4_vss_m1|sb_vss|sr1_vss|sr2_vss|sr3_vss|sr4_vss|sv_vss|tg_d_vss|tg_fbm_vss|tg_fbs_vss|tg_s_vss|vss|vss_link|vss_link_bridge|vss_link_dip|vss_link_m1|vss_x1|vss_x2|vss_x3__t28
+ g_vss_m1|inv_clk_vss|inv_mc_vss|inv_q_vss|mph_g|nand_m_vss|nand_s2_vss|s1_vss_m1|s2_vss_m1|s3_vss_m1|s4_vss_m1|sb_vss|sr1_vss|sr2_vss|sr3_vss|sr4_vss|sv_vss|tg_d_vss|tg_fbm_vss|tg_fbs_vss|tg_s_vss|vss|vss_link|vss_link_bridge|vss_link_dip|vss_link_m1|vss_x1|vss_x2|vss_x3__t215
+ sky130_fd_pr__nfet_01v8 L=2 W=0.48 AS=0.2016 AD=0.2016 PS=1.8 PD=1.8
* device instance $127 r0 *1 189.59,23.845 nfet
X$127 a|n3|s2_y|s3_a|y__t13 a|n2|s1_y|s2_a|y__t34 ny__t118
+ g_vss_m1|inv_clk_vss|inv_mc_vss|inv_q_vss|mph_g|nand_m_vss|nand_s2_vss|s1_vss_m1|s2_vss_m1|s3_vss_m1|s4_vss_m1|sb_vss|sr1_vss|sr2_vss|sr3_vss|sr4_vss|sv_vss|tg_d_vss|tg_fbm_vss|tg_fbs_vss|tg_s_vss|vss|vss_link|vss_link_bridge|vss_link_dip|vss_link_m1|vss_x1|vss_x2|vss_x3__t188
+ sky130_fd_pr__nfet_01v8 L=0.15 W=0.42 AS=0.1974 AD=0.1974 PS=1.78 PD=1.78
* device instance $128 r0 *1 195.16,23.845 nfet
X$128 ny__t019
+ g_vddr_m1|mnt_g|s1_vddr_m1|s2_vddr_m1|s3_vddr_m1|s4_vddr_m1|vddr|vddr4__t12
+ g_vss_m1|inv_clk_vss|inv_mc_vss|inv_q_vss|mph_g|nand_m_vss|nand_s2_vss|s1_vss_m1|s2_vss_m1|s3_vss_m1|s4_vss_m1|sb_vss|sr1_vss|sr2_vss|sr3_vss|sr4_vss|sv_vss|tg_d_vss|tg_fbm_vss|tg_fbs_vss|tg_s_vss|vss|vss_link|vss_link_bridge|vss_link_dip|vss_link_m1|vss_x1|vss_x2|vss_x3__t27
+ g_vss_m1|inv_clk_vss|inv_mc_vss|inv_q_vss|mph_g|nand_m_vss|nand_s2_vss|s1_vss_m1|s2_vss_m1|s3_vss_m1|s4_vss_m1|sb_vss|sr1_vss|sr2_vss|sr3_vss|sr4_vss|sv_vss|tg_d_vss|tg_fbm_vss|tg_fbs_vss|tg_s_vss|vss|vss_link|vss_link_bridge|vss_link_dip|vss_link_m1|vss_x1|vss_x2|vss_x3__t216
+ sky130_fd_pr__nfet_01v8 L=2 W=0.48 AS=0.2016 AD=0.2016 PS=1.8 PD=1.8
* device instance $129 r0 *1 197.765,23.845 nfet
X$129 a|n4|s3_y|s4_a|y__t14 a|n3|s2_y|s3_a|y__t33 ny__t119
+ g_vss_m1|inv_clk_vss|inv_mc_vss|inv_q_vss|mph_g|nand_m_vss|nand_s2_vss|s1_vss_m1|s2_vss_m1|s3_vss_m1|s4_vss_m1|sb_vss|sr1_vss|sr2_vss|sr3_vss|sr4_vss|sv_vss|tg_d_vss|tg_fbm_vss|tg_fbs_vss|tg_s_vss|vss|vss_link|vss_link_bridge|vss_link_dip|vss_link_m1|vss_x1|vss_x2|vss_x3__t189
+ sky130_fd_pr__nfet_01v8 L=0.15 W=0.42 AS=0.1974 AD=0.1974 PS=1.78 PD=1.78
* device instance $130 r0 *1 203.335,23.845 nfet
X$130 ny__t020
+ g_vddr_m1|mnt_g|s1_vddr_m1|s2_vddr_m1|s3_vddr_m1|s4_vddr_m1|vddr|vddr4__t11
+ g_vss_m1|inv_clk_vss|inv_mc_vss|inv_q_vss|mph_g|nand_m_vss|nand_s2_vss|s1_vss_m1|s2_vss_m1|s3_vss_m1|s4_vss_m1|sb_vss|sr1_vss|sr2_vss|sr3_vss|sr4_vss|sv_vss|tg_d_vss|tg_fbm_vss|tg_fbs_vss|tg_s_vss|vss|vss_link|vss_link_bridge|vss_link_dip|vss_link_m1|vss_x1|vss_x2|vss_x3__t26
+ g_vss_m1|inv_clk_vss|inv_mc_vss|inv_q_vss|mph_g|nand_m_vss|nand_s2_vss|s1_vss_m1|s2_vss_m1|s3_vss_m1|s4_vss_m1|sb_vss|sr1_vss|sr2_vss|sr3_vss|sr4_vss|sv_vss|tg_d_vss|tg_fbm_vss|tg_fbs_vss|tg_s_vss|vss|vss_link|vss_link_bridge|vss_link_dip|vss_link_m1|vss_x1|vss_x2|vss_x3__t217
+ sky130_fd_pr__nfet_01v8 L=2 W=0.48 AS=0.2016 AD=0.2016 PS=1.8 PD=1.8
* device instance $131 r0 *1 205.94,23.845 nfet
X$131 a|g_a|rn4|ro|s4_y|y__t1 a|n4|s3_y|s4_a|y__t34 ny__t120
+ g_vss_m1|inv_clk_vss|inv_mc_vss|inv_q_vss|mph_g|nand_m_vss|nand_s2_vss|s1_vss_m1|s2_vss_m1|s3_vss_m1|s4_vss_m1|sb_vss|sr1_vss|sr2_vss|sr3_vss|sr4_vss|sv_vss|tg_d_vss|tg_fbm_vss|tg_fbs_vss|tg_s_vss|vss|vss_link|vss_link_bridge|vss_link_dip|vss_link_m1|vss_x1|vss_x2|vss_x3__t190
+ sky130_fd_pr__nfet_01v8 L=0.15 W=0.42 AS=0.1974 AD=0.1974 PS=1.78 PD=1.78
* device instance $132 r0 *1 214.76,23.845 nfet
X$132 a|b|d|invb_a|mn12_g1|mp24_g0|ro4|ro4_esc|sr4_d_stub|tg_d_a|y__t3
+ a|g_a|rn4|ro|s4_y|y__t4
+ g_vss_m1|inv_clk_vss|inv_mc_vss|inv_q_vss|mph_g|nand_m_vss|nand_s2_vss|s1_vss_m1|s2_vss_m1|s3_vss_m1|s4_vss_m1|sb_vss|sr1_vss|sr2_vss|sr3_vss|sr4_vss|sv_vss|tg_d_vss|tg_fbm_vss|tg_fbs_vss|tg_s_vss|vss|vss_link|vss_link_bridge|vss_link_dip|vss_link_m1|vss_x1|vss_x2|vss_x3__t47
+ g_vss_m1|inv_clk_vss|inv_mc_vss|inv_q_vss|mph_g|nand_m_vss|nand_s2_vss|s1_vss_m1|s2_vss_m1|s3_vss_m1|s4_vss_m1|sb_vss|sr1_vss|sr2_vss|sr3_vss|sr4_vss|sv_vss|tg_d_vss|tg_fbm_vss|tg_fbs_vss|tg_s_vss|vss|vss_link|vss_link_bridge|vss_link_dip|vss_link_m1|vss_x1|vss_x2|vss_x3__t191
+ sky130_fd_pr__nfet_01v8 L=0.15 W=0.42 AS=0.1974 AD=0.1974 PS=1.78 PD=1.78
* device instance $133 r0 *1 0.545,3.53 pfet
X$133
+ clkb|clkb_bridge1|clkb_bridge2|clkb_mid|clkb_w|ctrl|ctrlb|inv_clk_y|tg_d_ctrlb|tg_fbm_ctrl|tg_fbs_ctrlb|tg_s_ctrl|y__t1
+ a|clk|ctrl|ctrlb|inv_clk_a|inv_clk_clk_via|tg_d_ctrl|tg_d_ctrl_via|tg_fbm_ctrlb|tg_fbm_ctrlb_via|tg_fbs_ctrl|tg_fbs_ctrl_via|tg_s_ctrlb|tg_s_ctrlb_via__t1
+ a|d|inv_clk_vdd|inv_mc_vdd|inv_q_vdd|mpa_py|mpb_py|nand_m_vdd|nand_s2_vdd|nwell_vdd|sb_vdd|sr1_vdd|sr2_vdd|sr3_vdd|sr4_vdd|sv_d_vdd_tie|sv_vdd|tg_d_a|tg_d_vdd|tg_fbm_vdd|tg_fbs_vdd|tg_s_vdd|vdd|vdd_b1|vdd_b2|vdd_b3|vdd_b4|vdd_link|vdd_link_dip|vdd_x1|vdd_x2|vdd_x3__t0
+ a|d|inv_clk_vdd|inv_mc_vdd|inv_q_vdd|mpa_py|mpb_py|nand_m_vdd|nand_s2_vdd|nwell_vdd|sb_vdd|sr1_vdd|sr2_vdd|sr3_vdd|sr4_vdd|sv_d_vdd_tie|sv_vdd|tg_d_a|tg_d_vdd|tg_fbm_vdd|tg_fbs_vdd|tg_s_vdd|vdd|vdd_b1|vdd_b2|vdd_b3|vdd_b4|vdd_link|vdd_link_dip|vdd_x1|vdd_x2|vdd_x3__t1
+ sky130_fd_pr__pfet_01v8 L=0.15 W=0.84 AS=0.3948 AD=0.3948 PS=2.62 PD=2.62
* device instance $134 r0 *1 5.31,3.53 pfet
X$134 a|d|sb_d_stub|tg_d_a|xo|xo_dip|xo_hop|xo_stub|y__t2
+ a|clk|ctrl|ctrlb|inv_clk_a|inv_clk_clk_via|tg_d_ctrl|tg_d_ctrl_via|tg_fbm_ctrlb|tg_fbm_ctrlb_via|tg_fbs_ctrl|tg_fbs_ctrl_via|tg_s_ctrlb|tg_s_ctrlb_via__t7
+ a|b|m_east|m_west|nand_m_a|nand_m_a_ext_via|nand_m_a_ext_via2|nand_m_a_stub|tg_d_b|tg_d_b_via|tg_d_b_via2|tg_fbm_b|tg_fbm_b_alt_via|tg_fbm_b_alt_via2__t42
+ a|d|inv_clk_vdd|inv_mc_vdd|inv_q_vdd|mpa_py|mpb_py|nand_m_vdd|nand_s2_vdd|nwell_vdd|sb_vdd|sr1_vdd|sr2_vdd|sr3_vdd|sr4_vdd|sv_d_vdd_tie|sv_vdd|tg_d_a|tg_d_vdd|tg_fbm_vdd|tg_fbs_vdd|tg_s_vdd|vdd|vdd_b1|vdd_b2|vdd_b3|vdd_b4|vdd_link|vdd_link_dip|vdd_x1|vdd_x2|vdd_x3__t67
+ sky130_fd_pr__pfet_01v8 L=0.15 W=0.84 AS=0.3948 AD=0.3948 PS=2.62 PD=2.62
* device instance $135 r0 *1 19.835,3.53 pfet
X$135 a|inv_mc_y|inv_mc_y_via|mc|tg_fbm_a|tg_fbm_a_via|y__t0
+ a|inv_mc_a|mb|mnab_y|mpa_y|mpb_y|nand_m_y|tg_s_a|y__t4
+ a|d|inv_clk_vdd|inv_mc_vdd|inv_q_vdd|mpa_py|mpb_py|nand_m_vdd|nand_s2_vdd|nwell_vdd|sb_vdd|sr1_vdd|sr2_vdd|sr3_vdd|sr4_vdd|sv_d_vdd_tie|sv_vdd|tg_d_a|tg_d_vdd|tg_fbm_vdd|tg_fbs_vdd|tg_s_vdd|vdd|vdd_b1|vdd_b2|vdd_b3|vdd_b4|vdd_link|vdd_link_dip|vdd_x1|vdd_x2|vdd_x3__t129
+ a|d|inv_clk_vdd|inv_mc_vdd|inv_q_vdd|mpa_py|mpb_py|nand_m_vdd|nand_s2_vdd|nwell_vdd|sb_vdd|sr1_vdd|sr2_vdd|sr3_vdd|sr4_vdd|sv_d_vdd_tie|sv_vdd|tg_d_a|tg_d_vdd|tg_fbm_vdd|tg_fbs_vdd|tg_s_vdd|vdd|vdd_b1|vdd_b2|vdd_b3|vdd_b4|vdd_link|vdd_link_dip|vdd_x1|vdd_x2|vdd_x3__t68
+ sky130_fd_pr__pfet_01v8 L=0.15 W=0.84 AS=0.3948 AD=0.3948 PS=2.62 PD=2.62
* device instance $136 r0 *1 24.6,3.53 pfet
X$136 a|inv_mc_y|inv_mc_y_via|mc|tg_fbm_a|tg_fbm_a_via|y__t1
+ clkb|clkb_bridge1|clkb_bridge2|clkb_mid|clkb_w|ctrl|ctrlb|inv_clk_y|tg_d_ctrlb|tg_fbm_ctrl|tg_fbs_ctrlb|tg_s_ctrl|y__t2
+ a|b|m_east|m_west|nand_m_a|nand_m_a_ext_via|nand_m_a_ext_via2|nand_m_a_stub|tg_d_b|tg_d_b_via|tg_d_b_via2|tg_fbm_b|tg_fbm_b_alt_via|tg_fbm_b_alt_via2__t52
+ a|d|inv_clk_vdd|inv_mc_vdd|inv_q_vdd|mpa_py|mpb_py|nand_m_vdd|nand_s2_vdd|nwell_vdd|sb_vdd|sr1_vdd|sr2_vdd|sr3_vdd|sr4_vdd|sv_d_vdd_tie|sv_vdd|tg_d_a|tg_d_vdd|tg_fbm_vdd|tg_fbs_vdd|tg_s_vdd|vdd|vdd_b1|vdd_b2|vdd_b3|vdd_b4|vdd_link|vdd_link_dip|vdd_x1|vdd_x2|vdd_x3__t69
+ sky130_fd_pr__pfet_01v8 L=0.15 W=0.84 AS=0.3948 AD=0.3948 PS=2.62 PD=2.62
* device instance $137 r0 *1 29.74,3.53 pfet
X$137 a|inv_mc_a|mb|mnab_y|mpa_y|mpb_y|nand_m_y|tg_s_a|y__t1
+ clkb|clkb_bridge1|clkb_bridge2|clkb_mid|clkb_w|ctrl|ctrlb|inv_clk_y|tg_d_ctrlb|tg_fbm_ctrl|tg_fbs_ctrlb|tg_s_ctrl|y__t3
+ a|b|inv_q_a|inv_q_a_via|s|tg_fbs_b|tg_fbs_b_via|tg_s_b|tg_s_b_via__t4
+ a|d|inv_clk_vdd|inv_mc_vdd|inv_q_vdd|mpa_py|mpb_py|nand_m_vdd|nand_s2_vdd|nwell_vdd|sb_vdd|sr1_vdd|sr2_vdd|sr3_vdd|sr4_vdd|sv_d_vdd_tie|sv_vdd|tg_d_a|tg_d_vdd|tg_fbm_vdd|tg_fbs_vdd|tg_s_vdd|vdd|vdd_b1|vdd_b2|vdd_b3|vdd_b4|vdd_link|vdd_link_dip|vdd_x1|vdd_x2|vdd_x3__t70
+ sky130_fd_pr__pfet_01v8 L=0.15 W=0.84 AS=0.3948 AD=0.3948 PS=2.62 PD=2.62
* device instance $138 r0 *1 36.545,3.53 pfet
X$138
+ a|inv_q_y|inv_q_y_via|inv_q_y_via2|nand_s2_a|nand_s2_a_stub|nand_s2_a_via|nand_s2_a_via2|q|y__t0
+ a|b|inv_q_a|inv_q_a_via|s|tg_fbs_b|tg_fbs_b_via|tg_s_b|tg_s_b_via__t0
+ a|d|inv_clk_vdd|inv_mc_vdd|inv_q_vdd|mpa_py|mpb_py|nand_m_vdd|nand_s2_vdd|nwell_vdd|sb_vdd|sr1_vdd|sr2_vdd|sr3_vdd|sr4_vdd|sv_d_vdd_tie|sv_vdd|tg_d_a|tg_d_vdd|tg_fbm_vdd|tg_fbs_vdd|tg_s_vdd|vdd|vdd_b1|vdd_b2|vdd_b3|vdd_b4|vdd_link|vdd_link_dip|vdd_x1|vdd_x2|vdd_x3__t130
+ a|d|inv_clk_vdd|inv_mc_vdd|inv_q_vdd|mpa_py|mpb_py|nand_m_vdd|nand_s2_vdd|nwell_vdd|sb_vdd|sr1_vdd|sr2_vdd|sr3_vdd|sr4_vdd|sv_d_vdd_tie|sv_vdd|tg_d_a|tg_d_vdd|tg_fbm_vdd|tg_fbs_vdd|tg_s_vdd|vdd|vdd_b1|vdd_b2|vdd_b3|vdd_b4|vdd_link|vdd_link_dip|vdd_x1|vdd_x2|vdd_x3__t71
+ sky130_fd_pr__pfet_01v8 L=0.15 W=0.84 AS=0.3948 AD=0.3948 PS=2.62 PD=2.62
* device instance $139 r0 *1 49.03,3.53 pfet
X$139 a|mnab_y|mpa_y|mpb_y|nand_s2_y|qb|tg_fbs_a|y__t0
+ a|clk|ctrl|ctrlb|inv_clk_a|inv_clk_clk_via|tg_d_ctrl|tg_d_ctrl_via|tg_fbm_ctrlb|tg_fbm_ctrlb_via|tg_fbs_ctrl|tg_fbs_ctrl_via|tg_s_ctrlb|tg_s_ctrlb_via__t8
+ a|b|inv_q_a|inv_q_a_via|s|tg_fbs_b|tg_fbs_b_via|tg_s_b|tg_s_b_via__t5
+ a|d|inv_clk_vdd|inv_mc_vdd|inv_q_vdd|mpa_py|mpb_py|nand_m_vdd|nand_s2_vdd|nwell_vdd|sb_vdd|sr1_vdd|sr2_vdd|sr3_vdd|sr4_vdd|sv_d_vdd_tie|sv_vdd|tg_d_a|tg_d_vdd|tg_fbm_vdd|tg_fbs_vdd|tg_s_vdd|vdd|vdd_b1|vdd_b2|vdd_b3|vdd_b4|vdd_link|vdd_link_dip|vdd_x1|vdd_x2|vdd_x3__t73
+ sky130_fd_pr__pfet_01v8 L=0.15 W=0.84 AS=0.3948 AD=0.3948 PS=2.62 PD=2.62
* device instance $140 r0 *1 56.205,3.53 pfet
X$140
+ clkb|clkb_bridge1|clkb_bridge2|clkb_mid|clkb_w|ctrl|ctrlb|inv_clk_y|tg_d_ctrlb|tg_fbm_ctrl|tg_fbs_ctrlb|tg_s_ctrl|y__t02
+ a|clk|ctrl|ctrlb|inv_clk_a|inv_clk_clk_via|tg_d_ctrl|tg_d_ctrl_via|tg_fbm_ctrlb|tg_fbm_ctrlb_via|tg_fbs_ctrl|tg_fbs_ctrl_via|tg_s_ctrlb|tg_s_ctrlb_via__t10
+ a|d|inv_clk_vdd|inv_mc_vdd|inv_q_vdd|mpa_py|mpb_py|nand_m_vdd|nand_s2_vdd|nwell_vdd|sb_vdd|sr1_vdd|sr2_vdd|sr3_vdd|sr4_vdd|sv_d_vdd_tie|sv_vdd|tg_d_a|tg_d_vdd|tg_fbm_vdd|tg_fbs_vdd|tg_s_vdd|vdd|vdd_b1|vdd_b2|vdd_b3|vdd_b4|vdd_link|vdd_link_dip|vdd_x1|vdd_x2|vdd_x3__t133
+ a|d|inv_clk_vdd|inv_mc_vdd|inv_q_vdd|mpa_py|mpb_py|nand_m_vdd|nand_s2_vdd|nwell_vdd|sb_vdd|sr1_vdd|sr2_vdd|sr3_vdd|sr4_vdd|sv_d_vdd_tie|sv_vdd|tg_d_a|tg_d_vdd|tg_fbm_vdd|tg_fbs_vdd|tg_s_vdd|vdd|vdd_b1|vdd_b2|vdd_b3|vdd_b4|vdd_link|vdd_link_dip|vdd_x1|vdd_x2|vdd_x3__t76
+ sky130_fd_pr__pfet_01v8 L=0.15 W=0.84 AS=0.3948 AD=0.3948 PS=2.62 PD=2.62
* device instance $141 r0 *1 60.97,3.53 pfet
X$141
+ a|d|inv_clk_vdd|inv_mc_vdd|inv_q_vdd|mpa_py|mpb_py|nand_m_vdd|nand_s2_vdd|nwell_vdd|sb_vdd|sr1_vdd|sr2_vdd|sr3_vdd|sr4_vdd|sv_d_vdd_tie|sv_vdd|tg_d_a|tg_d_vdd|tg_fbm_vdd|tg_fbs_vdd|tg_s_vdd|vdd|vdd_b1|vdd_b2|vdd_b3|vdd_b4|vdd_link|vdd_link_dip|vdd_x1|vdd_x2|vdd_x3__t27
+ a|clk|ctrl|ctrlb|inv_clk_a|inv_clk_clk_via|tg_d_ctrl|tg_d_ctrl_via|tg_fbm_ctrlb|tg_fbm_ctrlb_via|tg_fbs_ctrl|tg_fbs_ctrl_via|tg_s_ctrlb|tg_s_ctrlb_via__t11
+ a|b|m_east|m_west|nand_m_a|nand_m_a_ext_via|nand_m_a_ext_via2|nand_m_a_stub|tg_d_b|tg_d_b_via|tg_d_b_via2|tg_fbm_b|tg_fbm_b_alt_via|tg_fbm_b_alt_via2__t33
+ a|d|inv_clk_vdd|inv_mc_vdd|inv_q_vdd|mpa_py|mpb_py|nand_m_vdd|nand_s2_vdd|nwell_vdd|sb_vdd|sr1_vdd|sr2_vdd|sr3_vdd|sr4_vdd|sv_d_vdd_tie|sv_vdd|tg_d_a|tg_d_vdd|tg_fbm_vdd|tg_fbs_vdd|tg_s_vdd|vdd|vdd_b1|vdd_b2|vdd_b3|vdd_b4|vdd_link|vdd_link_dip|vdd_x1|vdd_x2|vdd_x3__t77
+ sky130_fd_pr__pfet_01v8 L=0.15 W=0.84 AS=0.3948 AD=0.3948 PS=2.62 PD=2.62
* device instance $142 r0 *1 75.495,3.53 pfet
X$142 a|inv_mc_y|inv_mc_y_via|mc|tg_fbm_a|tg_fbm_a_via|y__t02
+ a|inv_mc_a|mb|mnab_y|mpa_y|mpb_y|nand_m_y|tg_s_a|y__t32
+ a|d|inv_clk_vdd|inv_mc_vdd|inv_q_vdd|mpa_py|mpb_py|nand_m_vdd|nand_s2_vdd|nwell_vdd|sb_vdd|sr1_vdd|sr2_vdd|sr3_vdd|sr4_vdd|sv_d_vdd_tie|sv_vdd|tg_d_a|tg_d_vdd|tg_fbm_vdd|tg_fbs_vdd|tg_s_vdd|vdd|vdd_b1|vdd_b2|vdd_b3|vdd_b4|vdd_link|vdd_link_dip|vdd_x1|vdd_x2|vdd_x3__t134
+ a|d|inv_clk_vdd|inv_mc_vdd|inv_q_vdd|mpa_py|mpb_py|nand_m_vdd|nand_s2_vdd|nwell_vdd|sb_vdd|sr1_vdd|sr2_vdd|sr3_vdd|sr4_vdd|sv_d_vdd_tie|sv_vdd|tg_d_a|tg_d_vdd|tg_fbm_vdd|tg_fbs_vdd|tg_s_vdd|vdd|vdd_b1|vdd_b2|vdd_b3|vdd_b4|vdd_link|vdd_link_dip|vdd_x1|vdd_x2|vdd_x3__t79
+ sky130_fd_pr__pfet_01v8 L=0.15 W=0.84 AS=0.3948 AD=0.3948 PS=2.62 PD=2.62
* device instance $143 r0 *1 80.26,3.53 pfet
X$143 a|inv_mc_y|inv_mc_y_via|mc|tg_fbm_a|tg_fbm_a_via|y__t12
+ clkb|clkb_bridge1|clkb_bridge2|clkb_mid|clkb_w|ctrl|ctrlb|inv_clk_y|tg_d_ctrlb|tg_fbm_ctrl|tg_fbs_ctrlb|tg_s_ctrl|y__t22
+ a|b|m_east|m_west|nand_m_a|nand_m_a_ext_via|nand_m_a_ext_via2|nand_m_a_stub|tg_d_b|tg_d_b_via|tg_d_b_via2|tg_fbm_b|tg_fbm_b_alt_via|tg_fbm_b_alt_via2__t43
+ a|d|inv_clk_vdd|inv_mc_vdd|inv_q_vdd|mpa_py|mpb_py|nand_m_vdd|nand_s2_vdd|nwell_vdd|sb_vdd|sr1_vdd|sr2_vdd|sr3_vdd|sr4_vdd|sv_d_vdd_tie|sv_vdd|tg_d_a|tg_d_vdd|tg_fbm_vdd|tg_fbs_vdd|tg_s_vdd|vdd|vdd_b1|vdd_b2|vdd_b3|vdd_b4|vdd_link|vdd_link_dip|vdd_x1|vdd_x2|vdd_x3__t80
+ sky130_fd_pr__pfet_01v8 L=0.15 W=0.84 AS=0.3948 AD=0.3948 PS=2.62 PD=2.62
* device instance $144 r0 *1 85.4,3.53 pfet
X$144 a|inv_mc_a|mb|mnab_y|mpa_y|mpb_y|nand_m_y|tg_s_a|y__t02
+ clkb|clkb_bridge1|clkb_bridge2|clkb_mid|clkb_w|ctrl|ctrlb|inv_clk_y|tg_d_ctrlb|tg_fbm_ctrl|tg_fbs_ctrlb|tg_s_ctrl|y__t32
+ a|b|inv_q_a|inv_q_a_via|s|tg_fbs_b|tg_fbs_b_via|tg_s_b|tg_s_b_via__t52
+ a|d|inv_clk_vdd|inv_mc_vdd|inv_q_vdd|mpa_py|mpb_py|nand_m_vdd|nand_s2_vdd|nwell_vdd|sb_vdd|sr1_vdd|sr2_vdd|sr3_vdd|sr4_vdd|sv_d_vdd_tie|sv_vdd|tg_d_a|tg_d_vdd|tg_fbm_vdd|tg_fbs_vdd|tg_s_vdd|vdd|vdd_b1|vdd_b2|vdd_b3|vdd_b4|vdd_link|vdd_link_dip|vdd_x1|vdd_x2|vdd_x3__t84
+ sky130_fd_pr__pfet_01v8 L=0.15 W=0.84 AS=0.3948 AD=0.3948 PS=2.62 PD=2.62
* device instance $145 r0 *1 92.205,3.53 pfet
X$145
+ a|inv_q_y|inv_q_y_via|inv_q_y_via2|nand_s2_a|nand_s2_a_stub|nand_s2_a_via|nand_s2_a_via2|q|y__t02
+ a|b|inv_q_a|inv_q_a_via|s|tg_fbs_b|tg_fbs_b_via|tg_s_b|tg_s_b_via__t02
+ a|d|inv_clk_vdd|inv_mc_vdd|inv_q_vdd|mpa_py|mpb_py|nand_m_vdd|nand_s2_vdd|nwell_vdd|sb_vdd|sr1_vdd|sr2_vdd|sr3_vdd|sr4_vdd|sv_d_vdd_tie|sv_vdd|tg_d_a|tg_d_vdd|tg_fbm_vdd|tg_fbs_vdd|tg_s_vdd|vdd|vdd_b1|vdd_b2|vdd_b3|vdd_b4|vdd_link|vdd_link_dip|vdd_x1|vdd_x2|vdd_x3__t136
+ a|d|inv_clk_vdd|inv_mc_vdd|inv_q_vdd|mpa_py|mpb_py|nand_m_vdd|nand_s2_vdd|nwell_vdd|sb_vdd|sr1_vdd|sr2_vdd|sr3_vdd|sr4_vdd|sv_d_vdd_tie|sv_vdd|tg_d_a|tg_d_vdd|tg_fbm_vdd|tg_fbs_vdd|tg_s_vdd|vdd|vdd_b1|vdd_b2|vdd_b3|vdd_b4|vdd_link|vdd_link_dip|vdd_x1|vdd_x2|vdd_x3__t83
+ sky130_fd_pr__pfet_01v8 L=0.15 W=0.84 AS=0.3948 AD=0.3948 PS=2.62 PD=2.62
* device instance $146 r0 *1 104.69,3.53 pfet
X$146 a|mnab_y|mpa_y|mpb_y|nand_s2_y|qb|tg_fbs_a|y__t12
+ a|clk|ctrl|ctrlb|inv_clk_a|inv_clk_clk_via|tg_d_ctrl|tg_d_ctrl_via|tg_fbm_ctrlb|tg_fbm_ctrlb_via|tg_fbs_ctrl|tg_fbs_ctrl_via|tg_s_ctrlb|tg_s_ctrlb_via__t12
+ a|b|inv_q_a|inv_q_a_via|s|tg_fbs_b|tg_fbs_b_via|tg_s_b|tg_s_b_via__t42
+ a|d|inv_clk_vdd|inv_mc_vdd|inv_q_vdd|mpa_py|mpb_py|nand_m_vdd|nand_s2_vdd|nwell_vdd|sb_vdd|sr1_vdd|sr2_vdd|sr3_vdd|sr4_vdd|sv_d_vdd_tie|sv_vdd|tg_d_a|tg_d_vdd|tg_fbm_vdd|tg_fbs_vdd|tg_s_vdd|vdd|vdd_b1|vdd_b2|vdd_b3|vdd_b4|vdd_link|vdd_link_dip|vdd_x1|vdd_x2|vdd_x3__t82
+ sky130_fd_pr__pfet_01v8 L=0.15 W=0.84 AS=0.3948 AD=0.3948 PS=2.62 PD=2.62
* device instance $147 r0 *1 111.865,3.53 pfet
X$147
+ clkb|clkb_bridge1|clkb_bridge2|clkb_mid|clkb_w|ctrl|ctrlb|inv_clk_y|tg_d_ctrlb|tg_fbm_ctrl|tg_fbs_ctrlb|tg_s_ctrl|y__t03
+ a|clk|ctrl|ctrlb|inv_clk_a|inv_clk_clk_via|tg_d_ctrl|tg_d_ctrl_via|tg_fbm_ctrlb|tg_fbm_ctrlb_via|tg_fbs_ctrl|tg_fbs_ctrl_via|tg_s_ctrlb|tg_s_ctrlb_via__t9
+ a|d|inv_clk_vdd|inv_mc_vdd|inv_q_vdd|mpa_py|mpb_py|nand_m_vdd|nand_s2_vdd|nwell_vdd|sb_vdd|sr1_vdd|sr2_vdd|sr3_vdd|sr4_vdd|sv_d_vdd_tie|sv_vdd|tg_d_a|tg_d_vdd|tg_fbm_vdd|tg_fbs_vdd|tg_s_vdd|vdd|vdd_b1|vdd_b2|vdd_b3|vdd_b4|vdd_link|vdd_link_dip|vdd_x1|vdd_x2|vdd_x3__t132
+ a|d|inv_clk_vdd|inv_mc_vdd|inv_q_vdd|mpa_py|mpb_py|nand_m_vdd|nand_s2_vdd|nwell_vdd|sb_vdd|sr1_vdd|sr2_vdd|sr3_vdd|sr4_vdd|sv_d_vdd_tie|sv_vdd|tg_d_a|tg_d_vdd|tg_fbm_vdd|tg_fbs_vdd|tg_s_vdd|vdd|vdd_b1|vdd_b2|vdd_b3|vdd_b4|vdd_link|vdd_link_dip|vdd_x1|vdd_x2|vdd_x3__t75
+ sky130_fd_pr__pfet_01v8 L=0.15 W=0.84 AS=0.3948 AD=0.3948 PS=2.62 PD=2.62
* device instance $148 r0 *1 116.63,3.53 pfet
X$148 a|d|inva_a|mn12_g0|mp13_g0|ro1|ro1_esc|sr1_d_stub|tg_d_a|y__t2
+ a|clk|ctrl|ctrlb|inv_clk_a|inv_clk_clk_via|tg_d_ctrl|tg_d_ctrl_via|tg_fbm_ctrlb|tg_fbm_ctrlb_via|tg_fbs_ctrl|tg_fbs_ctrl_via|tg_s_ctrlb|tg_s_ctrlb_via__t6
+ a|b|m_east|m_west|nand_m_a|nand_m_a_ext_via|nand_m_a_ext_via2|nand_m_a_stub|tg_d_b|tg_d_b_via|tg_d_b_via2|tg_fbm_b|tg_fbm_b_alt_via|tg_fbm_b_alt_via2__t34
+ a|d|inv_clk_vdd|inv_mc_vdd|inv_q_vdd|mpa_py|mpb_py|nand_m_vdd|nand_s2_vdd|nwell_vdd|sb_vdd|sr1_vdd|sr2_vdd|sr3_vdd|sr4_vdd|sv_d_vdd_tie|sv_vdd|tg_d_a|tg_d_vdd|tg_fbm_vdd|tg_fbs_vdd|tg_s_vdd|vdd|vdd_b1|vdd_b2|vdd_b3|vdd_b4|vdd_link|vdd_link_dip|vdd_x1|vdd_x2|vdd_x3__t66
+ sky130_fd_pr__pfet_01v8 L=0.15 W=0.84 AS=0.3948 AD=0.3948 PS=2.62 PD=2.62
* device instance $149 r0 *1 131.155,3.53 pfet
X$149 a|inv_mc_y|inv_mc_y_via|mc|tg_fbm_a|tg_fbm_a_via|y__t03
+ a|inv_mc_a|mb|mnab_y|mpa_y|mpb_y|nand_m_y|tg_s_a|y__t33
+ a|d|inv_clk_vdd|inv_mc_vdd|inv_q_vdd|mpa_py|mpb_py|nand_m_vdd|nand_s2_vdd|nwell_vdd|sb_vdd|sr1_vdd|sr2_vdd|sr3_vdd|sr4_vdd|sv_d_vdd_tie|sv_vdd|tg_d_a|tg_d_vdd|tg_fbm_vdd|tg_fbs_vdd|tg_s_vdd|vdd|vdd_b1|vdd_b2|vdd_b3|vdd_b4|vdd_link|vdd_link_dip|vdd_x1|vdd_x2|vdd_x3__t128
+ a|d|inv_clk_vdd|inv_mc_vdd|inv_q_vdd|mpa_py|mpb_py|nand_m_vdd|nand_s2_vdd|nwell_vdd|sb_vdd|sr1_vdd|sr2_vdd|sr3_vdd|sr4_vdd|sv_d_vdd_tie|sv_vdd|tg_d_a|tg_d_vdd|tg_fbm_vdd|tg_fbs_vdd|tg_s_vdd|vdd|vdd_b1|vdd_b2|vdd_b3|vdd_b4|vdd_link|vdd_link_dip|vdd_x1|vdd_x2|vdd_x3__t65
+ sky130_fd_pr__pfet_01v8 L=0.15 W=0.84 AS=0.3948 AD=0.3948 PS=2.62 PD=2.62
* device instance $150 r0 *1 135.92,3.53 pfet
X$150 a|inv_mc_y|inv_mc_y_via|mc|tg_fbm_a|tg_fbm_a_via|y__t13
+ clkb|clkb_bridge1|clkb_bridge2|clkb_mid|clkb_w|ctrl|ctrlb|inv_clk_y|tg_d_ctrlb|tg_fbm_ctrl|tg_fbs_ctrlb|tg_s_ctrl|y__t33
+ a|b|m_east|m_west|nand_m_a|nand_m_a_ext_via|nand_m_a_ext_via2|nand_m_a_stub|tg_d_b|tg_d_b_via|tg_d_b_via2|tg_fbm_b|tg_fbm_b_alt_via|tg_fbm_b_alt_via2__t44
+ a|d|inv_clk_vdd|inv_mc_vdd|inv_q_vdd|mpa_py|mpb_py|nand_m_vdd|nand_s2_vdd|nwell_vdd|sb_vdd|sr1_vdd|sr2_vdd|sr3_vdd|sr4_vdd|sv_d_vdd_tie|sv_vdd|tg_d_a|tg_d_vdd|tg_fbm_vdd|tg_fbs_vdd|tg_s_vdd|vdd|vdd_b1|vdd_b2|vdd_b3|vdd_b4|vdd_link|vdd_link_dip|vdd_x1|vdd_x2|vdd_x3__t103
+ sky130_fd_pr__pfet_01v8 L=0.15 W=0.84 AS=0.3948 AD=0.3948 PS=2.62 PD=2.62
* device instance $151 r0 *1 141.06,3.53 pfet
X$151 a|inv_mc_a|mb|mnab_y|mpa_y|mpb_y|nand_m_y|tg_s_a|y__t13
+ clkb|clkb_bridge1|clkb_bridge2|clkb_mid|clkb_w|ctrl|ctrlb|inv_clk_y|tg_d_ctrlb|tg_fbm_ctrl|tg_fbs_ctrlb|tg_s_ctrl|y__t23
+ a|b|inv_q_a|inv_q_a_via|s|tg_fbs_b|tg_fbs_b_via|tg_s_b|tg_s_b_via__t53
+ a|d|inv_clk_vdd|inv_mc_vdd|inv_q_vdd|mpa_py|mpb_py|nand_m_vdd|nand_s2_vdd|nwell_vdd|sb_vdd|sr1_vdd|sr2_vdd|sr3_vdd|sr4_vdd|sv_d_vdd_tie|sv_vdd|tg_d_a|tg_d_vdd|tg_fbm_vdd|tg_fbs_vdd|tg_s_vdd|vdd|vdd_b1|vdd_b2|vdd_b3|vdd_b4|vdd_link|vdd_link_dip|vdd_x1|vdd_x2|vdd_x3__t100
+ sky130_fd_pr__pfet_01v8 L=0.15 W=0.84 AS=0.3948 AD=0.3948 PS=2.62 PD=2.62
* device instance $152 r0 *1 147.865,3.53 pfet
X$152
+ a|inv_q_y|inv_q_y_via|inv_q_y_via2|nand_s2_a|nand_s2_a_stub|nand_s2_a_via|nand_s2_a_via2|q|y__t03
+ a|b|inv_q_a|inv_q_a_via|s|tg_fbs_b|tg_fbs_b_via|tg_s_b|tg_s_b_via__t03
+ a|d|inv_clk_vdd|inv_mc_vdd|inv_q_vdd|mpa_py|mpb_py|nand_m_vdd|nand_s2_vdd|nwell_vdd|sb_vdd|sr1_vdd|sr2_vdd|sr3_vdd|sr4_vdd|sv_d_vdd_tie|sv_vdd|tg_d_a|tg_d_vdd|tg_fbm_vdd|tg_fbs_vdd|tg_s_vdd|vdd|vdd_b1|vdd_b2|vdd_b3|vdd_b4|vdd_link|vdd_link_dip|vdd_x1|vdd_x2|vdd_x3__t141
+ a|d|inv_clk_vdd|inv_mc_vdd|inv_q_vdd|mpa_py|mpb_py|nand_m_vdd|nand_s2_vdd|nwell_vdd|sb_vdd|sr1_vdd|sr2_vdd|sr3_vdd|sr4_vdd|sv_d_vdd_tie|sv_vdd|tg_d_a|tg_d_vdd|tg_fbm_vdd|tg_fbs_vdd|tg_s_vdd|vdd|vdd_b1|vdd_b2|vdd_b3|vdd_b4|vdd_link|vdd_link_dip|vdd_x1|vdd_x2|vdd_x3__t94
+ sky130_fd_pr__pfet_01v8 L=0.15 W=0.84 AS=0.3948 AD=0.3948 PS=2.62 PD=2.62
* device instance $153 r0 *1 160.35,3.53 pfet
X$153 a|mnab_y|mpa_y|mpb_y|nand_s2_y|qb|tg_fbs_a|y__t03
+ a|clk|ctrl|ctrlb|inv_clk_a|inv_clk_clk_via|tg_d_ctrl|tg_d_ctrl_via|tg_fbm_ctrlb|tg_fbm_ctrlb_via|tg_fbs_ctrl|tg_fbs_ctrl_via|tg_s_ctrlb|tg_s_ctrlb_via__t16
+ a|b|inv_q_a|inv_q_a_via|s|tg_fbs_b|tg_fbs_b_via|tg_s_b|tg_s_b_via__t43
+ a|d|inv_clk_vdd|inv_mc_vdd|inv_q_vdd|mpa_py|mpb_py|nand_m_vdd|nand_s2_vdd|nwell_vdd|sb_vdd|sr1_vdd|sr2_vdd|sr3_vdd|sr4_vdd|sv_d_vdd_tie|sv_vdd|tg_d_a|tg_d_vdd|tg_fbm_vdd|tg_fbs_vdd|tg_s_vdd|vdd|vdd_b1|vdd_b2|vdd_b3|vdd_b4|vdd_link|vdd_link_dip|vdd_x1|vdd_x2|vdd_x3__t93
+ sky130_fd_pr__pfet_01v8 L=0.15 W=0.84 AS=0.3948 AD=0.3948 PS=2.62 PD=2.62
* device instance $154 r0 *1 167.525,3.53 pfet
X$154
+ clkb|clkb_bridge1|clkb_bridge2|clkb_mid|clkb_w|ctrl|ctrlb|inv_clk_y|tg_d_ctrlb|tg_fbm_ctrl|tg_fbs_ctrlb|tg_s_ctrl|y__t04
+ a|clk|ctrl|ctrlb|inv_clk_a|inv_clk_clk_via|tg_d_ctrl|tg_d_ctrl_via|tg_fbm_ctrlb|tg_fbm_ctrlb_via|tg_fbs_ctrl|tg_fbs_ctrl_via|tg_s_ctrlb|tg_s_ctrlb_via__t17
+ a|d|inv_clk_vdd|inv_mc_vdd|inv_q_vdd|mpa_py|mpb_py|nand_m_vdd|nand_s2_vdd|nwell_vdd|sb_vdd|sr1_vdd|sr2_vdd|sr3_vdd|sr4_vdd|sv_d_vdd_tie|sv_vdd|tg_d_a|tg_d_vdd|tg_fbm_vdd|tg_fbs_vdd|tg_s_vdd|vdd|vdd_b1|vdd_b2|vdd_b3|vdd_b4|vdd_link|vdd_link_dip|vdd_x1|vdd_x2|vdd_x3__t143
+ a|d|inv_clk_vdd|inv_mc_vdd|inv_q_vdd|mpa_py|mpb_py|nand_m_vdd|nand_s2_vdd|nwell_vdd|sb_vdd|sr1_vdd|sr2_vdd|sr3_vdd|sr4_vdd|sv_d_vdd_tie|sv_vdd|tg_d_a|tg_d_vdd|tg_fbm_vdd|tg_fbs_vdd|tg_s_vdd|vdd|vdd_b1|vdd_b2|vdd_b3|vdd_b4|vdd_link|vdd_link_dip|vdd_x1|vdd_x2|vdd_x3__t96
+ sky130_fd_pr__pfet_01v8 L=0.15 W=0.84 AS=0.3948 AD=0.3948 PS=2.62 PD=2.62
* device instance $155 r0 *1 172.29,3.53 pfet
X$155 a|b|d|invb_a|mn12_g1|mp24_g0|ro2|ro2_esc|sr2_d_stub|tg_d_a|y__t2
+ a|clk|ctrl|ctrlb|inv_clk_a|inv_clk_clk_via|tg_d_ctrl|tg_d_ctrl_via|tg_fbm_ctrlb|tg_fbm_ctrlb_via|tg_fbs_ctrl|tg_fbs_ctrl_via|tg_s_ctrlb|tg_s_ctrlb_via__t18
+ a|b|m_east|m_west|nand_m_a|nand_m_a_ext_via|nand_m_a_ext_via2|nand_m_a_stub|tg_d_b|tg_d_b_via|tg_d_b_via2|tg_fbm_b|tg_fbm_b_alt_via|tg_fbm_b_alt_via2__t45
+ a|d|inv_clk_vdd|inv_mc_vdd|inv_q_vdd|mpa_py|mpb_py|nand_m_vdd|nand_s2_vdd|nwell_vdd|sb_vdd|sr1_vdd|sr2_vdd|sr3_vdd|sr4_vdd|sv_d_vdd_tie|sv_vdd|tg_d_a|tg_d_vdd|tg_fbm_vdd|tg_fbs_vdd|tg_s_vdd|vdd|vdd_b1|vdd_b2|vdd_b3|vdd_b4|vdd_link|vdd_link_dip|vdd_x1|vdd_x2|vdd_x3__t107
+ sky130_fd_pr__pfet_01v8 L=0.15 W=0.84 AS=0.3948 AD=0.3948 PS=2.62 PD=2.62
* device instance $156 r0 *1 186.815,3.53 pfet
X$156 a|inv_mc_y|inv_mc_y_via|mc|tg_fbm_a|tg_fbm_a_via|y__t14
+ a|inv_mc_a|mb|mnab_y|mpa_y|mpb_y|nand_m_y|tg_s_a|y__t34
+ a|d|inv_clk_vdd|inv_mc_vdd|inv_q_vdd|mpa_py|mpb_py|nand_m_vdd|nand_s2_vdd|nwell_vdd|sb_vdd|sr1_vdd|sr2_vdd|sr3_vdd|sr4_vdd|sv_d_vdd_tie|sv_vdd|tg_d_a|tg_d_vdd|tg_fbm_vdd|tg_fbs_vdd|tg_s_vdd|vdd|vdd_b1|vdd_b2|vdd_b3|vdd_b4|vdd_link|vdd_link_dip|vdd_x1|vdd_x2|vdd_x3__t146
+ a|d|inv_clk_vdd|inv_mc_vdd|inv_q_vdd|mpa_py|mpb_py|nand_m_vdd|nand_s2_vdd|nwell_vdd|sb_vdd|sr1_vdd|sr2_vdd|sr3_vdd|sr4_vdd|sv_d_vdd_tie|sv_vdd|tg_d_a|tg_d_vdd|tg_fbm_vdd|tg_fbs_vdd|tg_s_vdd|vdd|vdd_b1|vdd_b2|vdd_b3|vdd_b4|vdd_link|vdd_link_dip|vdd_x1|vdd_x2|vdd_x3__t104
+ sky130_fd_pr__pfet_01v8 L=0.15 W=0.84 AS=0.3948 AD=0.3948 PS=2.62 PD=2.62
* device instance $157 r0 *1 191.58,3.53 pfet
X$157 a|inv_mc_y|inv_mc_y_via|mc|tg_fbm_a|tg_fbm_a_via|y__t04
+ clkb|clkb_bridge1|clkb_bridge2|clkb_mid|clkb_w|ctrl|ctrlb|inv_clk_y|tg_d_ctrlb|tg_fbm_ctrl|tg_fbs_ctrlb|tg_s_ctrl|y__t24
+ a|b|m_east|m_west|nand_m_a|nand_m_a_ext_via|nand_m_a_ext_via2|nand_m_a_stub|tg_d_b|tg_d_b_via|tg_d_b_via2|tg_fbm_b|tg_fbm_b_alt_via|tg_fbm_b_alt_via2__t35
+ a|d|inv_clk_vdd|inv_mc_vdd|inv_q_vdd|mpa_py|mpb_py|nand_m_vdd|nand_s2_vdd|nwell_vdd|sb_vdd|sr1_vdd|sr2_vdd|sr3_vdd|sr4_vdd|sv_d_vdd_tie|sv_vdd|tg_d_a|tg_d_vdd|tg_fbm_vdd|tg_fbs_vdd|tg_s_vdd|vdd|vdd_b1|vdd_b2|vdd_b3|vdd_b4|vdd_link|vdd_link_dip|vdd_x1|vdd_x2|vdd_x3__t101
+ sky130_fd_pr__pfet_01v8 L=0.15 W=0.84 AS=0.3948 AD=0.3948 PS=2.62 PD=2.62
* device instance $158 r0 *1 196.72,3.53 pfet
X$158 a|inv_mc_a|mb|mnab_y|mpa_y|mpb_y|nand_m_y|tg_s_a|y__t14
+ clkb|clkb_bridge1|clkb_bridge2|clkb_mid|clkb_w|ctrl|ctrlb|inv_clk_y|tg_d_ctrlb|tg_fbm_ctrl|tg_fbs_ctrlb|tg_s_ctrl|y__t34
+ a|b|inv_q_a|inv_q_a_via|s|tg_fbs_b|tg_fbs_b_via|tg_s_b|tg_s_b_via__t54
+ a|d|inv_clk_vdd|inv_mc_vdd|inv_q_vdd|mpa_py|mpb_py|nand_m_vdd|nand_s2_vdd|nwell_vdd|sb_vdd|sr1_vdd|sr2_vdd|sr3_vdd|sr4_vdd|sv_d_vdd_tie|sv_vdd|tg_d_a|tg_d_vdd|tg_fbm_vdd|tg_fbs_vdd|tg_s_vdd|vdd|vdd_b1|vdd_b2|vdd_b3|vdd_b4|vdd_link|vdd_link_dip|vdd_x1|vdd_x2|vdd_x3__t108
+ sky130_fd_pr__pfet_01v8 L=0.15 W=0.84 AS=0.3948 AD=0.3948 PS=2.62 PD=2.62
* device instance $159 r0 *1 203.525,3.53 pfet
X$159
+ a|inv_q_y|inv_q_y_via|inv_q_y_via2|nand_s2_a|nand_s2_a_stub|nand_s2_a_via|nand_s2_a_via2|q|y__t04
+ a|b|inv_q_a|inv_q_a_via|s|tg_fbs_b|tg_fbs_b_via|tg_s_b|tg_s_b_via__t04
+ a|d|inv_clk_vdd|inv_mc_vdd|inv_q_vdd|mpa_py|mpb_py|nand_m_vdd|nand_s2_vdd|nwell_vdd|sb_vdd|sr1_vdd|sr2_vdd|sr3_vdd|sr4_vdd|sv_d_vdd_tie|sv_vdd|tg_d_a|tg_d_vdd|tg_fbm_vdd|tg_fbs_vdd|tg_s_vdd|vdd|vdd_b1|vdd_b2|vdd_b3|vdd_b4|vdd_link|vdd_link_dip|vdd_x1|vdd_x2|vdd_x3__t142
+ a|d|inv_clk_vdd|inv_mc_vdd|inv_q_vdd|mpa_py|mpb_py|nand_m_vdd|nand_s2_vdd|nwell_vdd|sb_vdd|sr1_vdd|sr2_vdd|sr3_vdd|sr4_vdd|sv_d_vdd_tie|sv_vdd|tg_d_a|tg_d_vdd|tg_fbm_vdd|tg_fbs_vdd|tg_s_vdd|vdd|vdd_b1|vdd_b2|vdd_b3|vdd_b4|vdd_link|vdd_link_dip|vdd_x1|vdd_x2|vdd_x3__t95
+ sky130_fd_pr__pfet_01v8 L=0.15 W=0.84 AS=0.3948 AD=0.3948 PS=2.62 PD=2.62
* device instance $160 r0 *1 216.01,3.53 pfet
X$160 a|mnab_y|mpa_y|mpb_y|nand_s2_y|qb|tg_fbs_a|y__t14
+ a|clk|ctrl|ctrlb|inv_clk_a|inv_clk_clk_via|tg_d_ctrl|tg_d_ctrl_via|tg_fbm_ctrlb|tg_fbm_ctrlb_via|tg_fbs_ctrl|tg_fbs_ctrl_via|tg_s_ctrlb|tg_s_ctrlb_via__t15
+ a|b|inv_q_a|inv_q_a_via|s|tg_fbs_b|tg_fbs_b_via|tg_s_b|tg_s_b_via__t44
+ a|d|inv_clk_vdd|inv_mc_vdd|inv_q_vdd|mpa_py|mpb_py|nand_m_vdd|nand_s2_vdd|nwell_vdd|sb_vdd|sr1_vdd|sr2_vdd|sr3_vdd|sr4_vdd|sv_d_vdd_tie|sv_vdd|tg_d_a|tg_d_vdd|tg_fbm_vdd|tg_fbs_vdd|tg_s_vdd|vdd|vdd_b1|vdd_b2|vdd_b3|vdd_b4|vdd_link|vdd_link_dip|vdd_x1|vdd_x2|vdd_x3__t90
+ sky130_fd_pr__pfet_01v8 L=0.15 W=0.84 AS=0.3948 AD=0.3948 PS=2.62 PD=2.62
* device instance $161 r0 *1 223.185,3.53 pfet
X$161
+ clkb|clkb_bridge1|clkb_bridge2|clkb_mid|clkb_w|ctrl|ctrlb|inv_clk_y|tg_d_ctrlb|tg_fbm_ctrl|tg_fbs_ctrlb|tg_s_ctrl|y__t05
+ a|clk|ctrl|ctrlb|inv_clk_a|inv_clk_clk_via|tg_d_ctrl|tg_d_ctrl_via|tg_fbm_ctrlb|tg_fbm_ctrlb_via|tg_fbs_ctrl|tg_fbs_ctrl_via|tg_s_ctrlb|tg_s_ctrlb_via__t14
+ a|d|inv_clk_vdd|inv_mc_vdd|inv_q_vdd|mpa_py|mpb_py|nand_m_vdd|nand_s2_vdd|nwell_vdd|sb_vdd|sr1_vdd|sr2_vdd|sr3_vdd|sr4_vdd|sv_d_vdd_tie|sv_vdd|tg_d_a|tg_d_vdd|tg_fbm_vdd|tg_fbs_vdd|tg_s_vdd|vdd|vdd_b1|vdd_b2|vdd_b3|vdd_b4|vdd_link|vdd_link_dip|vdd_x1|vdd_x2|vdd_x3__t139
+ a|d|inv_clk_vdd|inv_mc_vdd|inv_q_vdd|mpa_py|mpb_py|nand_m_vdd|nand_s2_vdd|nwell_vdd|sb_vdd|sr1_vdd|sr2_vdd|sr3_vdd|sr4_vdd|sv_d_vdd_tie|sv_vdd|tg_d_a|tg_d_vdd|tg_fbm_vdd|tg_fbs_vdd|tg_s_vdd|vdd|vdd_b1|vdd_b2|vdd_b3|vdd_b4|vdd_link|vdd_link_dip|vdd_x1|vdd_x2|vdd_x3__t89
+ sky130_fd_pr__pfet_01v8 L=0.15 W=0.84 AS=0.3948 AD=0.3948 PS=2.62 PD=2.62
* device instance $162 r0 *1 227.95,3.53 pfet
X$162
+ a|d|inva_a|mn12_g0|mp13_g0|ro3|ro3_esc_e|ro3_esc_w|ro3_hop|sr3_d_stub|tg_d_a|y__t2
+ a|clk|ctrl|ctrlb|inv_clk_a|inv_clk_clk_via|tg_d_ctrl|tg_d_ctrl_via|tg_fbm_ctrlb|tg_fbm_ctrlb_via|tg_fbs_ctrl|tg_fbs_ctrl_via|tg_s_ctrlb|tg_s_ctrlb_via__t13
+ a|b|m_east|m_west|nand_m_a|nand_m_a_ext_via|nand_m_a_ext_via2|nand_m_a_stub|tg_d_b|tg_d_b_via|tg_d_b_via2|tg_fbm_b|tg_fbm_b_alt_via|tg_fbm_b_alt_via2__t46
+ a|d|inv_clk_vdd|inv_mc_vdd|inv_q_vdd|mpa_py|mpb_py|nand_m_vdd|nand_s2_vdd|nwell_vdd|sb_vdd|sr1_vdd|sr2_vdd|sr3_vdd|sr4_vdd|sv_d_vdd_tie|sv_vdd|tg_d_a|tg_d_vdd|tg_fbm_vdd|tg_fbs_vdd|tg_s_vdd|vdd|vdd_b1|vdd_b2|vdd_b3|vdd_b4|vdd_link|vdd_link_dip|vdd_x1|vdd_x2|vdd_x3__t88
+ sky130_fd_pr__pfet_01v8 L=0.15 W=0.84 AS=0.3948 AD=0.3948 PS=2.62 PD=2.62
* device instance $163 r0 *1 242.475,3.53 pfet
X$163 a|inv_mc_y|inv_mc_y_via|mc|tg_fbm_a|tg_fbm_a_via|y__t15
+ a|inv_mc_a|mb|mnab_y|mpa_y|mpb_y|nand_m_y|tg_s_a|y__t35
+ a|d|inv_clk_vdd|inv_mc_vdd|inv_q_vdd|mpa_py|mpb_py|nand_m_vdd|nand_s2_vdd|nwell_vdd|sb_vdd|sr1_vdd|sr2_vdd|sr3_vdd|sr4_vdd|sv_d_vdd_tie|sv_vdd|tg_d_a|tg_d_vdd|tg_fbm_vdd|tg_fbs_vdd|tg_s_vdd|vdd|vdd_b1|vdd_b2|vdd_b3|vdd_b4|vdd_link|vdd_link_dip|vdd_x1|vdd_x2|vdd_x3__t138
+ a|d|inv_clk_vdd|inv_mc_vdd|inv_q_vdd|mpa_py|mpb_py|nand_m_vdd|nand_s2_vdd|nwell_vdd|sb_vdd|sr1_vdd|sr2_vdd|sr3_vdd|sr4_vdd|sv_d_vdd_tie|sv_vdd|tg_d_a|tg_d_vdd|tg_fbm_vdd|tg_fbs_vdd|tg_s_vdd|vdd|vdd_b1|vdd_b2|vdd_b3|vdd_b4|vdd_link|vdd_link_dip|vdd_x1|vdd_x2|vdd_x3__t87
+ sky130_fd_pr__pfet_01v8 L=0.15 W=0.84 AS=0.3948 AD=0.3948 PS=2.62 PD=2.62
* device instance $164 r0 *1 247.24,3.53 pfet
X$164 a|inv_mc_y|inv_mc_y_via|mc|tg_fbm_a|tg_fbm_a_via|y__t05
+ clkb|clkb_bridge1|clkb_bridge2|clkb_mid|clkb_w|ctrl|ctrlb|inv_clk_y|tg_d_ctrlb|tg_fbm_ctrl|tg_fbs_ctrlb|tg_s_ctrl|y__t35
+ a|b|m_east|m_west|nand_m_a|nand_m_a_ext_via|nand_m_a_ext_via2|nand_m_a_stub|tg_d_b|tg_d_b_via|tg_d_b_via2|tg_fbm_b|tg_fbm_b_alt_via|tg_fbm_b_alt_via2__t36
+ a|d|inv_clk_vdd|inv_mc_vdd|inv_q_vdd|mpa_py|mpb_py|nand_m_vdd|nand_s2_vdd|nwell_vdd|sb_vdd|sr1_vdd|sr2_vdd|sr3_vdd|sr4_vdd|sv_d_vdd_tie|sv_vdd|tg_d_a|tg_d_vdd|tg_fbm_vdd|tg_fbs_vdd|tg_s_vdd|vdd|vdd_b1|vdd_b2|vdd_b3|vdd_b4|vdd_link|vdd_link_dip|vdd_x1|vdd_x2|vdd_x3__t86
+ sky130_fd_pr__pfet_01v8 L=0.15 W=0.84 AS=0.3948 AD=0.3948 PS=2.62 PD=2.62
* device instance $165 r0 *1 252.38,3.53 pfet
X$165 a|inv_mc_a|mb|mnab_y|mpa_y|mpb_y|nand_m_y|tg_s_a|y__t05
+ clkb|clkb_bridge1|clkb_bridge2|clkb_mid|clkb_w|ctrl|ctrlb|inv_clk_y|tg_d_ctrlb|tg_fbm_ctrl|tg_fbs_ctrlb|tg_s_ctrl|y__t25
+ a|b|inv_q_a|inv_q_a_via|s|tg_fbs_b|tg_fbs_b_via|tg_s_b|tg_s_b_via__t45
+ a|d|inv_clk_vdd|inv_mc_vdd|inv_q_vdd|mpa_py|mpb_py|nand_m_vdd|nand_s2_vdd|nwell_vdd|sb_vdd|sr1_vdd|sr2_vdd|sr3_vdd|sr4_vdd|sv_d_vdd_tie|sv_vdd|tg_d_a|tg_d_vdd|tg_fbm_vdd|tg_fbs_vdd|tg_s_vdd|vdd|vdd_b1|vdd_b2|vdd_b3|vdd_b4|vdd_link|vdd_link_dip|vdd_x1|vdd_x2|vdd_x3__t34
+ sky130_fd_pr__pfet_01v8 L=0.15 W=0.84 AS=0.3948 AD=0.3948 PS=2.62 PD=2.62
* device instance $166 r0 *1 259.185,3.53 pfet
X$166
+ a|inv_q_y|inv_q_y_via|inv_q_y_via2|nand_s2_a|nand_s2_a_stub|nand_s2_a_via|nand_s2_a_via2|q|y__t05
+ a|b|inv_q_a|inv_q_a_via|s|tg_fbs_b|tg_fbs_b_via|tg_s_b|tg_s_b_via__t05
+ a|d|inv_clk_vdd|inv_mc_vdd|inv_q_vdd|mpa_py|mpb_py|nand_m_vdd|nand_s2_vdd|nwell_vdd|sb_vdd|sr1_vdd|sr2_vdd|sr3_vdd|sr4_vdd|sv_d_vdd_tie|sv_vdd|tg_d_a|tg_d_vdd|tg_fbm_vdd|tg_fbs_vdd|tg_s_vdd|vdd|vdd_b1|vdd_b2|vdd_b3|vdd_b4|vdd_link|vdd_link_dip|vdd_x1|vdd_x2|vdd_x3__t131
+ a|d|inv_clk_vdd|inv_mc_vdd|inv_q_vdd|mpa_py|mpb_py|nand_m_vdd|nand_s2_vdd|nwell_vdd|sb_vdd|sr1_vdd|sr2_vdd|sr3_vdd|sr4_vdd|sv_d_vdd_tie|sv_vdd|tg_d_a|tg_d_vdd|tg_fbm_vdd|tg_fbs_vdd|tg_s_vdd|vdd|vdd_b1|vdd_b2|vdd_b3|vdd_b4|vdd_link|vdd_link_dip|vdd_x1|vdd_x2|vdd_x3__t74
+ sky130_fd_pr__pfet_01v8 L=0.15 W=0.84 AS=0.3948 AD=0.3948 PS=2.62 PD=2.62
* device instance $167 r0 *1 271.67,3.53 pfet
X$167 a|mnab_y|mpa_y|mpb_y|nand_s2_y|qb|tg_fbs_a|y__t05
+ a|clk|ctrl|ctrlb|inv_clk_a|inv_clk_clk_via|tg_d_ctrl|tg_d_ctrl_via|tg_fbm_ctrlb|tg_fbm_ctrlb_via|tg_fbs_ctrl|tg_fbs_ctrl_via|tg_s_ctrlb|tg_s_ctrlb_via__t2
+ a|b|inv_q_a|inv_q_a_via|s|tg_fbs_b|tg_fbs_b_via|tg_s_b|tg_s_b_via__t55
+ a|d|inv_clk_vdd|inv_mc_vdd|inv_q_vdd|mpa_py|mpb_py|nand_m_vdd|nand_s2_vdd|nwell_vdd|sb_vdd|sr1_vdd|sr2_vdd|sr3_vdd|sr4_vdd|sv_d_vdd_tie|sv_vdd|tg_d_a|tg_d_vdd|tg_fbm_vdd|tg_fbs_vdd|tg_s_vdd|vdd|vdd_b1|vdd_b2|vdd_b3|vdd_b4|vdd_link|vdd_link_dip|vdd_x1|vdd_x2|vdd_x3__t35
+ sky130_fd_pr__pfet_01v8 L=0.15 W=0.84 AS=0.3948 AD=0.3948 PS=2.62 PD=2.62
* device instance $168 r0 *1 278.845,3.53 pfet
X$168
+ clkb|clkb_bridge1|clkb_bridge2|clkb_mid|clkb_w|ctrl|ctrlb|inv_clk_y|tg_d_ctrlb|tg_fbm_ctrl|tg_fbs_ctrlb|tg_s_ctrl|y__t06
+ a|clk|ctrl|ctrlb|inv_clk_a|inv_clk_clk_via|tg_d_ctrl|tg_d_ctrl_via|tg_fbm_ctrlb|tg_fbm_ctrlb_via|tg_fbs_ctrl|tg_fbs_ctrl_via|tg_s_ctrlb|tg_s_ctrlb_via__t3
+ a|d|inv_clk_vdd|inv_mc_vdd|inv_q_vdd|mpa_py|mpb_py|nand_m_vdd|nand_s2_vdd|nwell_vdd|sb_vdd|sr1_vdd|sr2_vdd|sr3_vdd|sr4_vdd|sv_d_vdd_tie|sv_vdd|tg_d_a|tg_d_vdd|tg_fbm_vdd|tg_fbs_vdd|tg_s_vdd|vdd|vdd_b1|vdd_b2|vdd_b3|vdd_b4|vdd_link|vdd_link_dip|vdd_x1|vdd_x2|vdd_x3__t109
+ a|d|inv_clk_vdd|inv_mc_vdd|inv_q_vdd|mpa_py|mpb_py|nand_m_vdd|nand_s2_vdd|nwell_vdd|sb_vdd|sr1_vdd|sr2_vdd|sr3_vdd|sr4_vdd|sv_d_vdd_tie|sv_vdd|tg_d_a|tg_d_vdd|tg_fbm_vdd|tg_fbs_vdd|tg_s_vdd|vdd|vdd_b1|vdd_b2|vdd_b3|vdd_b4|vdd_link|vdd_link_dip|vdd_x1|vdd_x2|vdd_x3__t36
+ sky130_fd_pr__pfet_01v8 L=0.15 W=0.84 AS=0.3948 AD=0.3948 PS=2.62 PD=2.62
* device instance $169 r0 *1 283.61,3.53 pfet
X$169 a|b|d|invb_a|mn12_g1|mp24_g0|ro4|ro4_esc|sr4_d_stub|tg_d_a|y__t1
+ a|clk|ctrl|ctrlb|inv_clk_a|inv_clk_clk_via|tg_d_ctrl|tg_d_ctrl_via|tg_fbm_ctrlb|tg_fbm_ctrlb_via|tg_fbs_ctrl|tg_fbs_ctrl_via|tg_s_ctrlb|tg_s_ctrlb_via__t4
+ a|b|m_east|m_west|nand_m_a|nand_m_a_ext_via|nand_m_a_ext_via2|nand_m_a_stub|tg_d_b|tg_d_b_via|tg_d_b_via2|tg_fbm_b|tg_fbm_b_alt_via|tg_fbm_b_alt_via2__t3
+ a|d|inv_clk_vdd|inv_mc_vdd|inv_q_vdd|mpa_py|mpb_py|nand_m_vdd|nand_s2_vdd|nwell_vdd|sb_vdd|sr1_vdd|sr2_vdd|sr3_vdd|sr4_vdd|sv_d_vdd_tie|sv_vdd|tg_d_a|tg_d_vdd|tg_fbm_vdd|tg_fbs_vdd|tg_s_vdd|vdd|vdd_b1|vdd_b2|vdd_b3|vdd_b4|vdd_link|vdd_link_dip|vdd_x1|vdd_x2|vdd_x3__t39
+ sky130_fd_pr__pfet_01v8 L=0.15 W=0.84 AS=0.3948 AD=0.3948 PS=2.62 PD=2.62
* device instance $170 r0 *1 298.135,3.53 pfet
X$170 a|inv_mc_y|inv_mc_y_via|mc|tg_fbm_a|tg_fbm_a_via|y__t16
+ a|inv_mc_a|mb|mnab_y|mpa_y|mpb_y|nand_m_y|tg_s_a|y__t36
+ a|d|inv_clk_vdd|inv_mc_vdd|inv_q_vdd|mpa_py|mpb_py|nand_m_vdd|nand_s2_vdd|nwell_vdd|sb_vdd|sr1_vdd|sr2_vdd|sr3_vdd|sr4_vdd|sv_d_vdd_tie|sv_vdd|tg_d_a|tg_d_vdd|tg_fbm_vdd|tg_fbs_vdd|tg_s_vdd|vdd|vdd_b1|vdd_b2|vdd_b3|vdd_b4|vdd_link|vdd_link_dip|vdd_x1|vdd_x2|vdd_x3__t119
+ a|d|inv_clk_vdd|inv_mc_vdd|inv_q_vdd|mpa_py|mpb_py|nand_m_vdd|nand_s2_vdd|nwell_vdd|sb_vdd|sr1_vdd|sr2_vdd|sr3_vdd|sr4_vdd|sv_d_vdd_tie|sv_vdd|tg_d_a|tg_d_vdd|tg_fbm_vdd|tg_fbs_vdd|tg_s_vdd|vdd|vdd_b1|vdd_b2|vdd_b3|vdd_b4|vdd_link|vdd_link_dip|vdd_x1|vdd_x2|vdd_x3__t51
+ sky130_fd_pr__pfet_01v8 L=0.15 W=0.84 AS=0.3948 AD=0.3948 PS=2.62 PD=2.62
* device instance $171 r0 *1 302.9,3.53 pfet
X$171 a|inv_mc_y|inv_mc_y_via|mc|tg_fbm_a|tg_fbm_a_via|y__t06
+ clkb|clkb_bridge1|clkb_bridge2|clkb_mid|clkb_w|ctrl|ctrlb|inv_clk_y|tg_d_ctrlb|tg_fbm_ctrl|tg_fbs_ctrlb|tg_s_ctrl|y__t26
+ a|b|m_east|m_west|nand_m_a|nand_m_a_ext_via|nand_m_a_ext_via2|nand_m_a_stub|tg_d_b|tg_d_b_via|tg_d_b_via2|tg_fbm_b|tg_fbm_b_alt_via|tg_fbm_b_alt_via2__t4
+ a|d|inv_clk_vdd|inv_mc_vdd|inv_q_vdd|mpa_py|mpb_py|nand_m_vdd|nand_s2_vdd|nwell_vdd|sb_vdd|sr1_vdd|sr2_vdd|sr3_vdd|sr4_vdd|sv_d_vdd_tie|sv_vdd|tg_d_a|tg_d_vdd|tg_fbm_vdd|tg_fbs_vdd|tg_s_vdd|vdd|vdd_b1|vdd_b2|vdd_b3|vdd_b4|vdd_link|vdd_link_dip|vdd_x1|vdd_x2|vdd_x3__t43
+ sky130_fd_pr__pfet_01v8 L=0.15 W=0.84 AS=0.3948 AD=0.3948 PS=2.62 PD=2.62
* device instance $172 r0 *1 308.04,3.53 pfet
X$172 a|inv_mc_a|mb|mnab_y|mpa_y|mpb_y|nand_m_y|tg_s_a|y__t06
+ clkb|clkb_bridge1|clkb_bridge2|clkb_mid|clkb_w|ctrl|ctrlb|inv_clk_y|tg_d_ctrlb|tg_fbm_ctrl|tg_fbs_ctrlb|tg_s_ctrl|y__t36
+ a|b|inv_q_a|inv_q_a_via|s|tg_fbs_b|tg_fbs_b_via|tg_s_b|tg_s_b_via__t46
+ a|d|inv_clk_vdd|inv_mc_vdd|inv_q_vdd|mpa_py|mpb_py|nand_m_vdd|nand_s2_vdd|nwell_vdd|sb_vdd|sr1_vdd|sr2_vdd|sr3_vdd|sr4_vdd|sv_d_vdd_tie|sv_vdd|tg_d_a|tg_d_vdd|tg_fbm_vdd|tg_fbs_vdd|tg_s_vdd|vdd|vdd_b1|vdd_b2|vdd_b3|vdd_b4|vdd_link|vdd_link_dip|vdd_x1|vdd_x2|vdd_x3__t44
+ sky130_fd_pr__pfet_01v8 L=0.15 W=0.84 AS=0.3948 AD=0.3948 PS=2.62 PD=2.62
* device instance $173 r0 *1 314.845,3.53 pfet
X$173
+ a|inv_q_y|inv_q_y_via|inv_q_y_via2|nand_s2_a|nand_s2_a_stub|nand_s2_a_via|nand_s2_a_via2|q|y__t06
+ a|b|inv_q_a|inv_q_a_via|s|tg_fbs_b|tg_fbs_b_via|tg_s_b|tg_s_b_via__t06
+ a|d|inv_clk_vdd|inv_mc_vdd|inv_q_vdd|mpa_py|mpb_py|nand_m_vdd|nand_s2_vdd|nwell_vdd|sb_vdd|sr1_vdd|sr2_vdd|sr3_vdd|sr4_vdd|sv_d_vdd_tie|sv_vdd|tg_d_a|tg_d_vdd|tg_fbm_vdd|tg_fbs_vdd|tg_s_vdd|vdd|vdd_b1|vdd_b2|vdd_b3|vdd_b4|vdd_link|vdd_link_dip|vdd_x1|vdd_x2|vdd_x3__t115
+ a|d|inv_clk_vdd|inv_mc_vdd|inv_q_vdd|mpa_py|mpb_py|nand_m_vdd|nand_s2_vdd|nwell_vdd|sb_vdd|sr1_vdd|sr2_vdd|sr3_vdd|sr4_vdd|sv_d_vdd_tie|sv_vdd|tg_d_a|tg_d_vdd|tg_fbm_vdd|tg_fbs_vdd|tg_s_vdd|vdd|vdd_b1|vdd_b2|vdd_b3|vdd_b4|vdd_link|vdd_link_dip|vdd_x1|vdd_x2|vdd_x3__t45
+ sky130_fd_pr__pfet_01v8 L=0.15 W=0.84 AS=0.3948 AD=0.3948 PS=2.62 PD=2.62
* device instance $174 r0 *1 327.33,3.53 pfet
X$174 a|mnab_y|mpa_y|mpb_y|nand_s2_y|qb|tg_fbs_a|y__t06
+ a|clk|ctrl|ctrlb|inv_clk_a|inv_clk_clk_via|tg_d_ctrl|tg_d_ctrl_via|tg_fbm_ctrlb|tg_fbm_ctrlb_via|tg_fbs_ctrl|tg_fbs_ctrl_via|tg_s_ctrlb|tg_s_ctrlb_via__t5
+ a|b|inv_q_a|inv_q_a_via|s|tg_fbs_b|tg_fbs_b_via|tg_s_b|tg_s_b_via__t56
+ a|d|inv_clk_vdd|inv_mc_vdd|inv_q_vdd|mpa_py|mpb_py|nand_m_vdd|nand_s2_vdd|nwell_vdd|sb_vdd|sr1_vdd|sr2_vdd|sr3_vdd|sr4_vdd|sv_d_vdd_tie|sv_vdd|tg_d_a|tg_d_vdd|tg_fbm_vdd|tg_fbs_vdd|tg_s_vdd|vdd|vdd_b1|vdd_b2|vdd_b3|vdd_b4|vdd_link|vdd_link_dip|vdd_x1|vdd_x2|vdd_x3__t46
+ sky130_fd_pr__pfet_01v8 L=0.15 W=0.84 AS=0.3948 AD=0.3948 PS=2.62 PD=2.62
* device instance $175 r0 *1 12.115,4.19 pfet
X$175 a|inv_mc_a|mb|mnab_y|mpa_y|mpb_y|nand_m_y|tg_s_a|y__t2
+ en|nand_m_en|nand_m_en_via|nand_s2_en|nand_s2_en_via|rst_n__t9
+ a|d|inv_clk_vdd|inv_mc_vdd|inv_q_vdd|mpa_py|mpb_py|nand_m_vdd|nand_s2_vdd|nwell_vdd|sb_vdd|sr1_vdd|sr2_vdd|sr3_vdd|sr4_vdd|sv_d_vdd_tie|sv_vdd|tg_d_a|tg_d_vdd|tg_fbm_vdd|tg_fbs_vdd|tg_s_vdd|vdd|vdd_b1|vdd_b2|vdd_b3|vdd_b4|vdd_link|vdd_link_dip|vdd_x1|vdd_x2|vdd_x3__t140
+ a|d|inv_clk_vdd|inv_mc_vdd|inv_q_vdd|mpa_py|mpb_py|nand_m_vdd|nand_s2_vdd|nwell_vdd|sb_vdd|sr1_vdd|sr2_vdd|sr3_vdd|sr4_vdd|sv_d_vdd_tie|sv_vdd|tg_d_a|tg_d_vdd|tg_fbm_vdd|tg_fbs_vdd|tg_s_vdd|vdd|vdd_b1|vdd_b2|vdd_b3|vdd_b4|vdd_link|vdd_link_dip|vdd_x1|vdd_x2|vdd_x3__t91
+ sky130_fd_pr__pfet_01v8 L=0.15 W=0.84 AS=0.3948 AD=0.3948 PS=2.62 PD=2.62
* device instance $176 r0 *1 13.405,4.19 pfet
X$176
+ a|d|inv_clk_vdd|inv_mc_vdd|inv_q_vdd|mpa_py|mpb_py|nand_m_vdd|nand_s2_vdd|nwell_vdd|sb_vdd|sr1_vdd|sr2_vdd|sr3_vdd|sr4_vdd|sv_d_vdd_tie|sv_vdd|tg_d_a|tg_d_vdd|tg_fbm_vdd|tg_fbs_vdd|tg_s_vdd|vdd|vdd_b1|vdd_b2|vdd_b3|vdd_b4|vdd_link|vdd_link_dip|vdd_x1|vdd_x2|vdd_x3__t29
+ a|b|m_east|m_west|nand_m_a|nand_m_a_ext_via|nand_m_a_ext_via2|nand_m_a_stub|tg_d_b|tg_d_b_via|tg_d_b_via2|tg_fbm_b|tg_fbm_b_alt_via|tg_fbm_b_alt_via2__t12
+ a|inv_mc_a|mb|mnab_y|mpa_y|mpb_y|nand_m_y|tg_s_a|y__t6
+ a|d|inv_clk_vdd|inv_mc_vdd|inv_q_vdd|mpa_py|mpb_py|nand_m_vdd|nand_s2_vdd|nwell_vdd|sb_vdd|sr1_vdd|sr2_vdd|sr3_vdd|sr4_vdd|sv_d_vdd_tie|sv_vdd|tg_d_a|tg_d_vdd|tg_fbm_vdd|tg_fbs_vdd|tg_s_vdd|vdd|vdd_b1|vdd_b2|vdd_b3|vdd_b4|vdd_link|vdd_link_dip|vdd_x1|vdd_x2|vdd_x3__t92
+ sky130_fd_pr__pfet_01v8 L=0.15 W=0.84 AS=0.3948 AD=0.3948 PS=2.62 PD=2.62
* device instance $177 r0 *1 15.075,27.375 pfet
X$177 a|n2|s1_y|s2_a|y__t0 a|g_y|mnab_y|mpa_y|mpb_y|n1|s1_a|y__t12 py__t1
+ g_vddr_m1|mnt_g|s1_vddr_m1|s2_vddr_m1|s3_vddr_m1|s4_vddr_m1|vddr|vddr1__t15
+ sky130_fd_pr__pfet_01v8 L=0.15 W=0.84 AS=0.3948 AD=0.3948 PS=2.62 PD=2.62
* device instance $178 r0 *1 23.25,27.375 pfet
X$178 a|n3|s2_y|s3_a|y__t0 a|n2|s1_y|s2_a|y__t2 py__t12
+ g_vddr_m1|mnt_g|s1_vddr_m1|s2_vddr_m1|s3_vddr_m1|s4_vddr_m1|vddr|vddr1__t16
+ sky130_fd_pr__pfet_01v8 L=0.15 W=0.84 AS=0.3948 AD=0.3948 PS=2.62 PD=2.62
* device instance $179 r0 *1 31.425,27.375 pfet
X$179 a|n4|s3_y|s4_a|y__t0 a|n3|s2_y|s3_a|y__t2 py__t13
+ g_vddr_m1|mnt_g|s1_vddr_m1|s2_vddr_m1|s3_vddr_m1|s4_vddr_m1|vddr|vddr1__t18
+ sky130_fd_pr__pfet_01v8 L=0.15 W=0.84 AS=0.3948 AD=0.3948 PS=2.62 PD=2.62
* device instance $180 r0 *1 39.6,27.375 pfet
X$180 a|g_a|rn1|ro|s4_y|y__t0 a|n4|s3_y|s4_a|y__t2 py__t14
+ g_vddr_m1|mnt_g|s1_vddr_m1|s2_vddr_m1|s3_vddr_m1|s4_vddr_m1|vddr|vddr1__t19
+ sky130_fd_pr__pfet_01v8 L=0.15 W=0.84 AS=0.3948 AD=0.3948 PS=2.62 PD=2.62
* device instance $181 r0 *1 42.975,4.19 pfet
X$181 a|mnab_y|mpa_y|mpb_y|nand_s2_y|qb|tg_fbs_a|y__t1
+ en|nand_m_en|nand_m_en_via|nand_s2_en|nand_s2_en_via|rst_n__t11
+ a|d|inv_clk_vdd|inv_mc_vdd|inv_q_vdd|mpa_py|mpb_py|nand_m_vdd|nand_s2_vdd|nwell_vdd|sb_vdd|sr1_vdd|sr2_vdd|sr3_vdd|sr4_vdd|sv_d_vdd_tie|sv_vdd|tg_d_a|tg_d_vdd|tg_fbm_vdd|tg_fbs_vdd|tg_s_vdd|vdd|vdd_b1|vdd_b2|vdd_b3|vdd_b4|vdd_link|vdd_link_dip|vdd_x1|vdd_x2|vdd_x3__t145
+ a|d|inv_clk_vdd|inv_mc_vdd|inv_q_vdd|mpa_py|mpb_py|nand_m_vdd|nand_s2_vdd|nwell_vdd|sb_vdd|sr1_vdd|sr2_vdd|sr3_vdd|sr4_vdd|sv_d_vdd_tie|sv_vdd|tg_d_a|tg_d_vdd|tg_fbm_vdd|tg_fbs_vdd|tg_s_vdd|vdd|vdd_b1|vdd_b2|vdd_b3|vdd_b4|vdd_link|vdd_link_dip|vdd_x1|vdd_x2|vdd_x3__t99
+ sky130_fd_pr__pfet_01v8 L=0.15 W=0.84 AS=0.3948 AD=0.3948 PS=2.62 PD=2.62
* device instance $182 r0 *1 44.265,4.19 pfet
X$182
+ a|d|inv_clk_vdd|inv_mc_vdd|inv_q_vdd|mpa_py|mpb_py|nand_m_vdd|nand_s2_vdd|nwell_vdd|sb_vdd|sr1_vdd|sr2_vdd|sr3_vdd|sr4_vdd|sv_d_vdd_tie|sv_vdd|tg_d_a|tg_d_vdd|tg_fbm_vdd|tg_fbs_vdd|tg_s_vdd|vdd|vdd_b1|vdd_b2|vdd_b3|vdd_b4|vdd_link|vdd_link_dip|vdd_x1|vdd_x2|vdd_x3__t31
+ a|inv_q_y|inv_q_y_via|inv_q_y_via2|nand_s2_a|nand_s2_a_stub|nand_s2_a_via|nand_s2_a_via2|q|y__t2
+ a|mnab_y|mpa_y|mpb_y|nand_s2_y|qb|tg_fbs_a|y__t3
+ a|d|inv_clk_vdd|inv_mc_vdd|inv_q_vdd|mpa_py|mpb_py|nand_m_vdd|nand_s2_vdd|nwell_vdd|sb_vdd|sr1_vdd|sr2_vdd|sr3_vdd|sr4_vdd|sv_d_vdd_tie|sv_vdd|tg_d_a|tg_d_vdd|tg_fbm_vdd|tg_fbs_vdd|tg_s_vdd|vdd|vdd_b1|vdd_b2|vdd_b3|vdd_b4|vdd_link|vdd_link_dip|vdd_x1|vdd_x2|vdd_x3__t102
+ sky130_fd_pr__pfet_01v8 L=0.15 W=0.84 AS=0.3948 AD=0.3948 PS=2.62 PD=2.62
* device instance $183 r0 *1 48.86,27.165 pfet
X$183 a|d|inva_a|mn12_g0|mp13_g0|ro1|ro1_esc|sr1_d_stub|tg_d_a|y__t1
+ a|g_a|rn1|ro|s4_y|y__t2
+ a|d|inv_clk_vdd|inv_mc_vdd|inv_q_vdd|mpa_py|mpb_py|nand_m_vdd|nand_s2_vdd|nwell_vdd|sb_vdd|sr1_vdd|sr2_vdd|sr3_vdd|sr4_vdd|sv_d_vdd_tie|sv_vdd|tg_d_a|tg_d_vdd|tg_fbm_vdd|tg_fbs_vdd|tg_s_vdd|vdd|vdd_b1|vdd_b2|vdd_b3|vdd_b4|vdd_link|vdd_link_dip|vdd_x1|vdd_x2|vdd_x3__t124
+ a|d|inv_clk_vdd|inv_mc_vdd|inv_q_vdd|mpa_py|mpb_py|nand_m_vdd|nand_s2_vdd|nwell_vdd|sb_vdd|sr1_vdd|sr2_vdd|sr3_vdd|sr4_vdd|sv_d_vdd_tie|sv_vdd|tg_d_a|tg_d_vdd|tg_fbm_vdd|tg_fbs_vdd|tg_s_vdd|vdd|vdd_b1|vdd_b2|vdd_b3|vdd_b4|vdd_link|vdd_link_dip|vdd_x1|vdd_x2|vdd_x3__t59
+ sky130_fd_pr__pfet_01v8 L=0.15 W=0.84 AS=0.3948 AD=0.3948 PS=2.62 PD=2.62
* device instance $184 r0 *1 67.775,4.19 pfet
X$184 a|inv_mc_a|mb|mnab_y|mpa_y|mpb_y|nand_m_y|tg_s_a|y__t12
+ en|nand_m_en|nand_m_en_via|nand_s2_en|nand_s2_en_via|rst_n__t12
+ a|d|inv_clk_vdd|inv_mc_vdd|inv_q_vdd|mpa_py|mpb_py|nand_m_vdd|nand_s2_vdd|nwell_vdd|sb_vdd|sr1_vdd|sr2_vdd|sr3_vdd|sr4_vdd|sv_d_vdd_tie|sv_vdd|tg_d_a|tg_d_vdd|tg_fbm_vdd|tg_fbs_vdd|tg_s_vdd|vdd|vdd_b1|vdd_b2|vdd_b3|vdd_b4|vdd_link|vdd_link_dip|vdd_x1|vdd_x2|vdd_x3__t147
+ a|d|inv_clk_vdd|inv_mc_vdd|inv_q_vdd|mpa_py|mpb_py|nand_m_vdd|nand_s2_vdd|nwell_vdd|sb_vdd|sr1_vdd|sr2_vdd|sr3_vdd|sr4_vdd|sv_d_vdd_tie|sv_vdd|tg_d_a|tg_d_vdd|tg_fbm_vdd|tg_fbs_vdd|tg_s_vdd|vdd|vdd_b1|vdd_b2|vdd_b3|vdd_b4|vdd_link|vdd_link_dip|vdd_x1|vdd_x2|vdd_x3__t105
+ sky130_fd_pr__pfet_01v8 L=0.15 W=0.84 AS=0.3948 AD=0.3948 PS=2.62 PD=2.62
* device instance $185 r0 *1 69.065,4.19 pfet
X$185
+ a|d|inv_clk_vdd|inv_mc_vdd|inv_q_vdd|mpa_py|mpb_py|nand_m_vdd|nand_s2_vdd|nwell_vdd|sb_vdd|sr1_vdd|sr2_vdd|sr3_vdd|sr4_vdd|sv_d_vdd_tie|sv_vdd|tg_d_a|tg_d_vdd|tg_fbm_vdd|tg_fbs_vdd|tg_s_vdd|vdd|vdd_b1|vdd_b2|vdd_b3|vdd_b4|vdd_link|vdd_link_dip|vdd_x1|vdd_x2|vdd_x3__t32
+ a|b|m_east|m_west|nand_m_a|nand_m_a_ext_via|nand_m_a_ext_via2|nand_m_a_stub|tg_d_b|tg_d_b_via|tg_d_b_via2|tg_fbm_b|tg_fbm_b_alt_via|tg_fbm_b_alt_via2__t03
+ a|inv_mc_a|mb|mnab_y|mpa_y|mpb_y|nand_m_y|tg_s_a|y__t52
+ a|d|inv_clk_vdd|inv_mc_vdd|inv_q_vdd|mpa_py|mpb_py|nand_m_vdd|nand_s2_vdd|nwell_vdd|sb_vdd|sr1_vdd|sr2_vdd|sr3_vdd|sr4_vdd|sv_d_vdd_tie|sv_vdd|tg_d_a|tg_d_vdd|tg_fbm_vdd|tg_fbs_vdd|tg_s_vdd|vdd|vdd_b1|vdd_b2|vdd_b3|vdd_b4|vdd_link|vdd_link_dip|vdd_x1|vdd_x2|vdd_x3__t106
+ sky130_fd_pr__pfet_01v8 L=0.15 W=0.84 AS=0.3948 AD=0.3948 PS=2.62 PD=2.62
* device instance $186 r0 *1 70.375,27.375 pfet
X$186 a|n2|s1_y|s2_a|y__t02 a|g_y|mnab_y|mpa_y|mpb_y|n1|s1_a|y__t1 py__t15
+ g_vddr_m1|mnt_g|s1_vddr_m1|s2_vddr_m1|s3_vddr_m1|s4_vddr_m1|vddr|vddr2__t19
+ sky130_fd_pr__pfet_01v8 L=0.15 W=0.84 AS=0.3948 AD=0.3948 PS=2.62 PD=2.62
* device instance $187 r0 *1 78.55,27.375 pfet
X$187 a|n3|s2_y|s3_a|y__t04 a|n2|s1_y|s2_a|y__t22 py__t16
+ g_vddr_m1|mnt_g|s1_vddr_m1|s2_vddr_m1|s3_vddr_m1|s4_vddr_m1|vddr|vddr2__t20
+ sky130_fd_pr__pfet_01v8 L=0.15 W=0.84 AS=0.3948 AD=0.3948 PS=2.62 PD=2.62
* device instance $188 r0 *1 86.725,27.375 pfet
X$188 a|n4|s3_y|s4_a|y__t03 a|n3|s2_y|s3_a|y__t24 py__t17
+ g_vddr_m1|mnt_g|s1_vddr_m1|s2_vddr_m1|s3_vddr_m1|s4_vddr_m1|vddr|vddr2__t16
+ sky130_fd_pr__pfet_01v8 L=0.15 W=0.84 AS=0.3948 AD=0.3948 PS=2.62 PD=2.62
* device instance $189 r0 *1 94.9,27.375 pfet
X$189 a|g_a|rn2|ro|s4_y|y__t0 a|n4|s3_y|s4_a|y__t23 py__t18
+ g_vddr_m1|mnt_g|s1_vddr_m1|s2_vddr_m1|s3_vddr_m1|s4_vddr_m1|vddr|vddr2__t15
+ sky130_fd_pr__pfet_01v8 L=0.15 W=0.84 AS=0.3948 AD=0.3948 PS=2.62 PD=2.62
* device instance $190 r0 *1 98.635,4.19 pfet
X$190 a|mnab_y|mpa_y|mpb_y|nand_s2_y|qb|tg_fbs_a|y__t02
+ en|nand_m_en|nand_m_en_via|nand_s2_en|nand_s2_en_via|rst_n__t7
+ a|d|inv_clk_vdd|inv_mc_vdd|inv_q_vdd|mpa_py|mpb_py|nand_m_vdd|nand_s2_vdd|nwell_vdd|sb_vdd|sr1_vdd|sr2_vdd|sr3_vdd|sr4_vdd|sv_d_vdd_tie|sv_vdd|tg_d_a|tg_d_vdd|tg_fbm_vdd|tg_fbs_vdd|tg_s_vdd|vdd|vdd_b1|vdd_b2|vdd_b3|vdd_b4|vdd_link|vdd_link_dip|vdd_x1|vdd_x2|vdd_x3__t135
+ a|d|inv_clk_vdd|inv_mc_vdd|inv_q_vdd|mpa_py|mpb_py|nand_m_vdd|nand_s2_vdd|nwell_vdd|sb_vdd|sr1_vdd|sr2_vdd|sr3_vdd|sr4_vdd|sv_d_vdd_tie|sv_vdd|tg_d_a|tg_d_vdd|tg_fbm_vdd|tg_fbs_vdd|tg_s_vdd|vdd|vdd_b1|vdd_b2|vdd_b3|vdd_b4|vdd_link|vdd_link_dip|vdd_x1|vdd_x2|vdd_x3__t81
+ sky130_fd_pr__pfet_01v8 L=0.15 W=0.84 AS=0.3948 AD=0.3948 PS=2.62 PD=2.62
* device instance $191 r0 *1 99.925,4.19 pfet
X$191
+ a|d|inv_clk_vdd|inv_mc_vdd|inv_q_vdd|mpa_py|mpb_py|nand_m_vdd|nand_s2_vdd|nwell_vdd|sb_vdd|sr1_vdd|sr2_vdd|sr3_vdd|sr4_vdd|sv_d_vdd_tie|sv_vdd|tg_d_a|tg_d_vdd|tg_fbm_vdd|tg_fbs_vdd|tg_s_vdd|vdd|vdd_b1|vdd_b2|vdd_b3|vdd_b4|vdd_link|vdd_link_dip|vdd_x1|vdd_x2|vdd_x3__t28
+ a|inv_q_y|inv_q_y_via|inv_q_y_via2|nand_s2_a|nand_s2_a_stub|nand_s2_a_via|nand_s2_a_via2|q|y__t22
+ a|mnab_y|mpa_y|mpb_y|nand_s2_y|qb|tg_fbs_a|y__t32
+ a|d|inv_clk_vdd|inv_mc_vdd|inv_q_vdd|mpa_py|mpb_py|nand_m_vdd|nand_s2_vdd|nwell_vdd|sb_vdd|sr1_vdd|sr2_vdd|sr3_vdd|sr4_vdd|sv_d_vdd_tie|sv_vdd|tg_d_a|tg_d_vdd|tg_fbm_vdd|tg_fbs_vdd|tg_s_vdd|vdd|vdd_b1|vdd_b2|vdd_b3|vdd_b4|vdd_link|vdd_link_dip|vdd_x1|vdd_x2|vdd_x3__t78
+ sky130_fd_pr__pfet_01v8 L=0.15 W=0.84 AS=0.3948 AD=0.3948 PS=2.62 PD=2.62
* device instance $192 r0 *1 104.16,27.165 pfet
X$192 a|b|d|invb_a|mn12_g1|mp24_g0|ro2|ro2_esc|sr2_d_stub|tg_d_a|y__t1
+ a|g_a|rn2|ro|s4_y|y__t2
+ a|d|inv_clk_vdd|inv_mc_vdd|inv_q_vdd|mpa_py|mpb_py|nand_m_vdd|nand_s2_vdd|nwell_vdd|sb_vdd|sr1_vdd|sr2_vdd|sr3_vdd|sr4_vdd|sv_d_vdd_tie|sv_vdd|tg_d_a|tg_d_vdd|tg_fbm_vdd|tg_fbs_vdd|tg_s_vdd|vdd|vdd_b1|vdd_b2|vdd_b3|vdd_b4|vdd_link|vdd_link_dip|vdd_x1|vdd_x2|vdd_x3__t112
+ a|d|inv_clk_vdd|inv_mc_vdd|inv_q_vdd|mpa_py|mpb_py|nand_m_vdd|nand_s2_vdd|nwell_vdd|sb_vdd|sr1_vdd|sr2_vdd|sr3_vdd|sr4_vdd|sv_d_vdd_tie|sv_vdd|tg_d_a|tg_d_vdd|tg_fbm_vdd|tg_fbs_vdd|tg_s_vdd|vdd|vdd_b1|vdd_b2|vdd_b3|vdd_b4|vdd_link|vdd_link_dip|vdd_x1|vdd_x2|vdd_x3__t40
+ sky130_fd_pr__pfet_01v8 L=0.15 W=0.84 AS=0.3948 AD=0.3948 PS=2.62 PD=2.62
* device instance $193 r0 *1 123.435,4.19 pfet
X$193 a|inv_mc_a|mb|mnab_y|mpa_y|mpb_y|nand_m_y|tg_s_a|y__t03
+ en|nand_m_en|nand_m_en_via|nand_s2_en|nand_s2_en_via|rst_n__t8
+ a|d|inv_clk_vdd|inv_mc_vdd|inv_q_vdd|mpa_py|mpb_py|nand_m_vdd|nand_s2_vdd|nwell_vdd|sb_vdd|sr1_vdd|sr2_vdd|sr3_vdd|sr4_vdd|sv_d_vdd_tie|sv_vdd|tg_d_a|tg_d_vdd|tg_fbm_vdd|tg_fbs_vdd|tg_s_vdd|vdd|vdd_b1|vdd_b2|vdd_b3|vdd_b4|vdd_link|vdd_link_dip|vdd_x1|vdd_x2|vdd_x3__t137
+ a|d|inv_clk_vdd|inv_mc_vdd|inv_q_vdd|mpa_py|mpb_py|nand_m_vdd|nand_s2_vdd|nwell_vdd|sb_vdd|sr1_vdd|sr2_vdd|sr3_vdd|sr4_vdd|sv_d_vdd_tie|sv_vdd|tg_d_a|tg_d_vdd|tg_fbm_vdd|tg_fbs_vdd|tg_s_vdd|vdd|vdd_b1|vdd_b2|vdd_b3|vdd_b4|vdd_link|vdd_link_dip|vdd_x1|vdd_x2|vdd_x3__t85
+ sky130_fd_pr__pfet_01v8 L=0.15 W=0.84 AS=0.3948 AD=0.3948 PS=2.62 PD=2.62
* device instance $194 r0 *1 124.725,4.19 pfet
X$194
+ a|d|inv_clk_vdd|inv_mc_vdd|inv_q_vdd|mpa_py|mpb_py|nand_m_vdd|nand_s2_vdd|nwell_vdd|sb_vdd|sr1_vdd|sr2_vdd|sr3_vdd|sr4_vdd|sv_d_vdd_tie|sv_vdd|tg_d_a|tg_d_vdd|tg_fbm_vdd|tg_fbs_vdd|tg_s_vdd|vdd|vdd_b1|vdd_b2|vdd_b3|vdd_b4|vdd_link|vdd_link_dip|vdd_x1|vdd_x2|vdd_x3__t26
+ a|b|m_east|m_west|nand_m_a|nand_m_a_ext_via|nand_m_a_ext_via2|nand_m_a_stub|tg_d_b|tg_d_b_via|tg_d_b_via2|tg_fbm_b|tg_fbm_b_alt_via|tg_fbm_b_alt_via2__t04
+ a|inv_mc_a|mb|mnab_y|mpa_y|mpb_y|nand_m_y|tg_s_a|y__t53
+ a|d|inv_clk_vdd|inv_mc_vdd|inv_q_vdd|mpa_py|mpb_py|nand_m_vdd|nand_s2_vdd|nwell_vdd|sb_vdd|sr1_vdd|sr2_vdd|sr3_vdd|sr4_vdd|sv_d_vdd_tie|sv_vdd|tg_d_a|tg_d_vdd|tg_fbm_vdd|tg_fbs_vdd|tg_s_vdd|vdd|vdd_b1|vdd_b2|vdd_b3|vdd_b4|vdd_link|vdd_link_dip|vdd_x1|vdd_x2|vdd_x3__t72
+ sky130_fd_pr__pfet_01v8 L=0.15 W=0.84 AS=0.3948 AD=0.3948 PS=2.62 PD=2.62
* device instance $195 r0 *1 125.675,27.375 pfet
X$195 a|n2|s1_y|s2_a|y__t03 a|g_y|mnab_y|mpa_y|mpb_y|n1|s1_a|y__t13 py__t19
+ g_vddr_m1|mnt_g|s1_vddr_m1|s2_vddr_m1|s3_vddr_m1|s4_vddr_m1|vddr|vddr3__t18
+ sky130_fd_pr__pfet_01v8 L=0.15 W=0.84 AS=0.3948 AD=0.3948 PS=2.62 PD=2.62
* device instance $196 r0 *1 133.85,27.375 pfet
X$196 a|n3|s2_y|s3_a|y__t02 a|n2|s1_y|s2_a|y__t23 py__t110
+ g_vddr_m1|mnt_g|s1_vddr_m1|s2_vddr_m1|s3_vddr_m1|s4_vddr_m1|vddr|vddr3__t17
+ sky130_fd_pr__pfet_01v8 L=0.15 W=0.84 AS=0.3948 AD=0.3948 PS=2.62 PD=2.62
* device instance $197 r0 *1 142.025,27.375 pfet
X$197 a|n4|s3_y|s4_a|y__t02 a|n3|s2_y|s3_a|y__t22 py__t111
+ g_vddr_m1|mnt_g|s1_vddr_m1|s2_vddr_m1|s3_vddr_m1|s4_vddr_m1|vddr|vddr3__t16
+ sky130_fd_pr__pfet_01v8 L=0.15 W=0.84 AS=0.3948 AD=0.3948 PS=2.62 PD=2.62
* device instance $198 r0 *1 150.2,27.375 pfet
X$198 a|g_a|rn3|ro|s4_y|y__t0 a|n4|s3_y|s4_a|y__t22 py__t112
+ g_vddr_m1|mnt_g|s1_vddr_m1|s2_vddr_m1|s3_vddr_m1|s4_vddr_m1|vddr|vddr3__t15
+ sky130_fd_pr__pfet_01v8 L=0.15 W=0.84 AS=0.3948 AD=0.3948 PS=2.62 PD=2.62
* device instance $199 r0 *1 154.295,4.19 pfet
X$199 a|mnab_y|mpa_y|mpb_y|nand_s2_y|qb|tg_fbs_a|y__t13
+ en|nand_m_en|nand_m_en_via|nand_s2_en|nand_s2_en_via|rst_n__t10
+ a|d|inv_clk_vdd|inv_mc_vdd|inv_q_vdd|mpa_py|mpb_py|nand_m_vdd|nand_s2_vdd|nwell_vdd|sb_vdd|sr1_vdd|sr2_vdd|sr3_vdd|sr4_vdd|sv_d_vdd_tie|sv_vdd|tg_d_a|tg_d_vdd|tg_fbm_vdd|tg_fbs_vdd|tg_s_vdd|vdd|vdd_b1|vdd_b2|vdd_b3|vdd_b4|vdd_link|vdd_link_dip|vdd_x1|vdd_x2|vdd_x3__t144
+ a|d|inv_clk_vdd|inv_mc_vdd|inv_q_vdd|mpa_py|mpb_py|nand_m_vdd|nand_s2_vdd|nwell_vdd|sb_vdd|sr1_vdd|sr2_vdd|sr3_vdd|sr4_vdd|sv_d_vdd_tie|sv_vdd|tg_d_a|tg_d_vdd|tg_fbm_vdd|tg_fbs_vdd|tg_s_vdd|vdd|vdd_b1|vdd_b2|vdd_b3|vdd_b4|vdd_link|vdd_link_dip|vdd_x1|vdd_x2|vdd_x3__t98
+ sky130_fd_pr__pfet_01v8 L=0.15 W=0.84 AS=0.3948 AD=0.3948 PS=2.62 PD=2.62
* device instance $200 r0 *1 155.585,4.19 pfet
X$200
+ a|d|inv_clk_vdd|inv_mc_vdd|inv_q_vdd|mpa_py|mpb_py|nand_m_vdd|nand_s2_vdd|nwell_vdd|sb_vdd|sr1_vdd|sr2_vdd|sr3_vdd|sr4_vdd|sv_d_vdd_tie|sv_vdd|tg_d_a|tg_d_vdd|tg_fbm_vdd|tg_fbs_vdd|tg_s_vdd|vdd|vdd_b1|vdd_b2|vdd_b3|vdd_b4|vdd_link|vdd_link_dip|vdd_x1|vdd_x2|vdd_x3__t30
+ a|inv_q_y|inv_q_y_via|inv_q_y_via2|nand_s2_a|nand_s2_a_stub|nand_s2_a_via|nand_s2_a_via2|q|y__t23
+ a|mnab_y|mpa_y|mpb_y|nand_s2_y|qb|tg_fbs_a|y__t33
+ a|d|inv_clk_vdd|inv_mc_vdd|inv_q_vdd|mpa_py|mpb_py|nand_m_vdd|nand_s2_vdd|nwell_vdd|sb_vdd|sr1_vdd|sr2_vdd|sr3_vdd|sr4_vdd|sv_d_vdd_tie|sv_vdd|tg_d_a|tg_d_vdd|tg_fbm_vdd|tg_fbs_vdd|tg_s_vdd|vdd|vdd_b1|vdd_b2|vdd_b3|vdd_b4|vdd_link|vdd_link_dip|vdd_x1|vdd_x2|vdd_x3__t97
+ sky130_fd_pr__pfet_01v8 L=0.15 W=0.84 AS=0.3948 AD=0.3948 PS=2.62 PD=2.62
* device instance $201 r0 *1 159.46,27.165 pfet
X$201
+ a|d|inva_a|mn12_g0|mp13_g0|ro3|ro3_esc_e|ro3_esc_w|ro3_hop|sr3_d_stub|tg_d_a|y__t1
+ a|g_a|rn3|ro|s4_y|y__t2
+ a|d|inv_clk_vdd|inv_mc_vdd|inv_q_vdd|mpa_py|mpb_py|nand_m_vdd|nand_s2_vdd|nwell_vdd|sb_vdd|sr1_vdd|sr2_vdd|sr3_vdd|sr4_vdd|sv_d_vdd_tie|sv_vdd|tg_d_a|tg_d_vdd|tg_fbm_vdd|tg_fbs_vdd|tg_s_vdd|vdd|vdd_b1|vdd_b2|vdd_b3|vdd_b4|vdd_link|vdd_link_dip|vdd_x1|vdd_x2|vdd_x3__t117
+ a|d|inv_clk_vdd|inv_mc_vdd|inv_q_vdd|mpa_py|mpb_py|nand_m_vdd|nand_s2_vdd|nwell_vdd|sb_vdd|sr1_vdd|sr2_vdd|sr3_vdd|sr4_vdd|sv_d_vdd_tie|sv_vdd|tg_d_a|tg_d_vdd|tg_fbm_vdd|tg_fbs_vdd|tg_s_vdd|vdd|vdd_b1|vdd_b2|vdd_b3|vdd_b4|vdd_link|vdd_link_dip|vdd_x1|vdd_x2|vdd_x3__t48
+ sky130_fd_pr__pfet_01v8 L=0.15 W=0.84 AS=0.3948 AD=0.3948 PS=2.62 PD=2.62
* device instance $202 r0 *1 179.095,4.19 pfet
X$202 a|inv_mc_a|mb|mnab_y|mpa_y|mpb_y|nand_m_y|tg_s_a|y__t04
+ en|nand_m_en|nand_m_en_via|nand_s2_en|nand_s2_en_via|rst_n__t1
+ a|d|inv_clk_vdd|inv_mc_vdd|inv_q_vdd|mpa_py|mpb_py|nand_m_vdd|nand_s2_vdd|nwell_vdd|sb_vdd|sr1_vdd|sr2_vdd|sr3_vdd|sr4_vdd|sv_d_vdd_tie|sv_vdd|tg_d_a|tg_d_vdd|tg_fbm_vdd|tg_fbs_vdd|tg_s_vdd|vdd|vdd_b1|vdd_b2|vdd_b3|vdd_b4|vdd_link|vdd_link_dip|vdd_x1|vdd_x2|vdd_x3__t116
+ a|d|inv_clk_vdd|inv_mc_vdd|inv_q_vdd|mpa_py|mpb_py|nand_m_vdd|nand_s2_vdd|nwell_vdd|sb_vdd|sr1_vdd|sr2_vdd|sr3_vdd|sr4_vdd|sv_d_vdd_tie|sv_vdd|tg_d_a|tg_d_vdd|tg_fbm_vdd|tg_fbs_vdd|tg_s_vdd|vdd|vdd_b1|vdd_b2|vdd_b3|vdd_b4|vdd_link|vdd_link_dip|vdd_x1|vdd_x2|vdd_x3__t47
+ sky130_fd_pr__pfet_01v8 L=0.15 W=0.84 AS=0.3948 AD=0.3948 PS=2.62 PD=2.62
* device instance $203 r0 *1 180.385,4.19 pfet
X$203
+ a|d|inv_clk_vdd|inv_mc_vdd|inv_q_vdd|mpa_py|mpb_py|nand_m_vdd|nand_s2_vdd|nwell_vdd|sb_vdd|sr1_vdd|sr2_vdd|sr3_vdd|sr4_vdd|sv_d_vdd_tie|sv_vdd|tg_d_a|tg_d_vdd|tg_fbm_vdd|tg_fbs_vdd|tg_s_vdd|vdd|vdd_b1|vdd_b2|vdd_b3|vdd_b4|vdd_link|vdd_link_dip|vdd_x1|vdd_x2|vdd_x3__t20
+ a|b|m_east|m_west|nand_m_a|nand_m_a_ext_via|nand_m_a_ext_via2|nand_m_a_stub|tg_d_b|tg_d_b_via|tg_d_b_via2|tg_fbm_b|tg_fbm_b_alt_via|tg_fbm_b_alt_via2__t05
+ a|inv_mc_a|mb|mnab_y|mpa_y|mpb_y|nand_m_y|tg_s_a|y__t54
+ a|d|inv_clk_vdd|inv_mc_vdd|inv_q_vdd|mpa_py|mpb_py|nand_m_vdd|nand_s2_vdd|nwell_vdd|sb_vdd|sr1_vdd|sr2_vdd|sr3_vdd|sr4_vdd|sv_d_vdd_tie|sv_vdd|tg_d_a|tg_d_vdd|tg_fbm_vdd|tg_fbs_vdd|tg_s_vdd|vdd|vdd_b1|vdd_b2|vdd_b3|vdd_b4|vdd_link|vdd_link_dip|vdd_x1|vdd_x2|vdd_x3__t49
+ sky130_fd_pr__pfet_01v8 L=0.15 W=0.84 AS=0.3948 AD=0.3948 PS=2.62 PD=2.62
* device instance $204 r0 *1 180.975,27.375 pfet
X$204 a|n2|s1_y|s2_a|y__t04 a|g_y|mnab_y|mpa_y|mpb_y|n1|s1_a|y__t14 py__t113
+ g_vddr_m1|mnt_g|s1_vddr_m1|s2_vddr_m1|s3_vddr_m1|s4_vddr_m1|vddr|vddr4__t15
+ sky130_fd_pr__pfet_01v8 L=0.15 W=0.84 AS=0.3948 AD=0.3948 PS=2.62 PD=2.62
* device instance $205 r0 *1 189.15,27.375 pfet
X$205 a|n3|s2_y|s3_a|y__t03 a|n2|s1_y|s2_a|y__t24 py__t114
+ g_vddr_m1|mnt_g|s1_vddr_m1|s2_vddr_m1|s3_vddr_m1|s4_vddr_m1|vddr|vddr4__t16
+ sky130_fd_pr__pfet_01v8 L=0.15 W=0.84 AS=0.3948 AD=0.3948 PS=2.62 PD=2.62
* device instance $206 r0 *1 197.325,27.375 pfet
X$206 a|n4|s3_y|s4_a|y__t04 a|n3|s2_y|s3_a|y__t23 py__t115
+ g_vddr_m1|mnt_g|s1_vddr_m1|s2_vddr_m1|s3_vddr_m1|s4_vddr_m1|vddr|vddr4__t20
+ sky130_fd_pr__pfet_01v8 L=0.15 W=0.84 AS=0.3948 AD=0.3948 PS=2.62 PD=2.62
* device instance $207 r0 *1 205.5,27.375 pfet
X$207 a|g_a|rn4|ro|s4_y|y__t0 a|n4|s3_y|s4_a|y__t24 py__t116
+ g_vddr_m1|mnt_g|s1_vddr_m1|s2_vddr_m1|s3_vddr_m1|s4_vddr_m1|vddr|vddr4__t19
+ sky130_fd_pr__pfet_01v8 L=0.15 W=0.84 AS=0.3948 AD=0.3948 PS=2.62 PD=2.62
* device instance $208 r0 *1 209.955,4.19 pfet
X$208 a|mnab_y|mpa_y|mpb_y|nand_s2_y|qb|tg_fbs_a|y__t04
+ en|nand_m_en|nand_m_en_via|nand_s2_en|nand_s2_en_via|rst_n__t5
+ a|d|inv_clk_vdd|inv_mc_vdd|inv_q_vdd|mpa_py|mpb_py|nand_m_vdd|nand_s2_vdd|nwell_vdd|sb_vdd|sr1_vdd|sr2_vdd|sr3_vdd|sr4_vdd|sv_d_vdd_tie|sv_vdd|tg_d_a|tg_d_vdd|tg_fbm_vdd|tg_fbs_vdd|tg_s_vdd|vdd|vdd_b1|vdd_b2|vdd_b3|vdd_b4|vdd_link|vdd_link_dip|vdd_x1|vdd_x2|vdd_x3__t123
+ a|d|inv_clk_vdd|inv_mc_vdd|inv_q_vdd|mpa_py|mpb_py|nand_m_vdd|nand_s2_vdd|nwell_vdd|sb_vdd|sr1_vdd|sr2_vdd|sr3_vdd|sr4_vdd|sv_d_vdd_tie|sv_vdd|tg_d_a|tg_d_vdd|tg_fbm_vdd|tg_fbs_vdd|tg_s_vdd|vdd|vdd_b1|vdd_b2|vdd_b3|vdd_b4|vdd_link|vdd_link_dip|vdd_x1|vdd_x2|vdd_x3__t58
+ sky130_fd_pr__pfet_01v8 L=0.15 W=0.84 AS=0.3948 AD=0.3948 PS=2.62 PD=2.62
* device instance $209 r0 *1 211.245,4.19 pfet
X$209
+ a|d|inv_clk_vdd|inv_mc_vdd|inv_q_vdd|mpa_py|mpb_py|nand_m_vdd|nand_s2_vdd|nwell_vdd|sb_vdd|sr1_vdd|sr2_vdd|sr3_vdd|sr4_vdd|sv_d_vdd_tie|sv_vdd|tg_d_a|tg_d_vdd|tg_fbm_vdd|tg_fbs_vdd|tg_s_vdd|vdd|vdd_b1|vdd_b2|vdd_b3|vdd_b4|vdd_link|vdd_link_dip|vdd_x1|vdd_x2|vdd_x3__t25
+ a|inv_q_y|inv_q_y_via|inv_q_y_via2|nand_s2_a|nand_s2_a_stub|nand_s2_a_via|nand_s2_a_via2|q|y__t24
+ a|mnab_y|mpa_y|mpb_y|nand_s2_y|qb|tg_fbs_a|y__t34
+ a|d|inv_clk_vdd|inv_mc_vdd|inv_q_vdd|mpa_py|mpb_py|nand_m_vdd|nand_s2_vdd|nwell_vdd|sb_vdd|sr1_vdd|sr2_vdd|sr3_vdd|sr4_vdd|sv_d_vdd_tie|sv_vdd|tg_d_a|tg_d_vdd|tg_fbm_vdd|tg_fbs_vdd|tg_s_vdd|vdd|vdd_b1|vdd_b2|vdd_b3|vdd_b4|vdd_link|vdd_link_dip|vdd_x1|vdd_x2|vdd_x3__t63
+ sky130_fd_pr__pfet_01v8 L=0.15 W=0.84 AS=0.3948 AD=0.3948 PS=2.62 PD=2.62
* device instance $210 r0 *1 214.76,27.165 pfet
X$210 a|b|d|invb_a|mn12_g1|mp24_g0|ro4|ro4_esc|sr4_d_stub|tg_d_a|y__t2
+ a|g_a|rn4|ro|s4_y|y__t3
+ a|d|inv_clk_vdd|inv_mc_vdd|inv_q_vdd|mpa_py|mpb_py|nand_m_vdd|nand_s2_vdd|nwell_vdd|sb_vdd|sr1_vdd|sr2_vdd|sr3_vdd|sr4_vdd|sv_d_vdd_tie|sv_vdd|tg_d_a|tg_d_vdd|tg_fbm_vdd|tg_fbs_vdd|tg_s_vdd|vdd|vdd_b1|vdd_b2|vdd_b3|vdd_b4|vdd_link|vdd_link_dip|vdd_x1|vdd_x2|vdd_x3__t126
+ a|d|inv_clk_vdd|inv_mc_vdd|inv_q_vdd|mpa_py|mpb_py|nand_m_vdd|nand_s2_vdd|nwell_vdd|sb_vdd|sr1_vdd|sr2_vdd|sr3_vdd|sr4_vdd|sv_d_vdd_tie|sv_vdd|tg_d_a|tg_d_vdd|tg_fbm_vdd|tg_fbs_vdd|tg_s_vdd|vdd|vdd_b1|vdd_b2|vdd_b3|vdd_b4|vdd_link|vdd_link_dip|vdd_x1|vdd_x2|vdd_x3__t62
+ sky130_fd_pr__pfet_01v8 L=0.15 W=0.84 AS=0.3948 AD=0.3948 PS=2.62 PD=2.62
* device instance $211 r0 *1 234.755,4.19 pfet
X$211 a|inv_mc_a|mb|mnab_y|mpa_y|mpb_y|nand_m_y|tg_s_a|y__t15
+ en|nand_m_en|nand_m_en_via|nand_s2_en|nand_s2_en_via|rst_n__t6
+ a|d|inv_clk_vdd|inv_mc_vdd|inv_q_vdd|mpa_py|mpb_py|nand_m_vdd|nand_s2_vdd|nwell_vdd|sb_vdd|sr1_vdd|sr2_vdd|sr3_vdd|sr4_vdd|sv_d_vdd_tie|sv_vdd|tg_d_a|tg_d_vdd|tg_fbm_vdd|tg_fbs_vdd|tg_s_vdd|vdd|vdd_b1|vdd_b2|vdd_b3|vdd_b4|vdd_link|vdd_link_dip|vdd_x1|vdd_x2|vdd_x3__t125
+ a|d|inv_clk_vdd|inv_mc_vdd|inv_q_vdd|mpa_py|mpb_py|nand_m_vdd|nand_s2_vdd|nwell_vdd|sb_vdd|sr1_vdd|sr2_vdd|sr3_vdd|sr4_vdd|sv_d_vdd_tie|sv_vdd|tg_d_a|tg_d_vdd|tg_fbm_vdd|tg_fbs_vdd|tg_s_vdd|vdd|vdd_b1|vdd_b2|vdd_b3|vdd_b4|vdd_link|vdd_link_dip|vdd_x1|vdd_x2|vdd_x3__t61
+ sky130_fd_pr__pfet_01v8 L=0.15 W=0.84 AS=0.3948 AD=0.3948 PS=2.62 PD=2.62
* device instance $212 r0 *1 236.045,4.19 pfet
X$212
+ a|d|inv_clk_vdd|inv_mc_vdd|inv_q_vdd|mpa_py|mpb_py|nand_m_vdd|nand_s2_vdd|nwell_vdd|sb_vdd|sr1_vdd|sr2_vdd|sr3_vdd|sr4_vdd|sv_d_vdd_tie|sv_vdd|tg_d_a|tg_d_vdd|tg_fbm_vdd|tg_fbs_vdd|tg_s_vdd|vdd|vdd_b1|vdd_b2|vdd_b3|vdd_b4|vdd_link|vdd_link_dip|vdd_x1|vdd_x2|vdd_x3__t24
+ a|b|m_east|m_west|nand_m_a|nand_m_a_ext_via|nand_m_a_ext_via2|nand_m_a_stub|tg_d_b|tg_d_b_via|tg_d_b_via2|tg_fbm_b|tg_fbm_b_alt_via|tg_fbm_b_alt_via2__t06
+ a|inv_mc_a|mb|mnab_y|mpa_y|mpb_y|nand_m_y|tg_s_a|y__t55
+ a|d|inv_clk_vdd|inv_mc_vdd|inv_q_vdd|mpa_py|mpb_py|nand_m_vdd|nand_s2_vdd|nwell_vdd|sb_vdd|sr1_vdd|sr2_vdd|sr3_vdd|sr4_vdd|sv_d_vdd_tie|sv_vdd|tg_d_a|tg_d_vdd|tg_fbm_vdd|tg_fbs_vdd|tg_s_vdd|vdd|vdd_b1|vdd_b2|vdd_b3|vdd_b4|vdd_link|vdd_link_dip|vdd_x1|vdd_x2|vdd_x3__t60
+ sky130_fd_pr__pfet_01v8 L=0.15 W=0.84 AS=0.3948 AD=0.3948 PS=2.62 PD=2.62
* device instance $213 r0 *1 265.615,4.19 pfet
X$213 a|mnab_y|mpa_y|mpb_y|nand_s2_y|qb|tg_fbs_a|y__t15
+ en|nand_m_en|nand_m_en_via|nand_s2_en|nand_s2_en_via|rst_n__t4
+ a|d|inv_clk_vdd|inv_mc_vdd|inv_q_vdd|mpa_py|mpb_py|nand_m_vdd|nand_s2_vdd|nwell_vdd|sb_vdd|sr1_vdd|sr2_vdd|sr3_vdd|sr4_vdd|sv_d_vdd_tie|sv_vdd|tg_d_a|tg_d_vdd|tg_fbm_vdd|tg_fbs_vdd|tg_s_vdd|vdd|vdd_b1|vdd_b2|vdd_b3|vdd_b4|vdd_link|vdd_link_dip|vdd_x1|vdd_x2|vdd_x3__t122
+ a|d|inv_clk_vdd|inv_mc_vdd|inv_q_vdd|mpa_py|mpb_py|nand_m_vdd|nand_s2_vdd|nwell_vdd|sb_vdd|sr1_vdd|sr2_vdd|sr3_vdd|sr4_vdd|sv_d_vdd_tie|sv_vdd|tg_d_a|tg_d_vdd|tg_fbm_vdd|tg_fbs_vdd|tg_s_vdd|vdd|vdd_b1|vdd_b2|vdd_b3|vdd_b4|vdd_link|vdd_link_dip|vdd_x1|vdd_x2|vdd_x3__t57
+ sky130_fd_pr__pfet_01v8 L=0.15 W=0.84 AS=0.3948 AD=0.3948 PS=2.62 PD=2.62
* device instance $214 r0 *1 266.905,4.19 pfet
X$214
+ a|d|inv_clk_vdd|inv_mc_vdd|inv_q_vdd|mpa_py|mpb_py|nand_m_vdd|nand_s2_vdd|nwell_vdd|sb_vdd|sr1_vdd|sr2_vdd|sr3_vdd|sr4_vdd|sv_d_vdd_tie|sv_vdd|tg_d_a|tg_d_vdd|tg_fbm_vdd|tg_fbs_vdd|tg_s_vdd|vdd|vdd_b1|vdd_b2|vdd_b3|vdd_b4|vdd_link|vdd_link_dip|vdd_x1|vdd_x2|vdd_x3__t23
+ a|inv_q_y|inv_q_y_via|inv_q_y_via2|nand_s2_a|nand_s2_a_stub|nand_s2_a_via|nand_s2_a_via2|q|y__t25
+ a|mnab_y|mpa_y|mpb_y|nand_s2_y|qb|tg_fbs_a|y__t35
+ a|d|inv_clk_vdd|inv_mc_vdd|inv_q_vdd|mpa_py|mpb_py|nand_m_vdd|nand_s2_vdd|nwell_vdd|sb_vdd|sr1_vdd|sr2_vdd|sr3_vdd|sr4_vdd|sv_d_vdd_tie|sv_vdd|tg_d_a|tg_d_vdd|tg_fbm_vdd|tg_fbs_vdd|tg_s_vdd|vdd|vdd_b1|vdd_b2|vdd_b3|vdd_b4|vdd_link|vdd_link_dip|vdd_x1|vdd_x2|vdd_x3__t56
+ sky130_fd_pr__pfet_01v8 L=0.15 W=0.84 AS=0.3948 AD=0.3948 PS=2.62 PD=2.62
* device instance $215 r0 *1 290.415,4.19 pfet
X$215 a|inv_mc_a|mb|mnab_y|mpa_y|mpb_y|nand_m_y|tg_s_a|y__t16
+ en|nand_m_en|nand_m_en_via|nand_s2_en|nand_s2_en_via|rst_n__t3
+ a|d|inv_clk_vdd|inv_mc_vdd|inv_q_vdd|mpa_py|mpb_py|nand_m_vdd|nand_s2_vdd|nwell_vdd|sb_vdd|sr1_vdd|sr2_vdd|sr3_vdd|sr4_vdd|sv_d_vdd_tie|sv_vdd|tg_d_a|tg_d_vdd|tg_fbm_vdd|tg_fbs_vdd|tg_s_vdd|vdd|vdd_b1|vdd_b2|vdd_b3|vdd_b4|vdd_link|vdd_link_dip|vdd_x1|vdd_x2|vdd_x3__t121
+ a|d|inv_clk_vdd|inv_mc_vdd|inv_q_vdd|mpa_py|mpb_py|nand_m_vdd|nand_s2_vdd|nwell_vdd|sb_vdd|sr1_vdd|sr2_vdd|sr3_vdd|sr4_vdd|sv_d_vdd_tie|sv_vdd|tg_d_a|tg_d_vdd|tg_fbm_vdd|tg_fbs_vdd|tg_s_vdd|vdd|vdd_b1|vdd_b2|vdd_b3|vdd_b4|vdd_link|vdd_link_dip|vdd_x1|vdd_x2|vdd_x3__t55
+ sky130_fd_pr__pfet_01v8 L=0.15 W=0.84 AS=0.3948 AD=0.3948 PS=2.62 PD=2.62
* device instance $216 r0 *1 291.705,4.19 pfet
X$216
+ a|d|inv_clk_vdd|inv_mc_vdd|inv_q_vdd|mpa_py|mpb_py|nand_m_vdd|nand_s2_vdd|nwell_vdd|sb_vdd|sr1_vdd|sr2_vdd|sr3_vdd|sr4_vdd|sv_d_vdd_tie|sv_vdd|tg_d_a|tg_d_vdd|tg_fbm_vdd|tg_fbs_vdd|tg_s_vdd|vdd|vdd_b1|vdd_b2|vdd_b3|vdd_b4|vdd_link|vdd_link_dip|vdd_x1|vdd_x2|vdd_x3__t22
+ a|b|m_east|m_west|nand_m_a|nand_m_a_ext_via|nand_m_a_ext_via2|nand_m_a_stub|tg_d_b|tg_d_b_via|tg_d_b_via2|tg_fbm_b|tg_fbm_b_alt_via|tg_fbm_b_alt_via2__t0
+ a|inv_mc_a|mb|mnab_y|mpa_y|mpb_y|nand_m_y|tg_s_a|y__t56
+ a|d|inv_clk_vdd|inv_mc_vdd|inv_q_vdd|mpa_py|mpb_py|nand_m_vdd|nand_s2_vdd|nwell_vdd|sb_vdd|sr1_vdd|sr2_vdd|sr3_vdd|sr4_vdd|sv_d_vdd_tie|sv_vdd|tg_d_a|tg_d_vdd|tg_fbm_vdd|tg_fbs_vdd|tg_s_vdd|vdd|vdd_b1|vdd_b2|vdd_b3|vdd_b4|vdd_link|vdd_link_dip|vdd_x1|vdd_x2|vdd_x3__t54
+ sky130_fd_pr__pfet_01v8 L=0.15 W=0.84 AS=0.3948 AD=0.3948 PS=2.62 PD=2.62
* device instance $217 r0 *1 321.275,4.19 pfet
X$217 a|mnab_y|mpa_y|mpb_y|nand_s2_y|qb|tg_fbs_a|y__t16
+ en|nand_m_en|nand_m_en_via|nand_s2_en|nand_s2_en_via|rst_n__t2
+ a|d|inv_clk_vdd|inv_mc_vdd|inv_q_vdd|mpa_py|mpb_py|nand_m_vdd|nand_s2_vdd|nwell_vdd|sb_vdd|sr1_vdd|sr2_vdd|sr3_vdd|sr4_vdd|sv_d_vdd_tie|sv_vdd|tg_d_a|tg_d_vdd|tg_fbm_vdd|tg_fbs_vdd|tg_s_vdd|vdd|vdd_b1|vdd_b2|vdd_b3|vdd_b4|vdd_link|vdd_link_dip|vdd_x1|vdd_x2|vdd_x3__t120
+ a|d|inv_clk_vdd|inv_mc_vdd|inv_q_vdd|mpa_py|mpb_py|nand_m_vdd|nand_s2_vdd|nwell_vdd|sb_vdd|sr1_vdd|sr2_vdd|sr3_vdd|sr4_vdd|sv_d_vdd_tie|sv_vdd|tg_d_a|tg_d_vdd|tg_fbm_vdd|tg_fbs_vdd|tg_s_vdd|vdd|vdd_b1|vdd_b2|vdd_b3|vdd_b4|vdd_link|vdd_link_dip|vdd_x1|vdd_x2|vdd_x3__t53
+ sky130_fd_pr__pfet_01v8 L=0.15 W=0.84 AS=0.3948 AD=0.3948 PS=2.62 PD=2.62
* device instance $218 r0 *1 322.565,4.19 pfet
X$218
+ a|d|inv_clk_vdd|inv_mc_vdd|inv_q_vdd|mpa_py|mpb_py|nand_m_vdd|nand_s2_vdd|nwell_vdd|sb_vdd|sr1_vdd|sr2_vdd|sr3_vdd|sr4_vdd|sv_d_vdd_tie|sv_vdd|tg_d_a|tg_d_vdd|tg_fbm_vdd|tg_fbs_vdd|tg_s_vdd|vdd|vdd_b1|vdd_b2|vdd_b3|vdd_b4|vdd_link|vdd_link_dip|vdd_x1|vdd_x2|vdd_x3__t21
+ a|inv_q_y|inv_q_y_via|inv_q_y_via2|nand_s2_a|nand_s2_a_stub|nand_s2_a_via|nand_s2_a_via2|q|y__t26
+ a|mnab_y|mpa_y|mpb_y|nand_s2_y|qb|tg_fbs_a|y__t36
+ a|d|inv_clk_vdd|inv_mc_vdd|inv_q_vdd|mpa_py|mpb_py|nand_m_vdd|nand_s2_vdd|nwell_vdd|sb_vdd|sr1_vdd|sr2_vdd|sr3_vdd|sr4_vdd|sv_d_vdd_tie|sv_vdd|tg_d_a|tg_d_vdd|tg_fbm_vdd|tg_fbs_vdd|tg_s_vdd|vdd|vdd_b1|vdd_b2|vdd_b3|vdd_b4|vdd_link|vdd_link_dip|vdd_x1|vdd_x2|vdd_x3__t52
+ sky130_fd_pr__pfet_01v8 L=0.15 W=0.84 AS=0.3948 AD=0.3948 PS=2.62 PD=2.62
* device instance $219 r0 *1 5.775,27.825 pfet
X$219 a|g_y|mnab_y|mpa_y|mpb_y|n1|s1_a|y__t02 en|en1|g_en__t0
+ mpa_py|mpb_py|mph_py|py__t2
+ g_vddr_m1|mnt_g|s1_vddr_m1|s2_vddr_m1|s3_vddr_m1|s4_vddr_m1|vddr|vddr1__t17
+ sky130_fd_pr__pfet_01v8 L=0.15 W=0.84 AS=0.3948 AD=0.3948 PS=2.62 PD=2.62
* device instance $220 r0 *1 7.065,27.825 pfet
X$220 mpa_py|mpb_py|mph_py|py__t1 a|g_a|rn1|ro|s4_y|y__t3
+ a|g_y|mnab_y|mpa_y|mpb_y|n1|s1_a|y__t32
+ g_vddr_m1|mnt_g|s1_vddr_m1|s2_vddr_m1|s3_vddr_m1|s4_vddr_m1|vddr|vddr1__t20
+ sky130_fd_pr__pfet_01v8 L=0.15 W=0.84 AS=0.3948 AD=0.3948 PS=2.62 PD=2.62
* device instance $221 r0 *1 12.91,27.375 pfet
X$221 py__t0
+ g_vss_m1|inv_clk_vss|inv_mc_vss|inv_q_vss|mph_g|nand_m_vss|nand_s2_vss|s1_vss_m1|s2_vss_m1|s3_vss_m1|s4_vss_m1|sb_vss|sr1_vss|sr2_vss|sr3_vss|sr4_vss|sv_vss|tg_d_vss|tg_fbm_vss|tg_fbs_vss|tg_s_vss|vss|vss_link|vss_link_bridge|vss_link_dip|vss_link_m1|vss_x1|vss_x2|vss_x3__t22
+ g_vddr_m1|mnt_g|s1_vddr_m1|s2_vddr_m1|s3_vddr_m1|s4_vddr_m1|vddr|vddr1__t7
+ g_vddr_m1|mnt_g|s1_vddr_m1|s2_vddr_m1|s3_vddr_m1|s4_vddr_m1|vddr|vddr1__t3
+ sky130_fd_pr__pfet_01v8 L=2 W=0.42 AS=0.1764 AD=0.1764 PS=1.68 PD=1.68
* device instance $222 r0 *1 21.085,27.375 pfet
X$222 py__t02
+ g_vss_m1|inv_clk_vss|inv_mc_vss|inv_q_vss|mph_g|nand_m_vss|nand_s2_vss|s1_vss_m1|s2_vss_m1|s3_vss_m1|s4_vss_m1|sb_vss|sr1_vss|sr2_vss|sr3_vss|sr4_vss|sv_vss|tg_d_vss|tg_fbm_vss|tg_fbs_vss|tg_s_vss|vss|vss_link|vss_link_bridge|vss_link_dip|vss_link_m1|vss_x1|vss_x2|vss_x3__t24
+ g_vddr_m1|mnt_g|s1_vddr_m1|s2_vddr_m1|s3_vddr_m1|s4_vddr_m1|vddr|vddr1__t9
+ g_vddr_m1|mnt_g|s1_vddr_m1|s2_vddr_m1|s3_vddr_m1|s4_vddr_m1|vddr|vddr1__t5
+ sky130_fd_pr__pfet_01v8 L=2 W=0.42 AS=0.1764 AD=0.1764 PS=1.68 PD=1.68
* device instance $223 r0 *1 29.26,27.375 pfet
X$223 py__t03
+ g_vss_m1|inv_clk_vss|inv_mc_vss|inv_q_vss|mph_g|nand_m_vss|nand_s2_vss|s1_vss_m1|s2_vss_m1|s3_vss_m1|s4_vss_m1|sb_vss|sr1_vss|sr2_vss|sr3_vss|sr4_vss|sv_vss|tg_d_vss|tg_fbm_vss|tg_fbs_vss|tg_s_vss|vss|vss_link|vss_link_bridge|vss_link_dip|vss_link_m1|vss_x1|vss_x2|vss_x3__t25
+ g_vddr_m1|mnt_g|s1_vddr_m1|s2_vddr_m1|s3_vddr_m1|s4_vddr_m1|vddr|vddr1__t10
+ g_vddr_m1|mnt_g|s1_vddr_m1|s2_vddr_m1|s3_vddr_m1|s4_vddr_m1|vddr|vddr1__t6
+ sky130_fd_pr__pfet_01v8 L=2 W=0.42 AS=0.1764 AD=0.1764 PS=1.68 PD=1.68
* device instance $224 r0 *1 37.435,27.375 pfet
X$224 py__t04
+ g_vss_m1|inv_clk_vss|inv_mc_vss|inv_q_vss|mph_g|nand_m_vss|nand_s2_vss|s1_vss_m1|s2_vss_m1|s3_vss_m1|s4_vss_m1|sb_vss|sr1_vss|sr2_vss|sr3_vss|sr4_vss|sv_vss|tg_d_vss|tg_fbm_vss|tg_fbs_vss|tg_s_vss|vss|vss_link|vss_link_bridge|vss_link_dip|vss_link_m1|vss_x1|vss_x2|vss_x3__t23
+ g_vddr_m1|mnt_g|s1_vddr_m1|s2_vddr_m1|s3_vddr_m1|s4_vddr_m1|vddr|vddr1__t8
+ g_vddr_m1|mnt_g|s1_vddr_m1|s2_vddr_m1|s3_vddr_m1|s4_vddr_m1|vddr|vddr1__t4
+ sky130_fd_pr__pfet_01v8 L=2 W=0.42 AS=0.1764 AD=0.1764 PS=1.68 PD=1.68
* device instance $225 r0 *1 61.075,27.825 pfet
X$225 a|g_y|mnab_y|mpa_y|mpb_y|n1|s1_a|y__t0 en|en2|g_en__t0
+ mpa_py|mpb_py|mph_py|py__t22
+ g_vddr_m1|mnt_g|s1_vddr_m1|s2_vddr_m1|s3_vddr_m1|s4_vddr_m1|vddr|vddr2__t17
+ sky130_fd_pr__pfet_01v8 L=0.15 W=0.84 AS=0.3948 AD=0.3948 PS=2.62 PD=2.62
* device instance $226 r0 *1 62.365,27.825 pfet
X$226 mpa_py|mpb_py|mph_py|py__t12 a|g_a|rn2|ro|s4_y|y__t3
+ a|g_y|mnab_y|mpa_y|mpb_y|n1|s1_a|y__t3
+ g_vddr_m1|mnt_g|s1_vddr_m1|s2_vddr_m1|s3_vddr_m1|s4_vddr_m1|vddr|vddr2__t18
+ sky130_fd_pr__pfet_01v8 L=0.15 W=0.84 AS=0.3948 AD=0.3948 PS=2.62 PD=2.62
* device instance $227 r0 *1 68.21,27.375 pfet
X$227 py__t05
+ g_vss_m1|inv_clk_vss|inv_mc_vss|inv_q_vss|mph_g|nand_m_vss|nand_s2_vss|s1_vss_m1|s2_vss_m1|s3_vss_m1|s4_vss_m1|sb_vss|sr1_vss|sr2_vss|sr3_vss|sr4_vss|sv_vss|tg_d_vss|tg_fbm_vss|tg_fbs_vss|tg_s_vss|vss|vss_link|vss_link_bridge|vss_link_dip|vss_link_m1|vss_x1|vss_x2|vss_x3__t18
+ g_vddr_m1|mnt_g|s1_vddr_m1|s2_vddr_m1|s3_vddr_m1|s4_vddr_m1|vddr|vddr2__t7
+ g_vddr_m1|mnt_g|s1_vddr_m1|s2_vddr_m1|s3_vddr_m1|s4_vddr_m1|vddr|vddr2__t3
+ sky130_fd_pr__pfet_01v8 L=2 W=0.44 AS=0.1848 AD=0.1848 PS=1.72 PD=1.72
* device instance $228 r0 *1 76.385,27.375 pfet
X$228 py__t06
+ g_vss_m1|inv_clk_vss|inv_mc_vss|inv_q_vss|mph_g|nand_m_vss|nand_s2_vss|s1_vss_m1|s2_vss_m1|s3_vss_m1|s4_vss_m1|sb_vss|sr1_vss|sr2_vss|sr3_vss|sr4_vss|sv_vss|tg_d_vss|tg_fbm_vss|tg_fbs_vss|tg_s_vss|vss|vss_link|vss_link_bridge|vss_link_dip|vss_link_m1|vss_x1|vss_x2|vss_x3__t19
+ g_vddr_m1|mnt_g|s1_vddr_m1|s2_vddr_m1|s3_vddr_m1|s4_vddr_m1|vddr|vddr2__t8
+ g_vddr_m1|mnt_g|s1_vddr_m1|s2_vddr_m1|s3_vddr_m1|s4_vddr_m1|vddr|vddr2__t4
+ sky130_fd_pr__pfet_01v8 L=2 W=0.44 AS=0.1848 AD=0.1848 PS=1.72 PD=1.72
* device instance $229 r0 *1 84.56,27.375 pfet
X$229 py__t07
+ g_vss_m1|inv_clk_vss|inv_mc_vss|inv_q_vss|mph_g|nand_m_vss|nand_s2_vss|s1_vss_m1|s2_vss_m1|s3_vss_m1|s4_vss_m1|sb_vss|sr1_vss|sr2_vss|sr3_vss|sr4_vss|sv_vss|tg_d_vss|tg_fbm_vss|tg_fbs_vss|tg_s_vss|vss|vss_link|vss_link_bridge|vss_link_dip|vss_link_m1|vss_x1|vss_x2|vss_x3__t21
+ g_vddr_m1|mnt_g|s1_vddr_m1|s2_vddr_m1|s3_vddr_m1|s4_vddr_m1|vddr|vddr2__t10
+ g_vddr_m1|mnt_g|s1_vddr_m1|s2_vddr_m1|s3_vddr_m1|s4_vddr_m1|vddr|vddr2__t6
+ sky130_fd_pr__pfet_01v8 L=2 W=0.44 AS=0.1848 AD=0.1848 PS=1.72 PD=1.72
* device instance $230 r0 *1 92.735,27.375 pfet
X$230 py__t08
+ g_vss_m1|inv_clk_vss|inv_mc_vss|inv_q_vss|mph_g|nand_m_vss|nand_s2_vss|s1_vss_m1|s2_vss_m1|s3_vss_m1|s4_vss_m1|sb_vss|sr1_vss|sr2_vss|sr3_vss|sr4_vss|sv_vss|tg_d_vss|tg_fbm_vss|tg_fbs_vss|tg_s_vss|vss|vss_link|vss_link_bridge|vss_link_dip|vss_link_m1|vss_x1|vss_x2|vss_x3__t20
+ g_vddr_m1|mnt_g|s1_vddr_m1|s2_vddr_m1|s3_vddr_m1|s4_vddr_m1|vddr|vddr2__t9
+ g_vddr_m1|mnt_g|s1_vddr_m1|s2_vddr_m1|s3_vddr_m1|s4_vddr_m1|vddr|vddr2__t5
+ sky130_fd_pr__pfet_01v8 L=2 W=0.44 AS=0.1848 AD=0.1848 PS=1.72 PD=1.72
* device instance $231 r0 *1 116.375,27.825 pfet
X$231 a|g_y|mnab_y|mpa_y|mpb_y|n1|s1_a|y__t03 en|en3|g_en__t0
+ mpa_py|mpb_py|mph_py|py__t23
+ g_vddr_m1|mnt_g|s1_vddr_m1|s2_vddr_m1|s3_vddr_m1|s4_vddr_m1|vddr|vddr3__t20
+ sky130_fd_pr__pfet_01v8 L=0.15 W=0.84 AS=0.3948 AD=0.3948 PS=2.62 PD=2.62
* device instance $232 r0 *1 117.665,27.825 pfet
X$232 mpa_py|mpb_py|mph_py|py__t13 a|g_a|rn3|ro|s4_y|y__t3
+ a|g_y|mnab_y|mpa_y|mpb_y|n1|s1_a|y__t33
+ g_vddr_m1|mnt_g|s1_vddr_m1|s2_vddr_m1|s3_vddr_m1|s4_vddr_m1|vddr|vddr3__t19
+ sky130_fd_pr__pfet_01v8 L=0.15 W=0.84 AS=0.3948 AD=0.3948 PS=2.62 PD=2.62
* device instance $233 r0 *1 123.51,27.375 pfet
X$233 py__t09
+ g_vss_m1|inv_clk_vss|inv_mc_vss|inv_q_vss|mph_g|nand_m_vss|nand_s2_vss|s1_vss_m1|s2_vss_m1|s3_vss_m1|s4_vss_m1|sb_vss|sr1_vss|sr2_vss|sr3_vss|sr4_vss|sv_vss|tg_d_vss|tg_fbm_vss|tg_fbs_vss|tg_s_vss|vss|vss_link|vss_link_bridge|vss_link_dip|vss_link_m1|vss_x1|vss_x2|vss_x3__t14
+ g_vddr_m1|mnt_g|s1_vddr_m1|s2_vddr_m1|s3_vddr_m1|s4_vddr_m1|vddr|vddr3__t7
+ g_vddr_m1|mnt_g|s1_vddr_m1|s2_vddr_m1|s3_vddr_m1|s4_vddr_m1|vddr|vddr3__t3
+ sky130_fd_pr__pfet_01v8 L=2 W=0.46 AS=0.1932 AD=0.1932 PS=1.76 PD=1.76
* device instance $234 r0 *1 131.685,27.375 pfet
X$234 py__t010
+ g_vss_m1|inv_clk_vss|inv_mc_vss|inv_q_vss|mph_g|nand_m_vss|nand_s2_vss|s1_vss_m1|s2_vss_m1|s3_vss_m1|s4_vss_m1|sb_vss|sr1_vss|sr2_vss|sr3_vss|sr4_vss|sv_vss|tg_d_vss|tg_fbm_vss|tg_fbs_vss|tg_s_vss|vss|vss_link|vss_link_bridge|vss_link_dip|vss_link_m1|vss_x1|vss_x2|vss_x3__t15
+ g_vddr_m1|mnt_g|s1_vddr_m1|s2_vddr_m1|s3_vddr_m1|s4_vddr_m1|vddr|vddr3__t8
+ g_vddr_m1|mnt_g|s1_vddr_m1|s2_vddr_m1|s3_vddr_m1|s4_vddr_m1|vddr|vddr3__t4
+ sky130_fd_pr__pfet_01v8 L=2 W=0.46 AS=0.1932 AD=0.1932 PS=1.76 PD=1.76
* device instance $235 r0 *1 139.86,27.375 pfet
X$235 py__t011
+ g_vss_m1|inv_clk_vss|inv_mc_vss|inv_q_vss|mph_g|nand_m_vss|nand_s2_vss|s1_vss_m1|s2_vss_m1|s3_vss_m1|s4_vss_m1|sb_vss|sr1_vss|sr2_vss|sr3_vss|sr4_vss|sv_vss|tg_d_vss|tg_fbm_vss|tg_fbs_vss|tg_s_vss|vss|vss_link|vss_link_bridge|vss_link_dip|vss_link_m1|vss_x1|vss_x2|vss_x3__t16
+ g_vddr_m1|mnt_g|s1_vddr_m1|s2_vddr_m1|s3_vddr_m1|s4_vddr_m1|vddr|vddr3__t9
+ g_vddr_m1|mnt_g|s1_vddr_m1|s2_vddr_m1|s3_vddr_m1|s4_vddr_m1|vddr|vddr3__t5
+ sky130_fd_pr__pfet_01v8 L=2 W=0.46 AS=0.1932 AD=0.1932 PS=1.76 PD=1.76
* device instance $236 r0 *1 148.035,27.375 pfet
X$236 py__t012
+ g_vss_m1|inv_clk_vss|inv_mc_vss|inv_q_vss|mph_g|nand_m_vss|nand_s2_vss|s1_vss_m1|s2_vss_m1|s3_vss_m1|s4_vss_m1|sb_vss|sr1_vss|sr2_vss|sr3_vss|sr4_vss|sv_vss|tg_d_vss|tg_fbm_vss|tg_fbs_vss|tg_s_vss|vss|vss_link|vss_link_bridge|vss_link_dip|vss_link_m1|vss_x1|vss_x2|vss_x3__t17
+ g_vddr_m1|mnt_g|s1_vddr_m1|s2_vddr_m1|s3_vddr_m1|s4_vddr_m1|vddr|vddr3__t10
+ g_vddr_m1|mnt_g|s1_vddr_m1|s2_vddr_m1|s3_vddr_m1|s4_vddr_m1|vddr|vddr3__t6
+ sky130_fd_pr__pfet_01v8 L=2 W=0.46 AS=0.1932 AD=0.1932 PS=1.76 PD=1.76
* device instance $237 r0 *1 171.675,27.825 pfet
X$237 a|g_y|mnab_y|mpa_y|mpb_y|n1|s1_a|y__t04 en|en4|g_en__t0
+ mpa_py|mpb_py|mph_py|py__t24
+ g_vddr_m1|mnt_g|s1_vddr_m1|s2_vddr_m1|s3_vddr_m1|s4_vddr_m1|vddr|vddr4__t18
+ sky130_fd_pr__pfet_01v8 L=0.15 W=0.84 AS=0.3948 AD=0.3948 PS=2.62 PD=2.62
* device instance $238 r0 *1 172.965,27.825 pfet
X$238 mpa_py|mpb_py|mph_py|py__t14 a|g_a|rn4|ro|s4_y|y__t2
+ a|g_y|mnab_y|mpa_y|mpb_y|n1|s1_a|y__t34
+ g_vddr_m1|mnt_g|s1_vddr_m1|s2_vddr_m1|s3_vddr_m1|s4_vddr_m1|vddr|vddr4__t17
+ sky130_fd_pr__pfet_01v8 L=0.15 W=0.84 AS=0.3948 AD=0.3948 PS=2.62 PD=2.62
* device instance $239 r0 *1 178.81,27.375 pfet
X$239 py__t013
+ g_vss_m1|inv_clk_vss|inv_mc_vss|inv_q_vss|mph_g|nand_m_vss|nand_s2_vss|s1_vss_m1|s2_vss_m1|s3_vss_m1|s4_vss_m1|sb_vss|sr1_vss|sr2_vss|sr3_vss|sr4_vss|sv_vss|tg_d_vss|tg_fbm_vss|tg_fbs_vss|tg_s_vss|vss|vss_link|vss_link_bridge|vss_link_dip|vss_link_m1|vss_x1|vss_x2|vss_x3__t11
+ g_vddr_m1|mnt_g|s1_vddr_m1|s2_vddr_m1|s3_vddr_m1|s4_vddr_m1|vddr|vddr4__t8
+ g_vddr_m1|mnt_g|s1_vddr_m1|s2_vddr_m1|s3_vddr_m1|s4_vddr_m1|vddr|vddr4__t4
+ sky130_fd_pr__pfet_01v8 L=2 W=0.48 AS=0.2016 AD=0.2016 PS=1.8 PD=1.8
* device instance $240 r0 *1 186.985,27.375 pfet
X$240 py__t014
+ g_vss_m1|inv_clk_vss|inv_mc_vss|inv_q_vss|mph_g|nand_m_vss|nand_s2_vss|s1_vss_m1|s2_vss_m1|s3_vss_m1|s4_vss_m1|sb_vss|sr1_vss|sr2_vss|sr3_vss|sr4_vss|sv_vss|tg_d_vss|tg_fbm_vss|tg_fbs_vss|tg_s_vss|vss|vss_link|vss_link_bridge|vss_link_dip|vss_link_m1|vss_x1|vss_x2|vss_x3__t10
+ g_vddr_m1|mnt_g|s1_vddr_m1|s2_vddr_m1|s3_vddr_m1|s4_vddr_m1|vddr|vddr4__t7
+ g_vddr_m1|mnt_g|s1_vddr_m1|s2_vddr_m1|s3_vddr_m1|s4_vddr_m1|vddr|vddr4__t3
+ sky130_fd_pr__pfet_01v8 L=2 W=0.48 AS=0.2016 AD=0.2016 PS=1.8 PD=1.8
* device instance $241 r0 *1 195.16,27.375 pfet
X$241 py__t015
+ g_vss_m1|inv_clk_vss|inv_mc_vss|inv_q_vss|mph_g|nand_m_vss|nand_s2_vss|s1_vss_m1|s2_vss_m1|s3_vss_m1|s4_vss_m1|sb_vss|sr1_vss|sr2_vss|sr3_vss|sr4_vss|sv_vss|tg_d_vss|tg_fbm_vss|tg_fbs_vss|tg_s_vss|vss|vss_link|vss_link_bridge|vss_link_dip|vss_link_m1|vss_x1|vss_x2|vss_x3__t13
+ g_vddr_m1|mnt_g|s1_vddr_m1|s2_vddr_m1|s3_vddr_m1|s4_vddr_m1|vddr|vddr4__t10
+ g_vddr_m1|mnt_g|s1_vddr_m1|s2_vddr_m1|s3_vddr_m1|s4_vddr_m1|vddr|vddr4__t6
+ sky130_fd_pr__pfet_01v8 L=2 W=0.48 AS=0.2016 AD=0.2016 PS=1.8 PD=1.8
* device instance $242 r0 *1 203.335,27.375 pfet
X$242 py__t016
+ g_vss_m1|inv_clk_vss|inv_mc_vss|inv_q_vss|mph_g|nand_m_vss|nand_s2_vss|s1_vss_m1|s2_vss_m1|s3_vss_m1|s4_vss_m1|sb_vss|sr1_vss|sr2_vss|sr3_vss|sr4_vss|sv_vss|tg_d_vss|tg_fbm_vss|tg_fbs_vss|tg_s_vss|vss|vss_link|vss_link_bridge|vss_link_dip|vss_link_m1|vss_x1|vss_x2|vss_x3__t12
+ g_vddr_m1|mnt_g|s1_vddr_m1|s2_vddr_m1|s3_vddr_m1|s4_vddr_m1|vddr|vddr4__t9
+ g_vddr_m1|mnt_g|s1_vddr_m1|s2_vddr_m1|s3_vddr_m1|s4_vddr_m1|vddr|vddr4__t5
+ sky130_fd_pr__pfet_01v8 L=2 W=0.48 AS=0.2016 AD=0.2016 PS=1.8 PD=1.8
* device instance $243 r0 *1 3.61,27.825 pfet
X$243 mpa_py|mpb_py|mph_py|py__t0
+ g_vss_m1|inv_clk_vss|inv_mc_vss|inv_q_vss|mph_g|nand_m_vss|nand_s2_vss|s1_vss_m1|s2_vss_m1|s3_vss_m1|s4_vss_m1|sb_vss|sr1_vss|sr2_vss|sr3_vss|sr4_vss|sv_vss|tg_d_vss|tg_fbm_vss|tg_fbs_vss|tg_s_vss|vss|vss_link|vss_link_bridge|vss_link_dip|vss_link_m1|vss_x1|vss_x2|vss_x3__t6
+ g_vddr_m1|mnt_g|s1_vddr_m1|s2_vddr_m1|s3_vddr_m1|s4_vddr_m1|vddr|vddr1__t1
+ g_vddr_m1|mnt_g|s1_vddr_m1|s2_vddr_m1|s3_vddr_m1|s4_vddr_m1|vddr|vddr1__t2
+ sky130_fd_pr__pfet_01v8 L=2 W=0.42 AS=0.1764 AD=0.1764 PS=1.68 PD=1.68
* device instance $244 r0 *1 3.445,44.86 pfet
X$244 an|inva_y|mn34_g0|mp13_g1|y__t1
+ a|d|inva_a|mn12_g0|mp13_g0|ro1|ro1_esc|sr1_d_stub|tg_d_a|y__t5
+ a|d|inv_clk_vdd|inv_mc_vdd|inv_q_vdd|mpa_py|mpb_py|nand_m_vdd|nand_s2_vdd|nwell_vdd|sb_vdd|sr1_vdd|sr2_vdd|sr3_vdd|sr4_vdd|sv_d_vdd_tie|sv_vdd|tg_d_a|tg_d_vdd|tg_fbm_vdd|tg_fbs_vdd|tg_s_vdd|vdd|vdd_b1|vdd_b2|vdd_b3|vdd_b4|vdd_link|vdd_link_dip|vdd_x1|vdd_x2|vdd_x3__t127
+ a|d|inv_clk_vdd|inv_mc_vdd|inv_q_vdd|mpa_py|mpb_py|nand_m_vdd|nand_s2_vdd|nwell_vdd|sb_vdd|sr1_vdd|sr2_vdd|sr3_vdd|sr4_vdd|sv_d_vdd_tie|sv_vdd|tg_d_a|tg_d_vdd|tg_fbm_vdd|tg_fbs_vdd|tg_s_vdd|vdd|vdd_b1|vdd_b2|vdd_b3|vdd_b4|vdd_link|vdd_link_dip|vdd_x1|vdd_x2|vdd_x3__t64
+ sky130_fd_pr__pfet_01v8 L=0.15 W=0.84 AS=0.3948 AD=0.3948 PS=2.62 PD=2.62
* device instance $245 r0 *1 7.43,49.22 pfet
X$245 mid__t1 a|d|inva_a|mn12_g0|mp13_g0|ro1|ro1_esc|sr1_d_stub|tg_d_a|y__t0
+ a|d|inv_clk_vdd|inv_mc_vdd|inv_q_vdd|mpa_py|mpb_py|nand_m_vdd|nand_s2_vdd|nwell_vdd|sb_vdd|sr1_vdd|sr2_vdd|sr3_vdd|sr4_vdd|sv_d_vdd_tie|sv_vdd|tg_d_a|tg_d_vdd|tg_fbm_vdd|tg_fbs_vdd|tg_s_vdd|vdd|vdd_b1|vdd_b2|vdd_b3|vdd_b4|vdd_link|vdd_link_dip|vdd_x1|vdd_x2|vdd_x3__t2
+ a|d|inv_clk_vdd|inv_mc_vdd|inv_q_vdd|mpa_py|mpb_py|nand_m_vdd|nand_s2_vdd|nwell_vdd|sb_vdd|sr1_vdd|sr2_vdd|sr3_vdd|sr4_vdd|sv_d_vdd_tie|sv_vdd|tg_d_a|tg_d_vdd|tg_fbm_vdd|tg_fbs_vdd|tg_s_vdd|vdd|vdd_b1|vdd_b2|vdd_b3|vdd_b4|vdd_link|vdd_link_dip|vdd_x1|vdd_x2|vdd_x3__t3
+ sky130_fd_pr__pfet_01v8 L=0.15 W=1.68 AS=0.7896 AD=0.4368 PS=4.3 PD=2.2
* device instance $246 r0 *1 8.1,49.22 pfet
X$246 a|inva_a|mn12_g0|mp13_g0|t1|y__t0 an|inva_y|mn34_g0|mp13_g1|y__t0 mid__t0
+ a|d|inv_clk_vdd|inv_mc_vdd|inv_q_vdd|mpa_py|mpb_py|nand_m_vdd|nand_s2_vdd|nwell_vdd|sb_vdd|sr1_vdd|sr2_vdd|sr3_vdd|sr4_vdd|sv_d_vdd_tie|sv_vdd|tg_d_a|tg_d_vdd|tg_fbm_vdd|tg_fbs_vdd|tg_s_vdd|vdd|vdd_b1|vdd_b2|vdd_b3|vdd_b4|vdd_link|vdd_link_dip|vdd_x1|vdd_x2|vdd_x3__t4
+ sky130_fd_pr__pfet_01v8 L=0.15 W=1.68 AS=0.4368 AD=0.7896 PS=2.2 PD=4.3
* device instance $247 r0 *1 14.58,49.22 pfet
X$247 mid__t2 bn|invb_y|mn34_g1|mp24_g1|y__t0 a|inva_a|mn12_g0|mp13_g0|t1|y__t2
+ a|d|inv_clk_vdd|inv_mc_vdd|inv_q_vdd|mpa_py|mpb_py|nand_m_vdd|nand_s2_vdd|nwell_vdd|sb_vdd|sr1_vdd|sr2_vdd|sr3_vdd|sr4_vdd|sv_d_vdd_tie|sv_vdd|tg_d_a|tg_d_vdd|tg_fbm_vdd|tg_fbs_vdd|tg_s_vdd|vdd|vdd_b1|vdd_b2|vdd_b3|vdd_b4|vdd_link|vdd_link_dip|vdd_x1|vdd_x2|vdd_x3__t17
+ sky130_fd_pr__pfet_01v8 L=0.15 W=1.68 AS=0.7896 AD=0.4368 PS=4.3 PD=2.2
* device instance $248 r0 *1 15.25,49.22 pfet
X$248
+ a|d|inv_clk_vdd|inv_mc_vdd|inv_q_vdd|mpa_py|mpb_py|nand_m_vdd|nand_s2_vdd|nwell_vdd|sb_vdd|sr1_vdd|sr2_vdd|sr3_vdd|sr4_vdd|sv_d_vdd_tie|sv_vdd|tg_d_a|tg_d_vdd|tg_fbm_vdd|tg_fbs_vdd|tg_s_vdd|vdd|vdd_b1|vdd_b2|vdd_b3|vdd_b4|vdd_link|vdd_link_dip|vdd_x1|vdd_x2|vdd_x3__t7
+ a|b|d|invb_a|mn12_g1|mp24_g0|ro2|ro2_esc|sr2_d_stub|tg_d_a|y__t0 mid__t3
+ a|d|inv_clk_vdd|inv_mc_vdd|inv_q_vdd|mpa_py|mpb_py|nand_m_vdd|nand_s2_vdd|nwell_vdd|sb_vdd|sr1_vdd|sr2_vdd|sr3_vdd|sr4_vdd|sv_d_vdd_tie|sv_vdd|tg_d_a|tg_d_vdd|tg_fbm_vdd|tg_fbs_vdd|tg_s_vdd|vdd|vdd_b1|vdd_b2|vdd_b3|vdd_b4|vdd_link|vdd_link_dip|vdd_x1|vdd_x2|vdd_x3__t12
+ sky130_fd_pr__pfet_01v8 L=0.15 W=1.68 AS=0.4368 AD=0.7896 PS=2.2 PD=4.3
* device instance $249 r0 *1 21.62,44.86 pfet
X$249 bn|invb_y|mn34_g1|mp24_g1|y__t1
+ a|b|d|invb_a|mn12_g1|mp24_g0|ro2|ro2_esc|sr2_d_stub|tg_d_a|y__t5
+ a|d|inv_clk_vdd|inv_mc_vdd|inv_q_vdd|mpa_py|mpb_py|nand_m_vdd|nand_s2_vdd|nwell_vdd|sb_vdd|sr1_vdd|sr2_vdd|sr3_vdd|sr4_vdd|sv_d_vdd_tie|sv_vdd|tg_d_a|tg_d_vdd|tg_fbm_vdd|tg_fbs_vdd|tg_s_vdd|vdd|vdd_b1|vdd_b2|vdd_b3|vdd_b4|vdd_link|vdd_link_dip|vdd_x1|vdd_x2|vdd_x3__t110
+ a|d|inv_clk_vdd|inv_mc_vdd|inv_q_vdd|mpa_py|mpb_py|nand_m_vdd|nand_s2_vdd|nwell_vdd|sb_vdd|sr1_vdd|sr2_vdd|sr3_vdd|sr4_vdd|sv_d_vdd_tie|sv_vdd|tg_d_a|tg_d_vdd|tg_fbm_vdd|tg_fbs_vdd|tg_s_vdd|vdd|vdd_b1|vdd_b2|vdd_b3|vdd_b4|vdd_link|vdd_link_dip|vdd_x1|vdd_x2|vdd_x3__t37
+ sky130_fd_pr__pfet_01v8 L=0.15 W=0.84 AS=0.3948 AD=0.3948 PS=2.62 PD=2.62
* device instance $250 r0 *1 32.415,44.86 pfet
X$250 an|inva_y|mn34_g0|mp13_g1|y__t12
+ a|d|inva_a|mn12_g0|mp13_g0|ro3|ro3_esc_e|ro3_esc_w|ro3_hop|sr3_d_stub|tg_d_a|y__t5
+ a|d|inv_clk_vdd|inv_mc_vdd|inv_q_vdd|mpa_py|mpb_py|nand_m_vdd|nand_s2_vdd|nwell_vdd|sb_vdd|sr1_vdd|sr2_vdd|sr3_vdd|sr4_vdd|sv_d_vdd_tie|sv_vdd|tg_d_a|tg_d_vdd|tg_fbm_vdd|tg_fbs_vdd|tg_s_vdd|vdd|vdd_b1|vdd_b2|vdd_b3|vdd_b4|vdd_link|vdd_link_dip|vdd_x1|vdd_x2|vdd_x3__t111
+ a|d|inv_clk_vdd|inv_mc_vdd|inv_q_vdd|mpa_py|mpb_py|nand_m_vdd|nand_s2_vdd|nwell_vdd|sb_vdd|sr1_vdd|sr2_vdd|sr3_vdd|sr4_vdd|sv_d_vdd_tie|sv_vdd|tg_d_a|tg_d_vdd|tg_fbm_vdd|tg_fbs_vdd|tg_s_vdd|vdd|vdd_b1|vdd_b2|vdd_b3|vdd_b4|vdd_link|vdd_link_dip|vdd_x1|vdd_x2|vdd_x3__t38
+ sky130_fd_pr__pfet_01v8 L=0.15 W=0.84 AS=0.3948 AD=0.3948 PS=2.62 PD=2.62
* device instance $251 r0 *1 36.4,49.22 pfet
X$251 mid__t12
+ a|d|inva_a|mn12_g0|mp13_g0|ro3|ro3_esc_e|ro3_esc_w|ro3_hop|sr3_d_stub|tg_d_a|y__t0
+ a|d|inv_clk_vdd|inv_mc_vdd|inv_q_vdd|mpa_py|mpb_py|nand_m_vdd|nand_s2_vdd|nwell_vdd|sb_vdd|sr1_vdd|sr2_vdd|sr3_vdd|sr4_vdd|sv_d_vdd_tie|sv_vdd|tg_d_a|tg_d_vdd|tg_fbm_vdd|tg_fbs_vdd|tg_s_vdd|vdd|vdd_b1|vdd_b2|vdd_b3|vdd_b4|vdd_link|vdd_link_dip|vdd_x1|vdd_x2|vdd_x3__t19
+ a|d|inv_clk_vdd|inv_mc_vdd|inv_q_vdd|mpa_py|mpb_py|nand_m_vdd|nand_s2_vdd|nwell_vdd|sb_vdd|sr1_vdd|sr2_vdd|sr3_vdd|sr4_vdd|sv_d_vdd_tie|sv_vdd|tg_d_a|tg_d_vdd|tg_fbm_vdd|tg_fbs_vdd|tg_s_vdd|vdd|vdd_b1|vdd_b2|vdd_b3|vdd_b4|vdd_link|vdd_link_dip|vdd_x1|vdd_x2|vdd_x3__t16
+ sky130_fd_pr__pfet_01v8 L=0.15 W=1.68 AS=0.7896 AD=0.4368 PS=4.3 PD=2.2
* device instance $252 r0 *1 37.07,49.22 pfet
X$252 a|b|b3|invb_a|mn12_g1|mp24_g0|t2|y__t0 an|inva_y|mn34_g0|mp13_g1|y__t02
+ mid__t32
+ a|d|inv_clk_vdd|inv_mc_vdd|inv_q_vdd|mpa_py|mpb_py|nand_m_vdd|nand_s2_vdd|nwell_vdd|sb_vdd|sr1_vdd|sr2_vdd|sr3_vdd|sr4_vdd|sv_d_vdd_tie|sv_vdd|tg_d_a|tg_d_vdd|tg_fbm_vdd|tg_fbs_vdd|tg_s_vdd|vdd|vdd_b1|vdd_b2|vdd_b3|vdd_b4|vdd_link|vdd_link_dip|vdd_x1|vdd_x2|vdd_x3__t11
+ sky130_fd_pr__pfet_01v8 L=0.15 W=1.68 AS=0.4368 AD=0.7896 PS=2.2 PD=4.3
* device instance $253 r0 *1 43.55,49.22 pfet
X$253 mid__t02 bn|invb_y|mn34_g1|mp24_g1|y__t02
+ a|b|b3|invb_a|mn12_g1|mp24_g0|t2|y__t2
+ a|d|inv_clk_vdd|inv_mc_vdd|inv_q_vdd|mpa_py|mpb_py|nand_m_vdd|nand_s2_vdd|nwell_vdd|sb_vdd|sr1_vdd|sr2_vdd|sr3_vdd|sr4_vdd|sv_d_vdd_tie|sv_vdd|tg_d_a|tg_d_vdd|tg_fbm_vdd|tg_fbs_vdd|tg_s_vdd|vdd|vdd_b1|vdd_b2|vdd_b3|vdd_b4|vdd_link|vdd_link_dip|vdd_x1|vdd_x2|vdd_x3__t15
+ sky130_fd_pr__pfet_01v8 L=0.15 W=1.68 AS=0.7896 AD=0.4368 PS=4.3 PD=2.2
* device instance $254 r0 *1 44.22,49.22 pfet
X$254
+ a|d|inv_clk_vdd|inv_mc_vdd|inv_q_vdd|mpa_py|mpb_py|nand_m_vdd|nand_s2_vdd|nwell_vdd|sb_vdd|sr1_vdd|sr2_vdd|sr3_vdd|sr4_vdd|sv_d_vdd_tie|sv_vdd|tg_d_a|tg_d_vdd|tg_fbm_vdd|tg_fbs_vdd|tg_s_vdd|vdd|vdd_b1|vdd_b2|vdd_b3|vdd_b4|vdd_link|vdd_link_dip|vdd_x1|vdd_x2|vdd_x3__t6
+ a|b|d|invb_a|mn12_g1|mp24_g0|ro4|ro4_esc|sr4_d_stub|tg_d_a|y__t0 mid__t22
+ a|d|inv_clk_vdd|inv_mc_vdd|inv_q_vdd|mpa_py|mpb_py|nand_m_vdd|nand_s2_vdd|nwell_vdd|sb_vdd|sr1_vdd|sr2_vdd|sr3_vdd|sr4_vdd|sv_d_vdd_tie|sv_vdd|tg_d_a|tg_d_vdd|tg_fbm_vdd|tg_fbs_vdd|tg_s_vdd|vdd|vdd_b1|vdd_b2|vdd_b3|vdd_b4|vdd_link|vdd_link_dip|vdd_x1|vdd_x2|vdd_x3__t10
+ sky130_fd_pr__pfet_01v8 L=0.15 W=1.68 AS=0.4368 AD=0.7896 PS=2.2 PD=4.3
* device instance $255 r0 *1 50.59,44.86 pfet
X$255 bn|invb_y|mn34_g1|mp24_g1|y__t12
+ a|b|d|invb_a|mn12_g1|mp24_g0|ro4|ro4_esc|sr4_d_stub|tg_d_a|y__t5
+ a|d|inv_clk_vdd|inv_mc_vdd|inv_q_vdd|mpa_py|mpb_py|nand_m_vdd|nand_s2_vdd|nwell_vdd|sb_vdd|sr1_vdd|sr2_vdd|sr3_vdd|sr4_vdd|sv_d_vdd_tie|sv_vdd|tg_d_a|tg_d_vdd|tg_fbm_vdd|tg_fbs_vdd|tg_s_vdd|vdd|vdd_b1|vdd_b2|vdd_b3|vdd_b4|vdd_link|vdd_link_dip|vdd_x1|vdd_x2|vdd_x3__t113
+ a|d|inv_clk_vdd|inv_mc_vdd|inv_q_vdd|mpa_py|mpb_py|nand_m_vdd|nand_s2_vdd|nwell_vdd|sb_vdd|sr1_vdd|sr2_vdd|sr3_vdd|sr4_vdd|sv_d_vdd_tie|sv_vdd|tg_d_a|tg_d_vdd|tg_fbm_vdd|tg_fbs_vdd|tg_s_vdd|vdd|vdd_b1|vdd_b2|vdd_b3|vdd_b4|vdd_link|vdd_link_dip|vdd_x1|vdd_x2|vdd_x3__t41
+ sky130_fd_pr__pfet_01v8 L=0.15 W=0.84 AS=0.3948 AD=0.3948 PS=2.62 PD=2.62
* device instance $256 r0 *1 58.91,27.825 pfet
X$256 mpa_py|mpb_py|mph_py|py__t02
+ g_vss_m1|inv_clk_vss|inv_mc_vss|inv_q_vss|mph_g|nand_m_vss|nand_s2_vss|s1_vss_m1|s2_vss_m1|s3_vss_m1|s4_vss_m1|sb_vss|sr1_vss|sr2_vss|sr3_vss|sr4_vss|sv_vss|tg_d_vss|tg_fbm_vss|tg_fbs_vss|tg_s_vss|vss|vss_link|vss_link_bridge|vss_link_dip|vss_link_m1|vss_x1|vss_x2|vss_x3__t7
+ g_vddr_m1|mnt_g|s1_vddr_m1|s2_vddr_m1|s3_vddr_m1|s4_vddr_m1|vddr|vddr2__t1
+ g_vddr_m1|mnt_g|s1_vddr_m1|s2_vddr_m1|s3_vddr_m1|s4_vddr_m1|vddr|vddr2__t2
+ sky130_fd_pr__pfet_01v8 L=2 W=0.44 AS=0.1848 AD=0.1848 PS=1.72 PD=1.72
* device instance $257 r0 *1 61.385,44.86 pfet
X$257 an|inva_y|mn34_g0|mp13_g1|y__t13 a|inva_a|mn12_g0|mp13_g0|t1|y__t3
+ a|d|inv_clk_vdd|inv_mc_vdd|inv_q_vdd|mpa_py|mpb_py|nand_m_vdd|nand_s2_vdd|nwell_vdd|sb_vdd|sr1_vdd|sr2_vdd|sr3_vdd|sr4_vdd|sv_d_vdd_tie|sv_vdd|tg_d_a|tg_d_vdd|tg_fbm_vdd|tg_fbs_vdd|tg_s_vdd|vdd|vdd_b1|vdd_b2|vdd_b3|vdd_b4|vdd_link|vdd_link_dip|vdd_x1|vdd_x2|vdd_x3__t114
+ a|d|inv_clk_vdd|inv_mc_vdd|inv_q_vdd|mpa_py|mpb_py|nand_m_vdd|nand_s2_vdd|nwell_vdd|sb_vdd|sr1_vdd|sr2_vdd|sr3_vdd|sr4_vdd|sv_d_vdd_tie|sv_vdd|tg_d_a|tg_d_vdd|tg_fbm_vdd|tg_fbs_vdd|tg_s_vdd|vdd|vdd_b1|vdd_b2|vdd_b3|vdd_b4|vdd_link|vdd_link_dip|vdd_x1|vdd_x2|vdd_x3__t42
+ sky130_fd_pr__pfet_01v8 L=0.15 W=0.84 AS=0.3948 AD=0.3948 PS=2.62 PD=2.62
* device instance $258 r0 *1 65.37,49.22 pfet
X$258 mid__t13 a|inva_a|mn12_g0|mp13_g0|t1|y__t1
+ a|d|inv_clk_vdd|inv_mc_vdd|inv_q_vdd|mpa_py|mpb_py|nand_m_vdd|nand_s2_vdd|nwell_vdd|sb_vdd|sr1_vdd|sr2_vdd|sr3_vdd|sr4_vdd|sv_d_vdd_tie|sv_vdd|tg_d_a|tg_d_vdd|tg_fbm_vdd|tg_fbs_vdd|tg_s_vdd|vdd|vdd_b1|vdd_b2|vdd_b3|vdd_b4|vdd_link|vdd_link_dip|vdd_x1|vdd_x2|vdd_x3__t18
+ a|d|inv_clk_vdd|inv_mc_vdd|inv_q_vdd|mpa_py|mpb_py|nand_m_vdd|nand_s2_vdd|nwell_vdd|sb_vdd|sr1_vdd|sr2_vdd|sr3_vdd|sr4_vdd|sv_d_vdd_tie|sv_vdd|tg_d_a|tg_d_vdd|tg_fbm_vdd|tg_fbs_vdd|tg_s_vdd|vdd|vdd_b1|vdd_b2|vdd_b3|vdd_b4|vdd_link|vdd_link_dip|vdd_x1|vdd_x2|vdd_x3__t14
+ sky130_fd_pr__pfet_01v8 L=0.15 W=1.68 AS=0.7896 AD=0.4368 PS=4.3 PD=2.2
* device instance $259 r0 *1 66.04,49.22 pfet
X$259 a|d|sb_d_stub|tg_d_a|xo|xo_dip|xo_hop|xo_stub|y__t0
+ an|inva_y|mn34_g0|mp13_g1|y__t03 mid__t33
+ a|d|inv_clk_vdd|inv_mc_vdd|inv_q_vdd|mpa_py|mpb_py|nand_m_vdd|nand_s2_vdd|nwell_vdd|sb_vdd|sr1_vdd|sr2_vdd|sr3_vdd|sr4_vdd|sv_d_vdd_tie|sv_vdd|tg_d_a|tg_d_vdd|tg_fbm_vdd|tg_fbs_vdd|tg_s_vdd|vdd|vdd_b1|vdd_b2|vdd_b3|vdd_b4|vdd_link|vdd_link_dip|vdd_x1|vdd_x2|vdd_x3__t9
+ sky130_fd_pr__pfet_01v8 L=0.15 W=1.68 AS=0.4368 AD=0.7896 PS=2.2 PD=4.3
* device instance $260 r0 *1 72.52,49.22 pfet
X$260 mid__t03 bn|invb_y|mn34_g1|mp24_g1|y__t03
+ a|d|sb_d_stub|tg_d_a|xo|xo_dip|xo_hop|xo_stub|y__t1
+ a|d|inv_clk_vdd|inv_mc_vdd|inv_q_vdd|mpa_py|mpb_py|nand_m_vdd|nand_s2_vdd|nwell_vdd|sb_vdd|sr1_vdd|sr2_vdd|sr3_vdd|sr4_vdd|sv_d_vdd_tie|sv_vdd|tg_d_a|tg_d_vdd|tg_fbm_vdd|tg_fbs_vdd|tg_s_vdd|vdd|vdd_b1|vdd_b2|vdd_b3|vdd_b4|vdd_link|vdd_link_dip|vdd_x1|vdd_x2|vdd_x3__t13
+ sky130_fd_pr__pfet_01v8 L=0.15 W=1.68 AS=0.7896 AD=0.4368 PS=4.3 PD=2.2
* device instance $261 r0 *1 73.19,49.22 pfet
X$261
+ a|d|inv_clk_vdd|inv_mc_vdd|inv_q_vdd|mpa_py|mpb_py|nand_m_vdd|nand_s2_vdd|nwell_vdd|sb_vdd|sr1_vdd|sr2_vdd|sr3_vdd|sr4_vdd|sv_d_vdd_tie|sv_vdd|tg_d_a|tg_d_vdd|tg_fbm_vdd|tg_fbs_vdd|tg_s_vdd|vdd|vdd_b1|vdd_b2|vdd_b3|vdd_b4|vdd_link|vdd_link_dip|vdd_x1|vdd_x2|vdd_x3__t5
+ a|b|b3|invb_a|mn12_g1|mp24_g0|t2|y__t1 mid__t23
+ a|d|inv_clk_vdd|inv_mc_vdd|inv_q_vdd|mpa_py|mpb_py|nand_m_vdd|nand_s2_vdd|nwell_vdd|sb_vdd|sr1_vdd|sr2_vdd|sr3_vdd|sr4_vdd|sv_d_vdd_tie|sv_vdd|tg_d_a|tg_d_vdd|tg_fbm_vdd|tg_fbs_vdd|tg_s_vdd|vdd|vdd_b1|vdd_b2|vdd_b3|vdd_b4|vdd_link|vdd_link_dip|vdd_x1|vdd_x2|vdd_x3__t8
+ sky130_fd_pr__pfet_01v8 L=0.15 W=1.68 AS=0.4368 AD=0.7896 PS=2.2 PD=4.3
* device instance $262 r0 *1 79.56,44.86 pfet
X$262 bn|invb_y|mn34_g1|mp24_g1|y__t13 a|b|b3|invb_a|mn12_g1|mp24_g0|t2|y__t3
+ a|d|inv_clk_vdd|inv_mc_vdd|inv_q_vdd|mpa_py|mpb_py|nand_m_vdd|nand_s2_vdd|nwell_vdd|sb_vdd|sr1_vdd|sr2_vdd|sr3_vdd|sr4_vdd|sv_d_vdd_tie|sv_vdd|tg_d_a|tg_d_vdd|tg_fbm_vdd|tg_fbs_vdd|tg_s_vdd|vdd|vdd_b1|vdd_b2|vdd_b3|vdd_b4|vdd_link|vdd_link_dip|vdd_x1|vdd_x2|vdd_x3__t118
+ a|d|inv_clk_vdd|inv_mc_vdd|inv_q_vdd|mpa_py|mpb_py|nand_m_vdd|nand_s2_vdd|nwell_vdd|sb_vdd|sr1_vdd|sr2_vdd|sr3_vdd|sr4_vdd|sv_d_vdd_tie|sv_vdd|tg_d_a|tg_d_vdd|tg_fbm_vdd|tg_fbs_vdd|tg_s_vdd|vdd|vdd_b1|vdd_b2|vdd_b3|vdd_b4|vdd_link|vdd_link_dip|vdd_x1|vdd_x2|vdd_x3__t50
+ sky130_fd_pr__pfet_01v8 L=0.15 W=0.84 AS=0.3948 AD=0.3948 PS=2.62 PD=2.62
* device instance $263 r0 *1 114.21,27.825 pfet
X$263 mpa_py|mpb_py|mph_py|py__t03
+ g_vss_m1|inv_clk_vss|inv_mc_vss|inv_q_vss|mph_g|nand_m_vss|nand_s2_vss|s1_vss_m1|s2_vss_m1|s3_vss_m1|s4_vss_m1|sb_vss|sr1_vss|sr2_vss|sr3_vss|sr4_vss|sv_vss|tg_d_vss|tg_fbm_vss|tg_fbs_vss|tg_s_vss|vss|vss_link|vss_link_bridge|vss_link_dip|vss_link_m1|vss_x1|vss_x2|vss_x3__t8
+ g_vddr_m1|mnt_g|s1_vddr_m1|s2_vddr_m1|s3_vddr_m1|s4_vddr_m1|vddr|vddr3__t1
+ g_vddr_m1|mnt_g|s1_vddr_m1|s2_vddr_m1|s3_vddr_m1|s4_vddr_m1|vddr|vddr3__t2
+ sky130_fd_pr__pfet_01v8 L=2 W=0.46 AS=0.1932 AD=0.1932 PS=1.76 PD=1.76
* device instance $264 r0 *1 169.51,27.825 pfet
X$264 mpa_py|mpb_py|mph_py|py__t04
+ g_vss_m1|inv_clk_vss|inv_mc_vss|inv_q_vss|mph_g|nand_m_vss|nand_s2_vss|s1_vss_m1|s2_vss_m1|s3_vss_m1|s4_vss_m1|sb_vss|sr1_vss|sr2_vss|sr3_vss|sr4_vss|sv_vss|tg_d_vss|tg_fbm_vss|tg_fbs_vss|tg_s_vss|vss|vss_link|vss_link_bridge|vss_link_dip|vss_link_m1|vss_x1|vss_x2|vss_x3__t9
+ g_vddr_m1|mnt_g|s1_vddr_m1|s2_vddr_m1|s3_vddr_m1|s4_vddr_m1|vddr|vddr4__t1
+ g_vddr_m1|mnt_g|s1_vddr_m1|s2_vddr_m1|s3_vddr_m1|s4_vddr_m1|vddr|vddr4__t2
+ sky130_fd_pr__pfet_01v8 L=2 W=0.48 AS=0.2016 AD=0.2016 PS=1.8 PD=1.8
* device instance _12_t0 r0 *1 0,0
R_12_t0 \$12__t0 \$12 12.8
* device instance _12_t1 r0 *1 0,0
R_12_t1 \$12__t1 \$12 12.8
* device instance _12 r0 *1 0,0
C_12 \$12 vsubs 1.15618e-16
* device instance _138_t0 r0 *1 0,0
R_138_t0 \$138__t0 \$138 12.8
* device instance _138_t1 r0 *1 0,0
R_138_t1 \$138__t1 \$138 12.8
* device instance _138 r0 *1 0,0
C_138 \$138 vsubs 1.15618e-16
* device instance _139_t0 r0 *1 0,0
R_139_t0 \$139__t0 \$139 12.8
* device instance _139_t1 r0 *1 0,0
R_139_t1 \$139__t1 \$139 12.8
* device instance _139 r0 *1 0,0
C_139 \$139 vsubs 1.15618e-16
* device instance _14_t0 r0 *1 0,0
R_14_t0 \$14__t0 \$14 12.8
* device instance _14_t1 r0 *1 0,0
R_14_t1 \$14__t1 \$14 12.8
* device instance _14 r0 *1 0,0
C_14 \$14 vsubs 1.15618e-16
* device instance _140_t0 r0 *1 0,0
R_140_t0 \$140__t0 \$140 12.8
* device instance _140_t1 r0 *1 0,0
R_140_t1 \$140__t1 \$140 12.8
* device instance _140 r0 *1 0,0
C_140 \$140 vsubs 1.15618e-16
* device instance _142_t0 r0 *1 0,0
R_142_t0 \$142__t0 \$142 12.8
* device instance _142_t1 r0 *1 0,0
R_142_t1 \$142__t1 \$142 12.8
* device instance _142 r0 *1 0,0
C_142 \$142 vsubs 1.15618e-16
* device instance _143_t0 r0 *1 0,0
R_143_t0 \$143__t0 \$143 12.8
* device instance _143_t1 r0 *1 0,0
R_143_t1 \$143__t1 \$143 12.8
* device instance _143 r0 *1 0,0
C_143 \$143 vsubs 1.15618e-16
* device instance _146_t0 r0 *1 0,0
R_146_t0 \$146__t0 \$146 12.8
* device instance _146_t1 r0 *1 0,0
R_146_t1 \$146__t1 \$146 12.8
* device instance _146 r0 *1 0,0
C_146 \$146 vsubs 1.15618e-16
* device instance _16_t0 r0 *1 0,0
R_16_t0 \$16__t0 \$16 12.8
* device instance _16_t1 r0 *1 0,0
R_16_t1 \$16__t1 \$16 12.8
* device instance _16 r0 *1 0,0
C_16 \$16 vsubs 1.15618e-16
* device instance _18_t0 r0 *1 0,0
R_18_t0 \$18__t0 \$18 12.8
* device instance _18_t1 r0 *1 0,0
R_18_t1 \$18__t1 \$18 12.8
* device instance _18 r0 *1 0,0
C_18 \$18 vsubs 1.15618e-16
* device instance _21_t0 r0 *1 0,0
R_21_t0 \$21__t0 \$21 12.8
* device instance _21_t1 r0 *1 0,0
R_21_t1 \$21__t1 \$21 12.8
* device instance _21 r0 *1 0,0
C_21 \$21 vsubs 1.15618e-16
* device instance _23_t0 r0 *1 0,0
R_23_t0 \$23__t0 \$23 12.8
* device instance _23_t1 r0 *1 0,0
R_23_t1 \$23__t1 \$23 12.8
* device instance _23 r0 *1 0,0
C_23 \$23 vsubs 1.15618e-16
* device instance _26_t0 r0 *1 0,0
R_26_t0 \$26__t0 \$26 12.8
* device instance _26_t1 r0 *1 0,0
R_26_t1 \$26__t1 \$26 12.8
* device instance _26 r0 *1 0,0
C_26 \$26 vsubs 1.15618e-16
* device instance _28_t0 r0 *1 0,0
R_28_t0 \$28__t0 \$28 12.8
* device instance _28_t1 r0 *1 0,0
R_28_t1 \$28__t1 \$28 12.8
* device instance _28 r0 *1 0,0
C_28 \$28 vsubs 1.15618e-16
* device instance _31_t0 r0 *1 0,0
R_31_t0 \$31__t0 \$31 12.8
* device instance _31_t1 r0 *1 0,0
R_31_t1 \$31__t1 \$31 12.8
* device instance _31 r0 *1 0,0
C_31 \$31 vsubs 1.15618e-16
* device instance _33_t0 r0 *1 0,0
R_33_t0 \$33__t0 \$33 12.8
* device instance _33_t1 r0 *1 0,0
R_33_t1 \$33__t1 \$33 12.8
* device instance _33 r0 *1 0,0
C_33 \$33 vsubs 1.15618e-16
* device instance _36_t0 r0 *1 0,0
R_36_t0 \$36__t0 \$36 12.8
* device instance _36_t1 r0 *1 0,0
R_36_t1 \$36__t1 \$36 12.8
* device instance _36 r0 *1 0,0
C_36 \$36 vsubs 1.15618e-16
* device instance _38_t0 r0 *1 0,0
R_38_t0 \$38__t0 \$38 12.8
* device instance _38_t1 r0 *1 0,0
R_38_t1 \$38__t1 \$38 12.8
* device instance _38 r0 *1 0,0
C_38 \$38 vsubs 1.15618e-16
* device instance _72_t0 r0 *1 0,0
R_72_t0 \$72__t0 \$72 12.8
* device instance _72_t1 r0 *1 0,0
R_72_t1 \$72__t1 \$72 12.8
* device instance _72 r0 *1 0,0
C_72 \$72 vsubs 1.15618e-16
* device instance _79_t0 r0 *1 0,0
R_79_t0 \$79__t0 \$79 12.8
* device instance _79_t1 r0 *1 0,0
R_79_t1 \$79__t1 \$79 12.8
* device instance _79 r0 *1 0,0
C_79 \$79 vsubs 1.15618e-16
* device instance _88_t0 r0 *1 0,0
R_88_t0 \$88__t0 \$88 12.8
* device instance _88_t1 r0 *1 0,0
R_88_t1 \$88__t1 \$88 12.8
* device instance _88 r0 *1 0,0
C_88 \$88 vsubs 1.15618e-16
* device instance _96_t0 r0 *1 0,0
R_96_t0 \$96__t0 \$96 12.8
* device instance _96_t1 r0 *1 0,0
R_96_t1 \$96__t1 \$96 12.8
* device instance _96 r0 *1 0,0
C_96 \$96 vsubs 1.15618e-16
* device instance a_b_b3_invb_a_mn12_g1_mp24_g0_t2_y_t0 r0 *1 0,0
Ra_b_b3_invb_a_mn12_g1_mp24_g0_t2_y_t0 a|b|b3|invb_a|mn12_g1|mp24_g0|t2|y__t0
+ a|b|b3|invb_a|mn12_g1|mp24_g0|t2|y 409.635106767
* device instance a_b_b3_invb_a_mn12_g1_mp24_g0_t2_y_t1 r0 *1 0,0
Ra_b_b3_invb_a_mn12_g1_mp24_g0_t2_y_t1 a|b|b3|invb_a|mn12_g1|mp24_g0|t2|y__t1
+ a|b|b3|invb_a|mn12_g1|mp24_g0|t2|y 294.133620825
* device instance a_b_b3_invb_a_mn12_g1_mp24_g0_t2_y_t2 r0 *1 0,0
Ra_b_b3_invb_a_mn12_g1_mp24_g0_t2_y_t2 a|b|b3|invb_a|mn12_g1|mp24_g0|t2|y__t2
+ a|b|b3|invb_a|mn12_g1|mp24_g0|t2|y 293.51720502
* device instance a_b_b3_invb_a_mn12_g1_mp24_g0_t2_y_t3 r0 *1 0,0
Ra_b_b3_invb_a_mn12_g1_mp24_g0_t2_y_t3 a|b|b3|invb_a|mn12_g1|mp24_g0|t2|y__t3
+ a|b|b3|invb_a|mn12_g1|mp24_g0|t2|y 396.642557999
* device instance a_b_b3_invb_a_mn12_g1_mp24_g0_t2_y_t4 r0 *1 0,0
Ra_b_b3_invb_a_mn12_g1_mp24_g0_t2_y_t4 a|b|b3|invb_a|mn12_g1|mp24_g0|t2|y__t4
+ a|b|b3|invb_a|mn12_g1|mp24_g0|t2|y 398.872164213
* device instance a_b_b3_invb_a_mn12_g1_mp24_g0_t2_y_t5 r0 *1 0,0
Ra_b_b3_invb_a_mn12_g1_mp24_g0_t2_y_t5 a|b|b3|invb_a|mn12_g1|mp24_g0|t2|y__t5
+ a|b|b3|invb_a|mn12_g1|mp24_g0|t2|y 294.652537151
* device instance a_b_b3_invb_a_mn12_g1_mp24_g0_t2_y_t6 r0 *1 0,0
Ra_b_b3_invb_a_mn12_g1_mp24_g0_t2_y_t6 a|b|b3|invb_a|mn12_g1|mp24_g0|t2|y__t6
+ a|b|b3|invb_a|mn12_g1|mp24_g0|t2|y 413.294026601
* device instance a_b_b3_invb_a_mn12_g1_mp24_g0_t2_y_t7 r0 *1 0,0
Ra_b_b3_invb_a_mn12_g1_mp24_g0_t2_y_t7 a|b|b3|invb_a|mn12_g1|mp24_g0|t2|y__t7
+ a|b|b3|invb_a|mn12_g1|mp24_g0|t2|y 286.911181424
* device instance a_b_b3_invb_a_mn12_g1_mp24_g0_t2_y r0 *1 0,0
Ca_b_b3_invb_a_mn12_g1_mp24_g0_t2_y a|b|b3|invb_a|mn12_g1|mp24_g0|t2|y vsubs
+ 1.0147503e-14
* device instance a_b_d_invb_a_mn12_g1_mp24_g0_ro2_ro2_esc_sr2_d_stub_tg_d_a_y_t0 r0 *1 0,0
Ra_b_d_invb_a_mn12_g1_mp24_g0_ro2_ro2_esc_sr2_d_stub_tg_d_a_y_t0
+ a|b|d|invb_a|mn12_g1|mp24_g0|ro2|ro2_esc|sr2_d_stub|tg_d_a|y__t0
+ a|b|d|invb_a|mn12_g1|mp24_g0|ro2|ro2_esc|sr2_d_stub|tg_d_a|y 255.012528793
* device instance a_b_d_invb_a_mn12_g1_mp24_g0_ro2_ro2_esc_sr2_d_stub_tg_d_a_y_t1 r0 *1 0,0
Ra_b_d_invb_a_mn12_g1_mp24_g0_ro2_ro2_esc_sr2_d_stub_tg_d_a_y_t1
+ a|b|d|invb_a|mn12_g1|mp24_g0|ro2|ro2_esc|sr2_d_stub|tg_d_a|y__t1
+ a|b|d|invb_a|mn12_g1|mp24_g0|ro2|ro2_esc|sr2_d_stub|tg_d_a|y 99.3433738514
* device instance a_b_d_invb_a_mn12_g1_mp24_g0_ro2_ro2_esc_sr2_d_stub_tg_d_a_y_t2 r0 *1 0,0
Ra_b_d_invb_a_mn12_g1_mp24_g0_ro2_ro2_esc_sr2_d_stub_tg_d_a_y_t2
+ a|b|d|invb_a|mn12_g1|mp24_g0|ro2|ro2_esc|sr2_d_stub|tg_d_a|y__t2
+ a|b|d|invb_a|mn12_g1|mp24_g0|ro2|ro2_esc|sr2_d_stub|tg_d_a|y 373.724634993
* device instance a_b_d_invb_a_mn12_g1_mp24_g0_ro2_ro2_esc_sr2_d_stub_tg_d_a_y_t3 r0 *1 0,0
Ra_b_d_invb_a_mn12_g1_mp24_g0_ro2_ro2_esc_sr2_d_stub_tg_d_a_y_t3
+ a|b|d|invb_a|mn12_g1|mp24_g0|ro2|ro2_esc|sr2_d_stub|tg_d_a|y__t3
+ a|b|d|invb_a|mn12_g1|mp24_g0|ro2|ro2_esc|sr2_d_stub|tg_d_a|y 377.228073538
* device instance a_b_d_invb_a_mn12_g1_mp24_g0_ro2_ro2_esc_sr2_d_stub_tg_d_a_y_t4 r0 *1 0,0
Ra_b_d_invb_a_mn12_g1_mp24_g0_ro2_ro2_esc_sr2_d_stub_tg_d_a_y_t4
+ a|b|d|invb_a|mn12_g1|mp24_g0|ro2|ro2_esc|sr2_d_stub|tg_d_a|y__t4
+ a|b|d|invb_a|mn12_g1|mp24_g0|ro2|ro2_esc|sr2_d_stub|tg_d_a|y 100.907361972
* device instance a_b_d_invb_a_mn12_g1_mp24_g0_ro2_ro2_esc_sr2_d_stub_tg_d_a_y_t5 r0 *1 0,0
Ra_b_d_invb_a_mn12_g1_mp24_g0_ro2_ro2_esc_sr2_d_stub_tg_d_a_y_t5
+ a|b|d|invb_a|mn12_g1|mp24_g0|ro2|ro2_esc|sr2_d_stub|tg_d_a|y__t5
+ a|b|d|invb_a|mn12_g1|mp24_g0|ro2|ro2_esc|sr2_d_stub|tg_d_a|y 226.705362657
* device instance a_b_d_invb_a_mn12_g1_mp24_g0_ro2_ro2_esc_sr2_d_stub_tg_d_a_y_t6 r0 *1 0,0
Ra_b_d_invb_a_mn12_g1_mp24_g0_ro2_ro2_esc_sr2_d_stub_tg_d_a_y_t6
+ a|b|d|invb_a|mn12_g1|mp24_g0|ro2|ro2_esc|sr2_d_stub|tg_d_a|y__t6
+ a|b|d|invb_a|mn12_g1|mp24_g0|ro2|ro2_esc|sr2_d_stub|tg_d_a|y 223.547043236
* device instance a_b_d_invb_a_mn12_g1_mp24_g0_ro2_ro2_esc_sr2_d_stub_tg_d_a_y_t7 r0 *1 0,0
Ra_b_d_invb_a_mn12_g1_mp24_g0_ro2_ro2_esc_sr2_d_stub_tg_d_a_y_t7
+ a|b|d|invb_a|mn12_g1|mp24_g0|ro2|ro2_esc|sr2_d_stub|tg_d_a|y__t7
+ a|b|d|invb_a|mn12_g1|mp24_g0|ro2|ro2_esc|sr2_d_stub|tg_d_a|y 245.10132096
* device instance a_b_d_invb_a_mn12_g1_mp24_g0_ro2_ro2_esc_sr2_d_stub_tg_d_a_y r0 *1 0,0
Ca_b_d_invb_a_mn12_g1_mp24_g0_ro2_ro2_esc_sr2_d_stub_tg_d_a_y
+ a|b|d|invb_a|mn12_g1|mp24_g0|ro2|ro2_esc|sr2_d_stub|tg_d_a|y vsubs
+ 3.0668813e-14
* device instance a_b_d_invb_a_mn12_g1_mp24_g0_ro4_ro4_esc_sr4_d_stub_tg_d_a_y_t0 r0 *1 0,0
Ra_b_d_invb_a_mn12_g1_mp24_g0_ro4_ro4_esc_sr4_d_stub_tg_d_a_y_t0
+ a|b|d|invb_a|mn12_g1|mp24_g0|ro4|ro4_esc|sr4_d_stub|tg_d_a|y__t0
+ a|b|d|invb_a|mn12_g1|mp24_g0|ro4|ro4_esc|sr4_d_stub|tg_d_a|y 243.020425688
* device instance a_b_d_invb_a_mn12_g1_mp24_g0_ro4_ro4_esc_sr4_d_stub_tg_d_a_y_t1 r0 *1 0,0
Ra_b_d_invb_a_mn12_g1_mp24_g0_ro4_ro4_esc_sr4_d_stub_tg_d_a_y_t1
+ a|b|d|invb_a|mn12_g1|mp24_g0|ro4|ro4_esc|sr4_d_stub|tg_d_a|y__t1
+ a|b|d|invb_a|mn12_g1|mp24_g0|ro4|ro4_esc|sr4_d_stub|tg_d_a|y 315.186307889
* device instance a_b_d_invb_a_mn12_g1_mp24_g0_ro4_ro4_esc_sr4_d_stub_tg_d_a_y_t2 r0 *1 0,0
Ra_b_d_invb_a_mn12_g1_mp24_g0_ro4_ro4_esc_sr4_d_stub_tg_d_a_y_t2
+ a|b|d|invb_a|mn12_g1|mp24_g0|ro4|ro4_esc|sr4_d_stub|tg_d_a|y__t2
+ a|b|d|invb_a|mn12_g1|mp24_g0|ro4|ro4_esc|sr4_d_stub|tg_d_a|y 152.215466951
* device instance a_b_d_invb_a_mn12_g1_mp24_g0_ro4_ro4_esc_sr4_d_stub_tg_d_a_y_t3 r0 *1 0,0
Ra_b_d_invb_a_mn12_g1_mp24_g0_ro4_ro4_esc_sr4_d_stub_tg_d_a_y_t3
+ a|b|d|invb_a|mn12_g1|mp24_g0|ro4|ro4_esc|sr4_d_stub|tg_d_a|y__t3
+ a|b|d|invb_a|mn12_g1|mp24_g0|ro4|ro4_esc|sr4_d_stub|tg_d_a|y 152.580461837
* device instance a_b_d_invb_a_mn12_g1_mp24_g0_ro4_ro4_esc_sr4_d_stub_tg_d_a_y_t4 r0 *1 0,0
Ra_b_d_invb_a_mn12_g1_mp24_g0_ro4_ro4_esc_sr4_d_stub_tg_d_a_y_t4
+ a|b|d|invb_a|mn12_g1|mp24_g0|ro4|ro4_esc|sr4_d_stub|tg_d_a|y__t4
+ a|b|d|invb_a|mn12_g1|mp24_g0|ro4|ro4_esc|sr4_d_stub|tg_d_a|y 316.665349301
* device instance a_b_d_invb_a_mn12_g1_mp24_g0_ro4_ro4_esc_sr4_d_stub_tg_d_a_y_t5 r0 *1 0,0
Ra_b_d_invb_a_mn12_g1_mp24_g0_ro4_ro4_esc_sr4_d_stub_tg_d_a_y_t5
+ a|b|d|invb_a|mn12_g1|mp24_g0|ro4|ro4_esc|sr4_d_stub|tg_d_a|y__t5
+ a|b|d|invb_a|mn12_g1|mp24_g0|ro4|ro4_esc|sr4_d_stub|tg_d_a|y 226.881843467
* device instance a_b_d_invb_a_mn12_g1_mp24_g0_ro4_ro4_esc_sr4_d_stub_tg_d_a_y_t6 r0 *1 0,0
Ra_b_d_invb_a_mn12_g1_mp24_g0_ro4_ro4_esc_sr4_d_stub_tg_d_a_y_t6
+ a|b|d|invb_a|mn12_g1|mp24_g0|ro4|ro4_esc|sr4_d_stub|tg_d_a|y__t6
+ a|b|d|invb_a|mn12_g1|mp24_g0|ro4|ro4_esc|sr4_d_stub|tg_d_a|y 225.765905383
* device instance a_b_d_invb_a_mn12_g1_mp24_g0_ro4_ro4_esc_sr4_d_stub_tg_d_a_y_t7 r0 *1 0,0
Ra_b_d_invb_a_mn12_g1_mp24_g0_ro4_ro4_esc_sr4_d_stub_tg_d_a_y_t7
+ a|b|d|invb_a|mn12_g1|mp24_g0|ro4|ro4_esc|sr4_d_stub|tg_d_a|y__t7
+ a|b|d|invb_a|mn12_g1|mp24_g0|ro4|ro4_esc|sr4_d_stub|tg_d_a|y 239.190739485
* device instance a_b_d_invb_a_mn12_g1_mp24_g0_ro4_ro4_esc_sr4_d_stub_tg_d_a_y r0 *1 0,0
Ca_b_d_invb_a_mn12_g1_mp24_g0_ro4_ro4_esc_sr4_d_stub_tg_d_a_y
+ a|b|d|invb_a|mn12_g1|mp24_g0|ro4|ro4_esc|sr4_d_stub|tg_d_a|y vsubs
+ 2.8023156e-14
* device instance a_b_inv_q_a_inv_q_a_via_s_tg_fbs_b_tg_fbs_b_via_tg_s_b_tg_s_b_via_t0 r0 *1 0,0
Ra_b_inv_q_a_inv_q_a_via_s_tg_fbs_b_tg_fbs_b_via_tg_s_b_tg_s_b_via_t0
+ a|b|inv_q_a|inv_q_a_via|s|tg_fbs_b|tg_fbs_b_via|tg_s_b|tg_s_b_via__t0
+ a|b|inv_q_a|inv_q_a_via|s|tg_fbs_b|tg_fbs_b_via|tg_s_b|tg_s_b_via
+ 65.5799158739
* device instance a_b_inv_q_a_inv_q_a_via_s_tg_fbs_b_tg_fbs_b_via_tg_s_b_tg_s_b_via_t1 r0 *1 0,0
Ra_b_inv_q_a_inv_q_a_via_s_tg_fbs_b_tg_fbs_b_via_tg_s_b_tg_s_b_via_t1
+ a|b|inv_q_a|inv_q_a_via|s|tg_fbs_b|tg_fbs_b_via|tg_s_b|tg_s_b_via__t1
+ a|b|inv_q_a|inv_q_a_via|s|tg_fbs_b|tg_fbs_b_via|tg_s_b|tg_s_b_via
+ 65.5799158739
* device instance a_b_inv_q_a_inv_q_a_via_s_tg_fbs_b_tg_fbs_b_via_tg_s_b_tg_s_b_via_t2 r0 *1 0,0
Ra_b_inv_q_a_inv_q_a_via_s_tg_fbs_b_tg_fbs_b_via_tg_s_b_tg_s_b_via_t2
+ a|b|inv_q_a|inv_q_a_via|s|tg_fbs_b|tg_fbs_b_via|tg_s_b|tg_s_b_via__t2
+ a|b|inv_q_a|inv_q_a_via|s|tg_fbs_b|tg_fbs_b_via|tg_s_b|tg_s_b_via
+ 230.632009296
* device instance a_b_inv_q_a_inv_q_a_via_s_tg_fbs_b_tg_fbs_b_via_tg_s_b_tg_s_b_via_t3 r0 *1 0,0
Ra_b_inv_q_a_inv_q_a_via_s_tg_fbs_b_tg_fbs_b_via_tg_s_b_tg_s_b_via_t3
+ a|b|inv_q_a|inv_q_a_via|s|tg_fbs_b|tg_fbs_b_via|tg_s_b|tg_s_b_via__t3
+ a|b|inv_q_a|inv_q_a_via|s|tg_fbs_b|tg_fbs_b_via|tg_s_b|tg_s_b_via 279.22177483
* device instance a_b_inv_q_a_inv_q_a_via_s_tg_fbs_b_tg_fbs_b_via_tg_s_b_tg_s_b_via_t4 r0 *1 0,0
Ra_b_inv_q_a_inv_q_a_via_s_tg_fbs_b_tg_fbs_b_via_tg_s_b_tg_s_b_via_t4
+ a|b|inv_q_a|inv_q_a_via|s|tg_fbs_b|tg_fbs_b_via|tg_s_b|tg_s_b_via__t4
+ a|b|inv_q_a|inv_q_a_via|s|tg_fbs_b|tg_fbs_b_via|tg_s_b|tg_s_b_via
+ 230.632009296
* device instance a_b_inv_q_a_inv_q_a_via_s_tg_fbs_b_tg_fbs_b_via_tg_s_b_tg_s_b_via_t5 r0 *1 0,0
Ra_b_inv_q_a_inv_q_a_via_s_tg_fbs_b_tg_fbs_b_via_tg_s_b_tg_s_b_via_t5
+ a|b|inv_q_a|inv_q_a_via|s|tg_fbs_b|tg_fbs_b_via|tg_s_b|tg_s_b_via__t5
+ a|b|inv_q_a|inv_q_a_via|s|tg_fbs_b|tg_fbs_b_via|tg_s_b|tg_s_b_via 279.22177483
* device instance a_b_inv_q_a_inv_q_a_via_s_tg_fbs_b_tg_fbs_b_via_tg_s_b_tg_s_b_via r0 *1 0,0
Ca_b_inv_q_a_inv_q_a_via_s_tg_fbs_b_tg_fbs_b_via_tg_s_b_tg_s_b_via
+ a|b|inv_q_a|inv_q_a_via|s|tg_fbs_b|tg_fbs_b_via|tg_s_b|tg_s_b_via vsubs
+ 3.962997e-15
* device instance a_b_inv_q_a_inv_q_a_via_s_tg_fbs_b_tg_fbs_b_via_tg_s_b_tg_s_b_via_dup1_t0 r0 *1 0,0
Ra_b_inv_q_a_inv_q_a_via_s_tg_fbs_b_tg_fbs_b_via_tg_s_b_tg_s_b_via_dup1_t0
+ a|b|inv_q_a|inv_q_a_via|s|tg_fbs_b|tg_fbs_b_via|tg_s_b|tg_s_b_via__t02
+ a|b|inv_q_a|inv_q_a_via|s|tg_fbs_b|tg_fbs_b_via|tg_s_b|tg_s_b_via$1
+ 65.5799158739
* device instance a_b_inv_q_a_inv_q_a_via_s_tg_fbs_b_tg_fbs_b_via_tg_s_b_tg_s_b_via_dup1_t1 r0 *1 0,0
Ra_b_inv_q_a_inv_q_a_via_s_tg_fbs_b_tg_fbs_b_via_tg_s_b_tg_s_b_via_dup1_t1
+ a|b|inv_q_a|inv_q_a_via|s|tg_fbs_b|tg_fbs_b_via|tg_s_b|tg_s_b_via__t12
+ a|b|inv_q_a|inv_q_a_via|s|tg_fbs_b|tg_fbs_b_via|tg_s_b|tg_s_b_via$1
+ 65.5799158739
* device instance a_b_inv_q_a_inv_q_a_via_s_tg_fbs_b_tg_fbs_b_via_tg_s_b_tg_s_b_via_dup1_t2 r0 *1 0,0
Ra_b_inv_q_a_inv_q_a_via_s_tg_fbs_b_tg_fbs_b_via_tg_s_b_tg_s_b_via_dup1_t2
+ a|b|inv_q_a|inv_q_a_via|s|tg_fbs_b|tg_fbs_b_via|tg_s_b|tg_s_b_via__t22
+ a|b|inv_q_a|inv_q_a_via|s|tg_fbs_b|tg_fbs_b_via|tg_s_b|tg_s_b_via$1
+ 279.22177483
* device instance a_b_inv_q_a_inv_q_a_via_s_tg_fbs_b_tg_fbs_b_via_tg_s_b_tg_s_b_via_dup1_t3 r0 *1 0,0
Ra_b_inv_q_a_inv_q_a_via_s_tg_fbs_b_tg_fbs_b_via_tg_s_b_tg_s_b_via_dup1_t3
+ a|b|inv_q_a|inv_q_a_via|s|tg_fbs_b|tg_fbs_b_via|tg_s_b|tg_s_b_via__t32
+ a|b|inv_q_a|inv_q_a_via|s|tg_fbs_b|tg_fbs_b_via|tg_s_b|tg_s_b_via$1
+ 230.632009296
* device instance a_b_inv_q_a_inv_q_a_via_s_tg_fbs_b_tg_fbs_b_via_tg_s_b_tg_s_b_via_dup1_t4 r0 *1 0,0
Ra_b_inv_q_a_inv_q_a_via_s_tg_fbs_b_tg_fbs_b_via_tg_s_b_tg_s_b_via_dup1_t4
+ a|b|inv_q_a|inv_q_a_via|s|tg_fbs_b|tg_fbs_b_via|tg_s_b|tg_s_b_via__t42
+ a|b|inv_q_a|inv_q_a_via|s|tg_fbs_b|tg_fbs_b_via|tg_s_b|tg_s_b_via$1
+ 279.22177483
* device instance a_b_inv_q_a_inv_q_a_via_s_tg_fbs_b_tg_fbs_b_via_tg_s_b_tg_s_b_via_dup1_t5 r0 *1 0,0
Ra_b_inv_q_a_inv_q_a_via_s_tg_fbs_b_tg_fbs_b_via_tg_s_b_tg_s_b_via_dup1_t5
+ a|b|inv_q_a|inv_q_a_via|s|tg_fbs_b|tg_fbs_b_via|tg_s_b|tg_s_b_via__t52
+ a|b|inv_q_a|inv_q_a_via|s|tg_fbs_b|tg_fbs_b_via|tg_s_b|tg_s_b_via$1
+ 230.632009296
* device instance a_b_inv_q_a_inv_q_a_via_s_tg_fbs_b_tg_fbs_b_via_tg_s_b_tg_s_b_via_dup1 r0 *1 0,0
Ca_b_inv_q_a_inv_q_a_via_s_tg_fbs_b_tg_fbs_b_via_tg_s_b_tg_s_b_via_dup1
+ a|b|inv_q_a|inv_q_a_via|s|tg_fbs_b|tg_fbs_b_via|tg_s_b|tg_s_b_via$1 vsubs
+ 3.962997e-15
* device instance a_b_inv_q_a_inv_q_a_via_s_tg_fbs_b_tg_fbs_b_via_tg_s_b_tg_s_b_via_dup2_t0 r0 *1 0,0
Ra_b_inv_q_a_inv_q_a_via_s_tg_fbs_b_tg_fbs_b_via_tg_s_b_tg_s_b_via_dup2_t0
+ a|b|inv_q_a|inv_q_a_via|s|tg_fbs_b|tg_fbs_b_via|tg_s_b|tg_s_b_via__t03
+ a|b|inv_q_a|inv_q_a_via|s|tg_fbs_b|tg_fbs_b_via|tg_s_b|tg_s_b_via$2
+ 65.5799158739
* device instance a_b_inv_q_a_inv_q_a_via_s_tg_fbs_b_tg_fbs_b_via_tg_s_b_tg_s_b_via_dup2_t1 r0 *1 0,0
Ra_b_inv_q_a_inv_q_a_via_s_tg_fbs_b_tg_fbs_b_via_tg_s_b_tg_s_b_via_dup2_t1
+ a|b|inv_q_a|inv_q_a_via|s|tg_fbs_b|tg_fbs_b_via|tg_s_b|tg_s_b_via__t13
+ a|b|inv_q_a|inv_q_a_via|s|tg_fbs_b|tg_fbs_b_via|tg_s_b|tg_s_b_via$2
+ 65.5799158739
* device instance a_b_inv_q_a_inv_q_a_via_s_tg_fbs_b_tg_fbs_b_via_tg_s_b_tg_s_b_via_dup2_t2 r0 *1 0,0
Ra_b_inv_q_a_inv_q_a_via_s_tg_fbs_b_tg_fbs_b_via_tg_s_b_tg_s_b_via_dup2_t2
+ a|b|inv_q_a|inv_q_a_via|s|tg_fbs_b|tg_fbs_b_via|tg_s_b|tg_s_b_via__t23
+ a|b|inv_q_a|inv_q_a_via|s|tg_fbs_b|tg_fbs_b_via|tg_s_b|tg_s_b_via$2
+ 279.22177483
* device instance a_b_inv_q_a_inv_q_a_via_s_tg_fbs_b_tg_fbs_b_via_tg_s_b_tg_s_b_via_dup2_t3 r0 *1 0,0
Ra_b_inv_q_a_inv_q_a_via_s_tg_fbs_b_tg_fbs_b_via_tg_s_b_tg_s_b_via_dup2_t3
+ a|b|inv_q_a|inv_q_a_via|s|tg_fbs_b|tg_fbs_b_via|tg_s_b|tg_s_b_via__t33
+ a|b|inv_q_a|inv_q_a_via|s|tg_fbs_b|tg_fbs_b_via|tg_s_b|tg_s_b_via$2
+ 230.632009296
* device instance a_b_inv_q_a_inv_q_a_via_s_tg_fbs_b_tg_fbs_b_via_tg_s_b_tg_s_b_via_dup2_t4 r0 *1 0,0
Ra_b_inv_q_a_inv_q_a_via_s_tg_fbs_b_tg_fbs_b_via_tg_s_b_tg_s_b_via_dup2_t4
+ a|b|inv_q_a|inv_q_a_via|s|tg_fbs_b|tg_fbs_b_via|tg_s_b|tg_s_b_via__t43
+ a|b|inv_q_a|inv_q_a_via|s|tg_fbs_b|tg_fbs_b_via|tg_s_b|tg_s_b_via$2
+ 279.22177483
* device instance a_b_inv_q_a_inv_q_a_via_s_tg_fbs_b_tg_fbs_b_via_tg_s_b_tg_s_b_via_dup2_t5 r0 *1 0,0
Ra_b_inv_q_a_inv_q_a_via_s_tg_fbs_b_tg_fbs_b_via_tg_s_b_tg_s_b_via_dup2_t5
+ a|b|inv_q_a|inv_q_a_via|s|tg_fbs_b|tg_fbs_b_via|tg_s_b|tg_s_b_via__t53
+ a|b|inv_q_a|inv_q_a_via|s|tg_fbs_b|tg_fbs_b_via|tg_s_b|tg_s_b_via$2
+ 230.632009296
* device instance a_b_inv_q_a_inv_q_a_via_s_tg_fbs_b_tg_fbs_b_via_tg_s_b_tg_s_b_via_dup2 r0 *1 0,0
Ca_b_inv_q_a_inv_q_a_via_s_tg_fbs_b_tg_fbs_b_via_tg_s_b_tg_s_b_via_dup2
+ a|b|inv_q_a|inv_q_a_via|s|tg_fbs_b|tg_fbs_b_via|tg_s_b|tg_s_b_via$2 vsubs
+ 3.962997e-15
* device instance a_b_inv_q_a_inv_q_a_via_s_tg_fbs_b_tg_fbs_b_via_tg_s_b_tg_s_b_via_dup3_t0 r0 *1 0,0
Ra_b_inv_q_a_inv_q_a_via_s_tg_fbs_b_tg_fbs_b_via_tg_s_b_tg_s_b_via_dup3_t0
+ a|b|inv_q_a|inv_q_a_via|s|tg_fbs_b|tg_fbs_b_via|tg_s_b|tg_s_b_via__t04
+ a|b|inv_q_a|inv_q_a_via|s|tg_fbs_b|tg_fbs_b_via|tg_s_b|tg_s_b_via$3
+ 65.5799158739
* device instance a_b_inv_q_a_inv_q_a_via_s_tg_fbs_b_tg_fbs_b_via_tg_s_b_tg_s_b_via_dup3_t1 r0 *1 0,0
Ra_b_inv_q_a_inv_q_a_via_s_tg_fbs_b_tg_fbs_b_via_tg_s_b_tg_s_b_via_dup3_t1
+ a|b|inv_q_a|inv_q_a_via|s|tg_fbs_b|tg_fbs_b_via|tg_s_b|tg_s_b_via__t14
+ a|b|inv_q_a|inv_q_a_via|s|tg_fbs_b|tg_fbs_b_via|tg_s_b|tg_s_b_via$3
+ 65.5799158739
* device instance a_b_inv_q_a_inv_q_a_via_s_tg_fbs_b_tg_fbs_b_via_tg_s_b_tg_s_b_via_dup3_t2 r0 *1 0,0
Ra_b_inv_q_a_inv_q_a_via_s_tg_fbs_b_tg_fbs_b_via_tg_s_b_tg_s_b_via_dup3_t2
+ a|b|inv_q_a|inv_q_a_via|s|tg_fbs_b|tg_fbs_b_via|tg_s_b|tg_s_b_via__t24
+ a|b|inv_q_a|inv_q_a_via|s|tg_fbs_b|tg_fbs_b_via|tg_s_b|tg_s_b_via$3
+ 279.22177483
* device instance a_b_inv_q_a_inv_q_a_via_s_tg_fbs_b_tg_fbs_b_via_tg_s_b_tg_s_b_via_dup3_t3 r0 *1 0,0
Ra_b_inv_q_a_inv_q_a_via_s_tg_fbs_b_tg_fbs_b_via_tg_s_b_tg_s_b_via_dup3_t3
+ a|b|inv_q_a|inv_q_a_via|s|tg_fbs_b|tg_fbs_b_via|tg_s_b|tg_s_b_via__t34
+ a|b|inv_q_a|inv_q_a_via|s|tg_fbs_b|tg_fbs_b_via|tg_s_b|tg_s_b_via$3
+ 230.632009296
* device instance a_b_inv_q_a_inv_q_a_via_s_tg_fbs_b_tg_fbs_b_via_tg_s_b_tg_s_b_via_dup3_t4 r0 *1 0,0
Ra_b_inv_q_a_inv_q_a_via_s_tg_fbs_b_tg_fbs_b_via_tg_s_b_tg_s_b_via_dup3_t4
+ a|b|inv_q_a|inv_q_a_via|s|tg_fbs_b|tg_fbs_b_via|tg_s_b|tg_s_b_via__t44
+ a|b|inv_q_a|inv_q_a_via|s|tg_fbs_b|tg_fbs_b_via|tg_s_b|tg_s_b_via$3
+ 279.22177483
* device instance a_b_inv_q_a_inv_q_a_via_s_tg_fbs_b_tg_fbs_b_via_tg_s_b_tg_s_b_via_dup3_t5 r0 *1 0,0
Ra_b_inv_q_a_inv_q_a_via_s_tg_fbs_b_tg_fbs_b_via_tg_s_b_tg_s_b_via_dup3_t5
+ a|b|inv_q_a|inv_q_a_via|s|tg_fbs_b|tg_fbs_b_via|tg_s_b|tg_s_b_via__t54
+ a|b|inv_q_a|inv_q_a_via|s|tg_fbs_b|tg_fbs_b_via|tg_s_b|tg_s_b_via$3
+ 230.632009296
* device instance a_b_inv_q_a_inv_q_a_via_s_tg_fbs_b_tg_fbs_b_via_tg_s_b_tg_s_b_via_dup3 r0 *1 0,0
Ca_b_inv_q_a_inv_q_a_via_s_tg_fbs_b_tg_fbs_b_via_tg_s_b_tg_s_b_via_dup3
+ a|b|inv_q_a|inv_q_a_via|s|tg_fbs_b|tg_fbs_b_via|tg_s_b|tg_s_b_via$3 vsubs
+ 3.962997e-15
* device instance a_b_inv_q_a_inv_q_a_via_s_tg_fbs_b_tg_fbs_b_via_tg_s_b_tg_s_b_via_dup4_t0 r0 *1 0,0
Ra_b_inv_q_a_inv_q_a_via_s_tg_fbs_b_tg_fbs_b_via_tg_s_b_tg_s_b_via_dup4_t0
+ a|b|inv_q_a|inv_q_a_via|s|tg_fbs_b|tg_fbs_b_via|tg_s_b|tg_s_b_via__t05
+ a|b|inv_q_a|inv_q_a_via|s|tg_fbs_b|tg_fbs_b_via|tg_s_b|tg_s_b_via$4
+ 65.5799158739
* device instance a_b_inv_q_a_inv_q_a_via_s_tg_fbs_b_tg_fbs_b_via_tg_s_b_tg_s_b_via_dup4_t1 r0 *1 0,0
Ra_b_inv_q_a_inv_q_a_via_s_tg_fbs_b_tg_fbs_b_via_tg_s_b_tg_s_b_via_dup4_t1
+ a|b|inv_q_a|inv_q_a_via|s|tg_fbs_b|tg_fbs_b_via|tg_s_b|tg_s_b_via__t15
+ a|b|inv_q_a|inv_q_a_via|s|tg_fbs_b|tg_fbs_b_via|tg_s_b|tg_s_b_via$4
+ 65.5799158739
* device instance a_b_inv_q_a_inv_q_a_via_s_tg_fbs_b_tg_fbs_b_via_tg_s_b_tg_s_b_via_dup4_t2 r0 *1 0,0
Ra_b_inv_q_a_inv_q_a_via_s_tg_fbs_b_tg_fbs_b_via_tg_s_b_tg_s_b_via_dup4_t2
+ a|b|inv_q_a|inv_q_a_via|s|tg_fbs_b|tg_fbs_b_via|tg_s_b|tg_s_b_via__t25
+ a|b|inv_q_a|inv_q_a_via|s|tg_fbs_b|tg_fbs_b_via|tg_s_b|tg_s_b_via$4
+ 230.632009296
* device instance a_b_inv_q_a_inv_q_a_via_s_tg_fbs_b_tg_fbs_b_via_tg_s_b_tg_s_b_via_dup4_t3 r0 *1 0,0
Ra_b_inv_q_a_inv_q_a_via_s_tg_fbs_b_tg_fbs_b_via_tg_s_b_tg_s_b_via_dup4_t3
+ a|b|inv_q_a|inv_q_a_via|s|tg_fbs_b|tg_fbs_b_via|tg_s_b|tg_s_b_via__t35
+ a|b|inv_q_a|inv_q_a_via|s|tg_fbs_b|tg_fbs_b_via|tg_s_b|tg_s_b_via$4
+ 279.22177483
* device instance a_b_inv_q_a_inv_q_a_via_s_tg_fbs_b_tg_fbs_b_via_tg_s_b_tg_s_b_via_dup4_t4 r0 *1 0,0
Ra_b_inv_q_a_inv_q_a_via_s_tg_fbs_b_tg_fbs_b_via_tg_s_b_tg_s_b_via_dup4_t4
+ a|b|inv_q_a|inv_q_a_via|s|tg_fbs_b|tg_fbs_b_via|tg_s_b|tg_s_b_via__t45
+ a|b|inv_q_a|inv_q_a_via|s|tg_fbs_b|tg_fbs_b_via|tg_s_b|tg_s_b_via$4
+ 230.632009296
* device instance a_b_inv_q_a_inv_q_a_via_s_tg_fbs_b_tg_fbs_b_via_tg_s_b_tg_s_b_via_dup4_t5 r0 *1 0,0
Ra_b_inv_q_a_inv_q_a_via_s_tg_fbs_b_tg_fbs_b_via_tg_s_b_tg_s_b_via_dup4_t5
+ a|b|inv_q_a|inv_q_a_via|s|tg_fbs_b|tg_fbs_b_via|tg_s_b|tg_s_b_via__t55
+ a|b|inv_q_a|inv_q_a_via|s|tg_fbs_b|tg_fbs_b_via|tg_s_b|tg_s_b_via$4
+ 279.22177483
* device instance a_b_inv_q_a_inv_q_a_via_s_tg_fbs_b_tg_fbs_b_via_tg_s_b_tg_s_b_via_dup4 r0 *1 0,0
Ca_b_inv_q_a_inv_q_a_via_s_tg_fbs_b_tg_fbs_b_via_tg_s_b_tg_s_b_via_dup4
+ a|b|inv_q_a|inv_q_a_via|s|tg_fbs_b|tg_fbs_b_via|tg_s_b|tg_s_b_via$4 vsubs
+ 3.962997e-15
* device instance a_b_inv_q_a_inv_q_a_via_s_tg_fbs_b_tg_fbs_b_via_tg_s_b_tg_s_b_via_dup5_t0 r0 *1 0,0
Ra_b_inv_q_a_inv_q_a_via_s_tg_fbs_b_tg_fbs_b_via_tg_s_b_tg_s_b_via_dup5_t0
+ a|b|inv_q_a|inv_q_a_via|s|tg_fbs_b|tg_fbs_b_via|tg_s_b|tg_s_b_via__t06
+ a|b|inv_q_a|inv_q_a_via|s|tg_fbs_b|tg_fbs_b_via|tg_s_b|tg_s_b_via$5
+ 65.5799158739
* device instance a_b_inv_q_a_inv_q_a_via_s_tg_fbs_b_tg_fbs_b_via_tg_s_b_tg_s_b_via_dup5_t1 r0 *1 0,0
Ra_b_inv_q_a_inv_q_a_via_s_tg_fbs_b_tg_fbs_b_via_tg_s_b_tg_s_b_via_dup5_t1
+ a|b|inv_q_a|inv_q_a_via|s|tg_fbs_b|tg_fbs_b_via|tg_s_b|tg_s_b_via__t16
+ a|b|inv_q_a|inv_q_a_via|s|tg_fbs_b|tg_fbs_b_via|tg_s_b|tg_s_b_via$5
+ 65.5799158739
* device instance a_b_inv_q_a_inv_q_a_via_s_tg_fbs_b_tg_fbs_b_via_tg_s_b_tg_s_b_via_dup5_t2 r0 *1 0,0
Ra_b_inv_q_a_inv_q_a_via_s_tg_fbs_b_tg_fbs_b_via_tg_s_b_tg_s_b_via_dup5_t2
+ a|b|inv_q_a|inv_q_a_via|s|tg_fbs_b|tg_fbs_b_via|tg_s_b|tg_s_b_via__t26
+ a|b|inv_q_a|inv_q_a_via|s|tg_fbs_b|tg_fbs_b_via|tg_s_b|tg_s_b_via$5
+ 279.22177483
* device instance a_b_inv_q_a_inv_q_a_via_s_tg_fbs_b_tg_fbs_b_via_tg_s_b_tg_s_b_via_dup5_t3 r0 *1 0,0
Ra_b_inv_q_a_inv_q_a_via_s_tg_fbs_b_tg_fbs_b_via_tg_s_b_tg_s_b_via_dup5_t3
+ a|b|inv_q_a|inv_q_a_via|s|tg_fbs_b|tg_fbs_b_via|tg_s_b|tg_s_b_via__t36
+ a|b|inv_q_a|inv_q_a_via|s|tg_fbs_b|tg_fbs_b_via|tg_s_b|tg_s_b_via$5
+ 230.632009296
* device instance a_b_inv_q_a_inv_q_a_via_s_tg_fbs_b_tg_fbs_b_via_tg_s_b_tg_s_b_via_dup5_t4 r0 *1 0,0
Ra_b_inv_q_a_inv_q_a_via_s_tg_fbs_b_tg_fbs_b_via_tg_s_b_tg_s_b_via_dup5_t4
+ a|b|inv_q_a|inv_q_a_via|s|tg_fbs_b|tg_fbs_b_via|tg_s_b|tg_s_b_via__t46
+ a|b|inv_q_a|inv_q_a_via|s|tg_fbs_b|tg_fbs_b_via|tg_s_b|tg_s_b_via$5
+ 230.632009296
* device instance a_b_inv_q_a_inv_q_a_via_s_tg_fbs_b_tg_fbs_b_via_tg_s_b_tg_s_b_via_dup5_t5 r0 *1 0,0
Ra_b_inv_q_a_inv_q_a_via_s_tg_fbs_b_tg_fbs_b_via_tg_s_b_tg_s_b_via_dup5_t5
+ a|b|inv_q_a|inv_q_a_via|s|tg_fbs_b|tg_fbs_b_via|tg_s_b|tg_s_b_via__t56
+ a|b|inv_q_a|inv_q_a_via|s|tg_fbs_b|tg_fbs_b_via|tg_s_b|tg_s_b_via$5
+ 279.22177483
* device instance a_b_inv_q_a_inv_q_a_via_s_tg_fbs_b_tg_fbs_b_via_tg_s_b_tg_s_b_via_dup5 r0 *1 0,0
Ca_b_inv_q_a_inv_q_a_via_s_tg_fbs_b_tg_fbs_b_via_tg_s_b_tg_s_b_via_dup5
+ a|b|inv_q_a|inv_q_a_via|s|tg_fbs_b|tg_fbs_b_via|tg_s_b|tg_s_b_via$5 vsubs
+ 3.962997e-15
* device instance a_b_m_east_m_west_nand_m_a_nand_m_a_ext_via_nand_m_a_ext_via2_nand_m_a_stub_tg_d_b_tg_d_b_via_tg_d_b_via2_tg_fbm_b_tg_fbm_b_alt_via_tg_fbm_b_alt_via2_t0 r0 *1 0,0
Ra_b_m_east_m_west_nand_m_a_nand_m_a_ext_via_nand_m_a_ext_via2_nand_m_a_stub_tg_d_b_tg_d_b_via_tg_d_b_via2_tg_fbm_b_tg_fbm_b_alt_via_tg_fbm_b_alt_via2_t0
+ a|b|m_east|m_west|nand_m_a|nand_m_a_ext_via|nand_m_a_ext_via2|nand_m_a_stub|tg_d_b|tg_d_b_via|tg_d_b_via2|tg_fbm_b|tg_fbm_b_alt_via|tg_fbm_b_alt_via2__t0
+ a|b|m_east|m_west|nand_m_a|nand_m_a_ext_via|nand_m_a_ext_via2|nand_m_a_stub|tg_d_b|tg_d_b_via|tg_d_b_via2|tg_fbm_b|tg_fbm_b_alt_via|tg_fbm_b_alt_via2
+ 68.7741894738
* device instance a_b_m_east_m_west_nand_m_a_nand_m_a_ext_via_nand_m_a_ext_via2_nand_m_a_stub_tg_d_b_tg_d_b_via_tg_d_b_via2_tg_fbm_b_tg_fbm_b_alt_via_tg_fbm_b_alt_via2_t1 r0 *1 0,0
Ra_b_m_east_m_west_nand_m_a_nand_m_a_ext_via_nand_m_a_ext_via2_nand_m_a_stub_tg_d_b_tg_d_b_via_tg_d_b_via2_tg_fbm_b_tg_fbm_b_alt_via_tg_fbm_b_alt_via2_t1
+ a|b|m_east|m_west|nand_m_a|nand_m_a_ext_via|nand_m_a_ext_via2|nand_m_a_stub|tg_d_b|tg_d_b_via|tg_d_b_via2|tg_fbm_b|tg_fbm_b_alt_via|tg_fbm_b_alt_via2__t1
+ a|b|m_east|m_west|nand_m_a|nand_m_a_ext_via|nand_m_a_ext_via2|nand_m_a_stub|tg_d_b|tg_d_b_via|tg_d_b_via2|tg_fbm_b|tg_fbm_b_alt_via|tg_fbm_b_alt_via2
+ 262.615776106
* device instance a_b_m_east_m_west_nand_m_a_nand_m_a_ext_via_nand_m_a_ext_via2_nand_m_a_stub_tg_d_b_tg_d_b_via_tg_d_b_via2_tg_fbm_b_tg_fbm_b_alt_via_tg_fbm_b_alt_via2_t2 r0 *1 0,0
Ra_b_m_east_m_west_nand_m_a_nand_m_a_ext_via_nand_m_a_ext_via2_nand_m_a_stub_tg_d_b_tg_d_b_via_tg_d_b_via2_tg_fbm_b_tg_fbm_b_alt_via_tg_fbm_b_alt_via2_t2
+ a|b|m_east|m_west|nand_m_a|nand_m_a_ext_via|nand_m_a_ext_via2|nand_m_a_stub|tg_d_b|tg_d_b_via|tg_d_b_via2|tg_fbm_b|tg_fbm_b_alt_via|tg_fbm_b_alt_via2__t2
+ a|b|m_east|m_west|nand_m_a|nand_m_a_ext_via|nand_m_a_ext_via2|nand_m_a_stub|tg_d_b|tg_d_b_via|tg_d_b_via2|tg_fbm_b|tg_fbm_b_alt_via|tg_fbm_b_alt_via2
+ 292.98458946
* device instance a_b_m_east_m_west_nand_m_a_nand_m_a_ext_via_nand_m_a_ext_via2_nand_m_a_stub_tg_d_b_tg_d_b_via_tg_d_b_via2_tg_fbm_b_tg_fbm_b_alt_via_tg_fbm_b_alt_via2_t3 r0 *1 0,0
Ra_b_m_east_m_west_nand_m_a_nand_m_a_ext_via_nand_m_a_ext_via2_nand_m_a_stub_tg_d_b_tg_d_b_via_tg_d_b_via2_tg_fbm_b_tg_fbm_b_alt_via_tg_fbm_b_alt_via2_t3
+ a|b|m_east|m_west|nand_m_a|nand_m_a_ext_via|nand_m_a_ext_via2|nand_m_a_stub|tg_d_b|tg_d_b_via|tg_d_b_via2|tg_fbm_b|tg_fbm_b_alt_via|tg_fbm_b_alt_via2__t3
+ a|b|m_east|m_west|nand_m_a|nand_m_a_ext_via|nand_m_a_ext_via2|nand_m_a_stub|tg_d_b|tg_d_b_via|tg_d_b_via2|tg_fbm_b|tg_fbm_b_alt_via|tg_fbm_b_alt_via2
+ 261.497453093
* device instance a_b_m_east_m_west_nand_m_a_nand_m_a_ext_via_nand_m_a_ext_via2_nand_m_a_stub_tg_d_b_tg_d_b_via_tg_d_b_via2_tg_fbm_b_tg_fbm_b_alt_via_tg_fbm_b_alt_via2_t4 r0 *1 0,0
Ra_b_m_east_m_west_nand_m_a_nand_m_a_ext_via_nand_m_a_ext_via2_nand_m_a_stub_tg_d_b_tg_d_b_via_tg_d_b_via2_tg_fbm_b_tg_fbm_b_alt_via_tg_fbm_b_alt_via2_t4
+ a|b|m_east|m_west|nand_m_a|nand_m_a_ext_via|nand_m_a_ext_via2|nand_m_a_stub|tg_d_b|tg_d_b_via|tg_d_b_via2|tg_fbm_b|tg_fbm_b_alt_via|tg_fbm_b_alt_via2__t4
+ a|b|m_east|m_west|nand_m_a|nand_m_a_ext_via|nand_m_a_ext_via2|nand_m_a_stub|tg_d_b|tg_d_b_via|tg_d_b_via2|tg_fbm_b|tg_fbm_b_alt_via|tg_fbm_b_alt_via2
+ 291.982605261
* device instance a_b_m_east_m_west_nand_m_a_nand_m_a_ext_via_nand_m_a_ext_via2_nand_m_a_stub_tg_d_b_tg_d_b_via_tg_d_b_via2_tg_fbm_b_tg_fbm_b_alt_via_tg_fbm_b_alt_via2_t5 r0 *1 0,0
Ra_b_m_east_m_west_nand_m_a_nand_m_a_ext_via_nand_m_a_ext_via2_nand_m_a_stub_tg_d_b_tg_d_b_via_tg_d_b_via2_tg_fbm_b_tg_fbm_b_alt_via_tg_fbm_b_alt_via2_t5
+ a|b|m_east|m_west|nand_m_a|nand_m_a_ext_via|nand_m_a_ext_via2|nand_m_a_stub|tg_d_b|tg_d_b_via|tg_d_b_via2|tg_fbm_b|tg_fbm_b_alt_via|tg_fbm_b_alt_via2__t5
+ a|b|m_east|m_west|nand_m_a|nand_m_a_ext_via|nand_m_a_ext_via2|nand_m_a_stub|tg_d_b|tg_d_b_via|tg_d_b_via2|tg_fbm_b|tg_fbm_b_alt_via|tg_fbm_b_alt_via2
+ 60.1829866055
* device instance a_b_m_east_m_west_nand_m_a_nand_m_a_ext_via_nand_m_a_ext_via2_nand_m_a_stub_tg_d_b_tg_d_b_via_tg_d_b_via2_tg_fbm_b_tg_fbm_b_alt_via_tg_fbm_b_alt_via2 r0 *1 0,0
Ca_b_m_east_m_west_nand_m_a_nand_m_a_ext_via_nand_m_a_ext_via2_nand_m_a_stub_tg_d_b_tg_d_b_via_tg_d_b_via2_tg_fbm_b_tg_fbm_b_alt_via_tg_fbm_b_alt_via2
+ a|b|m_east|m_west|nand_m_a|nand_m_a_ext_via|nand_m_a_ext_via2|nand_m_a_stub|tg_d_b|tg_d_b_via|tg_d_b_via2|tg_fbm_b|tg_fbm_b_alt_via|tg_fbm_b_alt_via2
+ vsubs 3.895867e-15
* device instance a_b_m_east_m_west_nand_m_a_nand_m_a_ext_via_nand_m_a_ext_via2_nand_m_a_stub_tg_d_b_tg_d_b_via_tg_d_b_via2_tg_fbm_b_tg_fbm_b_alt_via_tg_fbm_b_alt_via2_dup1_t0 r0 *1 0,0
Ra_b_m_east_m_west_nand_m_a_nand_m_a_ext_via_nand_m_a_ext_via2_nand_m_a_stub_tg_d_b_tg_d_b_via_tg_d_b_via2_tg_fbm_b_tg_fbm_b_alt_via_tg_fbm_b_alt_via2_dup1_t0
+ a|b|m_east|m_west|nand_m_a|nand_m_a_ext_via|nand_m_a_ext_via2|nand_m_a_stub|tg_d_b|tg_d_b_via|tg_d_b_via2|tg_fbm_b|tg_fbm_b_alt_via|tg_fbm_b_alt_via2__t02
+ a|b|m_east|m_west|nand_m_a|nand_m_a_ext_via|nand_m_a_ext_via2|nand_m_a_stub|tg_d_b|tg_d_b_via|tg_d_b_via2|tg_fbm_b|tg_fbm_b_alt_via|tg_fbm_b_alt_via2$1
+ 60.1829866055
* device instance a_b_m_east_m_west_nand_m_a_nand_m_a_ext_via_nand_m_a_ext_via2_nand_m_a_stub_tg_d_b_tg_d_b_via_tg_d_b_via2_tg_fbm_b_tg_fbm_b_alt_via_tg_fbm_b_alt_via2_dup1_t1 r0 *1 0,0
Ra_b_m_east_m_west_nand_m_a_nand_m_a_ext_via_nand_m_a_ext_via2_nand_m_a_stub_tg_d_b_tg_d_b_via_tg_d_b_via2_tg_fbm_b_tg_fbm_b_alt_via_tg_fbm_b_alt_via2_dup1_t1
+ a|b|m_east|m_west|nand_m_a|nand_m_a_ext_via|nand_m_a_ext_via2|nand_m_a_stub|tg_d_b|tg_d_b_via|tg_d_b_via2|tg_fbm_b|tg_fbm_b_alt_via|tg_fbm_b_alt_via2__t12
+ a|b|m_east|m_west|nand_m_a|nand_m_a_ext_via|nand_m_a_ext_via2|nand_m_a_stub|tg_d_b|tg_d_b_via|tg_d_b_via2|tg_fbm_b|tg_fbm_b_alt_via|tg_fbm_b_alt_via2$1
+ 68.7741894738
* device instance a_b_m_east_m_west_nand_m_a_nand_m_a_ext_via_nand_m_a_ext_via2_nand_m_a_stub_tg_d_b_tg_d_b_via_tg_d_b_via2_tg_fbm_b_tg_fbm_b_alt_via_tg_fbm_b_alt_via2_dup1_t2 r0 *1 0,0
Ra_b_m_east_m_west_nand_m_a_nand_m_a_ext_via_nand_m_a_ext_via2_nand_m_a_stub_tg_d_b_tg_d_b_via_tg_d_b_via2_tg_fbm_b_tg_fbm_b_alt_via_tg_fbm_b_alt_via2_dup1_t2
+ a|b|m_east|m_west|nand_m_a|nand_m_a_ext_via|nand_m_a_ext_via2|nand_m_a_stub|tg_d_b|tg_d_b_via|tg_d_b_via2|tg_fbm_b|tg_fbm_b_alt_via|tg_fbm_b_alt_via2__t22
+ a|b|m_east|m_west|nand_m_a|nand_m_a_ext_via|nand_m_a_ext_via2|nand_m_a_stub|tg_d_b|tg_d_b_via|tg_d_b_via2|tg_fbm_b|tg_fbm_b_alt_via|tg_fbm_b_alt_via2$1
+ 262.615776106
* device instance a_b_m_east_m_west_nand_m_a_nand_m_a_ext_via_nand_m_a_ext_via2_nand_m_a_stub_tg_d_b_tg_d_b_via_tg_d_b_via2_tg_fbm_b_tg_fbm_b_alt_via_tg_fbm_b_alt_via2_dup1_t3 r0 *1 0,0
Ra_b_m_east_m_west_nand_m_a_nand_m_a_ext_via_nand_m_a_ext_via2_nand_m_a_stub_tg_d_b_tg_d_b_via_tg_d_b_via2_tg_fbm_b_tg_fbm_b_alt_via_tg_fbm_b_alt_via2_dup1_t3
+ a|b|m_east|m_west|nand_m_a|nand_m_a_ext_via|nand_m_a_ext_via2|nand_m_a_stub|tg_d_b|tg_d_b_via|tg_d_b_via2|tg_fbm_b|tg_fbm_b_alt_via|tg_fbm_b_alt_via2__t32
+ a|b|m_east|m_west|nand_m_a|nand_m_a_ext_via|nand_m_a_ext_via2|nand_m_a_stub|tg_d_b|tg_d_b_via|tg_d_b_via2|tg_fbm_b|tg_fbm_b_alt_via|tg_fbm_b_alt_via2$1
+ 292.98458946
* device instance a_b_m_east_m_west_nand_m_a_nand_m_a_ext_via_nand_m_a_ext_via2_nand_m_a_stub_tg_d_b_tg_d_b_via_tg_d_b_via2_tg_fbm_b_tg_fbm_b_alt_via_tg_fbm_b_alt_via2_dup1_t4 r0 *1 0,0
Ra_b_m_east_m_west_nand_m_a_nand_m_a_ext_via_nand_m_a_ext_via2_nand_m_a_stub_tg_d_b_tg_d_b_via_tg_d_b_via2_tg_fbm_b_tg_fbm_b_alt_via_tg_fbm_b_alt_via2_dup1_t4
+ a|b|m_east|m_west|nand_m_a|nand_m_a_ext_via|nand_m_a_ext_via2|nand_m_a_stub|tg_d_b|tg_d_b_via|tg_d_b_via2|tg_fbm_b|tg_fbm_b_alt_via|tg_fbm_b_alt_via2__t42
+ a|b|m_east|m_west|nand_m_a|nand_m_a_ext_via|nand_m_a_ext_via2|nand_m_a_stub|tg_d_b|tg_d_b_via|tg_d_b_via2|tg_fbm_b|tg_fbm_b_alt_via|tg_fbm_b_alt_via2$1
+ 261.497453093
* device instance a_b_m_east_m_west_nand_m_a_nand_m_a_ext_via_nand_m_a_ext_via2_nand_m_a_stub_tg_d_b_tg_d_b_via_tg_d_b_via2_tg_fbm_b_tg_fbm_b_alt_via_tg_fbm_b_alt_via2_dup1_t5 r0 *1 0,0
Ra_b_m_east_m_west_nand_m_a_nand_m_a_ext_via_nand_m_a_ext_via2_nand_m_a_stub_tg_d_b_tg_d_b_via_tg_d_b_via2_tg_fbm_b_tg_fbm_b_alt_via_tg_fbm_b_alt_via2_dup1_t5
+ a|b|m_east|m_west|nand_m_a|nand_m_a_ext_via|nand_m_a_ext_via2|nand_m_a_stub|tg_d_b|tg_d_b_via|tg_d_b_via2|tg_fbm_b|tg_fbm_b_alt_via|tg_fbm_b_alt_via2__t52
+ a|b|m_east|m_west|nand_m_a|nand_m_a_ext_via|nand_m_a_ext_via2|nand_m_a_stub|tg_d_b|tg_d_b_via|tg_d_b_via2|tg_fbm_b|tg_fbm_b_alt_via|tg_fbm_b_alt_via2$1
+ 291.982605261
* device instance a_b_m_east_m_west_nand_m_a_nand_m_a_ext_via_nand_m_a_ext_via2_nand_m_a_stub_tg_d_b_tg_d_b_via_tg_d_b_via2_tg_fbm_b_tg_fbm_b_alt_via_tg_fbm_b_alt_via2_dup1 r0 *1 0,0
Ca_b_m_east_m_west_nand_m_a_nand_m_a_ext_via_nand_m_a_ext_via2_nand_m_a_stub_tg_d_b_tg_d_b_via_tg_d_b_via2_tg_fbm_b_tg_fbm_b_alt_via_tg_fbm_b_alt_via2_dup1
+ a|b|m_east|m_west|nand_m_a|nand_m_a_ext_via|nand_m_a_ext_via2|nand_m_a_stub|tg_d_b|tg_d_b_via|tg_d_b_via2|tg_fbm_b|tg_fbm_b_alt_via|tg_fbm_b_alt_via2$1
+ vsubs 3.895867e-15
* device instance a_b_m_east_m_west_nand_m_a_nand_m_a_ext_via_nand_m_a_ext_via2_nand_m_a_stub_tg_d_b_tg_d_b_via_tg_d_b_via2_tg_fbm_b_tg_fbm_b_alt_via_tg_fbm_b_alt_via2_dup2_t0 r0 *1 0,0
Ra_b_m_east_m_west_nand_m_a_nand_m_a_ext_via_nand_m_a_ext_via2_nand_m_a_stub_tg_d_b_tg_d_b_via_tg_d_b_via2_tg_fbm_b_tg_fbm_b_alt_via_tg_fbm_b_alt_via2_dup2_t0
+ a|b|m_east|m_west|nand_m_a|nand_m_a_ext_via|nand_m_a_ext_via2|nand_m_a_stub|tg_d_b|tg_d_b_via|tg_d_b_via2|tg_fbm_b|tg_fbm_b_alt_via|tg_fbm_b_alt_via2__t03
+ a|b|m_east|m_west|nand_m_a|nand_m_a_ext_via|nand_m_a_ext_via2|nand_m_a_stub|tg_d_b|tg_d_b_via|tg_d_b_via2|tg_fbm_b|tg_fbm_b_alt_via|tg_fbm_b_alt_via2$2
+ 68.7741894738
* device instance a_b_m_east_m_west_nand_m_a_nand_m_a_ext_via_nand_m_a_ext_via2_nand_m_a_stub_tg_d_b_tg_d_b_via_tg_d_b_via2_tg_fbm_b_tg_fbm_b_alt_via_tg_fbm_b_alt_via2_dup2_t1 r0 *1 0,0
Ra_b_m_east_m_west_nand_m_a_nand_m_a_ext_via_nand_m_a_ext_via2_nand_m_a_stub_tg_d_b_tg_d_b_via_tg_d_b_via2_tg_fbm_b_tg_fbm_b_alt_via_tg_fbm_b_alt_via2_dup2_t1
+ a|b|m_east|m_west|nand_m_a|nand_m_a_ext_via|nand_m_a_ext_via2|nand_m_a_stub|tg_d_b|tg_d_b_via|tg_d_b_via2|tg_fbm_b|tg_fbm_b_alt_via|tg_fbm_b_alt_via2__t13
+ a|b|m_east|m_west|nand_m_a|nand_m_a_ext_via|nand_m_a_ext_via2|nand_m_a_stub|tg_d_b|tg_d_b_via|tg_d_b_via2|tg_fbm_b|tg_fbm_b_alt_via|tg_fbm_b_alt_via2$2
+ 262.615776106
* device instance a_b_m_east_m_west_nand_m_a_nand_m_a_ext_via_nand_m_a_ext_via2_nand_m_a_stub_tg_d_b_tg_d_b_via_tg_d_b_via2_tg_fbm_b_tg_fbm_b_alt_via_tg_fbm_b_alt_via2_dup2_t2 r0 *1 0,0
Ra_b_m_east_m_west_nand_m_a_nand_m_a_ext_via_nand_m_a_ext_via2_nand_m_a_stub_tg_d_b_tg_d_b_via_tg_d_b_via2_tg_fbm_b_tg_fbm_b_alt_via_tg_fbm_b_alt_via2_dup2_t2
+ a|b|m_east|m_west|nand_m_a|nand_m_a_ext_via|nand_m_a_ext_via2|nand_m_a_stub|tg_d_b|tg_d_b_via|tg_d_b_via2|tg_fbm_b|tg_fbm_b_alt_via|tg_fbm_b_alt_via2__t23
+ a|b|m_east|m_west|nand_m_a|nand_m_a_ext_via|nand_m_a_ext_via2|nand_m_a_stub|tg_d_b|tg_d_b_via|tg_d_b_via2|tg_fbm_b|tg_fbm_b_alt_via|tg_fbm_b_alt_via2$2
+ 292.98458946
* device instance a_b_m_east_m_west_nand_m_a_nand_m_a_ext_via_nand_m_a_ext_via2_nand_m_a_stub_tg_d_b_tg_d_b_via_tg_d_b_via2_tg_fbm_b_tg_fbm_b_alt_via_tg_fbm_b_alt_via2_dup2_t3 r0 *1 0,0
Ra_b_m_east_m_west_nand_m_a_nand_m_a_ext_via_nand_m_a_ext_via2_nand_m_a_stub_tg_d_b_tg_d_b_via_tg_d_b_via2_tg_fbm_b_tg_fbm_b_alt_via_tg_fbm_b_alt_via2_dup2_t3
+ a|b|m_east|m_west|nand_m_a|nand_m_a_ext_via|nand_m_a_ext_via2|nand_m_a_stub|tg_d_b|tg_d_b_via|tg_d_b_via2|tg_fbm_b|tg_fbm_b_alt_via|tg_fbm_b_alt_via2__t33
+ a|b|m_east|m_west|nand_m_a|nand_m_a_ext_via|nand_m_a_ext_via2|nand_m_a_stub|tg_d_b|tg_d_b_via|tg_d_b_via2|tg_fbm_b|tg_fbm_b_alt_via|tg_fbm_b_alt_via2$2
+ 261.497453093
* device instance a_b_m_east_m_west_nand_m_a_nand_m_a_ext_via_nand_m_a_ext_via2_nand_m_a_stub_tg_d_b_tg_d_b_via_tg_d_b_via2_tg_fbm_b_tg_fbm_b_alt_via_tg_fbm_b_alt_via2_dup2_t4 r0 *1 0,0
Ra_b_m_east_m_west_nand_m_a_nand_m_a_ext_via_nand_m_a_ext_via2_nand_m_a_stub_tg_d_b_tg_d_b_via_tg_d_b_via2_tg_fbm_b_tg_fbm_b_alt_via_tg_fbm_b_alt_via2_dup2_t4
+ a|b|m_east|m_west|nand_m_a|nand_m_a_ext_via|nand_m_a_ext_via2|nand_m_a_stub|tg_d_b|tg_d_b_via|tg_d_b_via2|tg_fbm_b|tg_fbm_b_alt_via|tg_fbm_b_alt_via2__t43
+ a|b|m_east|m_west|nand_m_a|nand_m_a_ext_via|nand_m_a_ext_via2|nand_m_a_stub|tg_d_b|tg_d_b_via|tg_d_b_via2|tg_fbm_b|tg_fbm_b_alt_via|tg_fbm_b_alt_via2$2
+ 291.982605261
* device instance a_b_m_east_m_west_nand_m_a_nand_m_a_ext_via_nand_m_a_ext_via2_nand_m_a_stub_tg_d_b_tg_d_b_via_tg_d_b_via2_tg_fbm_b_tg_fbm_b_alt_via_tg_fbm_b_alt_via2_dup2_t5 r0 *1 0,0
Ra_b_m_east_m_west_nand_m_a_nand_m_a_ext_via_nand_m_a_ext_via2_nand_m_a_stub_tg_d_b_tg_d_b_via_tg_d_b_via2_tg_fbm_b_tg_fbm_b_alt_via_tg_fbm_b_alt_via2_dup2_t5
+ a|b|m_east|m_west|nand_m_a|nand_m_a_ext_via|nand_m_a_ext_via2|nand_m_a_stub|tg_d_b|tg_d_b_via|tg_d_b_via2|tg_fbm_b|tg_fbm_b_alt_via|tg_fbm_b_alt_via2__t53
+ a|b|m_east|m_west|nand_m_a|nand_m_a_ext_via|nand_m_a_ext_via2|nand_m_a_stub|tg_d_b|tg_d_b_via|tg_d_b_via2|tg_fbm_b|tg_fbm_b_alt_via|tg_fbm_b_alt_via2$2
+ 60.1829866055
* device instance a_b_m_east_m_west_nand_m_a_nand_m_a_ext_via_nand_m_a_ext_via2_nand_m_a_stub_tg_d_b_tg_d_b_via_tg_d_b_via2_tg_fbm_b_tg_fbm_b_alt_via_tg_fbm_b_alt_via2_dup2 r0 *1 0,0
Ca_b_m_east_m_west_nand_m_a_nand_m_a_ext_via_nand_m_a_ext_via2_nand_m_a_stub_tg_d_b_tg_d_b_via_tg_d_b_via2_tg_fbm_b_tg_fbm_b_alt_via_tg_fbm_b_alt_via2_dup2
+ a|b|m_east|m_west|nand_m_a|nand_m_a_ext_via|nand_m_a_ext_via2|nand_m_a_stub|tg_d_b|tg_d_b_via|tg_d_b_via2|tg_fbm_b|tg_fbm_b_alt_via|tg_fbm_b_alt_via2$2
+ vsubs 3.895867e-15
* device instance a_b_m_east_m_west_nand_m_a_nand_m_a_ext_via_nand_m_a_ext_via2_nand_m_a_stub_tg_d_b_tg_d_b_via_tg_d_b_via2_tg_fbm_b_tg_fbm_b_alt_via_tg_fbm_b_alt_via2_dup3_t0 r0 *1 0,0
Ra_b_m_east_m_west_nand_m_a_nand_m_a_ext_via_nand_m_a_ext_via2_nand_m_a_stub_tg_d_b_tg_d_b_via_tg_d_b_via2_tg_fbm_b_tg_fbm_b_alt_via_tg_fbm_b_alt_via2_dup3_t0
+ a|b|m_east|m_west|nand_m_a|nand_m_a_ext_via|nand_m_a_ext_via2|nand_m_a_stub|tg_d_b|tg_d_b_via|tg_d_b_via2|tg_fbm_b|tg_fbm_b_alt_via|tg_fbm_b_alt_via2__t04
+ a|b|m_east|m_west|nand_m_a|nand_m_a_ext_via|nand_m_a_ext_via2|nand_m_a_stub|tg_d_b|tg_d_b_via|tg_d_b_via2|tg_fbm_b|tg_fbm_b_alt_via|tg_fbm_b_alt_via2$3
+ 68.7741894738
* device instance a_b_m_east_m_west_nand_m_a_nand_m_a_ext_via_nand_m_a_ext_via2_nand_m_a_stub_tg_d_b_tg_d_b_via_tg_d_b_via2_tg_fbm_b_tg_fbm_b_alt_via_tg_fbm_b_alt_via2_dup3_t1 r0 *1 0,0
Ra_b_m_east_m_west_nand_m_a_nand_m_a_ext_via_nand_m_a_ext_via2_nand_m_a_stub_tg_d_b_tg_d_b_via_tg_d_b_via2_tg_fbm_b_tg_fbm_b_alt_via_tg_fbm_b_alt_via2_dup3_t1
+ a|b|m_east|m_west|nand_m_a|nand_m_a_ext_via|nand_m_a_ext_via2|nand_m_a_stub|tg_d_b|tg_d_b_via|tg_d_b_via2|tg_fbm_b|tg_fbm_b_alt_via|tg_fbm_b_alt_via2__t14
+ a|b|m_east|m_west|nand_m_a|nand_m_a_ext_via|nand_m_a_ext_via2|nand_m_a_stub|tg_d_b|tg_d_b_via|tg_d_b_via2|tg_fbm_b|tg_fbm_b_alt_via|tg_fbm_b_alt_via2$3
+ 292.98458946
* device instance a_b_m_east_m_west_nand_m_a_nand_m_a_ext_via_nand_m_a_ext_via2_nand_m_a_stub_tg_d_b_tg_d_b_via_tg_d_b_via2_tg_fbm_b_tg_fbm_b_alt_via_tg_fbm_b_alt_via2_dup3_t2 r0 *1 0,0
Ra_b_m_east_m_west_nand_m_a_nand_m_a_ext_via_nand_m_a_ext_via2_nand_m_a_stub_tg_d_b_tg_d_b_via_tg_d_b_via2_tg_fbm_b_tg_fbm_b_alt_via_tg_fbm_b_alt_via2_dup3_t2
+ a|b|m_east|m_west|nand_m_a|nand_m_a_ext_via|nand_m_a_ext_via2|nand_m_a_stub|tg_d_b|tg_d_b_via|tg_d_b_via2|tg_fbm_b|tg_fbm_b_alt_via|tg_fbm_b_alt_via2__t24
+ a|b|m_east|m_west|nand_m_a|nand_m_a_ext_via|nand_m_a_ext_via2|nand_m_a_stub|tg_d_b|tg_d_b_via|tg_d_b_via2|tg_fbm_b|tg_fbm_b_alt_via|tg_fbm_b_alt_via2$3
+ 262.615776106
* device instance a_b_m_east_m_west_nand_m_a_nand_m_a_ext_via_nand_m_a_ext_via2_nand_m_a_stub_tg_d_b_tg_d_b_via_tg_d_b_via2_tg_fbm_b_tg_fbm_b_alt_via_tg_fbm_b_alt_via2_dup3_t3 r0 *1 0,0
Ra_b_m_east_m_west_nand_m_a_nand_m_a_ext_via_nand_m_a_ext_via2_nand_m_a_stub_tg_d_b_tg_d_b_via_tg_d_b_via2_tg_fbm_b_tg_fbm_b_alt_via_tg_fbm_b_alt_via2_dup3_t3
+ a|b|m_east|m_west|nand_m_a|nand_m_a_ext_via|nand_m_a_ext_via2|nand_m_a_stub|tg_d_b|tg_d_b_via|tg_d_b_via2|tg_fbm_b|tg_fbm_b_alt_via|tg_fbm_b_alt_via2__t34
+ a|b|m_east|m_west|nand_m_a|nand_m_a_ext_via|nand_m_a_ext_via2|nand_m_a_stub|tg_d_b|tg_d_b_via|tg_d_b_via2|tg_fbm_b|tg_fbm_b_alt_via|tg_fbm_b_alt_via2$3
+ 261.497453093
* device instance a_b_m_east_m_west_nand_m_a_nand_m_a_ext_via_nand_m_a_ext_via2_nand_m_a_stub_tg_d_b_tg_d_b_via_tg_d_b_via2_tg_fbm_b_tg_fbm_b_alt_via_tg_fbm_b_alt_via2_dup3_t4 r0 *1 0,0
Ra_b_m_east_m_west_nand_m_a_nand_m_a_ext_via_nand_m_a_ext_via2_nand_m_a_stub_tg_d_b_tg_d_b_via_tg_d_b_via2_tg_fbm_b_tg_fbm_b_alt_via_tg_fbm_b_alt_via2_dup3_t4
+ a|b|m_east|m_west|nand_m_a|nand_m_a_ext_via|nand_m_a_ext_via2|nand_m_a_stub|tg_d_b|tg_d_b_via|tg_d_b_via2|tg_fbm_b|tg_fbm_b_alt_via|tg_fbm_b_alt_via2__t44
+ a|b|m_east|m_west|nand_m_a|nand_m_a_ext_via|nand_m_a_ext_via2|nand_m_a_stub|tg_d_b|tg_d_b_via|tg_d_b_via2|tg_fbm_b|tg_fbm_b_alt_via|tg_fbm_b_alt_via2$3
+ 291.982605261
* device instance a_b_m_east_m_west_nand_m_a_nand_m_a_ext_via_nand_m_a_ext_via2_nand_m_a_stub_tg_d_b_tg_d_b_via_tg_d_b_via2_tg_fbm_b_tg_fbm_b_alt_via_tg_fbm_b_alt_via2_dup3_t5 r0 *1 0,0
Ra_b_m_east_m_west_nand_m_a_nand_m_a_ext_via_nand_m_a_ext_via2_nand_m_a_stub_tg_d_b_tg_d_b_via_tg_d_b_via2_tg_fbm_b_tg_fbm_b_alt_via_tg_fbm_b_alt_via2_dup3_t5
+ a|b|m_east|m_west|nand_m_a|nand_m_a_ext_via|nand_m_a_ext_via2|nand_m_a_stub|tg_d_b|tg_d_b_via|tg_d_b_via2|tg_fbm_b|tg_fbm_b_alt_via|tg_fbm_b_alt_via2__t54
+ a|b|m_east|m_west|nand_m_a|nand_m_a_ext_via|nand_m_a_ext_via2|nand_m_a_stub|tg_d_b|tg_d_b_via|tg_d_b_via2|tg_fbm_b|tg_fbm_b_alt_via|tg_fbm_b_alt_via2$3
+ 60.1829866055
* device instance a_b_m_east_m_west_nand_m_a_nand_m_a_ext_via_nand_m_a_ext_via2_nand_m_a_stub_tg_d_b_tg_d_b_via_tg_d_b_via2_tg_fbm_b_tg_fbm_b_alt_via_tg_fbm_b_alt_via2_dup3 r0 *1 0,0
Ca_b_m_east_m_west_nand_m_a_nand_m_a_ext_via_nand_m_a_ext_via2_nand_m_a_stub_tg_d_b_tg_d_b_via_tg_d_b_via2_tg_fbm_b_tg_fbm_b_alt_via_tg_fbm_b_alt_via2_dup3
+ a|b|m_east|m_west|nand_m_a|nand_m_a_ext_via|nand_m_a_ext_via2|nand_m_a_stub|tg_d_b|tg_d_b_via|tg_d_b_via2|tg_fbm_b|tg_fbm_b_alt_via|tg_fbm_b_alt_via2$3
+ vsubs 3.895867e-15
* device instance a_b_m_east_m_west_nand_m_a_nand_m_a_ext_via_nand_m_a_ext_via2_nand_m_a_stub_tg_d_b_tg_d_b_via_tg_d_b_via2_tg_fbm_b_tg_fbm_b_alt_via_tg_fbm_b_alt_via2_dup4_t0 r0 *1 0,0
Ra_b_m_east_m_west_nand_m_a_nand_m_a_ext_via_nand_m_a_ext_via2_nand_m_a_stub_tg_d_b_tg_d_b_via_tg_d_b_via2_tg_fbm_b_tg_fbm_b_alt_via_tg_fbm_b_alt_via2_dup4_t0
+ a|b|m_east|m_west|nand_m_a|nand_m_a_ext_via|nand_m_a_ext_via2|nand_m_a_stub|tg_d_b|tg_d_b_via|tg_d_b_via2|tg_fbm_b|tg_fbm_b_alt_via|tg_fbm_b_alt_via2__t05
+ a|b|m_east|m_west|nand_m_a|nand_m_a_ext_via|nand_m_a_ext_via2|nand_m_a_stub|tg_d_b|tg_d_b_via|tg_d_b_via2|tg_fbm_b|tg_fbm_b_alt_via|tg_fbm_b_alt_via2$4
+ 68.7741894738
* device instance a_b_m_east_m_west_nand_m_a_nand_m_a_ext_via_nand_m_a_ext_via2_nand_m_a_stub_tg_d_b_tg_d_b_via_tg_d_b_via2_tg_fbm_b_tg_fbm_b_alt_via_tg_fbm_b_alt_via2_dup4_t1 r0 *1 0,0
Ra_b_m_east_m_west_nand_m_a_nand_m_a_ext_via_nand_m_a_ext_via2_nand_m_a_stub_tg_d_b_tg_d_b_via_tg_d_b_via2_tg_fbm_b_tg_fbm_b_alt_via_tg_fbm_b_alt_via2_dup4_t1
+ a|b|m_east|m_west|nand_m_a|nand_m_a_ext_via|nand_m_a_ext_via2|nand_m_a_stub|tg_d_b|tg_d_b_via|tg_d_b_via2|tg_fbm_b|tg_fbm_b_alt_via|tg_fbm_b_alt_via2__t15
+ a|b|m_east|m_west|nand_m_a|nand_m_a_ext_via|nand_m_a_ext_via2|nand_m_a_stub|tg_d_b|tg_d_b_via|tg_d_b_via2|tg_fbm_b|tg_fbm_b_alt_via|tg_fbm_b_alt_via2$4
+ 292.98458946
* device instance a_b_m_east_m_west_nand_m_a_nand_m_a_ext_via_nand_m_a_ext_via2_nand_m_a_stub_tg_d_b_tg_d_b_via_tg_d_b_via2_tg_fbm_b_tg_fbm_b_alt_via_tg_fbm_b_alt_via2_dup4_t2 r0 *1 0,0
Ra_b_m_east_m_west_nand_m_a_nand_m_a_ext_via_nand_m_a_ext_via2_nand_m_a_stub_tg_d_b_tg_d_b_via_tg_d_b_via2_tg_fbm_b_tg_fbm_b_alt_via_tg_fbm_b_alt_via2_dup4_t2
+ a|b|m_east|m_west|nand_m_a|nand_m_a_ext_via|nand_m_a_ext_via2|nand_m_a_stub|tg_d_b|tg_d_b_via|tg_d_b_via2|tg_fbm_b|tg_fbm_b_alt_via|tg_fbm_b_alt_via2__t25
+ a|b|m_east|m_west|nand_m_a|nand_m_a_ext_via|nand_m_a_ext_via2|nand_m_a_stub|tg_d_b|tg_d_b_via|tg_d_b_via2|tg_fbm_b|tg_fbm_b_alt_via|tg_fbm_b_alt_via2$4
+ 262.615776106
* device instance a_b_m_east_m_west_nand_m_a_nand_m_a_ext_via_nand_m_a_ext_via2_nand_m_a_stub_tg_d_b_tg_d_b_via_tg_d_b_via2_tg_fbm_b_tg_fbm_b_alt_via_tg_fbm_b_alt_via2_dup4_t3 r0 *1 0,0
Ra_b_m_east_m_west_nand_m_a_nand_m_a_ext_via_nand_m_a_ext_via2_nand_m_a_stub_tg_d_b_tg_d_b_via_tg_d_b_via2_tg_fbm_b_tg_fbm_b_alt_via_tg_fbm_b_alt_via2_dup4_t3
+ a|b|m_east|m_west|nand_m_a|nand_m_a_ext_via|nand_m_a_ext_via2|nand_m_a_stub|tg_d_b|tg_d_b_via|tg_d_b_via2|tg_fbm_b|tg_fbm_b_alt_via|tg_fbm_b_alt_via2__t35
+ a|b|m_east|m_west|nand_m_a|nand_m_a_ext_via|nand_m_a_ext_via2|nand_m_a_stub|tg_d_b|tg_d_b_via|tg_d_b_via2|tg_fbm_b|tg_fbm_b_alt_via|tg_fbm_b_alt_via2$4
+ 291.982605261
* device instance a_b_m_east_m_west_nand_m_a_nand_m_a_ext_via_nand_m_a_ext_via2_nand_m_a_stub_tg_d_b_tg_d_b_via_tg_d_b_via2_tg_fbm_b_tg_fbm_b_alt_via_tg_fbm_b_alt_via2_dup4_t4 r0 *1 0,0
Ra_b_m_east_m_west_nand_m_a_nand_m_a_ext_via_nand_m_a_ext_via2_nand_m_a_stub_tg_d_b_tg_d_b_via_tg_d_b_via2_tg_fbm_b_tg_fbm_b_alt_via_tg_fbm_b_alt_via2_dup4_t4
+ a|b|m_east|m_west|nand_m_a|nand_m_a_ext_via|nand_m_a_ext_via2|nand_m_a_stub|tg_d_b|tg_d_b_via|tg_d_b_via2|tg_fbm_b|tg_fbm_b_alt_via|tg_fbm_b_alt_via2__t45
+ a|b|m_east|m_west|nand_m_a|nand_m_a_ext_via|nand_m_a_ext_via2|nand_m_a_stub|tg_d_b|tg_d_b_via|tg_d_b_via2|tg_fbm_b|tg_fbm_b_alt_via|tg_fbm_b_alt_via2$4
+ 261.497453093
* device instance a_b_m_east_m_west_nand_m_a_nand_m_a_ext_via_nand_m_a_ext_via2_nand_m_a_stub_tg_d_b_tg_d_b_via_tg_d_b_via2_tg_fbm_b_tg_fbm_b_alt_via_tg_fbm_b_alt_via2_dup4_t5 r0 *1 0,0
Ra_b_m_east_m_west_nand_m_a_nand_m_a_ext_via_nand_m_a_ext_via2_nand_m_a_stub_tg_d_b_tg_d_b_via_tg_d_b_via2_tg_fbm_b_tg_fbm_b_alt_via_tg_fbm_b_alt_via2_dup4_t5
+ a|b|m_east|m_west|nand_m_a|nand_m_a_ext_via|nand_m_a_ext_via2|nand_m_a_stub|tg_d_b|tg_d_b_via|tg_d_b_via2|tg_fbm_b|tg_fbm_b_alt_via|tg_fbm_b_alt_via2__t55
+ a|b|m_east|m_west|nand_m_a|nand_m_a_ext_via|nand_m_a_ext_via2|nand_m_a_stub|tg_d_b|tg_d_b_via|tg_d_b_via2|tg_fbm_b|tg_fbm_b_alt_via|tg_fbm_b_alt_via2$4
+ 60.1829866055
* device instance a_b_m_east_m_west_nand_m_a_nand_m_a_ext_via_nand_m_a_ext_via2_nand_m_a_stub_tg_d_b_tg_d_b_via_tg_d_b_via2_tg_fbm_b_tg_fbm_b_alt_via_tg_fbm_b_alt_via2_dup4 r0 *1 0,0
Ca_b_m_east_m_west_nand_m_a_nand_m_a_ext_via_nand_m_a_ext_via2_nand_m_a_stub_tg_d_b_tg_d_b_via_tg_d_b_via2_tg_fbm_b_tg_fbm_b_alt_via_tg_fbm_b_alt_via2_dup4
+ a|b|m_east|m_west|nand_m_a|nand_m_a_ext_via|nand_m_a_ext_via2|nand_m_a_stub|tg_d_b|tg_d_b_via|tg_d_b_via2|tg_fbm_b|tg_fbm_b_alt_via|tg_fbm_b_alt_via2$4
+ vsubs 3.895867e-15
* device instance a_b_m_east_m_west_nand_m_a_nand_m_a_ext_via_nand_m_a_ext_via2_nand_m_a_stub_tg_d_b_tg_d_b_via_tg_d_b_via2_tg_fbm_b_tg_fbm_b_alt_via_tg_fbm_b_alt_via2_dup5_t0 r0 *1 0,0
Ra_b_m_east_m_west_nand_m_a_nand_m_a_ext_via_nand_m_a_ext_via2_nand_m_a_stub_tg_d_b_tg_d_b_via_tg_d_b_via2_tg_fbm_b_tg_fbm_b_alt_via_tg_fbm_b_alt_via2_dup5_t0
+ a|b|m_east|m_west|nand_m_a|nand_m_a_ext_via|nand_m_a_ext_via2|nand_m_a_stub|tg_d_b|tg_d_b_via|tg_d_b_via2|tg_fbm_b|tg_fbm_b_alt_via|tg_fbm_b_alt_via2__t06
+ a|b|m_east|m_west|nand_m_a|nand_m_a_ext_via|nand_m_a_ext_via2|nand_m_a_stub|tg_d_b|tg_d_b_via|tg_d_b_via2|tg_fbm_b|tg_fbm_b_alt_via|tg_fbm_b_alt_via2$5
+ 68.7741894738
* device instance a_b_m_east_m_west_nand_m_a_nand_m_a_ext_via_nand_m_a_ext_via2_nand_m_a_stub_tg_d_b_tg_d_b_via_tg_d_b_via2_tg_fbm_b_tg_fbm_b_alt_via_tg_fbm_b_alt_via2_dup5_t1 r0 *1 0,0
Ra_b_m_east_m_west_nand_m_a_nand_m_a_ext_via_nand_m_a_ext_via2_nand_m_a_stub_tg_d_b_tg_d_b_via_tg_d_b_via2_tg_fbm_b_tg_fbm_b_alt_via_tg_fbm_b_alt_via2_dup5_t1
+ a|b|m_east|m_west|nand_m_a|nand_m_a_ext_via|nand_m_a_ext_via2|nand_m_a_stub|tg_d_b|tg_d_b_via|tg_d_b_via2|tg_fbm_b|tg_fbm_b_alt_via|tg_fbm_b_alt_via2__t16
+ a|b|m_east|m_west|nand_m_a|nand_m_a_ext_via|nand_m_a_ext_via2|nand_m_a_stub|tg_d_b|tg_d_b_via|tg_d_b_via2|tg_fbm_b|tg_fbm_b_alt_via|tg_fbm_b_alt_via2$5
+ 262.615776106
* device instance a_b_m_east_m_west_nand_m_a_nand_m_a_ext_via_nand_m_a_ext_via2_nand_m_a_stub_tg_d_b_tg_d_b_via_tg_d_b_via2_tg_fbm_b_tg_fbm_b_alt_via_tg_fbm_b_alt_via2_dup5_t2 r0 *1 0,0
Ra_b_m_east_m_west_nand_m_a_nand_m_a_ext_via_nand_m_a_ext_via2_nand_m_a_stub_tg_d_b_tg_d_b_via_tg_d_b_via2_tg_fbm_b_tg_fbm_b_alt_via_tg_fbm_b_alt_via2_dup5_t2
+ a|b|m_east|m_west|nand_m_a|nand_m_a_ext_via|nand_m_a_ext_via2|nand_m_a_stub|tg_d_b|tg_d_b_via|tg_d_b_via2|tg_fbm_b|tg_fbm_b_alt_via|tg_fbm_b_alt_via2__t26
+ a|b|m_east|m_west|nand_m_a|nand_m_a_ext_via|nand_m_a_ext_via2|nand_m_a_stub|tg_d_b|tg_d_b_via|tg_d_b_via2|tg_fbm_b|tg_fbm_b_alt_via|tg_fbm_b_alt_via2$5
+ 292.98458946
* device instance a_b_m_east_m_west_nand_m_a_nand_m_a_ext_via_nand_m_a_ext_via2_nand_m_a_stub_tg_d_b_tg_d_b_via_tg_d_b_via2_tg_fbm_b_tg_fbm_b_alt_via_tg_fbm_b_alt_via2_dup5_t3 r0 *1 0,0
Ra_b_m_east_m_west_nand_m_a_nand_m_a_ext_via_nand_m_a_ext_via2_nand_m_a_stub_tg_d_b_tg_d_b_via_tg_d_b_via2_tg_fbm_b_tg_fbm_b_alt_via_tg_fbm_b_alt_via2_dup5_t3
+ a|b|m_east|m_west|nand_m_a|nand_m_a_ext_via|nand_m_a_ext_via2|nand_m_a_stub|tg_d_b|tg_d_b_via|tg_d_b_via2|tg_fbm_b|tg_fbm_b_alt_via|tg_fbm_b_alt_via2__t36
+ a|b|m_east|m_west|nand_m_a|nand_m_a_ext_via|nand_m_a_ext_via2|nand_m_a_stub|tg_d_b|tg_d_b_via|tg_d_b_via2|tg_fbm_b|tg_fbm_b_alt_via|tg_fbm_b_alt_via2$5
+ 291.982605261
* device instance a_b_m_east_m_west_nand_m_a_nand_m_a_ext_via_nand_m_a_ext_via2_nand_m_a_stub_tg_d_b_tg_d_b_via_tg_d_b_via2_tg_fbm_b_tg_fbm_b_alt_via_tg_fbm_b_alt_via2_dup5_t4 r0 *1 0,0
Ra_b_m_east_m_west_nand_m_a_nand_m_a_ext_via_nand_m_a_ext_via2_nand_m_a_stub_tg_d_b_tg_d_b_via_tg_d_b_via2_tg_fbm_b_tg_fbm_b_alt_via_tg_fbm_b_alt_via2_dup5_t4
+ a|b|m_east|m_west|nand_m_a|nand_m_a_ext_via|nand_m_a_ext_via2|nand_m_a_stub|tg_d_b|tg_d_b_via|tg_d_b_via2|tg_fbm_b|tg_fbm_b_alt_via|tg_fbm_b_alt_via2__t46
+ a|b|m_east|m_west|nand_m_a|nand_m_a_ext_via|nand_m_a_ext_via2|nand_m_a_stub|tg_d_b|tg_d_b_via|tg_d_b_via2|tg_fbm_b|tg_fbm_b_alt_via|tg_fbm_b_alt_via2$5
+ 261.497453093
* device instance a_b_m_east_m_west_nand_m_a_nand_m_a_ext_via_nand_m_a_ext_via2_nand_m_a_stub_tg_d_b_tg_d_b_via_tg_d_b_via2_tg_fbm_b_tg_fbm_b_alt_via_tg_fbm_b_alt_via2_dup5_t5 r0 *1 0,0
Ra_b_m_east_m_west_nand_m_a_nand_m_a_ext_via_nand_m_a_ext_via2_nand_m_a_stub_tg_d_b_tg_d_b_via_tg_d_b_via2_tg_fbm_b_tg_fbm_b_alt_via_tg_fbm_b_alt_via2_dup5_t5
+ a|b|m_east|m_west|nand_m_a|nand_m_a_ext_via|nand_m_a_ext_via2|nand_m_a_stub|tg_d_b|tg_d_b_via|tg_d_b_via2|tg_fbm_b|tg_fbm_b_alt_via|tg_fbm_b_alt_via2__t56
+ a|b|m_east|m_west|nand_m_a|nand_m_a_ext_via|nand_m_a_ext_via2|nand_m_a_stub|tg_d_b|tg_d_b_via|tg_d_b_via2|tg_fbm_b|tg_fbm_b_alt_via|tg_fbm_b_alt_via2$5
+ 60.1829866055
* device instance a_b_m_east_m_west_nand_m_a_nand_m_a_ext_via_nand_m_a_ext_via2_nand_m_a_stub_tg_d_b_tg_d_b_via_tg_d_b_via2_tg_fbm_b_tg_fbm_b_alt_via_tg_fbm_b_alt_via2_dup5 r0 *1 0,0
Ca_b_m_east_m_west_nand_m_a_nand_m_a_ext_via_nand_m_a_ext_via2_nand_m_a_stub_tg_d_b_tg_d_b_via_tg_d_b_via2_tg_fbm_b_tg_fbm_b_alt_via_tg_fbm_b_alt_via2_dup5
+ a|b|m_east|m_west|nand_m_a|nand_m_a_ext_via|nand_m_a_ext_via2|nand_m_a_stub|tg_d_b|tg_d_b_via|tg_d_b_via2|tg_fbm_b|tg_fbm_b_alt_via|tg_fbm_b_alt_via2$5
+ vsubs 3.895867e-15
* device instance a_clk_ctrl_ctrlb_inv_clk_a_inv_clk_clk_via_tg_d_ctrl_tg_d_ctrl_via_tg_fbm_ctrlb_tg_fbm_ctrlb_via_tg_fbs_ctrl_tg_fbs_ctrl_via_tg_s_ctrlb_tg_s_ctrlb_via_t0 r0 *1 0,0
Ra_clk_ctrl_ctrlb_inv_clk_a_inv_clk_clk_via_tg_d_ctrl_tg_d_ctrl_via_tg_fbm_ctrlb_tg_fbm_ctrlb_via_tg_fbs_ctrl_tg_fbs_ctrl_via_tg_s_ctrlb_tg_s_ctrlb_via_t0
+ a|clk|ctrl|ctrlb|inv_clk_a|inv_clk_clk_via|tg_d_ctrl|tg_d_ctrl_via|tg_fbm_ctrlb|tg_fbm_ctrlb_via|tg_fbs_ctrl|tg_fbs_ctrl_via|tg_s_ctrlb|tg_s_ctrlb_via__t0
+ a|clk|ctrl|ctrlb|inv_clk_a|inv_clk_clk_via|tg_d_ctrl|tg_d_ctrl_via|tg_fbm_ctrlb|tg_fbm_ctrlb_via|tg_fbs_ctrl|tg_fbs_ctrl_via|tg_s_ctrlb|tg_s_ctrlb_via
+ 388.751018027
* device instance a_clk_ctrl_ctrlb_inv_clk_a_inv_clk_clk_via_tg_d_ctrl_tg_d_ctrl_via_tg_fbm_ctrlb_tg_fbm_ctrlb_via_tg_fbs_ctrl_tg_fbs_ctrl_via_tg_s_ctrlb_tg_s_ctrlb_via_t1 r0 *1 0,0
Ra_clk_ctrl_ctrlb_inv_clk_a_inv_clk_clk_via_tg_d_ctrl_tg_d_ctrl_via_tg_fbm_ctrlb_tg_fbm_ctrlb_via_tg_fbs_ctrl_tg_fbs_ctrl_via_tg_s_ctrlb_tg_s_ctrlb_via_t1
+ a|clk|ctrl|ctrlb|inv_clk_a|inv_clk_clk_via|tg_d_ctrl|tg_d_ctrl_via|tg_fbm_ctrlb|tg_fbm_ctrlb_via|tg_fbs_ctrl|tg_fbs_ctrl_via|tg_s_ctrlb|tg_s_ctrlb_via__t1
+ a|clk|ctrl|ctrlb|inv_clk_a|inv_clk_clk_via|tg_d_ctrl|tg_d_ctrl_via|tg_fbm_ctrlb|tg_fbm_ctrlb_via|tg_fbs_ctrl|tg_fbs_ctrl_via|tg_s_ctrlb|tg_s_ctrlb_via
+ 388.751018027
* device instance a_clk_ctrl_ctrlb_inv_clk_a_inv_clk_clk_via_tg_d_ctrl_tg_d_ctrl_via_tg_fbm_ctrlb_tg_fbm_ctrlb_via_tg_fbs_ctrl_tg_fbs_ctrl_via_tg_s_ctrlb_tg_s_ctrlb_via_t2 r0 *1 0,0
Ra_clk_ctrl_ctrlb_inv_clk_a_inv_clk_clk_via_tg_d_ctrl_tg_d_ctrl_via_tg_fbm_ctrlb_tg_fbm_ctrlb_via_tg_fbs_ctrl_tg_fbs_ctrl_via_tg_s_ctrlb_tg_s_ctrlb_via_t2
+ a|clk|ctrl|ctrlb|inv_clk_a|inv_clk_clk_via|tg_d_ctrl|tg_d_ctrl_via|tg_fbm_ctrlb|tg_fbm_ctrlb_via|tg_fbs_ctrl|tg_fbs_ctrl_via|tg_s_ctrlb|tg_s_ctrlb_via__t2
+ a|clk|ctrl|ctrlb|inv_clk_a|inv_clk_clk_via|tg_d_ctrl|tg_d_ctrl_via|tg_fbm_ctrlb|tg_fbm_ctrlb_via|tg_fbs_ctrl|tg_fbs_ctrl_via|tg_s_ctrlb|tg_s_ctrlb_via
+ 283.029245649
* device instance a_clk_ctrl_ctrlb_inv_clk_a_inv_clk_clk_via_tg_d_ctrl_tg_d_ctrl_via_tg_fbm_ctrlb_tg_fbm_ctrlb_via_tg_fbs_ctrl_tg_fbs_ctrl_via_tg_s_ctrlb_tg_s_ctrlb_via_t3 r0 *1 0,0
Ra_clk_ctrl_ctrlb_inv_clk_a_inv_clk_clk_via_tg_d_ctrl_tg_d_ctrl_via_tg_fbm_ctrlb_tg_fbm_ctrlb_via_tg_fbs_ctrl_tg_fbs_ctrl_via_tg_s_ctrlb_tg_s_ctrlb_via_t3
+ a|clk|ctrl|ctrlb|inv_clk_a|inv_clk_clk_via|tg_d_ctrl|tg_d_ctrl_via|tg_fbm_ctrlb|tg_fbm_ctrlb_via|tg_fbs_ctrl|tg_fbs_ctrl_via|tg_s_ctrlb|tg_s_ctrlb_via__t3
+ a|clk|ctrl|ctrlb|inv_clk_a|inv_clk_clk_via|tg_d_ctrl|tg_d_ctrl_via|tg_fbm_ctrlb|tg_fbm_ctrlb_via|tg_fbs_ctrl|tg_fbs_ctrl_via|tg_s_ctrlb|tg_s_ctrlb_via
+ 300.803977152
* device instance a_clk_ctrl_ctrlb_inv_clk_a_inv_clk_clk_via_tg_d_ctrl_tg_d_ctrl_via_tg_fbm_ctrlb_tg_fbm_ctrlb_via_tg_fbs_ctrl_tg_fbs_ctrl_via_tg_s_ctrlb_tg_s_ctrlb_via_t4 r0 *1 0,0
Ra_clk_ctrl_ctrlb_inv_clk_a_inv_clk_clk_via_tg_d_ctrl_tg_d_ctrl_via_tg_fbm_ctrlb_tg_fbm_ctrlb_via_tg_fbs_ctrl_tg_fbs_ctrl_via_tg_s_ctrlb_tg_s_ctrlb_via_t4
+ a|clk|ctrl|ctrlb|inv_clk_a|inv_clk_clk_via|tg_d_ctrl|tg_d_ctrl_via|tg_fbm_ctrlb|tg_fbm_ctrlb_via|tg_fbs_ctrl|tg_fbs_ctrl_via|tg_s_ctrlb|tg_s_ctrlb_via__t4
+ a|clk|ctrl|ctrlb|inv_clk_a|inv_clk_clk_via|tg_d_ctrl|tg_d_ctrl_via|tg_fbm_ctrlb|tg_fbm_ctrlb_via|tg_fbs_ctrl|tg_fbs_ctrl_via|tg_s_ctrlb|tg_s_ctrlb_via
+ 312.6084917
* device instance a_clk_ctrl_ctrlb_inv_clk_a_inv_clk_clk_via_tg_d_ctrl_tg_d_ctrl_via_tg_fbm_ctrlb_tg_fbm_ctrlb_via_tg_fbs_ctrl_tg_fbs_ctrl_via_tg_s_ctrlb_tg_s_ctrlb_via_t5 r0 *1 0,0
Ra_clk_ctrl_ctrlb_inv_clk_a_inv_clk_clk_via_tg_d_ctrl_tg_d_ctrl_via_tg_fbm_ctrlb_tg_fbm_ctrlb_via_tg_fbs_ctrl_tg_fbs_ctrl_via_tg_s_ctrlb_tg_s_ctrlb_via_t5
+ a|clk|ctrl|ctrlb|inv_clk_a|inv_clk_clk_via|tg_d_ctrl|tg_d_ctrl_via|tg_fbm_ctrlb|tg_fbm_ctrlb_via|tg_fbs_ctrl|tg_fbs_ctrl_via|tg_s_ctrlb|tg_s_ctrlb_via__t5
+ a|clk|ctrl|ctrlb|inv_clk_a|inv_clk_clk_via|tg_d_ctrl|tg_d_ctrl_via|tg_fbm_ctrlb|tg_fbm_ctrlb_via|tg_fbs_ctrl|tg_fbs_ctrl_via|tg_s_ctrlb|tg_s_ctrlb_via
+ 420.920479953
* device instance a_clk_ctrl_ctrlb_inv_clk_a_inv_clk_clk_via_tg_d_ctrl_tg_d_ctrl_via_tg_fbm_ctrlb_tg_fbm_ctrlb_via_tg_fbs_ctrl_tg_fbs_ctrl_via_tg_s_ctrlb_tg_s_ctrlb_via_t6 r0 *1 0,0
Ra_clk_ctrl_ctrlb_inv_clk_a_inv_clk_clk_via_tg_d_ctrl_tg_d_ctrl_via_tg_fbm_ctrlb_tg_fbm_ctrlb_via_tg_fbs_ctrl_tg_fbs_ctrl_via_tg_s_ctrlb_tg_s_ctrlb_via_t6
+ a|clk|ctrl|ctrlb|inv_clk_a|inv_clk_clk_via|tg_d_ctrl|tg_d_ctrl_via|tg_fbm_ctrlb|tg_fbm_ctrlb_via|tg_fbs_ctrl|tg_fbs_ctrl_via|tg_s_ctrlb|tg_s_ctrlb_via__t6
+ a|clk|ctrl|ctrlb|inv_clk_a|inv_clk_clk_via|tg_d_ctrl|tg_d_ctrl_via|tg_fbm_ctrlb|tg_fbm_ctrlb_via|tg_fbs_ctrl|tg_fbs_ctrl_via|tg_s_ctrlb|tg_s_ctrlb_via
+ 101.205237893
* device instance a_clk_ctrl_ctrlb_inv_clk_a_inv_clk_clk_via_tg_d_ctrl_tg_d_ctrl_via_tg_fbm_ctrlb_tg_fbm_ctrlb_via_tg_fbs_ctrl_tg_fbs_ctrl_via_tg_s_ctrlb_tg_s_ctrlb_via_t7 r0 *1 0,0
Ra_clk_ctrl_ctrlb_inv_clk_a_inv_clk_clk_via_tg_d_ctrl_tg_d_ctrl_via_tg_fbm_ctrlb_tg_fbm_ctrlb_via_tg_fbs_ctrl_tg_fbs_ctrl_via_tg_s_ctrlb_tg_s_ctrlb_via_t7
+ a|clk|ctrl|ctrlb|inv_clk_a|inv_clk_clk_via|tg_d_ctrl|tg_d_ctrl_via|tg_fbm_ctrlb|tg_fbm_ctrlb_via|tg_fbs_ctrl|tg_fbs_ctrl_via|tg_s_ctrlb|tg_s_ctrlb_via__t7
+ a|clk|ctrl|ctrlb|inv_clk_a|inv_clk_clk_via|tg_d_ctrl|tg_d_ctrl_via|tg_fbm_ctrlb|tg_fbm_ctrlb_via|tg_fbs_ctrl|tg_fbs_ctrl_via|tg_s_ctrlb|tg_s_ctrlb_via
+ 376.946123016
* device instance a_clk_ctrl_ctrlb_inv_clk_a_inv_clk_clk_via_tg_d_ctrl_tg_d_ctrl_via_tg_fbm_ctrlb_tg_fbm_ctrlb_via_tg_fbs_ctrl_tg_fbs_ctrl_via_tg_s_ctrlb_tg_s_ctrlb_via_t8 r0 *1 0,0
Ra_clk_ctrl_ctrlb_inv_clk_a_inv_clk_clk_via_tg_d_ctrl_tg_d_ctrl_via_tg_fbm_ctrlb_tg_fbm_ctrlb_via_tg_fbs_ctrl_tg_fbs_ctrl_via_tg_s_ctrlb_tg_s_ctrlb_via_t8
+ a|clk|ctrl|ctrlb|inv_clk_a|inv_clk_clk_via|tg_d_ctrl|tg_d_ctrl_via|tg_fbm_ctrlb|tg_fbm_ctrlb_via|tg_fbs_ctrl|tg_fbs_ctrl_via|tg_s_ctrlb|tg_s_ctrlb_via__t8
+ a|clk|ctrl|ctrlb|inv_clk_a|inv_clk_clk_via|tg_d_ctrl|tg_d_ctrl_via|tg_fbm_ctrlb|tg_fbm_ctrlb_via|tg_fbs_ctrl|tg_fbs_ctrl_via|tg_s_ctrlb|tg_s_ctrlb_via
+ 268.636219679
* device instance a_clk_ctrl_ctrlb_inv_clk_a_inv_clk_clk_via_tg_d_ctrl_tg_d_ctrl_via_tg_fbm_ctrlb_tg_fbm_ctrlb_via_tg_fbs_ctrl_tg_fbs_ctrl_via_tg_s_ctrlb_tg_s_ctrlb_via_t9 r0 *1 0,0
Ra_clk_ctrl_ctrlb_inv_clk_a_inv_clk_clk_via_tg_d_ctrl_tg_d_ctrl_via_tg_fbm_ctrlb_tg_fbm_ctrlb_via_tg_fbs_ctrl_tg_fbs_ctrl_via_tg_s_ctrlb_tg_s_ctrlb_via_t9
+ a|clk|ctrl|ctrlb|inv_clk_a|inv_clk_clk_via|tg_d_ctrl|tg_d_ctrl_via|tg_fbm_ctrlb|tg_fbm_ctrlb_via|tg_fbs_ctrl|tg_fbs_ctrl_via|tg_s_ctrlb|tg_s_ctrlb_via__t9
+ a|clk|ctrl|ctrlb|inv_clk_a|inv_clk_clk_via|tg_d_ctrl|tg_d_ctrl_via|tg_fbm_ctrlb|tg_fbm_ctrlb_via|tg_fbs_ctrl|tg_fbs_ctrl_via|tg_s_ctrlb|tg_s_ctrlb_via
+ 113.002080638
* device instance a_clk_ctrl_ctrlb_inv_clk_a_inv_clk_clk_via_tg_d_ctrl_tg_d_ctrl_via_tg_fbm_ctrlb_tg_fbm_ctrlb_via_tg_fbs_ctrl_tg_fbs_ctrl_via_tg_s_ctrlb_tg_s_ctrlb_via_t10 r0 *1 0,0
Ra_clk_ctrl_ctrlb_inv_clk_a_inv_clk_clk_via_tg_d_ctrl_tg_d_ctrl_via_tg_fbm_ctrlb_tg_fbm_ctrlb_via_tg_fbs_ctrl_tg_fbs_ctrl_via_tg_s_ctrlb_tg_s_ctrlb_via_t10
+ a|clk|ctrl|ctrlb|inv_clk_a|inv_clk_clk_via|tg_d_ctrl|tg_d_ctrl_via|tg_fbm_ctrlb|tg_fbm_ctrlb_via|tg_fbs_ctrl|tg_fbs_ctrl_via|tg_s_ctrlb|tg_s_ctrlb_via__t10
+ a|clk|ctrl|ctrlb|inv_clk_a|inv_clk_clk_via|tg_d_ctrl|tg_d_ctrl_via|tg_fbm_ctrlb|tg_fbm_ctrlb_via|tg_fbs_ctrl|tg_fbs_ctrl_via|tg_s_ctrlb|tg_s_ctrlb_via
+ 250.861953236
* device instance a_clk_ctrl_ctrlb_inv_clk_a_inv_clk_clk_via_tg_d_ctrl_tg_d_ctrl_via_tg_fbm_ctrlb_tg_fbm_ctrlb_via_tg_fbs_ctrl_tg_fbs_ctrl_via_tg_s_ctrlb_tg_s_ctrlb_via_t11 r0 *1 0,0
Ra_clk_ctrl_ctrlb_inv_clk_a_inv_clk_clk_via_tg_d_ctrl_tg_d_ctrl_via_tg_fbm_ctrlb_tg_fbm_ctrlb_via_tg_fbs_ctrl_tg_fbs_ctrl_via_tg_s_ctrlb_tg_s_ctrlb_via_t11
+ a|clk|ctrl|ctrlb|inv_clk_a|inv_clk_clk_via|tg_d_ctrl|tg_d_ctrl_via|tg_fbm_ctrlb|tg_fbm_ctrlb_via|tg_fbs_ctrl|tg_fbs_ctrl_via|tg_s_ctrlb|tg_s_ctrlb_via__t11
+ a|clk|ctrl|ctrlb|inv_clk_a|inv_clk_clk_via|tg_d_ctrl|tg_d_ctrl_via|tg_fbm_ctrlb|tg_fbm_ctrlb_via|tg_fbs_ctrl|tg_fbs_ctrl_via|tg_s_ctrlb|tg_s_ctrlb_via
+ 239.058041854
* device instance a_clk_ctrl_ctrlb_inv_clk_a_inv_clk_clk_via_tg_d_ctrl_tg_d_ctrl_via_tg_fbm_ctrlb_tg_fbm_ctrlb_via_tg_fbs_ctrl_tg_fbs_ctrl_via_tg_s_ctrlb_tg_s_ctrlb_via_t12 r0 *1 0,0
Ra_clk_ctrl_ctrlb_inv_clk_a_inv_clk_clk_via_tg_d_ctrl_tg_d_ctrl_via_tg_fbm_ctrlb_tg_fbm_ctrlb_via_tg_fbs_ctrl_tg_fbs_ctrl_via_tg_s_ctrlb_tg_s_ctrlb_via_t12
+ a|clk|ctrl|ctrlb|inv_clk_a|inv_clk_clk_via|tg_d_ctrl|tg_d_ctrl_via|tg_fbm_ctrlb|tg_fbm_ctrlb_via|tg_fbs_ctrl|tg_fbs_ctrl_via|tg_s_ctrlb|tg_s_ctrlb_via__t12
+ a|clk|ctrl|ctrlb|inv_clk_a|inv_clk_clk_via|tg_d_ctrl|tg_d_ctrl_via|tg_fbm_ctrlb|tg_fbm_ctrlb_via|tg_fbs_ctrl|tg_fbs_ctrl_via|tg_s_ctrlb|tg_s_ctrlb_via
+ 130.768401154
* device instance a_clk_ctrl_ctrlb_inv_clk_a_inv_clk_clk_via_tg_d_ctrl_tg_d_ctrl_via_tg_fbm_ctrlb_tg_fbm_ctrlb_via_tg_fbs_ctrl_tg_fbs_ctrl_via_tg_s_ctrlb_tg_s_ctrlb_via_t13 r0 *1 0,0
Ra_clk_ctrl_ctrlb_inv_clk_a_inv_clk_clk_via_tg_d_ctrl_tg_d_ctrl_via_tg_fbm_ctrlb_tg_fbm_ctrlb_via_tg_fbs_ctrl_tg_fbs_ctrl_via_tg_s_ctrlb_tg_s_ctrlb_via_t13
+ a|clk|ctrl|ctrlb|inv_clk_a|inv_clk_clk_via|tg_d_ctrl|tg_d_ctrl_via|tg_fbm_ctrlb|tg_fbm_ctrlb_via|tg_fbs_ctrl|tg_fbs_ctrl_via|tg_s_ctrlb|tg_s_ctrlb_via__t13
+ a|clk|ctrl|ctrlb|inv_clk_a|inv_clk_clk_via|tg_d_ctrl|tg_d_ctrl_via|tg_fbm_ctrlb|tg_fbm_ctrlb_via|tg_fbs_ctrl|tg_fbs_ctrl_via|tg_s_ctrlb|tg_s_ctrlb_via
+ 174.728821408
* device instance a_clk_ctrl_ctrlb_inv_clk_a_inv_clk_clk_via_tg_d_ctrl_tg_d_ctrl_via_tg_fbm_ctrlb_tg_fbm_ctrlb_via_tg_fbs_ctrl_tg_fbs_ctrl_via_tg_s_ctrlb_tg_s_ctrlb_via_t14 r0 *1 0,0
Ra_clk_ctrl_ctrlb_inv_clk_a_inv_clk_clk_via_tg_d_ctrl_tg_d_ctrl_via_tg_fbm_ctrlb_tg_fbm_ctrlb_via_tg_fbs_ctrl_tg_fbs_ctrl_via_tg_s_ctrlb_tg_s_ctrlb_via_t14
+ a|clk|ctrl|ctrlb|inv_clk_a|inv_clk_clk_via|tg_d_ctrl|tg_d_ctrl_via|tg_fbm_ctrlb|tg_fbm_ctrlb_via|tg_fbs_ctrl|tg_fbs_ctrl_via|tg_s_ctrlb|tg_s_ctrlb_via__t14
+ a|clk|ctrl|ctrlb|inv_clk_a|inv_clk_clk_via|tg_d_ctrl|tg_d_ctrl_via|tg_fbm_ctrlb|tg_fbm_ctrlb_via|tg_fbs_ctrl|tg_fbs_ctrl_via|tg_s_ctrlb|tg_s_ctrlb_via
+ 162.926752786
* device instance a_clk_ctrl_ctrlb_inv_clk_a_inv_clk_clk_via_tg_d_ctrl_tg_d_ctrl_via_tg_fbm_ctrlb_tg_fbm_ctrlb_via_tg_fbs_ctrl_tg_fbs_ctrl_via_tg_s_ctrlb_tg_s_ctrlb_via_t15 r0 *1 0,0
Ra_clk_ctrl_ctrlb_inv_clk_a_inv_clk_clk_via_tg_d_ctrl_tg_d_ctrl_via_tg_fbm_ctrlb_tg_fbm_ctrlb_via_tg_fbs_ctrl_tg_fbs_ctrl_via_tg_s_ctrlb_tg_s_ctrlb_via_t15
+ a|clk|ctrl|ctrlb|inv_clk_a|inv_clk_clk_via|tg_d_ctrl|tg_d_ctrl_via|tg_fbm_ctrlb|tg_fbm_ctrlb_via|tg_fbs_ctrl|tg_fbs_ctrl_via|tg_s_ctrlb|tg_s_ctrlb_via__t15
+ a|clk|ctrl|ctrlb|inv_clk_a|inv_clk_clk_via|tg_d_ctrl|tg_d_ctrl_via|tg_fbm_ctrlb|tg_fbm_ctrlb_via|tg_fbs_ctrl|tg_fbs_ctrl_via|tg_s_ctrlb|tg_s_ctrlb_via
+ 145.15661344
* device instance a_clk_ctrl_ctrlb_inv_clk_a_inv_clk_clk_via_tg_d_ctrl_tg_d_ctrl_via_tg_fbm_ctrlb_tg_fbm_ctrlb_via_tg_fbs_ctrl_tg_fbs_ctrl_via_tg_s_ctrlb_tg_s_ctrlb_via_t16 r0 *1 0,0
Ra_clk_ctrl_ctrlb_inv_clk_a_inv_clk_clk_via_tg_d_ctrl_tg_d_ctrl_via_tg_fbm_ctrlb_tg_fbm_ctrlb_via_tg_fbs_ctrl_tg_fbs_ctrl_via_tg_s_ctrlb_tg_s_ctrlb_via_t16
+ a|clk|ctrl|ctrlb|inv_clk_a|inv_clk_clk_via|tg_d_ctrl|tg_d_ctrl_via|tg_fbm_ctrlb|tg_fbm_ctrlb_via|tg_fbs_ctrl|tg_fbs_ctrl_via|tg_s_ctrlb|tg_s_ctrlb_via__t16
+ a|clk|ctrl|ctrlb|inv_clk_a|inv_clk_clk_via|tg_d_ctrl|tg_d_ctrl_via|tg_fbm_ctrlb|tg_fbm_ctrlb_via|tg_fbs_ctrl|tg_fbs_ctrl_via|tg_s_ctrlb|tg_s_ctrlb_via
+ 8.28951392668
* device instance a_clk_ctrl_ctrlb_inv_clk_a_inv_clk_clk_via_tg_d_ctrl_tg_d_ctrl_via_tg_fbm_ctrlb_tg_fbm_ctrlb_via_tg_fbs_ctrl_tg_fbs_ctrl_via_tg_s_ctrlb_tg_s_ctrlb_via_t17 r0 *1 0,0
Ra_clk_ctrl_ctrlb_inv_clk_a_inv_clk_clk_via_tg_d_ctrl_tg_d_ctrl_via_tg_fbm_ctrlb_tg_fbm_ctrlb_via_tg_fbs_ctrl_tg_fbs_ctrl_via_tg_s_ctrlb_tg_s_ctrlb_via_t17
+ a|clk|ctrl|ctrlb|inv_clk_a|inv_clk_clk_via|tg_d_ctrl|tg_d_ctrl_via|tg_fbm_ctrlb|tg_fbm_ctrlb_via|tg_fbs_ctrl|tg_fbs_ctrl_via|tg_s_ctrlb|tg_s_ctrlb_via__t17
+ a|clk|ctrl|ctrlb|inv_clk_a|inv_clk_clk_via|tg_d_ctrl|tg_d_ctrl_via|tg_fbm_ctrlb|tg_fbm_ctrlb_via|tg_fbs_ctrl|tg_fbs_ctrl_via|tg_s_ctrlb|tg_s_ctrlb_via
+ 25.3101947672
* device instance a_clk_ctrl_ctrlb_inv_clk_a_inv_clk_clk_via_tg_d_ctrl_tg_d_ctrl_via_tg_fbm_ctrlb_tg_fbm_ctrlb_via_tg_fbs_ctrl_tg_fbs_ctrl_via_tg_s_ctrlb_tg_s_ctrlb_via_t18 r0 *1 0,0
Ra_clk_ctrl_ctrlb_inv_clk_a_inv_clk_clk_via_tg_d_ctrl_tg_d_ctrl_via_tg_fbm_ctrlb_tg_fbm_ctrlb_via_tg_fbs_ctrl_tg_fbs_ctrl_via_tg_s_ctrlb_tg_s_ctrlb_via_t18
+ a|clk|ctrl|ctrlb|inv_clk_a|inv_clk_clk_via|tg_d_ctrl|tg_d_ctrl_via|tg_fbm_ctrlb|tg_fbm_ctrlb_via|tg_fbs_ctrl|tg_fbs_ctrl_via|tg_s_ctrlb|tg_s_ctrlb_via__t18
+ a|clk|ctrl|ctrlb|inv_clk_a|inv_clk_clk_via|tg_d_ctrl|tg_d_ctrl_via|tg_fbm_ctrlb|tg_fbm_ctrlb_via|tg_fbs_ctrl|tg_fbs_ctrl_via|tg_s_ctrlb|tg_s_ctrlb_via
+ 37.0086214567
* device instance a_clk_ctrl_ctrlb_inv_clk_a_inv_clk_clk_via_tg_d_ctrl_tg_d_ctrl_via_tg_fbm_ctrlb_tg_fbm_ctrlb_via_tg_fbs_ctrl_tg_fbs_ctrl_via_tg_s_ctrlb_tg_s_ctrlb_via_t19 r0 *1 0,0
Ra_clk_ctrl_ctrlb_inv_clk_a_inv_clk_clk_via_tg_d_ctrl_tg_d_ctrl_via_tg_fbm_ctrlb_tg_fbm_ctrlb_via_tg_fbs_ctrl_tg_fbs_ctrl_via_tg_s_ctrlb_tg_s_ctrlb_via_t19
+ a|clk|ctrl|ctrlb|inv_clk_a|inv_clk_clk_via|tg_d_ctrl|tg_d_ctrl_via|tg_fbm_ctrlb|tg_fbm_ctrlb_via|tg_fbs_ctrl|tg_fbs_ctrl_via|tg_s_ctrlb|tg_s_ctrlb_via__t19
+ a|clk|ctrl|ctrlb|inv_clk_a|inv_clk_clk_via|tg_d_ctrl|tg_d_ctrl_via|tg_fbm_ctrlb|tg_fbm_ctrlb_via|tg_fbs_ctrl|tg_fbs_ctrl_via|tg_s_ctrlb|tg_s_ctrlb_via
+ 222.51056845
* device instance a_clk_ctrl_ctrlb_inv_clk_a_inv_clk_clk_via_tg_d_ctrl_tg_d_ctrl_via_tg_fbm_ctrlb_tg_fbm_ctrlb_via_tg_fbs_ctrl_tg_fbs_ctrl_via_tg_s_ctrlb_tg_s_ctrlb_via_t20 r0 *1 0,0
Ra_clk_ctrl_ctrlb_inv_clk_a_inv_clk_clk_via_tg_d_ctrl_tg_d_ctrl_via_tg_fbm_ctrlb_tg_fbm_ctrlb_via_tg_fbs_ctrl_tg_fbs_ctrl_via_tg_s_ctrlb_tg_s_ctrlb_via_t20
+ a|clk|ctrl|ctrlb|inv_clk_a|inv_clk_clk_via|tg_d_ctrl|tg_d_ctrl_via|tg_fbm_ctrlb|tg_fbm_ctrlb_via|tg_fbs_ctrl|tg_fbs_ctrl_via|tg_s_ctrlb|tg_s_ctrlb_via__t20
+ a|clk|ctrl|ctrlb|inv_clk_a|inv_clk_clk_via|tg_d_ctrl|tg_d_ctrl_via|tg_fbm_ctrlb|tg_fbm_ctrlb_via|tg_fbs_ctrl|tg_fbs_ctrl_via|tg_s_ctrlb|tg_s_ctrlb_via
+ 162.926752786
* device instance a_clk_ctrl_ctrlb_inv_clk_a_inv_clk_clk_via_tg_d_ctrl_tg_d_ctrl_via_tg_fbm_ctrlb_tg_fbm_ctrlb_via_tg_fbs_ctrl_tg_fbs_ctrl_via_tg_s_ctrlb_tg_s_ctrlb_via_t21 r0 *1 0,0
Ra_clk_ctrl_ctrlb_inv_clk_a_inv_clk_clk_via_tg_d_ctrl_tg_d_ctrl_via_tg_fbm_ctrlb_tg_fbm_ctrlb_via_tg_fbs_ctrl_tg_fbs_ctrl_via_tg_s_ctrlb_tg_s_ctrlb_via_t21
+ a|clk|ctrl|ctrlb|inv_clk_a|inv_clk_clk_via|tg_d_ctrl|tg_d_ctrl_via|tg_fbm_ctrlb|tg_fbm_ctrlb_via|tg_fbs_ctrl|tg_fbs_ctrl_via|tg_s_ctrlb|tg_s_ctrlb_via__t21
+ a|clk|ctrl|ctrlb|inv_clk_a|inv_clk_clk_via|tg_d_ctrl|tg_d_ctrl_via|tg_fbm_ctrlb|tg_fbm_ctrlb_via|tg_fbs_ctrl|tg_fbs_ctrl_via|tg_s_ctrlb|tg_s_ctrlb_via
+ 97.3930697106
* device instance a_clk_ctrl_ctrlb_inv_clk_a_inv_clk_clk_via_tg_d_ctrl_tg_d_ctrl_via_tg_fbm_ctrlb_tg_fbm_ctrlb_via_tg_fbs_ctrl_tg_fbs_ctrl_via_tg_s_ctrlb_tg_s_ctrlb_via_t22 r0 *1 0,0
Ra_clk_ctrl_ctrlb_inv_clk_a_inv_clk_clk_via_tg_d_ctrl_tg_d_ctrl_via_tg_fbm_ctrlb_tg_fbm_ctrlb_via_tg_fbs_ctrl_tg_fbs_ctrl_via_tg_s_ctrlb_tg_s_ctrlb_via_t22
+ a|clk|ctrl|ctrlb|inv_clk_a|inv_clk_clk_via|tg_d_ctrl|tg_d_ctrl_via|tg_fbm_ctrlb|tg_fbm_ctrlb_via|tg_fbs_ctrl|tg_fbs_ctrl_via|tg_s_ctrlb|tg_s_ctrlb_via__t22
+ a|clk|ctrl|ctrlb|inv_clk_a|inv_clk_clk_via|tg_d_ctrl|tg_d_ctrl_via|tg_fbm_ctrlb|tg_fbm_ctrlb_via|tg_fbs_ctrl|tg_fbs_ctrl_via|tg_s_ctrlb|tg_s_ctrlb_via
+ 84.6714753446
* device instance a_clk_ctrl_ctrlb_inv_clk_a_inv_clk_clk_via_tg_d_ctrl_tg_d_ctrl_via_tg_fbm_ctrlb_tg_fbm_ctrlb_via_tg_fbs_ctrl_tg_fbs_ctrl_via_tg_s_ctrlb_tg_s_ctrlb_via_t23 r0 *1 0,0
Ra_clk_ctrl_ctrlb_inv_clk_a_inv_clk_clk_via_tg_d_ctrl_tg_d_ctrl_via_tg_fbm_ctrlb_tg_fbm_ctrlb_via_tg_fbs_ctrl_tg_fbs_ctrl_via_tg_s_ctrlb_tg_s_ctrlb_via_t23
+ a|clk|ctrl|ctrlb|inv_clk_a|inv_clk_clk_via|tg_d_ctrl|tg_d_ctrl_via|tg_fbm_ctrlb|tg_fbm_ctrlb_via|tg_fbs_ctrl|tg_fbs_ctrl_via|tg_s_ctrlb|tg_s_ctrlb_via__t23
+ a|clk|ctrl|ctrlb|inv_clk_a|inv_clk_clk_via|tg_d_ctrl|tg_d_ctrl_via|tg_fbm_ctrlb|tg_fbm_ctrlb_via|tg_fbs_ctrl|tg_fbs_ctrl_via|tg_s_ctrlb|tg_s_ctrlb_via
+ 25.3101947672
* device instance a_clk_ctrl_ctrlb_inv_clk_a_inv_clk_clk_via_tg_d_ctrl_tg_d_ctrl_via_tg_fbm_ctrlb_tg_fbm_ctrlb_via_tg_fbs_ctrl_tg_fbs_ctrl_via_tg_s_ctrlb_tg_s_ctrlb_via_t24 r0 *1 0,0
Ra_clk_ctrl_ctrlb_inv_clk_a_inv_clk_clk_via_tg_d_ctrl_tg_d_ctrl_via_tg_fbm_ctrlb_tg_fbm_ctrlb_via_tg_fbs_ctrl_tg_fbs_ctrl_via_tg_s_ctrlb_tg_s_ctrlb_via_t24
+ a|clk|ctrl|ctrlb|inv_clk_a|inv_clk_clk_via|tg_d_ctrl|tg_d_ctrl_via|tg_fbm_ctrlb|tg_fbm_ctrlb_via|tg_fbs_ctrl|tg_fbs_ctrl_via|tg_s_ctrlb|tg_s_ctrlb_via__t24
+ a|clk|ctrl|ctrlb|inv_clk_a|inv_clk_clk_via|tg_d_ctrl|tg_d_ctrl_via|tg_fbm_ctrlb|tg_fbm_ctrlb_via|tg_fbs_ctrl|tg_fbs_ctrl_via|tg_s_ctrlb|tg_s_ctrlb_via
+ 235.243172332
* device instance a_clk_ctrl_ctrlb_inv_clk_a_inv_clk_clk_via_tg_d_ctrl_tg_d_ctrl_via_tg_fbm_ctrlb_tg_fbm_ctrlb_via_tg_fbs_ctrl_tg_fbs_ctrl_via_tg_s_ctrlb_tg_s_ctrlb_via_t25 r0 *1 0,0
Ra_clk_ctrl_ctrlb_inv_clk_a_inv_clk_clk_via_tg_d_ctrl_tg_d_ctrl_via_tg_fbm_ctrlb_tg_fbm_ctrlb_via_tg_fbs_ctrl_tg_fbs_ctrl_via_tg_s_ctrlb_tg_s_ctrlb_via_t25
+ a|clk|ctrl|ctrlb|inv_clk_a|inv_clk_clk_via|tg_d_ctrl|tg_d_ctrl_via|tg_fbm_ctrlb|tg_fbm_ctrlb_via|tg_fbs_ctrl|tg_fbs_ctrl_via|tg_s_ctrlb|tg_s_ctrlb_via__t25
+ a|clk|ctrl|ctrlb|inv_clk_a|inv_clk_clk_via|tg_d_ctrl|tg_d_ctrl_via|tg_fbm_ctrlb|tg_fbm_ctrlb_via|tg_fbs_ctrl|tg_fbs_ctrl_via|tg_s_ctrlb|tg_s_ctrlb_via
+ 300.803977152
* device instance a_clk_ctrl_ctrlb_inv_clk_a_inv_clk_clk_via_tg_d_ctrl_tg_d_ctrl_via_tg_fbm_ctrlb_tg_fbm_ctrlb_via_tg_fbs_ctrl_tg_fbs_ctrl_via_tg_s_ctrlb_tg_s_ctrlb_via_t26 r0 *1 0,0
Ra_clk_ctrl_ctrlb_inv_clk_a_inv_clk_clk_via_tg_d_ctrl_tg_d_ctrl_via_tg_fbm_ctrlb_tg_fbm_ctrlb_via_tg_fbs_ctrl_tg_fbs_ctrl_via_tg_s_ctrlb_tg_s_ctrlb_via_t26
+ a|clk|ctrl|ctrlb|inv_clk_a|inv_clk_clk_via|tg_d_ctrl|tg_d_ctrl_via|tg_fbm_ctrlb|tg_fbm_ctrlb_via|tg_fbs_ctrl|tg_fbs_ctrl_via|tg_s_ctrlb|tg_s_ctrlb_via__t26
+ a|clk|ctrl|ctrlb|inv_clk_a|inv_clk_clk_via|tg_d_ctrl|tg_d_ctrl_via|tg_fbm_ctrlb|tg_fbm_ctrlb_via|tg_fbs_ctrl|tg_fbs_ctrl_via|tg_s_ctrlb|tg_s_ctrlb_via
+ 360.397048393
* device instance a_clk_ctrl_ctrlb_inv_clk_a_inv_clk_clk_via_tg_d_ctrl_tg_d_ctrl_via_tg_fbm_ctrlb_tg_fbm_ctrlb_via_tg_fbs_ctrl_tg_fbs_ctrl_via_tg_s_ctrlb_tg_s_ctrlb_via_t27 r0 *1 0,0
Ra_clk_ctrl_ctrlb_inv_clk_a_inv_clk_clk_via_tg_d_ctrl_tg_d_ctrl_via_tg_fbm_ctrlb_tg_fbm_ctrlb_via_tg_fbs_ctrl_tg_fbs_ctrl_via_tg_s_ctrlb_tg_s_ctrlb_via_t27
+ a|clk|ctrl|ctrlb|inv_clk_a|inv_clk_clk_via|tg_d_ctrl|tg_d_ctrl_via|tg_fbm_ctrlb|tg_fbm_ctrlb_via|tg_fbs_ctrl|tg_fbs_ctrl_via|tg_s_ctrlb|tg_s_ctrlb_via__t27
+ a|clk|ctrl|ctrlb|inv_clk_a|inv_clk_clk_via|tg_d_ctrl|tg_d_ctrl_via|tg_fbm_ctrlb|tg_fbm_ctrlb_via|tg_fbs_ctrl|tg_fbs_ctrl_via|tg_s_ctrlb|tg_s_ctrlb_via
+ 373.130909083
* device instance a_clk_ctrl_ctrlb_inv_clk_a_inv_clk_clk_via_tg_d_ctrl_tg_d_ctrl_via_tg_fbm_ctrlb_tg_fbm_ctrlb_via_tg_fbs_ctrl_tg_fbs_ctrl_via_tg_s_ctrlb_tg_s_ctrlb_via_t28 r0 *1 0,0
Ra_clk_ctrl_ctrlb_inv_clk_a_inv_clk_clk_via_tg_d_ctrl_tg_d_ctrl_via_tg_fbm_ctrlb_tg_fbm_ctrlb_via_tg_fbs_ctrl_tg_fbs_ctrl_via_tg_s_ctrlb_tg_s_ctrlb_via_t28
+ a|clk|ctrl|ctrlb|inv_clk_a|inv_clk_clk_via|tg_d_ctrl|tg_d_ctrl_via|tg_fbm_ctrlb|tg_fbm_ctrlb_via|tg_fbs_ctrl|tg_fbs_ctrl_via|tg_s_ctrlb|tg_s_ctrlb_via__t28
+ a|clk|ctrl|ctrlb|inv_clk_a|inv_clk_clk_via|tg_d_ctrl|tg_d_ctrl_via|tg_fbm_ctrlb|tg_fbm_ctrlb_via|tg_fbs_ctrl|tg_fbs_ctrl_via|tg_s_ctrlb|tg_s_ctrlb_via
+ 329.157236336
* device instance a_clk_ctrl_ctrlb_inv_clk_a_inv_clk_clk_via_tg_d_ctrl_tg_d_ctrl_via_tg_fbm_ctrlb_tg_fbm_ctrlb_via_tg_fbs_ctrl_tg_fbs_ctrl_via_tg_s_ctrlb_tg_s_ctrlb_via_t29 r0 *1 0,0
Ra_clk_ctrl_ctrlb_inv_clk_a_inv_clk_clk_via_tg_d_ctrl_tg_d_ctrl_via_tg_fbm_ctrlb_tg_fbm_ctrlb_via_tg_fbs_ctrl_tg_fbs_ctrl_via_tg_s_ctrlb_tg_s_ctrlb_via_t29
+ a|clk|ctrl|ctrlb|inv_clk_a|inv_clk_clk_via|tg_d_ctrl|tg_d_ctrl_via|tg_fbm_ctrlb|tg_fbm_ctrlb_via|tg_fbs_ctrl|tg_fbs_ctrl_via|tg_s_ctrlb|tg_s_ctrlb_via__t29
+ a|clk|ctrl|ctrlb|inv_clk_a|inv_clk_clk_via|tg_d_ctrl|tg_d_ctrl_via|tg_fbm_ctrlb|tg_fbm_ctrlb_via|tg_fbs_ctrl|tg_fbs_ctrl_via|tg_s_ctrlb|tg_s_ctrlb_via
+ 316.42360883
* device instance a_clk_ctrl_ctrlb_inv_clk_a_inv_clk_clk_via_tg_d_ctrl_tg_d_ctrl_via_tg_fbm_ctrlb_tg_fbm_ctrlb_via_tg_fbs_ctrl_tg_fbs_ctrl_via_tg_s_ctrlb_tg_s_ctrlb_via_t30 r0 *1 0,0
Ra_clk_ctrl_ctrlb_inv_clk_a_inv_clk_clk_via_tg_d_ctrl_tg_d_ctrl_via_tg_fbm_ctrlb_tg_fbm_ctrlb_via_tg_fbs_ctrl_tg_fbs_ctrl_via_tg_s_ctrlb_tg_s_ctrlb_via_t30
+ a|clk|ctrl|ctrlb|inv_clk_a|inv_clk_clk_via|tg_d_ctrl|tg_d_ctrl_via|tg_fbm_ctrlb|tg_fbm_ctrlb_via|tg_fbs_ctrl|tg_fbs_ctrl_via|tg_s_ctrlb|tg_s_ctrlb_via__t30
+ a|clk|ctrl|ctrlb|inv_clk_a|inv_clk_clk_via|tg_d_ctrl|tg_d_ctrl_via|tg_fbm_ctrlb|tg_fbm_ctrlb_via|tg_fbs_ctrl|tg_fbs_ctrl_via|tg_s_ctrlb|tg_s_ctrlb_via
+ 250.861953236
* device instance a_clk_ctrl_ctrlb_inv_clk_a_inv_clk_clk_via_tg_d_ctrl_tg_d_ctrl_via_tg_fbm_ctrlb_tg_fbm_ctrlb_via_tg_fbs_ctrl_tg_fbs_ctrl_via_tg_s_ctrlb_tg_s_ctrlb_via_t31 r0 *1 0,0
Ra_clk_ctrl_ctrlb_inv_clk_a_inv_clk_clk_via_tg_d_ctrl_tg_d_ctrl_via_tg_fbm_ctrlb_tg_fbm_ctrlb_via_tg_fbs_ctrl_tg_fbs_ctrl_via_tg_s_ctrlb_tg_s_ctrlb_via_t31
+ a|clk|ctrl|ctrlb|inv_clk_a|inv_clk_clk_via|tg_d_ctrl|tg_d_ctrl_via|tg_fbm_ctrlb|tg_fbm_ctrlb_via|tg_fbs_ctrl|tg_fbs_ctrl_via|tg_s_ctrlb|tg_s_ctrlb_via__t31
+ a|clk|ctrl|ctrlb|inv_clk_a|inv_clk_clk_via|tg_d_ctrl|tg_d_ctrl_via|tg_fbm_ctrlb|tg_fbm_ctrlb_via|tg_fbs_ctrl|tg_fbs_ctrl_via|tg_s_ctrlb|tg_s_ctrlb_via
+ 191.274737791
* device instance a_clk_ctrl_ctrlb_inv_clk_a_inv_clk_clk_via_tg_d_ctrl_tg_d_ctrl_via_tg_fbm_ctrlb_tg_fbm_ctrlb_via_tg_fbs_ctrl_tg_fbs_ctrl_via_tg_s_ctrlb_tg_s_ctrlb_via_t32 r0 *1 0,0
Ra_clk_ctrl_ctrlb_inv_clk_a_inv_clk_clk_via_tg_d_ctrl_tg_d_ctrl_via_tg_fbm_ctrlb_tg_fbm_ctrlb_via_tg_fbs_ctrl_tg_fbs_ctrl_via_tg_s_ctrlb_tg_s_ctrlb_via_t32
+ a|clk|ctrl|ctrlb|inv_clk_a|inv_clk_clk_via|tg_d_ctrl|tg_d_ctrl_via|tg_fbm_ctrlb|tg_fbm_ctrlb_via|tg_fbs_ctrl|tg_fbs_ctrl_via|tg_s_ctrlb|tg_s_ctrlb_via__t32
+ a|clk|ctrl|ctrlb|inv_clk_a|inv_clk_clk_via|tg_d_ctrl|tg_d_ctrl_via|tg_fbm_ctrlb|tg_fbm_ctrlb_via|tg_fbs_ctrl|tg_fbs_ctrl_via|tg_s_ctrlb|tg_s_ctrlb_via
+ 40.8026348421
* device instance a_clk_ctrl_ctrlb_inv_clk_a_inv_clk_clk_via_tg_d_ctrl_tg_d_ctrl_via_tg_fbm_ctrlb_tg_fbm_ctrlb_via_tg_fbs_ctrl_tg_fbs_ctrl_via_tg_s_ctrlb_tg_s_ctrlb_via_t33 r0 *1 0,0
Ra_clk_ctrl_ctrlb_inv_clk_a_inv_clk_clk_via_tg_d_ctrl_tg_d_ctrl_via_tg_fbm_ctrlb_tg_fbm_ctrlb_via_tg_fbs_ctrl_tg_fbs_ctrl_via_tg_s_ctrlb_tg_s_ctrlb_via_t33
+ a|clk|ctrl|ctrlb|inv_clk_a|inv_clk_clk_via|tg_d_ctrl|tg_d_ctrl_via|tg_fbm_ctrlb|tg_fbm_ctrlb_via|tg_fbs_ctrl|tg_fbs_ctrl_via|tg_s_ctrlb|tg_s_ctrlb_via__t33
+ a|clk|ctrl|ctrlb|inv_clk_a|inv_clk_clk_via|tg_d_ctrl|tg_d_ctrl_via|tg_fbm_ctrlb|tg_fbm_ctrlb_via|tg_fbs_ctrl|tg_fbs_ctrl_via|tg_s_ctrlb|tg_s_ctrlb_via
+ 53.4878442761
* device instance a_clk_ctrl_ctrlb_inv_clk_a_inv_clk_clk_via_tg_d_ctrl_tg_d_ctrl_via_tg_fbm_ctrlb_tg_fbm_ctrlb_via_tg_fbs_ctrl_tg_fbs_ctrl_via_tg_s_ctrlb_tg_s_ctrlb_via_t34 r0 *1 0,0
Ra_clk_ctrl_ctrlb_inv_clk_a_inv_clk_clk_via_tg_d_ctrl_tg_d_ctrl_via_tg_fbm_ctrlb_tg_fbm_ctrlb_via_tg_fbs_ctrl_tg_fbs_ctrl_via_tg_s_ctrlb_tg_s_ctrlb_via_t34
+ a|clk|ctrl|ctrlb|inv_clk_a|inv_clk_clk_via|tg_d_ctrl|tg_d_ctrl_via|tg_fbm_ctrlb|tg_fbm_ctrlb_via|tg_fbs_ctrl|tg_fbs_ctrl_via|tg_s_ctrlb|tg_s_ctrlb_via__t34
+ a|clk|ctrl|ctrlb|inv_clk_a|inv_clk_clk_via|tg_d_ctrl|tg_d_ctrl_via|tg_fbm_ctrlb|tg_fbm_ctrlb_via|tg_fbs_ctrl|tg_fbs_ctrl_via|tg_s_ctrlb|tg_s_ctrlb_via
+ 113.002080638
* device instance a_clk_ctrl_ctrlb_inv_clk_a_inv_clk_clk_via_tg_d_ctrl_tg_d_ctrl_via_tg_fbm_ctrlb_tg_fbm_ctrlb_via_tg_fbs_ctrl_tg_fbs_ctrl_via_tg_s_ctrlb_tg_s_ctrlb_via_t35 r0 *1 0,0
Ra_clk_ctrl_ctrlb_inv_clk_a_inv_clk_clk_via_tg_d_ctrl_tg_d_ctrl_via_tg_fbm_ctrlb_tg_fbm_ctrlb_via_tg_fbs_ctrl_tg_fbs_ctrl_via_tg_s_ctrlb_tg_s_ctrlb_via_t35
+ a|clk|ctrl|ctrlb|inv_clk_a|inv_clk_clk_via|tg_d_ctrl|tg_d_ctrl_via|tg_fbm_ctrlb|tg_fbm_ctrlb_via|tg_fbs_ctrl|tg_fbs_ctrl_via|tg_s_ctrlb|tg_s_ctrlb_via__t35
+ a|clk|ctrl|ctrlb|inv_clk_a|inv_clk_clk_via|tg_d_ctrl|tg_d_ctrl_via|tg_fbm_ctrlb|tg_fbm_ctrlb_via|tg_fbs_ctrl|tg_fbs_ctrl_via|tg_s_ctrlb|tg_s_ctrlb_via
+ 178.543230272
* device instance a_clk_ctrl_ctrlb_inv_clk_a_inv_clk_clk_via_tg_d_ctrl_tg_d_ctrl_via_tg_fbm_ctrlb_tg_fbm_ctrlb_via_tg_fbs_ctrl_tg_fbs_ctrl_via_tg_s_ctrlb_tg_s_ctrlb_via r0 *1 0,0
Ca_clk_ctrl_ctrlb_inv_clk_a_inv_clk_clk_via_tg_d_ctrl_tg_d_ctrl_via_tg_fbm_ctrlb_tg_fbm_ctrlb_via_tg_fbs_ctrl_tg_fbs_ctrl_via_tg_s_ctrlb_tg_s_ctrlb_via
+ a|clk|ctrl|ctrlb|inv_clk_a|inv_clk_clk_via|tg_d_ctrl|tg_d_ctrl_via|tg_fbm_ctrlb|tg_fbm_ctrlb_via|tg_fbs_ctrl|tg_fbs_ctrl_via|tg_s_ctrlb|tg_s_ctrlb_via
+ vsubs 4.7831927e-14
* device instance a_d_inv_clk_vdd_inv_mc_vdd_inv_q_vdd_mpa_py_mpb_py_nand_m_vdd_nand_s2_vdd_nwell_vdd_sb_vdd_sr1_vdd_sr2_vdd_sr3_vdd_sr4_vdd_sv_d_vdd_tie_sv_vdd_tg_d_a_tg_d_vdd_tg_fbm_vdd_tg_fbs_vdd_tg_s_vdd_vdd_vdd_b1_vdd_b2_vdd_b3_vdd_b4_vdd_link_vdd_link_dip_vdd_x1_vdd_x2_vdd_x3_t0 r0 *1 0,0
Ra_d_inv_clk_vdd_inv_mc_vdd_inv_q_vdd_mpa_py_mpb_py_nand_m_vdd_nand_s2_vdd_nwell_vdd_sb_vdd_sr1_vdd_sr2_vdd_sr3_vdd_sr4_vdd_sv_d_vdd_tie_sv_vdd_tg_d_a_tg_d_vdd_tg_fbm_vdd_tg_fbs_vdd_tg_s_vdd_vdd_vdd_b1_vdd_b2_vdd_b3_vdd_b4_vdd_link_vdd_link_dip_vdd_x1_vdd_x2_vdd_x3_t0
+ a|d|inv_clk_vdd|inv_mc_vdd|inv_q_vdd|mpa_py|mpb_py|nand_m_vdd|nand_s2_vdd|nwell_vdd|sb_vdd|sr1_vdd|sr2_vdd|sr3_vdd|sr4_vdd|sv_d_vdd_tie|sv_vdd|tg_d_a|tg_d_vdd|tg_fbm_vdd|tg_fbs_vdd|tg_s_vdd|vdd|vdd_b1|vdd_b2|vdd_b3|vdd_b4|vdd_link|vdd_link_dip|vdd_x1|vdd_x2|vdd_x3__t0
+ a|d|inv_clk_vdd|inv_mc_vdd|inv_q_vdd|mpa_py|mpb_py|nand_m_vdd|nand_s2_vdd|nwell_vdd|sb_vdd|sr1_vdd|sr2_vdd|sr3_vdd|sr4_vdd|sv_d_vdd_tie|sv_vdd|tg_d_a|tg_d_vdd|tg_fbm_vdd|tg_fbs_vdd|tg_s_vdd|vdd|vdd_b1|vdd_b2|vdd_b3|vdd_b4|vdd_link|vdd_link_dip|vdd_x1|vdd_x2|vdd_x3
+ 199.396312919
* device instance a_d_inv_clk_vdd_inv_mc_vdd_inv_q_vdd_mpa_py_mpb_py_nand_m_vdd_nand_s2_vdd_nwell_vdd_sb_vdd_sr1_vdd_sr2_vdd_sr3_vdd_sr4_vdd_sv_d_vdd_tie_sv_vdd_tg_d_a_tg_d_vdd_tg_fbm_vdd_tg_fbs_vdd_tg_s_vdd_vdd_vdd_b1_vdd_b2_vdd_b3_vdd_b4_vdd_link_vdd_link_dip_vdd_x1_vdd_x2_vdd_x3_t1 r0 *1 0,0
Ra_d_inv_clk_vdd_inv_mc_vdd_inv_q_vdd_mpa_py_mpb_py_nand_m_vdd_nand_s2_vdd_nwell_vdd_sb_vdd_sr1_vdd_sr2_vdd_sr3_vdd_sr4_vdd_sv_d_vdd_tie_sv_vdd_tg_d_a_tg_d_vdd_tg_fbm_vdd_tg_fbs_vdd_tg_s_vdd_vdd_vdd_b1_vdd_b2_vdd_b3_vdd_b4_vdd_link_vdd_link_dip_vdd_x1_vdd_x2_vdd_x3_t1
+ a|d|inv_clk_vdd|inv_mc_vdd|inv_q_vdd|mpa_py|mpb_py|nand_m_vdd|nand_s2_vdd|nwell_vdd|sb_vdd|sr1_vdd|sr2_vdd|sr3_vdd|sr4_vdd|sv_d_vdd_tie|sv_vdd|tg_d_a|tg_d_vdd|tg_fbm_vdd|tg_fbs_vdd|tg_s_vdd|vdd|vdd_b1|vdd_b2|vdd_b3|vdd_b4|vdd_link|vdd_link_dip|vdd_x1|vdd_x2|vdd_x3__t1
+ a|d|inv_clk_vdd|inv_mc_vdd|inv_q_vdd|mpa_py|mpb_py|nand_m_vdd|nand_s2_vdd|nwell_vdd|sb_vdd|sr1_vdd|sr2_vdd|sr3_vdd|sr4_vdd|sv_d_vdd_tie|sv_vdd|tg_d_a|tg_d_vdd|tg_fbm_vdd|tg_fbs_vdd|tg_s_vdd|vdd|vdd_b1|vdd_b2|vdd_b3|vdd_b4|vdd_link|vdd_link_dip|vdd_x1|vdd_x2|vdd_x3
+ 199.396312919
* device instance a_d_inv_clk_vdd_inv_mc_vdd_inv_q_vdd_mpa_py_mpb_py_nand_m_vdd_nand_s2_vdd_nwell_vdd_sb_vdd_sr1_vdd_sr2_vdd_sr3_vdd_sr4_vdd_sv_d_vdd_tie_sv_vdd_tg_d_a_tg_d_vdd_tg_fbm_vdd_tg_fbs_vdd_tg_s_vdd_vdd_vdd_b1_vdd_b2_vdd_b3_vdd_b4_vdd_link_vdd_link_dip_vdd_x1_vdd_x2_vdd_x3_t2 r0 *1 0,0
Ra_d_inv_clk_vdd_inv_mc_vdd_inv_q_vdd_mpa_py_mpb_py_nand_m_vdd_nand_s2_vdd_nwell_vdd_sb_vdd_sr1_vdd_sr2_vdd_sr3_vdd_sr4_vdd_sv_d_vdd_tie_sv_vdd_tg_d_a_tg_d_vdd_tg_fbm_vdd_tg_fbs_vdd_tg_s_vdd_vdd_vdd_b1_vdd_b2_vdd_b3_vdd_b4_vdd_link_vdd_link_dip_vdd_x1_vdd_x2_vdd_x3_t2
+ a|d|inv_clk_vdd|inv_mc_vdd|inv_q_vdd|mpa_py|mpb_py|nand_m_vdd|nand_s2_vdd|nwell_vdd|sb_vdd|sr1_vdd|sr2_vdd|sr3_vdd|sr4_vdd|sv_d_vdd_tie|sv_vdd|tg_d_a|tg_d_vdd|tg_fbm_vdd|tg_fbs_vdd|tg_s_vdd|vdd|vdd_b1|vdd_b2|vdd_b3|vdd_b4|vdd_link|vdd_link_dip|vdd_x1|vdd_x2|vdd_x3__t2
+ a|d|inv_clk_vdd|inv_mc_vdd|inv_q_vdd|mpa_py|mpb_py|nand_m_vdd|nand_s2_vdd|nwell_vdd|sb_vdd|sr1_vdd|sr2_vdd|sr3_vdd|sr4_vdd|sv_d_vdd_tie|sv_vdd|tg_d_a|tg_d_vdd|tg_fbm_vdd|tg_fbs_vdd|tg_s_vdd|vdd|vdd_b1|vdd_b2|vdd_b3|vdd_b4|vdd_link|vdd_link_dip|vdd_x1|vdd_x2|vdd_x3
+ 195.698348688
* device instance a_d_inv_clk_vdd_inv_mc_vdd_inv_q_vdd_mpa_py_mpb_py_nand_m_vdd_nand_s2_vdd_nwell_vdd_sb_vdd_sr1_vdd_sr2_vdd_sr3_vdd_sr4_vdd_sv_d_vdd_tie_sv_vdd_tg_d_a_tg_d_vdd_tg_fbm_vdd_tg_fbs_vdd_tg_s_vdd_vdd_vdd_b1_vdd_b2_vdd_b3_vdd_b4_vdd_link_vdd_link_dip_vdd_x1_vdd_x2_vdd_x3_t3 r0 *1 0,0
Ra_d_inv_clk_vdd_inv_mc_vdd_inv_q_vdd_mpa_py_mpb_py_nand_m_vdd_nand_s2_vdd_nwell_vdd_sb_vdd_sr1_vdd_sr2_vdd_sr3_vdd_sr4_vdd_sv_d_vdd_tie_sv_vdd_tg_d_a_tg_d_vdd_tg_fbm_vdd_tg_fbs_vdd_tg_s_vdd_vdd_vdd_b1_vdd_b2_vdd_b3_vdd_b4_vdd_link_vdd_link_dip_vdd_x1_vdd_x2_vdd_x3_t3
+ a|d|inv_clk_vdd|inv_mc_vdd|inv_q_vdd|mpa_py|mpb_py|nand_m_vdd|nand_s2_vdd|nwell_vdd|sb_vdd|sr1_vdd|sr2_vdd|sr3_vdd|sr4_vdd|sv_d_vdd_tie|sv_vdd|tg_d_a|tg_d_vdd|tg_fbm_vdd|tg_fbs_vdd|tg_s_vdd|vdd|vdd_b1|vdd_b2|vdd_b3|vdd_b4|vdd_link|vdd_link_dip|vdd_x1|vdd_x2|vdd_x3__t3
+ a|d|inv_clk_vdd|inv_mc_vdd|inv_q_vdd|mpa_py|mpb_py|nand_m_vdd|nand_s2_vdd|nwell_vdd|sb_vdd|sr1_vdd|sr2_vdd|sr3_vdd|sr4_vdd|sv_d_vdd_tie|sv_vdd|tg_d_a|tg_d_vdd|tg_fbm_vdd|tg_fbs_vdd|tg_s_vdd|vdd|vdd_b1|vdd_b2|vdd_b3|vdd_b4|vdd_link|vdd_link_dip|vdd_x1|vdd_x2|vdd_x3
+ 195.698348688
* device instance a_d_inv_clk_vdd_inv_mc_vdd_inv_q_vdd_mpa_py_mpb_py_nand_m_vdd_nand_s2_vdd_nwell_vdd_sb_vdd_sr1_vdd_sr2_vdd_sr3_vdd_sr4_vdd_sv_d_vdd_tie_sv_vdd_tg_d_a_tg_d_vdd_tg_fbm_vdd_tg_fbs_vdd_tg_s_vdd_vdd_vdd_b1_vdd_b2_vdd_b3_vdd_b4_vdd_link_vdd_link_dip_vdd_x1_vdd_x2_vdd_x3_t4 r0 *1 0,0
Ra_d_inv_clk_vdd_inv_mc_vdd_inv_q_vdd_mpa_py_mpb_py_nand_m_vdd_nand_s2_vdd_nwell_vdd_sb_vdd_sr1_vdd_sr2_vdd_sr3_vdd_sr4_vdd_sv_d_vdd_tie_sv_vdd_tg_d_a_tg_d_vdd_tg_fbm_vdd_tg_fbs_vdd_tg_s_vdd_vdd_vdd_b1_vdd_b2_vdd_b3_vdd_b4_vdd_link_vdd_link_dip_vdd_x1_vdd_x2_vdd_x3_t4
+ a|d|inv_clk_vdd|inv_mc_vdd|inv_q_vdd|mpa_py|mpb_py|nand_m_vdd|nand_s2_vdd|nwell_vdd|sb_vdd|sr1_vdd|sr2_vdd|sr3_vdd|sr4_vdd|sv_d_vdd_tie|sv_vdd|tg_d_a|tg_d_vdd|tg_fbm_vdd|tg_fbs_vdd|tg_s_vdd|vdd|vdd_b1|vdd_b2|vdd_b3|vdd_b4|vdd_link|vdd_link_dip|vdd_x1|vdd_x2|vdd_x3__t4
+ a|d|inv_clk_vdd|inv_mc_vdd|inv_q_vdd|mpa_py|mpb_py|nand_m_vdd|nand_s2_vdd|nwell_vdd|sb_vdd|sr1_vdd|sr2_vdd|sr3_vdd|sr4_vdd|sv_d_vdd_tie|sv_vdd|tg_d_a|tg_d_vdd|tg_fbm_vdd|tg_fbs_vdd|tg_s_vdd|vdd|vdd_b1|vdd_b2|vdd_b3|vdd_b4|vdd_link|vdd_link_dip|vdd_x1|vdd_x2|vdd_x3
+ 194.749750182
* device instance a_d_inv_clk_vdd_inv_mc_vdd_inv_q_vdd_mpa_py_mpb_py_nand_m_vdd_nand_s2_vdd_nwell_vdd_sb_vdd_sr1_vdd_sr2_vdd_sr3_vdd_sr4_vdd_sv_d_vdd_tie_sv_vdd_tg_d_a_tg_d_vdd_tg_fbm_vdd_tg_fbs_vdd_tg_s_vdd_vdd_vdd_b1_vdd_b2_vdd_b3_vdd_b4_vdd_link_vdd_link_dip_vdd_x1_vdd_x2_vdd_x3_t5 r0 *1 0,0
Ra_d_inv_clk_vdd_inv_mc_vdd_inv_q_vdd_mpa_py_mpb_py_nand_m_vdd_nand_s2_vdd_nwell_vdd_sb_vdd_sr1_vdd_sr2_vdd_sr3_vdd_sr4_vdd_sv_d_vdd_tie_sv_vdd_tg_d_a_tg_d_vdd_tg_fbm_vdd_tg_fbs_vdd_tg_s_vdd_vdd_vdd_b1_vdd_b2_vdd_b3_vdd_b4_vdd_link_vdd_link_dip_vdd_x1_vdd_x2_vdd_x3_t5
+ a|d|inv_clk_vdd|inv_mc_vdd|inv_q_vdd|mpa_py|mpb_py|nand_m_vdd|nand_s2_vdd|nwell_vdd|sb_vdd|sr1_vdd|sr2_vdd|sr3_vdd|sr4_vdd|sv_d_vdd_tie|sv_vdd|tg_d_a|tg_d_vdd|tg_fbm_vdd|tg_fbs_vdd|tg_s_vdd|vdd|vdd_b1|vdd_b2|vdd_b3|vdd_b4|vdd_link|vdd_link_dip|vdd_x1|vdd_x2|vdd_x3__t5
+ a|d|inv_clk_vdd|inv_mc_vdd|inv_q_vdd|mpa_py|mpb_py|nand_m_vdd|nand_s2_vdd|nwell_vdd|sb_vdd|sr1_vdd|sr2_vdd|sr3_vdd|sr4_vdd|sv_d_vdd_tie|sv_vdd|tg_d_a|tg_d_vdd|tg_fbm_vdd|tg_fbs_vdd|tg_s_vdd|vdd|vdd_b1|vdd_b2|vdd_b3|vdd_b4|vdd_link|vdd_link_dip|vdd_x1|vdd_x2|vdd_x3
+ 105.721272036
* device instance a_d_inv_clk_vdd_inv_mc_vdd_inv_q_vdd_mpa_py_mpb_py_nand_m_vdd_nand_s2_vdd_nwell_vdd_sb_vdd_sr1_vdd_sr2_vdd_sr3_vdd_sr4_vdd_sv_d_vdd_tie_sv_vdd_tg_d_a_tg_d_vdd_tg_fbm_vdd_tg_fbs_vdd_tg_s_vdd_vdd_vdd_b1_vdd_b2_vdd_b3_vdd_b4_vdd_link_vdd_link_dip_vdd_x1_vdd_x2_vdd_x3_t6 r0 *1 0,0
Ra_d_inv_clk_vdd_inv_mc_vdd_inv_q_vdd_mpa_py_mpb_py_nand_m_vdd_nand_s2_vdd_nwell_vdd_sb_vdd_sr1_vdd_sr2_vdd_sr3_vdd_sr4_vdd_sv_d_vdd_tie_sv_vdd_tg_d_a_tg_d_vdd_tg_fbm_vdd_tg_fbs_vdd_tg_s_vdd_vdd_vdd_b1_vdd_b2_vdd_b3_vdd_b4_vdd_link_vdd_link_dip_vdd_x1_vdd_x2_vdd_x3_t6
+ a|d|inv_clk_vdd|inv_mc_vdd|inv_q_vdd|mpa_py|mpb_py|nand_m_vdd|nand_s2_vdd|nwell_vdd|sb_vdd|sr1_vdd|sr2_vdd|sr3_vdd|sr4_vdd|sv_d_vdd_tie|sv_vdd|tg_d_a|tg_d_vdd|tg_fbm_vdd|tg_fbs_vdd|tg_s_vdd|vdd|vdd_b1|vdd_b2|vdd_b3|vdd_b4|vdd_link|vdd_link_dip|vdd_x1|vdd_x2|vdd_x3__t6
+ a|d|inv_clk_vdd|inv_mc_vdd|inv_q_vdd|mpa_py|mpb_py|nand_m_vdd|nand_s2_vdd|nwell_vdd|sb_vdd|sr1_vdd|sr2_vdd|sr3_vdd|sr4_vdd|sv_d_vdd_tie|sv_vdd|tg_d_a|tg_d_vdd|tg_fbm_vdd|tg_fbs_vdd|tg_s_vdd|vdd|vdd_b1|vdd_b2|vdd_b3|vdd_b4|vdd_link|vdd_link_dip|vdd_x1|vdd_x2|vdd_x3
+ 144.312798732
* device instance a_d_inv_clk_vdd_inv_mc_vdd_inv_q_vdd_mpa_py_mpb_py_nand_m_vdd_nand_s2_vdd_nwell_vdd_sb_vdd_sr1_vdd_sr2_vdd_sr3_vdd_sr4_vdd_sv_d_vdd_tie_sv_vdd_tg_d_a_tg_d_vdd_tg_fbm_vdd_tg_fbs_vdd_tg_s_vdd_vdd_vdd_b1_vdd_b2_vdd_b3_vdd_b4_vdd_link_vdd_link_dip_vdd_x1_vdd_x2_vdd_x3_t7 r0 *1 0,0
Ra_d_inv_clk_vdd_inv_mc_vdd_inv_q_vdd_mpa_py_mpb_py_nand_m_vdd_nand_s2_vdd_nwell_vdd_sb_vdd_sr1_vdd_sr2_vdd_sr3_vdd_sr4_vdd_sv_d_vdd_tie_sv_vdd_tg_d_a_tg_d_vdd_tg_fbm_vdd_tg_fbs_vdd_tg_s_vdd_vdd_vdd_b1_vdd_b2_vdd_b3_vdd_b4_vdd_link_vdd_link_dip_vdd_x1_vdd_x2_vdd_x3_t7
+ a|d|inv_clk_vdd|inv_mc_vdd|inv_q_vdd|mpa_py|mpb_py|nand_m_vdd|nand_s2_vdd|nwell_vdd|sb_vdd|sr1_vdd|sr2_vdd|sr3_vdd|sr4_vdd|sv_d_vdd_tie|sv_vdd|tg_d_a|tg_d_vdd|tg_fbm_vdd|tg_fbs_vdd|tg_s_vdd|vdd|vdd_b1|vdd_b2|vdd_b3|vdd_b4|vdd_link|vdd_link_dip|vdd_x1|vdd_x2|vdd_x3__t7
+ a|d|inv_clk_vdd|inv_mc_vdd|inv_q_vdd|mpa_py|mpb_py|nand_m_vdd|nand_s2_vdd|nwell_vdd|sb_vdd|sr1_vdd|sr2_vdd|sr3_vdd|sr4_vdd|sv_d_vdd_tie|sv_vdd|tg_d_a|tg_d_vdd|tg_fbm_vdd|tg_fbs_vdd|tg_s_vdd|vdd|vdd_b1|vdd_b2|vdd_b3|vdd_b4|vdd_link|vdd_link_dip|vdd_x1|vdd_x2|vdd_x3
+ 184.649690647
* device instance a_d_inv_clk_vdd_inv_mc_vdd_inv_q_vdd_mpa_py_mpb_py_nand_m_vdd_nand_s2_vdd_nwell_vdd_sb_vdd_sr1_vdd_sr2_vdd_sr3_vdd_sr4_vdd_sv_d_vdd_tie_sv_vdd_tg_d_a_tg_d_vdd_tg_fbm_vdd_tg_fbs_vdd_tg_s_vdd_vdd_vdd_b1_vdd_b2_vdd_b3_vdd_b4_vdd_link_vdd_link_dip_vdd_x1_vdd_x2_vdd_x3_t8 r0 *1 0,0
Ra_d_inv_clk_vdd_inv_mc_vdd_inv_q_vdd_mpa_py_mpb_py_nand_m_vdd_nand_s2_vdd_nwell_vdd_sb_vdd_sr1_vdd_sr2_vdd_sr3_vdd_sr4_vdd_sv_d_vdd_tie_sv_vdd_tg_d_a_tg_d_vdd_tg_fbm_vdd_tg_fbs_vdd_tg_s_vdd_vdd_vdd_b1_vdd_b2_vdd_b3_vdd_b4_vdd_link_vdd_link_dip_vdd_x1_vdd_x2_vdd_x3_t8
+ a|d|inv_clk_vdd|inv_mc_vdd|inv_q_vdd|mpa_py|mpb_py|nand_m_vdd|nand_s2_vdd|nwell_vdd|sb_vdd|sr1_vdd|sr2_vdd|sr3_vdd|sr4_vdd|sv_d_vdd_tie|sv_vdd|tg_d_a|tg_d_vdd|tg_fbm_vdd|tg_fbs_vdd|tg_s_vdd|vdd|vdd_b1|vdd_b2|vdd_b3|vdd_b4|vdd_link|vdd_link_dip|vdd_x1|vdd_x2|vdd_x3__t8
+ a|d|inv_clk_vdd|inv_mc_vdd|inv_q_vdd|mpa_py|mpb_py|nand_m_vdd|nand_s2_vdd|nwell_vdd|sb_vdd|sr1_vdd|sr2_vdd|sr3_vdd|sr4_vdd|sv_d_vdd_tie|sv_vdd|tg_d_a|tg_d_vdd|tg_fbm_vdd|tg_fbs_vdd|tg_s_vdd|vdd|vdd_b1|vdd_b2|vdd_b3|vdd_b4|vdd_link|vdd_link_dip|vdd_x1|vdd_x2|vdd_x3
+ 105.721272036
* device instance a_d_inv_clk_vdd_inv_mc_vdd_inv_q_vdd_mpa_py_mpb_py_nand_m_vdd_nand_s2_vdd_nwell_vdd_sb_vdd_sr1_vdd_sr2_vdd_sr3_vdd_sr4_vdd_sv_d_vdd_tie_sv_vdd_tg_d_a_tg_d_vdd_tg_fbm_vdd_tg_fbs_vdd_tg_s_vdd_vdd_vdd_b1_vdd_b2_vdd_b3_vdd_b4_vdd_link_vdd_link_dip_vdd_x1_vdd_x2_vdd_x3_t9 r0 *1 0,0
Ra_d_inv_clk_vdd_inv_mc_vdd_inv_q_vdd_mpa_py_mpb_py_nand_m_vdd_nand_s2_vdd_nwell_vdd_sb_vdd_sr1_vdd_sr2_vdd_sr3_vdd_sr4_vdd_sv_d_vdd_tie_sv_vdd_tg_d_a_tg_d_vdd_tg_fbm_vdd_tg_fbs_vdd_tg_s_vdd_vdd_vdd_b1_vdd_b2_vdd_b3_vdd_b4_vdd_link_vdd_link_dip_vdd_x1_vdd_x2_vdd_x3_t9
+ a|d|inv_clk_vdd|inv_mc_vdd|inv_q_vdd|mpa_py|mpb_py|nand_m_vdd|nand_s2_vdd|nwell_vdd|sb_vdd|sr1_vdd|sr2_vdd|sr3_vdd|sr4_vdd|sv_d_vdd_tie|sv_vdd|tg_d_a|tg_d_vdd|tg_fbm_vdd|tg_fbs_vdd|tg_s_vdd|vdd|vdd_b1|vdd_b2|vdd_b3|vdd_b4|vdd_link|vdd_link_dip|vdd_x1|vdd_x2|vdd_x3__t9
+ a|d|inv_clk_vdd|inv_mc_vdd|inv_q_vdd|mpa_py|mpb_py|nand_m_vdd|nand_s2_vdd|nwell_vdd|sb_vdd|sr1_vdd|sr2_vdd|sr3_vdd|sr4_vdd|sv_d_vdd_tie|sv_vdd|tg_d_a|tg_d_vdd|tg_fbm_vdd|tg_fbs_vdd|tg_s_vdd|vdd|vdd_b1|vdd_b2|vdd_b3|vdd_b4|vdd_link|vdd_link_dip|vdd_x1|vdd_x2|vdd_x3
+ 114.986947975
* device instance a_d_inv_clk_vdd_inv_mc_vdd_inv_q_vdd_mpa_py_mpb_py_nand_m_vdd_nand_s2_vdd_nwell_vdd_sb_vdd_sr1_vdd_sr2_vdd_sr3_vdd_sr4_vdd_sv_d_vdd_tie_sv_vdd_tg_d_a_tg_d_vdd_tg_fbm_vdd_tg_fbs_vdd_tg_s_vdd_vdd_vdd_b1_vdd_b2_vdd_b3_vdd_b4_vdd_link_vdd_link_dip_vdd_x1_vdd_x2_vdd_x3_t10 r0 *1 0,0
Ra_d_inv_clk_vdd_inv_mc_vdd_inv_q_vdd_mpa_py_mpb_py_nand_m_vdd_nand_s2_vdd_nwell_vdd_sb_vdd_sr1_vdd_sr2_vdd_sr3_vdd_sr4_vdd_sv_d_vdd_tie_sv_vdd_tg_d_a_tg_d_vdd_tg_fbm_vdd_tg_fbs_vdd_tg_s_vdd_vdd_vdd_b1_vdd_b2_vdd_b3_vdd_b4_vdd_link_vdd_link_dip_vdd_x1_vdd_x2_vdd_x3_t10
+ a|d|inv_clk_vdd|inv_mc_vdd|inv_q_vdd|mpa_py|mpb_py|nand_m_vdd|nand_s2_vdd|nwell_vdd|sb_vdd|sr1_vdd|sr2_vdd|sr3_vdd|sr4_vdd|sv_d_vdd_tie|sv_vdd|tg_d_a|tg_d_vdd|tg_fbm_vdd|tg_fbs_vdd|tg_s_vdd|vdd|vdd_b1|vdd_b2|vdd_b3|vdd_b4|vdd_link|vdd_link_dip|vdd_x1|vdd_x2|vdd_x3__t10
+ a|d|inv_clk_vdd|inv_mc_vdd|inv_q_vdd|mpa_py|mpb_py|nand_m_vdd|nand_s2_vdd|nwell_vdd|sb_vdd|sr1_vdd|sr2_vdd|sr3_vdd|sr4_vdd|sv_d_vdd_tie|sv_vdd|tg_d_a|tg_d_vdd|tg_fbm_vdd|tg_fbs_vdd|tg_s_vdd|vdd|vdd_b1|vdd_b2|vdd_b3|vdd_b4|vdd_link|vdd_link_dip|vdd_x1|vdd_x2|vdd_x3
+ 144.312798732
* device instance a_d_inv_clk_vdd_inv_mc_vdd_inv_q_vdd_mpa_py_mpb_py_nand_m_vdd_nand_s2_vdd_nwell_vdd_sb_vdd_sr1_vdd_sr2_vdd_sr3_vdd_sr4_vdd_sv_d_vdd_tie_sv_vdd_tg_d_a_tg_d_vdd_tg_fbm_vdd_tg_fbs_vdd_tg_s_vdd_vdd_vdd_b1_vdd_b2_vdd_b3_vdd_b4_vdd_link_vdd_link_dip_vdd_x1_vdd_x2_vdd_x3_t11 r0 *1 0,0
Ra_d_inv_clk_vdd_inv_mc_vdd_inv_q_vdd_mpa_py_mpb_py_nand_m_vdd_nand_s2_vdd_nwell_vdd_sb_vdd_sr1_vdd_sr2_vdd_sr3_vdd_sr4_vdd_sv_d_vdd_tie_sv_vdd_tg_d_a_tg_d_vdd_tg_fbm_vdd_tg_fbs_vdd_tg_s_vdd_vdd_vdd_b1_vdd_b2_vdd_b3_vdd_b4_vdd_link_vdd_link_dip_vdd_x1_vdd_x2_vdd_x3_t11
+ a|d|inv_clk_vdd|inv_mc_vdd|inv_q_vdd|mpa_py|mpb_py|nand_m_vdd|nand_s2_vdd|nwell_vdd|sb_vdd|sr1_vdd|sr2_vdd|sr3_vdd|sr4_vdd|sv_d_vdd_tie|sv_vdd|tg_d_a|tg_d_vdd|tg_fbm_vdd|tg_fbs_vdd|tg_s_vdd|vdd|vdd_b1|vdd_b2|vdd_b3|vdd_b4|vdd_link|vdd_link_dip|vdd_x1|vdd_x2|vdd_x3__t11
+ a|d|inv_clk_vdd|inv_mc_vdd|inv_q_vdd|mpa_py|mpb_py|nand_m_vdd|nand_s2_vdd|nwell_vdd|sb_vdd|sr1_vdd|sr2_vdd|sr3_vdd|sr4_vdd|sv_d_vdd_tie|sv_vdd|tg_d_a|tg_d_vdd|tg_fbm_vdd|tg_fbs_vdd|tg_s_vdd|vdd|vdd_b1|vdd_b2|vdd_b3|vdd_b4|vdd_link|vdd_link_dip|vdd_x1|vdd_x2|vdd_x3
+ 154.157931258
* device instance a_d_inv_clk_vdd_inv_mc_vdd_inv_q_vdd_mpa_py_mpb_py_nand_m_vdd_nand_s2_vdd_nwell_vdd_sb_vdd_sr1_vdd_sr2_vdd_sr3_vdd_sr4_vdd_sv_d_vdd_tie_sv_vdd_tg_d_a_tg_d_vdd_tg_fbm_vdd_tg_fbs_vdd_tg_s_vdd_vdd_vdd_b1_vdd_b2_vdd_b3_vdd_b4_vdd_link_vdd_link_dip_vdd_x1_vdd_x2_vdd_x3_t12 r0 *1 0,0
Ra_d_inv_clk_vdd_inv_mc_vdd_inv_q_vdd_mpa_py_mpb_py_nand_m_vdd_nand_s2_vdd_nwell_vdd_sb_vdd_sr1_vdd_sr2_vdd_sr3_vdd_sr4_vdd_sv_d_vdd_tie_sv_vdd_tg_d_a_tg_d_vdd_tg_fbm_vdd_tg_fbs_vdd_tg_s_vdd_vdd_vdd_b1_vdd_b2_vdd_b3_vdd_b4_vdd_link_vdd_link_dip_vdd_x1_vdd_x2_vdd_x3_t12
+ a|d|inv_clk_vdd|inv_mc_vdd|inv_q_vdd|mpa_py|mpb_py|nand_m_vdd|nand_s2_vdd|nwell_vdd|sb_vdd|sr1_vdd|sr2_vdd|sr3_vdd|sr4_vdd|sv_d_vdd_tie|sv_vdd|tg_d_a|tg_d_vdd|tg_fbm_vdd|tg_fbs_vdd|tg_s_vdd|vdd|vdd_b1|vdd_b2|vdd_b3|vdd_b4|vdd_link|vdd_link_dip|vdd_x1|vdd_x2|vdd_x3__t12
+ a|d|inv_clk_vdd|inv_mc_vdd|inv_q_vdd|mpa_py|mpb_py|nand_m_vdd|nand_s2_vdd|nwell_vdd|sb_vdd|sr1_vdd|sr2_vdd|sr3_vdd|sr4_vdd|sv_d_vdd_tie|sv_vdd|tg_d_a|tg_d_vdd|tg_fbm_vdd|tg_fbs_vdd|tg_s_vdd|vdd|vdd_b1|vdd_b2|vdd_b3|vdd_b4|vdd_link|vdd_link_dip|vdd_x1|vdd_x2|vdd_x3
+ 184.649690647
* device instance a_d_inv_clk_vdd_inv_mc_vdd_inv_q_vdd_mpa_py_mpb_py_nand_m_vdd_nand_s2_vdd_nwell_vdd_sb_vdd_sr1_vdd_sr2_vdd_sr3_vdd_sr4_vdd_sv_d_vdd_tie_sv_vdd_tg_d_a_tg_d_vdd_tg_fbm_vdd_tg_fbs_vdd_tg_s_vdd_vdd_vdd_b1_vdd_b2_vdd_b3_vdd_b4_vdd_link_vdd_link_dip_vdd_x1_vdd_x2_vdd_x3_t13 r0 *1 0,0
Ra_d_inv_clk_vdd_inv_mc_vdd_inv_q_vdd_mpa_py_mpb_py_nand_m_vdd_nand_s2_vdd_nwell_vdd_sb_vdd_sr1_vdd_sr2_vdd_sr3_vdd_sr4_vdd_sv_d_vdd_tie_sv_vdd_tg_d_a_tg_d_vdd_tg_fbm_vdd_tg_fbs_vdd_tg_s_vdd_vdd_vdd_b1_vdd_b2_vdd_b3_vdd_b4_vdd_link_vdd_link_dip_vdd_x1_vdd_x2_vdd_x3_t13
+ a|d|inv_clk_vdd|inv_mc_vdd|inv_q_vdd|mpa_py|mpb_py|nand_m_vdd|nand_s2_vdd|nwell_vdd|sb_vdd|sr1_vdd|sr2_vdd|sr3_vdd|sr4_vdd|sv_d_vdd_tie|sv_vdd|tg_d_a|tg_d_vdd|tg_fbm_vdd|tg_fbs_vdd|tg_s_vdd|vdd|vdd_b1|vdd_b2|vdd_b3|vdd_b4|vdd_link|vdd_link_dip|vdd_x1|vdd_x2|vdd_x3__t13
+ a|d|inv_clk_vdd|inv_mc_vdd|inv_q_vdd|mpa_py|mpb_py|nand_m_vdd|nand_s2_vdd|nwell_vdd|sb_vdd|sr1_vdd|sr2_vdd|sr3_vdd|sr4_vdd|sv_d_vdd_tie|sv_vdd|tg_d_a|tg_d_vdd|tg_fbm_vdd|tg_fbs_vdd|tg_s_vdd|vdd|vdd_b1|vdd_b2|vdd_b3|vdd_b4|vdd_link|vdd_link_dip|vdd_x1|vdd_x2|vdd_x3
+ 106.579801389
* device instance a_d_inv_clk_vdd_inv_mc_vdd_inv_q_vdd_mpa_py_mpb_py_nand_m_vdd_nand_s2_vdd_nwell_vdd_sb_vdd_sr1_vdd_sr2_vdd_sr3_vdd_sr4_vdd_sv_d_vdd_tie_sv_vdd_tg_d_a_tg_d_vdd_tg_fbm_vdd_tg_fbs_vdd_tg_s_vdd_vdd_vdd_b1_vdd_b2_vdd_b3_vdd_b4_vdd_link_vdd_link_dip_vdd_x1_vdd_x2_vdd_x3_t14 r0 *1 0,0
Ra_d_inv_clk_vdd_inv_mc_vdd_inv_q_vdd_mpa_py_mpb_py_nand_m_vdd_nand_s2_vdd_nwell_vdd_sb_vdd_sr1_vdd_sr2_vdd_sr3_vdd_sr4_vdd_sv_d_vdd_tie_sv_vdd_tg_d_a_tg_d_vdd_tg_fbm_vdd_tg_fbs_vdd_tg_s_vdd_vdd_vdd_b1_vdd_b2_vdd_b3_vdd_b4_vdd_link_vdd_link_dip_vdd_x1_vdd_x2_vdd_x3_t14
+ a|d|inv_clk_vdd|inv_mc_vdd|inv_q_vdd|mpa_py|mpb_py|nand_m_vdd|nand_s2_vdd|nwell_vdd|sb_vdd|sr1_vdd|sr2_vdd|sr3_vdd|sr4_vdd|sv_d_vdd_tie|sv_vdd|tg_d_a|tg_d_vdd|tg_fbm_vdd|tg_fbs_vdd|tg_s_vdd|vdd|vdd_b1|vdd_b2|vdd_b3|vdd_b4|vdd_link|vdd_link_dip|vdd_x1|vdd_x2|vdd_x3__t14
+ a|d|inv_clk_vdd|inv_mc_vdd|inv_q_vdd|mpa_py|mpb_py|nand_m_vdd|nand_s2_vdd|nwell_vdd|sb_vdd|sr1_vdd|sr2_vdd|sr3_vdd|sr4_vdd|sv_d_vdd_tie|sv_vdd|tg_d_a|tg_d_vdd|tg_fbm_vdd|tg_fbs_vdd|tg_s_vdd|vdd|vdd_b1|vdd_b2|vdd_b3|vdd_b4|vdd_link|vdd_link_dip|vdd_x1|vdd_x2|vdd_x3
+ 115.865994115
* device instance a_d_inv_clk_vdd_inv_mc_vdd_inv_q_vdd_mpa_py_mpb_py_nand_m_vdd_nand_s2_vdd_nwell_vdd_sb_vdd_sr1_vdd_sr2_vdd_sr3_vdd_sr4_vdd_sv_d_vdd_tie_sv_vdd_tg_d_a_tg_d_vdd_tg_fbm_vdd_tg_fbs_vdd_tg_s_vdd_vdd_vdd_b1_vdd_b2_vdd_b3_vdd_b4_vdd_link_vdd_link_dip_vdd_x1_vdd_x2_vdd_x3_t15 r0 *1 0,0
Ra_d_inv_clk_vdd_inv_mc_vdd_inv_q_vdd_mpa_py_mpb_py_nand_m_vdd_nand_s2_vdd_nwell_vdd_sb_vdd_sr1_vdd_sr2_vdd_sr3_vdd_sr4_vdd_sv_d_vdd_tie_sv_vdd_tg_d_a_tg_d_vdd_tg_fbm_vdd_tg_fbs_vdd_tg_s_vdd_vdd_vdd_b1_vdd_b2_vdd_b3_vdd_b4_vdd_link_vdd_link_dip_vdd_x1_vdd_x2_vdd_x3_t15
+ a|d|inv_clk_vdd|inv_mc_vdd|inv_q_vdd|mpa_py|mpb_py|nand_m_vdd|nand_s2_vdd|nwell_vdd|sb_vdd|sr1_vdd|sr2_vdd|sr3_vdd|sr4_vdd|sv_d_vdd_tie|sv_vdd|tg_d_a|tg_d_vdd|tg_fbm_vdd|tg_fbs_vdd|tg_s_vdd|vdd|vdd_b1|vdd_b2|vdd_b3|vdd_b4|vdd_link|vdd_link_dip|vdd_x1|vdd_x2|vdd_x3__t15
+ a|d|inv_clk_vdd|inv_mc_vdd|inv_q_vdd|mpa_py|mpb_py|nand_m_vdd|nand_s2_vdd|nwell_vdd|sb_vdd|sr1_vdd|sr2_vdd|sr3_vdd|sr4_vdd|sv_d_vdd_tie|sv_vdd|tg_d_a|tg_d_vdd|tg_fbm_vdd|tg_fbs_vdd|tg_s_vdd|vdd|vdd_b1|vdd_b2|vdd_b3|vdd_b4|vdd_link|vdd_link_dip|vdd_x1|vdd_x2|vdd_x3
+ 145.231451927
* device instance a_d_inv_clk_vdd_inv_mc_vdd_inv_q_vdd_mpa_py_mpb_py_nand_m_vdd_nand_s2_vdd_nwell_vdd_sb_vdd_sr1_vdd_sr2_vdd_sr3_vdd_sr4_vdd_sv_d_vdd_tie_sv_vdd_tg_d_a_tg_d_vdd_tg_fbm_vdd_tg_fbs_vdd_tg_s_vdd_vdd_vdd_b1_vdd_b2_vdd_b3_vdd_b4_vdd_link_vdd_link_dip_vdd_x1_vdd_x2_vdd_x3_t16 r0 *1 0,0
Ra_d_inv_clk_vdd_inv_mc_vdd_inv_q_vdd_mpa_py_mpb_py_nand_m_vdd_nand_s2_vdd_nwell_vdd_sb_vdd_sr1_vdd_sr2_vdd_sr3_vdd_sr4_vdd_sv_d_vdd_tie_sv_vdd_tg_d_a_tg_d_vdd_tg_fbm_vdd_tg_fbs_vdd_tg_s_vdd_vdd_vdd_b1_vdd_b2_vdd_b3_vdd_b4_vdd_link_vdd_link_dip_vdd_x1_vdd_x2_vdd_x3_t16
+ a|d|inv_clk_vdd|inv_mc_vdd|inv_q_vdd|mpa_py|mpb_py|nand_m_vdd|nand_s2_vdd|nwell_vdd|sb_vdd|sr1_vdd|sr2_vdd|sr3_vdd|sr4_vdd|sv_d_vdd_tie|sv_vdd|tg_d_a|tg_d_vdd|tg_fbm_vdd|tg_fbs_vdd|tg_s_vdd|vdd|vdd_b1|vdd_b2|vdd_b3|vdd_b4|vdd_link|vdd_link_dip|vdd_x1|vdd_x2|vdd_x3__t16
+ a|d|inv_clk_vdd|inv_mc_vdd|inv_q_vdd|mpa_py|mpb_py|nand_m_vdd|nand_s2_vdd|nwell_vdd|sb_vdd|sr1_vdd|sr2_vdd|sr3_vdd|sr4_vdd|sv_d_vdd_tie|sv_vdd|tg_d_a|tg_d_vdd|tg_fbm_vdd|tg_fbs_vdd|tg_s_vdd|vdd|vdd_b1|vdd_b2|vdd_b3|vdd_b4|vdd_link|vdd_link_dip|vdd_x1|vdd_x2|vdd_x3
+ 155.084887095
* device instance a_d_inv_clk_vdd_inv_mc_vdd_inv_q_vdd_mpa_py_mpb_py_nand_m_vdd_nand_s2_vdd_nwell_vdd_sb_vdd_sr1_vdd_sr2_vdd_sr3_vdd_sr4_vdd_sv_d_vdd_tie_sv_vdd_tg_d_a_tg_d_vdd_tg_fbm_vdd_tg_fbs_vdd_tg_s_vdd_vdd_vdd_b1_vdd_b2_vdd_b3_vdd_b4_vdd_link_vdd_link_dip_vdd_x1_vdd_x2_vdd_x3_t17 r0 *1 0,0
Ra_d_inv_clk_vdd_inv_mc_vdd_inv_q_vdd_mpa_py_mpb_py_nand_m_vdd_nand_s2_vdd_nwell_vdd_sb_vdd_sr1_vdd_sr2_vdd_sr3_vdd_sr4_vdd_sv_d_vdd_tie_sv_vdd_tg_d_a_tg_d_vdd_tg_fbm_vdd_tg_fbs_vdd_tg_s_vdd_vdd_vdd_b1_vdd_b2_vdd_b3_vdd_b4_vdd_link_vdd_link_dip_vdd_x1_vdd_x2_vdd_x3_t17
+ a|d|inv_clk_vdd|inv_mc_vdd|inv_q_vdd|mpa_py|mpb_py|nand_m_vdd|nand_s2_vdd|nwell_vdd|sb_vdd|sr1_vdd|sr2_vdd|sr3_vdd|sr4_vdd|sv_d_vdd_tie|sv_vdd|tg_d_a|tg_d_vdd|tg_fbm_vdd|tg_fbs_vdd|tg_s_vdd|vdd|vdd_b1|vdd_b2|vdd_b3|vdd_b4|vdd_link|vdd_link_dip|vdd_x1|vdd_x2|vdd_x3__t17
+ a|d|inv_clk_vdd|inv_mc_vdd|inv_q_vdd|mpa_py|mpb_py|nand_m_vdd|nand_s2_vdd|nwell_vdd|sb_vdd|sr1_vdd|sr2_vdd|sr3_vdd|sr4_vdd|sv_d_vdd_tie|sv_vdd|tg_d_a|tg_d_vdd|tg_fbm_vdd|tg_fbs_vdd|tg_s_vdd|vdd|vdd_b1|vdd_b2|vdd_b3|vdd_b4|vdd_link|vdd_link_dip|vdd_x1|vdd_x2|vdd_x3
+ 185.594243054
* device instance a_d_inv_clk_vdd_inv_mc_vdd_inv_q_vdd_mpa_py_mpb_py_nand_m_vdd_nand_s2_vdd_nwell_vdd_sb_vdd_sr1_vdd_sr2_vdd_sr3_vdd_sr4_vdd_sv_d_vdd_tie_sv_vdd_tg_d_a_tg_d_vdd_tg_fbm_vdd_tg_fbs_vdd_tg_s_vdd_vdd_vdd_b1_vdd_b2_vdd_b3_vdd_b4_vdd_link_vdd_link_dip_vdd_x1_vdd_x2_vdd_x3_t18 r0 *1 0,0
Ra_d_inv_clk_vdd_inv_mc_vdd_inv_q_vdd_mpa_py_mpb_py_nand_m_vdd_nand_s2_vdd_nwell_vdd_sb_vdd_sr1_vdd_sr2_vdd_sr3_vdd_sr4_vdd_sv_d_vdd_tie_sv_vdd_tg_d_a_tg_d_vdd_tg_fbm_vdd_tg_fbs_vdd_tg_s_vdd_vdd_vdd_b1_vdd_b2_vdd_b3_vdd_b4_vdd_link_vdd_link_dip_vdd_x1_vdd_x2_vdd_x3_t18
+ a|d|inv_clk_vdd|inv_mc_vdd|inv_q_vdd|mpa_py|mpb_py|nand_m_vdd|nand_s2_vdd|nwell_vdd|sb_vdd|sr1_vdd|sr2_vdd|sr3_vdd|sr4_vdd|sv_d_vdd_tie|sv_vdd|tg_d_a|tg_d_vdd|tg_fbm_vdd|tg_fbs_vdd|tg_s_vdd|vdd|vdd_b1|vdd_b2|vdd_b3|vdd_b4|vdd_link|vdd_link_dip|vdd_x1|vdd_x2|vdd_x3__t18
+ a|d|inv_clk_vdd|inv_mc_vdd|inv_q_vdd|mpa_py|mpb_py|nand_m_vdd|nand_s2_vdd|nwell_vdd|sb_vdd|sr1_vdd|sr2_vdd|sr3_vdd|sr4_vdd|sv_d_vdd_tie|sv_vdd|tg_d_a|tg_d_vdd|tg_fbm_vdd|tg_fbs_vdd|tg_s_vdd|vdd|vdd_b1|vdd_b2|vdd_b3|vdd_b4|vdd_link|vdd_link_dip|vdd_x1|vdd_x2|vdd_x3
+ 115.865994115
* device instance a_d_inv_clk_vdd_inv_mc_vdd_inv_q_vdd_mpa_py_mpb_py_nand_m_vdd_nand_s2_vdd_nwell_vdd_sb_vdd_sr1_vdd_sr2_vdd_sr3_vdd_sr4_vdd_sv_d_vdd_tie_sv_vdd_tg_d_a_tg_d_vdd_tg_fbm_vdd_tg_fbs_vdd_tg_s_vdd_vdd_vdd_b1_vdd_b2_vdd_b3_vdd_b4_vdd_link_vdd_link_dip_vdd_x1_vdd_x2_vdd_x3_t19 r0 *1 0,0
Ra_d_inv_clk_vdd_inv_mc_vdd_inv_q_vdd_mpa_py_mpb_py_nand_m_vdd_nand_s2_vdd_nwell_vdd_sb_vdd_sr1_vdd_sr2_vdd_sr3_vdd_sr4_vdd_sv_d_vdd_tie_sv_vdd_tg_d_a_tg_d_vdd_tg_fbm_vdd_tg_fbs_vdd_tg_s_vdd_vdd_vdd_b1_vdd_b2_vdd_b3_vdd_b4_vdd_link_vdd_link_dip_vdd_x1_vdd_x2_vdd_x3_t19
+ a|d|inv_clk_vdd|inv_mc_vdd|inv_q_vdd|mpa_py|mpb_py|nand_m_vdd|nand_s2_vdd|nwell_vdd|sb_vdd|sr1_vdd|sr2_vdd|sr3_vdd|sr4_vdd|sv_d_vdd_tie|sv_vdd|tg_d_a|tg_d_vdd|tg_fbm_vdd|tg_fbs_vdd|tg_s_vdd|vdd|vdd_b1|vdd_b2|vdd_b3|vdd_b4|vdd_link|vdd_link_dip|vdd_x1|vdd_x2|vdd_x3__t19
+ a|d|inv_clk_vdd|inv_mc_vdd|inv_q_vdd|mpa_py|mpb_py|nand_m_vdd|nand_s2_vdd|nwell_vdd|sb_vdd|sr1_vdd|sr2_vdd|sr3_vdd|sr4_vdd|sv_d_vdd_tie|sv_vdd|tg_d_a|tg_d_vdd|tg_fbm_vdd|tg_fbs_vdd|tg_s_vdd|vdd|vdd_b1|vdd_b2|vdd_b3|vdd_b4|vdd_link|vdd_link_dip|vdd_x1|vdd_x2|vdd_x3
+ 155.084887095
* device instance a_d_inv_clk_vdd_inv_mc_vdd_inv_q_vdd_mpa_py_mpb_py_nand_m_vdd_nand_s2_vdd_nwell_vdd_sb_vdd_sr1_vdd_sr2_vdd_sr3_vdd_sr4_vdd_sv_d_vdd_tie_sv_vdd_tg_d_a_tg_d_vdd_tg_fbm_vdd_tg_fbs_vdd_tg_s_vdd_vdd_vdd_b1_vdd_b2_vdd_b3_vdd_b4_vdd_link_vdd_link_dip_vdd_x1_vdd_x2_vdd_x3_t20 r0 *1 0,0
Ra_d_inv_clk_vdd_inv_mc_vdd_inv_q_vdd_mpa_py_mpb_py_nand_m_vdd_nand_s2_vdd_nwell_vdd_sb_vdd_sr1_vdd_sr2_vdd_sr3_vdd_sr4_vdd_sv_d_vdd_tie_sv_vdd_tg_d_a_tg_d_vdd_tg_fbm_vdd_tg_fbs_vdd_tg_s_vdd_vdd_vdd_b1_vdd_b2_vdd_b3_vdd_b4_vdd_link_vdd_link_dip_vdd_x1_vdd_x2_vdd_x3_t20
+ a|d|inv_clk_vdd|inv_mc_vdd|inv_q_vdd|mpa_py|mpb_py|nand_m_vdd|nand_s2_vdd|nwell_vdd|sb_vdd|sr1_vdd|sr2_vdd|sr3_vdd|sr4_vdd|sv_d_vdd_tie|sv_vdd|tg_d_a|tg_d_vdd|tg_fbm_vdd|tg_fbs_vdd|tg_s_vdd|vdd|vdd_b1|vdd_b2|vdd_b3|vdd_b4|vdd_link|vdd_link_dip|vdd_x1|vdd_x2|vdd_x3__t20
+ a|d|inv_clk_vdd|inv_mc_vdd|inv_q_vdd|mpa_py|mpb_py|nand_m_vdd|nand_s2_vdd|nwell_vdd|sb_vdd|sr1_vdd|sr2_vdd|sr3_vdd|sr4_vdd|sv_d_vdd_tie|sv_vdd|tg_d_a|tg_d_vdd|tg_fbm_vdd|tg_fbs_vdd|tg_s_vdd|vdd|vdd_b1|vdd_b2|vdd_b3|vdd_b4|vdd_link|vdd_link_dip|vdd_x1|vdd_x2|vdd_x3
+ 66.8380635271
* device instance a_d_inv_clk_vdd_inv_mc_vdd_inv_q_vdd_mpa_py_mpb_py_nand_m_vdd_nand_s2_vdd_nwell_vdd_sb_vdd_sr1_vdd_sr2_vdd_sr3_vdd_sr4_vdd_sv_d_vdd_tie_sv_vdd_tg_d_a_tg_d_vdd_tg_fbm_vdd_tg_fbs_vdd_tg_s_vdd_vdd_vdd_b1_vdd_b2_vdd_b3_vdd_b4_vdd_link_vdd_link_dip_vdd_x1_vdd_x2_vdd_x3_t21 r0 *1 0,0
Ra_d_inv_clk_vdd_inv_mc_vdd_inv_q_vdd_mpa_py_mpb_py_nand_m_vdd_nand_s2_vdd_nwell_vdd_sb_vdd_sr1_vdd_sr2_vdd_sr3_vdd_sr4_vdd_sv_d_vdd_tie_sv_vdd_tg_d_a_tg_d_vdd_tg_fbm_vdd_tg_fbs_vdd_tg_s_vdd_vdd_vdd_b1_vdd_b2_vdd_b3_vdd_b4_vdd_link_vdd_link_dip_vdd_x1_vdd_x2_vdd_x3_t21
+ a|d|inv_clk_vdd|inv_mc_vdd|inv_q_vdd|mpa_py|mpb_py|nand_m_vdd|nand_s2_vdd|nwell_vdd|sb_vdd|sr1_vdd|sr2_vdd|sr3_vdd|sr4_vdd|sv_d_vdd_tie|sv_vdd|tg_d_a|tg_d_vdd|tg_fbm_vdd|tg_fbs_vdd|tg_s_vdd|vdd|vdd_b1|vdd_b2|vdd_b3|vdd_b4|vdd_link|vdd_link_dip|vdd_x1|vdd_x2|vdd_x3__t21
+ a|d|inv_clk_vdd|inv_mc_vdd|inv_q_vdd|mpa_py|mpb_py|nand_m_vdd|nand_s2_vdd|nwell_vdd|sb_vdd|sr1_vdd|sr2_vdd|sr3_vdd|sr4_vdd|sv_d_vdd_tie|sv_vdd|tg_d_a|tg_d_vdd|tg_fbm_vdd|tg_fbs_vdd|tg_s_vdd|vdd|vdd_b1|vdd_b2|vdd_b3|vdd_b4|vdd_link|vdd_link_dip|vdd_x1|vdd_x2|vdd_x3
+ 274.471210464
* device instance a_d_inv_clk_vdd_inv_mc_vdd_inv_q_vdd_mpa_py_mpb_py_nand_m_vdd_nand_s2_vdd_nwell_vdd_sb_vdd_sr1_vdd_sr2_vdd_sr3_vdd_sr4_vdd_sv_d_vdd_tie_sv_vdd_tg_d_a_tg_d_vdd_tg_fbm_vdd_tg_fbs_vdd_tg_s_vdd_vdd_vdd_b1_vdd_b2_vdd_b3_vdd_b4_vdd_link_vdd_link_dip_vdd_x1_vdd_x2_vdd_x3_t22 r0 *1 0,0
Ra_d_inv_clk_vdd_inv_mc_vdd_inv_q_vdd_mpa_py_mpb_py_nand_m_vdd_nand_s2_vdd_nwell_vdd_sb_vdd_sr1_vdd_sr2_vdd_sr3_vdd_sr4_vdd_sv_d_vdd_tie_sv_vdd_tg_d_a_tg_d_vdd_tg_fbm_vdd_tg_fbs_vdd_tg_s_vdd_vdd_vdd_b1_vdd_b2_vdd_b3_vdd_b4_vdd_link_vdd_link_dip_vdd_x1_vdd_x2_vdd_x3_t22
+ a|d|inv_clk_vdd|inv_mc_vdd|inv_q_vdd|mpa_py|mpb_py|nand_m_vdd|nand_s2_vdd|nwell_vdd|sb_vdd|sr1_vdd|sr2_vdd|sr3_vdd|sr4_vdd|sv_d_vdd_tie|sv_vdd|tg_d_a|tg_d_vdd|tg_fbm_vdd|tg_fbs_vdd|tg_s_vdd|vdd|vdd_b1|vdd_b2|vdd_b3|vdd_b4|vdd_link|vdd_link_dip|vdd_x1|vdd_x2|vdd_x3__t22
+ a|d|inv_clk_vdd|inv_mc_vdd|inv_q_vdd|mpa_py|mpb_py|nand_m_vdd|nand_s2_vdd|nwell_vdd|sb_vdd|sr1_vdd|sr2_vdd|sr3_vdd|sr4_vdd|sv_d_vdd_tie|sv_vdd|tg_d_a|tg_d_vdd|tg_fbm_vdd|tg_fbs_vdd|tg_s_vdd|vdd|vdd_b1|vdd_b2|vdd_b3|vdd_b4|vdd_link|vdd_link_dip|vdd_x1|vdd_x2|vdd_x3
+ 229.224151213
* device instance a_d_inv_clk_vdd_inv_mc_vdd_inv_q_vdd_mpa_py_mpb_py_nand_m_vdd_nand_s2_vdd_nwell_vdd_sb_vdd_sr1_vdd_sr2_vdd_sr3_vdd_sr4_vdd_sv_d_vdd_tie_sv_vdd_tg_d_a_tg_d_vdd_tg_fbm_vdd_tg_fbs_vdd_tg_s_vdd_vdd_vdd_b1_vdd_b2_vdd_b3_vdd_b4_vdd_link_vdd_link_dip_vdd_x1_vdd_x2_vdd_x3_t23 r0 *1 0,0
Ra_d_inv_clk_vdd_inv_mc_vdd_inv_q_vdd_mpa_py_mpb_py_nand_m_vdd_nand_s2_vdd_nwell_vdd_sb_vdd_sr1_vdd_sr2_vdd_sr3_vdd_sr4_vdd_sv_d_vdd_tie_sv_vdd_tg_d_a_tg_d_vdd_tg_fbm_vdd_tg_fbs_vdd_tg_s_vdd_vdd_vdd_b1_vdd_b2_vdd_b3_vdd_b4_vdd_link_vdd_link_dip_vdd_x1_vdd_x2_vdd_x3_t23
+ a|d|inv_clk_vdd|inv_mc_vdd|inv_q_vdd|mpa_py|mpb_py|nand_m_vdd|nand_s2_vdd|nwell_vdd|sb_vdd|sr1_vdd|sr2_vdd|sr3_vdd|sr4_vdd|sv_d_vdd_tie|sv_vdd|tg_d_a|tg_d_vdd|tg_fbm_vdd|tg_fbs_vdd|tg_s_vdd|vdd|vdd_b1|vdd_b2|vdd_b3|vdd_b4|vdd_link|vdd_link_dip|vdd_x1|vdd_x2|vdd_x3__t23
+ a|d|inv_clk_vdd|inv_mc_vdd|inv_q_vdd|mpa_py|mpb_py|nand_m_vdd|nand_s2_vdd|nwell_vdd|sb_vdd|sr1_vdd|sr2_vdd|sr3_vdd|sr4_vdd|sv_d_vdd_tie|sv_vdd|tg_d_a|tg_d_vdd|tg_fbm_vdd|tg_fbs_vdd|tg_s_vdd|vdd|vdd_b1|vdd_b2|vdd_b3|vdd_b4|vdd_link|vdd_link_dip|vdd_x1|vdd_x2|vdd_x3
+ 192.887270334
* device instance a_d_inv_clk_vdd_inv_mc_vdd_inv_q_vdd_mpa_py_mpb_py_nand_m_vdd_nand_s2_vdd_nwell_vdd_sb_vdd_sr1_vdd_sr2_vdd_sr3_vdd_sr4_vdd_sv_d_vdd_tie_sv_vdd_tg_d_a_tg_d_vdd_tg_fbm_vdd_tg_fbs_vdd_tg_s_vdd_vdd_vdd_b1_vdd_b2_vdd_b3_vdd_b4_vdd_link_vdd_link_dip_vdd_x1_vdd_x2_vdd_x3_t24 r0 *1 0,0
Ra_d_inv_clk_vdd_inv_mc_vdd_inv_q_vdd_mpa_py_mpb_py_nand_m_vdd_nand_s2_vdd_nwell_vdd_sb_vdd_sr1_vdd_sr2_vdd_sr3_vdd_sr4_vdd_sv_d_vdd_tie_sv_vdd_tg_d_a_tg_d_vdd_tg_fbm_vdd_tg_fbs_vdd_tg_s_vdd_vdd_vdd_b1_vdd_b2_vdd_b3_vdd_b4_vdd_link_vdd_link_dip_vdd_x1_vdd_x2_vdd_x3_t24
+ a|d|inv_clk_vdd|inv_mc_vdd|inv_q_vdd|mpa_py|mpb_py|nand_m_vdd|nand_s2_vdd|nwell_vdd|sb_vdd|sr1_vdd|sr2_vdd|sr3_vdd|sr4_vdd|sv_d_vdd_tie|sv_vdd|tg_d_a|tg_d_vdd|tg_fbm_vdd|tg_fbs_vdd|tg_s_vdd|vdd|vdd_b1|vdd_b2|vdd_b3|vdd_b4|vdd_link|vdd_link_dip|vdd_x1|vdd_x2|vdd_x3__t24
+ a|d|inv_clk_vdd|inv_mc_vdd|inv_q_vdd|mpa_py|mpb_py|nand_m_vdd|nand_s2_vdd|nwell_vdd|sb_vdd|sr1_vdd|sr2_vdd|sr3_vdd|sr4_vdd|sv_d_vdd_tie|sv_vdd|tg_d_a|tg_d_vdd|tg_fbm_vdd|tg_fbs_vdd|tg_s_vdd|vdd|vdd_b1|vdd_b2|vdd_b3|vdd_b4|vdd_link|vdd_link_dip|vdd_x1|vdd_x2|vdd_x3
+ 147.729060078
* device instance a_d_inv_clk_vdd_inv_mc_vdd_inv_q_vdd_mpa_py_mpb_py_nand_m_vdd_nand_s2_vdd_nwell_vdd_sb_vdd_sr1_vdd_sr2_vdd_sr3_vdd_sr4_vdd_sv_d_vdd_tie_sv_vdd_tg_d_a_tg_d_vdd_tg_fbm_vdd_tg_fbs_vdd_tg_s_vdd_vdd_vdd_b1_vdd_b2_vdd_b3_vdd_b4_vdd_link_vdd_link_dip_vdd_x1_vdd_x2_vdd_x3_t25 r0 *1 0,0
Ra_d_inv_clk_vdd_inv_mc_vdd_inv_q_vdd_mpa_py_mpb_py_nand_m_vdd_nand_s2_vdd_nwell_vdd_sb_vdd_sr1_vdd_sr2_vdd_sr3_vdd_sr4_vdd_sv_d_vdd_tie_sv_vdd_tg_d_a_tg_d_vdd_tg_fbm_vdd_tg_fbs_vdd_tg_s_vdd_vdd_vdd_b1_vdd_b2_vdd_b3_vdd_b4_vdd_link_vdd_link_dip_vdd_x1_vdd_x2_vdd_x3_t25
+ a|d|inv_clk_vdd|inv_mc_vdd|inv_q_vdd|mpa_py|mpb_py|nand_m_vdd|nand_s2_vdd|nwell_vdd|sb_vdd|sr1_vdd|sr2_vdd|sr3_vdd|sr4_vdd|sv_d_vdd_tie|sv_vdd|tg_d_a|tg_d_vdd|tg_fbm_vdd|tg_fbs_vdd|tg_s_vdd|vdd|vdd_b1|vdd_b2|vdd_b3|vdd_b4|vdd_link|vdd_link_dip|vdd_x1|vdd_x2|vdd_x3__t25
+ a|d|inv_clk_vdd|inv_mc_vdd|inv_q_vdd|mpa_py|mpb_py|nand_m_vdd|nand_s2_vdd|nwell_vdd|sb_vdd|sr1_vdd|sr2_vdd|sr3_vdd|sr4_vdd|sv_d_vdd_tie|sv_vdd|tg_d_a|tg_d_vdd|tg_fbm_vdd|tg_fbs_vdd|tg_s_vdd|vdd|vdd_b1|vdd_b2|vdd_b3|vdd_b4|vdd_link|vdd_link_dip|vdd_x1|vdd_x2|vdd_x3
+ 111.534033335
* device instance a_d_inv_clk_vdd_inv_mc_vdd_inv_q_vdd_mpa_py_mpb_py_nand_m_vdd_nand_s2_vdd_nwell_vdd_sb_vdd_sr1_vdd_sr2_vdd_sr3_vdd_sr4_vdd_sv_d_vdd_tie_sv_vdd_tg_d_a_tg_d_vdd_tg_fbm_vdd_tg_fbs_vdd_tg_s_vdd_vdd_vdd_b1_vdd_b2_vdd_b3_vdd_b4_vdd_link_vdd_link_dip_vdd_x1_vdd_x2_vdd_x3_t26 r0 *1 0,0
Ra_d_inv_clk_vdd_inv_mc_vdd_inv_q_vdd_mpa_py_mpb_py_nand_m_vdd_nand_s2_vdd_nwell_vdd_sb_vdd_sr1_vdd_sr2_vdd_sr3_vdd_sr4_vdd_sv_d_vdd_tie_sv_vdd_tg_d_a_tg_d_vdd_tg_fbm_vdd_tg_fbs_vdd_tg_s_vdd_vdd_vdd_b1_vdd_b2_vdd_b3_vdd_b4_vdd_link_vdd_link_dip_vdd_x1_vdd_x2_vdd_x3_t26
+ a|d|inv_clk_vdd|inv_mc_vdd|inv_q_vdd|mpa_py|mpb_py|nand_m_vdd|nand_s2_vdd|nwell_vdd|sb_vdd|sr1_vdd|sr2_vdd|sr3_vdd|sr4_vdd|sv_d_vdd_tie|sv_vdd|tg_d_a|tg_d_vdd|tg_fbm_vdd|tg_fbs_vdd|tg_s_vdd|vdd|vdd_b1|vdd_b2|vdd_b3|vdd_b4|vdd_link|vdd_link_dip|vdd_x1|vdd_x2|vdd_x3__t26
+ a|d|inv_clk_vdd|inv_mc_vdd|inv_q_vdd|mpa_py|mpb_py|nand_m_vdd|nand_s2_vdd|nwell_vdd|sb_vdd|sr1_vdd|sr2_vdd|sr3_vdd|sr4_vdd|sv_d_vdd_tie|sv_vdd|tg_d_a|tg_d_vdd|tg_fbm_vdd|tg_fbs_vdd|tg_s_vdd|vdd|vdd_b1|vdd_b2|vdd_b3|vdd_b4|vdd_link|vdd_link_dip|vdd_x1|vdd_x2|vdd_x3
+ 21.7730597858
* device instance a_d_inv_clk_vdd_inv_mc_vdd_inv_q_vdd_mpa_py_mpb_py_nand_m_vdd_nand_s2_vdd_nwell_vdd_sb_vdd_sr1_vdd_sr2_vdd_sr3_vdd_sr4_vdd_sv_d_vdd_tie_sv_vdd_tg_d_a_tg_d_vdd_tg_fbm_vdd_tg_fbs_vdd_tg_s_vdd_vdd_vdd_b1_vdd_b2_vdd_b3_vdd_b4_vdd_link_vdd_link_dip_vdd_x1_vdd_x2_vdd_x3_t27 r0 *1 0,0
Ra_d_inv_clk_vdd_inv_mc_vdd_inv_q_vdd_mpa_py_mpb_py_nand_m_vdd_nand_s2_vdd_nwell_vdd_sb_vdd_sr1_vdd_sr2_vdd_sr3_vdd_sr4_vdd_sv_d_vdd_tie_sv_vdd_tg_d_a_tg_d_vdd_tg_fbm_vdd_tg_fbs_vdd_tg_s_vdd_vdd_vdd_b1_vdd_b2_vdd_b3_vdd_b4_vdd_link_vdd_link_dip_vdd_x1_vdd_x2_vdd_x3_t27
+ a|d|inv_clk_vdd|inv_mc_vdd|inv_q_vdd|mpa_py|mpb_py|nand_m_vdd|nand_s2_vdd|nwell_vdd|sb_vdd|sr1_vdd|sr2_vdd|sr3_vdd|sr4_vdd|sv_d_vdd_tie|sv_vdd|tg_d_a|tg_d_vdd|tg_fbm_vdd|tg_fbs_vdd|tg_s_vdd|vdd|vdd_b1|vdd_b2|vdd_b3|vdd_b4|vdd_link|vdd_link_dip|vdd_x1|vdd_x2|vdd_x3__t27
+ a|d|inv_clk_vdd|inv_mc_vdd|inv_q_vdd|mpa_py|mpb_py|nand_m_vdd|nand_s2_vdd|nwell_vdd|sb_vdd|sr1_vdd|sr2_vdd|sr3_vdd|sr4_vdd|sv_d_vdd_tie|sv_vdd|tg_d_a|tg_d_vdd|tg_fbm_vdd|tg_fbs_vdd|tg_s_vdd|vdd|vdd_b1|vdd_b2|vdd_b3|vdd_b4|vdd_link|vdd_link_dip|vdd_x1|vdd_x2|vdd_x3
+ 111.123919524
* device instance a_d_inv_clk_vdd_inv_mc_vdd_inv_q_vdd_mpa_py_mpb_py_nand_m_vdd_nand_s2_vdd_nwell_vdd_sb_vdd_sr1_vdd_sr2_vdd_sr3_vdd_sr4_vdd_sv_d_vdd_tie_sv_vdd_tg_d_a_tg_d_vdd_tg_fbm_vdd_tg_fbs_vdd_tg_s_vdd_vdd_vdd_b1_vdd_b2_vdd_b3_vdd_b4_vdd_link_vdd_link_dip_vdd_x1_vdd_x2_vdd_x3_t28 r0 *1 0,0
Ra_d_inv_clk_vdd_inv_mc_vdd_inv_q_vdd_mpa_py_mpb_py_nand_m_vdd_nand_s2_vdd_nwell_vdd_sb_vdd_sr1_vdd_sr2_vdd_sr3_vdd_sr4_vdd_sv_d_vdd_tie_sv_vdd_tg_d_a_tg_d_vdd_tg_fbm_vdd_tg_fbs_vdd_tg_s_vdd_vdd_vdd_b1_vdd_b2_vdd_b3_vdd_b4_vdd_link_vdd_link_dip_vdd_x1_vdd_x2_vdd_x3_t28
+ a|d|inv_clk_vdd|inv_mc_vdd|inv_q_vdd|mpa_py|mpb_py|nand_m_vdd|nand_s2_vdd|nwell_vdd|sb_vdd|sr1_vdd|sr2_vdd|sr3_vdd|sr4_vdd|sv_d_vdd_tie|sv_vdd|tg_d_a|tg_d_vdd|tg_fbm_vdd|tg_fbs_vdd|tg_s_vdd|vdd|vdd_b1|vdd_b2|vdd_b3|vdd_b4|vdd_link|vdd_link_dip|vdd_x1|vdd_x2|vdd_x3__t28
+ a|d|inv_clk_vdd|inv_mc_vdd|inv_q_vdd|mpa_py|mpb_py|nand_m_vdd|nand_s2_vdd|nwell_vdd|sb_vdd|sr1_vdd|sr2_vdd|sr3_vdd|sr4_vdd|sv_d_vdd_tie|sv_vdd|tg_d_a|tg_d_vdd|tg_fbm_vdd|tg_fbs_vdd|tg_s_vdd|vdd|vdd_b1|vdd_b2|vdd_b3|vdd_b4|vdd_link|vdd_link_dip|vdd_x1|vdd_x2|vdd_x3
+ 54.7575311569
* device instance a_d_inv_clk_vdd_inv_mc_vdd_inv_q_vdd_mpa_py_mpb_py_nand_m_vdd_nand_s2_vdd_nwell_vdd_sb_vdd_sr1_vdd_sr2_vdd_sr3_vdd_sr4_vdd_sv_d_vdd_tie_sv_vdd_tg_d_a_tg_d_vdd_tg_fbm_vdd_tg_fbs_vdd_tg_s_vdd_vdd_vdd_b1_vdd_b2_vdd_b3_vdd_b4_vdd_link_vdd_link_dip_vdd_x1_vdd_x2_vdd_x3_t29 r0 *1 0,0
Ra_d_inv_clk_vdd_inv_mc_vdd_inv_q_vdd_mpa_py_mpb_py_nand_m_vdd_nand_s2_vdd_nwell_vdd_sb_vdd_sr1_vdd_sr2_vdd_sr3_vdd_sr4_vdd_sv_d_vdd_tie_sv_vdd_tg_d_a_tg_d_vdd_tg_fbm_vdd_tg_fbs_vdd_tg_s_vdd_vdd_vdd_b1_vdd_b2_vdd_b3_vdd_b4_vdd_link_vdd_link_dip_vdd_x1_vdd_x2_vdd_x3_t29
+ a|d|inv_clk_vdd|inv_mc_vdd|inv_q_vdd|mpa_py|mpb_py|nand_m_vdd|nand_s2_vdd|nwell_vdd|sb_vdd|sr1_vdd|sr2_vdd|sr3_vdd|sr4_vdd|sv_d_vdd_tie|sv_vdd|tg_d_a|tg_d_vdd|tg_fbm_vdd|tg_fbs_vdd|tg_s_vdd|vdd|vdd_b1|vdd_b2|vdd_b3|vdd_b4|vdd_link|vdd_link_dip|vdd_x1|vdd_x2|vdd_x3__t29
+ a|d|inv_clk_vdd|inv_mc_vdd|inv_q_vdd|mpa_py|mpb_py|nand_m_vdd|nand_s2_vdd|nwell_vdd|sb_vdd|sr1_vdd|sr2_vdd|sr3_vdd|sr4_vdd|sv_d_vdd_tie|sv_vdd|tg_d_a|tg_d_vdd|tg_fbm_vdd|tg_fbs_vdd|tg_s_vdd|vdd|vdd_b1|vdd_b2|vdd_b3|vdd_b4|vdd_link|vdd_link_dip|vdd_x1|vdd_x2|vdd_x3
+ 180.492128585
* device instance a_d_inv_clk_vdd_inv_mc_vdd_inv_q_vdd_mpa_py_mpb_py_nand_m_vdd_nand_s2_vdd_nwell_vdd_sb_vdd_sr1_vdd_sr2_vdd_sr3_vdd_sr4_vdd_sv_d_vdd_tie_sv_vdd_tg_d_a_tg_d_vdd_tg_fbm_vdd_tg_fbs_vdd_tg_s_vdd_vdd_vdd_b1_vdd_b2_vdd_b3_vdd_b4_vdd_link_vdd_link_dip_vdd_x1_vdd_x2_vdd_x3_t30 r0 *1 0,0
Ra_d_inv_clk_vdd_inv_mc_vdd_inv_q_vdd_mpa_py_mpb_py_nand_m_vdd_nand_s2_vdd_nwell_vdd_sb_vdd_sr1_vdd_sr2_vdd_sr3_vdd_sr4_vdd_sv_d_vdd_tie_sv_vdd_tg_d_a_tg_d_vdd_tg_fbm_vdd_tg_fbs_vdd_tg_s_vdd_vdd_vdd_b1_vdd_b2_vdd_b3_vdd_b4_vdd_link_vdd_link_dip_vdd_x1_vdd_x2_vdd_x3_t30
+ a|d|inv_clk_vdd|inv_mc_vdd|inv_q_vdd|mpa_py|mpb_py|nand_m_vdd|nand_s2_vdd|nwell_vdd|sb_vdd|sr1_vdd|sr2_vdd|sr3_vdd|sr4_vdd|sv_d_vdd_tie|sv_vdd|tg_d_a|tg_d_vdd|tg_fbm_vdd|tg_fbs_vdd|tg_s_vdd|vdd|vdd_b1|vdd_b2|vdd_b3|vdd_b4|vdd_link|vdd_link_dip|vdd_x1|vdd_x2|vdd_x3__t30
+ a|d|inv_clk_vdd|inv_mc_vdd|inv_q_vdd|mpa_py|mpb_py|nand_m_vdd|nand_s2_vdd|nwell_vdd|sb_vdd|sr1_vdd|sr2_vdd|sr3_vdd|sr4_vdd|sv_d_vdd_tie|sv_vdd|tg_d_a|tg_d_vdd|tg_fbm_vdd|tg_fbs_vdd|tg_s_vdd|vdd|vdd_b1|vdd_b2|vdd_b3|vdd_b4|vdd_link|vdd_link_dip|vdd_x1|vdd_x2|vdd_x3
+ 32.209780801
* device instance a_d_inv_clk_vdd_inv_mc_vdd_inv_q_vdd_mpa_py_mpb_py_nand_m_vdd_nand_s2_vdd_nwell_vdd_sb_vdd_sr1_vdd_sr2_vdd_sr3_vdd_sr4_vdd_sv_d_vdd_tie_sv_vdd_tg_d_a_tg_d_vdd_tg_fbm_vdd_tg_fbs_vdd_tg_s_vdd_vdd_vdd_b1_vdd_b2_vdd_b3_vdd_b4_vdd_link_vdd_link_dip_vdd_x1_vdd_x2_vdd_x3_t31 r0 *1 0,0
Ra_d_inv_clk_vdd_inv_mc_vdd_inv_q_vdd_mpa_py_mpb_py_nand_m_vdd_nand_s2_vdd_nwell_vdd_sb_vdd_sr1_vdd_sr2_vdd_sr3_vdd_sr4_vdd_sv_d_vdd_tie_sv_vdd_tg_d_a_tg_d_vdd_tg_fbm_vdd_tg_fbs_vdd_tg_s_vdd_vdd_vdd_b1_vdd_b2_vdd_b3_vdd_b4_vdd_link_vdd_link_dip_vdd_x1_vdd_x2_vdd_x3_t31
+ a|d|inv_clk_vdd|inv_mc_vdd|inv_q_vdd|mpa_py|mpb_py|nand_m_vdd|nand_s2_vdd|nwell_vdd|sb_vdd|sr1_vdd|sr2_vdd|sr3_vdd|sr4_vdd|sv_d_vdd_tie|sv_vdd|tg_d_a|tg_d_vdd|tg_fbm_vdd|tg_fbs_vdd|tg_s_vdd|vdd|vdd_b1|vdd_b2|vdd_b3|vdd_b4|vdd_link|vdd_link_dip|vdd_x1|vdd_x2|vdd_x3__t31
+ a|d|inv_clk_vdd|inv_mc_vdd|inv_q_vdd|mpa_py|mpb_py|nand_m_vdd|nand_s2_vdd|nwell_vdd|sb_vdd|sr1_vdd|sr2_vdd|sr3_vdd|sr4_vdd|sv_d_vdd_tie|sv_vdd|tg_d_a|tg_d_vdd|tg_fbm_vdd|tg_fbs_vdd|tg_s_vdd|vdd|vdd_b1|vdd_b2|vdd_b3|vdd_b4|vdd_link|vdd_link_dip|vdd_x1|vdd_x2|vdd_x3
+ 135.360970407
* device instance a_d_inv_clk_vdd_inv_mc_vdd_inv_q_vdd_mpa_py_mpb_py_nand_m_vdd_nand_s2_vdd_nwell_vdd_sb_vdd_sr1_vdd_sr2_vdd_sr3_vdd_sr4_vdd_sv_d_vdd_tie_sv_vdd_tg_d_a_tg_d_vdd_tg_fbm_vdd_tg_fbs_vdd_tg_s_vdd_vdd_vdd_b1_vdd_b2_vdd_b3_vdd_b4_vdd_link_vdd_link_dip_vdd_x1_vdd_x2_vdd_x3_t32 r0 *1 0,0
Ra_d_inv_clk_vdd_inv_mc_vdd_inv_q_vdd_mpa_py_mpb_py_nand_m_vdd_nand_s2_vdd_nwell_vdd_sb_vdd_sr1_vdd_sr2_vdd_sr3_vdd_sr4_vdd_sv_d_vdd_tie_sv_vdd_tg_d_a_tg_d_vdd_tg_fbm_vdd_tg_fbs_vdd_tg_s_vdd_vdd_vdd_b1_vdd_b2_vdd_b3_vdd_b4_vdd_link_vdd_link_dip_vdd_x1_vdd_x2_vdd_x3_t32
+ a|d|inv_clk_vdd|inv_mc_vdd|inv_q_vdd|mpa_py|mpb_py|nand_m_vdd|nand_s2_vdd|nwell_vdd|sb_vdd|sr1_vdd|sr2_vdd|sr3_vdd|sr4_vdd|sv_d_vdd_tie|sv_vdd|tg_d_a|tg_d_vdd|tg_fbm_vdd|tg_fbs_vdd|tg_s_vdd|vdd|vdd_b1|vdd_b2|vdd_b3|vdd_b4|vdd_link|vdd_link_dip|vdd_x1|vdd_x2|vdd_x3__t32
+ a|d|inv_clk_vdd|inv_mc_vdd|inv_q_vdd|mpa_py|mpb_py|nand_m_vdd|nand_s2_vdd|nwell_vdd|sb_vdd|sr1_vdd|sr2_vdd|sr3_vdd|sr4_vdd|sv_d_vdd_tie|sv_vdd|tg_d_a|tg_d_vdd|tg_fbm_vdd|tg_fbs_vdd|tg_s_vdd|vdd|vdd_b1|vdd_b2|vdd_b3|vdd_b4|vdd_link|vdd_link_dip|vdd_x1|vdd_x2|vdd_x3
+ 99.2174046262
* device instance a_d_inv_clk_vdd_inv_mc_vdd_inv_q_vdd_mpa_py_mpb_py_nand_m_vdd_nand_s2_vdd_nwell_vdd_sb_vdd_sr1_vdd_sr2_vdd_sr3_vdd_sr4_vdd_sv_d_vdd_tie_sv_vdd_tg_d_a_tg_d_vdd_tg_fbm_vdd_tg_fbs_vdd_tg_s_vdd_vdd_vdd_b1_vdd_b2_vdd_b3_vdd_b4_vdd_link_vdd_link_dip_vdd_x1_vdd_x2_vdd_x3_t33 r0 *1 0,0
Ra_d_inv_clk_vdd_inv_mc_vdd_inv_q_vdd_mpa_py_mpb_py_nand_m_vdd_nand_s2_vdd_nwell_vdd_sb_vdd_sr1_vdd_sr2_vdd_sr3_vdd_sr4_vdd_sv_d_vdd_tie_sv_vdd_tg_d_a_tg_d_vdd_tg_fbm_vdd_tg_fbs_vdd_tg_s_vdd_vdd_vdd_b1_vdd_b2_vdd_b3_vdd_b4_vdd_link_vdd_link_dip_vdd_x1_vdd_x2_vdd_x3_t33
+ a|d|inv_clk_vdd|inv_mc_vdd|inv_q_vdd|mpa_py|mpb_py|nand_m_vdd|nand_s2_vdd|nwell_vdd|sb_vdd|sr1_vdd|sr2_vdd|sr3_vdd|sr4_vdd|sv_d_vdd_tie|sv_vdd|tg_d_a|tg_d_vdd|tg_fbm_vdd|tg_fbs_vdd|tg_s_vdd|vdd|vdd_b1|vdd_b2|vdd_b3|vdd_b4|vdd_link|vdd_link_dip|vdd_x1|vdd_x2|vdd_x3__t33
+ a|d|inv_clk_vdd|inv_mc_vdd|inv_q_vdd|mpa_py|mpb_py|nand_m_vdd|nand_s2_vdd|nwell_vdd|sb_vdd|sr1_vdd|sr2_vdd|sr3_vdd|sr4_vdd|sv_d_vdd_tie|sv_vdd|tg_d_a|tg_d_vdd|tg_fbm_vdd|tg_fbs_vdd|tg_s_vdd|vdd|vdd_b1|vdd_b2|vdd_b3|vdd_b4|vdd_link|vdd_link_dip|vdd_x1|vdd_x2|vdd_x3
+ 111.896855982
* device instance a_d_inv_clk_vdd_inv_mc_vdd_inv_q_vdd_mpa_py_mpb_py_nand_m_vdd_nand_s2_vdd_nwell_vdd_sb_vdd_sr1_vdd_sr2_vdd_sr3_vdd_sr4_vdd_sv_d_vdd_tie_sv_vdd_tg_d_a_tg_d_vdd_tg_fbm_vdd_tg_fbs_vdd_tg_s_vdd_vdd_vdd_b1_vdd_b2_vdd_b3_vdd_b4_vdd_link_vdd_link_dip_vdd_x1_vdd_x2_vdd_x3_t34 r0 *1 0,0
Ra_d_inv_clk_vdd_inv_mc_vdd_inv_q_vdd_mpa_py_mpb_py_nand_m_vdd_nand_s2_vdd_nwell_vdd_sb_vdd_sr1_vdd_sr2_vdd_sr3_vdd_sr4_vdd_sv_d_vdd_tie_sv_vdd_tg_d_a_tg_d_vdd_tg_fbm_vdd_tg_fbs_vdd_tg_s_vdd_vdd_vdd_b1_vdd_b2_vdd_b3_vdd_b4_vdd_link_vdd_link_dip_vdd_x1_vdd_x2_vdd_x3_t34
+ a|d|inv_clk_vdd|inv_mc_vdd|inv_q_vdd|mpa_py|mpb_py|nand_m_vdd|nand_s2_vdd|nwell_vdd|sb_vdd|sr1_vdd|sr2_vdd|sr3_vdd|sr4_vdd|sv_d_vdd_tie|sv_vdd|tg_d_a|tg_d_vdd|tg_fbm_vdd|tg_fbs_vdd|tg_s_vdd|vdd|vdd_b1|vdd_b2|vdd_b3|vdd_b4|vdd_link|vdd_link_dip|vdd_x1|vdd_x2|vdd_x3__t34
+ a|d|inv_clk_vdd|inv_mc_vdd|inv_q_vdd|mpa_py|mpb_py|nand_m_vdd|nand_s2_vdd|nwell_vdd|sb_vdd|sr1_vdd|sr2_vdd|sr3_vdd|sr4_vdd|sv_d_vdd_tie|sv_vdd|tg_d_a|tg_d_vdd|tg_fbm_vdd|tg_fbs_vdd|tg_s_vdd|vdd|vdd_b1|vdd_b2|vdd_b3|vdd_b4|vdd_link|vdd_link_dip|vdd_x1|vdd_x2|vdd_x3
+ 171.705130511
* device instance a_d_inv_clk_vdd_inv_mc_vdd_inv_q_vdd_mpa_py_mpb_py_nand_m_vdd_nand_s2_vdd_nwell_vdd_sb_vdd_sr1_vdd_sr2_vdd_sr3_vdd_sr4_vdd_sv_d_vdd_tie_sv_vdd_tg_d_a_tg_d_vdd_tg_fbm_vdd_tg_fbs_vdd_tg_s_vdd_vdd_vdd_b1_vdd_b2_vdd_b3_vdd_b4_vdd_link_vdd_link_dip_vdd_x1_vdd_x2_vdd_x3_t35 r0 *1 0,0
Ra_d_inv_clk_vdd_inv_mc_vdd_inv_q_vdd_mpa_py_mpb_py_nand_m_vdd_nand_s2_vdd_nwell_vdd_sb_vdd_sr1_vdd_sr2_vdd_sr3_vdd_sr4_vdd_sv_d_vdd_tie_sv_vdd_tg_d_a_tg_d_vdd_tg_fbm_vdd_tg_fbs_vdd_tg_s_vdd_vdd_vdd_b1_vdd_b2_vdd_b3_vdd_b4_vdd_link_vdd_link_dip_vdd_x1_vdd_x2_vdd_x3_t35
+ a|d|inv_clk_vdd|inv_mc_vdd|inv_q_vdd|mpa_py|mpb_py|nand_m_vdd|nand_s2_vdd|nwell_vdd|sb_vdd|sr1_vdd|sr2_vdd|sr3_vdd|sr4_vdd|sv_d_vdd_tie|sv_vdd|tg_d_a|tg_d_vdd|tg_fbm_vdd|tg_fbs_vdd|tg_s_vdd|vdd|vdd_b1|vdd_b2|vdd_b3|vdd_b4|vdd_link|vdd_link_dip|vdd_x1|vdd_x2|vdd_x3__t35
+ a|d|inv_clk_vdd|inv_mc_vdd|inv_q_vdd|mpa_py|mpb_py|nand_m_vdd|nand_s2_vdd|nwell_vdd|sb_vdd|sr1_vdd|sr2_vdd|sr3_vdd|sr4_vdd|sv_d_vdd_tie|sv_vdd|tg_d_a|tg_d_vdd|tg_fbm_vdd|tg_fbs_vdd|tg_s_vdd|vdd|vdd_b1|vdd_b2|vdd_b3|vdd_b4|vdd_link|vdd_link_dip|vdd_x1|vdd_x2|vdd_x3
+ 199.938103526
* device instance a_d_inv_clk_vdd_inv_mc_vdd_inv_q_vdd_mpa_py_mpb_py_nand_m_vdd_nand_s2_vdd_nwell_vdd_sb_vdd_sr1_vdd_sr2_vdd_sr3_vdd_sr4_vdd_sv_d_vdd_tie_sv_vdd_tg_d_a_tg_d_vdd_tg_fbm_vdd_tg_fbs_vdd_tg_s_vdd_vdd_vdd_b1_vdd_b2_vdd_b3_vdd_b4_vdd_link_vdd_link_dip_vdd_x1_vdd_x2_vdd_x3_t36 r0 *1 0,0
Ra_d_inv_clk_vdd_inv_mc_vdd_inv_q_vdd_mpa_py_mpb_py_nand_m_vdd_nand_s2_vdd_nwell_vdd_sb_vdd_sr1_vdd_sr2_vdd_sr3_vdd_sr4_vdd_sv_d_vdd_tie_sv_vdd_tg_d_a_tg_d_vdd_tg_fbm_vdd_tg_fbs_vdd_tg_s_vdd_vdd_vdd_b1_vdd_b2_vdd_b3_vdd_b4_vdd_link_vdd_link_dip_vdd_x1_vdd_x2_vdd_x3_t36
+ a|d|inv_clk_vdd|inv_mc_vdd|inv_q_vdd|mpa_py|mpb_py|nand_m_vdd|nand_s2_vdd|nwell_vdd|sb_vdd|sr1_vdd|sr2_vdd|sr3_vdd|sr4_vdd|sv_d_vdd_tie|sv_vdd|tg_d_a|tg_d_vdd|tg_fbm_vdd|tg_fbs_vdd|tg_s_vdd|vdd|vdd_b1|vdd_b2|vdd_b3|vdd_b4|vdd_link|vdd_link_dip|vdd_x1|vdd_x2|vdd_x3__t36
+ a|d|inv_clk_vdd|inv_mc_vdd|inv_q_vdd|mpa_py|mpb_py|nand_m_vdd|nand_s2_vdd|nwell_vdd|sb_vdd|sr1_vdd|sr2_vdd|sr3_vdd|sr4_vdd|sv_d_vdd_tie|sv_vdd|tg_d_a|tg_d_vdd|tg_fbm_vdd|tg_fbs_vdd|tg_s_vdd|vdd|vdd_b1|vdd_b2|vdd_b3|vdd_b4|vdd_link|vdd_link_dip|vdd_x1|vdd_x2|vdd_x3
+ 210.446064443
* device instance a_d_inv_clk_vdd_inv_mc_vdd_inv_q_vdd_mpa_py_mpb_py_nand_m_vdd_nand_s2_vdd_nwell_vdd_sb_vdd_sr1_vdd_sr2_vdd_sr3_vdd_sr4_vdd_sv_d_vdd_tie_sv_vdd_tg_d_a_tg_d_vdd_tg_fbm_vdd_tg_fbs_vdd_tg_s_vdd_vdd_vdd_b1_vdd_b2_vdd_b3_vdd_b4_vdd_link_vdd_link_dip_vdd_x1_vdd_x2_vdd_x3_t37 r0 *1 0,0
Ra_d_inv_clk_vdd_inv_mc_vdd_inv_q_vdd_mpa_py_mpb_py_nand_m_vdd_nand_s2_vdd_nwell_vdd_sb_vdd_sr1_vdd_sr2_vdd_sr3_vdd_sr4_vdd_sv_d_vdd_tie_sv_vdd_tg_d_a_tg_d_vdd_tg_fbm_vdd_tg_fbs_vdd_tg_s_vdd_vdd_vdd_b1_vdd_b2_vdd_b3_vdd_b4_vdd_link_vdd_link_dip_vdd_x1_vdd_x2_vdd_x3_t37
+ a|d|inv_clk_vdd|inv_mc_vdd|inv_q_vdd|mpa_py|mpb_py|nand_m_vdd|nand_s2_vdd|nwell_vdd|sb_vdd|sr1_vdd|sr2_vdd|sr3_vdd|sr4_vdd|sv_d_vdd_tie|sv_vdd|tg_d_a|tg_d_vdd|tg_fbm_vdd|tg_fbs_vdd|tg_s_vdd|vdd|vdd_b1|vdd_b2|vdd_b3|vdd_b4|vdd_link|vdd_link_dip|vdd_x1|vdd_x2|vdd_x3__t37
+ a|d|inv_clk_vdd|inv_mc_vdd|inv_q_vdd|mpa_py|mpb_py|nand_m_vdd|nand_s2_vdd|nwell_vdd|sb_vdd|sr1_vdd|sr2_vdd|sr3_vdd|sr4_vdd|sv_d_vdd_tie|sv_vdd|tg_d_a|tg_d_vdd|tg_fbm_vdd|tg_fbs_vdd|tg_s_vdd|vdd|vdd_b1|vdd_b2|vdd_b3|vdd_b4|vdd_link|vdd_link_dip|vdd_x1|vdd_x2|vdd_x3
+ 173.908613154
* device instance a_d_inv_clk_vdd_inv_mc_vdd_inv_q_vdd_mpa_py_mpb_py_nand_m_vdd_nand_s2_vdd_nwell_vdd_sb_vdd_sr1_vdd_sr2_vdd_sr3_vdd_sr4_vdd_sv_d_vdd_tie_sv_vdd_tg_d_a_tg_d_vdd_tg_fbm_vdd_tg_fbs_vdd_tg_s_vdd_vdd_vdd_b1_vdd_b2_vdd_b3_vdd_b4_vdd_link_vdd_link_dip_vdd_x1_vdd_x2_vdd_x3_t38 r0 *1 0,0
Ra_d_inv_clk_vdd_inv_mc_vdd_inv_q_vdd_mpa_py_mpb_py_nand_m_vdd_nand_s2_vdd_nwell_vdd_sb_vdd_sr1_vdd_sr2_vdd_sr3_vdd_sr4_vdd_sv_d_vdd_tie_sv_vdd_tg_d_a_tg_d_vdd_tg_fbm_vdd_tg_fbs_vdd_tg_s_vdd_vdd_vdd_b1_vdd_b2_vdd_b3_vdd_b4_vdd_link_vdd_link_dip_vdd_x1_vdd_x2_vdd_x3_t38
+ a|d|inv_clk_vdd|inv_mc_vdd|inv_q_vdd|mpa_py|mpb_py|nand_m_vdd|nand_s2_vdd|nwell_vdd|sb_vdd|sr1_vdd|sr2_vdd|sr3_vdd|sr4_vdd|sv_d_vdd_tie|sv_vdd|tg_d_a|tg_d_vdd|tg_fbm_vdd|tg_fbs_vdd|tg_s_vdd|vdd|vdd_b1|vdd_b2|vdd_b3|vdd_b4|vdd_link|vdd_link_dip|vdd_x1|vdd_x2|vdd_x3__t38
+ a|d|inv_clk_vdd|inv_mc_vdd|inv_q_vdd|mpa_py|mpb_py|nand_m_vdd|nand_s2_vdd|nwell_vdd|sb_vdd|sr1_vdd|sr2_vdd|sr3_vdd|sr4_vdd|sv_d_vdd_tie|sv_vdd|tg_d_a|tg_d_vdd|tg_fbm_vdd|tg_fbs_vdd|tg_s_vdd|vdd|vdd_b1|vdd_b2|vdd_b3|vdd_b4|vdd_link|vdd_link_dip|vdd_x1|vdd_x2|vdd_x3
+ 158.660523292
* device instance a_d_inv_clk_vdd_inv_mc_vdd_inv_q_vdd_mpa_py_mpb_py_nand_m_vdd_nand_s2_vdd_nwell_vdd_sb_vdd_sr1_vdd_sr2_vdd_sr3_vdd_sr4_vdd_sv_d_vdd_tie_sv_vdd_tg_d_a_tg_d_vdd_tg_fbm_vdd_tg_fbs_vdd_tg_s_vdd_vdd_vdd_b1_vdd_b2_vdd_b3_vdd_b4_vdd_link_vdd_link_dip_vdd_x1_vdd_x2_vdd_x3_t39 r0 *1 0,0
Ra_d_inv_clk_vdd_inv_mc_vdd_inv_q_vdd_mpa_py_mpb_py_nand_m_vdd_nand_s2_vdd_nwell_vdd_sb_vdd_sr1_vdd_sr2_vdd_sr3_vdd_sr4_vdd_sv_d_vdd_tie_sv_vdd_tg_d_a_tg_d_vdd_tg_fbm_vdd_tg_fbs_vdd_tg_s_vdd_vdd_vdd_b1_vdd_b2_vdd_b3_vdd_b4_vdd_link_vdd_link_dip_vdd_x1_vdd_x2_vdd_x3_t39
+ a|d|inv_clk_vdd|inv_mc_vdd|inv_q_vdd|mpa_py|mpb_py|nand_m_vdd|nand_s2_vdd|nwell_vdd|sb_vdd|sr1_vdd|sr2_vdd|sr3_vdd|sr4_vdd|sv_d_vdd_tie|sv_vdd|tg_d_a|tg_d_vdd|tg_fbm_vdd|tg_fbs_vdd|tg_s_vdd|vdd|vdd_b1|vdd_b2|vdd_b3|vdd_b4|vdd_link|vdd_link_dip|vdd_x1|vdd_x2|vdd_x3__t39
+ a|d|inv_clk_vdd|inv_mc_vdd|inv_q_vdd|mpa_py|mpb_py|nand_m_vdd|nand_s2_vdd|nwell_vdd|sb_vdd|sr1_vdd|sr2_vdd|sr3_vdd|sr4_vdd|sv_d_vdd_tie|sv_vdd|tg_d_a|tg_d_vdd|tg_fbm_vdd|tg_fbs_vdd|tg_s_vdd|vdd|vdd_b1|vdd_b2|vdd_b3|vdd_b4|vdd_link|vdd_link_dip|vdd_x1|vdd_x2|vdd_x3
+ 217.426079666
* device instance a_d_inv_clk_vdd_inv_mc_vdd_inv_q_vdd_mpa_py_mpb_py_nand_m_vdd_nand_s2_vdd_nwell_vdd_sb_vdd_sr1_vdd_sr2_vdd_sr3_vdd_sr4_vdd_sv_d_vdd_tie_sv_vdd_tg_d_a_tg_d_vdd_tg_fbm_vdd_tg_fbs_vdd_tg_s_vdd_vdd_vdd_b1_vdd_b2_vdd_b3_vdd_b4_vdd_link_vdd_link_dip_vdd_x1_vdd_x2_vdd_x3_t40 r0 *1 0,0
Ra_d_inv_clk_vdd_inv_mc_vdd_inv_q_vdd_mpa_py_mpb_py_nand_m_vdd_nand_s2_vdd_nwell_vdd_sb_vdd_sr1_vdd_sr2_vdd_sr3_vdd_sr4_vdd_sv_d_vdd_tie_sv_vdd_tg_d_a_tg_d_vdd_tg_fbm_vdd_tg_fbs_vdd_tg_s_vdd_vdd_vdd_b1_vdd_b2_vdd_b3_vdd_b4_vdd_link_vdd_link_dip_vdd_x1_vdd_x2_vdd_x3_t40
+ a|d|inv_clk_vdd|inv_mc_vdd|inv_q_vdd|mpa_py|mpb_py|nand_m_vdd|nand_s2_vdd|nwell_vdd|sb_vdd|sr1_vdd|sr2_vdd|sr3_vdd|sr4_vdd|sv_d_vdd_tie|sv_vdd|tg_d_a|tg_d_vdd|tg_fbm_vdd|tg_fbs_vdd|tg_s_vdd|vdd|vdd_b1|vdd_b2|vdd_b3|vdd_b4|vdd_link|vdd_link_dip|vdd_x1|vdd_x2|vdd_x3__t40
+ a|d|inv_clk_vdd|inv_mc_vdd|inv_q_vdd|mpa_py|mpb_py|nand_m_vdd|nand_s2_vdd|nwell_vdd|sb_vdd|sr1_vdd|sr2_vdd|sr3_vdd|sr4_vdd|sv_d_vdd_tie|sv_vdd|tg_d_a|tg_d_vdd|tg_fbm_vdd|tg_fbs_vdd|tg_s_vdd|vdd|vdd_b1|vdd_b2|vdd_b3|vdd_b4|vdd_link|vdd_link_dip|vdd_x1|vdd_x2|vdd_x3
+ 50.5462818726
* device instance a_d_inv_clk_vdd_inv_mc_vdd_inv_q_vdd_mpa_py_mpb_py_nand_m_vdd_nand_s2_vdd_nwell_vdd_sb_vdd_sr1_vdd_sr2_vdd_sr3_vdd_sr4_vdd_sv_d_vdd_tie_sv_vdd_tg_d_a_tg_d_vdd_tg_fbm_vdd_tg_fbs_vdd_tg_s_vdd_vdd_vdd_b1_vdd_b2_vdd_b3_vdd_b4_vdd_link_vdd_link_dip_vdd_x1_vdd_x2_vdd_x3_t41 r0 *1 0,0
Ra_d_inv_clk_vdd_inv_mc_vdd_inv_q_vdd_mpa_py_mpb_py_nand_m_vdd_nand_s2_vdd_nwell_vdd_sb_vdd_sr1_vdd_sr2_vdd_sr3_vdd_sr4_vdd_sv_d_vdd_tie_sv_vdd_tg_d_a_tg_d_vdd_tg_fbm_vdd_tg_fbs_vdd_tg_s_vdd_vdd_vdd_b1_vdd_b2_vdd_b3_vdd_b4_vdd_link_vdd_link_dip_vdd_x1_vdd_x2_vdd_x3_t41
+ a|d|inv_clk_vdd|inv_mc_vdd|inv_q_vdd|mpa_py|mpb_py|nand_m_vdd|nand_s2_vdd|nwell_vdd|sb_vdd|sr1_vdd|sr2_vdd|sr3_vdd|sr4_vdd|sv_d_vdd_tie|sv_vdd|tg_d_a|tg_d_vdd|tg_fbm_vdd|tg_fbs_vdd|tg_s_vdd|vdd|vdd_b1|vdd_b2|vdd_b3|vdd_b4|vdd_link|vdd_link_dip|vdd_x1|vdd_x2|vdd_x3__t41
+ a|d|inv_clk_vdd|inv_mc_vdd|inv_q_vdd|mpa_py|mpb_py|nand_m_vdd|nand_s2_vdd|nwell_vdd|sb_vdd|sr1_vdd|sr2_vdd|sr3_vdd|sr4_vdd|sv_d_vdd_tie|sv_vdd|tg_d_a|tg_d_vdd|tg_fbm_vdd|tg_fbs_vdd|tg_s_vdd|vdd|vdd_b1|vdd_b2|vdd_b3|vdd_b4|vdd_link|vdd_link_dip|vdd_x1|vdd_x2|vdd_x3
+ 133.307481456
* device instance a_d_inv_clk_vdd_inv_mc_vdd_inv_q_vdd_mpa_py_mpb_py_nand_m_vdd_nand_s2_vdd_nwell_vdd_sb_vdd_sr1_vdd_sr2_vdd_sr3_vdd_sr4_vdd_sv_d_vdd_tie_sv_vdd_tg_d_a_tg_d_vdd_tg_fbm_vdd_tg_fbs_vdd_tg_s_vdd_vdd_vdd_b1_vdd_b2_vdd_b3_vdd_b4_vdd_link_vdd_link_dip_vdd_x1_vdd_x2_vdd_x3_t42 r0 *1 0,0
Ra_d_inv_clk_vdd_inv_mc_vdd_inv_q_vdd_mpa_py_mpb_py_nand_m_vdd_nand_s2_vdd_nwell_vdd_sb_vdd_sr1_vdd_sr2_vdd_sr3_vdd_sr4_vdd_sv_d_vdd_tie_sv_vdd_tg_d_a_tg_d_vdd_tg_fbm_vdd_tg_fbs_vdd_tg_s_vdd_vdd_vdd_b1_vdd_b2_vdd_b3_vdd_b4_vdd_link_vdd_link_dip_vdd_x1_vdd_x2_vdd_x3_t42
+ a|d|inv_clk_vdd|inv_mc_vdd|inv_q_vdd|mpa_py|mpb_py|nand_m_vdd|nand_s2_vdd|nwell_vdd|sb_vdd|sr1_vdd|sr2_vdd|sr3_vdd|sr4_vdd|sv_d_vdd_tie|sv_vdd|tg_d_a|tg_d_vdd|tg_fbm_vdd|tg_fbs_vdd|tg_s_vdd|vdd|vdd_b1|vdd_b2|vdd_b3|vdd_b4|vdd_link|vdd_link_dip|vdd_x1|vdd_x2|vdd_x3__t42
+ a|d|inv_clk_vdd|inv_mc_vdd|inv_q_vdd|mpa_py|mpb_py|nand_m_vdd|nand_s2_vdd|nwell_vdd|sb_vdd|sr1_vdd|sr2_vdd|sr3_vdd|sr4_vdd|sv_d_vdd_tie|sv_vdd|tg_d_a|tg_d_vdd|tg_fbm_vdd|tg_fbs_vdd|tg_s_vdd|vdd|vdd_b1|vdd_b2|vdd_b3|vdd_b4|vdd_link|vdd_link_dip|vdd_x1|vdd_x2|vdd_x3
+ 118.527622922
* device instance a_d_inv_clk_vdd_inv_mc_vdd_inv_q_vdd_mpa_py_mpb_py_nand_m_vdd_nand_s2_vdd_nwell_vdd_sb_vdd_sr1_vdd_sr2_vdd_sr3_vdd_sr4_vdd_sv_d_vdd_tie_sv_vdd_tg_d_a_tg_d_vdd_tg_fbm_vdd_tg_fbs_vdd_tg_s_vdd_vdd_vdd_b1_vdd_b2_vdd_b3_vdd_b4_vdd_link_vdd_link_dip_vdd_x1_vdd_x2_vdd_x3_t43 r0 *1 0,0
Ra_d_inv_clk_vdd_inv_mc_vdd_inv_q_vdd_mpa_py_mpb_py_nand_m_vdd_nand_s2_vdd_nwell_vdd_sb_vdd_sr1_vdd_sr2_vdd_sr3_vdd_sr4_vdd_sv_d_vdd_tie_sv_vdd_tg_d_a_tg_d_vdd_tg_fbm_vdd_tg_fbs_vdd_tg_s_vdd_vdd_vdd_b1_vdd_b2_vdd_b3_vdd_b4_vdd_link_vdd_link_dip_vdd_x1_vdd_x2_vdd_x3_t43
+ a|d|inv_clk_vdd|inv_mc_vdd|inv_q_vdd|mpa_py|mpb_py|nand_m_vdd|nand_s2_vdd|nwell_vdd|sb_vdd|sr1_vdd|sr2_vdd|sr3_vdd|sr4_vdd|sv_d_vdd_tie|sv_vdd|tg_d_a|tg_d_vdd|tg_fbm_vdd|tg_fbs_vdd|tg_s_vdd|vdd|vdd_b1|vdd_b2|vdd_b3|vdd_b4|vdd_link|vdd_link_dip|vdd_x1|vdd_x2|vdd_x3__t43
+ a|d|inv_clk_vdd|inv_mc_vdd|inv_q_vdd|mpa_py|mpb_py|nand_m_vdd|nand_s2_vdd|nwell_vdd|sb_vdd|sr1_vdd|sr2_vdd|sr3_vdd|sr4_vdd|sv_d_vdd_tie|sv_vdd|tg_d_a|tg_d_vdd|tg_fbm_vdd|tg_fbs_vdd|tg_s_vdd|vdd|vdd_b1|vdd_b2|vdd_b3|vdd_b4|vdd_link|vdd_link_dip|vdd_x1|vdd_x2|vdd_x3
+ 245.693393963
* device instance a_d_inv_clk_vdd_inv_mc_vdd_inv_q_vdd_mpa_py_mpb_py_nand_m_vdd_nand_s2_vdd_nwell_vdd_sb_vdd_sr1_vdd_sr2_vdd_sr3_vdd_sr4_vdd_sv_d_vdd_tie_sv_vdd_tg_d_a_tg_d_vdd_tg_fbm_vdd_tg_fbs_vdd_tg_s_vdd_vdd_vdd_b1_vdd_b2_vdd_b3_vdd_b4_vdd_link_vdd_link_dip_vdd_x1_vdd_x2_vdd_x3_t44 r0 *1 0,0
Ra_d_inv_clk_vdd_inv_mc_vdd_inv_q_vdd_mpa_py_mpb_py_nand_m_vdd_nand_s2_vdd_nwell_vdd_sb_vdd_sr1_vdd_sr2_vdd_sr3_vdd_sr4_vdd_sv_d_vdd_tie_sv_vdd_tg_d_a_tg_d_vdd_tg_fbm_vdd_tg_fbs_vdd_tg_s_vdd_vdd_vdd_b1_vdd_b2_vdd_b3_vdd_b4_vdd_link_vdd_link_dip_vdd_x1_vdd_x2_vdd_x3_t44
+ a|d|inv_clk_vdd|inv_mc_vdd|inv_q_vdd|mpa_py|mpb_py|nand_m_vdd|nand_s2_vdd|nwell_vdd|sb_vdd|sr1_vdd|sr2_vdd|sr3_vdd|sr4_vdd|sv_d_vdd_tie|sv_vdd|tg_d_a|tg_d_vdd|tg_fbm_vdd|tg_fbs_vdd|tg_s_vdd|vdd|vdd_b1|vdd_b2|vdd_b3|vdd_b4|vdd_link|vdd_link_dip|vdd_x1|vdd_x2|vdd_x3__t44
+ a|d|inv_clk_vdd|inv_mc_vdd|inv_q_vdd|mpa_py|mpb_py|nand_m_vdd|nand_s2_vdd|nwell_vdd|sb_vdd|sr1_vdd|sr2_vdd|sr3_vdd|sr4_vdd|sv_d_vdd_tie|sv_vdd|tg_d_a|tg_d_vdd|tg_fbm_vdd|tg_fbs_vdd|tg_s_vdd|vdd|vdd_b1|vdd_b2|vdd_b3|vdd_b4|vdd_link|vdd_link_dip|vdd_x1|vdd_x2|vdd_x3
+ 253.227807773
* device instance a_d_inv_clk_vdd_inv_mc_vdd_inv_q_vdd_mpa_py_mpb_py_nand_m_vdd_nand_s2_vdd_nwell_vdd_sb_vdd_sr1_vdd_sr2_vdd_sr3_vdd_sr4_vdd_sv_d_vdd_tie_sv_vdd_tg_d_a_tg_d_vdd_tg_fbm_vdd_tg_fbs_vdd_tg_s_vdd_vdd_vdd_b1_vdd_b2_vdd_b3_vdd_b4_vdd_link_vdd_link_dip_vdd_x1_vdd_x2_vdd_x3_t45 r0 *1 0,0
Ra_d_inv_clk_vdd_inv_mc_vdd_inv_q_vdd_mpa_py_mpb_py_nand_m_vdd_nand_s2_vdd_nwell_vdd_sb_vdd_sr1_vdd_sr2_vdd_sr3_vdd_sr4_vdd_sv_d_vdd_tie_sv_vdd_tg_d_a_tg_d_vdd_tg_fbm_vdd_tg_fbs_vdd_tg_s_vdd_vdd_vdd_b1_vdd_b2_vdd_b3_vdd_b4_vdd_link_vdd_link_dip_vdd_x1_vdd_x2_vdd_x3_t45
+ a|d|inv_clk_vdd|inv_mc_vdd|inv_q_vdd|mpa_py|mpb_py|nand_m_vdd|nand_s2_vdd|nwell_vdd|sb_vdd|sr1_vdd|sr2_vdd|sr3_vdd|sr4_vdd|sv_d_vdd_tie|sv_vdd|tg_d_a|tg_d_vdd|tg_fbm_vdd|tg_fbs_vdd|tg_s_vdd|vdd|vdd_b1|vdd_b2|vdd_b3|vdd_b4|vdd_link|vdd_link_dip|vdd_x1|vdd_x2|vdd_x3__t45
+ a|d|inv_clk_vdd|inv_mc_vdd|inv_q_vdd|mpa_py|mpb_py|nand_m_vdd|nand_s2_vdd|nwell_vdd|sb_vdd|sr1_vdd|sr2_vdd|sr3_vdd|sr4_vdd|sv_d_vdd_tie|sv_vdd|tg_d_a|tg_d_vdd|tg_fbm_vdd|tg_fbs_vdd|tg_s_vdd|vdd|vdd_b1|vdd_b2|vdd_b3|vdd_b4|vdd_link|vdd_link_dip|vdd_x1|vdd_x2|vdd_x3
+ 263.20408715
* device instance a_d_inv_clk_vdd_inv_mc_vdd_inv_q_vdd_mpa_py_mpb_py_nand_m_vdd_nand_s2_vdd_nwell_vdd_sb_vdd_sr1_vdd_sr2_vdd_sr3_vdd_sr4_vdd_sv_d_vdd_tie_sv_vdd_tg_d_a_tg_d_vdd_tg_fbm_vdd_tg_fbs_vdd_tg_s_vdd_vdd_vdd_b1_vdd_b2_vdd_b3_vdd_b4_vdd_link_vdd_link_dip_vdd_x1_vdd_x2_vdd_x3_t46 r0 *1 0,0
Ra_d_inv_clk_vdd_inv_mc_vdd_inv_q_vdd_mpa_py_mpb_py_nand_m_vdd_nand_s2_vdd_nwell_vdd_sb_vdd_sr1_vdd_sr2_vdd_sr3_vdd_sr4_vdd_sv_d_vdd_tie_sv_vdd_tg_d_a_tg_d_vdd_tg_fbm_vdd_tg_fbs_vdd_tg_s_vdd_vdd_vdd_b1_vdd_b2_vdd_b3_vdd_b4_vdd_link_vdd_link_dip_vdd_x1_vdd_x2_vdd_x3_t46
+ a|d|inv_clk_vdd|inv_mc_vdd|inv_q_vdd|mpa_py|mpb_py|nand_m_vdd|nand_s2_vdd|nwell_vdd|sb_vdd|sr1_vdd|sr2_vdd|sr3_vdd|sr4_vdd|sv_d_vdd_tie|sv_vdd|tg_d_a|tg_d_vdd|tg_fbm_vdd|tg_fbs_vdd|tg_s_vdd|vdd|vdd_b1|vdd_b2|vdd_b3|vdd_b4|vdd_link|vdd_link_dip|vdd_x1|vdd_x2|vdd_x3__t46
+ a|d|inv_clk_vdd|inv_mc_vdd|inv_q_vdd|mpa_py|mpb_py|nand_m_vdd|nand_s2_vdd|nwell_vdd|sb_vdd|sr1_vdd|sr2_vdd|sr3_vdd|sr4_vdd|sv_d_vdd_tie|sv_vdd|tg_d_a|tg_d_vdd|tg_fbm_vdd|tg_fbs_vdd|tg_s_vdd|vdd|vdd_b1|vdd_b2|vdd_b3|vdd_b4|vdd_link|vdd_link_dip|vdd_x1|vdd_x2|vdd_x3
+ 281.510585951
* device instance a_d_inv_clk_vdd_inv_mc_vdd_inv_q_vdd_mpa_py_mpb_py_nand_m_vdd_nand_s2_vdd_nwell_vdd_sb_vdd_sr1_vdd_sr2_vdd_sr3_vdd_sr4_vdd_sv_d_vdd_tie_sv_vdd_tg_d_a_tg_d_vdd_tg_fbm_vdd_tg_fbs_vdd_tg_s_vdd_vdd_vdd_b1_vdd_b2_vdd_b3_vdd_b4_vdd_link_vdd_link_dip_vdd_x1_vdd_x2_vdd_x3_t47 r0 *1 0,0
Ra_d_inv_clk_vdd_inv_mc_vdd_inv_q_vdd_mpa_py_mpb_py_nand_m_vdd_nand_s2_vdd_nwell_vdd_sb_vdd_sr1_vdd_sr2_vdd_sr3_vdd_sr4_vdd_sv_d_vdd_tie_sv_vdd_tg_d_a_tg_d_vdd_tg_fbm_vdd_tg_fbs_vdd_tg_s_vdd_vdd_vdd_b1_vdd_b2_vdd_b3_vdd_b4_vdd_link_vdd_link_dip_vdd_x1_vdd_x2_vdd_x3_t47
+ a|d|inv_clk_vdd|inv_mc_vdd|inv_q_vdd|mpa_py|mpb_py|nand_m_vdd|nand_s2_vdd|nwell_vdd|sb_vdd|sr1_vdd|sr2_vdd|sr3_vdd|sr4_vdd|sv_d_vdd_tie|sv_vdd|tg_d_a|tg_d_vdd|tg_fbm_vdd|tg_fbs_vdd|tg_s_vdd|vdd|vdd_b1|vdd_b2|vdd_b3|vdd_b4|vdd_link|vdd_link_dip|vdd_x1|vdd_x2|vdd_x3__t47
+ a|d|inv_clk_vdd|inv_mc_vdd|inv_q_vdd|mpa_py|mpb_py|nand_m_vdd|nand_s2_vdd|nwell_vdd|sb_vdd|sr1_vdd|sr2_vdd|sr3_vdd|sr4_vdd|sv_d_vdd_tie|sv_vdd|tg_d_a|tg_d_vdd|tg_fbm_vdd|tg_fbs_vdd|tg_s_vdd|vdd|vdd_b1|vdd_b2|vdd_b3|vdd_b4|vdd_link|vdd_link_dip|vdd_x1|vdd_x2|vdd_x3
+ 64.9885343757
* device instance a_d_inv_clk_vdd_inv_mc_vdd_inv_q_vdd_mpa_py_mpb_py_nand_m_vdd_nand_s2_vdd_nwell_vdd_sb_vdd_sr1_vdd_sr2_vdd_sr3_vdd_sr4_vdd_sv_d_vdd_tie_sv_vdd_tg_d_a_tg_d_vdd_tg_fbm_vdd_tg_fbs_vdd_tg_s_vdd_vdd_vdd_b1_vdd_b2_vdd_b3_vdd_b4_vdd_link_vdd_link_dip_vdd_x1_vdd_x2_vdd_x3_t48 r0 *1 0,0
Ra_d_inv_clk_vdd_inv_mc_vdd_inv_q_vdd_mpa_py_mpb_py_nand_m_vdd_nand_s2_vdd_nwell_vdd_sb_vdd_sr1_vdd_sr2_vdd_sr3_vdd_sr4_vdd_sv_d_vdd_tie_sv_vdd_tg_d_a_tg_d_vdd_tg_fbm_vdd_tg_fbs_vdd_tg_s_vdd_vdd_vdd_b1_vdd_b2_vdd_b3_vdd_b4_vdd_link_vdd_link_dip_vdd_x1_vdd_x2_vdd_x3_t48
+ a|d|inv_clk_vdd|inv_mc_vdd|inv_q_vdd|mpa_py|mpb_py|nand_m_vdd|nand_s2_vdd|nwell_vdd|sb_vdd|sr1_vdd|sr2_vdd|sr3_vdd|sr4_vdd|sv_d_vdd_tie|sv_vdd|tg_d_a|tg_d_vdd|tg_fbm_vdd|tg_fbs_vdd|tg_s_vdd|vdd|vdd_b1|vdd_b2|vdd_b3|vdd_b4|vdd_link|vdd_link_dip|vdd_x1|vdd_x2|vdd_x3__t48
+ a|d|inv_clk_vdd|inv_mc_vdd|inv_q_vdd|mpa_py|mpb_py|nand_m_vdd|nand_s2_vdd|nwell_vdd|sb_vdd|sr1_vdd|sr2_vdd|sr3_vdd|sr4_vdd|sv_d_vdd_tie|sv_vdd|tg_d_a|tg_d_vdd|tg_fbm_vdd|tg_fbs_vdd|tg_s_vdd|vdd|vdd_b1|vdd_b2|vdd_b3|vdd_b4|vdd_link|vdd_link_dip|vdd_x1|vdd_x2|vdd_x3
+ 39.6730583799
* device instance a_d_inv_clk_vdd_inv_mc_vdd_inv_q_vdd_mpa_py_mpb_py_nand_m_vdd_nand_s2_vdd_nwell_vdd_sb_vdd_sr1_vdd_sr2_vdd_sr3_vdd_sr4_vdd_sv_d_vdd_tie_sv_vdd_tg_d_a_tg_d_vdd_tg_fbm_vdd_tg_fbs_vdd_tg_s_vdd_vdd_vdd_b1_vdd_b2_vdd_b3_vdd_b4_vdd_link_vdd_link_dip_vdd_x1_vdd_x2_vdd_x3_t49 r0 *1 0,0
Ra_d_inv_clk_vdd_inv_mc_vdd_inv_q_vdd_mpa_py_mpb_py_nand_m_vdd_nand_s2_vdd_nwell_vdd_sb_vdd_sr1_vdd_sr2_vdd_sr3_vdd_sr4_vdd_sv_d_vdd_tie_sv_vdd_tg_d_a_tg_d_vdd_tg_fbm_vdd_tg_fbs_vdd_tg_s_vdd_vdd_vdd_b1_vdd_b2_vdd_b3_vdd_b4_vdd_link_vdd_link_dip_vdd_x1_vdd_x2_vdd_x3_t49
+ a|d|inv_clk_vdd|inv_mc_vdd|inv_q_vdd|mpa_py|mpb_py|nand_m_vdd|nand_s2_vdd|nwell_vdd|sb_vdd|sr1_vdd|sr2_vdd|sr3_vdd|sr4_vdd|sv_d_vdd_tie|sv_vdd|tg_d_a|tg_d_vdd|tg_fbm_vdd|tg_fbs_vdd|tg_s_vdd|vdd|vdd_b1|vdd_b2|vdd_b3|vdd_b4|vdd_link|vdd_link_dip|vdd_x1|vdd_x2|vdd_x3__t49
+ a|d|inv_clk_vdd|inv_mc_vdd|inv_q_vdd|mpa_py|mpb_py|nand_m_vdd|nand_s2_vdd|nwell_vdd|sb_vdd|sr1_vdd|sr2_vdd|sr3_vdd|sr4_vdd|sv_d_vdd_tie|sv_vdd|tg_d_a|tg_d_vdd|tg_fbm_vdd|tg_fbs_vdd|tg_s_vdd|vdd|vdd_b1|vdd_b2|vdd_b3|vdd_b4|vdd_link|vdd_link_dip|vdd_x1|vdd_x2|vdd_x3
+ 66.8380635271
* device instance a_d_inv_clk_vdd_inv_mc_vdd_inv_q_vdd_mpa_py_mpb_py_nand_m_vdd_nand_s2_vdd_nwell_vdd_sb_vdd_sr1_vdd_sr2_vdd_sr3_vdd_sr4_vdd_sv_d_vdd_tie_sv_vdd_tg_d_a_tg_d_vdd_tg_fbm_vdd_tg_fbs_vdd_tg_s_vdd_vdd_vdd_b1_vdd_b2_vdd_b3_vdd_b4_vdd_link_vdd_link_dip_vdd_x1_vdd_x2_vdd_x3_t50 r0 *1 0,0
Ra_d_inv_clk_vdd_inv_mc_vdd_inv_q_vdd_mpa_py_mpb_py_nand_m_vdd_nand_s2_vdd_nwell_vdd_sb_vdd_sr1_vdd_sr2_vdd_sr3_vdd_sr4_vdd_sv_d_vdd_tie_sv_vdd_tg_d_a_tg_d_vdd_tg_fbm_vdd_tg_fbs_vdd_tg_s_vdd_vdd_vdd_b1_vdd_b2_vdd_b3_vdd_b4_vdd_link_vdd_link_dip_vdd_x1_vdd_x2_vdd_x3_t50
+ a|d|inv_clk_vdd|inv_mc_vdd|inv_q_vdd|mpa_py|mpb_py|nand_m_vdd|nand_s2_vdd|nwell_vdd|sb_vdd|sr1_vdd|sr2_vdd|sr3_vdd|sr4_vdd|sv_d_vdd_tie|sv_vdd|tg_d_a|tg_d_vdd|tg_fbm_vdd|tg_fbs_vdd|tg_s_vdd|vdd|vdd_b1|vdd_b2|vdd_b3|vdd_b4|vdd_link|vdd_link_dip|vdd_x1|vdd_x2|vdd_x3__t50
+ a|d|inv_clk_vdd|inv_mc_vdd|inv_q_vdd|mpa_py|mpb_py|nand_m_vdd|nand_s2_vdd|nwell_vdd|sb_vdd|sr1_vdd|sr2_vdd|sr3_vdd|sr4_vdd|sv_d_vdd_tie|sv_vdd|tg_d_a|tg_d_vdd|tg_fbm_vdd|tg_fbs_vdd|tg_s_vdd|vdd|vdd_b1|vdd_b2|vdd_b3|vdd_b4|vdd_link|vdd_link_dip|vdd_x1|vdd_x2|vdd_x3
+ 94.4335287718
* device instance a_d_inv_clk_vdd_inv_mc_vdd_inv_q_vdd_mpa_py_mpb_py_nand_m_vdd_nand_s2_vdd_nwell_vdd_sb_vdd_sr1_vdd_sr2_vdd_sr3_vdd_sr4_vdd_sv_d_vdd_tie_sv_vdd_tg_d_a_tg_d_vdd_tg_fbm_vdd_tg_fbs_vdd_tg_s_vdd_vdd_vdd_b1_vdd_b2_vdd_b3_vdd_b4_vdd_link_vdd_link_dip_vdd_x1_vdd_x2_vdd_x3_t51 r0 *1 0,0
Ra_d_inv_clk_vdd_inv_mc_vdd_inv_q_vdd_mpa_py_mpb_py_nand_m_vdd_nand_s2_vdd_nwell_vdd_sb_vdd_sr1_vdd_sr2_vdd_sr3_vdd_sr4_vdd_sv_d_vdd_tie_sv_vdd_tg_d_a_tg_d_vdd_tg_fbm_vdd_tg_fbs_vdd_tg_s_vdd_vdd_vdd_b1_vdd_b2_vdd_b3_vdd_b4_vdd_link_vdd_link_dip_vdd_x1_vdd_x2_vdd_x3_t51
+ a|d|inv_clk_vdd|inv_mc_vdd|inv_q_vdd|mpa_py|mpb_py|nand_m_vdd|nand_s2_vdd|nwell_vdd|sb_vdd|sr1_vdd|sr2_vdd|sr3_vdd|sr4_vdd|sv_d_vdd_tie|sv_vdd|tg_d_a|tg_d_vdd|tg_fbm_vdd|tg_fbs_vdd|tg_s_vdd|vdd|vdd_b1|vdd_b2|vdd_b3|vdd_b4|vdd_link|vdd_link_dip|vdd_x1|vdd_x2|vdd_x3__t51
+ a|d|inv_clk_vdd|inv_mc_vdd|inv_q_vdd|mpa_py|mpb_py|nand_m_vdd|nand_s2_vdd|nwell_vdd|sb_vdd|sr1_vdd|sr2_vdd|sr3_vdd|sr4_vdd|sv_d_vdd_tie|sv_vdd|tg_d_a|tg_d_vdd|tg_fbm_vdd|tg_fbs_vdd|tg_s_vdd|vdd|vdd_b1|vdd_b2|vdd_b3|vdd_b4|vdd_link|vdd_link_dip|vdd_x1|vdd_x2|vdd_x3
+ 238.709465789
* device instance a_d_inv_clk_vdd_inv_mc_vdd_inv_q_vdd_mpa_py_mpb_py_nand_m_vdd_nand_s2_vdd_nwell_vdd_sb_vdd_sr1_vdd_sr2_vdd_sr3_vdd_sr4_vdd_sv_d_vdd_tie_sv_vdd_tg_d_a_tg_d_vdd_tg_fbm_vdd_tg_fbs_vdd_tg_s_vdd_vdd_vdd_b1_vdd_b2_vdd_b3_vdd_b4_vdd_link_vdd_link_dip_vdd_x1_vdd_x2_vdd_x3_t52 r0 *1 0,0
Ra_d_inv_clk_vdd_inv_mc_vdd_inv_q_vdd_mpa_py_mpb_py_nand_m_vdd_nand_s2_vdd_nwell_vdd_sb_vdd_sr1_vdd_sr2_vdd_sr3_vdd_sr4_vdd_sv_d_vdd_tie_sv_vdd_tg_d_a_tg_d_vdd_tg_fbm_vdd_tg_fbs_vdd_tg_s_vdd_vdd_vdd_b1_vdd_b2_vdd_b3_vdd_b4_vdd_link_vdd_link_dip_vdd_x1_vdd_x2_vdd_x3_t52
+ a|d|inv_clk_vdd|inv_mc_vdd|inv_q_vdd|mpa_py|mpb_py|nand_m_vdd|nand_s2_vdd|nwell_vdd|sb_vdd|sr1_vdd|sr2_vdd|sr3_vdd|sr4_vdd|sv_d_vdd_tie|sv_vdd|tg_d_a|tg_d_vdd|tg_fbm_vdd|tg_fbs_vdd|tg_s_vdd|vdd|vdd_b1|vdd_b2|vdd_b3|vdd_b4|vdd_link|vdd_link_dip|vdd_x1|vdd_x2|vdd_x3__t52
+ a|d|inv_clk_vdd|inv_mc_vdd|inv_q_vdd|mpa_py|mpb_py|nand_m_vdd|nand_s2_vdd|nwell_vdd|sb_vdd|sr1_vdd|sr2_vdd|sr3_vdd|sr4_vdd|sv_d_vdd_tie|sv_vdd|tg_d_a|tg_d_vdd|tg_fbm_vdd|tg_fbs_vdd|tg_s_vdd|vdd|vdd_b1|vdd_b2|vdd_b3|vdd_b4|vdd_link|vdd_link_dip|vdd_x1|vdd_x2|vdd_x3
+ 274.471210464
* device instance a_d_inv_clk_vdd_inv_mc_vdd_inv_q_vdd_mpa_py_mpb_py_nand_m_vdd_nand_s2_vdd_nwell_vdd_sb_vdd_sr1_vdd_sr2_vdd_sr3_vdd_sr4_vdd_sv_d_vdd_tie_sv_vdd_tg_d_a_tg_d_vdd_tg_fbm_vdd_tg_fbs_vdd_tg_s_vdd_vdd_vdd_b1_vdd_b2_vdd_b3_vdd_b4_vdd_link_vdd_link_dip_vdd_x1_vdd_x2_vdd_x3_t53 r0 *1 0,0
Ra_d_inv_clk_vdd_inv_mc_vdd_inv_q_vdd_mpa_py_mpb_py_nand_m_vdd_nand_s2_vdd_nwell_vdd_sb_vdd_sr1_vdd_sr2_vdd_sr3_vdd_sr4_vdd_sv_d_vdd_tie_sv_vdd_tg_d_a_tg_d_vdd_tg_fbm_vdd_tg_fbs_vdd_tg_s_vdd_vdd_vdd_b1_vdd_b2_vdd_b3_vdd_b4_vdd_link_vdd_link_dip_vdd_x1_vdd_x2_vdd_x3_t53
+ a|d|inv_clk_vdd|inv_mc_vdd|inv_q_vdd|mpa_py|mpb_py|nand_m_vdd|nand_s2_vdd|nwell_vdd|sb_vdd|sr1_vdd|sr2_vdd|sr3_vdd|sr4_vdd|sv_d_vdd_tie|sv_vdd|tg_d_a|tg_d_vdd|tg_fbm_vdd|tg_fbs_vdd|tg_s_vdd|vdd|vdd_b1|vdd_b2|vdd_b3|vdd_b4|vdd_link|vdd_link_dip|vdd_x1|vdd_x2|vdd_x3__t53
+ a|d|inv_clk_vdd|inv_mc_vdd|inv_q_vdd|mpa_py|mpb_py|nand_m_vdd|nand_s2_vdd|nwell_vdd|sb_vdd|sr1_vdd|sr2_vdd|sr3_vdd|sr4_vdd|sv_d_vdd_tie|sv_vdd|tg_d_a|tg_d_vdd|tg_fbm_vdd|tg_fbs_vdd|tg_s_vdd|vdd|vdd_b1|vdd_b2|vdd_b3|vdd_b4|vdd_link|vdd_link_dip|vdd_x1|vdd_x2|vdd_x3
+ 272.579318667
* device instance a_d_inv_clk_vdd_inv_mc_vdd_inv_q_vdd_mpa_py_mpb_py_nand_m_vdd_nand_s2_vdd_nwell_vdd_sb_vdd_sr1_vdd_sr2_vdd_sr3_vdd_sr4_vdd_sv_d_vdd_tie_sv_vdd_tg_d_a_tg_d_vdd_tg_fbm_vdd_tg_fbs_vdd_tg_s_vdd_vdd_vdd_b1_vdd_b2_vdd_b3_vdd_b4_vdd_link_vdd_link_dip_vdd_x1_vdd_x2_vdd_x3_t54 r0 *1 0,0
Ra_d_inv_clk_vdd_inv_mc_vdd_inv_q_vdd_mpa_py_mpb_py_nand_m_vdd_nand_s2_vdd_nwell_vdd_sb_vdd_sr1_vdd_sr2_vdd_sr3_vdd_sr4_vdd_sv_d_vdd_tie_sv_vdd_tg_d_a_tg_d_vdd_tg_fbm_vdd_tg_fbs_vdd_tg_s_vdd_vdd_vdd_b1_vdd_b2_vdd_b3_vdd_b4_vdd_link_vdd_link_dip_vdd_x1_vdd_x2_vdd_x3_t54
+ a|d|inv_clk_vdd|inv_mc_vdd|inv_q_vdd|mpa_py|mpb_py|nand_m_vdd|nand_s2_vdd|nwell_vdd|sb_vdd|sr1_vdd|sr2_vdd|sr3_vdd|sr4_vdd|sv_d_vdd_tie|sv_vdd|tg_d_a|tg_d_vdd|tg_fbm_vdd|tg_fbs_vdd|tg_s_vdd|vdd|vdd_b1|vdd_b2|vdd_b3|vdd_b4|vdd_link|vdd_link_dip|vdd_x1|vdd_x2|vdd_x3__t54
+ a|d|inv_clk_vdd|inv_mc_vdd|inv_q_vdd|mpa_py|mpb_py|nand_m_vdd|nand_s2_vdd|nwell_vdd|sb_vdd|sr1_vdd|sr2_vdd|sr3_vdd|sr4_vdd|sv_d_vdd_tie|sv_vdd|tg_d_a|tg_d_vdd|tg_fbm_vdd|tg_fbs_vdd|tg_s_vdd|vdd|vdd_b1|vdd_b2|vdd_b3|vdd_b4|vdd_link|vdd_link_dip|vdd_x1|vdd_x2|vdd_x3
+ 229.224151213
* device instance a_d_inv_clk_vdd_inv_mc_vdd_inv_q_vdd_mpa_py_mpb_py_nand_m_vdd_nand_s2_vdd_nwell_vdd_sb_vdd_sr1_vdd_sr2_vdd_sr3_vdd_sr4_vdd_sv_d_vdd_tie_sv_vdd_tg_d_a_tg_d_vdd_tg_fbm_vdd_tg_fbs_vdd_tg_s_vdd_vdd_vdd_b1_vdd_b2_vdd_b3_vdd_b4_vdd_link_vdd_link_dip_vdd_x1_vdd_x2_vdd_x3_t55 r0 *1 0,0
Ra_d_inv_clk_vdd_inv_mc_vdd_inv_q_vdd_mpa_py_mpb_py_nand_m_vdd_nand_s2_vdd_nwell_vdd_sb_vdd_sr1_vdd_sr2_vdd_sr3_vdd_sr4_vdd_sv_d_vdd_tie_sv_vdd_tg_d_a_tg_d_vdd_tg_fbm_vdd_tg_fbs_vdd_tg_s_vdd_vdd_vdd_b1_vdd_b2_vdd_b3_vdd_b4_vdd_link_vdd_link_dip_vdd_x1_vdd_x2_vdd_x3_t55
+ a|d|inv_clk_vdd|inv_mc_vdd|inv_q_vdd|mpa_py|mpb_py|nand_m_vdd|nand_s2_vdd|nwell_vdd|sb_vdd|sr1_vdd|sr2_vdd|sr3_vdd|sr4_vdd|sv_d_vdd_tie|sv_vdd|tg_d_a|tg_d_vdd|tg_fbm_vdd|tg_fbs_vdd|tg_s_vdd|vdd|vdd_b1|vdd_b2|vdd_b3|vdd_b4|vdd_link|vdd_link_dip|vdd_x1|vdd_x2|vdd_x3__t55
+ a|d|inv_clk_vdd|inv_mc_vdd|inv_q_vdd|mpa_py|mpb_py|nand_m_vdd|nand_s2_vdd|nwell_vdd|sb_vdd|sr1_vdd|sr2_vdd|sr3_vdd|sr4_vdd|sv_d_vdd_tie|sv_vdd|tg_d_a|tg_d_vdd|tg_fbm_vdd|tg_fbs_vdd|tg_s_vdd|vdd|vdd_b1|vdd_b2|vdd_b3|vdd_b4|vdd_link|vdd_link_dip|vdd_x1|vdd_x2|vdd_x3
+ 227.333384696
* device instance a_d_inv_clk_vdd_inv_mc_vdd_inv_q_vdd_mpa_py_mpb_py_nand_m_vdd_nand_s2_vdd_nwell_vdd_sb_vdd_sr1_vdd_sr2_vdd_sr3_vdd_sr4_vdd_sv_d_vdd_tie_sv_vdd_tg_d_a_tg_d_vdd_tg_fbm_vdd_tg_fbs_vdd_tg_s_vdd_vdd_vdd_b1_vdd_b2_vdd_b3_vdd_b4_vdd_link_vdd_link_dip_vdd_x1_vdd_x2_vdd_x3_t56 r0 *1 0,0
Ra_d_inv_clk_vdd_inv_mc_vdd_inv_q_vdd_mpa_py_mpb_py_nand_m_vdd_nand_s2_vdd_nwell_vdd_sb_vdd_sr1_vdd_sr2_vdd_sr3_vdd_sr4_vdd_sv_d_vdd_tie_sv_vdd_tg_d_a_tg_d_vdd_tg_fbm_vdd_tg_fbs_vdd_tg_s_vdd_vdd_vdd_b1_vdd_b2_vdd_b3_vdd_b4_vdd_link_vdd_link_dip_vdd_x1_vdd_x2_vdd_x3_t56
+ a|d|inv_clk_vdd|inv_mc_vdd|inv_q_vdd|mpa_py|mpb_py|nand_m_vdd|nand_s2_vdd|nwell_vdd|sb_vdd|sr1_vdd|sr2_vdd|sr3_vdd|sr4_vdd|sv_d_vdd_tie|sv_vdd|tg_d_a|tg_d_vdd|tg_fbm_vdd|tg_fbs_vdd|tg_s_vdd|vdd|vdd_b1|vdd_b2|vdd_b3|vdd_b4|vdd_link|vdd_link_dip|vdd_x1|vdd_x2|vdd_x3__t56
+ a|d|inv_clk_vdd|inv_mc_vdd|inv_q_vdd|mpa_py|mpb_py|nand_m_vdd|nand_s2_vdd|nwell_vdd|sb_vdd|sr1_vdd|sr2_vdd|sr3_vdd|sr4_vdd|sv_d_vdd_tie|sv_vdd|tg_d_a|tg_d_vdd|tg_fbm_vdd|tg_fbs_vdd|tg_s_vdd|vdd|vdd_b1|vdd_b2|vdd_b3|vdd_b4|vdd_link|vdd_link_dip|vdd_x1|vdd_x2|vdd_x3
+ 192.887270334
* device instance a_d_inv_clk_vdd_inv_mc_vdd_inv_q_vdd_mpa_py_mpb_py_nand_m_vdd_nand_s2_vdd_nwell_vdd_sb_vdd_sr1_vdd_sr2_vdd_sr3_vdd_sr4_vdd_sv_d_vdd_tie_sv_vdd_tg_d_a_tg_d_vdd_tg_fbm_vdd_tg_fbs_vdd_tg_s_vdd_vdd_vdd_b1_vdd_b2_vdd_b3_vdd_b4_vdd_link_vdd_link_dip_vdd_x1_vdd_x2_vdd_x3_t57 r0 *1 0,0
Ra_d_inv_clk_vdd_inv_mc_vdd_inv_q_vdd_mpa_py_mpb_py_nand_m_vdd_nand_s2_vdd_nwell_vdd_sb_vdd_sr1_vdd_sr2_vdd_sr3_vdd_sr4_vdd_sv_d_vdd_tie_sv_vdd_tg_d_a_tg_d_vdd_tg_fbm_vdd_tg_fbs_vdd_tg_s_vdd_vdd_vdd_b1_vdd_b2_vdd_b3_vdd_b4_vdd_link_vdd_link_dip_vdd_x1_vdd_x2_vdd_x3_t57
+ a|d|inv_clk_vdd|inv_mc_vdd|inv_q_vdd|mpa_py|mpb_py|nand_m_vdd|nand_s2_vdd|nwell_vdd|sb_vdd|sr1_vdd|sr2_vdd|sr3_vdd|sr4_vdd|sv_d_vdd_tie|sv_vdd|tg_d_a|tg_d_vdd|tg_fbm_vdd|tg_fbs_vdd|tg_s_vdd|vdd|vdd_b1|vdd_b2|vdd_b3|vdd_b4|vdd_link|vdd_link_dip|vdd_x1|vdd_x2|vdd_x3__t57
+ a|d|inv_clk_vdd|inv_mc_vdd|inv_q_vdd|mpa_py|mpb_py|nand_m_vdd|nand_s2_vdd|nwell_vdd|sb_vdd|sr1_vdd|sr2_vdd|sr3_vdd|sr4_vdd|sv_d_vdd_tie|sv_vdd|tg_d_a|tg_d_vdd|tg_fbm_vdd|tg_fbs_vdd|tg_s_vdd|vdd|vdd_b1|vdd_b2|vdd_b3|vdd_b4|vdd_link|vdd_link_dip|vdd_x1|vdd_x2|vdd_x3
+ 190.998041694
* device instance a_d_inv_clk_vdd_inv_mc_vdd_inv_q_vdd_mpa_py_mpb_py_nand_m_vdd_nand_s2_vdd_nwell_vdd_sb_vdd_sr1_vdd_sr2_vdd_sr3_vdd_sr4_vdd_sv_d_vdd_tie_sv_vdd_tg_d_a_tg_d_vdd_tg_fbm_vdd_tg_fbs_vdd_tg_s_vdd_vdd_vdd_b1_vdd_b2_vdd_b3_vdd_b4_vdd_link_vdd_link_dip_vdd_x1_vdd_x2_vdd_x3_t58 r0 *1 0,0
Ra_d_inv_clk_vdd_inv_mc_vdd_inv_q_vdd_mpa_py_mpb_py_nand_m_vdd_nand_s2_vdd_nwell_vdd_sb_vdd_sr1_vdd_sr2_vdd_sr3_vdd_sr4_vdd_sv_d_vdd_tie_sv_vdd_tg_d_a_tg_d_vdd_tg_fbm_vdd_tg_fbs_vdd_tg_s_vdd_vdd_vdd_b1_vdd_b2_vdd_b3_vdd_b4_vdd_link_vdd_link_dip_vdd_x1_vdd_x2_vdd_x3_t58
+ a|d|inv_clk_vdd|inv_mc_vdd|inv_q_vdd|mpa_py|mpb_py|nand_m_vdd|nand_s2_vdd|nwell_vdd|sb_vdd|sr1_vdd|sr2_vdd|sr3_vdd|sr4_vdd|sv_d_vdd_tie|sv_vdd|tg_d_a|tg_d_vdd|tg_fbm_vdd|tg_fbs_vdd|tg_s_vdd|vdd|vdd_b1|vdd_b2|vdd_b3|vdd_b4|vdd_link|vdd_link_dip|vdd_x1|vdd_x2|vdd_x3__t58
+ a|d|inv_clk_vdd|inv_mc_vdd|inv_q_vdd|mpa_py|mpb_py|nand_m_vdd|nand_s2_vdd|nwell_vdd|sb_vdd|sr1_vdd|sr2_vdd|sr3_vdd|sr4_vdd|sv_d_vdd_tie|sv_vdd|tg_d_a|tg_d_vdd|tg_fbm_vdd|tg_fbs_vdd|tg_s_vdd|vdd|vdd_b1|vdd_b2|vdd_b3|vdd_b4|vdd_link|vdd_link_dip|vdd_x1|vdd_x2|vdd_x3
+ 109.655400001
* device instance a_d_inv_clk_vdd_inv_mc_vdd_inv_q_vdd_mpa_py_mpb_py_nand_m_vdd_nand_s2_vdd_nwell_vdd_sb_vdd_sr1_vdd_sr2_vdd_sr3_vdd_sr4_vdd_sv_d_vdd_tie_sv_vdd_tg_d_a_tg_d_vdd_tg_fbm_vdd_tg_fbs_vdd_tg_s_vdd_vdd_vdd_b1_vdd_b2_vdd_b3_vdd_b4_vdd_link_vdd_link_dip_vdd_x1_vdd_x2_vdd_x3_t59 r0 *1 0,0
Ra_d_inv_clk_vdd_inv_mc_vdd_inv_q_vdd_mpa_py_mpb_py_nand_m_vdd_nand_s2_vdd_nwell_vdd_sb_vdd_sr1_vdd_sr2_vdd_sr3_vdd_sr4_vdd_sv_d_vdd_tie_sv_vdd_tg_d_a_tg_d_vdd_tg_fbm_vdd_tg_fbs_vdd_tg_s_vdd_vdd_vdd_b1_vdd_b2_vdd_b3_vdd_b4_vdd_link_vdd_link_dip_vdd_x1_vdd_x2_vdd_x3_t59
+ a|d|inv_clk_vdd|inv_mc_vdd|inv_q_vdd|mpa_py|mpb_py|nand_m_vdd|nand_s2_vdd|nwell_vdd|sb_vdd|sr1_vdd|sr2_vdd|sr3_vdd|sr4_vdd|sv_d_vdd_tie|sv_vdd|tg_d_a|tg_d_vdd|tg_fbm_vdd|tg_fbs_vdd|tg_s_vdd|vdd|vdd_b1|vdd_b2|vdd_b3|vdd_b4|vdd_link|vdd_link_dip|vdd_x1|vdd_x2|vdd_x3__t59
+ a|d|inv_clk_vdd|inv_mc_vdd|inv_q_vdd|mpa_py|mpb_py|nand_m_vdd|nand_s2_vdd|nwell_vdd|sb_vdd|sr1_vdd|sr2_vdd|sr3_vdd|sr4_vdd|sv_d_vdd_tie|sv_vdd|tg_d_a|tg_d_vdd|tg_fbm_vdd|tg_fbs_vdd|tg_s_vdd|vdd|vdd_b1|vdd_b2|vdd_b3|vdd_b4|vdd_link|vdd_link_dip|vdd_x1|vdd_x2|vdd_x3
+ 129.332460393
* device instance a_d_inv_clk_vdd_inv_mc_vdd_inv_q_vdd_mpa_py_mpb_py_nand_m_vdd_nand_s2_vdd_nwell_vdd_sb_vdd_sr1_vdd_sr2_vdd_sr3_vdd_sr4_vdd_sv_d_vdd_tie_sv_vdd_tg_d_a_tg_d_vdd_tg_fbm_vdd_tg_fbs_vdd_tg_s_vdd_vdd_vdd_b1_vdd_b2_vdd_b3_vdd_b4_vdd_link_vdd_link_dip_vdd_x1_vdd_x2_vdd_x3_t60 r0 *1 0,0
Ra_d_inv_clk_vdd_inv_mc_vdd_inv_q_vdd_mpa_py_mpb_py_nand_m_vdd_nand_s2_vdd_nwell_vdd_sb_vdd_sr1_vdd_sr2_vdd_sr3_vdd_sr4_vdd_sv_d_vdd_tie_sv_vdd_tg_d_a_tg_d_vdd_tg_fbm_vdd_tg_fbs_vdd_tg_s_vdd_vdd_vdd_b1_vdd_b2_vdd_b3_vdd_b4_vdd_link_vdd_link_dip_vdd_x1_vdd_x2_vdd_x3_t60
+ a|d|inv_clk_vdd|inv_mc_vdd|inv_q_vdd|mpa_py|mpb_py|nand_m_vdd|nand_s2_vdd|nwell_vdd|sb_vdd|sr1_vdd|sr2_vdd|sr3_vdd|sr4_vdd|sv_d_vdd_tie|sv_vdd|tg_d_a|tg_d_vdd|tg_fbm_vdd|tg_fbs_vdd|tg_s_vdd|vdd|vdd_b1|vdd_b2|vdd_b3|vdd_b4|vdd_link|vdd_link_dip|vdd_x1|vdd_x2|vdd_x3__t60
+ a|d|inv_clk_vdd|inv_mc_vdd|inv_q_vdd|mpa_py|mpb_py|nand_m_vdd|nand_s2_vdd|nwell_vdd|sb_vdd|sr1_vdd|sr2_vdd|sr3_vdd|sr4_vdd|sv_d_vdd_tie|sv_vdd|tg_d_a|tg_d_vdd|tg_fbm_vdd|tg_fbs_vdd|tg_s_vdd|vdd|vdd_b1|vdd_b2|vdd_b3|vdd_b4|vdd_link|vdd_link_dip|vdd_x1|vdd_x2|vdd_x3
+ 147.729060078
* device instance a_d_inv_clk_vdd_inv_mc_vdd_inv_q_vdd_mpa_py_mpb_py_nand_m_vdd_nand_s2_vdd_nwell_vdd_sb_vdd_sr1_vdd_sr2_vdd_sr3_vdd_sr4_vdd_sv_d_vdd_tie_sv_vdd_tg_d_a_tg_d_vdd_tg_fbm_vdd_tg_fbs_vdd_tg_s_vdd_vdd_vdd_b1_vdd_b2_vdd_b3_vdd_b4_vdd_link_vdd_link_dip_vdd_x1_vdd_x2_vdd_x3_t61 r0 *1 0,0
Ra_d_inv_clk_vdd_inv_mc_vdd_inv_q_vdd_mpa_py_mpb_py_nand_m_vdd_nand_s2_vdd_nwell_vdd_sb_vdd_sr1_vdd_sr2_vdd_sr3_vdd_sr4_vdd_sv_d_vdd_tie_sv_vdd_tg_d_a_tg_d_vdd_tg_fbm_vdd_tg_fbs_vdd_tg_s_vdd_vdd_vdd_b1_vdd_b2_vdd_b3_vdd_b4_vdd_link_vdd_link_dip_vdd_x1_vdd_x2_vdd_x3_t61
+ a|d|inv_clk_vdd|inv_mc_vdd|inv_q_vdd|mpa_py|mpb_py|nand_m_vdd|nand_s2_vdd|nwell_vdd|sb_vdd|sr1_vdd|sr2_vdd|sr3_vdd|sr4_vdd|sv_d_vdd_tie|sv_vdd|tg_d_a|tg_d_vdd|tg_fbm_vdd|tg_fbs_vdd|tg_s_vdd|vdd|vdd_b1|vdd_b2|vdd_b3|vdd_b4|vdd_link|vdd_link_dip|vdd_x1|vdd_x2|vdd_x3__t61
+ a|d|inv_clk_vdd|inv_mc_vdd|inv_q_vdd|mpa_py|mpb_py|nand_m_vdd|nand_s2_vdd|nwell_vdd|sb_vdd|sr1_vdd|sr2_vdd|sr3_vdd|sr4_vdd|sv_d_vdd_tie|sv_vdd|tg_d_a|tg_d_vdd|tg_fbm_vdd|tg_fbs_vdd|tg_s_vdd|vdd|vdd_b1|vdd_b2|vdd_b3|vdd_b4|vdd_link|vdd_link_dip|vdd_x1|vdd_x2|vdd_x3
+ 145.843562672
* device instance a_d_inv_clk_vdd_inv_mc_vdd_inv_q_vdd_mpa_py_mpb_py_nand_m_vdd_nand_s2_vdd_nwell_vdd_sb_vdd_sr1_vdd_sr2_vdd_sr3_vdd_sr4_vdd_sv_d_vdd_tie_sv_vdd_tg_d_a_tg_d_vdd_tg_fbm_vdd_tg_fbs_vdd_tg_s_vdd_vdd_vdd_b1_vdd_b2_vdd_b3_vdd_b4_vdd_link_vdd_link_dip_vdd_x1_vdd_x2_vdd_x3_t62 r0 *1 0,0
Ra_d_inv_clk_vdd_inv_mc_vdd_inv_q_vdd_mpa_py_mpb_py_nand_m_vdd_nand_s2_vdd_nwell_vdd_sb_vdd_sr1_vdd_sr2_vdd_sr3_vdd_sr4_vdd_sv_d_vdd_tie_sv_vdd_tg_d_a_tg_d_vdd_tg_fbm_vdd_tg_fbs_vdd_tg_s_vdd_vdd_vdd_b1_vdd_b2_vdd_b3_vdd_b4_vdd_link_vdd_link_dip_vdd_x1_vdd_x2_vdd_x3_t62
+ a|d|inv_clk_vdd|inv_mc_vdd|inv_q_vdd|mpa_py|mpb_py|nand_m_vdd|nand_s2_vdd|nwell_vdd|sb_vdd|sr1_vdd|sr2_vdd|sr3_vdd|sr4_vdd|sv_d_vdd_tie|sv_vdd|tg_d_a|tg_d_vdd|tg_fbm_vdd|tg_fbs_vdd|tg_s_vdd|vdd|vdd_b1|vdd_b2|vdd_b3|vdd_b4|vdd_link|vdd_link_dip|vdd_x1|vdd_x2|vdd_x3__t62
+ a|d|inv_clk_vdd|inv_mc_vdd|inv_q_vdd|mpa_py|mpb_py|nand_m_vdd|nand_s2_vdd|nwell_vdd|sb_vdd|sr1_vdd|sr2_vdd|sr3_vdd|sr4_vdd|sv_d_vdd_tie|sv_vdd|tg_d_a|tg_d_vdd|tg_fbm_vdd|tg_fbs_vdd|tg_s_vdd|vdd|vdd_b1|vdd_b2|vdd_b3|vdd_b4|vdd_link|vdd_link_dip|vdd_x1|vdd_x2|vdd_x3
+ 117.405111309
* device instance a_d_inv_clk_vdd_inv_mc_vdd_inv_q_vdd_mpa_py_mpb_py_nand_m_vdd_nand_s2_vdd_nwell_vdd_sb_vdd_sr1_vdd_sr2_vdd_sr3_vdd_sr4_vdd_sv_d_vdd_tie_sv_vdd_tg_d_a_tg_d_vdd_tg_fbm_vdd_tg_fbs_vdd_tg_s_vdd_vdd_vdd_b1_vdd_b2_vdd_b3_vdd_b4_vdd_link_vdd_link_dip_vdd_x1_vdd_x2_vdd_x3_t63 r0 *1 0,0
Ra_d_inv_clk_vdd_inv_mc_vdd_inv_q_vdd_mpa_py_mpb_py_nand_m_vdd_nand_s2_vdd_nwell_vdd_sb_vdd_sr1_vdd_sr2_vdd_sr3_vdd_sr4_vdd_sv_d_vdd_tie_sv_vdd_tg_d_a_tg_d_vdd_tg_fbm_vdd_tg_fbs_vdd_tg_s_vdd_vdd_vdd_b1_vdd_b2_vdd_b3_vdd_b4_vdd_link_vdd_link_dip_vdd_x1_vdd_x2_vdd_x3_t63
+ a|d|inv_clk_vdd|inv_mc_vdd|inv_q_vdd|mpa_py|mpb_py|nand_m_vdd|nand_s2_vdd|nwell_vdd|sb_vdd|sr1_vdd|sr2_vdd|sr3_vdd|sr4_vdd|sv_d_vdd_tie|sv_vdd|tg_d_a|tg_d_vdd|tg_fbm_vdd|tg_fbs_vdd|tg_s_vdd|vdd|vdd_b1|vdd_b2|vdd_b3|vdd_b4|vdd_link|vdd_link_dip|vdd_x1|vdd_x2|vdd_x3__t63
+ a|d|inv_clk_vdd|inv_mc_vdd|inv_q_vdd|mpa_py|mpb_py|nand_m_vdd|nand_s2_vdd|nwell_vdd|sb_vdd|sr1_vdd|sr2_vdd|sr3_vdd|sr4_vdd|sv_d_vdd_tie|sv_vdd|tg_d_a|tg_d_vdd|tg_fbm_vdd|tg_fbs_vdd|tg_s_vdd|vdd|vdd_b1|vdd_b2|vdd_b3|vdd_b4|vdd_link|vdd_link_dip|vdd_x1|vdd_x2|vdd_x3
+ 111.534033335
* device instance a_d_inv_clk_vdd_inv_mc_vdd_inv_q_vdd_mpa_py_mpb_py_nand_m_vdd_nand_s2_vdd_nwell_vdd_sb_vdd_sr1_vdd_sr2_vdd_sr3_vdd_sr4_vdd_sv_d_vdd_tie_sv_vdd_tg_d_a_tg_d_vdd_tg_fbm_vdd_tg_fbs_vdd_tg_s_vdd_vdd_vdd_b1_vdd_b2_vdd_b3_vdd_b4_vdd_link_vdd_link_dip_vdd_x1_vdd_x2_vdd_x3_t64 r0 *1 0,0
Ra_d_inv_clk_vdd_inv_mc_vdd_inv_q_vdd_mpa_py_mpb_py_nand_m_vdd_nand_s2_vdd_nwell_vdd_sb_vdd_sr1_vdd_sr2_vdd_sr3_vdd_sr4_vdd_sv_d_vdd_tie_sv_vdd_tg_d_a_tg_d_vdd_tg_fbm_vdd_tg_fbs_vdd_tg_s_vdd_vdd_vdd_b1_vdd_b2_vdd_b3_vdd_b4_vdd_link_vdd_link_dip_vdd_x1_vdd_x2_vdd_x3_t64
+ a|d|inv_clk_vdd|inv_mc_vdd|inv_q_vdd|mpa_py|mpb_py|nand_m_vdd|nand_s2_vdd|nwell_vdd|sb_vdd|sr1_vdd|sr2_vdd|sr3_vdd|sr4_vdd|sv_d_vdd_tie|sv_vdd|tg_d_a|tg_d_vdd|tg_fbm_vdd|tg_fbs_vdd|tg_s_vdd|vdd|vdd_b1|vdd_b2|vdd_b3|vdd_b4|vdd_link|vdd_link_dip|vdd_x1|vdd_x2|vdd_x3__t64
+ a|d|inv_clk_vdd|inv_mc_vdd|inv_q_vdd|mpa_py|mpb_py|nand_m_vdd|nand_s2_vdd|nwell_vdd|sb_vdd|sr1_vdd|sr2_vdd|sr3_vdd|sr4_vdd|sv_d_vdd_tie|sv_vdd|tg_d_a|tg_d_vdd|tg_fbm_vdd|tg_fbs_vdd|tg_s_vdd|vdd|vdd_b1|vdd_b2|vdd_b3|vdd_b4|vdd_link|vdd_link_dip|vdd_x1|vdd_x2|vdd_x3
+ 199.79402836
* device instance a_d_inv_clk_vdd_inv_mc_vdd_inv_q_vdd_mpa_py_mpb_py_nand_m_vdd_nand_s2_vdd_nwell_vdd_sb_vdd_sr1_vdd_sr2_vdd_sr3_vdd_sr4_vdd_sv_d_vdd_tie_sv_vdd_tg_d_a_tg_d_vdd_tg_fbm_vdd_tg_fbs_vdd_tg_s_vdd_vdd_vdd_b1_vdd_b2_vdd_b3_vdd_b4_vdd_link_vdd_link_dip_vdd_x1_vdd_x2_vdd_x3_t65 r0 *1 0,0
Ra_d_inv_clk_vdd_inv_mc_vdd_inv_q_vdd_mpa_py_mpb_py_nand_m_vdd_nand_s2_vdd_nwell_vdd_sb_vdd_sr1_vdd_sr2_vdd_sr3_vdd_sr4_vdd_sv_d_vdd_tie_sv_vdd_tg_d_a_tg_d_vdd_tg_fbm_vdd_tg_fbs_vdd_tg_s_vdd_vdd_vdd_b1_vdd_b2_vdd_b3_vdd_b4_vdd_link_vdd_link_dip_vdd_x1_vdd_x2_vdd_x3_t65
+ a|d|inv_clk_vdd|inv_mc_vdd|inv_q_vdd|mpa_py|mpb_py|nand_m_vdd|nand_s2_vdd|nwell_vdd|sb_vdd|sr1_vdd|sr2_vdd|sr3_vdd|sr4_vdd|sv_d_vdd_tie|sv_vdd|tg_d_a|tg_d_vdd|tg_fbm_vdd|tg_fbs_vdd|tg_s_vdd|vdd|vdd_b1|vdd_b2|vdd_b3|vdd_b4|vdd_link|vdd_link_dip|vdd_x1|vdd_x2|vdd_x3__t65
+ a|d|inv_clk_vdd|inv_mc_vdd|inv_q_vdd|mpa_py|mpb_py|nand_m_vdd|nand_s2_vdd|nwell_vdd|sb_vdd|sr1_vdd|sr2_vdd|sr3_vdd|sr4_vdd|sv_d_vdd_tie|sv_vdd|tg_d_a|tg_d_vdd|tg_fbm_vdd|tg_fbs_vdd|tg_s_vdd|vdd|vdd_b1|vdd_b2|vdd_b3|vdd_b4|vdd_link|vdd_link_dip|vdd_x1|vdd_x2|vdd_x3
+ 16.7710976171
* device instance a_d_inv_clk_vdd_inv_mc_vdd_inv_q_vdd_mpa_py_mpb_py_nand_m_vdd_nand_s2_vdd_nwell_vdd_sb_vdd_sr1_vdd_sr2_vdd_sr3_vdd_sr4_vdd_sv_d_vdd_tie_sv_vdd_tg_d_a_tg_d_vdd_tg_fbm_vdd_tg_fbs_vdd_tg_s_vdd_vdd_vdd_b1_vdd_b2_vdd_b3_vdd_b4_vdd_link_vdd_link_dip_vdd_x1_vdd_x2_vdd_x3_t66 r0 *1 0,0
Ra_d_inv_clk_vdd_inv_mc_vdd_inv_q_vdd_mpa_py_mpb_py_nand_m_vdd_nand_s2_vdd_nwell_vdd_sb_vdd_sr1_vdd_sr2_vdd_sr3_vdd_sr4_vdd_sv_d_vdd_tie_sv_vdd_tg_d_a_tg_d_vdd_tg_fbm_vdd_tg_fbs_vdd_tg_s_vdd_vdd_vdd_b1_vdd_b2_vdd_b3_vdd_b4_vdd_link_vdd_link_dip_vdd_x1_vdd_x2_vdd_x3_t66
+ a|d|inv_clk_vdd|inv_mc_vdd|inv_q_vdd|mpa_py|mpb_py|nand_m_vdd|nand_s2_vdd|nwell_vdd|sb_vdd|sr1_vdd|sr2_vdd|sr3_vdd|sr4_vdd|sv_d_vdd_tie|sv_vdd|tg_d_a|tg_d_vdd|tg_fbm_vdd|tg_fbs_vdd|tg_s_vdd|vdd|vdd_b1|vdd_b2|vdd_b3|vdd_b4|vdd_link|vdd_link_dip|vdd_x1|vdd_x2|vdd_x3__t66
+ a|d|inv_clk_vdd|inv_mc_vdd|inv_q_vdd|mpa_py|mpb_py|nand_m_vdd|nand_s2_vdd|nwell_vdd|sb_vdd|sr1_vdd|sr2_vdd|sr3_vdd|sr4_vdd|sv_d_vdd_tie|sv_vdd|tg_d_a|tg_d_vdd|tg_fbm_vdd|tg_fbs_vdd|tg_s_vdd|vdd|vdd_b1|vdd_b2|vdd_b3|vdd_b4|vdd_link|vdd_link_dip|vdd_x1|vdd_x2|vdd_x3
+ 32.1712195844
* device instance a_d_inv_clk_vdd_inv_mc_vdd_inv_q_vdd_mpa_py_mpb_py_nand_m_vdd_nand_s2_vdd_nwell_vdd_sb_vdd_sr1_vdd_sr2_vdd_sr3_vdd_sr4_vdd_sv_d_vdd_tie_sv_vdd_tg_d_a_tg_d_vdd_tg_fbm_vdd_tg_fbs_vdd_tg_s_vdd_vdd_vdd_b1_vdd_b2_vdd_b3_vdd_b4_vdd_link_vdd_link_dip_vdd_x1_vdd_x2_vdd_x3_t67 r0 *1 0,0
Ra_d_inv_clk_vdd_inv_mc_vdd_inv_q_vdd_mpa_py_mpb_py_nand_m_vdd_nand_s2_vdd_nwell_vdd_sb_vdd_sr1_vdd_sr2_vdd_sr3_vdd_sr4_vdd_sv_d_vdd_tie_sv_vdd_tg_d_a_tg_d_vdd_tg_fbm_vdd_tg_fbs_vdd_tg_s_vdd_vdd_vdd_b1_vdd_b2_vdd_b3_vdd_b4_vdd_link_vdd_link_dip_vdd_x1_vdd_x2_vdd_x3_t67
+ a|d|inv_clk_vdd|inv_mc_vdd|inv_q_vdd|mpa_py|mpb_py|nand_m_vdd|nand_s2_vdd|nwell_vdd|sb_vdd|sr1_vdd|sr2_vdd|sr3_vdd|sr4_vdd|sv_d_vdd_tie|sv_vdd|tg_d_a|tg_d_vdd|tg_fbm_vdd|tg_fbs_vdd|tg_s_vdd|vdd|vdd_b1|vdd_b2|vdd_b3|vdd_b4|vdd_link|vdd_link_dip|vdd_x1|vdd_x2|vdd_x3__t67
+ a|d|inv_clk_vdd|inv_mc_vdd|inv_q_vdd|mpa_py|mpb_py|nand_m_vdd|nand_s2_vdd|nwell_vdd|sb_vdd|sr1_vdd|sr2_vdd|sr3_vdd|sr4_vdd|sv_d_vdd_tie|sv_vdd|tg_d_a|tg_d_vdd|tg_fbm_vdd|tg_fbs_vdd|tg_s_vdd|vdd|vdd_b1|vdd_b2|vdd_b3|vdd_b4|vdd_link|vdd_link_dip|vdd_x1|vdd_x2|vdd_x3
+ 192.419727323
* device instance a_d_inv_clk_vdd_inv_mc_vdd_inv_q_vdd_mpa_py_mpb_py_nand_m_vdd_nand_s2_vdd_nwell_vdd_sb_vdd_sr1_vdd_sr2_vdd_sr3_vdd_sr4_vdd_sv_d_vdd_tie_sv_vdd_tg_d_a_tg_d_vdd_tg_fbm_vdd_tg_fbs_vdd_tg_s_vdd_vdd_vdd_b1_vdd_b2_vdd_b3_vdd_b4_vdd_link_vdd_link_dip_vdd_x1_vdd_x2_vdd_x3_t68 r0 *1 0,0
Ra_d_inv_clk_vdd_inv_mc_vdd_inv_q_vdd_mpa_py_mpb_py_nand_m_vdd_nand_s2_vdd_nwell_vdd_sb_vdd_sr1_vdd_sr2_vdd_sr3_vdd_sr4_vdd_sv_d_vdd_tie_sv_vdd_tg_d_a_tg_d_vdd_tg_fbm_vdd_tg_fbs_vdd_tg_s_vdd_vdd_vdd_b1_vdd_b2_vdd_b3_vdd_b4_vdd_link_vdd_link_dip_vdd_x1_vdd_x2_vdd_x3_t68
+ a|d|inv_clk_vdd|inv_mc_vdd|inv_q_vdd|mpa_py|mpb_py|nand_m_vdd|nand_s2_vdd|nwell_vdd|sb_vdd|sr1_vdd|sr2_vdd|sr3_vdd|sr4_vdd|sv_d_vdd_tie|sv_vdd|tg_d_a|tg_d_vdd|tg_fbm_vdd|tg_fbs_vdd|tg_s_vdd|vdd|vdd_b1|vdd_b2|vdd_b3|vdd_b4|vdd_link|vdd_link_dip|vdd_x1|vdd_x2|vdd_x3__t68
+ a|d|inv_clk_vdd|inv_mc_vdd|inv_q_vdd|mpa_py|mpb_py|nand_m_vdd|nand_s2_vdd|nwell_vdd|sb_vdd|sr1_vdd|sr2_vdd|sr3_vdd|sr4_vdd|sv_d_vdd_tie|sv_vdd|tg_d_a|tg_d_vdd|tg_fbm_vdd|tg_fbs_vdd|tg_s_vdd|vdd|vdd_b1|vdd_b2|vdd_b3|vdd_b4|vdd_link|vdd_link_dip|vdd_x1|vdd_x2|vdd_x3
+ 171.163906087
* device instance a_d_inv_clk_vdd_inv_mc_vdd_inv_q_vdd_mpa_py_mpb_py_nand_m_vdd_nand_s2_vdd_nwell_vdd_sb_vdd_sr1_vdd_sr2_vdd_sr3_vdd_sr4_vdd_sv_d_vdd_tie_sv_vdd_tg_d_a_tg_d_vdd_tg_fbm_vdd_tg_fbs_vdd_tg_s_vdd_vdd_vdd_b1_vdd_b2_vdd_b3_vdd_b4_vdd_link_vdd_link_dip_vdd_x1_vdd_x2_vdd_x3_t69 r0 *1 0,0
Ra_d_inv_clk_vdd_inv_mc_vdd_inv_q_vdd_mpa_py_mpb_py_nand_m_vdd_nand_s2_vdd_nwell_vdd_sb_vdd_sr1_vdd_sr2_vdd_sr3_vdd_sr4_vdd_sv_d_vdd_tie_sv_vdd_tg_d_a_tg_d_vdd_tg_fbm_vdd_tg_fbs_vdd_tg_s_vdd_vdd_vdd_b1_vdd_b2_vdd_b3_vdd_b4_vdd_link_vdd_link_dip_vdd_x1_vdd_x2_vdd_x3_t69
+ a|d|inv_clk_vdd|inv_mc_vdd|inv_q_vdd|mpa_py|mpb_py|nand_m_vdd|nand_s2_vdd|nwell_vdd|sb_vdd|sr1_vdd|sr2_vdd|sr3_vdd|sr4_vdd|sv_d_vdd_tie|sv_vdd|tg_d_a|tg_d_vdd|tg_fbm_vdd|tg_fbs_vdd|tg_s_vdd|vdd|vdd_b1|vdd_b2|vdd_b3|vdd_b4|vdd_link|vdd_link_dip|vdd_x1|vdd_x2|vdd_x3__t69
+ a|d|inv_clk_vdd|inv_mc_vdd|inv_q_vdd|mpa_py|mpb_py|nand_m_vdd|nand_s2_vdd|nwell_vdd|sb_vdd|sr1_vdd|sr2_vdd|sr3_vdd|sr4_vdd|sv_d_vdd_tie|sv_vdd|tg_d_a|tg_d_vdd|tg_fbm_vdd|tg_fbs_vdd|tg_s_vdd|vdd|vdd_b1|vdd_b2|vdd_b3|vdd_b4|vdd_link|vdd_link_dip|vdd_x1|vdd_x2|vdd_x3
+ 164.195083072
* device instance a_d_inv_clk_vdd_inv_mc_vdd_inv_q_vdd_mpa_py_mpb_py_nand_m_vdd_nand_s2_vdd_nwell_vdd_sb_vdd_sr1_vdd_sr2_vdd_sr3_vdd_sr4_vdd_sv_d_vdd_tie_sv_vdd_tg_d_a_tg_d_vdd_tg_fbm_vdd_tg_fbs_vdd_tg_s_vdd_vdd_vdd_b1_vdd_b2_vdd_b3_vdd_b4_vdd_link_vdd_link_dip_vdd_x1_vdd_x2_vdd_x3_t70 r0 *1 0,0
Ra_d_inv_clk_vdd_inv_mc_vdd_inv_q_vdd_mpa_py_mpb_py_nand_m_vdd_nand_s2_vdd_nwell_vdd_sb_vdd_sr1_vdd_sr2_vdd_sr3_vdd_sr4_vdd_sv_d_vdd_tie_sv_vdd_tg_d_a_tg_d_vdd_tg_fbm_vdd_tg_fbs_vdd_tg_s_vdd_vdd_vdd_b1_vdd_b2_vdd_b3_vdd_b4_vdd_link_vdd_link_dip_vdd_x1_vdd_x2_vdd_x3_t70
+ a|d|inv_clk_vdd|inv_mc_vdd|inv_q_vdd|mpa_py|mpb_py|nand_m_vdd|nand_s2_vdd|nwell_vdd|sb_vdd|sr1_vdd|sr2_vdd|sr3_vdd|sr4_vdd|sv_d_vdd_tie|sv_vdd|tg_d_a|tg_d_vdd|tg_fbm_vdd|tg_fbs_vdd|tg_s_vdd|vdd|vdd_b1|vdd_b2|vdd_b3|vdd_b4|vdd_link|vdd_link_dip|vdd_x1|vdd_x2|vdd_x3__t70
+ a|d|inv_clk_vdd|inv_mc_vdd|inv_q_vdd|mpa_py|mpb_py|nand_m_vdd|nand_s2_vdd|nwell_vdd|sb_vdd|sr1_vdd|sr2_vdd|sr3_vdd|sr4_vdd|sv_d_vdd_tie|sv_vdd|tg_d_a|tg_d_vdd|tg_fbm_vdd|tg_fbs_vdd|tg_s_vdd|vdd|vdd_b1|vdd_b2|vdd_b3|vdd_b4|vdd_link|vdd_link_dip|vdd_x1|vdd_x2|vdd_x3
+ 156.680717448
* device instance a_d_inv_clk_vdd_inv_mc_vdd_inv_q_vdd_mpa_py_mpb_py_nand_m_vdd_nand_s2_vdd_nwell_vdd_sb_vdd_sr1_vdd_sr2_vdd_sr3_vdd_sr4_vdd_sv_d_vdd_tie_sv_vdd_tg_d_a_tg_d_vdd_tg_fbm_vdd_tg_fbs_vdd_tg_s_vdd_vdd_vdd_b1_vdd_b2_vdd_b3_vdd_b4_vdd_link_vdd_link_dip_vdd_x1_vdd_x2_vdd_x3_t71 r0 *1 0,0
Ra_d_inv_clk_vdd_inv_mc_vdd_inv_q_vdd_mpa_py_mpb_py_nand_m_vdd_nand_s2_vdd_nwell_vdd_sb_vdd_sr1_vdd_sr2_vdd_sr3_vdd_sr4_vdd_sv_d_vdd_tie_sv_vdd_tg_d_a_tg_d_vdd_tg_fbm_vdd_tg_fbs_vdd_tg_s_vdd_vdd_vdd_b1_vdd_b2_vdd_b3_vdd_b4_vdd_link_vdd_link_dip_vdd_x1_vdd_x2_vdd_x3_t71
+ a|d|inv_clk_vdd|inv_mc_vdd|inv_q_vdd|mpa_py|mpb_py|nand_m_vdd|nand_s2_vdd|nwell_vdd|sb_vdd|sr1_vdd|sr2_vdd|sr3_vdd|sr4_vdd|sv_d_vdd_tie|sv_vdd|tg_d_a|tg_d_vdd|tg_fbm_vdd|tg_fbs_vdd|tg_s_vdd|vdd|vdd_b1|vdd_b2|vdd_b3|vdd_b4|vdd_link|vdd_link_dip|vdd_x1|vdd_x2|vdd_x3__t71
+ a|d|inv_clk_vdd|inv_mc_vdd|inv_q_vdd|mpa_py|mpb_py|nand_m_vdd|nand_s2_vdd|nwell_vdd|sb_vdd|sr1_vdd|sr2_vdd|sr3_vdd|sr4_vdd|sv_d_vdd_tie|sv_vdd|tg_d_a|tg_d_vdd|tg_fbm_vdd|tg_fbs_vdd|tg_s_vdd|vdd|vdd_b1|vdd_b2|vdd_b3|vdd_b4|vdd_link|vdd_link_dip|vdd_x1|vdd_x2|vdd_x3
+ 146.737616634
* device instance a_d_inv_clk_vdd_inv_mc_vdd_inv_q_vdd_mpa_py_mpb_py_nand_m_vdd_nand_s2_vdd_nwell_vdd_sb_vdd_sr1_vdd_sr2_vdd_sr3_vdd_sr4_vdd_sv_d_vdd_tie_sv_vdd_tg_d_a_tg_d_vdd_tg_fbm_vdd_tg_fbs_vdd_tg_s_vdd_vdd_vdd_b1_vdd_b2_vdd_b3_vdd_b4_vdd_link_vdd_link_dip_vdd_x1_vdd_x2_vdd_x3_t72 r0 *1 0,0
Ra_d_inv_clk_vdd_inv_mc_vdd_inv_q_vdd_mpa_py_mpb_py_nand_m_vdd_nand_s2_vdd_nwell_vdd_sb_vdd_sr1_vdd_sr2_vdd_sr3_vdd_sr4_vdd_sv_d_vdd_tie_sv_vdd_tg_d_a_tg_d_vdd_tg_fbm_vdd_tg_fbs_vdd_tg_s_vdd_vdd_vdd_b1_vdd_b2_vdd_b3_vdd_b4_vdd_link_vdd_link_dip_vdd_x1_vdd_x2_vdd_x3_t72
+ a|d|inv_clk_vdd|inv_mc_vdd|inv_q_vdd|mpa_py|mpb_py|nand_m_vdd|nand_s2_vdd|nwell_vdd|sb_vdd|sr1_vdd|sr2_vdd|sr3_vdd|sr4_vdd|sv_d_vdd_tie|sv_vdd|tg_d_a|tg_d_vdd|tg_fbm_vdd|tg_fbs_vdd|tg_s_vdd|vdd|vdd_b1|vdd_b2|vdd_b3|vdd_b4|vdd_link|vdd_link_dip|vdd_x1|vdd_x2|vdd_x3__t72
+ a|d|inv_clk_vdd|inv_mc_vdd|inv_q_vdd|mpa_py|mpb_py|nand_m_vdd|nand_s2_vdd|nwell_vdd|sb_vdd|sr1_vdd|sr2_vdd|sr3_vdd|sr4_vdd|sv_d_vdd_tie|sv_vdd|tg_d_a|tg_d_vdd|tg_fbm_vdd|tg_fbs_vdd|tg_s_vdd|vdd|vdd_b1|vdd_b2|vdd_b3|vdd_b4|vdd_link|vdd_link_dip|vdd_x1|vdd_x2|vdd_x3
+ 21.7730597858
* device instance a_d_inv_clk_vdd_inv_mc_vdd_inv_q_vdd_mpa_py_mpb_py_nand_m_vdd_nand_s2_vdd_nwell_vdd_sb_vdd_sr1_vdd_sr2_vdd_sr3_vdd_sr4_vdd_sv_d_vdd_tie_sv_vdd_tg_d_a_tg_d_vdd_tg_fbm_vdd_tg_fbs_vdd_tg_s_vdd_vdd_vdd_b1_vdd_b2_vdd_b3_vdd_b4_vdd_link_vdd_link_dip_vdd_x1_vdd_x2_vdd_x3_t73 r0 *1 0,0
Ra_d_inv_clk_vdd_inv_mc_vdd_inv_q_vdd_mpa_py_mpb_py_nand_m_vdd_nand_s2_vdd_nwell_vdd_sb_vdd_sr1_vdd_sr2_vdd_sr3_vdd_sr4_vdd_sv_d_vdd_tie_sv_vdd_tg_d_a_tg_d_vdd_tg_fbm_vdd_tg_fbs_vdd_tg_s_vdd_vdd_vdd_b1_vdd_b2_vdd_b3_vdd_b4_vdd_link_vdd_link_dip_vdd_x1_vdd_x2_vdd_x3_t73
+ a|d|inv_clk_vdd|inv_mc_vdd|inv_q_vdd|mpa_py|mpb_py|nand_m_vdd|nand_s2_vdd|nwell_vdd|sb_vdd|sr1_vdd|sr2_vdd|sr3_vdd|sr4_vdd|sv_d_vdd_tie|sv_vdd|tg_d_a|tg_d_vdd|tg_fbm_vdd|tg_fbs_vdd|tg_s_vdd|vdd|vdd_b1|vdd_b2|vdd_b3|vdd_b4|vdd_link|vdd_link_dip|vdd_x1|vdd_x2|vdd_x3__t73
+ a|d|inv_clk_vdd|inv_mc_vdd|inv_q_vdd|mpa_py|mpb_py|nand_m_vdd|nand_s2_vdd|nwell_vdd|sb_vdd|sr1_vdd|sr2_vdd|sr3_vdd|sr4_vdd|sv_d_vdd_tie|sv_vdd|tg_d_a|tg_d_vdd|tg_fbm_vdd|tg_fbs_vdd|tg_s_vdd|vdd|vdd_b1|vdd_b2|vdd_b3|vdd_b4|vdd_link|vdd_link_dip|vdd_x1|vdd_x2|vdd_x3
+ 128.515620516
* device instance a_d_inv_clk_vdd_inv_mc_vdd_inv_q_vdd_mpa_py_mpb_py_nand_m_vdd_nand_s2_vdd_nwell_vdd_sb_vdd_sr1_vdd_sr2_vdd_sr3_vdd_sr4_vdd_sv_d_vdd_tie_sv_vdd_tg_d_a_tg_d_vdd_tg_fbm_vdd_tg_fbs_vdd_tg_s_vdd_vdd_vdd_b1_vdd_b2_vdd_b3_vdd_b4_vdd_link_vdd_link_dip_vdd_x1_vdd_x2_vdd_x3_t74 r0 *1 0,0
Ra_d_inv_clk_vdd_inv_mc_vdd_inv_q_vdd_mpa_py_mpb_py_nand_m_vdd_nand_s2_vdd_nwell_vdd_sb_vdd_sr1_vdd_sr2_vdd_sr3_vdd_sr4_vdd_sv_d_vdd_tie_sv_vdd_tg_d_a_tg_d_vdd_tg_fbm_vdd_tg_fbs_vdd_tg_s_vdd_vdd_vdd_b1_vdd_b2_vdd_b3_vdd_b4_vdd_link_vdd_link_dip_vdd_x1_vdd_x2_vdd_x3_t74
+ a|d|inv_clk_vdd|inv_mc_vdd|inv_q_vdd|mpa_py|mpb_py|nand_m_vdd|nand_s2_vdd|nwell_vdd|sb_vdd|sr1_vdd|sr2_vdd|sr3_vdd|sr4_vdd|sv_d_vdd_tie|sv_vdd|tg_d_a|tg_d_vdd|tg_fbm_vdd|tg_fbs_vdd|tg_s_vdd|vdd|vdd_b1|vdd_b2|vdd_b3|vdd_b4|vdd_link|vdd_link_dip|vdd_x1|vdd_x2|vdd_x3__t74
+ a|d|inv_clk_vdd|inv_mc_vdd|inv_q_vdd|mpa_py|mpb_py|nand_m_vdd|nand_s2_vdd|nwell_vdd|sb_vdd|sr1_vdd|sr2_vdd|sr3_vdd|sr4_vdd|sv_d_vdd_tie|sv_vdd|tg_d_a|tg_d_vdd|tg_fbm_vdd|tg_fbs_vdd|tg_s_vdd|vdd|vdd_b1|vdd_b2|vdd_b3|vdd_b4|vdd_link|vdd_link_dip|vdd_x1|vdd_x2|vdd_x3
+ 181.661562025
* device instance a_d_inv_clk_vdd_inv_mc_vdd_inv_q_vdd_mpa_py_mpb_py_nand_m_vdd_nand_s2_vdd_nwell_vdd_sb_vdd_sr1_vdd_sr2_vdd_sr3_vdd_sr4_vdd_sv_d_vdd_tie_sv_vdd_tg_d_a_tg_d_vdd_tg_fbm_vdd_tg_fbs_vdd_tg_s_vdd_vdd_vdd_b1_vdd_b2_vdd_b3_vdd_b4_vdd_link_vdd_link_dip_vdd_x1_vdd_x2_vdd_x3_t75 r0 *1 0,0
Ra_d_inv_clk_vdd_inv_mc_vdd_inv_q_vdd_mpa_py_mpb_py_nand_m_vdd_nand_s2_vdd_nwell_vdd_sb_vdd_sr1_vdd_sr2_vdd_sr3_vdd_sr4_vdd_sv_d_vdd_tie_sv_vdd_tg_d_a_tg_d_vdd_tg_fbm_vdd_tg_fbs_vdd_tg_s_vdd_vdd_vdd_b1_vdd_b2_vdd_b3_vdd_b4_vdd_link_vdd_link_dip_vdd_x1_vdd_x2_vdd_x3_t75
+ a|d|inv_clk_vdd|inv_mc_vdd|inv_q_vdd|mpa_py|mpb_py|nand_m_vdd|nand_s2_vdd|nwell_vdd|sb_vdd|sr1_vdd|sr2_vdd|sr3_vdd|sr4_vdd|sv_d_vdd_tie|sv_vdd|tg_d_a|tg_d_vdd|tg_fbm_vdd|tg_fbs_vdd|tg_s_vdd|vdd|vdd_b1|vdd_b2|vdd_b3|vdd_b4|vdd_link|vdd_link_dip|vdd_x1|vdd_x2|vdd_x3__t75
+ a|d|inv_clk_vdd|inv_mc_vdd|inv_q_vdd|mpa_py|mpb_py|nand_m_vdd|nand_s2_vdd|nwell_vdd|sb_vdd|sr1_vdd|sr2_vdd|sr3_vdd|sr4_vdd|sv_d_vdd_tie|sv_vdd|tg_d_a|tg_d_vdd|tg_fbm_vdd|tg_fbs_vdd|tg_s_vdd|vdd|vdd_b1|vdd_b2|vdd_b3|vdd_b4|vdd_link|vdd_link_dip|vdd_x1|vdd_x2|vdd_x3
+ 38.4771181778
* device instance a_d_inv_clk_vdd_inv_mc_vdd_inv_q_vdd_mpa_py_mpb_py_nand_m_vdd_nand_s2_vdd_nwell_vdd_sb_vdd_sr1_vdd_sr2_vdd_sr3_vdd_sr4_vdd_sv_d_vdd_tie_sv_vdd_tg_d_a_tg_d_vdd_tg_fbm_vdd_tg_fbs_vdd_tg_s_vdd_vdd_vdd_b1_vdd_b2_vdd_b3_vdd_b4_vdd_link_vdd_link_dip_vdd_x1_vdd_x2_vdd_x3_t76 r0 *1 0,0
Ra_d_inv_clk_vdd_inv_mc_vdd_inv_q_vdd_mpa_py_mpb_py_nand_m_vdd_nand_s2_vdd_nwell_vdd_sb_vdd_sr1_vdd_sr2_vdd_sr3_vdd_sr4_vdd_sv_d_vdd_tie_sv_vdd_tg_d_a_tg_d_vdd_tg_fbm_vdd_tg_fbs_vdd_tg_s_vdd_vdd_vdd_b1_vdd_b2_vdd_b3_vdd_b4_vdd_link_vdd_link_dip_vdd_x1_vdd_x2_vdd_x3_t76
+ a|d|inv_clk_vdd|inv_mc_vdd|inv_q_vdd|mpa_py|mpb_py|nand_m_vdd|nand_s2_vdd|nwell_vdd|sb_vdd|sr1_vdd|sr2_vdd|sr3_vdd|sr4_vdd|sv_d_vdd_tie|sv_vdd|tg_d_a|tg_d_vdd|tg_fbm_vdd|tg_fbs_vdd|tg_s_vdd|vdd|vdd_b1|vdd_b2|vdd_b3|vdd_b4|vdd_link|vdd_link_dip|vdd_x1|vdd_x2|vdd_x3__t76
+ a|d|inv_clk_vdd|inv_mc_vdd|inv_q_vdd|mpa_py|mpb_py|nand_m_vdd|nand_s2_vdd|nwell_vdd|sb_vdd|sr1_vdd|sr2_vdd|sr3_vdd|sr4_vdd|sv_d_vdd_tie|sv_vdd|tg_d_a|tg_d_vdd|tg_fbm_vdd|tg_fbs_vdd|tg_s_vdd|vdd|vdd_b1|vdd_b2|vdd_b3|vdd_b4|vdd_link|vdd_link_dip|vdd_x1|vdd_x2|vdd_x3
+ 118.05949851
* device instance a_d_inv_clk_vdd_inv_mc_vdd_inv_q_vdd_mpa_py_mpb_py_nand_m_vdd_nand_s2_vdd_nwell_vdd_sb_vdd_sr1_vdd_sr2_vdd_sr3_vdd_sr4_vdd_sv_d_vdd_tie_sv_vdd_tg_d_a_tg_d_vdd_tg_fbm_vdd_tg_fbs_vdd_tg_s_vdd_vdd_vdd_b1_vdd_b2_vdd_b3_vdd_b4_vdd_link_vdd_link_dip_vdd_x1_vdd_x2_vdd_x3_t77 r0 *1 0,0
Ra_d_inv_clk_vdd_inv_mc_vdd_inv_q_vdd_mpa_py_mpb_py_nand_m_vdd_nand_s2_vdd_nwell_vdd_sb_vdd_sr1_vdd_sr2_vdd_sr3_vdd_sr4_vdd_sv_d_vdd_tie_sv_vdd_tg_d_a_tg_d_vdd_tg_fbm_vdd_tg_fbs_vdd_tg_s_vdd_vdd_vdd_b1_vdd_b2_vdd_b3_vdd_b4_vdd_link_vdd_link_dip_vdd_x1_vdd_x2_vdd_x3_t77
+ a|d|inv_clk_vdd|inv_mc_vdd|inv_q_vdd|mpa_py|mpb_py|nand_m_vdd|nand_s2_vdd|nwell_vdd|sb_vdd|sr1_vdd|sr2_vdd|sr3_vdd|sr4_vdd|sv_d_vdd_tie|sv_vdd|tg_d_a|tg_d_vdd|tg_fbm_vdd|tg_fbs_vdd|tg_s_vdd|vdd|vdd_b1|vdd_b2|vdd_b3|vdd_b4|vdd_link|vdd_link_dip|vdd_x1|vdd_x2|vdd_x3__t77
+ a|d|inv_clk_vdd|inv_mc_vdd|inv_q_vdd|mpa_py|mpb_py|nand_m_vdd|nand_s2_vdd|nwell_vdd|sb_vdd|sr1_vdd|sr2_vdd|sr3_vdd|sr4_vdd|sv_d_vdd_tie|sv_vdd|tg_d_a|tg_d_vdd|tg_fbm_vdd|tg_fbs_vdd|tg_s_vdd|vdd|vdd_b1|vdd_b2|vdd_b3|vdd_b4|vdd_link|vdd_link_dip|vdd_x1|vdd_x2|vdd_x3
+ 111.123919524
* device instance a_d_inv_clk_vdd_inv_mc_vdd_inv_q_vdd_mpa_py_mpb_py_nand_m_vdd_nand_s2_vdd_nwell_vdd_sb_vdd_sr1_vdd_sr2_vdd_sr3_vdd_sr4_vdd_sv_d_vdd_tie_sv_vdd_tg_d_a_tg_d_vdd_tg_fbm_vdd_tg_fbs_vdd_tg_s_vdd_vdd_vdd_b1_vdd_b2_vdd_b3_vdd_b4_vdd_link_vdd_link_dip_vdd_x1_vdd_x2_vdd_x3_t78 r0 *1 0,0
Ra_d_inv_clk_vdd_inv_mc_vdd_inv_q_vdd_mpa_py_mpb_py_nand_m_vdd_nand_s2_vdd_nwell_vdd_sb_vdd_sr1_vdd_sr2_vdd_sr3_vdd_sr4_vdd_sv_d_vdd_tie_sv_vdd_tg_d_a_tg_d_vdd_tg_fbm_vdd_tg_fbs_vdd_tg_s_vdd_vdd_vdd_b1_vdd_b2_vdd_b3_vdd_b4_vdd_link_vdd_link_dip_vdd_x1_vdd_x2_vdd_x3_t78
+ a|d|inv_clk_vdd|inv_mc_vdd|inv_q_vdd|mpa_py|mpb_py|nand_m_vdd|nand_s2_vdd|nwell_vdd|sb_vdd|sr1_vdd|sr2_vdd|sr3_vdd|sr4_vdd|sv_d_vdd_tie|sv_vdd|tg_d_a|tg_d_vdd|tg_fbm_vdd|tg_fbs_vdd|tg_s_vdd|vdd|vdd_b1|vdd_b2|vdd_b3|vdd_b4|vdd_link|vdd_link_dip|vdd_x1|vdd_x2|vdd_x3__t78
+ a|d|inv_clk_vdd|inv_mc_vdd|inv_q_vdd|mpa_py|mpb_py|nand_m_vdd|nand_s2_vdd|nwell_vdd|sb_vdd|sr1_vdd|sr2_vdd|sr3_vdd|sr4_vdd|sv_d_vdd_tie|sv_vdd|tg_d_a|tg_d_vdd|tg_fbm_vdd|tg_fbs_vdd|tg_s_vdd|vdd|vdd_b1|vdd_b2|vdd_b3|vdd_b4|vdd_link|vdd_link_dip|vdd_x1|vdd_x2|vdd_x3
+ 54.7575311569
* device instance a_d_inv_clk_vdd_inv_mc_vdd_inv_q_vdd_mpa_py_mpb_py_nand_m_vdd_nand_s2_vdd_nwell_vdd_sb_vdd_sr1_vdd_sr2_vdd_sr3_vdd_sr4_vdd_sv_d_vdd_tie_sv_vdd_tg_d_a_tg_d_vdd_tg_fbm_vdd_tg_fbs_vdd_tg_s_vdd_vdd_vdd_b1_vdd_b2_vdd_b3_vdd_b4_vdd_link_vdd_link_dip_vdd_x1_vdd_x2_vdd_x3_t79 r0 *1 0,0
Ra_d_inv_clk_vdd_inv_mc_vdd_inv_q_vdd_mpa_py_mpb_py_nand_m_vdd_nand_s2_vdd_nwell_vdd_sb_vdd_sr1_vdd_sr2_vdd_sr3_vdd_sr4_vdd_sv_d_vdd_tie_sv_vdd_tg_d_a_tg_d_vdd_tg_fbm_vdd_tg_fbs_vdd_tg_s_vdd_vdd_vdd_b1_vdd_b2_vdd_b3_vdd_b4_vdd_link_vdd_link_dip_vdd_x1_vdd_x2_vdd_x3_t79
+ a|d|inv_clk_vdd|inv_mc_vdd|inv_q_vdd|mpa_py|mpb_py|nand_m_vdd|nand_s2_vdd|nwell_vdd|sb_vdd|sr1_vdd|sr2_vdd|sr3_vdd|sr4_vdd|sv_d_vdd_tie|sv_vdd|tg_d_a|tg_d_vdd|tg_fbm_vdd|tg_fbs_vdd|tg_s_vdd|vdd|vdd_b1|vdd_b2|vdd_b3|vdd_b4|vdd_link|vdd_link_dip|vdd_x1|vdd_x2|vdd_x3__t79
+ a|d|inv_clk_vdd|inv_mc_vdd|inv_q_vdd|mpa_py|mpb_py|nand_m_vdd|nand_s2_vdd|nwell_vdd|sb_vdd|sr1_vdd|sr2_vdd|sr3_vdd|sr4_vdd|sv_d_vdd_tie|sv_vdd|tg_d_a|tg_d_vdd|tg_fbm_vdd|tg_fbs_vdd|tg_s_vdd|vdd|vdd_b1|vdd_b2|vdd_b3|vdd_b4|vdd_link|vdd_link_dip|vdd_x1|vdd_x2|vdd_x3
+ 90.041836416
* device instance a_d_inv_clk_vdd_inv_mc_vdd_inv_q_vdd_mpa_py_mpb_py_nand_m_vdd_nand_s2_vdd_nwell_vdd_sb_vdd_sr1_vdd_sr2_vdd_sr3_vdd_sr4_vdd_sv_d_vdd_tie_sv_vdd_tg_d_a_tg_d_vdd_tg_fbm_vdd_tg_fbs_vdd_tg_s_vdd_vdd_vdd_b1_vdd_b2_vdd_b3_vdd_b4_vdd_link_vdd_link_dip_vdd_x1_vdd_x2_vdd_x3_t80 r0 *1 0,0
Ra_d_inv_clk_vdd_inv_mc_vdd_inv_q_vdd_mpa_py_mpb_py_nand_m_vdd_nand_s2_vdd_nwell_vdd_sb_vdd_sr1_vdd_sr2_vdd_sr3_vdd_sr4_vdd_sv_d_vdd_tie_sv_vdd_tg_d_a_tg_d_vdd_tg_fbm_vdd_tg_fbs_vdd_tg_s_vdd_vdd_vdd_b1_vdd_b2_vdd_b3_vdd_b4_vdd_link_vdd_link_dip_vdd_x1_vdd_x2_vdd_x3_t80
+ a|d|inv_clk_vdd|inv_mc_vdd|inv_q_vdd|mpa_py|mpb_py|nand_m_vdd|nand_s2_vdd|nwell_vdd|sb_vdd|sr1_vdd|sr2_vdd|sr3_vdd|sr4_vdd|sv_d_vdd_tie|sv_vdd|tg_d_a|tg_d_vdd|tg_fbm_vdd|tg_fbs_vdd|tg_s_vdd|vdd|vdd_b1|vdd_b2|vdd_b3|vdd_b4|vdd_link|vdd_link_dip|vdd_x1|vdd_x2|vdd_x3__t80
+ a|d|inv_clk_vdd|inv_mc_vdd|inv_q_vdd|mpa_py|mpb_py|nand_m_vdd|nand_s2_vdd|nwell_vdd|sb_vdd|sr1_vdd|sr2_vdd|sr3_vdd|sr4_vdd|sv_d_vdd_tie|sv_vdd|tg_d_a|tg_d_vdd|tg_fbm_vdd|tg_fbs_vdd|tg_s_vdd|vdd|vdd_b1|vdd_b2|vdd_b3|vdd_b4|vdd_link|vdd_link_dip|vdd_x1|vdd_x2|vdd_x3
+ 83.1534323261
* device instance a_d_inv_clk_vdd_inv_mc_vdd_inv_q_vdd_mpa_py_mpb_py_nand_m_vdd_nand_s2_vdd_nwell_vdd_sb_vdd_sr1_vdd_sr2_vdd_sr3_vdd_sr4_vdd_sv_d_vdd_tie_sv_vdd_tg_d_a_tg_d_vdd_tg_fbm_vdd_tg_fbs_vdd_tg_s_vdd_vdd_vdd_b1_vdd_b2_vdd_b3_vdd_b4_vdd_link_vdd_link_dip_vdd_x1_vdd_x2_vdd_x3_t81 r0 *1 0,0
Ra_d_inv_clk_vdd_inv_mc_vdd_inv_q_vdd_mpa_py_mpb_py_nand_m_vdd_nand_s2_vdd_nwell_vdd_sb_vdd_sr1_vdd_sr2_vdd_sr3_vdd_sr4_vdd_sv_d_vdd_tie_sv_vdd_tg_d_a_tg_d_vdd_tg_fbm_vdd_tg_fbs_vdd_tg_s_vdd_vdd_vdd_b1_vdd_b2_vdd_b3_vdd_b4_vdd_link_vdd_link_dip_vdd_x1_vdd_x2_vdd_x3_t81
+ a|d|inv_clk_vdd|inv_mc_vdd|inv_q_vdd|mpa_py|mpb_py|nand_m_vdd|nand_s2_vdd|nwell_vdd|sb_vdd|sr1_vdd|sr2_vdd|sr3_vdd|sr4_vdd|sv_d_vdd_tie|sv_vdd|tg_d_a|tg_d_vdd|tg_fbm_vdd|tg_fbs_vdd|tg_s_vdd|vdd|vdd_b1|vdd_b2|vdd_b3|vdd_b4|vdd_link|vdd_link_dip|vdd_x1|vdd_x2|vdd_x3__t81
+ a|d|inv_clk_vdd|inv_mc_vdd|inv_q_vdd|mpa_py|mpb_py|nand_m_vdd|nand_s2_vdd|nwell_vdd|sb_vdd|sr1_vdd|sr2_vdd|sr3_vdd|sr4_vdd|sv_d_vdd_tie|sv_vdd|tg_d_a|tg_d_vdd|tg_fbm_vdd|tg_fbs_vdd|tg_s_vdd|vdd|vdd_b1|vdd_b2|vdd_b3|vdd_b4|vdd_link|vdd_link_dip|vdd_x1|vdd_x2|vdd_x3
+ 56.5886909333
* device instance a_d_inv_clk_vdd_inv_mc_vdd_inv_q_vdd_mpa_py_mpb_py_nand_m_vdd_nand_s2_vdd_nwell_vdd_sb_vdd_sr1_vdd_sr2_vdd_sr3_vdd_sr4_vdd_sv_d_vdd_tie_sv_vdd_tg_d_a_tg_d_vdd_tg_fbm_vdd_tg_fbs_vdd_tg_s_vdd_vdd_vdd_b1_vdd_b2_vdd_b3_vdd_b4_vdd_link_vdd_link_dip_vdd_x1_vdd_x2_vdd_x3_t82 r0 *1 0,0
Ra_d_inv_clk_vdd_inv_mc_vdd_inv_q_vdd_mpa_py_mpb_py_nand_m_vdd_nand_s2_vdd_nwell_vdd_sb_vdd_sr1_vdd_sr2_vdd_sr3_vdd_sr4_vdd_sv_d_vdd_tie_sv_vdd_tg_d_a_tg_d_vdd_tg_fbm_vdd_tg_fbs_vdd_tg_s_vdd_vdd_vdd_b1_vdd_b2_vdd_b3_vdd_b4_vdd_link_vdd_link_dip_vdd_x1_vdd_x2_vdd_x3_t82
+ a|d|inv_clk_vdd|inv_mc_vdd|inv_q_vdd|mpa_py|mpb_py|nand_m_vdd|nand_s2_vdd|nwell_vdd|sb_vdd|sr1_vdd|sr2_vdd|sr3_vdd|sr4_vdd|sv_d_vdd_tie|sv_vdd|tg_d_a|tg_d_vdd|tg_fbm_vdd|tg_fbs_vdd|tg_s_vdd|vdd|vdd_b1|vdd_b2|vdd_b3|vdd_b4|vdd_link|vdd_link_dip|vdd_x1|vdd_x2|vdd_x3__t82
+ a|d|inv_clk_vdd|inv_mc_vdd|inv_q_vdd|mpa_py|mpb_py|nand_m_vdd|nand_s2_vdd|nwell_vdd|sb_vdd|sr1_vdd|sr2_vdd|sr3_vdd|sr4_vdd|sv_d_vdd_tie|sv_vdd|tg_d_a|tg_d_vdd|tg_fbm_vdd|tg_fbs_vdd|tg_s_vdd|vdd|vdd_b1|vdd_b2|vdd_b3|vdd_b4|vdd_link|vdd_link_dip|vdd_x1|vdd_x2|vdd_x3
+ 48.3329915273
* device instance a_d_inv_clk_vdd_inv_mc_vdd_inv_q_vdd_mpa_py_mpb_py_nand_m_vdd_nand_s2_vdd_nwell_vdd_sb_vdd_sr1_vdd_sr2_vdd_sr3_vdd_sr4_vdd_sv_d_vdd_tie_sv_vdd_tg_d_a_tg_d_vdd_tg_fbm_vdd_tg_fbs_vdd_tg_s_vdd_vdd_vdd_b1_vdd_b2_vdd_b3_vdd_b4_vdd_link_vdd_link_dip_vdd_x1_vdd_x2_vdd_x3_t83 r0 *1 0,0
Ra_d_inv_clk_vdd_inv_mc_vdd_inv_q_vdd_mpa_py_mpb_py_nand_m_vdd_nand_s2_vdd_nwell_vdd_sb_vdd_sr1_vdd_sr2_vdd_sr3_vdd_sr4_vdd_sv_d_vdd_tie_sv_vdd_tg_d_a_tg_d_vdd_tg_fbm_vdd_tg_fbs_vdd_tg_s_vdd_vdd_vdd_b1_vdd_b2_vdd_b3_vdd_b4_vdd_link_vdd_link_dip_vdd_x1_vdd_x2_vdd_x3_t83
+ a|d|inv_clk_vdd|inv_mc_vdd|inv_q_vdd|mpa_py|mpb_py|nand_m_vdd|nand_s2_vdd|nwell_vdd|sb_vdd|sr1_vdd|sr2_vdd|sr3_vdd|sr4_vdd|sv_d_vdd_tie|sv_vdd|tg_d_a|tg_d_vdd|tg_fbm_vdd|tg_fbs_vdd|tg_s_vdd|vdd|vdd_b1|vdd_b2|vdd_b3|vdd_b4|vdd_link|vdd_link_dip|vdd_x1|vdd_x2|vdd_x3__t83
+ a|d|inv_clk_vdd|inv_mc_vdd|inv_q_vdd|mpa_py|mpb_py|nand_m_vdd|nand_s2_vdd|nwell_vdd|sb_vdd|sr1_vdd|sr2_vdd|sr3_vdd|sr4_vdd|sv_d_vdd_tie|sv_vdd|tg_d_a|tg_d_vdd|tg_fbm_vdd|tg_fbs_vdd|tg_s_vdd|vdd|vdd_b1|vdd_b2|vdd_b3|vdd_b4|vdd_link|vdd_link_dip|vdd_x1|vdd_x2|vdd_x3
+ 65.9867039863
* device instance a_d_inv_clk_vdd_inv_mc_vdd_inv_q_vdd_mpa_py_mpb_py_nand_m_vdd_nand_s2_vdd_nwell_vdd_sb_vdd_sr1_vdd_sr2_vdd_sr3_vdd_sr4_vdd_sv_d_vdd_tie_sv_vdd_tg_d_a_tg_d_vdd_tg_fbm_vdd_tg_fbs_vdd_tg_s_vdd_vdd_vdd_b1_vdd_b2_vdd_b3_vdd_b4_vdd_link_vdd_link_dip_vdd_x1_vdd_x2_vdd_x3_t84 r0 *1 0,0
Ra_d_inv_clk_vdd_inv_mc_vdd_inv_q_vdd_mpa_py_mpb_py_nand_m_vdd_nand_s2_vdd_nwell_vdd_sb_vdd_sr1_vdd_sr2_vdd_sr3_vdd_sr4_vdd_sv_d_vdd_tie_sv_vdd_tg_d_a_tg_d_vdd_tg_fbm_vdd_tg_fbs_vdd_tg_s_vdd_vdd_vdd_b1_vdd_b2_vdd_b3_vdd_b4_vdd_link_vdd_link_dip_vdd_x1_vdd_x2_vdd_x3_t84
+ a|d|inv_clk_vdd|inv_mc_vdd|inv_q_vdd|mpa_py|mpb_py|nand_m_vdd|nand_s2_vdd|nwell_vdd|sb_vdd|sr1_vdd|sr2_vdd|sr3_vdd|sr4_vdd|sv_d_vdd_tie|sv_vdd|tg_d_a|tg_d_vdd|tg_fbm_vdd|tg_fbs_vdd|tg_s_vdd|vdd|vdd_b1|vdd_b2|vdd_b3|vdd_b4|vdd_link|vdd_link_dip|vdd_x1|vdd_x2|vdd_x3__t84
+ a|d|inv_clk_vdd|inv_mc_vdd|inv_q_vdd|mpa_py|mpb_py|nand_m_vdd|nand_s2_vdd|nwell_vdd|sb_vdd|sr1_vdd|sr2_vdd|sr3_vdd|sr4_vdd|sv_d_vdd_tie|sv_vdd|tg_d_a|tg_d_vdd|tg_fbm_vdd|tg_fbs_vdd|tg_s_vdd|vdd|vdd_b1|vdd_b2|vdd_b3|vdd_b4|vdd_link|vdd_link_dip|vdd_x1|vdd_x2|vdd_x3
+ 75.7454064487
* device instance a_d_inv_clk_vdd_inv_mc_vdd_inv_q_vdd_mpa_py_mpb_py_nand_m_vdd_nand_s2_vdd_nwell_vdd_sb_vdd_sr1_vdd_sr2_vdd_sr3_vdd_sr4_vdd_sv_d_vdd_tie_sv_vdd_tg_d_a_tg_d_vdd_tg_fbm_vdd_tg_fbs_vdd_tg_s_vdd_vdd_vdd_b1_vdd_b2_vdd_b3_vdd_b4_vdd_link_vdd_link_dip_vdd_x1_vdd_x2_vdd_x3_t85 r0 *1 0,0
Ra_d_inv_clk_vdd_inv_mc_vdd_inv_q_vdd_mpa_py_mpb_py_nand_m_vdd_nand_s2_vdd_nwell_vdd_sb_vdd_sr1_vdd_sr2_vdd_sr3_vdd_sr4_vdd_sv_d_vdd_tie_sv_vdd_tg_d_a_tg_d_vdd_tg_fbm_vdd_tg_fbs_vdd_tg_s_vdd_vdd_vdd_b1_vdd_b2_vdd_b3_vdd_b4_vdd_link_vdd_link_dip_vdd_x1_vdd_x2_vdd_x3_t85
+ a|d|inv_clk_vdd|inv_mc_vdd|inv_q_vdd|mpa_py|mpb_py|nand_m_vdd|nand_s2_vdd|nwell_vdd|sb_vdd|sr1_vdd|sr2_vdd|sr3_vdd|sr4_vdd|sv_d_vdd_tie|sv_vdd|tg_d_a|tg_d_vdd|tg_fbm_vdd|tg_fbs_vdd|tg_s_vdd|vdd|vdd_b1|vdd_b2|vdd_b3|vdd_b4|vdd_link|vdd_link_dip|vdd_x1|vdd_x2|vdd_x3__t85
+ a|d|inv_clk_vdd|inv_mc_vdd|inv_q_vdd|mpa_py|mpb_py|nand_m_vdd|nand_s2_vdd|nwell_vdd|sb_vdd|sr1_vdd|sr2_vdd|sr3_vdd|sr4_vdd|sv_d_vdd_tie|sv_vdd|tg_d_a|tg_d_vdd|tg_fbm_vdd|tg_fbs_vdd|tg_s_vdd|vdd|vdd_b1|vdd_b2|vdd_b3|vdd_b4|vdd_link|vdd_link_dip|vdd_x1|vdd_x2|vdd_x3
+ 23.2370884501
* device instance a_d_inv_clk_vdd_inv_mc_vdd_inv_q_vdd_mpa_py_mpb_py_nand_m_vdd_nand_s2_vdd_nwell_vdd_sb_vdd_sr1_vdd_sr2_vdd_sr3_vdd_sr4_vdd_sv_d_vdd_tie_sv_vdd_tg_d_a_tg_d_vdd_tg_fbm_vdd_tg_fbs_vdd_tg_s_vdd_vdd_vdd_b1_vdd_b2_vdd_b3_vdd_b4_vdd_link_vdd_link_dip_vdd_x1_vdd_x2_vdd_x3_t86 r0 *1 0,0
Ra_d_inv_clk_vdd_inv_mc_vdd_inv_q_vdd_mpa_py_mpb_py_nand_m_vdd_nand_s2_vdd_nwell_vdd_sb_vdd_sr1_vdd_sr2_vdd_sr3_vdd_sr4_vdd_sv_d_vdd_tie_sv_vdd_tg_d_a_tg_d_vdd_tg_fbm_vdd_tg_fbs_vdd_tg_s_vdd_vdd_vdd_b1_vdd_b2_vdd_b3_vdd_b4_vdd_link_vdd_link_dip_vdd_x1_vdd_x2_vdd_x3_t86
+ a|d|inv_clk_vdd|inv_mc_vdd|inv_q_vdd|mpa_py|mpb_py|nand_m_vdd|nand_s2_vdd|nwell_vdd|sb_vdd|sr1_vdd|sr2_vdd|sr3_vdd|sr4_vdd|sv_d_vdd_tie|sv_vdd|tg_d_a|tg_d_vdd|tg_fbm_vdd|tg_fbs_vdd|tg_s_vdd|vdd|vdd_b1|vdd_b2|vdd_b3|vdd_b4|vdd_link|vdd_link_dip|vdd_x1|vdd_x2|vdd_x3__t86
+ a|d|inv_clk_vdd|inv_mc_vdd|inv_q_vdd|mpa_py|mpb_py|nand_m_vdd|nand_s2_vdd|nwell_vdd|sb_vdd|sr1_vdd|sr2_vdd|sr3_vdd|sr4_vdd|sv_d_vdd_tie|sv_vdd|tg_d_a|tg_d_vdd|tg_fbm_vdd|tg_fbs_vdd|tg_s_vdd|vdd|vdd_b1|vdd_b2|vdd_b3|vdd_b4|vdd_link|vdd_link_dip|vdd_x1|vdd_x2|vdd_x3
+ 164.187771856
* device instance a_d_inv_clk_vdd_inv_mc_vdd_inv_q_vdd_mpa_py_mpb_py_nand_m_vdd_nand_s2_vdd_nwell_vdd_sb_vdd_sr1_vdd_sr2_vdd_sr3_vdd_sr4_vdd_sv_d_vdd_tie_sv_vdd_tg_d_a_tg_d_vdd_tg_fbm_vdd_tg_fbs_vdd_tg_s_vdd_vdd_vdd_b1_vdd_b2_vdd_b3_vdd_b4_vdd_link_vdd_link_dip_vdd_x1_vdd_x2_vdd_x3_t87 r0 *1 0,0
Ra_d_inv_clk_vdd_inv_mc_vdd_inv_q_vdd_mpa_py_mpb_py_nand_m_vdd_nand_s2_vdd_nwell_vdd_sb_vdd_sr1_vdd_sr2_vdd_sr3_vdd_sr4_vdd_sv_d_vdd_tie_sv_vdd_tg_d_a_tg_d_vdd_tg_fbm_vdd_tg_fbs_vdd_tg_s_vdd_vdd_vdd_b1_vdd_b2_vdd_b3_vdd_b4_vdd_link_vdd_link_dip_vdd_x1_vdd_x2_vdd_x3_t87
+ a|d|inv_clk_vdd|inv_mc_vdd|inv_q_vdd|mpa_py|mpb_py|nand_m_vdd|nand_s2_vdd|nwell_vdd|sb_vdd|sr1_vdd|sr2_vdd|sr3_vdd|sr4_vdd|sv_d_vdd_tie|sv_vdd|tg_d_a|tg_d_vdd|tg_fbm_vdd|tg_fbs_vdd|tg_s_vdd|vdd|vdd_b1|vdd_b2|vdd_b3|vdd_b4|vdd_link|vdd_link_dip|vdd_x1|vdd_x2|vdd_x3__t87
+ a|d|inv_clk_vdd|inv_mc_vdd|inv_q_vdd|mpa_py|mpb_py|nand_m_vdd|nand_s2_vdd|nwell_vdd|sb_vdd|sr1_vdd|sr2_vdd|sr3_vdd|sr4_vdd|sv_d_vdd_tie|sv_vdd|tg_d_a|tg_d_vdd|tg_fbm_vdd|tg_fbs_vdd|tg_s_vdd|vdd|vdd_b1|vdd_b2|vdd_b3|vdd_b4|vdd_link|vdd_link_dip|vdd_x1|vdd_x2|vdd_x3
+ 157.221525534
* device instance a_d_inv_clk_vdd_inv_mc_vdd_inv_q_vdd_mpa_py_mpb_py_nand_m_vdd_nand_s2_vdd_nwell_vdd_sb_vdd_sr1_vdd_sr2_vdd_sr3_vdd_sr4_vdd_sv_d_vdd_tie_sv_vdd_tg_d_a_tg_d_vdd_tg_fbm_vdd_tg_fbs_vdd_tg_s_vdd_vdd_vdd_b1_vdd_b2_vdd_b3_vdd_b4_vdd_link_vdd_link_dip_vdd_x1_vdd_x2_vdd_x3_t88 r0 *1 0,0
Ra_d_inv_clk_vdd_inv_mc_vdd_inv_q_vdd_mpa_py_mpb_py_nand_m_vdd_nand_s2_vdd_nwell_vdd_sb_vdd_sr1_vdd_sr2_vdd_sr3_vdd_sr4_vdd_sv_d_vdd_tie_sv_vdd_tg_d_a_tg_d_vdd_tg_fbm_vdd_tg_fbs_vdd_tg_s_vdd_vdd_vdd_b1_vdd_b2_vdd_b3_vdd_b4_vdd_link_vdd_link_dip_vdd_x1_vdd_x2_vdd_x3_t88
+ a|d|inv_clk_vdd|inv_mc_vdd|inv_q_vdd|mpa_py|mpb_py|nand_m_vdd|nand_s2_vdd|nwell_vdd|sb_vdd|sr1_vdd|sr2_vdd|sr3_vdd|sr4_vdd|sv_d_vdd_tie|sv_vdd|tg_d_a|tg_d_vdd|tg_fbm_vdd|tg_fbs_vdd|tg_s_vdd|vdd|vdd_b1|vdd_b2|vdd_b3|vdd_b4|vdd_link|vdd_link_dip|vdd_x1|vdd_x2|vdd_x3__t88
+ a|d|inv_clk_vdd|inv_mc_vdd|inv_q_vdd|mpa_py|mpb_py|nand_m_vdd|nand_s2_vdd|nwell_vdd|sb_vdd|sr1_vdd|sr2_vdd|sr3_vdd|sr4_vdd|sv_d_vdd_tie|sv_vdd|tg_d_a|tg_d_vdd|tg_fbm_vdd|tg_fbs_vdd|tg_s_vdd|vdd|vdd_b1|vdd_b2|vdd_b3|vdd_b4|vdd_link|vdd_link_dip|vdd_x1|vdd_x2|vdd_x3
+ 136.006524416
* device instance a_d_inv_clk_vdd_inv_mc_vdd_inv_q_vdd_mpa_py_mpb_py_nand_m_vdd_nand_s2_vdd_nwell_vdd_sb_vdd_sr1_vdd_sr2_vdd_sr3_vdd_sr4_vdd_sv_d_vdd_tie_sv_vdd_tg_d_a_tg_d_vdd_tg_fbm_vdd_tg_fbs_vdd_tg_s_vdd_vdd_vdd_b1_vdd_b2_vdd_b3_vdd_b4_vdd_link_vdd_link_dip_vdd_x1_vdd_x2_vdd_x3_t89 r0 *1 0,0
Ra_d_inv_clk_vdd_inv_mc_vdd_inv_q_vdd_mpa_py_mpb_py_nand_m_vdd_nand_s2_vdd_nwell_vdd_sb_vdd_sr1_vdd_sr2_vdd_sr3_vdd_sr4_vdd_sv_d_vdd_tie_sv_vdd_tg_d_a_tg_d_vdd_tg_fbm_vdd_tg_fbs_vdd_tg_s_vdd_vdd_vdd_b1_vdd_b2_vdd_b3_vdd_b4_vdd_link_vdd_link_dip_vdd_x1_vdd_x2_vdd_x3_t89
+ a|d|inv_clk_vdd|inv_mc_vdd|inv_q_vdd|mpa_py|mpb_py|nand_m_vdd|nand_s2_vdd|nwell_vdd|sb_vdd|sr1_vdd|sr2_vdd|sr3_vdd|sr4_vdd|sv_d_vdd_tie|sv_vdd|tg_d_a|tg_d_vdd|tg_fbm_vdd|tg_fbs_vdd|tg_s_vdd|vdd|vdd_b1|vdd_b2|vdd_b3|vdd_b4|vdd_link|vdd_link_dip|vdd_x1|vdd_x2|vdd_x3__t89
+ a|d|inv_clk_vdd|inv_mc_vdd|inv_q_vdd|mpa_py|mpb_py|nand_m_vdd|nand_s2_vdd|nwell_vdd|sb_vdd|sr1_vdd|sr2_vdd|sr3_vdd|sr4_vdd|sv_d_vdd_tie|sv_vdd|tg_d_a|tg_d_vdd|tg_fbm_vdd|tg_fbs_vdd|tg_s_vdd|vdd|vdd_b1|vdd_b2|vdd_b3|vdd_b4|vdd_link|vdd_link_dip|vdd_x1|vdd_x2|vdd_x3
+ 129.05517831
* device instance a_d_inv_clk_vdd_inv_mc_vdd_inv_q_vdd_mpa_py_mpb_py_nand_m_vdd_nand_s2_vdd_nwell_vdd_sb_vdd_sr1_vdd_sr2_vdd_sr3_vdd_sr4_vdd_sv_d_vdd_tie_sv_vdd_tg_d_a_tg_d_vdd_tg_fbm_vdd_tg_fbs_vdd_tg_s_vdd_vdd_vdd_b1_vdd_b2_vdd_b3_vdd_b4_vdd_link_vdd_link_dip_vdd_x1_vdd_x2_vdd_x3_t90 r0 *1 0,0
Ra_d_inv_clk_vdd_inv_mc_vdd_inv_q_vdd_mpa_py_mpb_py_nand_m_vdd_nand_s2_vdd_nwell_vdd_sb_vdd_sr1_vdd_sr2_vdd_sr3_vdd_sr4_vdd_sv_d_vdd_tie_sv_vdd_tg_d_a_tg_d_vdd_tg_fbm_vdd_tg_fbs_vdd_tg_s_vdd_vdd_vdd_b1_vdd_b2_vdd_b3_vdd_b4_vdd_link_vdd_link_dip_vdd_x1_vdd_x2_vdd_x3_t90
+ a|d|inv_clk_vdd|inv_mc_vdd|inv_q_vdd|mpa_py|mpb_py|nand_m_vdd|nand_s2_vdd|nwell_vdd|sb_vdd|sr1_vdd|sr2_vdd|sr3_vdd|sr4_vdd|sv_d_vdd_tie|sv_vdd|tg_d_a|tg_d_vdd|tg_fbm_vdd|tg_fbs_vdd|tg_s_vdd|vdd|vdd_b1|vdd_b2|vdd_b3|vdd_b4|vdd_link|vdd_link_dip|vdd_x1|vdd_x2|vdd_x3__t90
+ a|d|inv_clk_vdd|inv_mc_vdd|inv_q_vdd|mpa_py|mpb_py|nand_m_vdd|nand_s2_vdd|nwell_vdd|sb_vdd|sr1_vdd|sr2_vdd|sr3_vdd|sr4_vdd|sv_d_vdd_tie|sv_vdd|tg_d_a|tg_d_vdd|tg_fbm_vdd|tg_fbs_vdd|tg_s_vdd|vdd|vdd_b1|vdd_b2|vdd_b3|vdd_b4|vdd_link|vdd_link_dip|vdd_x1|vdd_x2|vdd_x3
+ 118.598348776
* device instance a_d_inv_clk_vdd_inv_mc_vdd_inv_q_vdd_mpa_py_mpb_py_nand_m_vdd_nand_s2_vdd_nwell_vdd_sb_vdd_sr1_vdd_sr2_vdd_sr3_vdd_sr4_vdd_sv_d_vdd_tie_sv_vdd_tg_d_a_tg_d_vdd_tg_fbm_vdd_tg_fbs_vdd_tg_s_vdd_vdd_vdd_b1_vdd_b2_vdd_b3_vdd_b4_vdd_link_vdd_link_dip_vdd_x1_vdd_x2_vdd_x3_t91 r0 *1 0,0
Ra_d_inv_clk_vdd_inv_mc_vdd_inv_q_vdd_mpa_py_mpb_py_nand_m_vdd_nand_s2_vdd_nwell_vdd_sb_vdd_sr1_vdd_sr2_vdd_sr3_vdd_sr4_vdd_sv_d_vdd_tie_sv_vdd_tg_d_a_tg_d_vdd_tg_fbm_vdd_tg_fbs_vdd_tg_s_vdd_vdd_vdd_b1_vdd_b2_vdd_b3_vdd_b4_vdd_link_vdd_link_dip_vdd_x1_vdd_x2_vdd_x3_t91
+ a|d|inv_clk_vdd|inv_mc_vdd|inv_q_vdd|mpa_py|mpb_py|nand_m_vdd|nand_s2_vdd|nwell_vdd|sb_vdd|sr1_vdd|sr2_vdd|sr3_vdd|sr4_vdd|sv_d_vdd_tie|sv_vdd|tg_d_a|tg_d_vdd|tg_fbm_vdd|tg_fbs_vdd|tg_s_vdd|vdd|vdd_b1|vdd_b2|vdd_b3|vdd_b4|vdd_link|vdd_link_dip|vdd_x1|vdd_x2|vdd_x3__t91
+ a|d|inv_clk_vdd|inv_mc_vdd|inv_q_vdd|mpa_py|mpb_py|nand_m_vdd|nand_s2_vdd|nwell_vdd|sb_vdd|sr1_vdd|sr2_vdd|sr3_vdd|sr4_vdd|sv_d_vdd_tie|sv_vdd|tg_d_a|tg_d_vdd|tg_fbm_vdd|tg_fbs_vdd|tg_s_vdd|vdd|vdd_b1|vdd_b2|vdd_b3|vdd_b4|vdd_link|vdd_link_dip|vdd_x1|vdd_x2|vdd_x3
+ 182.380731422
* device instance a_d_inv_clk_vdd_inv_mc_vdd_inv_q_vdd_mpa_py_mpb_py_nand_m_vdd_nand_s2_vdd_nwell_vdd_sb_vdd_sr1_vdd_sr2_vdd_sr3_vdd_sr4_vdd_sv_d_vdd_tie_sv_vdd_tg_d_a_tg_d_vdd_tg_fbm_vdd_tg_fbs_vdd_tg_s_vdd_vdd_vdd_b1_vdd_b2_vdd_b3_vdd_b4_vdd_link_vdd_link_dip_vdd_x1_vdd_x2_vdd_x3_t92 r0 *1 0,0
Ra_d_inv_clk_vdd_inv_mc_vdd_inv_q_vdd_mpa_py_mpb_py_nand_m_vdd_nand_s2_vdd_nwell_vdd_sb_vdd_sr1_vdd_sr2_vdd_sr3_vdd_sr4_vdd_sv_d_vdd_tie_sv_vdd_tg_d_a_tg_d_vdd_tg_fbm_vdd_tg_fbs_vdd_tg_s_vdd_vdd_vdd_b1_vdd_b2_vdd_b3_vdd_b4_vdd_link_vdd_link_dip_vdd_x1_vdd_x2_vdd_x3_t92
+ a|d|inv_clk_vdd|inv_mc_vdd|inv_q_vdd|mpa_py|mpb_py|nand_m_vdd|nand_s2_vdd|nwell_vdd|sb_vdd|sr1_vdd|sr2_vdd|sr3_vdd|sr4_vdd|sv_d_vdd_tie|sv_vdd|tg_d_a|tg_d_vdd|tg_fbm_vdd|tg_fbs_vdd|tg_s_vdd|vdd|vdd_b1|vdd_b2|vdd_b3|vdd_b4|vdd_link|vdd_link_dip|vdd_x1|vdd_x2|vdd_x3__t92
+ a|d|inv_clk_vdd|inv_mc_vdd|inv_q_vdd|mpa_py|mpb_py|nand_m_vdd|nand_s2_vdd|nwell_vdd|sb_vdd|sr1_vdd|sr2_vdd|sr3_vdd|sr4_vdd|sv_d_vdd_tie|sv_vdd|tg_d_a|tg_d_vdd|tg_fbm_vdd|tg_fbs_vdd|tg_s_vdd|vdd|vdd_b1|vdd_b2|vdd_b3|vdd_b4|vdd_link|vdd_link_dip|vdd_x1|vdd_x2|vdd_x3
+ 180.492128585
* device instance a_d_inv_clk_vdd_inv_mc_vdd_inv_q_vdd_mpa_py_mpb_py_nand_m_vdd_nand_s2_vdd_nwell_vdd_sb_vdd_sr1_vdd_sr2_vdd_sr3_vdd_sr4_vdd_sv_d_vdd_tie_sv_vdd_tg_d_a_tg_d_vdd_tg_fbm_vdd_tg_fbs_vdd_tg_s_vdd_vdd_vdd_b1_vdd_b2_vdd_b3_vdd_b4_vdd_link_vdd_link_dip_vdd_x1_vdd_x2_vdd_x3_t93 r0 *1 0,0
Ra_d_inv_clk_vdd_inv_mc_vdd_inv_q_vdd_mpa_py_mpb_py_nand_m_vdd_nand_s2_vdd_nwell_vdd_sb_vdd_sr1_vdd_sr2_vdd_sr3_vdd_sr4_vdd_sv_d_vdd_tie_sv_vdd_tg_d_a_tg_d_vdd_tg_fbm_vdd_tg_fbs_vdd_tg_s_vdd_vdd_vdd_b1_vdd_b2_vdd_b3_vdd_b4_vdd_link_vdd_link_dip_vdd_x1_vdd_x2_vdd_x3_t93
+ a|d|inv_clk_vdd|inv_mc_vdd|inv_q_vdd|mpa_py|mpb_py|nand_m_vdd|nand_s2_vdd|nwell_vdd|sb_vdd|sr1_vdd|sr2_vdd|sr3_vdd|sr4_vdd|sv_d_vdd_tie|sv_vdd|tg_d_a|tg_d_vdd|tg_fbm_vdd|tg_fbs_vdd|tg_s_vdd|vdd|vdd_b1|vdd_b2|vdd_b3|vdd_b4|vdd_link|vdd_link_dip|vdd_x1|vdd_x2|vdd_x3__t93
+ a|d|inv_clk_vdd|inv_mc_vdd|inv_q_vdd|mpa_py|mpb_py|nand_m_vdd|nand_s2_vdd|nwell_vdd|sb_vdd|sr1_vdd|sr2_vdd|sr3_vdd|sr4_vdd|sv_d_vdd_tie|sv_vdd|tg_d_a|tg_d_vdd|tg_fbm_vdd|tg_fbs_vdd|tg_s_vdd|vdd|vdd_b1|vdd_b2|vdd_b3|vdd_b4|vdd_link|vdd_link_dip|vdd_x1|vdd_x2|vdd_x3
+ 38.9766503848
* device instance a_d_inv_clk_vdd_inv_mc_vdd_inv_q_vdd_mpa_py_mpb_py_nand_m_vdd_nand_s2_vdd_nwell_vdd_sb_vdd_sr1_vdd_sr2_vdd_sr3_vdd_sr4_vdd_sv_d_vdd_tie_sv_vdd_tg_d_a_tg_d_vdd_tg_fbm_vdd_tg_fbs_vdd_tg_s_vdd_vdd_vdd_b1_vdd_b2_vdd_b3_vdd_b4_vdd_link_vdd_link_dip_vdd_x1_vdd_x2_vdd_x3_t94 r0 *1 0,0
Ra_d_inv_clk_vdd_inv_mc_vdd_inv_q_vdd_mpa_py_mpb_py_nand_m_vdd_nand_s2_vdd_nwell_vdd_sb_vdd_sr1_vdd_sr2_vdd_sr3_vdd_sr4_vdd_sv_d_vdd_tie_sv_vdd_tg_d_a_tg_d_vdd_tg_fbm_vdd_tg_fbs_vdd_tg_s_vdd_vdd_vdd_b1_vdd_b2_vdd_b3_vdd_b4_vdd_link_vdd_link_dip_vdd_x1_vdd_x2_vdd_x3_t94
+ a|d|inv_clk_vdd|inv_mc_vdd|inv_q_vdd|mpa_py|mpb_py|nand_m_vdd|nand_s2_vdd|nwell_vdd|sb_vdd|sr1_vdd|sr2_vdd|sr3_vdd|sr4_vdd|sv_d_vdd_tie|sv_vdd|tg_d_a|tg_d_vdd|tg_fbm_vdd|tg_fbs_vdd|tg_s_vdd|vdd|vdd_b1|vdd_b2|vdd_b3|vdd_b4|vdd_link|vdd_link_dip|vdd_x1|vdd_x2|vdd_x3__t94
+ a|d|inv_clk_vdd|inv_mc_vdd|inv_q_vdd|mpa_py|mpb_py|nand_m_vdd|nand_s2_vdd|nwell_vdd|sb_vdd|sr1_vdd|sr2_vdd|sr3_vdd|sr4_vdd|sv_d_vdd_tie|sv_vdd|tg_d_a|tg_d_vdd|tg_fbm_vdd|tg_fbs_vdd|tg_s_vdd|vdd|vdd_b1|vdd_b2|vdd_b3|vdd_b4|vdd_link|vdd_link_dip|vdd_x1|vdd_x2|vdd_x3
+ 23.2346706982
* device instance a_d_inv_clk_vdd_inv_mc_vdd_inv_q_vdd_mpa_py_mpb_py_nand_m_vdd_nand_s2_vdd_nwell_vdd_sb_vdd_sr1_vdd_sr2_vdd_sr3_vdd_sr4_vdd_sv_d_vdd_tie_sv_vdd_tg_d_a_tg_d_vdd_tg_fbm_vdd_tg_fbs_vdd_tg_s_vdd_vdd_vdd_b1_vdd_b2_vdd_b3_vdd_b4_vdd_link_vdd_link_dip_vdd_x1_vdd_x2_vdd_x3_t95 r0 *1 0,0
Ra_d_inv_clk_vdd_inv_mc_vdd_inv_q_vdd_mpa_py_mpb_py_nand_m_vdd_nand_s2_vdd_nwell_vdd_sb_vdd_sr1_vdd_sr2_vdd_sr3_vdd_sr4_vdd_sv_d_vdd_tie_sv_vdd_tg_d_a_tg_d_vdd_tg_fbm_vdd_tg_fbs_vdd_tg_s_vdd_vdd_vdd_b1_vdd_b2_vdd_b3_vdd_b4_vdd_link_vdd_link_dip_vdd_x1_vdd_x2_vdd_x3_t95
+ a|d|inv_clk_vdd|inv_mc_vdd|inv_q_vdd|mpa_py|mpb_py|nand_m_vdd|nand_s2_vdd|nwell_vdd|sb_vdd|sr1_vdd|sr2_vdd|sr3_vdd|sr4_vdd|sv_d_vdd_tie|sv_vdd|tg_d_a|tg_d_vdd|tg_fbm_vdd|tg_fbs_vdd|tg_s_vdd|vdd|vdd_b1|vdd_b2|vdd_b3|vdd_b4|vdd_link|vdd_link_dip|vdd_x1|vdd_x2|vdd_x3__t95
+ a|d|inv_clk_vdd|inv_mc_vdd|inv_q_vdd|mpa_py|mpb_py|nand_m_vdd|nand_s2_vdd|nwell_vdd|sb_vdd|sr1_vdd|sr2_vdd|sr3_vdd|sr4_vdd|sv_d_vdd_tie|sv_vdd|tg_d_a|tg_d_vdd|tg_fbm_vdd|tg_fbs_vdd|tg_s_vdd|vdd|vdd_b1|vdd_b2|vdd_b3|vdd_b4|vdd_link|vdd_link_dip|vdd_x1|vdd_x2|vdd_x3
+ 100.442732907
* device instance a_d_inv_clk_vdd_inv_mc_vdd_inv_q_vdd_mpa_py_mpb_py_nand_m_vdd_nand_s2_vdd_nwell_vdd_sb_vdd_sr1_vdd_sr2_vdd_sr3_vdd_sr4_vdd_sv_d_vdd_tie_sv_vdd_tg_d_a_tg_d_vdd_tg_fbm_vdd_tg_fbs_vdd_tg_s_vdd_vdd_vdd_b1_vdd_b2_vdd_b3_vdd_b4_vdd_link_vdd_link_dip_vdd_x1_vdd_x2_vdd_x3_t96 r0 *1 0,0
Ra_d_inv_clk_vdd_inv_mc_vdd_inv_q_vdd_mpa_py_mpb_py_nand_m_vdd_nand_s2_vdd_nwell_vdd_sb_vdd_sr1_vdd_sr2_vdd_sr3_vdd_sr4_vdd_sv_d_vdd_tie_sv_vdd_tg_d_a_tg_d_vdd_tg_fbm_vdd_tg_fbs_vdd_tg_s_vdd_vdd_vdd_b1_vdd_b2_vdd_b3_vdd_b4_vdd_link_vdd_link_dip_vdd_x1_vdd_x2_vdd_x3_t96
+ a|d|inv_clk_vdd|inv_mc_vdd|inv_q_vdd|mpa_py|mpb_py|nand_m_vdd|nand_s2_vdd|nwell_vdd|sb_vdd|sr1_vdd|sr2_vdd|sr3_vdd|sr4_vdd|sv_d_vdd_tie|sv_vdd|tg_d_a|tg_d_vdd|tg_fbm_vdd|tg_fbs_vdd|tg_s_vdd|vdd|vdd_b1|vdd_b2|vdd_b3|vdd_b4|vdd_link|vdd_link_dip|vdd_x1|vdd_x2|vdd_x3__t96
+ a|d|inv_clk_vdd|inv_mc_vdd|inv_q_vdd|mpa_py|mpb_py|nand_m_vdd|nand_s2_vdd|nwell_vdd|sb_vdd|sr1_vdd|sr2_vdd|sr3_vdd|sr4_vdd|sv_d_vdd_tie|sv_vdd|tg_d_a|tg_d_vdd|tg_fbm_vdd|tg_fbs_vdd|tg_s_vdd|vdd|vdd_b1|vdd_b2|vdd_b3|vdd_b4|vdd_link|vdd_link_dip|vdd_x1|vdd_x2|vdd_x3
+ 48.8489499379
* device instance a_d_inv_clk_vdd_inv_mc_vdd_inv_q_vdd_mpa_py_mpb_py_nand_m_vdd_nand_s2_vdd_nwell_vdd_sb_vdd_sr1_vdd_sr2_vdd_sr3_vdd_sr4_vdd_sv_d_vdd_tie_sv_vdd_tg_d_a_tg_d_vdd_tg_fbm_vdd_tg_fbs_vdd_tg_s_vdd_vdd_vdd_b1_vdd_b2_vdd_b3_vdd_b4_vdd_link_vdd_link_dip_vdd_x1_vdd_x2_vdd_x3_t97 r0 *1 0,0
Ra_d_inv_clk_vdd_inv_mc_vdd_inv_q_vdd_mpa_py_mpb_py_nand_m_vdd_nand_s2_vdd_nwell_vdd_sb_vdd_sr1_vdd_sr2_vdd_sr3_vdd_sr4_vdd_sv_d_vdd_tie_sv_vdd_tg_d_a_tg_d_vdd_tg_fbm_vdd_tg_fbs_vdd_tg_s_vdd_vdd_vdd_b1_vdd_b2_vdd_b3_vdd_b4_vdd_link_vdd_link_dip_vdd_x1_vdd_x2_vdd_x3_t97
+ a|d|inv_clk_vdd|inv_mc_vdd|inv_q_vdd|mpa_py|mpb_py|nand_m_vdd|nand_s2_vdd|nwell_vdd|sb_vdd|sr1_vdd|sr2_vdd|sr3_vdd|sr4_vdd|sv_d_vdd_tie|sv_vdd|tg_d_a|tg_d_vdd|tg_fbm_vdd|tg_fbs_vdd|tg_s_vdd|vdd|vdd_b1|vdd_b2|vdd_b3|vdd_b4|vdd_link|vdd_link_dip|vdd_x1|vdd_x2|vdd_x3__t97
+ a|d|inv_clk_vdd|inv_mc_vdd|inv_q_vdd|mpa_py|mpb_py|nand_m_vdd|nand_s2_vdd|nwell_vdd|sb_vdd|sr1_vdd|sr2_vdd|sr3_vdd|sr4_vdd|sv_d_vdd_tie|sv_vdd|tg_d_a|tg_d_vdd|tg_fbm_vdd|tg_fbs_vdd|tg_s_vdd|vdd|vdd_b1|vdd_b2|vdd_b3|vdd_b4|vdd_link|vdd_link_dip|vdd_x1|vdd_x2|vdd_x3
+ 32.209780801
* device instance a_d_inv_clk_vdd_inv_mc_vdd_inv_q_vdd_mpa_py_mpb_py_nand_m_vdd_nand_s2_vdd_nwell_vdd_sb_vdd_sr1_vdd_sr2_vdd_sr3_vdd_sr4_vdd_sv_d_vdd_tie_sv_vdd_tg_d_a_tg_d_vdd_tg_fbm_vdd_tg_fbs_vdd_tg_s_vdd_vdd_vdd_b1_vdd_b2_vdd_b3_vdd_b4_vdd_link_vdd_link_dip_vdd_x1_vdd_x2_vdd_x3_t98 r0 *1 0,0
Ra_d_inv_clk_vdd_inv_mc_vdd_inv_q_vdd_mpa_py_mpb_py_nand_m_vdd_nand_s2_vdd_nwell_vdd_sb_vdd_sr1_vdd_sr2_vdd_sr3_vdd_sr4_vdd_sv_d_vdd_tie_sv_vdd_tg_d_a_tg_d_vdd_tg_fbm_vdd_tg_fbs_vdd_tg_s_vdd_vdd_vdd_b1_vdd_b2_vdd_b3_vdd_b4_vdd_link_vdd_link_dip_vdd_x1_vdd_x2_vdd_x3_t98
+ a|d|inv_clk_vdd|inv_mc_vdd|inv_q_vdd|mpa_py|mpb_py|nand_m_vdd|nand_s2_vdd|nwell_vdd|sb_vdd|sr1_vdd|sr2_vdd|sr3_vdd|sr4_vdd|sv_d_vdd_tie|sv_vdd|tg_d_a|tg_d_vdd|tg_fbm_vdd|tg_fbs_vdd|tg_s_vdd|vdd|vdd_b1|vdd_b2|vdd_b3|vdd_b4|vdd_link|vdd_link_dip|vdd_x1|vdd_x2|vdd_x3__t98
+ a|d|inv_clk_vdd|inv_mc_vdd|inv_q_vdd|mpa_py|mpb_py|nand_m_vdd|nand_s2_vdd|nwell_vdd|sb_vdd|sr1_vdd|sr2_vdd|sr3_vdd|sr4_vdd|sv_d_vdd_tie|sv_vdd|tg_d_a|tg_d_vdd|tg_fbm_vdd|tg_fbs_vdd|tg_s_vdd|vdd|vdd_b1|vdd_b2|vdd_b3|vdd_b4|vdd_link|vdd_link_dip|vdd_x1|vdd_x2|vdd_x3
+ 30.522932681
* device instance a_d_inv_clk_vdd_inv_mc_vdd_inv_q_vdd_mpa_py_mpb_py_nand_m_vdd_nand_s2_vdd_nwell_vdd_sb_vdd_sr1_vdd_sr2_vdd_sr3_vdd_sr4_vdd_sv_d_vdd_tie_sv_vdd_tg_d_a_tg_d_vdd_tg_fbm_vdd_tg_fbs_vdd_tg_s_vdd_vdd_vdd_b1_vdd_b2_vdd_b3_vdd_b4_vdd_link_vdd_link_dip_vdd_x1_vdd_x2_vdd_x3_t99 r0 *1 0,0
Ra_d_inv_clk_vdd_inv_mc_vdd_inv_q_vdd_mpa_py_mpb_py_nand_m_vdd_nand_s2_vdd_nwell_vdd_sb_vdd_sr1_vdd_sr2_vdd_sr3_vdd_sr4_vdd_sv_d_vdd_tie_sv_vdd_tg_d_a_tg_d_vdd_tg_fbm_vdd_tg_fbs_vdd_tg_s_vdd_vdd_vdd_b1_vdd_b2_vdd_b3_vdd_b4_vdd_link_vdd_link_dip_vdd_x1_vdd_x2_vdd_x3_t99
+ a|d|inv_clk_vdd|inv_mc_vdd|inv_q_vdd|mpa_py|mpb_py|nand_m_vdd|nand_s2_vdd|nwell_vdd|sb_vdd|sr1_vdd|sr2_vdd|sr3_vdd|sr4_vdd|sv_d_vdd_tie|sv_vdd|tg_d_a|tg_d_vdd|tg_fbm_vdd|tg_fbs_vdd|tg_s_vdd|vdd|vdd_b1|vdd_b2|vdd_b3|vdd_b4|vdd_link|vdd_link_dip|vdd_x1|vdd_x2|vdd_x3__t99
+ a|d|inv_clk_vdd|inv_mc_vdd|inv_q_vdd|mpa_py|mpb_py|nand_m_vdd|nand_s2_vdd|nwell_vdd|sb_vdd|sr1_vdd|sr2_vdd|sr3_vdd|sr4_vdd|sv_d_vdd_tie|sv_vdd|tg_d_a|tg_d_vdd|tg_fbm_vdd|tg_fbs_vdd|tg_s_vdd|vdd|vdd_b1|vdd_b2|vdd_b3|vdd_b4|vdd_link|vdd_link_dip|vdd_x1|vdd_x2|vdd_x3
+ 137.245030204
* device instance a_d_inv_clk_vdd_inv_mc_vdd_inv_q_vdd_mpa_py_mpb_py_nand_m_vdd_nand_s2_vdd_nwell_vdd_sb_vdd_sr1_vdd_sr2_vdd_sr3_vdd_sr4_vdd_sv_d_vdd_tie_sv_vdd_tg_d_a_tg_d_vdd_tg_fbm_vdd_tg_fbs_vdd_tg_s_vdd_vdd_vdd_b1_vdd_b2_vdd_b3_vdd_b4_vdd_link_vdd_link_dip_vdd_x1_vdd_x2_vdd_x3_t100 r0 *1 0,0
Ra_d_inv_clk_vdd_inv_mc_vdd_inv_q_vdd_mpa_py_mpb_py_nand_m_vdd_nand_s2_vdd_nwell_vdd_sb_vdd_sr1_vdd_sr2_vdd_sr3_vdd_sr4_vdd_sv_d_vdd_tie_sv_vdd_tg_d_a_tg_d_vdd_tg_fbm_vdd_tg_fbs_vdd_tg_s_vdd_vdd_vdd_b1_vdd_b2_vdd_b3_vdd_b4_vdd_link_vdd_link_dip_vdd_x1_vdd_x2_vdd_x3_t100
+ a|d|inv_clk_vdd|inv_mc_vdd|inv_q_vdd|mpa_py|mpb_py|nand_m_vdd|nand_s2_vdd|nwell_vdd|sb_vdd|sr1_vdd|sr2_vdd|sr3_vdd|sr4_vdd|sv_d_vdd_tie|sv_vdd|tg_d_a|tg_d_vdd|tg_fbm_vdd|tg_fbs_vdd|tg_s_vdd|vdd|vdd_b1|vdd_b2|vdd_b3|vdd_b4|vdd_link|vdd_link_dip|vdd_x1|vdd_x2|vdd_x3__t100
+ a|d|inv_clk_vdd|inv_mc_vdd|inv_q_vdd|mpa_py|mpb_py|nand_m_vdd|nand_s2_vdd|nwell_vdd|sb_vdd|sr1_vdd|sr2_vdd|sr3_vdd|sr4_vdd|sv_d_vdd_tie|sv_vdd|tg_d_a|tg_d_vdd|tg_fbm_vdd|tg_fbs_vdd|tg_s_vdd|vdd|vdd_b1|vdd_b2|vdd_b3|vdd_b4|vdd_link|vdd_link_dip|vdd_x1|vdd_x2|vdd_x3
+ 17.0051118211
* device instance a_d_inv_clk_vdd_inv_mc_vdd_inv_q_vdd_mpa_py_mpb_py_nand_m_vdd_nand_s2_vdd_nwell_vdd_sb_vdd_sr1_vdd_sr2_vdd_sr3_vdd_sr4_vdd_sv_d_vdd_tie_sv_vdd_tg_d_a_tg_d_vdd_tg_fbm_vdd_tg_fbs_vdd_tg_s_vdd_vdd_vdd_b1_vdd_b2_vdd_b3_vdd_b4_vdd_link_vdd_link_dip_vdd_x1_vdd_x2_vdd_x3_t101 r0 *1 0,0
Ra_d_inv_clk_vdd_inv_mc_vdd_inv_q_vdd_mpa_py_mpb_py_nand_m_vdd_nand_s2_vdd_nwell_vdd_sb_vdd_sr1_vdd_sr2_vdd_sr3_vdd_sr4_vdd_sv_d_vdd_tie_sv_vdd_tg_d_a_tg_d_vdd_tg_fbm_vdd_tg_fbs_vdd_tg_s_vdd_vdd_vdd_b1_vdd_b2_vdd_b3_vdd_b4_vdd_link_vdd_link_dip_vdd_x1_vdd_x2_vdd_x3_t101
+ a|d|inv_clk_vdd|inv_mc_vdd|inv_q_vdd|mpa_py|mpb_py|nand_m_vdd|nand_s2_vdd|nwell_vdd|sb_vdd|sr1_vdd|sr2_vdd|sr3_vdd|sr4_vdd|sv_d_vdd_tie|sv_vdd|tg_d_a|tg_d_vdd|tg_fbm_vdd|tg_fbs_vdd|tg_s_vdd|vdd|vdd_b1|vdd_b2|vdd_b3|vdd_b4|vdd_link|vdd_link_dip|vdd_x1|vdd_x2|vdd_x3__t101
+ a|d|inv_clk_vdd|inv_mc_vdd|inv_q_vdd|mpa_py|mpb_py|nand_m_vdd|nand_s2_vdd|nwell_vdd|sb_vdd|sr1_vdd|sr2_vdd|sr3_vdd|sr4_vdd|sv_d_vdd_tie|sv_vdd|tg_d_a|tg_d_vdd|tg_fbm_vdd|tg_fbs_vdd|tg_s_vdd|vdd|vdd_b1|vdd_b2|vdd_b3|vdd_b4|vdd_link|vdd_link_dip|vdd_x1|vdd_x2|vdd_x3
+ 83.1462137955
* device instance a_d_inv_clk_vdd_inv_mc_vdd_inv_q_vdd_mpa_py_mpb_py_nand_m_vdd_nand_s2_vdd_nwell_vdd_sb_vdd_sr1_vdd_sr2_vdd_sr3_vdd_sr4_vdd_sv_d_vdd_tie_sv_vdd_tg_d_a_tg_d_vdd_tg_fbm_vdd_tg_fbs_vdd_tg_s_vdd_vdd_vdd_b1_vdd_b2_vdd_b3_vdd_b4_vdd_link_vdd_link_dip_vdd_x1_vdd_x2_vdd_x3_t102 r0 *1 0,0
Ra_d_inv_clk_vdd_inv_mc_vdd_inv_q_vdd_mpa_py_mpb_py_nand_m_vdd_nand_s2_vdd_nwell_vdd_sb_vdd_sr1_vdd_sr2_vdd_sr3_vdd_sr4_vdd_sv_d_vdd_tie_sv_vdd_tg_d_a_tg_d_vdd_tg_fbm_vdd_tg_fbs_vdd_tg_s_vdd_vdd_vdd_b1_vdd_b2_vdd_b3_vdd_b4_vdd_link_vdd_link_dip_vdd_x1_vdd_x2_vdd_x3_t102
+ a|d|inv_clk_vdd|inv_mc_vdd|inv_q_vdd|mpa_py|mpb_py|nand_m_vdd|nand_s2_vdd|nwell_vdd|sb_vdd|sr1_vdd|sr2_vdd|sr3_vdd|sr4_vdd|sv_d_vdd_tie|sv_vdd|tg_d_a|tg_d_vdd|tg_fbm_vdd|tg_fbs_vdd|tg_s_vdd|vdd|vdd_b1|vdd_b2|vdd_b3|vdd_b4|vdd_link|vdd_link_dip|vdd_x1|vdd_x2|vdd_x3__t102
+ a|d|inv_clk_vdd|inv_mc_vdd|inv_q_vdd|mpa_py|mpb_py|nand_m_vdd|nand_s2_vdd|nwell_vdd|sb_vdd|sr1_vdd|sr2_vdd|sr3_vdd|sr4_vdd|sv_d_vdd_tie|sv_vdd|tg_d_a|tg_d_vdd|tg_fbm_vdd|tg_fbs_vdd|tg_s_vdd|vdd|vdd_b1|vdd_b2|vdd_b3|vdd_b4|vdd_link|vdd_link_dip|vdd_x1|vdd_x2|vdd_x3
+ 135.360970407
* device instance a_d_inv_clk_vdd_inv_mc_vdd_inv_q_vdd_mpa_py_mpb_py_nand_m_vdd_nand_s2_vdd_nwell_vdd_sb_vdd_sr1_vdd_sr2_vdd_sr3_vdd_sr4_vdd_sv_d_vdd_tie_sv_vdd_tg_d_a_tg_d_vdd_tg_fbm_vdd_tg_fbs_vdd_tg_s_vdd_vdd_vdd_b1_vdd_b2_vdd_b3_vdd_b4_vdd_link_vdd_link_dip_vdd_x1_vdd_x2_vdd_x3_t103 r0 *1 0,0
Ra_d_inv_clk_vdd_inv_mc_vdd_inv_q_vdd_mpa_py_mpb_py_nand_m_vdd_nand_s2_vdd_nwell_vdd_sb_vdd_sr1_vdd_sr2_vdd_sr3_vdd_sr4_vdd_sv_d_vdd_tie_sv_vdd_tg_d_a_tg_d_vdd_tg_fbm_vdd_tg_fbs_vdd_tg_s_vdd_vdd_vdd_b1_vdd_b2_vdd_b3_vdd_b4_vdd_link_vdd_link_dip_vdd_x1_vdd_x2_vdd_x3_t103
+ a|d|inv_clk_vdd|inv_mc_vdd|inv_q_vdd|mpa_py|mpb_py|nand_m_vdd|nand_s2_vdd|nwell_vdd|sb_vdd|sr1_vdd|sr2_vdd|sr3_vdd|sr4_vdd|sv_d_vdd_tie|sv_vdd|tg_d_a|tg_d_vdd|tg_fbm_vdd|tg_fbs_vdd|tg_s_vdd|vdd|vdd_b1|vdd_b2|vdd_b3|vdd_b4|vdd_link|vdd_link_dip|vdd_x1|vdd_x2|vdd_x3__t103
+ a|d|inv_clk_vdd|inv_mc_vdd|inv_q_vdd|mpa_py|mpb_py|nand_m_vdd|nand_s2_vdd|nwell_vdd|sb_vdd|sr1_vdd|sr2_vdd|sr3_vdd|sr4_vdd|sv_d_vdd_tie|sv_vdd|tg_d_a|tg_d_vdd|tg_fbm_vdd|tg_fbs_vdd|tg_s_vdd|vdd|vdd_b1|vdd_b2|vdd_b3|vdd_b4|vdd_link|vdd_link_dip|vdd_x1|vdd_x2|vdd_x3
+ 15.2397231636
* device instance a_d_inv_clk_vdd_inv_mc_vdd_inv_q_vdd_mpa_py_mpb_py_nand_m_vdd_nand_s2_vdd_nwell_vdd_sb_vdd_sr1_vdd_sr2_vdd_sr3_vdd_sr4_vdd_sv_d_vdd_tie_sv_vdd_tg_d_a_tg_d_vdd_tg_fbm_vdd_tg_fbs_vdd_tg_s_vdd_vdd_vdd_b1_vdd_b2_vdd_b3_vdd_b4_vdd_link_vdd_link_dip_vdd_x1_vdd_x2_vdd_x3_t104 r0 *1 0,0
Ra_d_inv_clk_vdd_inv_mc_vdd_inv_q_vdd_mpa_py_mpb_py_nand_m_vdd_nand_s2_vdd_nwell_vdd_sb_vdd_sr1_vdd_sr2_vdd_sr3_vdd_sr4_vdd_sv_d_vdd_tie_sv_vdd_tg_d_a_tg_d_vdd_tg_fbm_vdd_tg_fbs_vdd_tg_s_vdd_vdd_vdd_b1_vdd_b2_vdd_b3_vdd_b4_vdd_link_vdd_link_dip_vdd_x1_vdd_x2_vdd_x3_t104
+ a|d|inv_clk_vdd|inv_mc_vdd|inv_q_vdd|mpa_py|mpb_py|nand_m_vdd|nand_s2_vdd|nwell_vdd|sb_vdd|sr1_vdd|sr2_vdd|sr3_vdd|sr4_vdd|sv_d_vdd_tie|sv_vdd|tg_d_a|tg_d_vdd|tg_fbm_vdd|tg_fbs_vdd|tg_s_vdd|vdd|vdd_b1|vdd_b2|vdd_b3|vdd_b4|vdd_link|vdd_link_dip|vdd_x1|vdd_x2|vdd_x3__t104
+ a|d|inv_clk_vdd|inv_mc_vdd|inv_q_vdd|mpa_py|mpb_py|nand_m_vdd|nand_s2_vdd|nwell_vdd|sb_vdd|sr1_vdd|sr2_vdd|sr3_vdd|sr4_vdd|sv_d_vdd_tie|sv_vdd|tg_d_a|tg_d_vdd|tg_fbm_vdd|tg_fbs_vdd|tg_s_vdd|vdd|vdd_b1|vdd_b2|vdd_b3|vdd_b4|vdd_link|vdd_link_dip|vdd_x1|vdd_x2|vdd_x3
+ 76.2777489005
* device instance a_d_inv_clk_vdd_inv_mc_vdd_inv_q_vdd_mpa_py_mpb_py_nand_m_vdd_nand_s2_vdd_nwell_vdd_sb_vdd_sr1_vdd_sr2_vdd_sr3_vdd_sr4_vdd_sv_d_vdd_tie_sv_vdd_tg_d_a_tg_d_vdd_tg_fbm_vdd_tg_fbs_vdd_tg_s_vdd_vdd_vdd_b1_vdd_b2_vdd_b3_vdd_b4_vdd_link_vdd_link_dip_vdd_x1_vdd_x2_vdd_x3_t105 r0 *1 0,0
Ra_d_inv_clk_vdd_inv_mc_vdd_inv_q_vdd_mpa_py_mpb_py_nand_m_vdd_nand_s2_vdd_nwell_vdd_sb_vdd_sr1_vdd_sr2_vdd_sr3_vdd_sr4_vdd_sv_d_vdd_tie_sv_vdd_tg_d_a_tg_d_vdd_tg_fbm_vdd_tg_fbs_vdd_tg_s_vdd_vdd_vdd_b1_vdd_b2_vdd_b3_vdd_b4_vdd_link_vdd_link_dip_vdd_x1_vdd_x2_vdd_x3_t105
+ a|d|inv_clk_vdd|inv_mc_vdd|inv_q_vdd|mpa_py|mpb_py|nand_m_vdd|nand_s2_vdd|nwell_vdd|sb_vdd|sr1_vdd|sr2_vdd|sr3_vdd|sr4_vdd|sv_d_vdd_tie|sv_vdd|tg_d_a|tg_d_vdd|tg_fbm_vdd|tg_fbs_vdd|tg_s_vdd|vdd|vdd_b1|vdd_b2|vdd_b3|vdd_b4|vdd_link|vdd_link_dip|vdd_x1|vdd_x2|vdd_x3__t105
+ a|d|inv_clk_vdd|inv_mc_vdd|inv_q_vdd|mpa_py|mpb_py|nand_m_vdd|nand_s2_vdd|nwell_vdd|sb_vdd|sr1_vdd|sr2_vdd|sr3_vdd|sr4_vdd|sv_d_vdd_tie|sv_vdd|tg_d_a|tg_d_vdd|tg_fbm_vdd|tg_fbs_vdd|tg_s_vdd|vdd|vdd_b1|vdd_b2|vdd_b3|vdd_b4|vdd_link|vdd_link_dip|vdd_x1|vdd_x2|vdd_x3
+ 101.092545773
* device instance a_d_inv_clk_vdd_inv_mc_vdd_inv_q_vdd_mpa_py_mpb_py_nand_m_vdd_nand_s2_vdd_nwell_vdd_sb_vdd_sr1_vdd_sr2_vdd_sr3_vdd_sr4_vdd_sv_d_vdd_tie_sv_vdd_tg_d_a_tg_d_vdd_tg_fbm_vdd_tg_fbs_vdd_tg_s_vdd_vdd_vdd_b1_vdd_b2_vdd_b3_vdd_b4_vdd_link_vdd_link_dip_vdd_x1_vdd_x2_vdd_x3_t106 r0 *1 0,0
Ra_d_inv_clk_vdd_inv_mc_vdd_inv_q_vdd_mpa_py_mpb_py_nand_m_vdd_nand_s2_vdd_nwell_vdd_sb_vdd_sr1_vdd_sr2_vdd_sr3_vdd_sr4_vdd_sv_d_vdd_tie_sv_vdd_tg_d_a_tg_d_vdd_tg_fbm_vdd_tg_fbs_vdd_tg_s_vdd_vdd_vdd_b1_vdd_b2_vdd_b3_vdd_b4_vdd_link_vdd_link_dip_vdd_x1_vdd_x2_vdd_x3_t106
+ a|d|inv_clk_vdd|inv_mc_vdd|inv_q_vdd|mpa_py|mpb_py|nand_m_vdd|nand_s2_vdd|nwell_vdd|sb_vdd|sr1_vdd|sr2_vdd|sr3_vdd|sr4_vdd|sv_d_vdd_tie|sv_vdd|tg_d_a|tg_d_vdd|tg_fbm_vdd|tg_fbs_vdd|tg_s_vdd|vdd|vdd_b1|vdd_b2|vdd_b3|vdd_b4|vdd_link|vdd_link_dip|vdd_x1|vdd_x2|vdd_x3__t106
+ a|d|inv_clk_vdd|inv_mc_vdd|inv_q_vdd|mpa_py|mpb_py|nand_m_vdd|nand_s2_vdd|nwell_vdd|sb_vdd|sr1_vdd|sr2_vdd|sr3_vdd|sr4_vdd|sv_d_vdd_tie|sv_vdd|tg_d_a|tg_d_vdd|tg_fbm_vdd|tg_fbs_vdd|tg_s_vdd|vdd|vdd_b1|vdd_b2|vdd_b3|vdd_b4|vdd_link|vdd_link_dip|vdd_x1|vdd_x2|vdd_x3
+ 99.2174046262
* device instance a_d_inv_clk_vdd_inv_mc_vdd_inv_q_vdd_mpa_py_mpb_py_nand_m_vdd_nand_s2_vdd_nwell_vdd_sb_vdd_sr1_vdd_sr2_vdd_sr3_vdd_sr4_vdd_sv_d_vdd_tie_sv_vdd_tg_d_a_tg_d_vdd_tg_fbm_vdd_tg_fbs_vdd_tg_s_vdd_vdd_vdd_b1_vdd_b2_vdd_b3_vdd_b4_vdd_link_vdd_link_dip_vdd_x1_vdd_x2_vdd_x3_t107 r0 *1 0,0
Ra_d_inv_clk_vdd_inv_mc_vdd_inv_q_vdd_mpa_py_mpb_py_nand_m_vdd_nand_s2_vdd_nwell_vdd_sb_vdd_sr1_vdd_sr2_vdd_sr3_vdd_sr4_vdd_sv_d_vdd_tie_sv_vdd_tg_d_a_tg_d_vdd_tg_fbm_vdd_tg_fbs_vdd_tg_s_vdd_vdd_vdd_b1_vdd_b2_vdd_b3_vdd_b4_vdd_link_vdd_link_dip_vdd_x1_vdd_x2_vdd_x3_t107
+ a|d|inv_clk_vdd|inv_mc_vdd|inv_q_vdd|mpa_py|mpb_py|nand_m_vdd|nand_s2_vdd|nwell_vdd|sb_vdd|sr1_vdd|sr2_vdd|sr3_vdd|sr4_vdd|sv_d_vdd_tie|sv_vdd|tg_d_a|tg_d_vdd|tg_fbm_vdd|tg_fbs_vdd|tg_s_vdd|vdd|vdd_b1|vdd_b2|vdd_b3|vdd_b4|vdd_link|vdd_link_dip|vdd_x1|vdd_x2|vdd_x3__t107
+ a|d|inv_clk_vdd|inv_mc_vdd|inv_q_vdd|mpa_py|mpb_py|nand_m_vdd|nand_s2_vdd|nwell_vdd|sb_vdd|sr1_vdd|sr2_vdd|sr3_vdd|sr4_vdd|sv_d_vdd_tie|sv_vdd|tg_d_a|tg_d_vdd|tg_fbm_vdd|tg_fbs_vdd|tg_s_vdd|vdd|vdd_b1|vdd_b2|vdd_b3|vdd_b4|vdd_link|vdd_link_dip|vdd_x1|vdd_x2|vdd_x3
+ 55.5404096195
* device instance a_d_inv_clk_vdd_inv_mc_vdd_inv_q_vdd_mpa_py_mpb_py_nand_m_vdd_nand_s2_vdd_nwell_vdd_sb_vdd_sr1_vdd_sr2_vdd_sr3_vdd_sr4_vdd_sv_d_vdd_tie_sv_vdd_tg_d_a_tg_d_vdd_tg_fbm_vdd_tg_fbs_vdd_tg_s_vdd_vdd_vdd_b1_vdd_b2_vdd_b3_vdd_b4_vdd_link_vdd_link_dip_vdd_x1_vdd_x2_vdd_x3_t108 r0 *1 0,0
Ra_d_inv_clk_vdd_inv_mc_vdd_inv_q_vdd_mpa_py_mpb_py_nand_m_vdd_nand_s2_vdd_nwell_vdd_sb_vdd_sr1_vdd_sr2_vdd_sr3_vdd_sr4_vdd_sv_d_vdd_tie_sv_vdd_tg_d_a_tg_d_vdd_tg_fbm_vdd_tg_fbs_vdd_tg_s_vdd_vdd_vdd_b1_vdd_b2_vdd_b3_vdd_b4_vdd_link_vdd_link_dip_vdd_x1_vdd_x2_vdd_x3_t108
+ a|d|inv_clk_vdd|inv_mc_vdd|inv_q_vdd|mpa_py|mpb_py|nand_m_vdd|nand_s2_vdd|nwell_vdd|sb_vdd|sr1_vdd|sr2_vdd|sr3_vdd|sr4_vdd|sv_d_vdd_tie|sv_vdd|tg_d_a|tg_d_vdd|tg_fbm_vdd|tg_fbs_vdd|tg_s_vdd|vdd|vdd_b1|vdd_b2|vdd_b3|vdd_b4|vdd_link|vdd_link_dip|vdd_x1|vdd_x2|vdd_x3__t108
+ a|d|inv_clk_vdd|inv_mc_vdd|inv_q_vdd|mpa_py|mpb_py|nand_m_vdd|nand_s2_vdd|nwell_vdd|sb_vdd|sr1_vdd|sr2_vdd|sr3_vdd|sr4_vdd|sv_d_vdd_tie|sv_vdd|tg_d_a|tg_d_vdd|tg_fbm_vdd|tg_fbs_vdd|tg_s_vdd|vdd|vdd_b1|vdd_b2|vdd_b3|vdd_b4|vdd_link|vdd_link_dip|vdd_x1|vdd_x2|vdd_x3
+ 90.5774194264
* device instance a_d_inv_clk_vdd_inv_mc_vdd_inv_q_vdd_mpa_py_mpb_py_nand_m_vdd_nand_s2_vdd_nwell_vdd_sb_vdd_sr1_vdd_sr2_vdd_sr3_vdd_sr4_vdd_sv_d_vdd_tie_sv_vdd_tg_d_a_tg_d_vdd_tg_fbm_vdd_tg_fbs_vdd_tg_s_vdd_vdd_vdd_b1_vdd_b2_vdd_b3_vdd_b4_vdd_link_vdd_link_dip_vdd_x1_vdd_x2_vdd_x3_t109 r0 *1 0,0
Ra_d_inv_clk_vdd_inv_mc_vdd_inv_q_vdd_mpa_py_mpb_py_nand_m_vdd_nand_s2_vdd_nwell_vdd_sb_vdd_sr1_vdd_sr2_vdd_sr3_vdd_sr4_vdd_sv_d_vdd_tie_sv_vdd_tg_d_a_tg_d_vdd_tg_fbm_vdd_tg_fbs_vdd_tg_s_vdd_vdd_vdd_b1_vdd_b2_vdd_b3_vdd_b4_vdd_link_vdd_link_dip_vdd_x1_vdd_x2_vdd_x3_t109
+ a|d|inv_clk_vdd|inv_mc_vdd|inv_q_vdd|mpa_py|mpb_py|nand_m_vdd|nand_s2_vdd|nwell_vdd|sb_vdd|sr1_vdd|sr2_vdd|sr3_vdd|sr4_vdd|sv_d_vdd_tie|sv_vdd|tg_d_a|tg_d_vdd|tg_fbm_vdd|tg_fbs_vdd|tg_s_vdd|vdd|vdd_b1|vdd_b2|vdd_b3|vdd_b4|vdd_link|vdd_link_dip|vdd_x1|vdd_x2|vdd_x3__t109
+ a|d|inv_clk_vdd|inv_mc_vdd|inv_q_vdd|mpa_py|mpb_py|nand_m_vdd|nand_s2_vdd|nwell_vdd|sb_vdd|sr1_vdd|sr2_vdd|sr3_vdd|sr4_vdd|sv_d_vdd_tie|sv_vdd|tg_d_a|tg_d_vdd|tg_fbm_vdd|tg_fbs_vdd|tg_s_vdd|vdd|vdd_b1|vdd_b2|vdd_b3|vdd_b4|vdd_link|vdd_link_dip|vdd_x1|vdd_x2|vdd_x3
+ 210.446064443
* device instance a_d_inv_clk_vdd_inv_mc_vdd_inv_q_vdd_mpa_py_mpb_py_nand_m_vdd_nand_s2_vdd_nwell_vdd_sb_vdd_sr1_vdd_sr2_vdd_sr3_vdd_sr4_vdd_sv_d_vdd_tie_sv_vdd_tg_d_a_tg_d_vdd_tg_fbm_vdd_tg_fbs_vdd_tg_s_vdd_vdd_vdd_b1_vdd_b2_vdd_b3_vdd_b4_vdd_link_vdd_link_dip_vdd_x1_vdd_x2_vdd_x3_t110 r0 *1 0,0
Ra_d_inv_clk_vdd_inv_mc_vdd_inv_q_vdd_mpa_py_mpb_py_nand_m_vdd_nand_s2_vdd_nwell_vdd_sb_vdd_sr1_vdd_sr2_vdd_sr3_vdd_sr4_vdd_sv_d_vdd_tie_sv_vdd_tg_d_a_tg_d_vdd_tg_fbm_vdd_tg_fbs_vdd_tg_s_vdd_vdd_vdd_b1_vdd_b2_vdd_b3_vdd_b4_vdd_link_vdd_link_dip_vdd_x1_vdd_x2_vdd_x3_t110
+ a|d|inv_clk_vdd|inv_mc_vdd|inv_q_vdd|mpa_py|mpb_py|nand_m_vdd|nand_s2_vdd|nwell_vdd|sb_vdd|sr1_vdd|sr2_vdd|sr3_vdd|sr4_vdd|sv_d_vdd_tie|sv_vdd|tg_d_a|tg_d_vdd|tg_fbm_vdd|tg_fbs_vdd|tg_s_vdd|vdd|vdd_b1|vdd_b2|vdd_b3|vdd_b4|vdd_link|vdd_link_dip|vdd_x1|vdd_x2|vdd_x3__t110
+ a|d|inv_clk_vdd|inv_mc_vdd|inv_q_vdd|mpa_py|mpb_py|nand_m_vdd|nand_s2_vdd|nwell_vdd|sb_vdd|sr1_vdd|sr2_vdd|sr3_vdd|sr4_vdd|sv_d_vdd_tie|sv_vdd|tg_d_a|tg_d_vdd|tg_fbm_vdd|tg_fbs_vdd|tg_s_vdd|vdd|vdd_b1|vdd_b2|vdd_b3|vdd_b4|vdd_link|vdd_link_dip|vdd_x1|vdd_x2|vdd_x3
+ 173.908613154
* device instance a_d_inv_clk_vdd_inv_mc_vdd_inv_q_vdd_mpa_py_mpb_py_nand_m_vdd_nand_s2_vdd_nwell_vdd_sb_vdd_sr1_vdd_sr2_vdd_sr3_vdd_sr4_vdd_sv_d_vdd_tie_sv_vdd_tg_d_a_tg_d_vdd_tg_fbm_vdd_tg_fbs_vdd_tg_s_vdd_vdd_vdd_b1_vdd_b2_vdd_b3_vdd_b4_vdd_link_vdd_link_dip_vdd_x1_vdd_x2_vdd_x3_t111 r0 *1 0,0
Ra_d_inv_clk_vdd_inv_mc_vdd_inv_q_vdd_mpa_py_mpb_py_nand_m_vdd_nand_s2_vdd_nwell_vdd_sb_vdd_sr1_vdd_sr2_vdd_sr3_vdd_sr4_vdd_sv_d_vdd_tie_sv_vdd_tg_d_a_tg_d_vdd_tg_fbm_vdd_tg_fbs_vdd_tg_s_vdd_vdd_vdd_b1_vdd_b2_vdd_b3_vdd_b4_vdd_link_vdd_link_dip_vdd_x1_vdd_x2_vdd_x3_t111
+ a|d|inv_clk_vdd|inv_mc_vdd|inv_q_vdd|mpa_py|mpb_py|nand_m_vdd|nand_s2_vdd|nwell_vdd|sb_vdd|sr1_vdd|sr2_vdd|sr3_vdd|sr4_vdd|sv_d_vdd_tie|sv_vdd|tg_d_a|tg_d_vdd|tg_fbm_vdd|tg_fbs_vdd|tg_s_vdd|vdd|vdd_b1|vdd_b2|vdd_b3|vdd_b4|vdd_link|vdd_link_dip|vdd_x1|vdd_x2|vdd_x3__t111
+ a|d|inv_clk_vdd|inv_mc_vdd|inv_q_vdd|mpa_py|mpb_py|nand_m_vdd|nand_s2_vdd|nwell_vdd|sb_vdd|sr1_vdd|sr2_vdd|sr3_vdd|sr4_vdd|sv_d_vdd_tie|sv_vdd|tg_d_a|tg_d_vdd|tg_fbm_vdd|tg_fbs_vdd|tg_s_vdd|vdd|vdd_b1|vdd_b2|vdd_b3|vdd_b4|vdd_link|vdd_link_dip|vdd_x1|vdd_x2|vdd_x3
+ 158.660523292
* device instance a_d_inv_clk_vdd_inv_mc_vdd_inv_q_vdd_mpa_py_mpb_py_nand_m_vdd_nand_s2_vdd_nwell_vdd_sb_vdd_sr1_vdd_sr2_vdd_sr3_vdd_sr4_vdd_sv_d_vdd_tie_sv_vdd_tg_d_a_tg_d_vdd_tg_fbm_vdd_tg_fbs_vdd_tg_s_vdd_vdd_vdd_b1_vdd_b2_vdd_b3_vdd_b4_vdd_link_vdd_link_dip_vdd_x1_vdd_x2_vdd_x3_t112 r0 *1 0,0
Ra_d_inv_clk_vdd_inv_mc_vdd_inv_q_vdd_mpa_py_mpb_py_nand_m_vdd_nand_s2_vdd_nwell_vdd_sb_vdd_sr1_vdd_sr2_vdd_sr3_vdd_sr4_vdd_sv_d_vdd_tie_sv_vdd_tg_d_a_tg_d_vdd_tg_fbm_vdd_tg_fbs_vdd_tg_s_vdd_vdd_vdd_b1_vdd_b2_vdd_b3_vdd_b4_vdd_link_vdd_link_dip_vdd_x1_vdd_x2_vdd_x3_t112
+ a|d|inv_clk_vdd|inv_mc_vdd|inv_q_vdd|mpa_py|mpb_py|nand_m_vdd|nand_s2_vdd|nwell_vdd|sb_vdd|sr1_vdd|sr2_vdd|sr3_vdd|sr4_vdd|sv_d_vdd_tie|sv_vdd|tg_d_a|tg_d_vdd|tg_fbm_vdd|tg_fbs_vdd|tg_s_vdd|vdd|vdd_b1|vdd_b2|vdd_b3|vdd_b4|vdd_link|vdd_link_dip|vdd_x1|vdd_x2|vdd_x3__t112
+ a|d|inv_clk_vdd|inv_mc_vdd|inv_q_vdd|mpa_py|mpb_py|nand_m_vdd|nand_s2_vdd|nwell_vdd|sb_vdd|sr1_vdd|sr2_vdd|sr3_vdd|sr4_vdd|sv_d_vdd_tie|sv_vdd|tg_d_a|tg_d_vdd|tg_fbm_vdd|tg_fbs_vdd|tg_s_vdd|vdd|vdd_b1|vdd_b2|vdd_b3|vdd_b4|vdd_link|vdd_link_dip|vdd_x1|vdd_x2|vdd_x3
+ 50.5462818726
* device instance a_d_inv_clk_vdd_inv_mc_vdd_inv_q_vdd_mpa_py_mpb_py_nand_m_vdd_nand_s2_vdd_nwell_vdd_sb_vdd_sr1_vdd_sr2_vdd_sr3_vdd_sr4_vdd_sv_d_vdd_tie_sv_vdd_tg_d_a_tg_d_vdd_tg_fbm_vdd_tg_fbs_vdd_tg_s_vdd_vdd_vdd_b1_vdd_b2_vdd_b3_vdd_b4_vdd_link_vdd_link_dip_vdd_x1_vdd_x2_vdd_x3_t113 r0 *1 0,0
Ra_d_inv_clk_vdd_inv_mc_vdd_inv_q_vdd_mpa_py_mpb_py_nand_m_vdd_nand_s2_vdd_nwell_vdd_sb_vdd_sr1_vdd_sr2_vdd_sr3_vdd_sr4_vdd_sv_d_vdd_tie_sv_vdd_tg_d_a_tg_d_vdd_tg_fbm_vdd_tg_fbs_vdd_tg_s_vdd_vdd_vdd_b1_vdd_b2_vdd_b3_vdd_b4_vdd_link_vdd_link_dip_vdd_x1_vdd_x2_vdd_x3_t113
+ a|d|inv_clk_vdd|inv_mc_vdd|inv_q_vdd|mpa_py|mpb_py|nand_m_vdd|nand_s2_vdd|nwell_vdd|sb_vdd|sr1_vdd|sr2_vdd|sr3_vdd|sr4_vdd|sv_d_vdd_tie|sv_vdd|tg_d_a|tg_d_vdd|tg_fbm_vdd|tg_fbs_vdd|tg_s_vdd|vdd|vdd_b1|vdd_b2|vdd_b3|vdd_b4|vdd_link|vdd_link_dip|vdd_x1|vdd_x2|vdd_x3__t113
+ a|d|inv_clk_vdd|inv_mc_vdd|inv_q_vdd|mpa_py|mpb_py|nand_m_vdd|nand_s2_vdd|nwell_vdd|sb_vdd|sr1_vdd|sr2_vdd|sr3_vdd|sr4_vdd|sv_d_vdd_tie|sv_vdd|tg_d_a|tg_d_vdd|tg_fbm_vdd|tg_fbs_vdd|tg_s_vdd|vdd|vdd_b1|vdd_b2|vdd_b3|vdd_b4|vdd_link|vdd_link_dip|vdd_x1|vdd_x2|vdd_x3
+ 133.307481456
* device instance a_d_inv_clk_vdd_inv_mc_vdd_inv_q_vdd_mpa_py_mpb_py_nand_m_vdd_nand_s2_vdd_nwell_vdd_sb_vdd_sr1_vdd_sr2_vdd_sr3_vdd_sr4_vdd_sv_d_vdd_tie_sv_vdd_tg_d_a_tg_d_vdd_tg_fbm_vdd_tg_fbs_vdd_tg_s_vdd_vdd_vdd_b1_vdd_b2_vdd_b3_vdd_b4_vdd_link_vdd_link_dip_vdd_x1_vdd_x2_vdd_x3_t114 r0 *1 0,0
Ra_d_inv_clk_vdd_inv_mc_vdd_inv_q_vdd_mpa_py_mpb_py_nand_m_vdd_nand_s2_vdd_nwell_vdd_sb_vdd_sr1_vdd_sr2_vdd_sr3_vdd_sr4_vdd_sv_d_vdd_tie_sv_vdd_tg_d_a_tg_d_vdd_tg_fbm_vdd_tg_fbs_vdd_tg_s_vdd_vdd_vdd_b1_vdd_b2_vdd_b3_vdd_b4_vdd_link_vdd_link_dip_vdd_x1_vdd_x2_vdd_x3_t114
+ a|d|inv_clk_vdd|inv_mc_vdd|inv_q_vdd|mpa_py|mpb_py|nand_m_vdd|nand_s2_vdd|nwell_vdd|sb_vdd|sr1_vdd|sr2_vdd|sr3_vdd|sr4_vdd|sv_d_vdd_tie|sv_vdd|tg_d_a|tg_d_vdd|tg_fbm_vdd|tg_fbs_vdd|tg_s_vdd|vdd|vdd_b1|vdd_b2|vdd_b3|vdd_b4|vdd_link|vdd_link_dip|vdd_x1|vdd_x2|vdd_x3__t114
+ a|d|inv_clk_vdd|inv_mc_vdd|inv_q_vdd|mpa_py|mpb_py|nand_m_vdd|nand_s2_vdd|nwell_vdd|sb_vdd|sr1_vdd|sr2_vdd|sr3_vdd|sr4_vdd|sv_d_vdd_tie|sv_vdd|tg_d_a|tg_d_vdd|tg_fbm_vdd|tg_fbs_vdd|tg_s_vdd|vdd|vdd_b1|vdd_b2|vdd_b3|vdd_b4|vdd_link|vdd_link_dip|vdd_x1|vdd_x2|vdd_x3
+ 118.527622922
* device instance a_d_inv_clk_vdd_inv_mc_vdd_inv_q_vdd_mpa_py_mpb_py_nand_m_vdd_nand_s2_vdd_nwell_vdd_sb_vdd_sr1_vdd_sr2_vdd_sr3_vdd_sr4_vdd_sv_d_vdd_tie_sv_vdd_tg_d_a_tg_d_vdd_tg_fbm_vdd_tg_fbs_vdd_tg_s_vdd_vdd_vdd_b1_vdd_b2_vdd_b3_vdd_b4_vdd_link_vdd_link_dip_vdd_x1_vdd_x2_vdd_x3_t115 r0 *1 0,0
Ra_d_inv_clk_vdd_inv_mc_vdd_inv_q_vdd_mpa_py_mpb_py_nand_m_vdd_nand_s2_vdd_nwell_vdd_sb_vdd_sr1_vdd_sr2_vdd_sr3_vdd_sr4_vdd_sv_d_vdd_tie_sv_vdd_tg_d_a_tg_d_vdd_tg_fbm_vdd_tg_fbs_vdd_tg_s_vdd_vdd_vdd_b1_vdd_b2_vdd_b3_vdd_b4_vdd_link_vdd_link_dip_vdd_x1_vdd_x2_vdd_x3_t115
+ a|d|inv_clk_vdd|inv_mc_vdd|inv_q_vdd|mpa_py|mpb_py|nand_m_vdd|nand_s2_vdd|nwell_vdd|sb_vdd|sr1_vdd|sr2_vdd|sr3_vdd|sr4_vdd|sv_d_vdd_tie|sv_vdd|tg_d_a|tg_d_vdd|tg_fbm_vdd|tg_fbs_vdd|tg_s_vdd|vdd|vdd_b1|vdd_b2|vdd_b3|vdd_b4|vdd_link|vdd_link_dip|vdd_x1|vdd_x2|vdd_x3__t115
+ a|d|inv_clk_vdd|inv_mc_vdd|inv_q_vdd|mpa_py|mpb_py|nand_m_vdd|nand_s2_vdd|nwell_vdd|sb_vdd|sr1_vdd|sr2_vdd|sr3_vdd|sr4_vdd|sv_d_vdd_tie|sv_vdd|tg_d_a|tg_d_vdd|tg_fbm_vdd|tg_fbs_vdd|tg_s_vdd|vdd|vdd_b1|vdd_b2|vdd_b3|vdd_b4|vdd_link|vdd_link_dip|vdd_x1|vdd_x2|vdd_x3
+ 263.20408715
* device instance a_d_inv_clk_vdd_inv_mc_vdd_inv_q_vdd_mpa_py_mpb_py_nand_m_vdd_nand_s2_vdd_nwell_vdd_sb_vdd_sr1_vdd_sr2_vdd_sr3_vdd_sr4_vdd_sv_d_vdd_tie_sv_vdd_tg_d_a_tg_d_vdd_tg_fbm_vdd_tg_fbs_vdd_tg_s_vdd_vdd_vdd_b1_vdd_b2_vdd_b3_vdd_b4_vdd_link_vdd_link_dip_vdd_x1_vdd_x2_vdd_x3_t116 r0 *1 0,0
Ra_d_inv_clk_vdd_inv_mc_vdd_inv_q_vdd_mpa_py_mpb_py_nand_m_vdd_nand_s2_vdd_nwell_vdd_sb_vdd_sr1_vdd_sr2_vdd_sr3_vdd_sr4_vdd_sv_d_vdd_tie_sv_vdd_tg_d_a_tg_d_vdd_tg_fbm_vdd_tg_fbs_vdd_tg_s_vdd_vdd_vdd_b1_vdd_b2_vdd_b3_vdd_b4_vdd_link_vdd_link_dip_vdd_x1_vdd_x2_vdd_x3_t116
+ a|d|inv_clk_vdd|inv_mc_vdd|inv_q_vdd|mpa_py|mpb_py|nand_m_vdd|nand_s2_vdd|nwell_vdd|sb_vdd|sr1_vdd|sr2_vdd|sr3_vdd|sr4_vdd|sv_d_vdd_tie|sv_vdd|tg_d_a|tg_d_vdd|tg_fbm_vdd|tg_fbs_vdd|tg_s_vdd|vdd|vdd_b1|vdd_b2|vdd_b3|vdd_b4|vdd_link|vdd_link_dip|vdd_x1|vdd_x2|vdd_x3__t116
+ a|d|inv_clk_vdd|inv_mc_vdd|inv_q_vdd|mpa_py|mpb_py|nand_m_vdd|nand_s2_vdd|nwell_vdd|sb_vdd|sr1_vdd|sr2_vdd|sr3_vdd|sr4_vdd|sv_d_vdd_tie|sv_vdd|tg_d_a|tg_d_vdd|tg_fbm_vdd|tg_fbs_vdd|tg_s_vdd|vdd|vdd_b1|vdd_b2|vdd_b3|vdd_b4|vdd_link|vdd_link_dip|vdd_x1|vdd_x2|vdd_x3
+ 64.9885343757
* device instance a_d_inv_clk_vdd_inv_mc_vdd_inv_q_vdd_mpa_py_mpb_py_nand_m_vdd_nand_s2_vdd_nwell_vdd_sb_vdd_sr1_vdd_sr2_vdd_sr3_vdd_sr4_vdd_sv_d_vdd_tie_sv_vdd_tg_d_a_tg_d_vdd_tg_fbm_vdd_tg_fbs_vdd_tg_s_vdd_vdd_vdd_b1_vdd_b2_vdd_b3_vdd_b4_vdd_link_vdd_link_dip_vdd_x1_vdd_x2_vdd_x3_t117 r0 *1 0,0
Ra_d_inv_clk_vdd_inv_mc_vdd_inv_q_vdd_mpa_py_mpb_py_nand_m_vdd_nand_s2_vdd_nwell_vdd_sb_vdd_sr1_vdd_sr2_vdd_sr3_vdd_sr4_vdd_sv_d_vdd_tie_sv_vdd_tg_d_a_tg_d_vdd_tg_fbm_vdd_tg_fbs_vdd_tg_s_vdd_vdd_vdd_b1_vdd_b2_vdd_b3_vdd_b4_vdd_link_vdd_link_dip_vdd_x1_vdd_x2_vdd_x3_t117
+ a|d|inv_clk_vdd|inv_mc_vdd|inv_q_vdd|mpa_py|mpb_py|nand_m_vdd|nand_s2_vdd|nwell_vdd|sb_vdd|sr1_vdd|sr2_vdd|sr3_vdd|sr4_vdd|sv_d_vdd_tie|sv_vdd|tg_d_a|tg_d_vdd|tg_fbm_vdd|tg_fbs_vdd|tg_s_vdd|vdd|vdd_b1|vdd_b2|vdd_b3|vdd_b4|vdd_link|vdd_link_dip|vdd_x1|vdd_x2|vdd_x3__t117
+ a|d|inv_clk_vdd|inv_mc_vdd|inv_q_vdd|mpa_py|mpb_py|nand_m_vdd|nand_s2_vdd|nwell_vdd|sb_vdd|sr1_vdd|sr2_vdd|sr3_vdd|sr4_vdd|sv_d_vdd_tie|sv_vdd|tg_d_a|tg_d_vdd|tg_fbm_vdd|tg_fbs_vdd|tg_s_vdd|vdd|vdd_b1|vdd_b2|vdd_b3|vdd_b4|vdd_link|vdd_link_dip|vdd_x1|vdd_x2|vdd_x3
+ 39.6730583799
* device instance a_d_inv_clk_vdd_inv_mc_vdd_inv_q_vdd_mpa_py_mpb_py_nand_m_vdd_nand_s2_vdd_nwell_vdd_sb_vdd_sr1_vdd_sr2_vdd_sr3_vdd_sr4_vdd_sv_d_vdd_tie_sv_vdd_tg_d_a_tg_d_vdd_tg_fbm_vdd_tg_fbs_vdd_tg_s_vdd_vdd_vdd_b1_vdd_b2_vdd_b3_vdd_b4_vdd_link_vdd_link_dip_vdd_x1_vdd_x2_vdd_x3_t118 r0 *1 0,0
Ra_d_inv_clk_vdd_inv_mc_vdd_inv_q_vdd_mpa_py_mpb_py_nand_m_vdd_nand_s2_vdd_nwell_vdd_sb_vdd_sr1_vdd_sr2_vdd_sr3_vdd_sr4_vdd_sv_d_vdd_tie_sv_vdd_tg_d_a_tg_d_vdd_tg_fbm_vdd_tg_fbs_vdd_tg_s_vdd_vdd_vdd_b1_vdd_b2_vdd_b3_vdd_b4_vdd_link_vdd_link_dip_vdd_x1_vdd_x2_vdd_x3_t118
+ a|d|inv_clk_vdd|inv_mc_vdd|inv_q_vdd|mpa_py|mpb_py|nand_m_vdd|nand_s2_vdd|nwell_vdd|sb_vdd|sr1_vdd|sr2_vdd|sr3_vdd|sr4_vdd|sv_d_vdd_tie|sv_vdd|tg_d_a|tg_d_vdd|tg_fbm_vdd|tg_fbs_vdd|tg_s_vdd|vdd|vdd_b1|vdd_b2|vdd_b3|vdd_b4|vdd_link|vdd_link_dip|vdd_x1|vdd_x2|vdd_x3__t118
+ a|d|inv_clk_vdd|inv_mc_vdd|inv_q_vdd|mpa_py|mpb_py|nand_m_vdd|nand_s2_vdd|nwell_vdd|sb_vdd|sr1_vdd|sr2_vdd|sr3_vdd|sr4_vdd|sv_d_vdd_tie|sv_vdd|tg_d_a|tg_d_vdd|tg_fbm_vdd|tg_fbs_vdd|tg_s_vdd|vdd|vdd_b1|vdd_b2|vdd_b3|vdd_b4|vdd_link|vdd_link_dip|vdd_x1|vdd_x2|vdd_x3
+ 94.4335287718
* device instance a_d_inv_clk_vdd_inv_mc_vdd_inv_q_vdd_mpa_py_mpb_py_nand_m_vdd_nand_s2_vdd_nwell_vdd_sb_vdd_sr1_vdd_sr2_vdd_sr3_vdd_sr4_vdd_sv_d_vdd_tie_sv_vdd_tg_d_a_tg_d_vdd_tg_fbm_vdd_tg_fbs_vdd_tg_s_vdd_vdd_vdd_b1_vdd_b2_vdd_b3_vdd_b4_vdd_link_vdd_link_dip_vdd_x1_vdd_x2_vdd_x3_t119 r0 *1 0,0
Ra_d_inv_clk_vdd_inv_mc_vdd_inv_q_vdd_mpa_py_mpb_py_nand_m_vdd_nand_s2_vdd_nwell_vdd_sb_vdd_sr1_vdd_sr2_vdd_sr3_vdd_sr4_vdd_sv_d_vdd_tie_sv_vdd_tg_d_a_tg_d_vdd_tg_fbm_vdd_tg_fbs_vdd_tg_s_vdd_vdd_vdd_b1_vdd_b2_vdd_b3_vdd_b4_vdd_link_vdd_link_dip_vdd_x1_vdd_x2_vdd_x3_t119
+ a|d|inv_clk_vdd|inv_mc_vdd|inv_q_vdd|mpa_py|mpb_py|nand_m_vdd|nand_s2_vdd|nwell_vdd|sb_vdd|sr1_vdd|sr2_vdd|sr3_vdd|sr4_vdd|sv_d_vdd_tie|sv_vdd|tg_d_a|tg_d_vdd|tg_fbm_vdd|tg_fbs_vdd|tg_s_vdd|vdd|vdd_b1|vdd_b2|vdd_b3|vdd_b4|vdd_link|vdd_link_dip|vdd_x1|vdd_x2|vdd_x3__t119
+ a|d|inv_clk_vdd|inv_mc_vdd|inv_q_vdd|mpa_py|mpb_py|nand_m_vdd|nand_s2_vdd|nwell_vdd|sb_vdd|sr1_vdd|sr2_vdd|sr3_vdd|sr4_vdd|sv_d_vdd_tie|sv_vdd|tg_d_a|tg_d_vdd|tg_fbm_vdd|tg_fbs_vdd|tg_s_vdd|vdd|vdd_b1|vdd_b2|vdd_b3|vdd_b4|vdd_link|vdd_link_dip|vdd_x1|vdd_x2|vdd_x3
+ 238.709465789
* device instance a_d_inv_clk_vdd_inv_mc_vdd_inv_q_vdd_mpa_py_mpb_py_nand_m_vdd_nand_s2_vdd_nwell_vdd_sb_vdd_sr1_vdd_sr2_vdd_sr3_vdd_sr4_vdd_sv_d_vdd_tie_sv_vdd_tg_d_a_tg_d_vdd_tg_fbm_vdd_tg_fbs_vdd_tg_s_vdd_vdd_vdd_b1_vdd_b2_vdd_b3_vdd_b4_vdd_link_vdd_link_dip_vdd_x1_vdd_x2_vdd_x3_t120 r0 *1 0,0
Ra_d_inv_clk_vdd_inv_mc_vdd_inv_q_vdd_mpa_py_mpb_py_nand_m_vdd_nand_s2_vdd_nwell_vdd_sb_vdd_sr1_vdd_sr2_vdd_sr3_vdd_sr4_vdd_sv_d_vdd_tie_sv_vdd_tg_d_a_tg_d_vdd_tg_fbm_vdd_tg_fbs_vdd_tg_s_vdd_vdd_vdd_b1_vdd_b2_vdd_b3_vdd_b4_vdd_link_vdd_link_dip_vdd_x1_vdd_x2_vdd_x3_t120
+ a|d|inv_clk_vdd|inv_mc_vdd|inv_q_vdd|mpa_py|mpb_py|nand_m_vdd|nand_s2_vdd|nwell_vdd|sb_vdd|sr1_vdd|sr2_vdd|sr3_vdd|sr4_vdd|sv_d_vdd_tie|sv_vdd|tg_d_a|tg_d_vdd|tg_fbm_vdd|tg_fbs_vdd|tg_s_vdd|vdd|vdd_b1|vdd_b2|vdd_b3|vdd_b4|vdd_link|vdd_link_dip|vdd_x1|vdd_x2|vdd_x3__t120
+ a|d|inv_clk_vdd|inv_mc_vdd|inv_q_vdd|mpa_py|mpb_py|nand_m_vdd|nand_s2_vdd|nwell_vdd|sb_vdd|sr1_vdd|sr2_vdd|sr3_vdd|sr4_vdd|sv_d_vdd_tie|sv_vdd|tg_d_a|tg_d_vdd|tg_fbm_vdd|tg_fbs_vdd|tg_s_vdd|vdd|vdd_b1|vdd_b2|vdd_b3|vdd_b4|vdd_link|vdd_link_dip|vdd_x1|vdd_x2|vdd_x3
+ 272.579318667
* device instance a_d_inv_clk_vdd_inv_mc_vdd_inv_q_vdd_mpa_py_mpb_py_nand_m_vdd_nand_s2_vdd_nwell_vdd_sb_vdd_sr1_vdd_sr2_vdd_sr3_vdd_sr4_vdd_sv_d_vdd_tie_sv_vdd_tg_d_a_tg_d_vdd_tg_fbm_vdd_tg_fbs_vdd_tg_s_vdd_vdd_vdd_b1_vdd_b2_vdd_b3_vdd_b4_vdd_link_vdd_link_dip_vdd_x1_vdd_x2_vdd_x3_t121 r0 *1 0,0
Ra_d_inv_clk_vdd_inv_mc_vdd_inv_q_vdd_mpa_py_mpb_py_nand_m_vdd_nand_s2_vdd_nwell_vdd_sb_vdd_sr1_vdd_sr2_vdd_sr3_vdd_sr4_vdd_sv_d_vdd_tie_sv_vdd_tg_d_a_tg_d_vdd_tg_fbm_vdd_tg_fbs_vdd_tg_s_vdd_vdd_vdd_b1_vdd_b2_vdd_b3_vdd_b4_vdd_link_vdd_link_dip_vdd_x1_vdd_x2_vdd_x3_t121
+ a|d|inv_clk_vdd|inv_mc_vdd|inv_q_vdd|mpa_py|mpb_py|nand_m_vdd|nand_s2_vdd|nwell_vdd|sb_vdd|sr1_vdd|sr2_vdd|sr3_vdd|sr4_vdd|sv_d_vdd_tie|sv_vdd|tg_d_a|tg_d_vdd|tg_fbm_vdd|tg_fbs_vdd|tg_s_vdd|vdd|vdd_b1|vdd_b2|vdd_b3|vdd_b4|vdd_link|vdd_link_dip|vdd_x1|vdd_x2|vdd_x3__t121
+ a|d|inv_clk_vdd|inv_mc_vdd|inv_q_vdd|mpa_py|mpb_py|nand_m_vdd|nand_s2_vdd|nwell_vdd|sb_vdd|sr1_vdd|sr2_vdd|sr3_vdd|sr4_vdd|sv_d_vdd_tie|sv_vdd|tg_d_a|tg_d_vdd|tg_fbm_vdd|tg_fbs_vdd|tg_s_vdd|vdd|vdd_b1|vdd_b2|vdd_b3|vdd_b4|vdd_link|vdd_link_dip|vdd_x1|vdd_x2|vdd_x3
+ 227.333384696
* device instance a_d_inv_clk_vdd_inv_mc_vdd_inv_q_vdd_mpa_py_mpb_py_nand_m_vdd_nand_s2_vdd_nwell_vdd_sb_vdd_sr1_vdd_sr2_vdd_sr3_vdd_sr4_vdd_sv_d_vdd_tie_sv_vdd_tg_d_a_tg_d_vdd_tg_fbm_vdd_tg_fbs_vdd_tg_s_vdd_vdd_vdd_b1_vdd_b2_vdd_b3_vdd_b4_vdd_link_vdd_link_dip_vdd_x1_vdd_x2_vdd_x3_t122 r0 *1 0,0
Ra_d_inv_clk_vdd_inv_mc_vdd_inv_q_vdd_mpa_py_mpb_py_nand_m_vdd_nand_s2_vdd_nwell_vdd_sb_vdd_sr1_vdd_sr2_vdd_sr3_vdd_sr4_vdd_sv_d_vdd_tie_sv_vdd_tg_d_a_tg_d_vdd_tg_fbm_vdd_tg_fbs_vdd_tg_s_vdd_vdd_vdd_b1_vdd_b2_vdd_b3_vdd_b4_vdd_link_vdd_link_dip_vdd_x1_vdd_x2_vdd_x3_t122
+ a|d|inv_clk_vdd|inv_mc_vdd|inv_q_vdd|mpa_py|mpb_py|nand_m_vdd|nand_s2_vdd|nwell_vdd|sb_vdd|sr1_vdd|sr2_vdd|sr3_vdd|sr4_vdd|sv_d_vdd_tie|sv_vdd|tg_d_a|tg_d_vdd|tg_fbm_vdd|tg_fbs_vdd|tg_s_vdd|vdd|vdd_b1|vdd_b2|vdd_b3|vdd_b4|vdd_link|vdd_link_dip|vdd_x1|vdd_x2|vdd_x3__t122
+ a|d|inv_clk_vdd|inv_mc_vdd|inv_q_vdd|mpa_py|mpb_py|nand_m_vdd|nand_s2_vdd|nwell_vdd|sb_vdd|sr1_vdd|sr2_vdd|sr3_vdd|sr4_vdd|sv_d_vdd_tie|sv_vdd|tg_d_a|tg_d_vdd|tg_fbm_vdd|tg_fbs_vdd|tg_s_vdd|vdd|vdd_b1|vdd_b2|vdd_b3|vdd_b4|vdd_link|vdd_link_dip|vdd_x1|vdd_x2|vdd_x3
+ 190.998041694
* device instance a_d_inv_clk_vdd_inv_mc_vdd_inv_q_vdd_mpa_py_mpb_py_nand_m_vdd_nand_s2_vdd_nwell_vdd_sb_vdd_sr1_vdd_sr2_vdd_sr3_vdd_sr4_vdd_sv_d_vdd_tie_sv_vdd_tg_d_a_tg_d_vdd_tg_fbm_vdd_tg_fbs_vdd_tg_s_vdd_vdd_vdd_b1_vdd_b2_vdd_b3_vdd_b4_vdd_link_vdd_link_dip_vdd_x1_vdd_x2_vdd_x3_t123 r0 *1 0,0
Ra_d_inv_clk_vdd_inv_mc_vdd_inv_q_vdd_mpa_py_mpb_py_nand_m_vdd_nand_s2_vdd_nwell_vdd_sb_vdd_sr1_vdd_sr2_vdd_sr3_vdd_sr4_vdd_sv_d_vdd_tie_sv_vdd_tg_d_a_tg_d_vdd_tg_fbm_vdd_tg_fbs_vdd_tg_s_vdd_vdd_vdd_b1_vdd_b2_vdd_b3_vdd_b4_vdd_link_vdd_link_dip_vdd_x1_vdd_x2_vdd_x3_t123
+ a|d|inv_clk_vdd|inv_mc_vdd|inv_q_vdd|mpa_py|mpb_py|nand_m_vdd|nand_s2_vdd|nwell_vdd|sb_vdd|sr1_vdd|sr2_vdd|sr3_vdd|sr4_vdd|sv_d_vdd_tie|sv_vdd|tg_d_a|tg_d_vdd|tg_fbm_vdd|tg_fbs_vdd|tg_s_vdd|vdd|vdd_b1|vdd_b2|vdd_b3|vdd_b4|vdd_link|vdd_link_dip|vdd_x1|vdd_x2|vdd_x3__t123
+ a|d|inv_clk_vdd|inv_mc_vdd|inv_q_vdd|mpa_py|mpb_py|nand_m_vdd|nand_s2_vdd|nwell_vdd|sb_vdd|sr1_vdd|sr2_vdd|sr3_vdd|sr4_vdd|sv_d_vdd_tie|sv_vdd|tg_d_a|tg_d_vdd|tg_fbm_vdd|tg_fbs_vdd|tg_s_vdd|vdd|vdd_b1|vdd_b2|vdd_b3|vdd_b4|vdd_link|vdd_link_dip|vdd_x1|vdd_x2|vdd_x3
+ 109.655400001
* device instance a_d_inv_clk_vdd_inv_mc_vdd_inv_q_vdd_mpa_py_mpb_py_nand_m_vdd_nand_s2_vdd_nwell_vdd_sb_vdd_sr1_vdd_sr2_vdd_sr3_vdd_sr4_vdd_sv_d_vdd_tie_sv_vdd_tg_d_a_tg_d_vdd_tg_fbm_vdd_tg_fbs_vdd_tg_s_vdd_vdd_vdd_b1_vdd_b2_vdd_b3_vdd_b4_vdd_link_vdd_link_dip_vdd_x1_vdd_x2_vdd_x3_t124 r0 *1 0,0
Ra_d_inv_clk_vdd_inv_mc_vdd_inv_q_vdd_mpa_py_mpb_py_nand_m_vdd_nand_s2_vdd_nwell_vdd_sb_vdd_sr1_vdd_sr2_vdd_sr3_vdd_sr4_vdd_sv_d_vdd_tie_sv_vdd_tg_d_a_tg_d_vdd_tg_fbm_vdd_tg_fbs_vdd_tg_s_vdd_vdd_vdd_b1_vdd_b2_vdd_b3_vdd_b4_vdd_link_vdd_link_dip_vdd_x1_vdd_x2_vdd_x3_t124
+ a|d|inv_clk_vdd|inv_mc_vdd|inv_q_vdd|mpa_py|mpb_py|nand_m_vdd|nand_s2_vdd|nwell_vdd|sb_vdd|sr1_vdd|sr2_vdd|sr3_vdd|sr4_vdd|sv_d_vdd_tie|sv_vdd|tg_d_a|tg_d_vdd|tg_fbm_vdd|tg_fbs_vdd|tg_s_vdd|vdd|vdd_b1|vdd_b2|vdd_b3|vdd_b4|vdd_link|vdd_link_dip|vdd_x1|vdd_x2|vdd_x3__t124
+ a|d|inv_clk_vdd|inv_mc_vdd|inv_q_vdd|mpa_py|mpb_py|nand_m_vdd|nand_s2_vdd|nwell_vdd|sb_vdd|sr1_vdd|sr2_vdd|sr3_vdd|sr4_vdd|sv_d_vdd_tie|sv_vdd|tg_d_a|tg_d_vdd|tg_fbm_vdd|tg_fbs_vdd|tg_s_vdd|vdd|vdd_b1|vdd_b2|vdd_b3|vdd_b4|vdd_link|vdd_link_dip|vdd_x1|vdd_x2|vdd_x3
+ 129.332460393
* device instance a_d_inv_clk_vdd_inv_mc_vdd_inv_q_vdd_mpa_py_mpb_py_nand_m_vdd_nand_s2_vdd_nwell_vdd_sb_vdd_sr1_vdd_sr2_vdd_sr3_vdd_sr4_vdd_sv_d_vdd_tie_sv_vdd_tg_d_a_tg_d_vdd_tg_fbm_vdd_tg_fbs_vdd_tg_s_vdd_vdd_vdd_b1_vdd_b2_vdd_b3_vdd_b4_vdd_link_vdd_link_dip_vdd_x1_vdd_x2_vdd_x3_t125 r0 *1 0,0
Ra_d_inv_clk_vdd_inv_mc_vdd_inv_q_vdd_mpa_py_mpb_py_nand_m_vdd_nand_s2_vdd_nwell_vdd_sb_vdd_sr1_vdd_sr2_vdd_sr3_vdd_sr4_vdd_sv_d_vdd_tie_sv_vdd_tg_d_a_tg_d_vdd_tg_fbm_vdd_tg_fbs_vdd_tg_s_vdd_vdd_vdd_b1_vdd_b2_vdd_b3_vdd_b4_vdd_link_vdd_link_dip_vdd_x1_vdd_x2_vdd_x3_t125
+ a|d|inv_clk_vdd|inv_mc_vdd|inv_q_vdd|mpa_py|mpb_py|nand_m_vdd|nand_s2_vdd|nwell_vdd|sb_vdd|sr1_vdd|sr2_vdd|sr3_vdd|sr4_vdd|sv_d_vdd_tie|sv_vdd|tg_d_a|tg_d_vdd|tg_fbm_vdd|tg_fbs_vdd|tg_s_vdd|vdd|vdd_b1|vdd_b2|vdd_b3|vdd_b4|vdd_link|vdd_link_dip|vdd_x1|vdd_x2|vdd_x3__t125
+ a|d|inv_clk_vdd|inv_mc_vdd|inv_q_vdd|mpa_py|mpb_py|nand_m_vdd|nand_s2_vdd|nwell_vdd|sb_vdd|sr1_vdd|sr2_vdd|sr3_vdd|sr4_vdd|sv_d_vdd_tie|sv_vdd|tg_d_a|tg_d_vdd|tg_fbm_vdd|tg_fbs_vdd|tg_s_vdd|vdd|vdd_b1|vdd_b2|vdd_b3|vdd_b4|vdd_link|vdd_link_dip|vdd_x1|vdd_x2|vdd_x3
+ 145.843562672
* device instance a_d_inv_clk_vdd_inv_mc_vdd_inv_q_vdd_mpa_py_mpb_py_nand_m_vdd_nand_s2_vdd_nwell_vdd_sb_vdd_sr1_vdd_sr2_vdd_sr3_vdd_sr4_vdd_sv_d_vdd_tie_sv_vdd_tg_d_a_tg_d_vdd_tg_fbm_vdd_tg_fbs_vdd_tg_s_vdd_vdd_vdd_b1_vdd_b2_vdd_b3_vdd_b4_vdd_link_vdd_link_dip_vdd_x1_vdd_x2_vdd_x3_t126 r0 *1 0,0
Ra_d_inv_clk_vdd_inv_mc_vdd_inv_q_vdd_mpa_py_mpb_py_nand_m_vdd_nand_s2_vdd_nwell_vdd_sb_vdd_sr1_vdd_sr2_vdd_sr3_vdd_sr4_vdd_sv_d_vdd_tie_sv_vdd_tg_d_a_tg_d_vdd_tg_fbm_vdd_tg_fbs_vdd_tg_s_vdd_vdd_vdd_b1_vdd_b2_vdd_b3_vdd_b4_vdd_link_vdd_link_dip_vdd_x1_vdd_x2_vdd_x3_t126
+ a|d|inv_clk_vdd|inv_mc_vdd|inv_q_vdd|mpa_py|mpb_py|nand_m_vdd|nand_s2_vdd|nwell_vdd|sb_vdd|sr1_vdd|sr2_vdd|sr3_vdd|sr4_vdd|sv_d_vdd_tie|sv_vdd|tg_d_a|tg_d_vdd|tg_fbm_vdd|tg_fbs_vdd|tg_s_vdd|vdd|vdd_b1|vdd_b2|vdd_b3|vdd_b4|vdd_link|vdd_link_dip|vdd_x1|vdd_x2|vdd_x3__t126
+ a|d|inv_clk_vdd|inv_mc_vdd|inv_q_vdd|mpa_py|mpb_py|nand_m_vdd|nand_s2_vdd|nwell_vdd|sb_vdd|sr1_vdd|sr2_vdd|sr3_vdd|sr4_vdd|sv_d_vdd_tie|sv_vdd|tg_d_a|tg_d_vdd|tg_fbm_vdd|tg_fbs_vdd|tg_s_vdd|vdd|vdd_b1|vdd_b2|vdd_b3|vdd_b4|vdd_link|vdd_link_dip|vdd_x1|vdd_x2|vdd_x3
+ 117.405111309
* device instance a_d_inv_clk_vdd_inv_mc_vdd_inv_q_vdd_mpa_py_mpb_py_nand_m_vdd_nand_s2_vdd_nwell_vdd_sb_vdd_sr1_vdd_sr2_vdd_sr3_vdd_sr4_vdd_sv_d_vdd_tie_sv_vdd_tg_d_a_tg_d_vdd_tg_fbm_vdd_tg_fbs_vdd_tg_s_vdd_vdd_vdd_b1_vdd_b2_vdd_b3_vdd_b4_vdd_link_vdd_link_dip_vdd_x1_vdd_x2_vdd_x3_t127 r0 *1 0,0
Ra_d_inv_clk_vdd_inv_mc_vdd_inv_q_vdd_mpa_py_mpb_py_nand_m_vdd_nand_s2_vdd_nwell_vdd_sb_vdd_sr1_vdd_sr2_vdd_sr3_vdd_sr4_vdd_sv_d_vdd_tie_sv_vdd_tg_d_a_tg_d_vdd_tg_fbm_vdd_tg_fbs_vdd_tg_s_vdd_vdd_vdd_b1_vdd_b2_vdd_b3_vdd_b4_vdd_link_vdd_link_dip_vdd_x1_vdd_x2_vdd_x3_t127
+ a|d|inv_clk_vdd|inv_mc_vdd|inv_q_vdd|mpa_py|mpb_py|nand_m_vdd|nand_s2_vdd|nwell_vdd|sb_vdd|sr1_vdd|sr2_vdd|sr3_vdd|sr4_vdd|sv_d_vdd_tie|sv_vdd|tg_d_a|tg_d_vdd|tg_fbm_vdd|tg_fbs_vdd|tg_s_vdd|vdd|vdd_b1|vdd_b2|vdd_b3|vdd_b4|vdd_link|vdd_link_dip|vdd_x1|vdd_x2|vdd_x3__t127
+ a|d|inv_clk_vdd|inv_mc_vdd|inv_q_vdd|mpa_py|mpb_py|nand_m_vdd|nand_s2_vdd|nwell_vdd|sb_vdd|sr1_vdd|sr2_vdd|sr3_vdd|sr4_vdd|sv_d_vdd_tie|sv_vdd|tg_d_a|tg_d_vdd|tg_fbm_vdd|tg_fbs_vdd|tg_s_vdd|vdd|vdd_b1|vdd_b2|vdd_b3|vdd_b4|vdd_link|vdd_link_dip|vdd_x1|vdd_x2|vdd_x3
+ 199.79402836
* device instance a_d_inv_clk_vdd_inv_mc_vdd_inv_q_vdd_mpa_py_mpb_py_nand_m_vdd_nand_s2_vdd_nwell_vdd_sb_vdd_sr1_vdd_sr2_vdd_sr3_vdd_sr4_vdd_sv_d_vdd_tie_sv_vdd_tg_d_a_tg_d_vdd_tg_fbm_vdd_tg_fbs_vdd_tg_s_vdd_vdd_vdd_b1_vdd_b2_vdd_b3_vdd_b4_vdd_link_vdd_link_dip_vdd_x1_vdd_x2_vdd_x3_t128 r0 *1 0,0
Ra_d_inv_clk_vdd_inv_mc_vdd_inv_q_vdd_mpa_py_mpb_py_nand_m_vdd_nand_s2_vdd_nwell_vdd_sb_vdd_sr1_vdd_sr2_vdd_sr3_vdd_sr4_vdd_sv_d_vdd_tie_sv_vdd_tg_d_a_tg_d_vdd_tg_fbm_vdd_tg_fbs_vdd_tg_s_vdd_vdd_vdd_b1_vdd_b2_vdd_b3_vdd_b4_vdd_link_vdd_link_dip_vdd_x1_vdd_x2_vdd_x3_t128
+ a|d|inv_clk_vdd|inv_mc_vdd|inv_q_vdd|mpa_py|mpb_py|nand_m_vdd|nand_s2_vdd|nwell_vdd|sb_vdd|sr1_vdd|sr2_vdd|sr3_vdd|sr4_vdd|sv_d_vdd_tie|sv_vdd|tg_d_a|tg_d_vdd|tg_fbm_vdd|tg_fbs_vdd|tg_s_vdd|vdd|vdd_b1|vdd_b2|vdd_b3|vdd_b4|vdd_link|vdd_link_dip|vdd_x1|vdd_x2|vdd_x3__t128
+ a|d|inv_clk_vdd|inv_mc_vdd|inv_q_vdd|mpa_py|mpb_py|nand_m_vdd|nand_s2_vdd|nwell_vdd|sb_vdd|sr1_vdd|sr2_vdd|sr3_vdd|sr4_vdd|sv_d_vdd_tie|sv_vdd|tg_d_a|tg_d_vdd|tg_fbm_vdd|tg_fbs_vdd|tg_s_vdd|vdd|vdd_b1|vdd_b2|vdd_b3|vdd_b4|vdd_link|vdd_link_dip|vdd_x1|vdd_x2|vdd_x3
+ 16.7710976171
* device instance a_d_inv_clk_vdd_inv_mc_vdd_inv_q_vdd_mpa_py_mpb_py_nand_m_vdd_nand_s2_vdd_nwell_vdd_sb_vdd_sr1_vdd_sr2_vdd_sr3_vdd_sr4_vdd_sv_d_vdd_tie_sv_vdd_tg_d_a_tg_d_vdd_tg_fbm_vdd_tg_fbs_vdd_tg_s_vdd_vdd_vdd_b1_vdd_b2_vdd_b3_vdd_b4_vdd_link_vdd_link_dip_vdd_x1_vdd_x2_vdd_x3_t129 r0 *1 0,0
Ra_d_inv_clk_vdd_inv_mc_vdd_inv_q_vdd_mpa_py_mpb_py_nand_m_vdd_nand_s2_vdd_nwell_vdd_sb_vdd_sr1_vdd_sr2_vdd_sr3_vdd_sr4_vdd_sv_d_vdd_tie_sv_vdd_tg_d_a_tg_d_vdd_tg_fbm_vdd_tg_fbs_vdd_tg_s_vdd_vdd_vdd_b1_vdd_b2_vdd_b3_vdd_b4_vdd_link_vdd_link_dip_vdd_x1_vdd_x2_vdd_x3_t129
+ a|d|inv_clk_vdd|inv_mc_vdd|inv_q_vdd|mpa_py|mpb_py|nand_m_vdd|nand_s2_vdd|nwell_vdd|sb_vdd|sr1_vdd|sr2_vdd|sr3_vdd|sr4_vdd|sv_d_vdd_tie|sv_vdd|tg_d_a|tg_d_vdd|tg_fbm_vdd|tg_fbs_vdd|tg_s_vdd|vdd|vdd_b1|vdd_b2|vdd_b3|vdd_b4|vdd_link|vdd_link_dip|vdd_x1|vdd_x2|vdd_x3__t129
+ a|d|inv_clk_vdd|inv_mc_vdd|inv_q_vdd|mpa_py|mpb_py|nand_m_vdd|nand_s2_vdd|nwell_vdd|sb_vdd|sr1_vdd|sr2_vdd|sr3_vdd|sr4_vdd|sv_d_vdd_tie|sv_vdd|tg_d_a|tg_d_vdd|tg_fbm_vdd|tg_fbs_vdd|tg_s_vdd|vdd|vdd_b1|vdd_b2|vdd_b3|vdd_b4|vdd_link|vdd_link_dip|vdd_x1|vdd_x2|vdd_x3
+ 171.163906087
* device instance a_d_inv_clk_vdd_inv_mc_vdd_inv_q_vdd_mpa_py_mpb_py_nand_m_vdd_nand_s2_vdd_nwell_vdd_sb_vdd_sr1_vdd_sr2_vdd_sr3_vdd_sr4_vdd_sv_d_vdd_tie_sv_vdd_tg_d_a_tg_d_vdd_tg_fbm_vdd_tg_fbs_vdd_tg_s_vdd_vdd_vdd_b1_vdd_b2_vdd_b3_vdd_b4_vdd_link_vdd_link_dip_vdd_x1_vdd_x2_vdd_x3_t130 r0 *1 0,0
Ra_d_inv_clk_vdd_inv_mc_vdd_inv_q_vdd_mpa_py_mpb_py_nand_m_vdd_nand_s2_vdd_nwell_vdd_sb_vdd_sr1_vdd_sr2_vdd_sr3_vdd_sr4_vdd_sv_d_vdd_tie_sv_vdd_tg_d_a_tg_d_vdd_tg_fbm_vdd_tg_fbs_vdd_tg_s_vdd_vdd_vdd_b1_vdd_b2_vdd_b3_vdd_b4_vdd_link_vdd_link_dip_vdd_x1_vdd_x2_vdd_x3_t130
+ a|d|inv_clk_vdd|inv_mc_vdd|inv_q_vdd|mpa_py|mpb_py|nand_m_vdd|nand_s2_vdd|nwell_vdd|sb_vdd|sr1_vdd|sr2_vdd|sr3_vdd|sr4_vdd|sv_d_vdd_tie|sv_vdd|tg_d_a|tg_d_vdd|tg_fbm_vdd|tg_fbs_vdd|tg_s_vdd|vdd|vdd_b1|vdd_b2|vdd_b3|vdd_b4|vdd_link|vdd_link_dip|vdd_x1|vdd_x2|vdd_x3__t130
+ a|d|inv_clk_vdd|inv_mc_vdd|inv_q_vdd|mpa_py|mpb_py|nand_m_vdd|nand_s2_vdd|nwell_vdd|sb_vdd|sr1_vdd|sr2_vdd|sr3_vdd|sr4_vdd|sv_d_vdd_tie|sv_vdd|tg_d_a|tg_d_vdd|tg_fbm_vdd|tg_fbs_vdd|tg_s_vdd|vdd|vdd_b1|vdd_b2|vdd_b3|vdd_b4|vdd_link|vdd_link_dip|vdd_x1|vdd_x2|vdd_x3
+ 146.737616634
* device instance a_d_inv_clk_vdd_inv_mc_vdd_inv_q_vdd_mpa_py_mpb_py_nand_m_vdd_nand_s2_vdd_nwell_vdd_sb_vdd_sr1_vdd_sr2_vdd_sr3_vdd_sr4_vdd_sv_d_vdd_tie_sv_vdd_tg_d_a_tg_d_vdd_tg_fbm_vdd_tg_fbs_vdd_tg_s_vdd_vdd_vdd_b1_vdd_b2_vdd_b3_vdd_b4_vdd_link_vdd_link_dip_vdd_x1_vdd_x2_vdd_x3_t131 r0 *1 0,0
Ra_d_inv_clk_vdd_inv_mc_vdd_inv_q_vdd_mpa_py_mpb_py_nand_m_vdd_nand_s2_vdd_nwell_vdd_sb_vdd_sr1_vdd_sr2_vdd_sr3_vdd_sr4_vdd_sv_d_vdd_tie_sv_vdd_tg_d_a_tg_d_vdd_tg_fbm_vdd_tg_fbs_vdd_tg_s_vdd_vdd_vdd_b1_vdd_b2_vdd_b3_vdd_b4_vdd_link_vdd_link_dip_vdd_x1_vdd_x2_vdd_x3_t131
+ a|d|inv_clk_vdd|inv_mc_vdd|inv_q_vdd|mpa_py|mpb_py|nand_m_vdd|nand_s2_vdd|nwell_vdd|sb_vdd|sr1_vdd|sr2_vdd|sr3_vdd|sr4_vdd|sv_d_vdd_tie|sv_vdd|tg_d_a|tg_d_vdd|tg_fbm_vdd|tg_fbs_vdd|tg_s_vdd|vdd|vdd_b1|vdd_b2|vdd_b3|vdd_b4|vdd_link|vdd_link_dip|vdd_x1|vdd_x2|vdd_x3__t131
+ a|d|inv_clk_vdd|inv_mc_vdd|inv_q_vdd|mpa_py|mpb_py|nand_m_vdd|nand_s2_vdd|nwell_vdd|sb_vdd|sr1_vdd|sr2_vdd|sr3_vdd|sr4_vdd|sv_d_vdd_tie|sv_vdd|tg_d_a|tg_d_vdd|tg_fbm_vdd|tg_fbs_vdd|tg_s_vdd|vdd|vdd_b1|vdd_b2|vdd_b3|vdd_b4|vdd_link|vdd_link_dip|vdd_x1|vdd_x2|vdd_x3
+ 181.661562025
* device instance a_d_inv_clk_vdd_inv_mc_vdd_inv_q_vdd_mpa_py_mpb_py_nand_m_vdd_nand_s2_vdd_nwell_vdd_sb_vdd_sr1_vdd_sr2_vdd_sr3_vdd_sr4_vdd_sv_d_vdd_tie_sv_vdd_tg_d_a_tg_d_vdd_tg_fbm_vdd_tg_fbs_vdd_tg_s_vdd_vdd_vdd_b1_vdd_b2_vdd_b3_vdd_b4_vdd_link_vdd_link_dip_vdd_x1_vdd_x2_vdd_x3_t132 r0 *1 0,0
Ra_d_inv_clk_vdd_inv_mc_vdd_inv_q_vdd_mpa_py_mpb_py_nand_m_vdd_nand_s2_vdd_nwell_vdd_sb_vdd_sr1_vdd_sr2_vdd_sr3_vdd_sr4_vdd_sv_d_vdd_tie_sv_vdd_tg_d_a_tg_d_vdd_tg_fbm_vdd_tg_fbs_vdd_tg_s_vdd_vdd_vdd_b1_vdd_b2_vdd_b3_vdd_b4_vdd_link_vdd_link_dip_vdd_x1_vdd_x2_vdd_x3_t132
+ a|d|inv_clk_vdd|inv_mc_vdd|inv_q_vdd|mpa_py|mpb_py|nand_m_vdd|nand_s2_vdd|nwell_vdd|sb_vdd|sr1_vdd|sr2_vdd|sr3_vdd|sr4_vdd|sv_d_vdd_tie|sv_vdd|tg_d_a|tg_d_vdd|tg_fbm_vdd|tg_fbs_vdd|tg_s_vdd|vdd|vdd_b1|vdd_b2|vdd_b3|vdd_b4|vdd_link|vdd_link_dip|vdd_x1|vdd_x2|vdd_x3__t132
+ a|d|inv_clk_vdd|inv_mc_vdd|inv_q_vdd|mpa_py|mpb_py|nand_m_vdd|nand_s2_vdd|nwell_vdd|sb_vdd|sr1_vdd|sr2_vdd|sr3_vdd|sr4_vdd|sv_d_vdd_tie|sv_vdd|tg_d_a|tg_d_vdd|tg_fbm_vdd|tg_fbs_vdd|tg_s_vdd|vdd|vdd_b1|vdd_b2|vdd_b3|vdd_b4|vdd_link|vdd_link_dip|vdd_x1|vdd_x2|vdd_x3
+ 38.4771181778
* device instance a_d_inv_clk_vdd_inv_mc_vdd_inv_q_vdd_mpa_py_mpb_py_nand_m_vdd_nand_s2_vdd_nwell_vdd_sb_vdd_sr1_vdd_sr2_vdd_sr3_vdd_sr4_vdd_sv_d_vdd_tie_sv_vdd_tg_d_a_tg_d_vdd_tg_fbm_vdd_tg_fbs_vdd_tg_s_vdd_vdd_vdd_b1_vdd_b2_vdd_b3_vdd_b4_vdd_link_vdd_link_dip_vdd_x1_vdd_x2_vdd_x3_t133 r0 *1 0,0
Ra_d_inv_clk_vdd_inv_mc_vdd_inv_q_vdd_mpa_py_mpb_py_nand_m_vdd_nand_s2_vdd_nwell_vdd_sb_vdd_sr1_vdd_sr2_vdd_sr3_vdd_sr4_vdd_sv_d_vdd_tie_sv_vdd_tg_d_a_tg_d_vdd_tg_fbm_vdd_tg_fbs_vdd_tg_s_vdd_vdd_vdd_b1_vdd_b2_vdd_b3_vdd_b4_vdd_link_vdd_link_dip_vdd_x1_vdd_x2_vdd_x3_t133
+ a|d|inv_clk_vdd|inv_mc_vdd|inv_q_vdd|mpa_py|mpb_py|nand_m_vdd|nand_s2_vdd|nwell_vdd|sb_vdd|sr1_vdd|sr2_vdd|sr3_vdd|sr4_vdd|sv_d_vdd_tie|sv_vdd|tg_d_a|tg_d_vdd|tg_fbm_vdd|tg_fbs_vdd|tg_s_vdd|vdd|vdd_b1|vdd_b2|vdd_b3|vdd_b4|vdd_link|vdd_link_dip|vdd_x1|vdd_x2|vdd_x3__t133
+ a|d|inv_clk_vdd|inv_mc_vdd|inv_q_vdd|mpa_py|mpb_py|nand_m_vdd|nand_s2_vdd|nwell_vdd|sb_vdd|sr1_vdd|sr2_vdd|sr3_vdd|sr4_vdd|sv_d_vdd_tie|sv_vdd|tg_d_a|tg_d_vdd|tg_fbm_vdd|tg_fbs_vdd|tg_s_vdd|vdd|vdd_b1|vdd_b2|vdd_b3|vdd_b4|vdd_link|vdd_link_dip|vdd_x1|vdd_x2|vdd_x3
+ 118.05949851
* device instance a_d_inv_clk_vdd_inv_mc_vdd_inv_q_vdd_mpa_py_mpb_py_nand_m_vdd_nand_s2_vdd_nwell_vdd_sb_vdd_sr1_vdd_sr2_vdd_sr3_vdd_sr4_vdd_sv_d_vdd_tie_sv_vdd_tg_d_a_tg_d_vdd_tg_fbm_vdd_tg_fbs_vdd_tg_s_vdd_vdd_vdd_b1_vdd_b2_vdd_b3_vdd_b4_vdd_link_vdd_link_dip_vdd_x1_vdd_x2_vdd_x3_t134 r0 *1 0,0
Ra_d_inv_clk_vdd_inv_mc_vdd_inv_q_vdd_mpa_py_mpb_py_nand_m_vdd_nand_s2_vdd_nwell_vdd_sb_vdd_sr1_vdd_sr2_vdd_sr3_vdd_sr4_vdd_sv_d_vdd_tie_sv_vdd_tg_d_a_tg_d_vdd_tg_fbm_vdd_tg_fbs_vdd_tg_s_vdd_vdd_vdd_b1_vdd_b2_vdd_b3_vdd_b4_vdd_link_vdd_link_dip_vdd_x1_vdd_x2_vdd_x3_t134
+ a|d|inv_clk_vdd|inv_mc_vdd|inv_q_vdd|mpa_py|mpb_py|nand_m_vdd|nand_s2_vdd|nwell_vdd|sb_vdd|sr1_vdd|sr2_vdd|sr3_vdd|sr4_vdd|sv_d_vdd_tie|sv_vdd|tg_d_a|tg_d_vdd|tg_fbm_vdd|tg_fbs_vdd|tg_s_vdd|vdd|vdd_b1|vdd_b2|vdd_b3|vdd_b4|vdd_link|vdd_link_dip|vdd_x1|vdd_x2|vdd_x3__t134
+ a|d|inv_clk_vdd|inv_mc_vdd|inv_q_vdd|mpa_py|mpb_py|nand_m_vdd|nand_s2_vdd|nwell_vdd|sb_vdd|sr1_vdd|sr2_vdd|sr3_vdd|sr4_vdd|sv_d_vdd_tie|sv_vdd|tg_d_a|tg_d_vdd|tg_fbm_vdd|tg_fbs_vdd|tg_s_vdd|vdd|vdd_b1|vdd_b2|vdd_b3|vdd_b4|vdd_link|vdd_link_dip|vdd_x1|vdd_x2|vdd_x3
+ 90.041836416
* device instance a_d_inv_clk_vdd_inv_mc_vdd_inv_q_vdd_mpa_py_mpb_py_nand_m_vdd_nand_s2_vdd_nwell_vdd_sb_vdd_sr1_vdd_sr2_vdd_sr3_vdd_sr4_vdd_sv_d_vdd_tie_sv_vdd_tg_d_a_tg_d_vdd_tg_fbm_vdd_tg_fbs_vdd_tg_s_vdd_vdd_vdd_b1_vdd_b2_vdd_b3_vdd_b4_vdd_link_vdd_link_dip_vdd_x1_vdd_x2_vdd_x3_t135 r0 *1 0,0
Ra_d_inv_clk_vdd_inv_mc_vdd_inv_q_vdd_mpa_py_mpb_py_nand_m_vdd_nand_s2_vdd_nwell_vdd_sb_vdd_sr1_vdd_sr2_vdd_sr3_vdd_sr4_vdd_sv_d_vdd_tie_sv_vdd_tg_d_a_tg_d_vdd_tg_fbm_vdd_tg_fbs_vdd_tg_s_vdd_vdd_vdd_b1_vdd_b2_vdd_b3_vdd_b4_vdd_link_vdd_link_dip_vdd_x1_vdd_x2_vdd_x3_t135
+ a|d|inv_clk_vdd|inv_mc_vdd|inv_q_vdd|mpa_py|mpb_py|nand_m_vdd|nand_s2_vdd|nwell_vdd|sb_vdd|sr1_vdd|sr2_vdd|sr3_vdd|sr4_vdd|sv_d_vdd_tie|sv_vdd|tg_d_a|tg_d_vdd|tg_fbm_vdd|tg_fbs_vdd|tg_s_vdd|vdd|vdd_b1|vdd_b2|vdd_b3|vdd_b4|vdd_link|vdd_link_dip|vdd_x1|vdd_x2|vdd_x3__t135
+ a|d|inv_clk_vdd|inv_mc_vdd|inv_q_vdd|mpa_py|mpb_py|nand_m_vdd|nand_s2_vdd|nwell_vdd|sb_vdd|sr1_vdd|sr2_vdd|sr3_vdd|sr4_vdd|sv_d_vdd_tie|sv_vdd|tg_d_a|tg_d_vdd|tg_fbm_vdd|tg_fbs_vdd|tg_s_vdd|vdd|vdd_b1|vdd_b2|vdd_b3|vdd_b4|vdd_link|vdd_link_dip|vdd_x1|vdd_x2|vdd_x3
+ 56.5886909333
* device instance a_d_inv_clk_vdd_inv_mc_vdd_inv_q_vdd_mpa_py_mpb_py_nand_m_vdd_nand_s2_vdd_nwell_vdd_sb_vdd_sr1_vdd_sr2_vdd_sr3_vdd_sr4_vdd_sv_d_vdd_tie_sv_vdd_tg_d_a_tg_d_vdd_tg_fbm_vdd_tg_fbs_vdd_tg_s_vdd_vdd_vdd_b1_vdd_b2_vdd_b3_vdd_b4_vdd_link_vdd_link_dip_vdd_x1_vdd_x2_vdd_x3_t136 r0 *1 0,0
Ra_d_inv_clk_vdd_inv_mc_vdd_inv_q_vdd_mpa_py_mpb_py_nand_m_vdd_nand_s2_vdd_nwell_vdd_sb_vdd_sr1_vdd_sr2_vdd_sr3_vdd_sr4_vdd_sv_d_vdd_tie_sv_vdd_tg_d_a_tg_d_vdd_tg_fbm_vdd_tg_fbs_vdd_tg_s_vdd_vdd_vdd_b1_vdd_b2_vdd_b3_vdd_b4_vdd_link_vdd_link_dip_vdd_x1_vdd_x2_vdd_x3_t136
+ a|d|inv_clk_vdd|inv_mc_vdd|inv_q_vdd|mpa_py|mpb_py|nand_m_vdd|nand_s2_vdd|nwell_vdd|sb_vdd|sr1_vdd|sr2_vdd|sr3_vdd|sr4_vdd|sv_d_vdd_tie|sv_vdd|tg_d_a|tg_d_vdd|tg_fbm_vdd|tg_fbs_vdd|tg_s_vdd|vdd|vdd_b1|vdd_b2|vdd_b3|vdd_b4|vdd_link|vdd_link_dip|vdd_x1|vdd_x2|vdd_x3__t136
+ a|d|inv_clk_vdd|inv_mc_vdd|inv_q_vdd|mpa_py|mpb_py|nand_m_vdd|nand_s2_vdd|nwell_vdd|sb_vdd|sr1_vdd|sr2_vdd|sr3_vdd|sr4_vdd|sv_d_vdd_tie|sv_vdd|tg_d_a|tg_d_vdd|tg_fbm_vdd|tg_fbs_vdd|tg_s_vdd|vdd|vdd_b1|vdd_b2|vdd_b3|vdd_b4|vdd_link|vdd_link_dip|vdd_x1|vdd_x2|vdd_x3
+ 65.9867039863
* device instance a_d_inv_clk_vdd_inv_mc_vdd_inv_q_vdd_mpa_py_mpb_py_nand_m_vdd_nand_s2_vdd_nwell_vdd_sb_vdd_sr1_vdd_sr2_vdd_sr3_vdd_sr4_vdd_sv_d_vdd_tie_sv_vdd_tg_d_a_tg_d_vdd_tg_fbm_vdd_tg_fbs_vdd_tg_s_vdd_vdd_vdd_b1_vdd_b2_vdd_b3_vdd_b4_vdd_link_vdd_link_dip_vdd_x1_vdd_x2_vdd_x3_t137 r0 *1 0,0
Ra_d_inv_clk_vdd_inv_mc_vdd_inv_q_vdd_mpa_py_mpb_py_nand_m_vdd_nand_s2_vdd_nwell_vdd_sb_vdd_sr1_vdd_sr2_vdd_sr3_vdd_sr4_vdd_sv_d_vdd_tie_sv_vdd_tg_d_a_tg_d_vdd_tg_fbm_vdd_tg_fbs_vdd_tg_s_vdd_vdd_vdd_b1_vdd_b2_vdd_b3_vdd_b4_vdd_link_vdd_link_dip_vdd_x1_vdd_x2_vdd_x3_t137
+ a|d|inv_clk_vdd|inv_mc_vdd|inv_q_vdd|mpa_py|mpb_py|nand_m_vdd|nand_s2_vdd|nwell_vdd|sb_vdd|sr1_vdd|sr2_vdd|sr3_vdd|sr4_vdd|sv_d_vdd_tie|sv_vdd|tg_d_a|tg_d_vdd|tg_fbm_vdd|tg_fbs_vdd|tg_s_vdd|vdd|vdd_b1|vdd_b2|vdd_b3|vdd_b4|vdd_link|vdd_link_dip|vdd_x1|vdd_x2|vdd_x3__t137
+ a|d|inv_clk_vdd|inv_mc_vdd|inv_q_vdd|mpa_py|mpb_py|nand_m_vdd|nand_s2_vdd|nwell_vdd|sb_vdd|sr1_vdd|sr2_vdd|sr3_vdd|sr4_vdd|sv_d_vdd_tie|sv_vdd|tg_d_a|tg_d_vdd|tg_fbm_vdd|tg_fbs_vdd|tg_s_vdd|vdd|vdd_b1|vdd_b2|vdd_b3|vdd_b4|vdd_link|vdd_link_dip|vdd_x1|vdd_x2|vdd_x3
+ 23.2370884501
* device instance a_d_inv_clk_vdd_inv_mc_vdd_inv_q_vdd_mpa_py_mpb_py_nand_m_vdd_nand_s2_vdd_nwell_vdd_sb_vdd_sr1_vdd_sr2_vdd_sr3_vdd_sr4_vdd_sv_d_vdd_tie_sv_vdd_tg_d_a_tg_d_vdd_tg_fbm_vdd_tg_fbs_vdd_tg_s_vdd_vdd_vdd_b1_vdd_b2_vdd_b3_vdd_b4_vdd_link_vdd_link_dip_vdd_x1_vdd_x2_vdd_x3_t138 r0 *1 0,0
Ra_d_inv_clk_vdd_inv_mc_vdd_inv_q_vdd_mpa_py_mpb_py_nand_m_vdd_nand_s2_vdd_nwell_vdd_sb_vdd_sr1_vdd_sr2_vdd_sr3_vdd_sr4_vdd_sv_d_vdd_tie_sv_vdd_tg_d_a_tg_d_vdd_tg_fbm_vdd_tg_fbs_vdd_tg_s_vdd_vdd_vdd_b1_vdd_b2_vdd_b3_vdd_b4_vdd_link_vdd_link_dip_vdd_x1_vdd_x2_vdd_x3_t138
+ a|d|inv_clk_vdd|inv_mc_vdd|inv_q_vdd|mpa_py|mpb_py|nand_m_vdd|nand_s2_vdd|nwell_vdd|sb_vdd|sr1_vdd|sr2_vdd|sr3_vdd|sr4_vdd|sv_d_vdd_tie|sv_vdd|tg_d_a|tg_d_vdd|tg_fbm_vdd|tg_fbs_vdd|tg_s_vdd|vdd|vdd_b1|vdd_b2|vdd_b3|vdd_b4|vdd_link|vdd_link_dip|vdd_x1|vdd_x2|vdd_x3__t138
+ a|d|inv_clk_vdd|inv_mc_vdd|inv_q_vdd|mpa_py|mpb_py|nand_m_vdd|nand_s2_vdd|nwell_vdd|sb_vdd|sr1_vdd|sr2_vdd|sr3_vdd|sr4_vdd|sv_d_vdd_tie|sv_vdd|tg_d_a|tg_d_vdd|tg_fbm_vdd|tg_fbs_vdd|tg_s_vdd|vdd|vdd_b1|vdd_b2|vdd_b3|vdd_b4|vdd_link|vdd_link_dip|vdd_x1|vdd_x2|vdd_x3
+ 157.221525534
* device instance a_d_inv_clk_vdd_inv_mc_vdd_inv_q_vdd_mpa_py_mpb_py_nand_m_vdd_nand_s2_vdd_nwell_vdd_sb_vdd_sr1_vdd_sr2_vdd_sr3_vdd_sr4_vdd_sv_d_vdd_tie_sv_vdd_tg_d_a_tg_d_vdd_tg_fbm_vdd_tg_fbs_vdd_tg_s_vdd_vdd_vdd_b1_vdd_b2_vdd_b3_vdd_b4_vdd_link_vdd_link_dip_vdd_x1_vdd_x2_vdd_x3_t139 r0 *1 0,0
Ra_d_inv_clk_vdd_inv_mc_vdd_inv_q_vdd_mpa_py_mpb_py_nand_m_vdd_nand_s2_vdd_nwell_vdd_sb_vdd_sr1_vdd_sr2_vdd_sr3_vdd_sr4_vdd_sv_d_vdd_tie_sv_vdd_tg_d_a_tg_d_vdd_tg_fbm_vdd_tg_fbs_vdd_tg_s_vdd_vdd_vdd_b1_vdd_b2_vdd_b3_vdd_b4_vdd_link_vdd_link_dip_vdd_x1_vdd_x2_vdd_x3_t139
+ a|d|inv_clk_vdd|inv_mc_vdd|inv_q_vdd|mpa_py|mpb_py|nand_m_vdd|nand_s2_vdd|nwell_vdd|sb_vdd|sr1_vdd|sr2_vdd|sr3_vdd|sr4_vdd|sv_d_vdd_tie|sv_vdd|tg_d_a|tg_d_vdd|tg_fbm_vdd|tg_fbs_vdd|tg_s_vdd|vdd|vdd_b1|vdd_b2|vdd_b3|vdd_b4|vdd_link|vdd_link_dip|vdd_x1|vdd_x2|vdd_x3__t139
+ a|d|inv_clk_vdd|inv_mc_vdd|inv_q_vdd|mpa_py|mpb_py|nand_m_vdd|nand_s2_vdd|nwell_vdd|sb_vdd|sr1_vdd|sr2_vdd|sr3_vdd|sr4_vdd|sv_d_vdd_tie|sv_vdd|tg_d_a|tg_d_vdd|tg_fbm_vdd|tg_fbs_vdd|tg_s_vdd|vdd|vdd_b1|vdd_b2|vdd_b3|vdd_b4|vdd_link|vdd_link_dip|vdd_x1|vdd_x2|vdd_x3
+ 129.05517831
* device instance a_d_inv_clk_vdd_inv_mc_vdd_inv_q_vdd_mpa_py_mpb_py_nand_m_vdd_nand_s2_vdd_nwell_vdd_sb_vdd_sr1_vdd_sr2_vdd_sr3_vdd_sr4_vdd_sv_d_vdd_tie_sv_vdd_tg_d_a_tg_d_vdd_tg_fbm_vdd_tg_fbs_vdd_tg_s_vdd_vdd_vdd_b1_vdd_b2_vdd_b3_vdd_b4_vdd_link_vdd_link_dip_vdd_x1_vdd_x2_vdd_x3_t140 r0 *1 0,0
Ra_d_inv_clk_vdd_inv_mc_vdd_inv_q_vdd_mpa_py_mpb_py_nand_m_vdd_nand_s2_vdd_nwell_vdd_sb_vdd_sr1_vdd_sr2_vdd_sr3_vdd_sr4_vdd_sv_d_vdd_tie_sv_vdd_tg_d_a_tg_d_vdd_tg_fbm_vdd_tg_fbs_vdd_tg_s_vdd_vdd_vdd_b1_vdd_b2_vdd_b3_vdd_b4_vdd_link_vdd_link_dip_vdd_x1_vdd_x2_vdd_x3_t140
+ a|d|inv_clk_vdd|inv_mc_vdd|inv_q_vdd|mpa_py|mpb_py|nand_m_vdd|nand_s2_vdd|nwell_vdd|sb_vdd|sr1_vdd|sr2_vdd|sr3_vdd|sr4_vdd|sv_d_vdd_tie|sv_vdd|tg_d_a|tg_d_vdd|tg_fbm_vdd|tg_fbs_vdd|tg_s_vdd|vdd|vdd_b1|vdd_b2|vdd_b3|vdd_b4|vdd_link|vdd_link_dip|vdd_x1|vdd_x2|vdd_x3__t140
+ a|d|inv_clk_vdd|inv_mc_vdd|inv_q_vdd|mpa_py|mpb_py|nand_m_vdd|nand_s2_vdd|nwell_vdd|sb_vdd|sr1_vdd|sr2_vdd|sr3_vdd|sr4_vdd|sv_d_vdd_tie|sv_vdd|tg_d_a|tg_d_vdd|tg_fbm_vdd|tg_fbs_vdd|tg_s_vdd|vdd|vdd_b1|vdd_b2|vdd_b3|vdd_b4|vdd_link|vdd_link_dip|vdd_x1|vdd_x2|vdd_x3
+ 182.380731422
* device instance a_d_inv_clk_vdd_inv_mc_vdd_inv_q_vdd_mpa_py_mpb_py_nand_m_vdd_nand_s2_vdd_nwell_vdd_sb_vdd_sr1_vdd_sr2_vdd_sr3_vdd_sr4_vdd_sv_d_vdd_tie_sv_vdd_tg_d_a_tg_d_vdd_tg_fbm_vdd_tg_fbs_vdd_tg_s_vdd_vdd_vdd_b1_vdd_b2_vdd_b3_vdd_b4_vdd_link_vdd_link_dip_vdd_x1_vdd_x2_vdd_x3_t141 r0 *1 0,0
Ra_d_inv_clk_vdd_inv_mc_vdd_inv_q_vdd_mpa_py_mpb_py_nand_m_vdd_nand_s2_vdd_nwell_vdd_sb_vdd_sr1_vdd_sr2_vdd_sr3_vdd_sr4_vdd_sv_d_vdd_tie_sv_vdd_tg_d_a_tg_d_vdd_tg_fbm_vdd_tg_fbs_vdd_tg_s_vdd_vdd_vdd_b1_vdd_b2_vdd_b3_vdd_b4_vdd_link_vdd_link_dip_vdd_x1_vdd_x2_vdd_x3_t141
+ a|d|inv_clk_vdd|inv_mc_vdd|inv_q_vdd|mpa_py|mpb_py|nand_m_vdd|nand_s2_vdd|nwell_vdd|sb_vdd|sr1_vdd|sr2_vdd|sr3_vdd|sr4_vdd|sv_d_vdd_tie|sv_vdd|tg_d_a|tg_d_vdd|tg_fbm_vdd|tg_fbs_vdd|tg_s_vdd|vdd|vdd_b1|vdd_b2|vdd_b3|vdd_b4|vdd_link|vdd_link_dip|vdd_x1|vdd_x2|vdd_x3__t141
+ a|d|inv_clk_vdd|inv_mc_vdd|inv_q_vdd|mpa_py|mpb_py|nand_m_vdd|nand_s2_vdd|nwell_vdd|sb_vdd|sr1_vdd|sr2_vdd|sr3_vdd|sr4_vdd|sv_d_vdd_tie|sv_vdd|tg_d_a|tg_d_vdd|tg_fbm_vdd|tg_fbs_vdd|tg_s_vdd|vdd|vdd_b1|vdd_b2|vdd_b3|vdd_b4|vdd_link|vdd_link_dip|vdd_x1|vdd_x2|vdd_x3
+ 23.2346706982
* device instance a_d_inv_clk_vdd_inv_mc_vdd_inv_q_vdd_mpa_py_mpb_py_nand_m_vdd_nand_s2_vdd_nwell_vdd_sb_vdd_sr1_vdd_sr2_vdd_sr3_vdd_sr4_vdd_sv_d_vdd_tie_sv_vdd_tg_d_a_tg_d_vdd_tg_fbm_vdd_tg_fbs_vdd_tg_s_vdd_vdd_vdd_b1_vdd_b2_vdd_b3_vdd_b4_vdd_link_vdd_link_dip_vdd_x1_vdd_x2_vdd_x3_t142 r0 *1 0,0
Ra_d_inv_clk_vdd_inv_mc_vdd_inv_q_vdd_mpa_py_mpb_py_nand_m_vdd_nand_s2_vdd_nwell_vdd_sb_vdd_sr1_vdd_sr2_vdd_sr3_vdd_sr4_vdd_sv_d_vdd_tie_sv_vdd_tg_d_a_tg_d_vdd_tg_fbm_vdd_tg_fbs_vdd_tg_s_vdd_vdd_vdd_b1_vdd_b2_vdd_b3_vdd_b4_vdd_link_vdd_link_dip_vdd_x1_vdd_x2_vdd_x3_t142
+ a|d|inv_clk_vdd|inv_mc_vdd|inv_q_vdd|mpa_py|mpb_py|nand_m_vdd|nand_s2_vdd|nwell_vdd|sb_vdd|sr1_vdd|sr2_vdd|sr3_vdd|sr4_vdd|sv_d_vdd_tie|sv_vdd|tg_d_a|tg_d_vdd|tg_fbm_vdd|tg_fbs_vdd|tg_s_vdd|vdd|vdd_b1|vdd_b2|vdd_b3|vdd_b4|vdd_link|vdd_link_dip|vdd_x1|vdd_x2|vdd_x3__t142
+ a|d|inv_clk_vdd|inv_mc_vdd|inv_q_vdd|mpa_py|mpb_py|nand_m_vdd|nand_s2_vdd|nwell_vdd|sb_vdd|sr1_vdd|sr2_vdd|sr3_vdd|sr4_vdd|sv_d_vdd_tie|sv_vdd|tg_d_a|tg_d_vdd|tg_fbm_vdd|tg_fbs_vdd|tg_s_vdd|vdd|vdd_b1|vdd_b2|vdd_b3|vdd_b4|vdd_link|vdd_link_dip|vdd_x1|vdd_x2|vdd_x3
+ 100.442732907
* device instance a_d_inv_clk_vdd_inv_mc_vdd_inv_q_vdd_mpa_py_mpb_py_nand_m_vdd_nand_s2_vdd_nwell_vdd_sb_vdd_sr1_vdd_sr2_vdd_sr3_vdd_sr4_vdd_sv_d_vdd_tie_sv_vdd_tg_d_a_tg_d_vdd_tg_fbm_vdd_tg_fbs_vdd_tg_s_vdd_vdd_vdd_b1_vdd_b2_vdd_b3_vdd_b4_vdd_link_vdd_link_dip_vdd_x1_vdd_x2_vdd_x3_t143 r0 *1 0,0
Ra_d_inv_clk_vdd_inv_mc_vdd_inv_q_vdd_mpa_py_mpb_py_nand_m_vdd_nand_s2_vdd_nwell_vdd_sb_vdd_sr1_vdd_sr2_vdd_sr3_vdd_sr4_vdd_sv_d_vdd_tie_sv_vdd_tg_d_a_tg_d_vdd_tg_fbm_vdd_tg_fbs_vdd_tg_s_vdd_vdd_vdd_b1_vdd_b2_vdd_b3_vdd_b4_vdd_link_vdd_link_dip_vdd_x1_vdd_x2_vdd_x3_t143
+ a|d|inv_clk_vdd|inv_mc_vdd|inv_q_vdd|mpa_py|mpb_py|nand_m_vdd|nand_s2_vdd|nwell_vdd|sb_vdd|sr1_vdd|sr2_vdd|sr3_vdd|sr4_vdd|sv_d_vdd_tie|sv_vdd|tg_d_a|tg_d_vdd|tg_fbm_vdd|tg_fbs_vdd|tg_s_vdd|vdd|vdd_b1|vdd_b2|vdd_b3|vdd_b4|vdd_link|vdd_link_dip|vdd_x1|vdd_x2|vdd_x3__t143
+ a|d|inv_clk_vdd|inv_mc_vdd|inv_q_vdd|mpa_py|mpb_py|nand_m_vdd|nand_s2_vdd|nwell_vdd|sb_vdd|sr1_vdd|sr2_vdd|sr3_vdd|sr4_vdd|sv_d_vdd_tie|sv_vdd|tg_d_a|tg_d_vdd|tg_fbm_vdd|tg_fbs_vdd|tg_s_vdd|vdd|vdd_b1|vdd_b2|vdd_b3|vdd_b4|vdd_link|vdd_link_dip|vdd_x1|vdd_x2|vdd_x3
+ 48.8489499379
* device instance a_d_inv_clk_vdd_inv_mc_vdd_inv_q_vdd_mpa_py_mpb_py_nand_m_vdd_nand_s2_vdd_nwell_vdd_sb_vdd_sr1_vdd_sr2_vdd_sr3_vdd_sr4_vdd_sv_d_vdd_tie_sv_vdd_tg_d_a_tg_d_vdd_tg_fbm_vdd_tg_fbs_vdd_tg_s_vdd_vdd_vdd_b1_vdd_b2_vdd_b3_vdd_b4_vdd_link_vdd_link_dip_vdd_x1_vdd_x2_vdd_x3_t144 r0 *1 0,0
Ra_d_inv_clk_vdd_inv_mc_vdd_inv_q_vdd_mpa_py_mpb_py_nand_m_vdd_nand_s2_vdd_nwell_vdd_sb_vdd_sr1_vdd_sr2_vdd_sr3_vdd_sr4_vdd_sv_d_vdd_tie_sv_vdd_tg_d_a_tg_d_vdd_tg_fbm_vdd_tg_fbs_vdd_tg_s_vdd_vdd_vdd_b1_vdd_b2_vdd_b3_vdd_b4_vdd_link_vdd_link_dip_vdd_x1_vdd_x2_vdd_x3_t144
+ a|d|inv_clk_vdd|inv_mc_vdd|inv_q_vdd|mpa_py|mpb_py|nand_m_vdd|nand_s2_vdd|nwell_vdd|sb_vdd|sr1_vdd|sr2_vdd|sr3_vdd|sr4_vdd|sv_d_vdd_tie|sv_vdd|tg_d_a|tg_d_vdd|tg_fbm_vdd|tg_fbs_vdd|tg_s_vdd|vdd|vdd_b1|vdd_b2|vdd_b3|vdd_b4|vdd_link|vdd_link_dip|vdd_x1|vdd_x2|vdd_x3__t144
+ a|d|inv_clk_vdd|inv_mc_vdd|inv_q_vdd|mpa_py|mpb_py|nand_m_vdd|nand_s2_vdd|nwell_vdd|sb_vdd|sr1_vdd|sr2_vdd|sr3_vdd|sr4_vdd|sv_d_vdd_tie|sv_vdd|tg_d_a|tg_d_vdd|tg_fbm_vdd|tg_fbs_vdd|tg_s_vdd|vdd|vdd_b1|vdd_b2|vdd_b3|vdd_b4|vdd_link|vdd_link_dip|vdd_x1|vdd_x2|vdd_x3
+ 30.522932681
* device instance a_d_inv_clk_vdd_inv_mc_vdd_inv_q_vdd_mpa_py_mpb_py_nand_m_vdd_nand_s2_vdd_nwell_vdd_sb_vdd_sr1_vdd_sr2_vdd_sr3_vdd_sr4_vdd_sv_d_vdd_tie_sv_vdd_tg_d_a_tg_d_vdd_tg_fbm_vdd_tg_fbs_vdd_tg_s_vdd_vdd_vdd_b1_vdd_b2_vdd_b3_vdd_b4_vdd_link_vdd_link_dip_vdd_x1_vdd_x2_vdd_x3_t145 r0 *1 0,0
Ra_d_inv_clk_vdd_inv_mc_vdd_inv_q_vdd_mpa_py_mpb_py_nand_m_vdd_nand_s2_vdd_nwell_vdd_sb_vdd_sr1_vdd_sr2_vdd_sr3_vdd_sr4_vdd_sv_d_vdd_tie_sv_vdd_tg_d_a_tg_d_vdd_tg_fbm_vdd_tg_fbs_vdd_tg_s_vdd_vdd_vdd_b1_vdd_b2_vdd_b3_vdd_b4_vdd_link_vdd_link_dip_vdd_x1_vdd_x2_vdd_x3_t145
+ a|d|inv_clk_vdd|inv_mc_vdd|inv_q_vdd|mpa_py|mpb_py|nand_m_vdd|nand_s2_vdd|nwell_vdd|sb_vdd|sr1_vdd|sr2_vdd|sr3_vdd|sr4_vdd|sv_d_vdd_tie|sv_vdd|tg_d_a|tg_d_vdd|tg_fbm_vdd|tg_fbs_vdd|tg_s_vdd|vdd|vdd_b1|vdd_b2|vdd_b3|vdd_b4|vdd_link|vdd_link_dip|vdd_x1|vdd_x2|vdd_x3__t145
+ a|d|inv_clk_vdd|inv_mc_vdd|inv_q_vdd|mpa_py|mpb_py|nand_m_vdd|nand_s2_vdd|nwell_vdd|sb_vdd|sr1_vdd|sr2_vdd|sr3_vdd|sr4_vdd|sv_d_vdd_tie|sv_vdd|tg_d_a|tg_d_vdd|tg_fbm_vdd|tg_fbs_vdd|tg_s_vdd|vdd|vdd_b1|vdd_b2|vdd_b3|vdd_b4|vdd_link|vdd_link_dip|vdd_x1|vdd_x2|vdd_x3
+ 137.245030204
* device instance a_d_inv_clk_vdd_inv_mc_vdd_inv_q_vdd_mpa_py_mpb_py_nand_m_vdd_nand_s2_vdd_nwell_vdd_sb_vdd_sr1_vdd_sr2_vdd_sr3_vdd_sr4_vdd_sv_d_vdd_tie_sv_vdd_tg_d_a_tg_d_vdd_tg_fbm_vdd_tg_fbs_vdd_tg_s_vdd_vdd_vdd_b1_vdd_b2_vdd_b3_vdd_b4_vdd_link_vdd_link_dip_vdd_x1_vdd_x2_vdd_x3_t146 r0 *1 0,0
Ra_d_inv_clk_vdd_inv_mc_vdd_inv_q_vdd_mpa_py_mpb_py_nand_m_vdd_nand_s2_vdd_nwell_vdd_sb_vdd_sr1_vdd_sr2_vdd_sr3_vdd_sr4_vdd_sv_d_vdd_tie_sv_vdd_tg_d_a_tg_d_vdd_tg_fbm_vdd_tg_fbs_vdd_tg_s_vdd_vdd_vdd_b1_vdd_b2_vdd_b3_vdd_b4_vdd_link_vdd_link_dip_vdd_x1_vdd_x2_vdd_x3_t146
+ a|d|inv_clk_vdd|inv_mc_vdd|inv_q_vdd|mpa_py|mpb_py|nand_m_vdd|nand_s2_vdd|nwell_vdd|sb_vdd|sr1_vdd|sr2_vdd|sr3_vdd|sr4_vdd|sv_d_vdd_tie|sv_vdd|tg_d_a|tg_d_vdd|tg_fbm_vdd|tg_fbs_vdd|tg_s_vdd|vdd|vdd_b1|vdd_b2|vdd_b3|vdd_b4|vdd_link|vdd_link_dip|vdd_x1|vdd_x2|vdd_x3__t146
+ a|d|inv_clk_vdd|inv_mc_vdd|inv_q_vdd|mpa_py|mpb_py|nand_m_vdd|nand_s2_vdd|nwell_vdd|sb_vdd|sr1_vdd|sr2_vdd|sr3_vdd|sr4_vdd|sv_d_vdd_tie|sv_vdd|tg_d_a|tg_d_vdd|tg_fbm_vdd|tg_fbs_vdd|tg_s_vdd|vdd|vdd_b1|vdd_b2|vdd_b3|vdd_b4|vdd_link|vdd_link_dip|vdd_x1|vdd_x2|vdd_x3
+ 76.2777489005
* device instance a_d_inv_clk_vdd_inv_mc_vdd_inv_q_vdd_mpa_py_mpb_py_nand_m_vdd_nand_s2_vdd_nwell_vdd_sb_vdd_sr1_vdd_sr2_vdd_sr3_vdd_sr4_vdd_sv_d_vdd_tie_sv_vdd_tg_d_a_tg_d_vdd_tg_fbm_vdd_tg_fbs_vdd_tg_s_vdd_vdd_vdd_b1_vdd_b2_vdd_b3_vdd_b4_vdd_link_vdd_link_dip_vdd_x1_vdd_x2_vdd_x3_t147 r0 *1 0,0
Ra_d_inv_clk_vdd_inv_mc_vdd_inv_q_vdd_mpa_py_mpb_py_nand_m_vdd_nand_s2_vdd_nwell_vdd_sb_vdd_sr1_vdd_sr2_vdd_sr3_vdd_sr4_vdd_sv_d_vdd_tie_sv_vdd_tg_d_a_tg_d_vdd_tg_fbm_vdd_tg_fbs_vdd_tg_s_vdd_vdd_vdd_b1_vdd_b2_vdd_b3_vdd_b4_vdd_link_vdd_link_dip_vdd_x1_vdd_x2_vdd_x3_t147
+ a|d|inv_clk_vdd|inv_mc_vdd|inv_q_vdd|mpa_py|mpb_py|nand_m_vdd|nand_s2_vdd|nwell_vdd|sb_vdd|sr1_vdd|sr2_vdd|sr3_vdd|sr4_vdd|sv_d_vdd_tie|sv_vdd|tg_d_a|tg_d_vdd|tg_fbm_vdd|tg_fbs_vdd|tg_s_vdd|vdd|vdd_b1|vdd_b2|vdd_b3|vdd_b4|vdd_link|vdd_link_dip|vdd_x1|vdd_x2|vdd_x3__t147
+ a|d|inv_clk_vdd|inv_mc_vdd|inv_q_vdd|mpa_py|mpb_py|nand_m_vdd|nand_s2_vdd|nwell_vdd|sb_vdd|sr1_vdd|sr2_vdd|sr3_vdd|sr4_vdd|sv_d_vdd_tie|sv_vdd|tg_d_a|tg_d_vdd|tg_fbm_vdd|tg_fbs_vdd|tg_s_vdd|vdd|vdd_b1|vdd_b2|vdd_b3|vdd_b4|vdd_link|vdd_link_dip|vdd_x1|vdd_x2|vdd_x3
+ 101.092545773
* device instance a_d_inv_clk_vdd_inv_mc_vdd_inv_q_vdd_mpa_py_mpb_py_nand_m_vdd_nand_s2_vdd_nwell_vdd_sb_vdd_sr1_vdd_sr2_vdd_sr3_vdd_sr4_vdd_sv_d_vdd_tie_sv_vdd_tg_d_a_tg_d_vdd_tg_fbm_vdd_tg_fbs_vdd_tg_s_vdd_vdd_vdd_b1_vdd_b2_vdd_b3_vdd_b4_vdd_link_vdd_link_dip_vdd_x1_vdd_x2_vdd_x3 r0 *1 0,0
Ca_d_inv_clk_vdd_inv_mc_vdd_inv_q_vdd_mpa_py_mpb_py_nand_m_vdd_nand_s2_vdd_nwell_vdd_sb_vdd_sr1_vdd_sr2_vdd_sr3_vdd_sr4_vdd_sv_d_vdd_tie_sv_vdd_tg_d_a_tg_d_vdd_tg_fbm_vdd_tg_fbs_vdd_tg_s_vdd_vdd_vdd_b1_vdd_b2_vdd_b3_vdd_b4_vdd_link_vdd_link_dip_vdd_x1_vdd_x2_vdd_x3
+ a|d|inv_clk_vdd|inv_mc_vdd|inv_q_vdd|mpa_py|mpb_py|nand_m_vdd|nand_s2_vdd|nwell_vdd|sb_vdd|sr1_vdd|sr2_vdd|sr3_vdd|sr4_vdd|sv_d_vdd_tie|sv_vdd|tg_d_a|tg_d_vdd|tg_fbm_vdd|tg_fbs_vdd|tg_s_vdd|vdd|vdd_b1|vdd_b2|vdd_b3|vdd_b4|vdd_link|vdd_link_dip|vdd_x1|vdd_x2|vdd_x3
+ vsubs 1.30595139e-13
* device instance a_d_inva_a_mn12_g0_mp13_g0_ro1_ro1_esc_sr1_d_stub_tg_d_a_y_t0 r0 *1 0,0
Ra_d_inva_a_mn12_g0_mp13_g0_ro1_ro1_esc_sr1_d_stub_tg_d_a_y_t0
+ a|d|inva_a|mn12_g0|mp13_g0|ro1|ro1_esc|sr1_d_stub|tg_d_a|y__t0
+ a|d|inva_a|mn12_g0|mp13_g0|ro1|ro1_esc|sr1_d_stub|tg_d_a|y 241.625140689
* device instance a_d_inva_a_mn12_g0_mp13_g0_ro1_ro1_esc_sr1_d_stub_tg_d_a_y_t1 r0 *1 0,0
Ra_d_inva_a_mn12_g0_mp13_g0_ro1_ro1_esc_sr1_d_stub_tg_d_a_y_t1
+ a|d|inva_a|mn12_g0|mp13_g0|ro1|ro1_esc|sr1_d_stub|tg_d_a|y__t1
+ a|d|inva_a|mn12_g0|mp13_g0|ro1|ro1_esc|sr1_d_stub|tg_d_a|y 23.3863836703
* device instance a_d_inva_a_mn12_g0_mp13_g0_ro1_ro1_esc_sr1_d_stub_tg_d_a_y_t2 r0 *1 0,0
Ra_d_inva_a_mn12_g0_mp13_g0_ro1_ro1_esc_sr1_d_stub_tg_d_a_y_t2
+ a|d|inva_a|mn12_g0|mp13_g0|ro1|ro1_esc|sr1_d_stub|tg_d_a|y__t2
+ a|d|inva_a|mn12_g0|mp13_g0|ro1|ro1_esc|sr1_d_stub|tg_d_a|y 428.386996214
* device instance a_d_inva_a_mn12_g0_mp13_g0_ro1_ro1_esc_sr1_d_stub_tg_d_a_y_t3 r0 *1 0,0
Ra_d_inva_a_mn12_g0_mp13_g0_ro1_ro1_esc_sr1_d_stub_tg_d_a_y_t3
+ a|d|inva_a|mn12_g0|mp13_g0|ro1|ro1_esc|sr1_d_stub|tg_d_a|y__t3
+ a|d|inva_a|mn12_g0|mp13_g0|ro1|ro1_esc|sr1_d_stub|tg_d_a|y 34.9604041223
* device instance a_d_inva_a_mn12_g0_mp13_g0_ro1_ro1_esc_sr1_d_stub_tg_d_a_y_t4 r0 *1 0,0
Ra_d_inva_a_mn12_g0_mp13_g0_ro1_ro1_esc_sr1_d_stub_tg_d_a_y_t4
+ a|d|inva_a|mn12_g0|mp13_g0|ro1|ro1_esc|sr1_d_stub|tg_d_a|y__t4
+ a|d|inva_a|mn12_g0|mp13_g0|ro1|ro1_esc|sr1_d_stub|tg_d_a|y 434.957769124
* device instance a_d_inva_a_mn12_g0_mp13_g0_ro1_ro1_esc_sr1_d_stub_tg_d_a_y_t5 r0 *1 0,0
Ra_d_inva_a_mn12_g0_mp13_g0_ro1_ro1_esc_sr1_d_stub_tg_d_a_y_t5
+ a|d|inva_a|mn12_g0|mp13_g0|ro1|ro1_esc|sr1_d_stub|tg_d_a|y__t5
+ a|d|inva_a|mn12_g0|mp13_g0|ro1|ro1_esc|sr1_d_stub|tg_d_a|y 251.660758886
* device instance a_d_inva_a_mn12_g0_mp13_g0_ro1_ro1_esc_sr1_d_stub_tg_d_a_y_t6 r0 *1 0,0
Ra_d_inva_a_mn12_g0_mp13_g0_ro1_ro1_esc_sr1_d_stub_tg_d_a_y_t6
+ a|d|inva_a|mn12_g0|mp13_g0|ro1|ro1_esc|sr1_d_stub|tg_d_a|y__t6
+ a|d|inva_a|mn12_g0|mp13_g0|ro1|ro1_esc|sr1_d_stub|tg_d_a|y 245.493178251
* device instance a_d_inva_a_mn12_g0_mp13_g0_ro1_ro1_esc_sr1_d_stub_tg_d_a_y_t7 r0 *1 0,0
Ra_d_inva_a_mn12_g0_mp13_g0_ro1_ro1_esc_sr1_d_stub_tg_d_a_y_t7
+ a|d|inva_a|mn12_g0|mp13_g0|ro1|ro1_esc|sr1_d_stub|tg_d_a|y__t7
+ a|d|inva_a|mn12_g0|mp13_g0|ro1|ro1_esc|sr1_d_stub|tg_d_a|y 180.626969044
* device instance a_d_inva_a_mn12_g0_mp13_g0_ro1_ro1_esc_sr1_d_stub_tg_d_a_y r0 *1 0,0
Ca_d_inva_a_mn12_g0_mp13_g0_ro1_ro1_esc_sr1_d_stub_tg_d_a_y
+ a|d|inva_a|mn12_g0|mp13_g0|ro1|ro1_esc|sr1_d_stub|tg_d_a|y vsubs 2.4132638e-14
* device instance a_d_inva_a_mn12_g0_mp13_g0_ro3_ro3_esc_e_ro3_esc_w_ro3_hop_sr3_d_stub_tg_d_a_y_t0 r0 *1 0,0
Ra_d_inva_a_mn12_g0_mp13_g0_ro3_ro3_esc_e_ro3_esc_w_ro3_hop_sr3_d_stub_tg_d_a_y_t0
+ a|d|inva_a|mn12_g0|mp13_g0|ro3|ro3_esc_e|ro3_esc_w|ro3_hop|sr3_d_stub|tg_d_a|y__t0
+ a|d|inva_a|mn12_g0|mp13_g0|ro3|ro3_esc_e|ro3_esc_w|ro3_hop|sr3_d_stub|tg_d_a|y
+ 253.173111403
* device instance a_d_inva_a_mn12_g0_mp13_g0_ro3_ro3_esc_e_ro3_esc_w_ro3_hop_sr3_d_stub_tg_d_a_y_t1 r0 *1 0,0
Ra_d_inva_a_mn12_g0_mp13_g0_ro3_ro3_esc_e_ro3_esc_w_ro3_hop_sr3_d_stub_tg_d_a_y_t1
+ a|d|inva_a|mn12_g0|mp13_g0|ro3|ro3_esc_e|ro3_esc_w|ro3_hop|sr3_d_stub|tg_d_a|y__t1
+ a|d|inva_a|mn12_g0|mp13_g0|ro3|ro3_esc_e|ro3_esc_w|ro3_hop|sr3_d_stub|tg_d_a|y
+ 138.763975578
* device instance a_d_inva_a_mn12_g0_mp13_g0_ro3_ro3_esc_e_ro3_esc_w_ro3_hop_sr3_d_stub_tg_d_a_y_t2 r0 *1 0,0
Ra_d_inva_a_mn12_g0_mp13_g0_ro3_ro3_esc_e_ro3_esc_w_ro3_hop_sr3_d_stub_tg_d_a_y_t2
+ a|d|inva_a|mn12_g0|mp13_g0|ro3|ro3_esc_e|ro3_esc_w|ro3_hop|sr3_d_stub|tg_d_a|y__t2
+ a|d|inva_a|mn12_g0|mp13_g0|ro3|ro3_esc_e|ro3_esc_w|ro3_hop|sr3_d_stub|tg_d_a|y
+ 360.832767757
* device instance a_d_inva_a_mn12_g0_mp13_g0_ro3_ro3_esc_e_ro3_esc_w_ro3_hop_sr3_d_stub_tg_d_a_y_t3 r0 *1 0,0
Ra_d_inva_a_mn12_g0_mp13_g0_ro3_ro3_esc_e_ro3_esc_w_ro3_hop_sr3_d_stub_tg_d_a_y_t3
+ a|d|inva_a|mn12_g0|mp13_g0|ro3|ro3_esc_e|ro3_esc_w|ro3_hop|sr3_d_stub|tg_d_a|y__t3
+ a|d|inva_a|mn12_g0|mp13_g0|ro3|ro3_esc_e|ro3_esc_w|ro3_hop|sr3_d_stub|tg_d_a|y
+ 363.223914773
* device instance a_d_inva_a_mn12_g0_mp13_g0_ro3_ro3_esc_e_ro3_esc_w_ro3_hop_sr3_d_stub_tg_d_a_y_t4 r0 *1 0,0
Ra_d_inva_a_mn12_g0_mp13_g0_ro3_ro3_esc_e_ro3_esc_w_ro3_hop_sr3_d_stub_tg_d_a_y_t4
+ a|d|inva_a|mn12_g0|mp13_g0|ro3|ro3_esc_e|ro3_esc_w|ro3_hop|sr3_d_stub|tg_d_a|y__t4
+ a|d|inva_a|mn12_g0|mp13_g0|ro3|ro3_esc_e|ro3_esc_w|ro3_hop|sr3_d_stub|tg_d_a|y
+ 139.504629136
* device instance a_d_inva_a_mn12_g0_mp13_g0_ro3_ro3_esc_e_ro3_esc_w_ro3_hop_sr3_d_stub_tg_d_a_y_t5 r0 *1 0,0
Ra_d_inva_a_mn12_g0_mp13_g0_ro3_ro3_esc_e_ro3_esc_w_ro3_hop_sr3_d_stub_tg_d_a_y_t5
+ a|d|inva_a|mn12_g0|mp13_g0|ro3|ro3_esc_e|ro3_esc_w|ro3_hop|sr3_d_stub|tg_d_a|y__t5
+ a|d|inva_a|mn12_g0|mp13_g0|ro3|ro3_esc_e|ro3_esc_w|ro3_hop|sr3_d_stub|tg_d_a|y
+ 262.264906181
* device instance a_d_inva_a_mn12_g0_mp13_g0_ro3_ro3_esc_e_ro3_esc_w_ro3_hop_sr3_d_stub_tg_d_a_y_t6 r0 *1 0,0
Ra_d_inva_a_mn12_g0_mp13_g0_ro3_ro3_esc_e_ro3_esc_w_ro3_hop_sr3_d_stub_tg_d_a_y_t6
+ a|d|inva_a|mn12_g0|mp13_g0|ro3|ro3_esc_e|ro3_esc_w|ro3_hop|sr3_d_stub|tg_d_a|y__t6
+ a|d|inva_a|mn12_g0|mp13_g0|ro3|ro3_esc_e|ro3_esc_w|ro3_hop|sr3_d_stub|tg_d_a|y
+ 260.474719078
* device instance a_d_inva_a_mn12_g0_mp13_g0_ro3_ro3_esc_e_ro3_esc_w_ro3_hop_sr3_d_stub_tg_d_a_y_t7 r0 *1 0,0
Ra_d_inva_a_mn12_g0_mp13_g0_ro3_ro3_esc_e_ro3_esc_w_ro3_hop_sr3_d_stub_tg_d_a_y_t7
+ a|d|inva_a|mn12_g0|mp13_g0|ro3|ro3_esc_e|ro3_esc_w|ro3_hop|sr3_d_stub|tg_d_a|y__t7
+ a|d|inva_a|mn12_g0|mp13_g0|ro3|ro3_esc_e|ro3_esc_w|ro3_hop|sr3_d_stub|tg_d_a|y
+ 224.452776094
* device instance a_d_inva_a_mn12_g0_mp13_g0_ro3_ro3_esc_e_ro3_esc_w_ro3_hop_sr3_d_stub_tg_d_a_y r0 *1 0,0
Ca_d_inva_a_mn12_g0_mp13_g0_ro3_ro3_esc_e_ro3_esc_w_ro3_hop_sr3_d_stub_tg_d_a_y
+ a|d|inva_a|mn12_g0|mp13_g0|ro3|ro3_esc_e|ro3_esc_w|ro3_hop|sr3_d_stub|tg_d_a|y
+ vsubs 4.2174205e-14
* device instance a_d_sb_d_stub_tg_d_a_xo_xo_dip_xo_hop_xo_stub_y_t0 r0 *1 0,0
Ra_d_sb_d_stub_tg_d_a_xo_xo_dip_xo_hop_xo_stub_y_t0
+ a|d|sb_d_stub|tg_d_a|xo|xo_dip|xo_hop|xo_stub|y__t0
+ a|d|sb_d_stub|tg_d_a|xo|xo_dip|xo_hop|xo_stub|y 309.65915439
* device instance a_d_sb_d_stub_tg_d_a_xo_xo_dip_xo_hop_xo_stub_y_t1 r0 *1 0,0
Ra_d_sb_d_stub_tg_d_a_xo_xo_dip_xo_hop_xo_stub_y_t1
+ a|d|sb_d_stub|tg_d_a|xo|xo_dip|xo_hop|xo_stub|y__t1
+ a|d|sb_d_stub|tg_d_a|xo|xo_dip|xo_hop|xo_stub|y 366.268766032
* device instance a_d_sb_d_stub_tg_d_a_xo_xo_dip_xo_hop_xo_stub_y_t2 r0 *1 0,0
Ra_d_sb_d_stub_tg_d_a_xo_xo_dip_xo_hop_xo_stub_y_t2
+ a|d|sb_d_stub|tg_d_a|xo|xo_dip|xo_hop|xo_stub|y__t2
+ a|d|sb_d_stub|tg_d_a|xo|xo_dip|xo_hop|xo_stub|y 590.792974152
* device instance a_d_sb_d_stub_tg_d_a_xo_xo_dip_xo_hop_xo_stub_y_t3 r0 *1 0,0
Ra_d_sb_d_stub_tg_d_a_xo_xo_dip_xo_hop_xo_stub_y_t3
+ a|d|sb_d_stub|tg_d_a|xo|xo_dip|xo_hop|xo_stub|y__t3
+ a|d|sb_d_stub|tg_d_a|xo|xo_dip|xo_hop|xo_stub|y 612.347438434
* device instance a_d_sb_d_stub_tg_d_a_xo_xo_dip_xo_hop_xo_stub_y_t4 r0 *1 0,0
Ra_d_sb_d_stub_tg_d_a_xo_xo_dip_xo_hop_xo_stub_y_t4
+ a|d|sb_d_stub|tg_d_a|xo|xo_dip|xo_hop|xo_stub|y__t4
+ a|d|sb_d_stub|tg_d_a|xo|xo_dip|xo_hop|xo_stub|y 235.041332418
* device instance a_d_sb_d_stub_tg_d_a_xo_xo_dip_xo_hop_xo_stub_y_t5 r0 *1 0,0
Ra_d_sb_d_stub_tg_d_a_xo_xo_dip_xo_hop_xo_stub_y_t5
+ a|d|sb_d_stub|tg_d_a|xo|xo_dip|xo_hop|xo_stub|y__t5
+ a|d|sb_d_stub|tg_d_a|xo|xo_dip|xo_hop|xo_stub|y 310.584634574
* device instance a_d_sb_d_stub_tg_d_a_xo_xo_dip_xo_hop_xo_stub_y r0 *1 0,0
Ca_d_sb_d_stub_tg_d_a_xo_xo_dip_xo_hop_xo_stub_y
+ a|d|sb_d_stub|tg_d_a|xo|xo_dip|xo_hop|xo_stub|y vsubs 1.4299822e-14
* device instance a_g_a_rn1_ro_s4_y_y_t0 r0 *1 0,0
Ra_g_a_rn1_ro_s4_y_y_t0 a|g_a|rn1|ro|s4_y|y__t0 a|g_a|rn1|ro|s4_y|y
+ 108.856657591
* device instance a_g_a_rn1_ro_s4_y_y_t1 r0 *1 0,0
Ra_g_a_rn1_ro_s4_y_y_t1 a|g_a|rn1|ro|s4_y|y__t1 a|g_a|rn1|ro|s4_y|y
+ 115.011240917
* device instance a_g_a_rn1_ro_s4_y_y_t2 r0 *1 0,0
Ra_g_a_rn1_ro_s4_y_y_t2 a|g_a|rn1|ro|s4_y|y__t2 a|g_a|rn1|ro|s4_y|y
+ 234.695939179
* device instance a_g_a_rn1_ro_s4_y_y_t3 r0 *1 0,0
Ra_g_a_rn1_ro_s4_y_y_t3 a|g_a|rn1|ro|s4_y|y__t3 a|g_a|rn1|ro|s4_y|y
+ 343.168292152
* device instance a_g_a_rn1_ro_s4_y_y_t4 r0 *1 0,0
Ra_g_a_rn1_ro_s4_y_y_t4 a|g_a|rn1|ro|s4_y|y__t4 a|g_a|rn1|ro|s4_y|y
+ 235.084690218
* device instance a_g_a_rn1_ro_s4_y_y_t5 r0 *1 0,0
Ra_g_a_rn1_ro_s4_y_y_t5 a|g_a|rn1|ro|s4_y|y__t5 a|g_a|rn1|ro|s4_y|y
+ 345.096279942
* device instance a_g_a_rn1_ro_s4_y_y r0 *1 0,0
Ca_g_a_rn1_ro_s4_y_y a|g_a|rn1|ro|s4_y|y vsubs 6.563292e-15
* device instance a_g_a_rn2_ro_s4_y_y_t0 r0 *1 0,0
Ra_g_a_rn2_ro_s4_y_y_t0 a|g_a|rn2|ro|s4_y|y__t0 a|g_a|rn2|ro|s4_y|y
+ 108.856657591
* device instance a_g_a_rn2_ro_s4_y_y_t1 r0 *1 0,0
Ra_g_a_rn2_ro_s4_y_y_t1 a|g_a|rn2|ro|s4_y|y__t1 a|g_a|rn2|ro|s4_y|y
+ 115.011240917
* device instance a_g_a_rn2_ro_s4_y_y_t2 r0 *1 0,0
Ra_g_a_rn2_ro_s4_y_y_t2 a|g_a|rn2|ro|s4_y|y__t2 a|g_a|rn2|ro|s4_y|y
+ 234.695939179
* device instance a_g_a_rn2_ro_s4_y_y_t3 r0 *1 0,0
Ra_g_a_rn2_ro_s4_y_y_t3 a|g_a|rn2|ro|s4_y|y__t3 a|g_a|rn2|ro|s4_y|y
+ 343.168292152
* device instance a_g_a_rn2_ro_s4_y_y_t4 r0 *1 0,0
Ra_g_a_rn2_ro_s4_y_y_t4 a|g_a|rn2|ro|s4_y|y__t4 a|g_a|rn2|ro|s4_y|y
+ 235.084690218
* device instance a_g_a_rn2_ro_s4_y_y_t5 r0 *1 0,0
Ra_g_a_rn2_ro_s4_y_y_t5 a|g_a|rn2|ro|s4_y|y__t5 a|g_a|rn2|ro|s4_y|y
+ 345.096279942
* device instance a_g_a_rn2_ro_s4_y_y r0 *1 0,0
Ca_g_a_rn2_ro_s4_y_y a|g_a|rn2|ro|s4_y|y vsubs 6.563292e-15
* device instance a_g_a_rn3_ro_s4_y_y_t0 r0 *1 0,0
Ra_g_a_rn3_ro_s4_y_y_t0 a|g_a|rn3|ro|s4_y|y__t0 a|g_a|rn3|ro|s4_y|y
+ 108.856657591
* device instance a_g_a_rn3_ro_s4_y_y_t1 r0 *1 0,0
Ra_g_a_rn3_ro_s4_y_y_t1 a|g_a|rn3|ro|s4_y|y__t1 a|g_a|rn3|ro|s4_y|y
+ 115.011240917
* device instance a_g_a_rn3_ro_s4_y_y_t2 r0 *1 0,0
Ra_g_a_rn3_ro_s4_y_y_t2 a|g_a|rn3|ro|s4_y|y__t2 a|g_a|rn3|ro|s4_y|y
+ 234.695939179
* device instance a_g_a_rn3_ro_s4_y_y_t3 r0 *1 0,0
Ra_g_a_rn3_ro_s4_y_y_t3 a|g_a|rn3|ro|s4_y|y__t3 a|g_a|rn3|ro|s4_y|y
+ 343.168292152
* device instance a_g_a_rn3_ro_s4_y_y_t4 r0 *1 0,0
Ra_g_a_rn3_ro_s4_y_y_t4 a|g_a|rn3|ro|s4_y|y__t4 a|g_a|rn3|ro|s4_y|y
+ 235.084690218
* device instance a_g_a_rn3_ro_s4_y_y_t5 r0 *1 0,0
Ra_g_a_rn3_ro_s4_y_y_t5 a|g_a|rn3|ro|s4_y|y__t5 a|g_a|rn3|ro|s4_y|y
+ 345.096279942
* device instance a_g_a_rn3_ro_s4_y_y r0 *1 0,0
Ca_g_a_rn3_ro_s4_y_y a|g_a|rn3|ro|s4_y|y vsubs 6.563292e-15
* device instance a_g_a_rn4_ro_s4_y_y_t0 r0 *1 0,0
Ra_g_a_rn4_ro_s4_y_y_t0 a|g_a|rn4|ro|s4_y|y__t0 a|g_a|rn4|ro|s4_y|y
+ 108.856657591
* device instance a_g_a_rn4_ro_s4_y_y_t1 r0 *1 0,0
Ra_g_a_rn4_ro_s4_y_y_t1 a|g_a|rn4|ro|s4_y|y__t1 a|g_a|rn4|ro|s4_y|y
+ 115.011240917
* device instance a_g_a_rn4_ro_s4_y_y_t2 r0 *1 0,0
Ra_g_a_rn4_ro_s4_y_y_t2 a|g_a|rn4|ro|s4_y|y__t2 a|g_a|rn4|ro|s4_y|y
+ 343.168292152
* device instance a_g_a_rn4_ro_s4_y_y_t3 r0 *1 0,0
Ra_g_a_rn4_ro_s4_y_y_t3 a|g_a|rn4|ro|s4_y|y__t3 a|g_a|rn4|ro|s4_y|y
+ 234.695939179
* device instance a_g_a_rn4_ro_s4_y_y_t4 r0 *1 0,0
Ra_g_a_rn4_ro_s4_y_y_t4 a|g_a|rn4|ro|s4_y|y__t4 a|g_a|rn4|ro|s4_y|y
+ 235.084690218
* device instance a_g_a_rn4_ro_s4_y_y_t5 r0 *1 0,0
Ra_g_a_rn4_ro_s4_y_y_t5 a|g_a|rn4|ro|s4_y|y__t5 a|g_a|rn4|ro|s4_y|y
+ 345.096279942
* device instance a_g_a_rn4_ro_s4_y_y r0 *1 0,0
Ca_g_a_rn4_ro_s4_y_y a|g_a|rn4|ro|s4_y|y vsubs 6.557229e-15
* device instance a_g_y_mnab_y_mpa_y_mpb_y_n1_s1_a_y_t0 r0 *1 0,0
Ra_g_y_mnab_y_mpa_y_mpb_y_n1_s1_a_y_t0 a|g_y|mnab_y|mpa_y|mpb_y|n1|s1_a|y__t0
+ a|g_y|mnab_y|mpa_y|mpb_y|n1|s1_a|y 118.690159634
* device instance a_g_y_mnab_y_mpa_y_mpb_y_n1_s1_a_y_t1 r0 *1 0,0
Ra_g_y_mnab_y_mpa_y_mpb_y_n1_s1_a_y_t1 a|g_y|mnab_y|mpa_y|mpb_y|n1|s1_a|y__t1
+ a|g_y|mnab_y|mpa_y|mpb_y|n1|s1_a|y 132.890468841
* device instance a_g_y_mnab_y_mpa_y_mpb_y_n1_s1_a_y_t2 r0 *1 0,0
Ra_g_y_mnab_y_mpa_y_mpb_y_n1_s1_a_y_t2 a|g_y|mnab_y|mpa_y|mpb_y|n1|s1_a|y__t2
+ a|g_y|mnab_y|mpa_y|mpb_y|n1|s1_a|y 152.348139631
* device instance a_g_y_mnab_y_mpa_y_mpb_y_n1_s1_a_y_t3 r0 *1 0,0
Ra_g_y_mnab_y_mpa_y_mpb_y_n1_s1_a_y_t3 a|g_y|mnab_y|mpa_y|mpb_y|n1|s1_a|y__t3
+ a|g_y|mnab_y|mpa_y|mpb_y|n1|s1_a|y 88.589660111
* device instance a_g_y_mnab_y_mpa_y_mpb_y_n1_s1_a_y_t4 r0 *1 0,0
Ra_g_y_mnab_y_mpa_y_mpb_y_n1_s1_a_y_t4 a|g_y|mnab_y|mpa_y|mpb_y|n1|s1_a|y__t4
+ a|g_y|mnab_y|mpa_y|mpb_y|n1|s1_a|y 100.849471782
* device instance a_g_y_mnab_y_mpa_y_mpb_y_n1_s1_a_y r0 *1 0,0
Ca_g_y_mnab_y_mpa_y_mpb_y_n1_s1_a_y a|g_y|mnab_y|mpa_y|mpb_y|n1|s1_a|y vsubs
+ 2.784627e-15
* device instance a_g_y_mnab_y_mpa_y_mpb_y_n1_s1_a_y_dup1_t0 r0 *1 0,0
Ra_g_y_mnab_y_mpa_y_mpb_y_n1_s1_a_y_dup1_t0
+ a|g_y|mnab_y|mpa_y|mpb_y|n1|s1_a|y__t02 a|g_y|mnab_y|mpa_y|mpb_y|n1|s1_a|y$1
+ 118.690159634
* device instance a_g_y_mnab_y_mpa_y_mpb_y_n1_s1_a_y_dup1_t1 r0 *1 0,0
Ra_g_y_mnab_y_mpa_y_mpb_y_n1_s1_a_y_dup1_t1
+ a|g_y|mnab_y|mpa_y|mpb_y|n1|s1_a|y__t12 a|g_y|mnab_y|mpa_y|mpb_y|n1|s1_a|y$1
+ 132.890468841
* device instance a_g_y_mnab_y_mpa_y_mpb_y_n1_s1_a_y_dup1_t2 r0 *1 0,0
Ra_g_y_mnab_y_mpa_y_mpb_y_n1_s1_a_y_dup1_t2
+ a|g_y|mnab_y|mpa_y|mpb_y|n1|s1_a|y__t22 a|g_y|mnab_y|mpa_y|mpb_y|n1|s1_a|y$1
+ 152.348139631
* device instance a_g_y_mnab_y_mpa_y_mpb_y_n1_s1_a_y_dup1_t3 r0 *1 0,0
Ra_g_y_mnab_y_mpa_y_mpb_y_n1_s1_a_y_dup1_t3
+ a|g_y|mnab_y|mpa_y|mpb_y|n1|s1_a|y__t32 a|g_y|mnab_y|mpa_y|mpb_y|n1|s1_a|y$1
+ 88.589660111
* device instance a_g_y_mnab_y_mpa_y_mpb_y_n1_s1_a_y_dup1_t4 r0 *1 0,0
Ra_g_y_mnab_y_mpa_y_mpb_y_n1_s1_a_y_dup1_t4
+ a|g_y|mnab_y|mpa_y|mpb_y|n1|s1_a|y__t42 a|g_y|mnab_y|mpa_y|mpb_y|n1|s1_a|y$1
+ 100.849471782
* device instance a_g_y_mnab_y_mpa_y_mpb_y_n1_s1_a_y_dup1 r0 *1 0,0
Ca_g_y_mnab_y_mpa_y_mpb_y_n1_s1_a_y_dup1 a|g_y|mnab_y|mpa_y|mpb_y|n1|s1_a|y$1
+ vsubs 2.784627e-15
* device instance a_g_y_mnab_y_mpa_y_mpb_y_n1_s1_a_y_dup2_t0 r0 *1 0,0
Ra_g_y_mnab_y_mpa_y_mpb_y_n1_s1_a_y_dup2_t0
+ a|g_y|mnab_y|mpa_y|mpb_y|n1|s1_a|y__t03 a|g_y|mnab_y|mpa_y|mpb_y|n1|s1_a|y$2
+ 118.690159634
* device instance a_g_y_mnab_y_mpa_y_mpb_y_n1_s1_a_y_dup2_t1 r0 *1 0,0
Ra_g_y_mnab_y_mpa_y_mpb_y_n1_s1_a_y_dup2_t1
+ a|g_y|mnab_y|mpa_y|mpb_y|n1|s1_a|y__t13 a|g_y|mnab_y|mpa_y|mpb_y|n1|s1_a|y$2
+ 132.890468841
* device instance a_g_y_mnab_y_mpa_y_mpb_y_n1_s1_a_y_dup2_t2 r0 *1 0,0
Ra_g_y_mnab_y_mpa_y_mpb_y_n1_s1_a_y_dup2_t2
+ a|g_y|mnab_y|mpa_y|mpb_y|n1|s1_a|y__t23 a|g_y|mnab_y|mpa_y|mpb_y|n1|s1_a|y$2
+ 152.348139631
* device instance a_g_y_mnab_y_mpa_y_mpb_y_n1_s1_a_y_dup2_t3 r0 *1 0,0
Ra_g_y_mnab_y_mpa_y_mpb_y_n1_s1_a_y_dup2_t3
+ a|g_y|mnab_y|mpa_y|mpb_y|n1|s1_a|y__t33 a|g_y|mnab_y|mpa_y|mpb_y|n1|s1_a|y$2
+ 88.589660111
* device instance a_g_y_mnab_y_mpa_y_mpb_y_n1_s1_a_y_dup2_t4 r0 *1 0,0
Ra_g_y_mnab_y_mpa_y_mpb_y_n1_s1_a_y_dup2_t4
+ a|g_y|mnab_y|mpa_y|mpb_y|n1|s1_a|y__t43 a|g_y|mnab_y|mpa_y|mpb_y|n1|s1_a|y$2
+ 100.849471782
* device instance a_g_y_mnab_y_mpa_y_mpb_y_n1_s1_a_y_dup2 r0 *1 0,0
Ca_g_y_mnab_y_mpa_y_mpb_y_n1_s1_a_y_dup2 a|g_y|mnab_y|mpa_y|mpb_y|n1|s1_a|y$2
+ vsubs 2.784627e-15
* device instance a_g_y_mnab_y_mpa_y_mpb_y_n1_s1_a_y_dup3_t0 r0 *1 0,0
Ra_g_y_mnab_y_mpa_y_mpb_y_n1_s1_a_y_dup3_t0
+ a|g_y|mnab_y|mpa_y|mpb_y|n1|s1_a|y__t04 a|g_y|mnab_y|mpa_y|mpb_y|n1|s1_a|y$3
+ 118.690159634
* device instance a_g_y_mnab_y_mpa_y_mpb_y_n1_s1_a_y_dup3_t1 r0 *1 0,0
Ra_g_y_mnab_y_mpa_y_mpb_y_n1_s1_a_y_dup3_t1
+ a|g_y|mnab_y|mpa_y|mpb_y|n1|s1_a|y__t14 a|g_y|mnab_y|mpa_y|mpb_y|n1|s1_a|y$3
+ 132.890468841
* device instance a_g_y_mnab_y_mpa_y_mpb_y_n1_s1_a_y_dup3_t2 r0 *1 0,0
Ra_g_y_mnab_y_mpa_y_mpb_y_n1_s1_a_y_dup3_t2
+ a|g_y|mnab_y|mpa_y|mpb_y|n1|s1_a|y__t24 a|g_y|mnab_y|mpa_y|mpb_y|n1|s1_a|y$3
+ 152.348139631
* device instance a_g_y_mnab_y_mpa_y_mpb_y_n1_s1_a_y_dup3_t3 r0 *1 0,0
Ra_g_y_mnab_y_mpa_y_mpb_y_n1_s1_a_y_dup3_t3
+ a|g_y|mnab_y|mpa_y|mpb_y|n1|s1_a|y__t34 a|g_y|mnab_y|mpa_y|mpb_y|n1|s1_a|y$3
+ 88.589660111
* device instance a_g_y_mnab_y_mpa_y_mpb_y_n1_s1_a_y_dup3_t4 r0 *1 0,0
Ra_g_y_mnab_y_mpa_y_mpb_y_n1_s1_a_y_dup3_t4
+ a|g_y|mnab_y|mpa_y|mpb_y|n1|s1_a|y__t44 a|g_y|mnab_y|mpa_y|mpb_y|n1|s1_a|y$3
+ 100.849471782
* device instance a_g_y_mnab_y_mpa_y_mpb_y_n1_s1_a_y_dup3 r0 *1 0,0
Ca_g_y_mnab_y_mpa_y_mpb_y_n1_s1_a_y_dup3 a|g_y|mnab_y|mpa_y|mpb_y|n1|s1_a|y$3
+ vsubs 2.784627e-15
* device instance a_inv_mc_a_mb_mnab_y_mpa_y_mpb_y_nand_m_y_tg_s_a_y_t0 r0 *1 0,0
Ra_inv_mc_a_mb_mnab_y_mpa_y_mpb_y_nand_m_y_tg_s_a_y_t0
+ a|inv_mc_a|mb|mnab_y|mpa_y|mpb_y|nand_m_y|tg_s_a|y__t0
+ a|inv_mc_a|mb|mnab_y|mpa_y|mpb_y|nand_m_y|tg_s_a|y 145.790727379
* device instance a_inv_mc_a_mb_mnab_y_mpa_y_mpb_y_nand_m_y_tg_s_a_y_t1 r0 *1 0,0
Ra_inv_mc_a_mb_mnab_y_mpa_y_mpb_y_nand_m_y_tg_s_a_y_t1
+ a|inv_mc_a|mb|mnab_y|mpa_y|mpb_y|nand_m_y|tg_s_a|y__t1
+ a|inv_mc_a|mb|mnab_y|mpa_y|mpb_y|nand_m_y|tg_s_a|y 217.059082598
* device instance a_inv_mc_a_mb_mnab_y_mpa_y_mpb_y_nand_m_y_tg_s_a_y_t2 r0 *1 0,0
Ra_inv_mc_a_mb_mnab_y_mpa_y_mpb_y_nand_m_y_tg_s_a_y_t2
+ a|inv_mc_a|mb|mnab_y|mpa_y|mpb_y|nand_m_y|tg_s_a|y__t2
+ a|inv_mc_a|mb|mnab_y|mpa_y|mpb_y|nand_m_y|tg_s_a|y 167.783594207
* device instance a_inv_mc_a_mb_mnab_y_mpa_y_mpb_y_nand_m_y_tg_s_a_y_t3 r0 *1 0,0
Ra_inv_mc_a_mb_mnab_y_mpa_y_mpb_y_nand_m_y_tg_s_a_y_t3
+ a|inv_mc_a|mb|mnab_y|mpa_y|mpb_y|nand_m_y|tg_s_a|y__t3
+ a|inv_mc_a|mb|mnab_y|mpa_y|mpb_y|nand_m_y|tg_s_a|y 220.037214754
* device instance a_inv_mc_a_mb_mnab_y_mpa_y_mpb_y_nand_m_y_tg_s_a_y_t4 r0 *1 0,0
Ra_inv_mc_a_mb_mnab_y_mpa_y_mpb_y_nand_m_y_tg_s_a_y_t4
+ a|inv_mc_a|mb|mnab_y|mpa_y|mpb_y|nand_m_y|tg_s_a|y__t4
+ a|inv_mc_a|mb|mnab_y|mpa_y|mpb_y|nand_m_y|tg_s_a|y 26.6433173121
* device instance a_inv_mc_a_mb_mnab_y_mpa_y_mpb_y_nand_m_y_tg_s_a_y_t5 r0 *1 0,0
Ra_inv_mc_a_mb_mnab_y_mpa_y_mpb_y_nand_m_y_tg_s_a_y_t5
+ a|inv_mc_a|mb|mnab_y|mpa_y|mpb_y|nand_m_y|tg_s_a|y__t5
+ a|inv_mc_a|mb|mnab_y|mpa_y|mpb_y|nand_m_y|tg_s_a|y 44.8508293778
* device instance a_inv_mc_a_mb_mnab_y_mpa_y_mpb_y_nand_m_y_tg_s_a_y_t6 r0 *1 0,0
Ra_inv_mc_a_mb_mnab_y_mpa_y_mpb_y_nand_m_y_tg_s_a_y_t6
+ a|inv_mc_a|mb|mnab_y|mpa_y|mpb_y|nand_m_y|tg_s_a|y__t6
+ a|inv_mc_a|mb|mnab_y|mpa_y|mpb_y|nand_m_y|tg_s_a|y 141.085234372
* device instance a_inv_mc_a_mb_mnab_y_mpa_y_mpb_y_nand_m_y_tg_s_a_y r0 *1 0,0
Ca_inv_mc_a_mb_mnab_y_mpa_y_mpb_y_nand_m_y_tg_s_a_y
+ a|inv_mc_a|mb|mnab_y|mpa_y|mpb_y|nand_m_y|tg_s_a|y vsubs 4.160899e-15
* device instance a_inv_mc_a_mb_mnab_y_mpa_y_mpb_y_nand_m_y_tg_s_a_y_dup1_t0 r0 *1 0,0
Ra_inv_mc_a_mb_mnab_y_mpa_y_mpb_y_nand_m_y_tg_s_a_y_dup1_t0
+ a|inv_mc_a|mb|mnab_y|mpa_y|mpb_y|nand_m_y|tg_s_a|y__t02
+ a|inv_mc_a|mb|mnab_y|mpa_y|mpb_y|nand_m_y|tg_s_a|y$1 217.059082598
* device instance a_inv_mc_a_mb_mnab_y_mpa_y_mpb_y_nand_m_y_tg_s_a_y_dup1_t1 r0 *1 0,0
Ra_inv_mc_a_mb_mnab_y_mpa_y_mpb_y_nand_m_y_tg_s_a_y_dup1_t1
+ a|inv_mc_a|mb|mnab_y|mpa_y|mpb_y|nand_m_y|tg_s_a|y__t12
+ a|inv_mc_a|mb|mnab_y|mpa_y|mpb_y|nand_m_y|tg_s_a|y$1 167.783594207
* device instance a_inv_mc_a_mb_mnab_y_mpa_y_mpb_y_nand_m_y_tg_s_a_y_dup1_t2 r0 *1 0,0
Ra_inv_mc_a_mb_mnab_y_mpa_y_mpb_y_nand_m_y_tg_s_a_y_dup1_t2
+ a|inv_mc_a|mb|mnab_y|mpa_y|mpb_y|nand_m_y|tg_s_a|y__t22
+ a|inv_mc_a|mb|mnab_y|mpa_y|mpb_y|nand_m_y|tg_s_a|y$1 220.037214754
* device instance a_inv_mc_a_mb_mnab_y_mpa_y_mpb_y_nand_m_y_tg_s_a_y_dup1_t3 r0 *1 0,0
Ra_inv_mc_a_mb_mnab_y_mpa_y_mpb_y_nand_m_y_tg_s_a_y_dup1_t3
+ a|inv_mc_a|mb|mnab_y|mpa_y|mpb_y|nand_m_y|tg_s_a|y__t32
+ a|inv_mc_a|mb|mnab_y|mpa_y|mpb_y|nand_m_y|tg_s_a|y$1 26.6433173121
* device instance a_inv_mc_a_mb_mnab_y_mpa_y_mpb_y_nand_m_y_tg_s_a_y_dup1_t4 r0 *1 0,0
Ra_inv_mc_a_mb_mnab_y_mpa_y_mpb_y_nand_m_y_tg_s_a_y_dup1_t4
+ a|inv_mc_a|mb|mnab_y|mpa_y|mpb_y|nand_m_y|tg_s_a|y__t42
+ a|inv_mc_a|mb|mnab_y|mpa_y|mpb_y|nand_m_y|tg_s_a|y$1 44.8508293778
* device instance a_inv_mc_a_mb_mnab_y_mpa_y_mpb_y_nand_m_y_tg_s_a_y_dup1_t5 r0 *1 0,0
Ra_inv_mc_a_mb_mnab_y_mpa_y_mpb_y_nand_m_y_tg_s_a_y_dup1_t5
+ a|inv_mc_a|mb|mnab_y|mpa_y|mpb_y|nand_m_y|tg_s_a|y__t52
+ a|inv_mc_a|mb|mnab_y|mpa_y|mpb_y|nand_m_y|tg_s_a|y$1 141.085234372
* device instance a_inv_mc_a_mb_mnab_y_mpa_y_mpb_y_nand_m_y_tg_s_a_y_dup1_t6 r0 *1 0,0
Ra_inv_mc_a_mb_mnab_y_mpa_y_mpb_y_nand_m_y_tg_s_a_y_dup1_t6
+ a|inv_mc_a|mb|mnab_y|mpa_y|mpb_y|nand_m_y|tg_s_a|y__t62
+ a|inv_mc_a|mb|mnab_y|mpa_y|mpb_y|nand_m_y|tg_s_a|y$1 145.790727379
* device instance a_inv_mc_a_mb_mnab_y_mpa_y_mpb_y_nand_m_y_tg_s_a_y_dup1 r0 *1 0,0
Ca_inv_mc_a_mb_mnab_y_mpa_y_mpb_y_nand_m_y_tg_s_a_y_dup1
+ a|inv_mc_a|mb|mnab_y|mpa_y|mpb_y|nand_m_y|tg_s_a|y$1 vsubs 4.160899e-15
* device instance a_inv_mc_a_mb_mnab_y_mpa_y_mpb_y_nand_m_y_tg_s_a_y_dup2_t0 r0 *1 0,0
Ra_inv_mc_a_mb_mnab_y_mpa_y_mpb_y_nand_m_y_tg_s_a_y_dup2_t0
+ a|inv_mc_a|mb|mnab_y|mpa_y|mpb_y|nand_m_y|tg_s_a|y__t03
+ a|inv_mc_a|mb|mnab_y|mpa_y|mpb_y|nand_m_y|tg_s_a|y$2 167.783594207
* device instance a_inv_mc_a_mb_mnab_y_mpa_y_mpb_y_nand_m_y_tg_s_a_y_dup2_t1 r0 *1 0,0
Ra_inv_mc_a_mb_mnab_y_mpa_y_mpb_y_nand_m_y_tg_s_a_y_dup2_t1
+ a|inv_mc_a|mb|mnab_y|mpa_y|mpb_y|nand_m_y|tg_s_a|y__t13
+ a|inv_mc_a|mb|mnab_y|mpa_y|mpb_y|nand_m_y|tg_s_a|y$2 217.059082598
* device instance a_inv_mc_a_mb_mnab_y_mpa_y_mpb_y_nand_m_y_tg_s_a_y_dup2_t2 r0 *1 0,0
Ra_inv_mc_a_mb_mnab_y_mpa_y_mpb_y_nand_m_y_tg_s_a_y_dup2_t2
+ a|inv_mc_a|mb|mnab_y|mpa_y|mpb_y|nand_m_y|tg_s_a|y__t23
+ a|inv_mc_a|mb|mnab_y|mpa_y|mpb_y|nand_m_y|tg_s_a|y$2 220.037214754
* device instance a_inv_mc_a_mb_mnab_y_mpa_y_mpb_y_nand_m_y_tg_s_a_y_dup2_t3 r0 *1 0,0
Ra_inv_mc_a_mb_mnab_y_mpa_y_mpb_y_nand_m_y_tg_s_a_y_dup2_t3
+ a|inv_mc_a|mb|mnab_y|mpa_y|mpb_y|nand_m_y|tg_s_a|y__t33
+ a|inv_mc_a|mb|mnab_y|mpa_y|mpb_y|nand_m_y|tg_s_a|y$2 26.6433173121
* device instance a_inv_mc_a_mb_mnab_y_mpa_y_mpb_y_nand_m_y_tg_s_a_y_dup2_t4 r0 *1 0,0
Ra_inv_mc_a_mb_mnab_y_mpa_y_mpb_y_nand_m_y_tg_s_a_y_dup2_t4
+ a|inv_mc_a|mb|mnab_y|mpa_y|mpb_y|nand_m_y|tg_s_a|y__t43
+ a|inv_mc_a|mb|mnab_y|mpa_y|mpb_y|nand_m_y|tg_s_a|y$2 44.8508293778
* device instance a_inv_mc_a_mb_mnab_y_mpa_y_mpb_y_nand_m_y_tg_s_a_y_dup2_t5 r0 *1 0,0
Ra_inv_mc_a_mb_mnab_y_mpa_y_mpb_y_nand_m_y_tg_s_a_y_dup2_t5
+ a|inv_mc_a|mb|mnab_y|mpa_y|mpb_y|nand_m_y|tg_s_a|y__t53
+ a|inv_mc_a|mb|mnab_y|mpa_y|mpb_y|nand_m_y|tg_s_a|y$2 141.085234372
* device instance a_inv_mc_a_mb_mnab_y_mpa_y_mpb_y_nand_m_y_tg_s_a_y_dup2_t6 r0 *1 0,0
Ra_inv_mc_a_mb_mnab_y_mpa_y_mpb_y_nand_m_y_tg_s_a_y_dup2_t6
+ a|inv_mc_a|mb|mnab_y|mpa_y|mpb_y|nand_m_y|tg_s_a|y__t63
+ a|inv_mc_a|mb|mnab_y|mpa_y|mpb_y|nand_m_y|tg_s_a|y$2 145.790727379
* device instance a_inv_mc_a_mb_mnab_y_mpa_y_mpb_y_nand_m_y_tg_s_a_y_dup2 r0 *1 0,0
Ca_inv_mc_a_mb_mnab_y_mpa_y_mpb_y_nand_m_y_tg_s_a_y_dup2
+ a|inv_mc_a|mb|mnab_y|mpa_y|mpb_y|nand_m_y|tg_s_a|y$2 vsubs 4.160899e-15
* device instance a_inv_mc_a_mb_mnab_y_mpa_y_mpb_y_nand_m_y_tg_s_a_y_dup3_t0 r0 *1 0,0
Ra_inv_mc_a_mb_mnab_y_mpa_y_mpb_y_nand_m_y_tg_s_a_y_dup3_t0
+ a|inv_mc_a|mb|mnab_y|mpa_y|mpb_y|nand_m_y|tg_s_a|y__t04
+ a|inv_mc_a|mb|mnab_y|mpa_y|mpb_y|nand_m_y|tg_s_a|y$3 167.783594207
* device instance a_inv_mc_a_mb_mnab_y_mpa_y_mpb_y_nand_m_y_tg_s_a_y_dup3_t1 r0 *1 0,0
Ra_inv_mc_a_mb_mnab_y_mpa_y_mpb_y_nand_m_y_tg_s_a_y_dup3_t1
+ a|inv_mc_a|mb|mnab_y|mpa_y|mpb_y|nand_m_y|tg_s_a|y__t14
+ a|inv_mc_a|mb|mnab_y|mpa_y|mpb_y|nand_m_y|tg_s_a|y$3 217.059082598
* device instance a_inv_mc_a_mb_mnab_y_mpa_y_mpb_y_nand_m_y_tg_s_a_y_dup3_t2 r0 *1 0,0
Ra_inv_mc_a_mb_mnab_y_mpa_y_mpb_y_nand_m_y_tg_s_a_y_dup3_t2
+ a|inv_mc_a|mb|mnab_y|mpa_y|mpb_y|nand_m_y|tg_s_a|y__t24
+ a|inv_mc_a|mb|mnab_y|mpa_y|mpb_y|nand_m_y|tg_s_a|y$3 220.037214754
* device instance a_inv_mc_a_mb_mnab_y_mpa_y_mpb_y_nand_m_y_tg_s_a_y_dup3_t3 r0 *1 0,0
Ra_inv_mc_a_mb_mnab_y_mpa_y_mpb_y_nand_m_y_tg_s_a_y_dup3_t3
+ a|inv_mc_a|mb|mnab_y|mpa_y|mpb_y|nand_m_y|tg_s_a|y__t34
+ a|inv_mc_a|mb|mnab_y|mpa_y|mpb_y|nand_m_y|tg_s_a|y$3 26.6433173121
* device instance a_inv_mc_a_mb_mnab_y_mpa_y_mpb_y_nand_m_y_tg_s_a_y_dup3_t4 r0 *1 0,0
Ra_inv_mc_a_mb_mnab_y_mpa_y_mpb_y_nand_m_y_tg_s_a_y_dup3_t4
+ a|inv_mc_a|mb|mnab_y|mpa_y|mpb_y|nand_m_y|tg_s_a|y__t44
+ a|inv_mc_a|mb|mnab_y|mpa_y|mpb_y|nand_m_y|tg_s_a|y$3 44.8508293778
* device instance a_inv_mc_a_mb_mnab_y_mpa_y_mpb_y_nand_m_y_tg_s_a_y_dup3_t5 r0 *1 0,0
Ra_inv_mc_a_mb_mnab_y_mpa_y_mpb_y_nand_m_y_tg_s_a_y_dup3_t5
+ a|inv_mc_a|mb|mnab_y|mpa_y|mpb_y|nand_m_y|tg_s_a|y__t54
+ a|inv_mc_a|mb|mnab_y|mpa_y|mpb_y|nand_m_y|tg_s_a|y$3 141.085234372
* device instance a_inv_mc_a_mb_mnab_y_mpa_y_mpb_y_nand_m_y_tg_s_a_y_dup3_t6 r0 *1 0,0
Ra_inv_mc_a_mb_mnab_y_mpa_y_mpb_y_nand_m_y_tg_s_a_y_dup3_t6
+ a|inv_mc_a|mb|mnab_y|mpa_y|mpb_y|nand_m_y|tg_s_a|y__t64
+ a|inv_mc_a|mb|mnab_y|mpa_y|mpb_y|nand_m_y|tg_s_a|y$3 145.790727379
* device instance a_inv_mc_a_mb_mnab_y_mpa_y_mpb_y_nand_m_y_tg_s_a_y_dup3 r0 *1 0,0
Ca_inv_mc_a_mb_mnab_y_mpa_y_mpb_y_nand_m_y_tg_s_a_y_dup3
+ a|inv_mc_a|mb|mnab_y|mpa_y|mpb_y|nand_m_y|tg_s_a|y$3 vsubs 4.160899e-15
* device instance a_inv_mc_a_mb_mnab_y_mpa_y_mpb_y_nand_m_y_tg_s_a_y_dup4_t0 r0 *1 0,0
Ra_inv_mc_a_mb_mnab_y_mpa_y_mpb_y_nand_m_y_tg_s_a_y_dup4_t0
+ a|inv_mc_a|mb|mnab_y|mpa_y|mpb_y|nand_m_y|tg_s_a|y__t05
+ a|inv_mc_a|mb|mnab_y|mpa_y|mpb_y|nand_m_y|tg_s_a|y$4 217.059082598
* device instance a_inv_mc_a_mb_mnab_y_mpa_y_mpb_y_nand_m_y_tg_s_a_y_dup4_t1 r0 *1 0,0
Ra_inv_mc_a_mb_mnab_y_mpa_y_mpb_y_nand_m_y_tg_s_a_y_dup4_t1
+ a|inv_mc_a|mb|mnab_y|mpa_y|mpb_y|nand_m_y|tg_s_a|y__t15
+ a|inv_mc_a|mb|mnab_y|mpa_y|mpb_y|nand_m_y|tg_s_a|y$4 167.783594207
* device instance a_inv_mc_a_mb_mnab_y_mpa_y_mpb_y_nand_m_y_tg_s_a_y_dup4_t2 r0 *1 0,0
Ra_inv_mc_a_mb_mnab_y_mpa_y_mpb_y_nand_m_y_tg_s_a_y_dup4_t2
+ a|inv_mc_a|mb|mnab_y|mpa_y|mpb_y|nand_m_y|tg_s_a|y__t25
+ a|inv_mc_a|mb|mnab_y|mpa_y|mpb_y|nand_m_y|tg_s_a|y$4 220.037214754
* device instance a_inv_mc_a_mb_mnab_y_mpa_y_mpb_y_nand_m_y_tg_s_a_y_dup4_t3 r0 *1 0,0
Ra_inv_mc_a_mb_mnab_y_mpa_y_mpb_y_nand_m_y_tg_s_a_y_dup4_t3
+ a|inv_mc_a|mb|mnab_y|mpa_y|mpb_y|nand_m_y|tg_s_a|y__t35
+ a|inv_mc_a|mb|mnab_y|mpa_y|mpb_y|nand_m_y|tg_s_a|y$4 26.6433173121
* device instance a_inv_mc_a_mb_mnab_y_mpa_y_mpb_y_nand_m_y_tg_s_a_y_dup4_t4 r0 *1 0,0
Ra_inv_mc_a_mb_mnab_y_mpa_y_mpb_y_nand_m_y_tg_s_a_y_dup4_t4
+ a|inv_mc_a|mb|mnab_y|mpa_y|mpb_y|nand_m_y|tg_s_a|y__t45
+ a|inv_mc_a|mb|mnab_y|mpa_y|mpb_y|nand_m_y|tg_s_a|y$4 44.8508293778
* device instance a_inv_mc_a_mb_mnab_y_mpa_y_mpb_y_nand_m_y_tg_s_a_y_dup4_t5 r0 *1 0,0
Ra_inv_mc_a_mb_mnab_y_mpa_y_mpb_y_nand_m_y_tg_s_a_y_dup4_t5
+ a|inv_mc_a|mb|mnab_y|mpa_y|mpb_y|nand_m_y|tg_s_a|y__t55
+ a|inv_mc_a|mb|mnab_y|mpa_y|mpb_y|nand_m_y|tg_s_a|y$4 141.085234372
* device instance a_inv_mc_a_mb_mnab_y_mpa_y_mpb_y_nand_m_y_tg_s_a_y_dup4_t6 r0 *1 0,0
Ra_inv_mc_a_mb_mnab_y_mpa_y_mpb_y_nand_m_y_tg_s_a_y_dup4_t6
+ a|inv_mc_a|mb|mnab_y|mpa_y|mpb_y|nand_m_y|tg_s_a|y__t65
+ a|inv_mc_a|mb|mnab_y|mpa_y|mpb_y|nand_m_y|tg_s_a|y$4 145.790727379
* device instance a_inv_mc_a_mb_mnab_y_mpa_y_mpb_y_nand_m_y_tg_s_a_y_dup4 r0 *1 0,0
Ca_inv_mc_a_mb_mnab_y_mpa_y_mpb_y_nand_m_y_tg_s_a_y_dup4
+ a|inv_mc_a|mb|mnab_y|mpa_y|mpb_y|nand_m_y|tg_s_a|y$4 vsubs 4.160899e-15
* device instance a_inv_mc_a_mb_mnab_y_mpa_y_mpb_y_nand_m_y_tg_s_a_y_dup5_t0 r0 *1 0,0
Ra_inv_mc_a_mb_mnab_y_mpa_y_mpb_y_nand_m_y_tg_s_a_y_dup5_t0
+ a|inv_mc_a|mb|mnab_y|mpa_y|mpb_y|nand_m_y|tg_s_a|y__t06
+ a|inv_mc_a|mb|mnab_y|mpa_y|mpb_y|nand_m_y|tg_s_a|y$5 217.059082598
* device instance a_inv_mc_a_mb_mnab_y_mpa_y_mpb_y_nand_m_y_tg_s_a_y_dup5_t1 r0 *1 0,0
Ra_inv_mc_a_mb_mnab_y_mpa_y_mpb_y_nand_m_y_tg_s_a_y_dup5_t1
+ a|inv_mc_a|mb|mnab_y|mpa_y|mpb_y|nand_m_y|tg_s_a|y__t16
+ a|inv_mc_a|mb|mnab_y|mpa_y|mpb_y|nand_m_y|tg_s_a|y$5 167.783594207
* device instance a_inv_mc_a_mb_mnab_y_mpa_y_mpb_y_nand_m_y_tg_s_a_y_dup5_t2 r0 *1 0,0
Ra_inv_mc_a_mb_mnab_y_mpa_y_mpb_y_nand_m_y_tg_s_a_y_dup5_t2
+ a|inv_mc_a|mb|mnab_y|mpa_y|mpb_y|nand_m_y|tg_s_a|y__t26
+ a|inv_mc_a|mb|mnab_y|mpa_y|mpb_y|nand_m_y|tg_s_a|y$5 220.037214754
* device instance a_inv_mc_a_mb_mnab_y_mpa_y_mpb_y_nand_m_y_tg_s_a_y_dup5_t3 r0 *1 0,0
Ra_inv_mc_a_mb_mnab_y_mpa_y_mpb_y_nand_m_y_tg_s_a_y_dup5_t3
+ a|inv_mc_a|mb|mnab_y|mpa_y|mpb_y|nand_m_y|tg_s_a|y__t36
+ a|inv_mc_a|mb|mnab_y|mpa_y|mpb_y|nand_m_y|tg_s_a|y$5 26.6433173121
* device instance a_inv_mc_a_mb_mnab_y_mpa_y_mpb_y_nand_m_y_tg_s_a_y_dup5_t4 r0 *1 0,0
Ra_inv_mc_a_mb_mnab_y_mpa_y_mpb_y_nand_m_y_tg_s_a_y_dup5_t4
+ a|inv_mc_a|mb|mnab_y|mpa_y|mpb_y|nand_m_y|tg_s_a|y__t46
+ a|inv_mc_a|mb|mnab_y|mpa_y|mpb_y|nand_m_y|tg_s_a|y$5 44.8508293778
* device instance a_inv_mc_a_mb_mnab_y_mpa_y_mpb_y_nand_m_y_tg_s_a_y_dup5_t5 r0 *1 0,0
Ra_inv_mc_a_mb_mnab_y_mpa_y_mpb_y_nand_m_y_tg_s_a_y_dup5_t5
+ a|inv_mc_a|mb|mnab_y|mpa_y|mpb_y|nand_m_y|tg_s_a|y__t56
+ a|inv_mc_a|mb|mnab_y|mpa_y|mpb_y|nand_m_y|tg_s_a|y$5 141.085234372
* device instance a_inv_mc_a_mb_mnab_y_mpa_y_mpb_y_nand_m_y_tg_s_a_y_dup5_t6 r0 *1 0,0
Ra_inv_mc_a_mb_mnab_y_mpa_y_mpb_y_nand_m_y_tg_s_a_y_dup5_t6
+ a|inv_mc_a|mb|mnab_y|mpa_y|mpb_y|nand_m_y|tg_s_a|y__t66
+ a|inv_mc_a|mb|mnab_y|mpa_y|mpb_y|nand_m_y|tg_s_a|y$5 145.790727379
* device instance a_inv_mc_a_mb_mnab_y_mpa_y_mpb_y_nand_m_y_tg_s_a_y_dup5 r0 *1 0,0
Ca_inv_mc_a_mb_mnab_y_mpa_y_mpb_y_nand_m_y_tg_s_a_y_dup5
+ a|inv_mc_a|mb|mnab_y|mpa_y|mpb_y|nand_m_y|tg_s_a|y$5 vsubs 4.160899e-15
* device instance a_inv_mc_y_inv_mc_y_via_mc_tg_fbm_a_tg_fbm_a_via_y_t0 r0 *1 0,0
Ra_inv_mc_y_inv_mc_y_via_mc_tg_fbm_a_tg_fbm_a_via_y_t0
+ a|inv_mc_y|inv_mc_y_via|mc|tg_fbm_a|tg_fbm_a_via|y__t0
+ a|inv_mc_y|inv_mc_y_via|mc|tg_fbm_a|tg_fbm_a_via|y 208.313425
* device instance a_inv_mc_y_inv_mc_y_via_mc_tg_fbm_a_tg_fbm_a_via_y_t1 r0 *1 0,0
Ra_inv_mc_y_inv_mc_y_via_mc_tg_fbm_a_tg_fbm_a_via_y_t1
+ a|inv_mc_y|inv_mc_y_via|mc|tg_fbm_a|tg_fbm_a_via|y__t1
+ a|inv_mc_y|inv_mc_y_via|mc|tg_fbm_a|tg_fbm_a_via|y 208.313425
* device instance a_inv_mc_y_inv_mc_y_via_mc_tg_fbm_a_tg_fbm_a_via_y_t2 r0 *1 0,0
Ra_inv_mc_y_inv_mc_y_via_mc_tg_fbm_a_tg_fbm_a_via_y_t2
+ a|inv_mc_y|inv_mc_y_via|mc|tg_fbm_a|tg_fbm_a_via|y__t2
+ a|inv_mc_y|inv_mc_y_via|mc|tg_fbm_a|tg_fbm_a_via|y 208.313425
* device instance a_inv_mc_y_inv_mc_y_via_mc_tg_fbm_a_tg_fbm_a_via_y_t3 r0 *1 0,0
Ra_inv_mc_y_inv_mc_y_via_mc_tg_fbm_a_tg_fbm_a_via_y_t3
+ a|inv_mc_y|inv_mc_y_via|mc|tg_fbm_a|tg_fbm_a_via|y__t3
+ a|inv_mc_y|inv_mc_y_via|mc|tg_fbm_a|tg_fbm_a_via|y 208.313425
* device instance a_inv_mc_y_inv_mc_y_via_mc_tg_fbm_a_tg_fbm_a_via_y r0 *1 0,0
Ca_inv_mc_y_inv_mc_y_via_mc_tg_fbm_a_tg_fbm_a_via_y
+ a|inv_mc_y|inv_mc_y_via|mc|tg_fbm_a|tg_fbm_a_via|y vsubs 1.955756e-15
* device instance a_inv_mc_y_inv_mc_y_via_mc_tg_fbm_a_tg_fbm_a_via_y_dup1_t0 r0 *1 0,0
Ra_inv_mc_y_inv_mc_y_via_mc_tg_fbm_a_tg_fbm_a_via_y_dup1_t0
+ a|inv_mc_y|inv_mc_y_via|mc|tg_fbm_a|tg_fbm_a_via|y__t02
+ a|inv_mc_y|inv_mc_y_via|mc|tg_fbm_a|tg_fbm_a_via|y$1 208.313425
* device instance a_inv_mc_y_inv_mc_y_via_mc_tg_fbm_a_tg_fbm_a_via_y_dup1_t1 r0 *1 0,0
Ra_inv_mc_y_inv_mc_y_via_mc_tg_fbm_a_tg_fbm_a_via_y_dup1_t1
+ a|inv_mc_y|inv_mc_y_via|mc|tg_fbm_a|tg_fbm_a_via|y__t12
+ a|inv_mc_y|inv_mc_y_via|mc|tg_fbm_a|tg_fbm_a_via|y$1 208.313425
* device instance a_inv_mc_y_inv_mc_y_via_mc_tg_fbm_a_tg_fbm_a_via_y_dup1_t2 r0 *1 0,0
Ra_inv_mc_y_inv_mc_y_via_mc_tg_fbm_a_tg_fbm_a_via_y_dup1_t2
+ a|inv_mc_y|inv_mc_y_via|mc|tg_fbm_a|tg_fbm_a_via|y__t22
+ a|inv_mc_y|inv_mc_y_via|mc|tg_fbm_a|tg_fbm_a_via|y$1 208.313425
* device instance a_inv_mc_y_inv_mc_y_via_mc_tg_fbm_a_tg_fbm_a_via_y_dup1_t3 r0 *1 0,0
Ra_inv_mc_y_inv_mc_y_via_mc_tg_fbm_a_tg_fbm_a_via_y_dup1_t3
+ a|inv_mc_y|inv_mc_y_via|mc|tg_fbm_a|tg_fbm_a_via|y__t32
+ a|inv_mc_y|inv_mc_y_via|mc|tg_fbm_a|tg_fbm_a_via|y$1 208.313425
* device instance a_inv_mc_y_inv_mc_y_via_mc_tg_fbm_a_tg_fbm_a_via_y_dup1 r0 *1 0,0
Ca_inv_mc_y_inv_mc_y_via_mc_tg_fbm_a_tg_fbm_a_via_y_dup1
+ a|inv_mc_y|inv_mc_y_via|mc|tg_fbm_a|tg_fbm_a_via|y$1 vsubs 1.955756e-15
* device instance a_inv_mc_y_inv_mc_y_via_mc_tg_fbm_a_tg_fbm_a_via_y_dup2_t0 r0 *1 0,0
Ra_inv_mc_y_inv_mc_y_via_mc_tg_fbm_a_tg_fbm_a_via_y_dup2_t0
+ a|inv_mc_y|inv_mc_y_via|mc|tg_fbm_a|tg_fbm_a_via|y__t03
+ a|inv_mc_y|inv_mc_y_via|mc|tg_fbm_a|tg_fbm_a_via|y$2 208.313425
* device instance a_inv_mc_y_inv_mc_y_via_mc_tg_fbm_a_tg_fbm_a_via_y_dup2_t1 r0 *1 0,0
Ra_inv_mc_y_inv_mc_y_via_mc_tg_fbm_a_tg_fbm_a_via_y_dup2_t1
+ a|inv_mc_y|inv_mc_y_via|mc|tg_fbm_a|tg_fbm_a_via|y__t13
+ a|inv_mc_y|inv_mc_y_via|mc|tg_fbm_a|tg_fbm_a_via|y$2 208.313425
* device instance a_inv_mc_y_inv_mc_y_via_mc_tg_fbm_a_tg_fbm_a_via_y_dup2_t2 r0 *1 0,0
Ra_inv_mc_y_inv_mc_y_via_mc_tg_fbm_a_tg_fbm_a_via_y_dup2_t2
+ a|inv_mc_y|inv_mc_y_via|mc|tg_fbm_a|tg_fbm_a_via|y__t23
+ a|inv_mc_y|inv_mc_y_via|mc|tg_fbm_a|tg_fbm_a_via|y$2 208.313425
* device instance a_inv_mc_y_inv_mc_y_via_mc_tg_fbm_a_tg_fbm_a_via_y_dup2_t3 r0 *1 0,0
Ra_inv_mc_y_inv_mc_y_via_mc_tg_fbm_a_tg_fbm_a_via_y_dup2_t3
+ a|inv_mc_y|inv_mc_y_via|mc|tg_fbm_a|tg_fbm_a_via|y__t33
+ a|inv_mc_y|inv_mc_y_via|mc|tg_fbm_a|tg_fbm_a_via|y$2 208.313425
* device instance a_inv_mc_y_inv_mc_y_via_mc_tg_fbm_a_tg_fbm_a_via_y_dup2 r0 *1 0,0
Ca_inv_mc_y_inv_mc_y_via_mc_tg_fbm_a_tg_fbm_a_via_y_dup2
+ a|inv_mc_y|inv_mc_y_via|mc|tg_fbm_a|tg_fbm_a_via|y$2 vsubs 1.955756e-15
* device instance a_inv_mc_y_inv_mc_y_via_mc_tg_fbm_a_tg_fbm_a_via_y_dup3_t0 r0 *1 0,0
Ra_inv_mc_y_inv_mc_y_via_mc_tg_fbm_a_tg_fbm_a_via_y_dup3_t0
+ a|inv_mc_y|inv_mc_y_via|mc|tg_fbm_a|tg_fbm_a_via|y__t04
+ a|inv_mc_y|inv_mc_y_via|mc|tg_fbm_a|tg_fbm_a_via|y$3 208.313425
* device instance a_inv_mc_y_inv_mc_y_via_mc_tg_fbm_a_tg_fbm_a_via_y_dup3_t1 r0 *1 0,0
Ra_inv_mc_y_inv_mc_y_via_mc_tg_fbm_a_tg_fbm_a_via_y_dup3_t1
+ a|inv_mc_y|inv_mc_y_via|mc|tg_fbm_a|tg_fbm_a_via|y__t14
+ a|inv_mc_y|inv_mc_y_via|mc|tg_fbm_a|tg_fbm_a_via|y$3 208.313425
* device instance a_inv_mc_y_inv_mc_y_via_mc_tg_fbm_a_tg_fbm_a_via_y_dup3_t2 r0 *1 0,0
Ra_inv_mc_y_inv_mc_y_via_mc_tg_fbm_a_tg_fbm_a_via_y_dup3_t2
+ a|inv_mc_y|inv_mc_y_via|mc|tg_fbm_a|tg_fbm_a_via|y__t24
+ a|inv_mc_y|inv_mc_y_via|mc|tg_fbm_a|tg_fbm_a_via|y$3 208.313425
* device instance a_inv_mc_y_inv_mc_y_via_mc_tg_fbm_a_tg_fbm_a_via_y_dup3_t3 r0 *1 0,0
Ra_inv_mc_y_inv_mc_y_via_mc_tg_fbm_a_tg_fbm_a_via_y_dup3_t3
+ a|inv_mc_y|inv_mc_y_via|mc|tg_fbm_a|tg_fbm_a_via|y__t34
+ a|inv_mc_y|inv_mc_y_via|mc|tg_fbm_a|tg_fbm_a_via|y$3 208.313425
* device instance a_inv_mc_y_inv_mc_y_via_mc_tg_fbm_a_tg_fbm_a_via_y_dup3 r0 *1 0,0
Ca_inv_mc_y_inv_mc_y_via_mc_tg_fbm_a_tg_fbm_a_via_y_dup3
+ a|inv_mc_y|inv_mc_y_via|mc|tg_fbm_a|tg_fbm_a_via|y$3 vsubs 1.955756e-15
* device instance a_inv_mc_y_inv_mc_y_via_mc_tg_fbm_a_tg_fbm_a_via_y_dup4_t0 r0 *1 0,0
Ra_inv_mc_y_inv_mc_y_via_mc_tg_fbm_a_tg_fbm_a_via_y_dup4_t0
+ a|inv_mc_y|inv_mc_y_via|mc|tg_fbm_a|tg_fbm_a_via|y__t05
+ a|inv_mc_y|inv_mc_y_via|mc|tg_fbm_a|tg_fbm_a_via|y$4 208.313425
* device instance a_inv_mc_y_inv_mc_y_via_mc_tg_fbm_a_tg_fbm_a_via_y_dup4_t1 r0 *1 0,0
Ra_inv_mc_y_inv_mc_y_via_mc_tg_fbm_a_tg_fbm_a_via_y_dup4_t1
+ a|inv_mc_y|inv_mc_y_via|mc|tg_fbm_a|tg_fbm_a_via|y__t15
+ a|inv_mc_y|inv_mc_y_via|mc|tg_fbm_a|tg_fbm_a_via|y$4 208.313425
* device instance a_inv_mc_y_inv_mc_y_via_mc_tg_fbm_a_tg_fbm_a_via_y_dup4_t2 r0 *1 0,0
Ra_inv_mc_y_inv_mc_y_via_mc_tg_fbm_a_tg_fbm_a_via_y_dup4_t2
+ a|inv_mc_y|inv_mc_y_via|mc|tg_fbm_a|tg_fbm_a_via|y__t25
+ a|inv_mc_y|inv_mc_y_via|mc|tg_fbm_a|tg_fbm_a_via|y$4 208.313425
* device instance a_inv_mc_y_inv_mc_y_via_mc_tg_fbm_a_tg_fbm_a_via_y_dup4_t3 r0 *1 0,0
Ra_inv_mc_y_inv_mc_y_via_mc_tg_fbm_a_tg_fbm_a_via_y_dup4_t3
+ a|inv_mc_y|inv_mc_y_via|mc|tg_fbm_a|tg_fbm_a_via|y__t35
+ a|inv_mc_y|inv_mc_y_via|mc|tg_fbm_a|tg_fbm_a_via|y$4 208.313425
* device instance a_inv_mc_y_inv_mc_y_via_mc_tg_fbm_a_tg_fbm_a_via_y_dup4 r0 *1 0,0
Ca_inv_mc_y_inv_mc_y_via_mc_tg_fbm_a_tg_fbm_a_via_y_dup4
+ a|inv_mc_y|inv_mc_y_via|mc|tg_fbm_a|tg_fbm_a_via|y$4 vsubs 1.955756e-15
* device instance a_inv_mc_y_inv_mc_y_via_mc_tg_fbm_a_tg_fbm_a_via_y_dup5_t0 r0 *1 0,0
Ra_inv_mc_y_inv_mc_y_via_mc_tg_fbm_a_tg_fbm_a_via_y_dup5_t0
+ a|inv_mc_y|inv_mc_y_via|mc|tg_fbm_a|tg_fbm_a_via|y__t06
+ a|inv_mc_y|inv_mc_y_via|mc|tg_fbm_a|tg_fbm_a_via|y$5 208.313425
* device instance a_inv_mc_y_inv_mc_y_via_mc_tg_fbm_a_tg_fbm_a_via_y_dup5_t1 r0 *1 0,0
Ra_inv_mc_y_inv_mc_y_via_mc_tg_fbm_a_tg_fbm_a_via_y_dup5_t1
+ a|inv_mc_y|inv_mc_y_via|mc|tg_fbm_a|tg_fbm_a_via|y__t16
+ a|inv_mc_y|inv_mc_y_via|mc|tg_fbm_a|tg_fbm_a_via|y$5 208.313425
* device instance a_inv_mc_y_inv_mc_y_via_mc_tg_fbm_a_tg_fbm_a_via_y_dup5_t2 r0 *1 0,0
Ra_inv_mc_y_inv_mc_y_via_mc_tg_fbm_a_tg_fbm_a_via_y_dup5_t2
+ a|inv_mc_y|inv_mc_y_via|mc|tg_fbm_a|tg_fbm_a_via|y__t26
+ a|inv_mc_y|inv_mc_y_via|mc|tg_fbm_a|tg_fbm_a_via|y$5 208.313425
* device instance a_inv_mc_y_inv_mc_y_via_mc_tg_fbm_a_tg_fbm_a_via_y_dup5_t3 r0 *1 0,0
Ra_inv_mc_y_inv_mc_y_via_mc_tg_fbm_a_tg_fbm_a_via_y_dup5_t3
+ a|inv_mc_y|inv_mc_y_via|mc|tg_fbm_a|tg_fbm_a_via|y__t36
+ a|inv_mc_y|inv_mc_y_via|mc|tg_fbm_a|tg_fbm_a_via|y$5 208.313425
* device instance a_inv_mc_y_inv_mc_y_via_mc_tg_fbm_a_tg_fbm_a_via_y_dup5 r0 *1 0,0
Ca_inv_mc_y_inv_mc_y_via_mc_tg_fbm_a_tg_fbm_a_via_y_dup5
+ a|inv_mc_y|inv_mc_y_via|mc|tg_fbm_a|tg_fbm_a_via|y$5 vsubs 1.955756e-15
* device instance a_inv_q_y_inv_q_y_via_inv_q_y_via2_nand_s2_a_nand_s2_a_stub_nand_s2_a_via_nand_s2_a_via2_q_y_t0 r0 *1 0,0
Ra_inv_q_y_inv_q_y_via_inv_q_y_via2_nand_s2_a_nand_s2_a_stub_nand_s2_a_via_nand_s2_a_via2_q_y_t0
+ a|inv_q_y|inv_q_y_via|inv_q_y_via2|nand_s2_a|nand_s2_a_stub|nand_s2_a_via|nand_s2_a_via2|q|y__t0
+ a|inv_q_y|inv_q_y_via|inv_q_y_via2|nand_s2_a|nand_s2_a_stub|nand_s2_a_via|nand_s2_a_via2|q|y
+ 233.614896758
* device instance a_inv_q_y_inv_q_y_via_inv_q_y_via2_nand_s2_a_nand_s2_a_stub_nand_s2_a_via_nand_s2_a_via2_q_y_t1 r0 *1 0,0
Ra_inv_q_y_inv_q_y_via_inv_q_y_via2_nand_s2_a_nand_s2_a_stub_nand_s2_a_via_nand_s2_a_via2_q_y_t1
+ a|inv_q_y|inv_q_y_via|inv_q_y_via2|nand_s2_a|nand_s2_a_stub|nand_s2_a_via|nand_s2_a_via2|q|y__t1
+ a|inv_q_y|inv_q_y_via|inv_q_y_via2|nand_s2_a|nand_s2_a_stub|nand_s2_a_via|nand_s2_a_via2|q|y
+ 241.108451742
* device instance a_inv_q_y_inv_q_y_via_inv_q_y_via2_nand_s2_a_nand_s2_a_stub_nand_s2_a_via_nand_s2_a_via2_q_y_t2 r0 *1 0,0
Ra_inv_q_y_inv_q_y_via_inv_q_y_via2_nand_s2_a_nand_s2_a_stub_nand_s2_a_via_nand_s2_a_via2_q_y_t2
+ a|inv_q_y|inv_q_y_via|inv_q_y_via2|nand_s2_a|nand_s2_a_stub|nand_s2_a_via|nand_s2_a_via2|q|y__t2
+ a|inv_q_y|inv_q_y_via|inv_q_y_via2|nand_s2_a|nand_s2_a_stub|nand_s2_a_via|nand_s2_a_via2|q|y
+ 254.024587343
* device instance a_inv_q_y_inv_q_y_via_inv_q_y_via2_nand_s2_a_nand_s2_a_stub_nand_s2_a_via_nand_s2_a_via2_q_y_t3 r0 *1 0,0
Ra_inv_q_y_inv_q_y_via_inv_q_y_via2_nand_s2_a_nand_s2_a_stub_nand_s2_a_via_nand_s2_a_via2_q_y_t3
+ a|inv_q_y|inv_q_y_via|inv_q_y_via2|nand_s2_a|nand_s2_a_stub|nand_s2_a_via|nand_s2_a_via2|q|y__t3
+ a|inv_q_y|inv_q_y_via|inv_q_y_via2|nand_s2_a|nand_s2_a_stub|nand_s2_a_via|nand_s2_a_via2|q|y
+ 236.747864158
* device instance a_inv_q_y_inv_q_y_via_inv_q_y_via2_nand_s2_a_nand_s2_a_stub_nand_s2_a_via_nand_s2_a_via2_q_y r0 *1 0,0
Ca_inv_q_y_inv_q_y_via_inv_q_y_via2_nand_s2_a_nand_s2_a_stub_nand_s2_a_via_nand_s2_a_via2_q_y
+ a|inv_q_y|inv_q_y_via|inv_q_y_via2|nand_s2_a|nand_s2_a_stub|nand_s2_a_via|nand_s2_a_via2|q|y
+ vsubs 2.344911e-15
* device instance a_inv_q_y_inv_q_y_via_inv_q_y_via2_nand_s2_a_nand_s2_a_stub_nand_s2_a_via_nand_s2_a_via2_q_y_dup1_t0 r0 *1 0,0
Ra_inv_q_y_inv_q_y_via_inv_q_y_via2_nand_s2_a_nand_s2_a_stub_nand_s2_a_via_nand_s2_a_via2_q_y_dup1_t0
+ a|inv_q_y|inv_q_y_via|inv_q_y_via2|nand_s2_a|nand_s2_a_stub|nand_s2_a_via|nand_s2_a_via2|q|y__t02
+ a|inv_q_y|inv_q_y_via|inv_q_y_via2|nand_s2_a|nand_s2_a_stub|nand_s2_a_via|nand_s2_a_via2|q|y$1
+ 233.614896758
* device instance a_inv_q_y_inv_q_y_via_inv_q_y_via2_nand_s2_a_nand_s2_a_stub_nand_s2_a_via_nand_s2_a_via2_q_y_dup1_t1 r0 *1 0,0
Ra_inv_q_y_inv_q_y_via_inv_q_y_via2_nand_s2_a_nand_s2_a_stub_nand_s2_a_via_nand_s2_a_via2_q_y_dup1_t1
+ a|inv_q_y|inv_q_y_via|inv_q_y_via2|nand_s2_a|nand_s2_a_stub|nand_s2_a_via|nand_s2_a_via2|q|y__t12
+ a|inv_q_y|inv_q_y_via|inv_q_y_via2|nand_s2_a|nand_s2_a_stub|nand_s2_a_via|nand_s2_a_via2|q|y$1
+ 241.108451742
* device instance a_inv_q_y_inv_q_y_via_inv_q_y_via2_nand_s2_a_nand_s2_a_stub_nand_s2_a_via_nand_s2_a_via2_q_y_dup1_t2 r0 *1 0,0
Ra_inv_q_y_inv_q_y_via_inv_q_y_via2_nand_s2_a_nand_s2_a_stub_nand_s2_a_via_nand_s2_a_via2_q_y_dup1_t2
+ a|inv_q_y|inv_q_y_via|inv_q_y_via2|nand_s2_a|nand_s2_a_stub|nand_s2_a_via|nand_s2_a_via2|q|y__t22
+ a|inv_q_y|inv_q_y_via|inv_q_y_via2|nand_s2_a|nand_s2_a_stub|nand_s2_a_via|nand_s2_a_via2|q|y$1
+ 254.024587343
* device instance a_inv_q_y_inv_q_y_via_inv_q_y_via2_nand_s2_a_nand_s2_a_stub_nand_s2_a_via_nand_s2_a_via2_q_y_dup1_t3 r0 *1 0,0
Ra_inv_q_y_inv_q_y_via_inv_q_y_via2_nand_s2_a_nand_s2_a_stub_nand_s2_a_via_nand_s2_a_via2_q_y_dup1_t3
+ a|inv_q_y|inv_q_y_via|inv_q_y_via2|nand_s2_a|nand_s2_a_stub|nand_s2_a_via|nand_s2_a_via2|q|y__t32
+ a|inv_q_y|inv_q_y_via|inv_q_y_via2|nand_s2_a|nand_s2_a_stub|nand_s2_a_via|nand_s2_a_via2|q|y$1
+ 236.747864158
* device instance a_inv_q_y_inv_q_y_via_inv_q_y_via2_nand_s2_a_nand_s2_a_stub_nand_s2_a_via_nand_s2_a_via2_q_y_dup1 r0 *1 0,0
Ca_inv_q_y_inv_q_y_via_inv_q_y_via2_nand_s2_a_nand_s2_a_stub_nand_s2_a_via_nand_s2_a_via2_q_y_dup1
+ a|inv_q_y|inv_q_y_via|inv_q_y_via2|nand_s2_a|nand_s2_a_stub|nand_s2_a_via|nand_s2_a_via2|q|y$1
+ vsubs 2.344911e-15
* device instance a_inv_q_y_inv_q_y_via_inv_q_y_via2_nand_s2_a_nand_s2_a_stub_nand_s2_a_via_nand_s2_a_via2_q_y_dup2_t0 r0 *1 0,0
Ra_inv_q_y_inv_q_y_via_inv_q_y_via2_nand_s2_a_nand_s2_a_stub_nand_s2_a_via_nand_s2_a_via2_q_y_dup2_t0
+ a|inv_q_y|inv_q_y_via|inv_q_y_via2|nand_s2_a|nand_s2_a_stub|nand_s2_a_via|nand_s2_a_via2|q|y__t03
+ a|inv_q_y|inv_q_y_via|inv_q_y_via2|nand_s2_a|nand_s2_a_stub|nand_s2_a_via|nand_s2_a_via2|q|y$2
+ 233.614896758
* device instance a_inv_q_y_inv_q_y_via_inv_q_y_via2_nand_s2_a_nand_s2_a_stub_nand_s2_a_via_nand_s2_a_via2_q_y_dup2_t1 r0 *1 0,0
Ra_inv_q_y_inv_q_y_via_inv_q_y_via2_nand_s2_a_nand_s2_a_stub_nand_s2_a_via_nand_s2_a_via2_q_y_dup2_t1
+ a|inv_q_y|inv_q_y_via|inv_q_y_via2|nand_s2_a|nand_s2_a_stub|nand_s2_a_via|nand_s2_a_via2|q|y__t13
+ a|inv_q_y|inv_q_y_via|inv_q_y_via2|nand_s2_a|nand_s2_a_stub|nand_s2_a_via|nand_s2_a_via2|q|y$2
+ 241.108451742
* device instance a_inv_q_y_inv_q_y_via_inv_q_y_via2_nand_s2_a_nand_s2_a_stub_nand_s2_a_via_nand_s2_a_via2_q_y_dup2_t2 r0 *1 0,0
Ra_inv_q_y_inv_q_y_via_inv_q_y_via2_nand_s2_a_nand_s2_a_stub_nand_s2_a_via_nand_s2_a_via2_q_y_dup2_t2
+ a|inv_q_y|inv_q_y_via|inv_q_y_via2|nand_s2_a|nand_s2_a_stub|nand_s2_a_via|nand_s2_a_via2|q|y__t23
+ a|inv_q_y|inv_q_y_via|inv_q_y_via2|nand_s2_a|nand_s2_a_stub|nand_s2_a_via|nand_s2_a_via2|q|y$2
+ 254.024587343
* device instance a_inv_q_y_inv_q_y_via_inv_q_y_via2_nand_s2_a_nand_s2_a_stub_nand_s2_a_via_nand_s2_a_via2_q_y_dup2_t3 r0 *1 0,0
Ra_inv_q_y_inv_q_y_via_inv_q_y_via2_nand_s2_a_nand_s2_a_stub_nand_s2_a_via_nand_s2_a_via2_q_y_dup2_t3
+ a|inv_q_y|inv_q_y_via|inv_q_y_via2|nand_s2_a|nand_s2_a_stub|nand_s2_a_via|nand_s2_a_via2|q|y__t33
+ a|inv_q_y|inv_q_y_via|inv_q_y_via2|nand_s2_a|nand_s2_a_stub|nand_s2_a_via|nand_s2_a_via2|q|y$2
+ 236.747864158
* device instance a_inv_q_y_inv_q_y_via_inv_q_y_via2_nand_s2_a_nand_s2_a_stub_nand_s2_a_via_nand_s2_a_via2_q_y_dup2 r0 *1 0,0
Ca_inv_q_y_inv_q_y_via_inv_q_y_via2_nand_s2_a_nand_s2_a_stub_nand_s2_a_via_nand_s2_a_via2_q_y_dup2
+ a|inv_q_y|inv_q_y_via|inv_q_y_via2|nand_s2_a|nand_s2_a_stub|nand_s2_a_via|nand_s2_a_via2|q|y$2
+ vsubs 2.344911e-15
* device instance a_inv_q_y_inv_q_y_via_inv_q_y_via2_nand_s2_a_nand_s2_a_stub_nand_s2_a_via_nand_s2_a_via2_q_y_dup3_t0 r0 *1 0,0
Ra_inv_q_y_inv_q_y_via_inv_q_y_via2_nand_s2_a_nand_s2_a_stub_nand_s2_a_via_nand_s2_a_via2_q_y_dup3_t0
+ a|inv_q_y|inv_q_y_via|inv_q_y_via2|nand_s2_a|nand_s2_a_stub|nand_s2_a_via|nand_s2_a_via2|q|y__t04
+ a|inv_q_y|inv_q_y_via|inv_q_y_via2|nand_s2_a|nand_s2_a_stub|nand_s2_a_via|nand_s2_a_via2|q|y$3
+ 233.614896758
* device instance a_inv_q_y_inv_q_y_via_inv_q_y_via2_nand_s2_a_nand_s2_a_stub_nand_s2_a_via_nand_s2_a_via2_q_y_dup3_t1 r0 *1 0,0
Ra_inv_q_y_inv_q_y_via_inv_q_y_via2_nand_s2_a_nand_s2_a_stub_nand_s2_a_via_nand_s2_a_via2_q_y_dup3_t1
+ a|inv_q_y|inv_q_y_via|inv_q_y_via2|nand_s2_a|nand_s2_a_stub|nand_s2_a_via|nand_s2_a_via2|q|y__t14
+ a|inv_q_y|inv_q_y_via|inv_q_y_via2|nand_s2_a|nand_s2_a_stub|nand_s2_a_via|nand_s2_a_via2|q|y$3
+ 241.108451742
* device instance a_inv_q_y_inv_q_y_via_inv_q_y_via2_nand_s2_a_nand_s2_a_stub_nand_s2_a_via_nand_s2_a_via2_q_y_dup3_t2 r0 *1 0,0
Ra_inv_q_y_inv_q_y_via_inv_q_y_via2_nand_s2_a_nand_s2_a_stub_nand_s2_a_via_nand_s2_a_via2_q_y_dup3_t2
+ a|inv_q_y|inv_q_y_via|inv_q_y_via2|nand_s2_a|nand_s2_a_stub|nand_s2_a_via|nand_s2_a_via2|q|y__t24
+ a|inv_q_y|inv_q_y_via|inv_q_y_via2|nand_s2_a|nand_s2_a_stub|nand_s2_a_via|nand_s2_a_via2|q|y$3
+ 254.024587343
* device instance a_inv_q_y_inv_q_y_via_inv_q_y_via2_nand_s2_a_nand_s2_a_stub_nand_s2_a_via_nand_s2_a_via2_q_y_dup3_t3 r0 *1 0,0
Ra_inv_q_y_inv_q_y_via_inv_q_y_via2_nand_s2_a_nand_s2_a_stub_nand_s2_a_via_nand_s2_a_via2_q_y_dup3_t3
+ a|inv_q_y|inv_q_y_via|inv_q_y_via2|nand_s2_a|nand_s2_a_stub|nand_s2_a_via|nand_s2_a_via2|q|y__t34
+ a|inv_q_y|inv_q_y_via|inv_q_y_via2|nand_s2_a|nand_s2_a_stub|nand_s2_a_via|nand_s2_a_via2|q|y$3
+ 236.747864158
* device instance a_inv_q_y_inv_q_y_via_inv_q_y_via2_nand_s2_a_nand_s2_a_stub_nand_s2_a_via_nand_s2_a_via2_q_y_dup3 r0 *1 0,0
Ca_inv_q_y_inv_q_y_via_inv_q_y_via2_nand_s2_a_nand_s2_a_stub_nand_s2_a_via_nand_s2_a_via2_q_y_dup3
+ a|inv_q_y|inv_q_y_via|inv_q_y_via2|nand_s2_a|nand_s2_a_stub|nand_s2_a_via|nand_s2_a_via2|q|y$3
+ vsubs 2.344911e-15
* device instance a_inv_q_y_inv_q_y_via_inv_q_y_via2_nand_s2_a_nand_s2_a_stub_nand_s2_a_via_nand_s2_a_via2_q_y_dup4_t0 r0 *1 0,0
Ra_inv_q_y_inv_q_y_via_inv_q_y_via2_nand_s2_a_nand_s2_a_stub_nand_s2_a_via_nand_s2_a_via2_q_y_dup4_t0
+ a|inv_q_y|inv_q_y_via|inv_q_y_via2|nand_s2_a|nand_s2_a_stub|nand_s2_a_via|nand_s2_a_via2|q|y__t05
+ a|inv_q_y|inv_q_y_via|inv_q_y_via2|nand_s2_a|nand_s2_a_stub|nand_s2_a_via|nand_s2_a_via2|q|y$4
+ 233.614896758
* device instance a_inv_q_y_inv_q_y_via_inv_q_y_via2_nand_s2_a_nand_s2_a_stub_nand_s2_a_via_nand_s2_a_via2_q_y_dup4_t1 r0 *1 0,0
Ra_inv_q_y_inv_q_y_via_inv_q_y_via2_nand_s2_a_nand_s2_a_stub_nand_s2_a_via_nand_s2_a_via2_q_y_dup4_t1
+ a|inv_q_y|inv_q_y_via|inv_q_y_via2|nand_s2_a|nand_s2_a_stub|nand_s2_a_via|nand_s2_a_via2|q|y__t15
+ a|inv_q_y|inv_q_y_via|inv_q_y_via2|nand_s2_a|nand_s2_a_stub|nand_s2_a_via|nand_s2_a_via2|q|y$4
+ 241.108451742
* device instance a_inv_q_y_inv_q_y_via_inv_q_y_via2_nand_s2_a_nand_s2_a_stub_nand_s2_a_via_nand_s2_a_via2_q_y_dup4_t2 r0 *1 0,0
Ra_inv_q_y_inv_q_y_via_inv_q_y_via2_nand_s2_a_nand_s2_a_stub_nand_s2_a_via_nand_s2_a_via2_q_y_dup4_t2
+ a|inv_q_y|inv_q_y_via|inv_q_y_via2|nand_s2_a|nand_s2_a_stub|nand_s2_a_via|nand_s2_a_via2|q|y__t25
+ a|inv_q_y|inv_q_y_via|inv_q_y_via2|nand_s2_a|nand_s2_a_stub|nand_s2_a_via|nand_s2_a_via2|q|y$4
+ 254.024587343
* device instance a_inv_q_y_inv_q_y_via_inv_q_y_via2_nand_s2_a_nand_s2_a_stub_nand_s2_a_via_nand_s2_a_via2_q_y_dup4_t3 r0 *1 0,0
Ra_inv_q_y_inv_q_y_via_inv_q_y_via2_nand_s2_a_nand_s2_a_stub_nand_s2_a_via_nand_s2_a_via2_q_y_dup4_t3
+ a|inv_q_y|inv_q_y_via|inv_q_y_via2|nand_s2_a|nand_s2_a_stub|nand_s2_a_via|nand_s2_a_via2|q|y__t35
+ a|inv_q_y|inv_q_y_via|inv_q_y_via2|nand_s2_a|nand_s2_a_stub|nand_s2_a_via|nand_s2_a_via2|q|y$4
+ 236.747864158
* device instance a_inv_q_y_inv_q_y_via_inv_q_y_via2_nand_s2_a_nand_s2_a_stub_nand_s2_a_via_nand_s2_a_via2_q_y_dup4 r0 *1 0,0
Ca_inv_q_y_inv_q_y_via_inv_q_y_via2_nand_s2_a_nand_s2_a_stub_nand_s2_a_via_nand_s2_a_via2_q_y_dup4
+ a|inv_q_y|inv_q_y_via|inv_q_y_via2|nand_s2_a|nand_s2_a_stub|nand_s2_a_via|nand_s2_a_via2|q|y$4
+ vsubs 2.344911e-15
* device instance a_inv_q_y_inv_q_y_via_inv_q_y_via2_nand_s2_a_nand_s2_a_stub_nand_s2_a_via_nand_s2_a_via2_q_y_dup5_t0 r0 *1 0,0
Ra_inv_q_y_inv_q_y_via_inv_q_y_via2_nand_s2_a_nand_s2_a_stub_nand_s2_a_via_nand_s2_a_via2_q_y_dup5_t0
+ a|inv_q_y|inv_q_y_via|inv_q_y_via2|nand_s2_a|nand_s2_a_stub|nand_s2_a_via|nand_s2_a_via2|q|y__t06
+ a|inv_q_y|inv_q_y_via|inv_q_y_via2|nand_s2_a|nand_s2_a_stub|nand_s2_a_via|nand_s2_a_via2|q|y$5
+ 233.614896758
* device instance a_inv_q_y_inv_q_y_via_inv_q_y_via2_nand_s2_a_nand_s2_a_stub_nand_s2_a_via_nand_s2_a_via2_q_y_dup5_t1 r0 *1 0,0
Ra_inv_q_y_inv_q_y_via_inv_q_y_via2_nand_s2_a_nand_s2_a_stub_nand_s2_a_via_nand_s2_a_via2_q_y_dup5_t1
+ a|inv_q_y|inv_q_y_via|inv_q_y_via2|nand_s2_a|nand_s2_a_stub|nand_s2_a_via|nand_s2_a_via2|q|y__t16
+ a|inv_q_y|inv_q_y_via|inv_q_y_via2|nand_s2_a|nand_s2_a_stub|nand_s2_a_via|nand_s2_a_via2|q|y$5
+ 241.108451742
* device instance a_inv_q_y_inv_q_y_via_inv_q_y_via2_nand_s2_a_nand_s2_a_stub_nand_s2_a_via_nand_s2_a_via2_q_y_dup5_t2 r0 *1 0,0
Ra_inv_q_y_inv_q_y_via_inv_q_y_via2_nand_s2_a_nand_s2_a_stub_nand_s2_a_via_nand_s2_a_via2_q_y_dup5_t2
+ a|inv_q_y|inv_q_y_via|inv_q_y_via2|nand_s2_a|nand_s2_a_stub|nand_s2_a_via|nand_s2_a_via2|q|y__t26
+ a|inv_q_y|inv_q_y_via|inv_q_y_via2|nand_s2_a|nand_s2_a_stub|nand_s2_a_via|nand_s2_a_via2|q|y$5
+ 254.024587343
* device instance a_inv_q_y_inv_q_y_via_inv_q_y_via2_nand_s2_a_nand_s2_a_stub_nand_s2_a_via_nand_s2_a_via2_q_y_dup5_t3 r0 *1 0,0
Ra_inv_q_y_inv_q_y_via_inv_q_y_via2_nand_s2_a_nand_s2_a_stub_nand_s2_a_via_nand_s2_a_via2_q_y_dup5_t3
+ a|inv_q_y|inv_q_y_via|inv_q_y_via2|nand_s2_a|nand_s2_a_stub|nand_s2_a_via|nand_s2_a_via2|q|y__t36
+ a|inv_q_y|inv_q_y_via|inv_q_y_via2|nand_s2_a|nand_s2_a_stub|nand_s2_a_via|nand_s2_a_via2|q|y$5
+ 236.747864158
* device instance a_inv_q_y_inv_q_y_via_inv_q_y_via2_nand_s2_a_nand_s2_a_stub_nand_s2_a_via_nand_s2_a_via2_q_y_dup5 r0 *1 0,0
Ca_inv_q_y_inv_q_y_via_inv_q_y_via2_nand_s2_a_nand_s2_a_stub_nand_s2_a_via_nand_s2_a_via2_q_y_dup5
+ a|inv_q_y|inv_q_y_via|inv_q_y_via2|nand_s2_a|nand_s2_a_stub|nand_s2_a_via|nand_s2_a_via2|q|y$5
+ vsubs 2.344911e-15
* device instance a_inva_a_mn12_g0_mp13_g0_t1_y_t0 r0 *1 0,0
Ra_inva_a_mn12_g0_mp13_g0_t1_y_t0 a|inva_a|mn12_g0|mp13_g0|t1|y__t0
+ a|inva_a|mn12_g0|mp13_g0|t1|y 393.96501156
* device instance a_inva_a_mn12_g0_mp13_g0_t1_y_t1 r0 *1 0,0
Ra_inva_a_mn12_g0_mp13_g0_t1_y_t1 a|inva_a|mn12_g0|mp13_g0|t1|y__t1
+ a|inva_a|mn12_g0|mp13_g0|t1|y 355.301959278
* device instance a_inva_a_mn12_g0_mp13_g0_t1_y_t2 r0 *1 0,0
Ra_inva_a_mn12_g0_mp13_g0_t1_y_t2 a|inva_a|mn12_g0|mp13_g0|t1|y__t2
+ a|inva_a|mn12_g0|mp13_g0|t1|y 312.148663125
* device instance a_inva_a_mn12_g0_mp13_g0_t1_y_t3 r0 *1 0,0
Ra_inva_a_mn12_g0_mp13_g0_t1_y_t3 a|inva_a|mn12_g0|mp13_g0|t1|y__t3
+ a|inva_a|mn12_g0|mp13_g0|t1|y 297.753615342
* device instance a_inva_a_mn12_g0_mp13_g0_t1_y_t4 r0 *1 0,0
Ra_inva_a_mn12_g0_mp13_g0_t1_y_t4 a|inva_a|mn12_g0|mp13_g0|t1|y__t4
+ a|inva_a|mn12_g0|mp13_g0|t1|y 299.162613598
* device instance a_inva_a_mn12_g0_mp13_g0_t1_y_t5 r0 *1 0,0
Ra_inva_a_mn12_g0_mp13_g0_t1_y_t5 a|inva_a|mn12_g0|mp13_g0|t1|y__t5
+ a|inva_a|mn12_g0|mp13_g0|t1|y 447.569121132
* device instance a_inva_a_mn12_g0_mp13_g0_t1_y_t6 r0 *1 0,0
Ra_inva_a_mn12_g0_mp13_g0_t1_y_t6 a|inva_a|mn12_g0|mp13_g0|t1|y__t6
+ a|inva_a|mn12_g0|mp13_g0|t1|y 396.959960366
* device instance a_inva_a_mn12_g0_mp13_g0_t1_y_t7 r0 *1 0,0
Ra_inva_a_mn12_g0_mp13_g0_t1_y_t7 a|inva_a|mn12_g0|mp13_g0|t1|y__t7
+ a|inva_a|mn12_g0|mp13_g0|t1|y 308.270155599
* device instance a_inva_a_mn12_g0_mp13_g0_t1_y r0 *1 0,0
Ca_inva_a_mn12_g0_mp13_g0_t1_y a|inva_a|mn12_g0|mp13_g0|t1|y vsubs 1.3119286e-14
* device instance a_mnab_y_mpa_y_mpb_y_nand_s2_y_qb_tg_fbs_a_y_t0 r0 *1 0,0
Ra_mnab_y_mpa_y_mpb_y_nand_s2_y_qb_tg_fbs_a_y_t0
+ a|mnab_y|mpa_y|mpb_y|nand_s2_y|qb|tg_fbs_a|y__t0
+ a|mnab_y|mpa_y|mpb_y|nand_s2_y|qb|tg_fbs_a|y 102.854507587
* device instance a_mnab_y_mpa_y_mpb_y_nand_s2_y_qb_tg_fbs_a_y_t1 r0 *1 0,0
Ra_mnab_y_mpa_y_mpb_y_nand_s2_y_qb_tg_fbs_a_y_t1
+ a|mnab_y|mpa_y|mpb_y|nand_s2_y|qb|tg_fbs_a|y__t1
+ a|mnab_y|mpa_y|mpb_y|nand_s2_y|qb|tg_fbs_a|y 104.443944063
* device instance a_mnab_y_mpa_y_mpb_y_nand_s2_y_qb_tg_fbs_a_y_t2 r0 *1 0,0
Ra_mnab_y_mpa_y_mpb_y_nand_s2_y_qb_tg_fbs_a_y_t2
+ a|mnab_y|mpa_y|mpb_y|nand_s2_y|qb|tg_fbs_a|y__t2
+ a|mnab_y|mpa_y|mpb_y|nand_s2_y|qb|tg_fbs_a|y 119.850286886
* device instance a_mnab_y_mpa_y_mpb_y_nand_s2_y_qb_tg_fbs_a_y_t3 r0 *1 0,0
Ra_mnab_y_mpa_y_mpb_y_nand_s2_y_qb_tg_fbs_a_y_t3
+ a|mnab_y|mpa_y|mpb_y|nand_s2_y|qb|tg_fbs_a|y__t3
+ a|mnab_y|mpa_y|mpb_y|nand_s2_y|qb|tg_fbs_a|y 73.0356963663
* device instance a_mnab_y_mpa_y_mpb_y_nand_s2_y_qb_tg_fbs_a_y_t4 r0 *1 0,0
Ra_mnab_y_mpa_y_mpb_y_nand_s2_y_qb_tg_fbs_a_y_t4
+ a|mnab_y|mpa_y|mpb_y|nand_s2_y|qb|tg_fbs_a|y__t4
+ a|mnab_y|mpa_y|mpb_y|nand_s2_y|qb|tg_fbs_a|y 88.9484650974
* device instance a_mnab_y_mpa_y_mpb_y_nand_s2_y_qb_tg_fbs_a_y r0 *1 0,0
Ca_mnab_y_mpa_y_mpb_y_nand_s2_y_qb_tg_fbs_a_y
+ a|mnab_y|mpa_y|mpb_y|nand_s2_y|qb|tg_fbs_a|y vsubs 2.243998e-15
* device instance a_mnab_y_mpa_y_mpb_y_nand_s2_y_qb_tg_fbs_a_y_dup1_t0 r0 *1 0,0
Ra_mnab_y_mpa_y_mpb_y_nand_s2_y_qb_tg_fbs_a_y_dup1_t0
+ a|mnab_y|mpa_y|mpb_y|nand_s2_y|qb|tg_fbs_a|y__t02
+ a|mnab_y|mpa_y|mpb_y|nand_s2_y|qb|tg_fbs_a|y$1 104.443944063
* device instance a_mnab_y_mpa_y_mpb_y_nand_s2_y_qb_tg_fbs_a_y_dup1_t1 r0 *1 0,0
Ra_mnab_y_mpa_y_mpb_y_nand_s2_y_qb_tg_fbs_a_y_dup1_t1
+ a|mnab_y|mpa_y|mpb_y|nand_s2_y|qb|tg_fbs_a|y__t12
+ a|mnab_y|mpa_y|mpb_y|nand_s2_y|qb|tg_fbs_a|y$1 102.854507587
* device instance a_mnab_y_mpa_y_mpb_y_nand_s2_y_qb_tg_fbs_a_y_dup1_t2 r0 *1 0,0
Ra_mnab_y_mpa_y_mpb_y_nand_s2_y_qb_tg_fbs_a_y_dup1_t2
+ a|mnab_y|mpa_y|mpb_y|nand_s2_y|qb|tg_fbs_a|y__t22
+ a|mnab_y|mpa_y|mpb_y|nand_s2_y|qb|tg_fbs_a|y$1 119.850286886
* device instance a_mnab_y_mpa_y_mpb_y_nand_s2_y_qb_tg_fbs_a_y_dup1_t3 r0 *1 0,0
Ra_mnab_y_mpa_y_mpb_y_nand_s2_y_qb_tg_fbs_a_y_dup1_t3
+ a|mnab_y|mpa_y|mpb_y|nand_s2_y|qb|tg_fbs_a|y__t32
+ a|mnab_y|mpa_y|mpb_y|nand_s2_y|qb|tg_fbs_a|y$1 73.0356963663
* device instance a_mnab_y_mpa_y_mpb_y_nand_s2_y_qb_tg_fbs_a_y_dup1_t4 r0 *1 0,0
Ra_mnab_y_mpa_y_mpb_y_nand_s2_y_qb_tg_fbs_a_y_dup1_t4
+ a|mnab_y|mpa_y|mpb_y|nand_s2_y|qb|tg_fbs_a|y__t42
+ a|mnab_y|mpa_y|mpb_y|nand_s2_y|qb|tg_fbs_a|y$1 88.9484650974
* device instance a_mnab_y_mpa_y_mpb_y_nand_s2_y_qb_tg_fbs_a_y_dup1 r0 *1 0,0
Ca_mnab_y_mpa_y_mpb_y_nand_s2_y_qb_tg_fbs_a_y_dup1
+ a|mnab_y|mpa_y|mpb_y|nand_s2_y|qb|tg_fbs_a|y$1 vsubs 2.243998e-15
* device instance a_mnab_y_mpa_y_mpb_y_nand_s2_y_qb_tg_fbs_a_y_dup2_t0 r0 *1 0,0
Ra_mnab_y_mpa_y_mpb_y_nand_s2_y_qb_tg_fbs_a_y_dup2_t0
+ a|mnab_y|mpa_y|mpb_y|nand_s2_y|qb|tg_fbs_a|y__t03
+ a|mnab_y|mpa_y|mpb_y|nand_s2_y|qb|tg_fbs_a|y$2 102.854507587
* device instance a_mnab_y_mpa_y_mpb_y_nand_s2_y_qb_tg_fbs_a_y_dup2_t1 r0 *1 0,0
Ra_mnab_y_mpa_y_mpb_y_nand_s2_y_qb_tg_fbs_a_y_dup2_t1
+ a|mnab_y|mpa_y|mpb_y|nand_s2_y|qb|tg_fbs_a|y__t13
+ a|mnab_y|mpa_y|mpb_y|nand_s2_y|qb|tg_fbs_a|y$2 104.443944063
* device instance a_mnab_y_mpa_y_mpb_y_nand_s2_y_qb_tg_fbs_a_y_dup2_t2 r0 *1 0,0
Ra_mnab_y_mpa_y_mpb_y_nand_s2_y_qb_tg_fbs_a_y_dup2_t2
+ a|mnab_y|mpa_y|mpb_y|nand_s2_y|qb|tg_fbs_a|y__t23
+ a|mnab_y|mpa_y|mpb_y|nand_s2_y|qb|tg_fbs_a|y$2 119.850286886
* device instance a_mnab_y_mpa_y_mpb_y_nand_s2_y_qb_tg_fbs_a_y_dup2_t3 r0 *1 0,0
Ra_mnab_y_mpa_y_mpb_y_nand_s2_y_qb_tg_fbs_a_y_dup2_t3
+ a|mnab_y|mpa_y|mpb_y|nand_s2_y|qb|tg_fbs_a|y__t33
+ a|mnab_y|mpa_y|mpb_y|nand_s2_y|qb|tg_fbs_a|y$2 73.0356963663
* device instance a_mnab_y_mpa_y_mpb_y_nand_s2_y_qb_tg_fbs_a_y_dup2_t4 r0 *1 0,0
Ra_mnab_y_mpa_y_mpb_y_nand_s2_y_qb_tg_fbs_a_y_dup2_t4
+ a|mnab_y|mpa_y|mpb_y|nand_s2_y|qb|tg_fbs_a|y__t43
+ a|mnab_y|mpa_y|mpb_y|nand_s2_y|qb|tg_fbs_a|y$2 88.9484650974
* device instance a_mnab_y_mpa_y_mpb_y_nand_s2_y_qb_tg_fbs_a_y_dup2 r0 *1 0,0
Ca_mnab_y_mpa_y_mpb_y_nand_s2_y_qb_tg_fbs_a_y_dup2
+ a|mnab_y|mpa_y|mpb_y|nand_s2_y|qb|tg_fbs_a|y$2 vsubs 2.243998e-15
* device instance a_mnab_y_mpa_y_mpb_y_nand_s2_y_qb_tg_fbs_a_y_dup3_t0 r0 *1 0,0
Ra_mnab_y_mpa_y_mpb_y_nand_s2_y_qb_tg_fbs_a_y_dup3_t0
+ a|mnab_y|mpa_y|mpb_y|nand_s2_y|qb|tg_fbs_a|y__t04
+ a|mnab_y|mpa_y|mpb_y|nand_s2_y|qb|tg_fbs_a|y$3 104.443944063
* device instance a_mnab_y_mpa_y_mpb_y_nand_s2_y_qb_tg_fbs_a_y_dup3_t1 r0 *1 0,0
Ra_mnab_y_mpa_y_mpb_y_nand_s2_y_qb_tg_fbs_a_y_dup3_t1
+ a|mnab_y|mpa_y|mpb_y|nand_s2_y|qb|tg_fbs_a|y__t14
+ a|mnab_y|mpa_y|mpb_y|nand_s2_y|qb|tg_fbs_a|y$3 102.854507587
* device instance a_mnab_y_mpa_y_mpb_y_nand_s2_y_qb_tg_fbs_a_y_dup3_t2 r0 *1 0,0
Ra_mnab_y_mpa_y_mpb_y_nand_s2_y_qb_tg_fbs_a_y_dup3_t2
+ a|mnab_y|mpa_y|mpb_y|nand_s2_y|qb|tg_fbs_a|y__t24
+ a|mnab_y|mpa_y|mpb_y|nand_s2_y|qb|tg_fbs_a|y$3 119.850286886
* device instance a_mnab_y_mpa_y_mpb_y_nand_s2_y_qb_tg_fbs_a_y_dup3_t3 r0 *1 0,0
Ra_mnab_y_mpa_y_mpb_y_nand_s2_y_qb_tg_fbs_a_y_dup3_t3
+ a|mnab_y|mpa_y|mpb_y|nand_s2_y|qb|tg_fbs_a|y__t34
+ a|mnab_y|mpa_y|mpb_y|nand_s2_y|qb|tg_fbs_a|y$3 73.0356963663
* device instance a_mnab_y_mpa_y_mpb_y_nand_s2_y_qb_tg_fbs_a_y_dup3_t4 r0 *1 0,0
Ra_mnab_y_mpa_y_mpb_y_nand_s2_y_qb_tg_fbs_a_y_dup3_t4
+ a|mnab_y|mpa_y|mpb_y|nand_s2_y|qb|tg_fbs_a|y__t44
+ a|mnab_y|mpa_y|mpb_y|nand_s2_y|qb|tg_fbs_a|y$3 88.9484650974
* device instance a_mnab_y_mpa_y_mpb_y_nand_s2_y_qb_tg_fbs_a_y_dup3 r0 *1 0,0
Ca_mnab_y_mpa_y_mpb_y_nand_s2_y_qb_tg_fbs_a_y_dup3
+ a|mnab_y|mpa_y|mpb_y|nand_s2_y|qb|tg_fbs_a|y$3 vsubs 2.243998e-15
* device instance a_mnab_y_mpa_y_mpb_y_nand_s2_y_qb_tg_fbs_a_y_dup4_t0 r0 *1 0,0
Ra_mnab_y_mpa_y_mpb_y_nand_s2_y_qb_tg_fbs_a_y_dup4_t0
+ a|mnab_y|mpa_y|mpb_y|nand_s2_y|qb|tg_fbs_a|y__t05
+ a|mnab_y|mpa_y|mpb_y|nand_s2_y|qb|tg_fbs_a|y$4 102.854507587
* device instance a_mnab_y_mpa_y_mpb_y_nand_s2_y_qb_tg_fbs_a_y_dup4_t1 r0 *1 0,0
Ra_mnab_y_mpa_y_mpb_y_nand_s2_y_qb_tg_fbs_a_y_dup4_t1
+ a|mnab_y|mpa_y|mpb_y|nand_s2_y|qb|tg_fbs_a|y__t15
+ a|mnab_y|mpa_y|mpb_y|nand_s2_y|qb|tg_fbs_a|y$4 104.443944063
* device instance a_mnab_y_mpa_y_mpb_y_nand_s2_y_qb_tg_fbs_a_y_dup4_t2 r0 *1 0,0
Ra_mnab_y_mpa_y_mpb_y_nand_s2_y_qb_tg_fbs_a_y_dup4_t2
+ a|mnab_y|mpa_y|mpb_y|nand_s2_y|qb|tg_fbs_a|y__t25
+ a|mnab_y|mpa_y|mpb_y|nand_s2_y|qb|tg_fbs_a|y$4 119.850286886
* device instance a_mnab_y_mpa_y_mpb_y_nand_s2_y_qb_tg_fbs_a_y_dup4_t3 r0 *1 0,0
Ra_mnab_y_mpa_y_mpb_y_nand_s2_y_qb_tg_fbs_a_y_dup4_t3
+ a|mnab_y|mpa_y|mpb_y|nand_s2_y|qb|tg_fbs_a|y__t35
+ a|mnab_y|mpa_y|mpb_y|nand_s2_y|qb|tg_fbs_a|y$4 73.0356963663
* device instance a_mnab_y_mpa_y_mpb_y_nand_s2_y_qb_tg_fbs_a_y_dup4_t4 r0 *1 0,0
Ra_mnab_y_mpa_y_mpb_y_nand_s2_y_qb_tg_fbs_a_y_dup4_t4
+ a|mnab_y|mpa_y|mpb_y|nand_s2_y|qb|tg_fbs_a|y__t45
+ a|mnab_y|mpa_y|mpb_y|nand_s2_y|qb|tg_fbs_a|y$4 88.9484650974
* device instance a_mnab_y_mpa_y_mpb_y_nand_s2_y_qb_tg_fbs_a_y_dup4 r0 *1 0,0
Ca_mnab_y_mpa_y_mpb_y_nand_s2_y_qb_tg_fbs_a_y_dup4
+ a|mnab_y|mpa_y|mpb_y|nand_s2_y|qb|tg_fbs_a|y$4 vsubs 2.243998e-15
* device instance a_mnab_y_mpa_y_mpb_y_nand_s2_y_qb_tg_fbs_a_y_dup5_t0 r0 *1 0,0
Ra_mnab_y_mpa_y_mpb_y_nand_s2_y_qb_tg_fbs_a_y_dup5_t0
+ a|mnab_y|mpa_y|mpb_y|nand_s2_y|qb|tg_fbs_a|y__t06
+ a|mnab_y|mpa_y|mpb_y|nand_s2_y|qb|tg_fbs_a|y$5 102.854507587
* device instance a_mnab_y_mpa_y_mpb_y_nand_s2_y_qb_tg_fbs_a_y_dup5_t1 r0 *1 0,0
Ra_mnab_y_mpa_y_mpb_y_nand_s2_y_qb_tg_fbs_a_y_dup5_t1
+ a|mnab_y|mpa_y|mpb_y|nand_s2_y|qb|tg_fbs_a|y__t16
+ a|mnab_y|mpa_y|mpb_y|nand_s2_y|qb|tg_fbs_a|y$5 104.443944063
* device instance a_mnab_y_mpa_y_mpb_y_nand_s2_y_qb_tg_fbs_a_y_dup5_t2 r0 *1 0,0
Ra_mnab_y_mpa_y_mpb_y_nand_s2_y_qb_tg_fbs_a_y_dup5_t2
+ a|mnab_y|mpa_y|mpb_y|nand_s2_y|qb|tg_fbs_a|y__t26
+ a|mnab_y|mpa_y|mpb_y|nand_s2_y|qb|tg_fbs_a|y$5 119.850286886
* device instance a_mnab_y_mpa_y_mpb_y_nand_s2_y_qb_tg_fbs_a_y_dup5_t3 r0 *1 0,0
Ra_mnab_y_mpa_y_mpb_y_nand_s2_y_qb_tg_fbs_a_y_dup5_t3
+ a|mnab_y|mpa_y|mpb_y|nand_s2_y|qb|tg_fbs_a|y__t36
+ a|mnab_y|mpa_y|mpb_y|nand_s2_y|qb|tg_fbs_a|y$5 73.0356963663
* device instance a_mnab_y_mpa_y_mpb_y_nand_s2_y_qb_tg_fbs_a_y_dup5_t4 r0 *1 0,0
Ra_mnab_y_mpa_y_mpb_y_nand_s2_y_qb_tg_fbs_a_y_dup5_t4
+ a|mnab_y|mpa_y|mpb_y|nand_s2_y|qb|tg_fbs_a|y__t46
+ a|mnab_y|mpa_y|mpb_y|nand_s2_y|qb|tg_fbs_a|y$5 88.9484650974
* device instance a_mnab_y_mpa_y_mpb_y_nand_s2_y_qb_tg_fbs_a_y_dup5 r0 *1 0,0
Ca_mnab_y_mpa_y_mpb_y_nand_s2_y_qb_tg_fbs_a_y_dup5
+ a|mnab_y|mpa_y|mpb_y|nand_s2_y|qb|tg_fbs_a|y$5 vsubs 2.243998e-15
* device instance a_n2_s1_y_s2_a_y_t0 r0 *1 0,0
Ra_n2_s1_y_s2_a_y_t0 a|n2|s1_y|s2_a|y__t0 a|n2|s1_y|s2_a|y 236.534411421
* device instance a_n2_s1_y_s2_a_y_t1 r0 *1 0,0
Ra_n2_s1_y_s2_a_y_t1 a|n2|s1_y|s2_a|y__t1 a|n2|s1_y|s2_a|y 216.012838579
* device instance a_n2_s1_y_s2_a_y_t2 r0 *1 0,0
Ra_n2_s1_y_s2_a_y_t2 a|n2|s1_y|s2_a|y__t2 a|n2|s1_y|s2_a|y 216.012838579
* device instance a_n2_s1_y_s2_a_y_t3 r0 *1 0,0
Ra_n2_s1_y_s2_a_y_t3 a|n2|s1_y|s2_a|y__t3 a|n2|s1_y|s2_a|y 236.534411421
* device instance a_n2_s1_y_s2_a_y r0 *1 0,0
Ca_n2_s1_y_s2_a_y a|n2|s1_y|s2_a|y vsubs 2.620771e-15
* device instance a_n2_s1_y_s2_a_y_dup1_t0 r0 *1 0,0
Ra_n2_s1_y_s2_a_y_dup1_t0 a|n2|s1_y|s2_a|y__t02 a|n2|s1_y|s2_a|y$1 236.534411421
* device instance a_n2_s1_y_s2_a_y_dup1_t1 r0 *1 0,0
Ra_n2_s1_y_s2_a_y_dup1_t1 a|n2|s1_y|s2_a|y__t12 a|n2|s1_y|s2_a|y$1 216.012838579
* device instance a_n2_s1_y_s2_a_y_dup1_t2 r0 *1 0,0
Ra_n2_s1_y_s2_a_y_dup1_t2 a|n2|s1_y|s2_a|y__t22 a|n2|s1_y|s2_a|y$1 216.012838579
* device instance a_n2_s1_y_s2_a_y_dup1_t3 r0 *1 0,0
Ra_n2_s1_y_s2_a_y_dup1_t3 a|n2|s1_y|s2_a|y__t32 a|n2|s1_y|s2_a|y$1 236.534411421
* device instance a_n2_s1_y_s2_a_y_dup1 r0 *1 0,0
Ca_n2_s1_y_s2_a_y_dup1 a|n2|s1_y|s2_a|y$1 vsubs 2.620771e-15
* device instance a_n2_s1_y_s2_a_y_dup2_t0 r0 *1 0,0
Ra_n2_s1_y_s2_a_y_dup2_t0 a|n2|s1_y|s2_a|y__t03 a|n2|s1_y|s2_a|y$2 236.534411421
* device instance a_n2_s1_y_s2_a_y_dup2_t1 r0 *1 0,0
Ra_n2_s1_y_s2_a_y_dup2_t1 a|n2|s1_y|s2_a|y__t13 a|n2|s1_y|s2_a|y$2 216.012838579
* device instance a_n2_s1_y_s2_a_y_dup2_t2 r0 *1 0,0
Ra_n2_s1_y_s2_a_y_dup2_t2 a|n2|s1_y|s2_a|y__t23 a|n2|s1_y|s2_a|y$2 216.012838579
* device instance a_n2_s1_y_s2_a_y_dup2_t3 r0 *1 0,0
Ra_n2_s1_y_s2_a_y_dup2_t3 a|n2|s1_y|s2_a|y__t33 a|n2|s1_y|s2_a|y$2 236.534411421
* device instance a_n2_s1_y_s2_a_y_dup2 r0 *1 0,0
Ca_n2_s1_y_s2_a_y_dup2 a|n2|s1_y|s2_a|y$2 vsubs 2.620771e-15
* device instance a_n2_s1_y_s2_a_y_dup3_t0 r0 *1 0,0
Ra_n2_s1_y_s2_a_y_dup3_t0 a|n2|s1_y|s2_a|y__t04 a|n2|s1_y|s2_a|y$3 236.534411421
* device instance a_n2_s1_y_s2_a_y_dup3_t1 r0 *1 0,0
Ra_n2_s1_y_s2_a_y_dup3_t1 a|n2|s1_y|s2_a|y__t14 a|n2|s1_y|s2_a|y$3 216.012838579
* device instance a_n2_s1_y_s2_a_y_dup3_t2 r0 *1 0,0
Ra_n2_s1_y_s2_a_y_dup3_t2 a|n2|s1_y|s2_a|y__t24 a|n2|s1_y|s2_a|y$3 216.012838579
* device instance a_n2_s1_y_s2_a_y_dup3_t3 r0 *1 0,0
Ra_n2_s1_y_s2_a_y_dup3_t3 a|n2|s1_y|s2_a|y__t34 a|n2|s1_y|s2_a|y$3 236.534411421
* device instance a_n2_s1_y_s2_a_y_dup3 r0 *1 0,0
Ca_n2_s1_y_s2_a_y_dup3 a|n2|s1_y|s2_a|y$3 vsubs 2.620771e-15
* device instance a_n3_s2_y_s3_a_y_t0 r0 *1 0,0
Ra_n3_s2_y_s3_a_y_t0 a|n3|s2_y|s3_a|y__t0 a|n3|s2_y|s3_a|y 236.534411421
* device instance a_n3_s2_y_s3_a_y_t1 r0 *1 0,0
Ra_n3_s2_y_s3_a_y_t1 a|n3|s2_y|s3_a|y__t1 a|n3|s2_y|s3_a|y 216.012838579
* device instance a_n3_s2_y_s3_a_y_t2 r0 *1 0,0
Ra_n3_s2_y_s3_a_y_t2 a|n3|s2_y|s3_a|y__t2 a|n3|s2_y|s3_a|y 216.012838579
* device instance a_n3_s2_y_s3_a_y_t3 r0 *1 0,0
Ra_n3_s2_y_s3_a_y_t3 a|n3|s2_y|s3_a|y__t3 a|n3|s2_y|s3_a|y 236.534411421
* device instance a_n3_s2_y_s3_a_y r0 *1 0,0
Ca_n3_s2_y_s3_a_y a|n3|s2_y|s3_a|y vsubs 2.620771e-15
* device instance a_n3_s2_y_s3_a_y_dup1_t0 r0 *1 0,0
Ra_n3_s2_y_s3_a_y_dup1_t0 a|n3|s2_y|s3_a|y__t02 a|n3|s2_y|s3_a|y$1 236.534411421
* device instance a_n3_s2_y_s3_a_y_dup1_t1 r0 *1 0,0
Ra_n3_s2_y_s3_a_y_dup1_t1 a|n3|s2_y|s3_a|y__t12 a|n3|s2_y|s3_a|y$1 216.012838579
* device instance a_n3_s2_y_s3_a_y_dup1_t2 r0 *1 0,0
Ra_n3_s2_y_s3_a_y_dup1_t2 a|n3|s2_y|s3_a|y__t22 a|n3|s2_y|s3_a|y$1 216.012838579
* device instance a_n3_s2_y_s3_a_y_dup1_t3 r0 *1 0,0
Ra_n3_s2_y_s3_a_y_dup1_t3 a|n3|s2_y|s3_a|y__t32 a|n3|s2_y|s3_a|y$1 236.534411421
* device instance a_n3_s2_y_s3_a_y_dup1 r0 *1 0,0
Ca_n3_s2_y_s3_a_y_dup1 a|n3|s2_y|s3_a|y$1 vsubs 2.620771e-15
* device instance a_n3_s2_y_s3_a_y_dup2_t0 r0 *1 0,0
Ra_n3_s2_y_s3_a_y_dup2_t0 a|n3|s2_y|s3_a|y__t03 a|n3|s2_y|s3_a|y$2 236.534411421
* device instance a_n3_s2_y_s3_a_y_dup2_t1 r0 *1 0,0
Ra_n3_s2_y_s3_a_y_dup2_t1 a|n3|s2_y|s3_a|y__t13 a|n3|s2_y|s3_a|y$2 216.012838579
* device instance a_n3_s2_y_s3_a_y_dup2_t2 r0 *1 0,0
Ra_n3_s2_y_s3_a_y_dup2_t2 a|n3|s2_y|s3_a|y__t23 a|n3|s2_y|s3_a|y$2 216.012838579
* device instance a_n3_s2_y_s3_a_y_dup2_t3 r0 *1 0,0
Ra_n3_s2_y_s3_a_y_dup2_t3 a|n3|s2_y|s3_a|y__t33 a|n3|s2_y|s3_a|y$2 236.534411421
* device instance a_n3_s2_y_s3_a_y_dup2 r0 *1 0,0
Ca_n3_s2_y_s3_a_y_dup2 a|n3|s2_y|s3_a|y$2 vsubs 2.620771e-15
* device instance a_n3_s2_y_s3_a_y_dup3_t0 r0 *1 0,0
Ra_n3_s2_y_s3_a_y_dup3_t0 a|n3|s2_y|s3_a|y__t04 a|n3|s2_y|s3_a|y$3 236.534411421
* device instance a_n3_s2_y_s3_a_y_dup3_t1 r0 *1 0,0
Ra_n3_s2_y_s3_a_y_dup3_t1 a|n3|s2_y|s3_a|y__t14 a|n3|s2_y|s3_a|y$3 216.012838579
* device instance a_n3_s2_y_s3_a_y_dup3_t2 r0 *1 0,0
Ra_n3_s2_y_s3_a_y_dup3_t2 a|n3|s2_y|s3_a|y__t24 a|n3|s2_y|s3_a|y$3 216.012838579
* device instance a_n3_s2_y_s3_a_y_dup3_t3 r0 *1 0,0
Ra_n3_s2_y_s3_a_y_dup3_t3 a|n3|s2_y|s3_a|y__t34 a|n3|s2_y|s3_a|y$3 236.534411421
* device instance a_n3_s2_y_s3_a_y_dup3 r0 *1 0,0
Ca_n3_s2_y_s3_a_y_dup3 a|n3|s2_y|s3_a|y$3 vsubs 2.620771e-15
* device instance a_n4_s3_y_s4_a_y_t0 r0 *1 0,0
Ra_n4_s3_y_s4_a_y_t0 a|n4|s3_y|s4_a|y__t0 a|n4|s3_y|s4_a|y 236.534411421
* device instance a_n4_s3_y_s4_a_y_t1 r0 *1 0,0
Ra_n4_s3_y_s4_a_y_t1 a|n4|s3_y|s4_a|y__t1 a|n4|s3_y|s4_a|y 216.012838579
* device instance a_n4_s3_y_s4_a_y_t2 r0 *1 0,0
Ra_n4_s3_y_s4_a_y_t2 a|n4|s3_y|s4_a|y__t2 a|n4|s3_y|s4_a|y 216.012838579
* device instance a_n4_s3_y_s4_a_y_t3 r0 *1 0,0
Ra_n4_s3_y_s4_a_y_t3 a|n4|s3_y|s4_a|y__t3 a|n4|s3_y|s4_a|y 236.534411421
* device instance a_n4_s3_y_s4_a_y r0 *1 0,0
Ca_n4_s3_y_s4_a_y a|n4|s3_y|s4_a|y vsubs 2.620771e-15
* device instance a_n4_s3_y_s4_a_y_dup1_t0 r0 *1 0,0
Ra_n4_s3_y_s4_a_y_dup1_t0 a|n4|s3_y|s4_a|y__t02 a|n4|s3_y|s4_a|y$1 236.534411421
* device instance a_n4_s3_y_s4_a_y_dup1_t1 r0 *1 0,0
Ra_n4_s3_y_s4_a_y_dup1_t1 a|n4|s3_y|s4_a|y__t12 a|n4|s3_y|s4_a|y$1 216.012838579
* device instance a_n4_s3_y_s4_a_y_dup1_t2 r0 *1 0,0
Ra_n4_s3_y_s4_a_y_dup1_t2 a|n4|s3_y|s4_a|y__t22 a|n4|s3_y|s4_a|y$1 216.012838579
* device instance a_n4_s3_y_s4_a_y_dup1_t3 r0 *1 0,0
Ra_n4_s3_y_s4_a_y_dup1_t3 a|n4|s3_y|s4_a|y__t32 a|n4|s3_y|s4_a|y$1 236.534411421
* device instance a_n4_s3_y_s4_a_y_dup1 r0 *1 0,0
Ca_n4_s3_y_s4_a_y_dup1 a|n4|s3_y|s4_a|y$1 vsubs 2.620771e-15
* device instance a_n4_s3_y_s4_a_y_dup2_t0 r0 *1 0,0
Ra_n4_s3_y_s4_a_y_dup2_t0 a|n4|s3_y|s4_a|y__t03 a|n4|s3_y|s4_a|y$2 236.534411421
* device instance a_n4_s3_y_s4_a_y_dup2_t1 r0 *1 0,0
Ra_n4_s3_y_s4_a_y_dup2_t1 a|n4|s3_y|s4_a|y__t13 a|n4|s3_y|s4_a|y$2 216.012838579
* device instance a_n4_s3_y_s4_a_y_dup2_t2 r0 *1 0,0
Ra_n4_s3_y_s4_a_y_dup2_t2 a|n4|s3_y|s4_a|y__t23 a|n4|s3_y|s4_a|y$2 216.012838579
* device instance a_n4_s3_y_s4_a_y_dup2_t3 r0 *1 0,0
Ra_n4_s3_y_s4_a_y_dup2_t3 a|n4|s3_y|s4_a|y__t33 a|n4|s3_y|s4_a|y$2 236.534411421
* device instance a_n4_s3_y_s4_a_y_dup2 r0 *1 0,0
Ca_n4_s3_y_s4_a_y_dup2 a|n4|s3_y|s4_a|y$2 vsubs 2.620771e-15
* device instance a_n4_s3_y_s4_a_y_dup3_t0 r0 *1 0,0
Ra_n4_s3_y_s4_a_y_dup3_t0 a|n4|s3_y|s4_a|y__t04 a|n4|s3_y|s4_a|y$3 236.534411421
* device instance a_n4_s3_y_s4_a_y_dup3_t1 r0 *1 0,0
Ra_n4_s3_y_s4_a_y_dup3_t1 a|n4|s3_y|s4_a|y__t14 a|n4|s3_y|s4_a|y$3 216.012838579
* device instance a_n4_s3_y_s4_a_y_dup3_t2 r0 *1 0,0
Ra_n4_s3_y_s4_a_y_dup3_t2 a|n4|s3_y|s4_a|y__t24 a|n4|s3_y|s4_a|y$3 216.012838579
* device instance a_n4_s3_y_s4_a_y_dup3_t3 r0 *1 0,0
Ra_n4_s3_y_s4_a_y_dup3_t3 a|n4|s3_y|s4_a|y__t34 a|n4|s3_y|s4_a|y$3 236.534411421
* device instance a_n4_s3_y_s4_a_y_dup3 r0 *1 0,0
Ca_n4_s3_y_s4_a_y_dup3 a|n4|s3_y|s4_a|y$3 vsubs 2.620771e-15
* device instance an_inva_y_mn34_g0_mp13_g1_y_t0 r0 *1 0,0
Ran_inva_y_mn34_g0_mp13_g1_y_t0 an|inva_y|mn34_g0|mp13_g1|y__t0
+ an|inva_y|mn34_g0|mp13_g1|y 286.425880004
* device instance an_inva_y_mn34_g0_mp13_g1_y_t1 r0 *1 0,0
Ran_inva_y_mn34_g0_mp13_g1_y_t1 an|inva_y|mn34_g0|mp13_g1|y__t1
+ an|inva_y|mn34_g0|mp13_g1|y 120.259350571
* device instance an_inva_y_mn34_g0_mp13_g1_y_t2 r0 *1 0,0
Ran_inva_y_mn34_g0_mp13_g1_y_t2 an|inva_y|mn34_g0|mp13_g1|y__t2
+ an|inva_y|mn34_g0|mp13_g1|y 148.815961258
* device instance an_inva_y_mn34_g0_mp13_g1_y_t3 r0 *1 0,0
Ran_inva_y_mn34_g0_mp13_g1_y_t3 an|inva_y|mn34_g0|mp13_g1|y__t3
+ an|inva_y|mn34_g0|mp13_g1|y 235.863908166
* device instance an_inva_y_mn34_g0_mp13_g1_y r0 *1 0,0
Can_inva_y_mn34_g0_mp13_g1_y an|inva_y|mn34_g0|mp13_g1|y vsubs 2.26736e-15
* device instance an_inva_y_mn34_g0_mp13_g1_y_dup1_t0 r0 *1 0,0
Ran_inva_y_mn34_g0_mp13_g1_y_dup1_t0 an|inva_y|mn34_g0|mp13_g1|y__t02
+ an|inva_y|mn34_g0|mp13_g1|y$1 286.425880004
* device instance an_inva_y_mn34_g0_mp13_g1_y_dup1_t1 r0 *1 0,0
Ran_inva_y_mn34_g0_mp13_g1_y_dup1_t1 an|inva_y|mn34_g0|mp13_g1|y__t12
+ an|inva_y|mn34_g0|mp13_g1|y$1 120.259350571
* device instance an_inva_y_mn34_g0_mp13_g1_y_dup1_t2 r0 *1 0,0
Ran_inva_y_mn34_g0_mp13_g1_y_dup1_t2 an|inva_y|mn34_g0|mp13_g1|y__t22
+ an|inva_y|mn34_g0|mp13_g1|y$1 148.815961258
* device instance an_inva_y_mn34_g0_mp13_g1_y_dup1_t3 r0 *1 0,0
Ran_inva_y_mn34_g0_mp13_g1_y_dup1_t3 an|inva_y|mn34_g0|mp13_g1|y__t32
+ an|inva_y|mn34_g0|mp13_g1|y$1 235.863908166
* device instance an_inva_y_mn34_g0_mp13_g1_y_dup1 r0 *1 0,0
Can_inva_y_mn34_g0_mp13_g1_y_dup1 an|inva_y|mn34_g0|mp13_g1|y$1 vsubs
+ 2.26736e-15
* device instance an_inva_y_mn34_g0_mp13_g1_y_dup2_t0 r0 *1 0,0
Ran_inva_y_mn34_g0_mp13_g1_y_dup2_t0 an|inva_y|mn34_g0|mp13_g1|y__t03
+ an|inva_y|mn34_g0|mp13_g1|y$2 286.425880004
* device instance an_inva_y_mn34_g0_mp13_g1_y_dup2_t1 r0 *1 0,0
Ran_inva_y_mn34_g0_mp13_g1_y_dup2_t1 an|inva_y|mn34_g0|mp13_g1|y__t13
+ an|inva_y|mn34_g0|mp13_g1|y$2 120.259350571
* device instance an_inva_y_mn34_g0_mp13_g1_y_dup2_t2 r0 *1 0,0
Ran_inva_y_mn34_g0_mp13_g1_y_dup2_t2 an|inva_y|mn34_g0|mp13_g1|y__t23
+ an|inva_y|mn34_g0|mp13_g1|y$2 148.815961258
* device instance an_inva_y_mn34_g0_mp13_g1_y_dup2_t3 r0 *1 0,0
Ran_inva_y_mn34_g0_mp13_g1_y_dup2_t3 an|inva_y|mn34_g0|mp13_g1|y__t33
+ an|inva_y|mn34_g0|mp13_g1|y$2 235.863908166
* device instance an_inva_y_mn34_g0_mp13_g1_y_dup2 r0 *1 0,0
Can_inva_y_mn34_g0_mp13_g1_y_dup2 an|inva_y|mn34_g0|mp13_g1|y$2 vsubs
+ 2.26736e-15
* device instance bn_invb_y_mn34_g1_mp24_g1_y_t0 r0 *1 0,0
Rbn_invb_y_mn34_g1_mp24_g1_y_t0 bn|invb_y|mn34_g1|mp24_g1|y__t0
+ bn|invb_y|mn34_g1|mp24_g1|y 185.302815577
* device instance bn_invb_y_mn34_g1_mp24_g1_y_t1 r0 *1 0,0
Rbn_invb_y_mn34_g1_mp24_g1_y_t1 bn|invb_y|mn34_g1|mp24_g1|y__t1
+ bn|invb_y|mn34_g1|mp24_g1|y 163.924646135
* device instance bn_invb_y_mn34_g1_mp24_g1_y_t2 r0 *1 0,0
Rbn_invb_y_mn34_g1_mp24_g1_y_t2 bn|invb_y|mn34_g1|mp24_g1|y__t2
+ bn|invb_y|mn34_g1|mp24_g1|y 173.955001003
* device instance bn_invb_y_mn34_g1_mp24_g1_y_t3 r0 *1 0,0
Rbn_invb_y_mn34_g1_mp24_g1_y_t3 bn|invb_y|mn34_g1|mp24_g1|y__t3
+ bn|invb_y|mn34_g1|mp24_g1|y 293.464337285
* device instance bn_invb_y_mn34_g1_mp24_g1_y r0 *1 0,0
Cbn_invb_y_mn34_g1_mp24_g1_y bn|invb_y|mn34_g1|mp24_g1|y vsubs 5.210763e-15
* device instance bn_invb_y_mn34_g1_mp24_g1_y_dup1_t0 r0 *1 0,0
Rbn_invb_y_mn34_g1_mp24_g1_y_dup1_t0 bn|invb_y|mn34_g1|mp24_g1|y__t02
+ bn|invb_y|mn34_g1|mp24_g1|y$1 185.302815577
* device instance bn_invb_y_mn34_g1_mp24_g1_y_dup1_t1 r0 *1 0,0
Rbn_invb_y_mn34_g1_mp24_g1_y_dup1_t1 bn|invb_y|mn34_g1|mp24_g1|y__t12
+ bn|invb_y|mn34_g1|mp24_g1|y$1 163.924646135
* device instance bn_invb_y_mn34_g1_mp24_g1_y_dup1_t2 r0 *1 0,0
Rbn_invb_y_mn34_g1_mp24_g1_y_dup1_t2 bn|invb_y|mn34_g1|mp24_g1|y__t22
+ bn|invb_y|mn34_g1|mp24_g1|y$1 173.955001003
* device instance bn_invb_y_mn34_g1_mp24_g1_y_dup1_t3 r0 *1 0,0
Rbn_invb_y_mn34_g1_mp24_g1_y_dup1_t3 bn|invb_y|mn34_g1|mp24_g1|y__t32
+ bn|invb_y|mn34_g1|mp24_g1|y$1 293.464337285
* device instance bn_invb_y_mn34_g1_mp24_g1_y_dup1 r0 *1 0,0
Cbn_invb_y_mn34_g1_mp24_g1_y_dup1 bn|invb_y|mn34_g1|mp24_g1|y$1 vsubs
+ 5.210763e-15
* device instance bn_invb_y_mn34_g1_mp24_g1_y_dup2_t0 r0 *1 0,0
Rbn_invb_y_mn34_g1_mp24_g1_y_dup2_t0 bn|invb_y|mn34_g1|mp24_g1|y__t03
+ bn|invb_y|mn34_g1|mp24_g1|y$2 185.302815577
* device instance bn_invb_y_mn34_g1_mp24_g1_y_dup2_t1 r0 *1 0,0
Rbn_invb_y_mn34_g1_mp24_g1_y_dup2_t1 bn|invb_y|mn34_g1|mp24_g1|y__t13
+ bn|invb_y|mn34_g1|mp24_g1|y$2 163.924646135
* device instance bn_invb_y_mn34_g1_mp24_g1_y_dup2_t2 r0 *1 0,0
Rbn_invb_y_mn34_g1_mp24_g1_y_dup2_t2 bn|invb_y|mn34_g1|mp24_g1|y__t23
+ bn|invb_y|mn34_g1|mp24_g1|y$2 173.955001003
* device instance bn_invb_y_mn34_g1_mp24_g1_y_dup2_t3 r0 *1 0,0
Rbn_invb_y_mn34_g1_mp24_g1_y_dup2_t3 bn|invb_y|mn34_g1|mp24_g1|y__t33
+ bn|invb_y|mn34_g1|mp24_g1|y$2 293.464337285
* device instance bn_invb_y_mn34_g1_mp24_g1_y_dup2 r0 *1 0,0
Cbn_invb_y_mn34_g1_mp24_g1_y_dup2 bn|invb_y|mn34_g1|mp24_g1|y$2 vsubs
+ 5.210018e-15
* device instance clkb_clkb_bridge1_clkb_bridge2_clkb_mid_clkb_w_ctrl_ctrlb_inv_clk_y_tg_d_ctrlb_tg_fbm_ctrl_tg_fbs_ctrlb_tg_s_ctrl_y_t0 r0 *1 0,0
Rclkb_clkb_bridge1_clkb_bridge2_clkb_mid_clkb_w_ctrl_ctrlb_inv_clk_y_tg_d_ctrlb_tg_fbm_ctrl_tg_fbs_ctrlb_tg_s_ctrl_y_t0
+ clkb|clkb_bridge1|clkb_bridge2|clkb_mid|clkb_w|ctrl|ctrlb|inv_clk_y|tg_d_ctrlb|tg_fbm_ctrl|tg_fbs_ctrlb|tg_s_ctrl|y__t0
+ clkb|clkb_bridge1|clkb_bridge2|clkb_mid|clkb_w|ctrl|ctrlb|inv_clk_y|tg_d_ctrlb|tg_fbm_ctrl|tg_fbs_ctrlb|tg_s_ctrl|y
+ 217.842328504
* device instance clkb_clkb_bridge1_clkb_bridge2_clkb_mid_clkb_w_ctrl_ctrlb_inv_clk_y_tg_d_ctrlb_tg_fbm_ctrl_tg_fbs_ctrlb_tg_s_ctrl_y_t1 r0 *1 0,0
Rclkb_clkb_bridge1_clkb_bridge2_clkb_mid_clkb_w_ctrl_ctrlb_inv_clk_y_tg_d_ctrlb_tg_fbm_ctrl_tg_fbs_ctrlb_tg_s_ctrl_y_t1
+ clkb|clkb_bridge1|clkb_bridge2|clkb_mid|clkb_w|ctrl|ctrlb|inv_clk_y|tg_d_ctrlb|tg_fbm_ctrl|tg_fbs_ctrlb|tg_s_ctrl|y__t1
+ clkb|clkb_bridge1|clkb_bridge2|clkb_mid|clkb_w|ctrl|ctrlb|inv_clk_y|tg_d_ctrlb|tg_fbm_ctrl|tg_fbs_ctrlb|tg_s_ctrl|y
+ 217.842328504
* device instance clkb_clkb_bridge1_clkb_bridge2_clkb_mid_clkb_w_ctrl_ctrlb_inv_clk_y_tg_d_ctrlb_tg_fbm_ctrl_tg_fbs_ctrlb_tg_s_ctrl_y_t2 r0 *1 0,0
Rclkb_clkb_bridge1_clkb_bridge2_clkb_mid_clkb_w_ctrl_ctrlb_inv_clk_y_tg_d_ctrlb_tg_fbm_ctrl_tg_fbs_ctrlb_tg_s_ctrl_y_t2
+ clkb|clkb_bridge1|clkb_bridge2|clkb_mid|clkb_w|ctrl|ctrlb|inv_clk_y|tg_d_ctrlb|tg_fbm_ctrl|tg_fbs_ctrlb|tg_s_ctrl|y__t2
+ clkb|clkb_bridge1|clkb_bridge2|clkb_mid|clkb_w|ctrl|ctrlb|inv_clk_y|tg_d_ctrlb|tg_fbm_ctrl|tg_fbs_ctrlb|tg_s_ctrl|y
+ 79.6693888508
* device instance clkb_clkb_bridge1_clkb_bridge2_clkb_mid_clkb_w_ctrl_ctrlb_inv_clk_y_tg_d_ctrlb_tg_fbm_ctrl_tg_fbs_ctrlb_tg_s_ctrl_y_t3 r0 *1 0,0
Rclkb_clkb_bridge1_clkb_bridge2_clkb_mid_clkb_w_ctrl_ctrlb_inv_clk_y_tg_d_ctrlb_tg_fbm_ctrl_tg_fbs_ctrlb_tg_s_ctrl_y_t3
+ clkb|clkb_bridge1|clkb_bridge2|clkb_mid|clkb_w|ctrl|ctrlb|inv_clk_y|tg_d_ctrlb|tg_fbm_ctrl|tg_fbs_ctrlb|tg_s_ctrl|y__t3
+ clkb|clkb_bridge1|clkb_bridge2|clkb_mid|clkb_w|ctrl|ctrlb|inv_clk_y|tg_d_ctrlb|tg_fbm_ctrl|tg_fbs_ctrlb|tg_s_ctrl|y
+ 141.315403239
* device instance clkb_clkb_bridge1_clkb_bridge2_clkb_mid_clkb_w_ctrl_ctrlb_inv_clk_y_tg_d_ctrlb_tg_fbm_ctrl_tg_fbs_ctrlb_tg_s_ctrl_y_t4 r0 *1 0,0
Rclkb_clkb_bridge1_clkb_bridge2_clkb_mid_clkb_w_ctrl_ctrlb_inv_clk_y_tg_d_ctrlb_tg_fbm_ctrl_tg_fbs_ctrlb_tg_s_ctrl_y_t4
+ clkb|clkb_bridge1|clkb_bridge2|clkb_mid|clkb_w|ctrl|ctrlb|inv_clk_y|tg_d_ctrlb|tg_fbm_ctrl|tg_fbs_ctrlb|tg_s_ctrl|y__t4
+ clkb|clkb_bridge1|clkb_bridge2|clkb_mid|clkb_w|ctrl|ctrlb|inv_clk_y|tg_d_ctrlb|tg_fbm_ctrl|tg_fbs_ctrlb|tg_s_ctrl|y
+ 159.961351597
* device instance clkb_clkb_bridge1_clkb_bridge2_clkb_mid_clkb_w_ctrl_ctrlb_inv_clk_y_tg_d_ctrlb_tg_fbm_ctrl_tg_fbs_ctrlb_tg_s_ctrl_y_t5 r0 *1 0,0
Rclkb_clkb_bridge1_clkb_bridge2_clkb_mid_clkb_w_ctrl_ctrlb_inv_clk_y_tg_d_ctrlb_tg_fbm_ctrl_tg_fbs_ctrlb_tg_s_ctrl_y_t5
+ clkb|clkb_bridge1|clkb_bridge2|clkb_mid|clkb_w|ctrl|ctrlb|inv_clk_y|tg_d_ctrlb|tg_fbm_ctrl|tg_fbs_ctrlb|tg_s_ctrl|y__t5
+ clkb|clkb_bridge1|clkb_bridge2|clkb_mid|clkb_w|ctrl|ctrlb|inv_clk_y|tg_d_ctrlb|tg_fbm_ctrl|tg_fbs_ctrlb|tg_s_ctrl|y
+ 376.113299304
* device instance clkb_clkb_bridge1_clkb_bridge2_clkb_mid_clkb_w_ctrl_ctrlb_inv_clk_y_tg_d_ctrlb_tg_fbm_ctrl_tg_fbs_ctrlb_tg_s_ctrl_y r0 *1 0,0
Cclkb_clkb_bridge1_clkb_bridge2_clkb_mid_clkb_w_ctrl_ctrlb_inv_clk_y_tg_d_ctrlb_tg_fbm_ctrl_tg_fbs_ctrlb_tg_s_ctrl_y
+ clkb|clkb_bridge1|clkb_bridge2|clkb_mid|clkb_w|ctrl|ctrlb|inv_clk_y|tg_d_ctrlb|tg_fbm_ctrl|tg_fbs_ctrlb|tg_s_ctrl|y
+ vsubs 6.914554e-15
* device instance clkb_clkb_bridge1_clkb_bridge2_clkb_mid_clkb_w_ctrl_ctrlb_inv_clk_y_tg_d_ctrlb_tg_fbm_ctrl_tg_fbs_ctrlb_tg_s_ctrl_y_dup1_t0 r0 *1 0,0
Rclkb_clkb_bridge1_clkb_bridge2_clkb_mid_clkb_w_ctrl_ctrlb_inv_clk_y_tg_d_ctrlb_tg_fbm_ctrl_tg_fbs_ctrlb_tg_s_ctrl_y_dup1_t0
+ clkb|clkb_bridge1|clkb_bridge2|clkb_mid|clkb_w|ctrl|ctrlb|inv_clk_y|tg_d_ctrlb|tg_fbm_ctrl|tg_fbs_ctrlb|tg_s_ctrl|y__t02
+ clkb|clkb_bridge1|clkb_bridge2|clkb_mid|clkb_w|ctrl|ctrlb|inv_clk_y|tg_d_ctrlb|tg_fbm_ctrl|tg_fbs_ctrlb|tg_s_ctrl|y$1
+ 217.842328504
* device instance clkb_clkb_bridge1_clkb_bridge2_clkb_mid_clkb_w_ctrl_ctrlb_inv_clk_y_tg_d_ctrlb_tg_fbm_ctrl_tg_fbs_ctrlb_tg_s_ctrl_y_dup1_t1 r0 *1 0,0
Rclkb_clkb_bridge1_clkb_bridge2_clkb_mid_clkb_w_ctrl_ctrlb_inv_clk_y_tg_d_ctrlb_tg_fbm_ctrl_tg_fbs_ctrlb_tg_s_ctrl_y_dup1_t1
+ clkb|clkb_bridge1|clkb_bridge2|clkb_mid|clkb_w|ctrl|ctrlb|inv_clk_y|tg_d_ctrlb|tg_fbm_ctrl|tg_fbs_ctrlb|tg_s_ctrl|y__t12
+ clkb|clkb_bridge1|clkb_bridge2|clkb_mid|clkb_w|ctrl|ctrlb|inv_clk_y|tg_d_ctrlb|tg_fbm_ctrl|tg_fbs_ctrlb|tg_s_ctrl|y$1
+ 217.842328504
* device instance clkb_clkb_bridge1_clkb_bridge2_clkb_mid_clkb_w_ctrl_ctrlb_inv_clk_y_tg_d_ctrlb_tg_fbm_ctrl_tg_fbs_ctrlb_tg_s_ctrl_y_dup1_t2 r0 *1 0,0
Rclkb_clkb_bridge1_clkb_bridge2_clkb_mid_clkb_w_ctrl_ctrlb_inv_clk_y_tg_d_ctrlb_tg_fbm_ctrl_tg_fbs_ctrlb_tg_s_ctrl_y_dup1_t2
+ clkb|clkb_bridge1|clkb_bridge2|clkb_mid|clkb_w|ctrl|ctrlb|inv_clk_y|tg_d_ctrlb|tg_fbm_ctrl|tg_fbs_ctrlb|tg_s_ctrl|y__t22
+ clkb|clkb_bridge1|clkb_bridge2|clkb_mid|clkb_w|ctrl|ctrlb|inv_clk_y|tg_d_ctrlb|tg_fbm_ctrl|tg_fbs_ctrlb|tg_s_ctrl|y$1
+ 79.6693888508
* device instance clkb_clkb_bridge1_clkb_bridge2_clkb_mid_clkb_w_ctrl_ctrlb_inv_clk_y_tg_d_ctrlb_tg_fbm_ctrl_tg_fbs_ctrlb_tg_s_ctrl_y_dup1_t3 r0 *1 0,0
Rclkb_clkb_bridge1_clkb_bridge2_clkb_mid_clkb_w_ctrl_ctrlb_inv_clk_y_tg_d_ctrlb_tg_fbm_ctrl_tg_fbs_ctrlb_tg_s_ctrl_y_dup1_t3
+ clkb|clkb_bridge1|clkb_bridge2|clkb_mid|clkb_w|ctrl|ctrlb|inv_clk_y|tg_d_ctrlb|tg_fbm_ctrl|tg_fbs_ctrlb|tg_s_ctrl|y__t32
+ clkb|clkb_bridge1|clkb_bridge2|clkb_mid|clkb_w|ctrl|ctrlb|inv_clk_y|tg_d_ctrlb|tg_fbm_ctrl|tg_fbs_ctrlb|tg_s_ctrl|y$1
+ 141.315403239
* device instance clkb_clkb_bridge1_clkb_bridge2_clkb_mid_clkb_w_ctrl_ctrlb_inv_clk_y_tg_d_ctrlb_tg_fbm_ctrl_tg_fbs_ctrlb_tg_s_ctrl_y_dup1_t4 r0 *1 0,0
Rclkb_clkb_bridge1_clkb_bridge2_clkb_mid_clkb_w_ctrl_ctrlb_inv_clk_y_tg_d_ctrlb_tg_fbm_ctrl_tg_fbs_ctrlb_tg_s_ctrl_y_dup1_t4
+ clkb|clkb_bridge1|clkb_bridge2|clkb_mid|clkb_w|ctrl|ctrlb|inv_clk_y|tg_d_ctrlb|tg_fbm_ctrl|tg_fbs_ctrlb|tg_s_ctrl|y__t42
+ clkb|clkb_bridge1|clkb_bridge2|clkb_mid|clkb_w|ctrl|ctrlb|inv_clk_y|tg_d_ctrlb|tg_fbm_ctrl|tg_fbs_ctrlb|tg_s_ctrl|y$1
+ 159.961351597
* device instance clkb_clkb_bridge1_clkb_bridge2_clkb_mid_clkb_w_ctrl_ctrlb_inv_clk_y_tg_d_ctrlb_tg_fbm_ctrl_tg_fbs_ctrlb_tg_s_ctrl_y_dup1_t5 r0 *1 0,0
Rclkb_clkb_bridge1_clkb_bridge2_clkb_mid_clkb_w_ctrl_ctrlb_inv_clk_y_tg_d_ctrlb_tg_fbm_ctrl_tg_fbs_ctrlb_tg_s_ctrl_y_dup1_t5
+ clkb|clkb_bridge1|clkb_bridge2|clkb_mid|clkb_w|ctrl|ctrlb|inv_clk_y|tg_d_ctrlb|tg_fbm_ctrl|tg_fbs_ctrlb|tg_s_ctrl|y__t52
+ clkb|clkb_bridge1|clkb_bridge2|clkb_mid|clkb_w|ctrl|ctrlb|inv_clk_y|tg_d_ctrlb|tg_fbm_ctrl|tg_fbs_ctrlb|tg_s_ctrl|y$1
+ 376.113299304
* device instance clkb_clkb_bridge1_clkb_bridge2_clkb_mid_clkb_w_ctrl_ctrlb_inv_clk_y_tg_d_ctrlb_tg_fbm_ctrl_tg_fbs_ctrlb_tg_s_ctrl_y_dup1 r0 *1 0,0
Cclkb_clkb_bridge1_clkb_bridge2_clkb_mid_clkb_w_ctrl_ctrlb_inv_clk_y_tg_d_ctrlb_tg_fbm_ctrl_tg_fbs_ctrlb_tg_s_ctrl_y_dup1
+ clkb|clkb_bridge1|clkb_bridge2|clkb_mid|clkb_w|ctrl|ctrlb|inv_clk_y|tg_d_ctrlb|tg_fbm_ctrl|tg_fbs_ctrlb|tg_s_ctrl|y$1
+ vsubs 6.914554e-15
* device instance clkb_clkb_bridge1_clkb_bridge2_clkb_mid_clkb_w_ctrl_ctrlb_inv_clk_y_tg_d_ctrlb_tg_fbm_ctrl_tg_fbs_ctrlb_tg_s_ctrl_y_dup2_t0 r0 *1 0,0
Rclkb_clkb_bridge1_clkb_bridge2_clkb_mid_clkb_w_ctrl_ctrlb_inv_clk_y_tg_d_ctrlb_tg_fbm_ctrl_tg_fbs_ctrlb_tg_s_ctrl_y_dup2_t0
+ clkb|clkb_bridge1|clkb_bridge2|clkb_mid|clkb_w|ctrl|ctrlb|inv_clk_y|tg_d_ctrlb|tg_fbm_ctrl|tg_fbs_ctrlb|tg_s_ctrl|y__t03
+ clkb|clkb_bridge1|clkb_bridge2|clkb_mid|clkb_w|ctrl|ctrlb|inv_clk_y|tg_d_ctrlb|tg_fbm_ctrl|tg_fbs_ctrlb|tg_s_ctrl|y$2
+ 217.842328504
* device instance clkb_clkb_bridge1_clkb_bridge2_clkb_mid_clkb_w_ctrl_ctrlb_inv_clk_y_tg_d_ctrlb_tg_fbm_ctrl_tg_fbs_ctrlb_tg_s_ctrl_y_dup2_t1 r0 *1 0,0
Rclkb_clkb_bridge1_clkb_bridge2_clkb_mid_clkb_w_ctrl_ctrlb_inv_clk_y_tg_d_ctrlb_tg_fbm_ctrl_tg_fbs_ctrlb_tg_s_ctrl_y_dup2_t1
+ clkb|clkb_bridge1|clkb_bridge2|clkb_mid|clkb_w|ctrl|ctrlb|inv_clk_y|tg_d_ctrlb|tg_fbm_ctrl|tg_fbs_ctrlb|tg_s_ctrl|y__t13
+ clkb|clkb_bridge1|clkb_bridge2|clkb_mid|clkb_w|ctrl|ctrlb|inv_clk_y|tg_d_ctrlb|tg_fbm_ctrl|tg_fbs_ctrlb|tg_s_ctrl|y$2
+ 217.842328504
* device instance clkb_clkb_bridge1_clkb_bridge2_clkb_mid_clkb_w_ctrl_ctrlb_inv_clk_y_tg_d_ctrlb_tg_fbm_ctrl_tg_fbs_ctrlb_tg_s_ctrl_y_dup2_t2 r0 *1 0,0
Rclkb_clkb_bridge1_clkb_bridge2_clkb_mid_clkb_w_ctrl_ctrlb_inv_clk_y_tg_d_ctrlb_tg_fbm_ctrl_tg_fbs_ctrlb_tg_s_ctrl_y_dup2_t2
+ clkb|clkb_bridge1|clkb_bridge2|clkb_mid|clkb_w|ctrl|ctrlb|inv_clk_y|tg_d_ctrlb|tg_fbm_ctrl|tg_fbs_ctrlb|tg_s_ctrl|y__t23
+ clkb|clkb_bridge1|clkb_bridge2|clkb_mid|clkb_w|ctrl|ctrlb|inv_clk_y|tg_d_ctrlb|tg_fbm_ctrl|tg_fbs_ctrlb|tg_s_ctrl|y$2
+ 141.315403239
* device instance clkb_clkb_bridge1_clkb_bridge2_clkb_mid_clkb_w_ctrl_ctrlb_inv_clk_y_tg_d_ctrlb_tg_fbm_ctrl_tg_fbs_ctrlb_tg_s_ctrl_y_dup2_t3 r0 *1 0,0
Rclkb_clkb_bridge1_clkb_bridge2_clkb_mid_clkb_w_ctrl_ctrlb_inv_clk_y_tg_d_ctrlb_tg_fbm_ctrl_tg_fbs_ctrlb_tg_s_ctrl_y_dup2_t3
+ clkb|clkb_bridge1|clkb_bridge2|clkb_mid|clkb_w|ctrl|ctrlb|inv_clk_y|tg_d_ctrlb|tg_fbm_ctrl|tg_fbs_ctrlb|tg_s_ctrl|y__t33
+ clkb|clkb_bridge1|clkb_bridge2|clkb_mid|clkb_w|ctrl|ctrlb|inv_clk_y|tg_d_ctrlb|tg_fbm_ctrl|tg_fbs_ctrlb|tg_s_ctrl|y$2
+ 79.6693888508
* device instance clkb_clkb_bridge1_clkb_bridge2_clkb_mid_clkb_w_ctrl_ctrlb_inv_clk_y_tg_d_ctrlb_tg_fbm_ctrl_tg_fbs_ctrlb_tg_s_ctrl_y_dup2_t4 r0 *1 0,0
Rclkb_clkb_bridge1_clkb_bridge2_clkb_mid_clkb_w_ctrl_ctrlb_inv_clk_y_tg_d_ctrlb_tg_fbm_ctrl_tg_fbs_ctrlb_tg_s_ctrl_y_dup2_t4
+ clkb|clkb_bridge1|clkb_bridge2|clkb_mid|clkb_w|ctrl|ctrlb|inv_clk_y|tg_d_ctrlb|tg_fbm_ctrl|tg_fbs_ctrlb|tg_s_ctrl|y__t43
+ clkb|clkb_bridge1|clkb_bridge2|clkb_mid|clkb_w|ctrl|ctrlb|inv_clk_y|tg_d_ctrlb|tg_fbm_ctrl|tg_fbs_ctrlb|tg_s_ctrl|y$2
+ 376.113299304
* device instance clkb_clkb_bridge1_clkb_bridge2_clkb_mid_clkb_w_ctrl_ctrlb_inv_clk_y_tg_d_ctrlb_tg_fbm_ctrl_tg_fbs_ctrlb_tg_s_ctrl_y_dup2_t5 r0 *1 0,0
Rclkb_clkb_bridge1_clkb_bridge2_clkb_mid_clkb_w_ctrl_ctrlb_inv_clk_y_tg_d_ctrlb_tg_fbm_ctrl_tg_fbs_ctrlb_tg_s_ctrl_y_dup2_t5
+ clkb|clkb_bridge1|clkb_bridge2|clkb_mid|clkb_w|ctrl|ctrlb|inv_clk_y|tg_d_ctrlb|tg_fbm_ctrl|tg_fbs_ctrlb|tg_s_ctrl|y__t53
+ clkb|clkb_bridge1|clkb_bridge2|clkb_mid|clkb_w|ctrl|ctrlb|inv_clk_y|tg_d_ctrlb|tg_fbm_ctrl|tg_fbs_ctrlb|tg_s_ctrl|y$2
+ 159.961351597
* device instance clkb_clkb_bridge1_clkb_bridge2_clkb_mid_clkb_w_ctrl_ctrlb_inv_clk_y_tg_d_ctrlb_tg_fbm_ctrl_tg_fbs_ctrlb_tg_s_ctrl_y_dup2 r0 *1 0,0
Cclkb_clkb_bridge1_clkb_bridge2_clkb_mid_clkb_w_ctrl_ctrlb_inv_clk_y_tg_d_ctrlb_tg_fbm_ctrl_tg_fbs_ctrlb_tg_s_ctrl_y_dup2
+ clkb|clkb_bridge1|clkb_bridge2|clkb_mid|clkb_w|ctrl|ctrlb|inv_clk_y|tg_d_ctrlb|tg_fbm_ctrl|tg_fbs_ctrlb|tg_s_ctrl|y$2
+ vsubs 6.914554e-15
* device instance clkb_clkb_bridge1_clkb_bridge2_clkb_mid_clkb_w_ctrl_ctrlb_inv_clk_y_tg_d_ctrlb_tg_fbm_ctrl_tg_fbs_ctrlb_tg_s_ctrl_y_dup3_t0 r0 *1 0,0
Rclkb_clkb_bridge1_clkb_bridge2_clkb_mid_clkb_w_ctrl_ctrlb_inv_clk_y_tg_d_ctrlb_tg_fbm_ctrl_tg_fbs_ctrlb_tg_s_ctrl_y_dup3_t0
+ clkb|clkb_bridge1|clkb_bridge2|clkb_mid|clkb_w|ctrl|ctrlb|inv_clk_y|tg_d_ctrlb|tg_fbm_ctrl|tg_fbs_ctrlb|tg_s_ctrl|y__t04
+ clkb|clkb_bridge1|clkb_bridge2|clkb_mid|clkb_w|ctrl|ctrlb|inv_clk_y|tg_d_ctrlb|tg_fbm_ctrl|tg_fbs_ctrlb|tg_s_ctrl|y$3
+ 217.842328504
* device instance clkb_clkb_bridge1_clkb_bridge2_clkb_mid_clkb_w_ctrl_ctrlb_inv_clk_y_tg_d_ctrlb_tg_fbm_ctrl_tg_fbs_ctrlb_tg_s_ctrl_y_dup3_t1 r0 *1 0,0
Rclkb_clkb_bridge1_clkb_bridge2_clkb_mid_clkb_w_ctrl_ctrlb_inv_clk_y_tg_d_ctrlb_tg_fbm_ctrl_tg_fbs_ctrlb_tg_s_ctrl_y_dup3_t1
+ clkb|clkb_bridge1|clkb_bridge2|clkb_mid|clkb_w|ctrl|ctrlb|inv_clk_y|tg_d_ctrlb|tg_fbm_ctrl|tg_fbs_ctrlb|tg_s_ctrl|y__t14
+ clkb|clkb_bridge1|clkb_bridge2|clkb_mid|clkb_w|ctrl|ctrlb|inv_clk_y|tg_d_ctrlb|tg_fbm_ctrl|tg_fbs_ctrlb|tg_s_ctrl|y$3
+ 217.842328504
* device instance clkb_clkb_bridge1_clkb_bridge2_clkb_mid_clkb_w_ctrl_ctrlb_inv_clk_y_tg_d_ctrlb_tg_fbm_ctrl_tg_fbs_ctrlb_tg_s_ctrl_y_dup3_t2 r0 *1 0,0
Rclkb_clkb_bridge1_clkb_bridge2_clkb_mid_clkb_w_ctrl_ctrlb_inv_clk_y_tg_d_ctrlb_tg_fbm_ctrl_tg_fbs_ctrlb_tg_s_ctrl_y_dup3_t2
+ clkb|clkb_bridge1|clkb_bridge2|clkb_mid|clkb_w|ctrl|ctrlb|inv_clk_y|tg_d_ctrlb|tg_fbm_ctrl|tg_fbs_ctrlb|tg_s_ctrl|y__t24
+ clkb|clkb_bridge1|clkb_bridge2|clkb_mid|clkb_w|ctrl|ctrlb|inv_clk_y|tg_d_ctrlb|tg_fbm_ctrl|tg_fbs_ctrlb|tg_s_ctrl|y$3
+ 79.6693888508
* device instance clkb_clkb_bridge1_clkb_bridge2_clkb_mid_clkb_w_ctrl_ctrlb_inv_clk_y_tg_d_ctrlb_tg_fbm_ctrl_tg_fbs_ctrlb_tg_s_ctrl_y_dup3_t3 r0 *1 0,0
Rclkb_clkb_bridge1_clkb_bridge2_clkb_mid_clkb_w_ctrl_ctrlb_inv_clk_y_tg_d_ctrlb_tg_fbm_ctrl_tg_fbs_ctrlb_tg_s_ctrl_y_dup3_t3
+ clkb|clkb_bridge1|clkb_bridge2|clkb_mid|clkb_w|ctrl|ctrlb|inv_clk_y|tg_d_ctrlb|tg_fbm_ctrl|tg_fbs_ctrlb|tg_s_ctrl|y__t34
+ clkb|clkb_bridge1|clkb_bridge2|clkb_mid|clkb_w|ctrl|ctrlb|inv_clk_y|tg_d_ctrlb|tg_fbm_ctrl|tg_fbs_ctrlb|tg_s_ctrl|y$3
+ 141.315403239
* device instance clkb_clkb_bridge1_clkb_bridge2_clkb_mid_clkb_w_ctrl_ctrlb_inv_clk_y_tg_d_ctrlb_tg_fbm_ctrl_tg_fbs_ctrlb_tg_s_ctrl_y_dup3_t4 r0 *1 0,0
Rclkb_clkb_bridge1_clkb_bridge2_clkb_mid_clkb_w_ctrl_ctrlb_inv_clk_y_tg_d_ctrlb_tg_fbm_ctrl_tg_fbs_ctrlb_tg_s_ctrl_y_dup3_t4
+ clkb|clkb_bridge1|clkb_bridge2|clkb_mid|clkb_w|ctrl|ctrlb|inv_clk_y|tg_d_ctrlb|tg_fbm_ctrl|tg_fbs_ctrlb|tg_s_ctrl|y__t44
+ clkb|clkb_bridge1|clkb_bridge2|clkb_mid|clkb_w|ctrl|ctrlb|inv_clk_y|tg_d_ctrlb|tg_fbm_ctrl|tg_fbs_ctrlb|tg_s_ctrl|y$3
+ 376.113299304
* device instance clkb_clkb_bridge1_clkb_bridge2_clkb_mid_clkb_w_ctrl_ctrlb_inv_clk_y_tg_d_ctrlb_tg_fbm_ctrl_tg_fbs_ctrlb_tg_s_ctrl_y_dup3_t5 r0 *1 0,0
Rclkb_clkb_bridge1_clkb_bridge2_clkb_mid_clkb_w_ctrl_ctrlb_inv_clk_y_tg_d_ctrlb_tg_fbm_ctrl_tg_fbs_ctrlb_tg_s_ctrl_y_dup3_t5
+ clkb|clkb_bridge1|clkb_bridge2|clkb_mid|clkb_w|ctrl|ctrlb|inv_clk_y|tg_d_ctrlb|tg_fbm_ctrl|tg_fbs_ctrlb|tg_s_ctrl|y__t54
+ clkb|clkb_bridge1|clkb_bridge2|clkb_mid|clkb_w|ctrl|ctrlb|inv_clk_y|tg_d_ctrlb|tg_fbm_ctrl|tg_fbs_ctrlb|tg_s_ctrl|y$3
+ 159.961351597
* device instance clkb_clkb_bridge1_clkb_bridge2_clkb_mid_clkb_w_ctrl_ctrlb_inv_clk_y_tg_d_ctrlb_tg_fbm_ctrl_tg_fbs_ctrlb_tg_s_ctrl_y_dup3 r0 *1 0,0
Cclkb_clkb_bridge1_clkb_bridge2_clkb_mid_clkb_w_ctrl_ctrlb_inv_clk_y_tg_d_ctrlb_tg_fbm_ctrl_tg_fbs_ctrlb_tg_s_ctrl_y_dup3
+ clkb|clkb_bridge1|clkb_bridge2|clkb_mid|clkb_w|ctrl|ctrlb|inv_clk_y|tg_d_ctrlb|tg_fbm_ctrl|tg_fbs_ctrlb|tg_s_ctrl|y$3
+ vsubs 6.914554e-15
* device instance clkb_clkb_bridge1_clkb_bridge2_clkb_mid_clkb_w_ctrl_ctrlb_inv_clk_y_tg_d_ctrlb_tg_fbm_ctrl_tg_fbs_ctrlb_tg_s_ctrl_y_dup4_t0 r0 *1 0,0
Rclkb_clkb_bridge1_clkb_bridge2_clkb_mid_clkb_w_ctrl_ctrlb_inv_clk_y_tg_d_ctrlb_tg_fbm_ctrl_tg_fbs_ctrlb_tg_s_ctrl_y_dup4_t0
+ clkb|clkb_bridge1|clkb_bridge2|clkb_mid|clkb_w|ctrl|ctrlb|inv_clk_y|tg_d_ctrlb|tg_fbm_ctrl|tg_fbs_ctrlb|tg_s_ctrl|y__t05
+ clkb|clkb_bridge1|clkb_bridge2|clkb_mid|clkb_w|ctrl|ctrlb|inv_clk_y|tg_d_ctrlb|tg_fbm_ctrl|tg_fbs_ctrlb|tg_s_ctrl|y$4
+ 217.842328504
* device instance clkb_clkb_bridge1_clkb_bridge2_clkb_mid_clkb_w_ctrl_ctrlb_inv_clk_y_tg_d_ctrlb_tg_fbm_ctrl_tg_fbs_ctrlb_tg_s_ctrl_y_dup4_t1 r0 *1 0,0
Rclkb_clkb_bridge1_clkb_bridge2_clkb_mid_clkb_w_ctrl_ctrlb_inv_clk_y_tg_d_ctrlb_tg_fbm_ctrl_tg_fbs_ctrlb_tg_s_ctrl_y_dup4_t1
+ clkb|clkb_bridge1|clkb_bridge2|clkb_mid|clkb_w|ctrl|ctrlb|inv_clk_y|tg_d_ctrlb|tg_fbm_ctrl|tg_fbs_ctrlb|tg_s_ctrl|y__t15
+ clkb|clkb_bridge1|clkb_bridge2|clkb_mid|clkb_w|ctrl|ctrlb|inv_clk_y|tg_d_ctrlb|tg_fbm_ctrl|tg_fbs_ctrlb|tg_s_ctrl|y$4
+ 217.842328504
* device instance clkb_clkb_bridge1_clkb_bridge2_clkb_mid_clkb_w_ctrl_ctrlb_inv_clk_y_tg_d_ctrlb_tg_fbm_ctrl_tg_fbs_ctrlb_tg_s_ctrl_y_dup4_t2 r0 *1 0,0
Rclkb_clkb_bridge1_clkb_bridge2_clkb_mid_clkb_w_ctrl_ctrlb_inv_clk_y_tg_d_ctrlb_tg_fbm_ctrl_tg_fbs_ctrlb_tg_s_ctrl_y_dup4_t2
+ clkb|clkb_bridge1|clkb_bridge2|clkb_mid|clkb_w|ctrl|ctrlb|inv_clk_y|tg_d_ctrlb|tg_fbm_ctrl|tg_fbs_ctrlb|tg_s_ctrl|y__t25
+ clkb|clkb_bridge1|clkb_bridge2|clkb_mid|clkb_w|ctrl|ctrlb|inv_clk_y|tg_d_ctrlb|tg_fbm_ctrl|tg_fbs_ctrlb|tg_s_ctrl|y$4
+ 141.315403239
* device instance clkb_clkb_bridge1_clkb_bridge2_clkb_mid_clkb_w_ctrl_ctrlb_inv_clk_y_tg_d_ctrlb_tg_fbm_ctrl_tg_fbs_ctrlb_tg_s_ctrl_y_dup4_t3 r0 *1 0,0
Rclkb_clkb_bridge1_clkb_bridge2_clkb_mid_clkb_w_ctrl_ctrlb_inv_clk_y_tg_d_ctrlb_tg_fbm_ctrl_tg_fbs_ctrlb_tg_s_ctrl_y_dup4_t3
+ clkb|clkb_bridge1|clkb_bridge2|clkb_mid|clkb_w|ctrl|ctrlb|inv_clk_y|tg_d_ctrlb|tg_fbm_ctrl|tg_fbs_ctrlb|tg_s_ctrl|y__t35
+ clkb|clkb_bridge1|clkb_bridge2|clkb_mid|clkb_w|ctrl|ctrlb|inv_clk_y|tg_d_ctrlb|tg_fbm_ctrl|tg_fbs_ctrlb|tg_s_ctrl|y$4
+ 79.6693888508
* device instance clkb_clkb_bridge1_clkb_bridge2_clkb_mid_clkb_w_ctrl_ctrlb_inv_clk_y_tg_d_ctrlb_tg_fbm_ctrl_tg_fbs_ctrlb_tg_s_ctrl_y_dup4_t4 r0 *1 0,0
Rclkb_clkb_bridge1_clkb_bridge2_clkb_mid_clkb_w_ctrl_ctrlb_inv_clk_y_tg_d_ctrlb_tg_fbm_ctrl_tg_fbs_ctrlb_tg_s_ctrl_y_dup4_t4
+ clkb|clkb_bridge1|clkb_bridge2|clkb_mid|clkb_w|ctrl|ctrlb|inv_clk_y|tg_d_ctrlb|tg_fbm_ctrl|tg_fbs_ctrlb|tg_s_ctrl|y__t45
+ clkb|clkb_bridge1|clkb_bridge2|clkb_mid|clkb_w|ctrl|ctrlb|inv_clk_y|tg_d_ctrlb|tg_fbm_ctrl|tg_fbs_ctrlb|tg_s_ctrl|y$4
+ 159.961351597
* device instance clkb_clkb_bridge1_clkb_bridge2_clkb_mid_clkb_w_ctrl_ctrlb_inv_clk_y_tg_d_ctrlb_tg_fbm_ctrl_tg_fbs_ctrlb_tg_s_ctrl_y_dup4_t5 r0 *1 0,0
Rclkb_clkb_bridge1_clkb_bridge2_clkb_mid_clkb_w_ctrl_ctrlb_inv_clk_y_tg_d_ctrlb_tg_fbm_ctrl_tg_fbs_ctrlb_tg_s_ctrl_y_dup4_t5
+ clkb|clkb_bridge1|clkb_bridge2|clkb_mid|clkb_w|ctrl|ctrlb|inv_clk_y|tg_d_ctrlb|tg_fbm_ctrl|tg_fbs_ctrlb|tg_s_ctrl|y__t55
+ clkb|clkb_bridge1|clkb_bridge2|clkb_mid|clkb_w|ctrl|ctrlb|inv_clk_y|tg_d_ctrlb|tg_fbm_ctrl|tg_fbs_ctrlb|tg_s_ctrl|y$4
+ 376.113299304
* device instance clkb_clkb_bridge1_clkb_bridge2_clkb_mid_clkb_w_ctrl_ctrlb_inv_clk_y_tg_d_ctrlb_tg_fbm_ctrl_tg_fbs_ctrlb_tg_s_ctrl_y_dup4 r0 *1 0,0
Cclkb_clkb_bridge1_clkb_bridge2_clkb_mid_clkb_w_ctrl_ctrlb_inv_clk_y_tg_d_ctrlb_tg_fbm_ctrl_tg_fbs_ctrlb_tg_s_ctrl_y_dup4
+ clkb|clkb_bridge1|clkb_bridge2|clkb_mid|clkb_w|ctrl|ctrlb|inv_clk_y|tg_d_ctrlb|tg_fbm_ctrl|tg_fbs_ctrlb|tg_s_ctrl|y$4
+ vsubs 6.914554e-15
* device instance clkb_clkb_bridge1_clkb_bridge2_clkb_mid_clkb_w_ctrl_ctrlb_inv_clk_y_tg_d_ctrlb_tg_fbm_ctrl_tg_fbs_ctrlb_tg_s_ctrl_y_dup5_t0 r0 *1 0,0
Rclkb_clkb_bridge1_clkb_bridge2_clkb_mid_clkb_w_ctrl_ctrlb_inv_clk_y_tg_d_ctrlb_tg_fbm_ctrl_tg_fbs_ctrlb_tg_s_ctrl_y_dup5_t0
+ clkb|clkb_bridge1|clkb_bridge2|clkb_mid|clkb_w|ctrl|ctrlb|inv_clk_y|tg_d_ctrlb|tg_fbm_ctrl|tg_fbs_ctrlb|tg_s_ctrl|y__t06
+ clkb|clkb_bridge1|clkb_bridge2|clkb_mid|clkb_w|ctrl|ctrlb|inv_clk_y|tg_d_ctrlb|tg_fbm_ctrl|tg_fbs_ctrlb|tg_s_ctrl|y$5
+ 217.842328504
* device instance clkb_clkb_bridge1_clkb_bridge2_clkb_mid_clkb_w_ctrl_ctrlb_inv_clk_y_tg_d_ctrlb_tg_fbm_ctrl_tg_fbs_ctrlb_tg_s_ctrl_y_dup5_t1 r0 *1 0,0
Rclkb_clkb_bridge1_clkb_bridge2_clkb_mid_clkb_w_ctrl_ctrlb_inv_clk_y_tg_d_ctrlb_tg_fbm_ctrl_tg_fbs_ctrlb_tg_s_ctrl_y_dup5_t1
+ clkb|clkb_bridge1|clkb_bridge2|clkb_mid|clkb_w|ctrl|ctrlb|inv_clk_y|tg_d_ctrlb|tg_fbm_ctrl|tg_fbs_ctrlb|tg_s_ctrl|y__t16
+ clkb|clkb_bridge1|clkb_bridge2|clkb_mid|clkb_w|ctrl|ctrlb|inv_clk_y|tg_d_ctrlb|tg_fbm_ctrl|tg_fbs_ctrlb|tg_s_ctrl|y$5
+ 217.842328504
* device instance clkb_clkb_bridge1_clkb_bridge2_clkb_mid_clkb_w_ctrl_ctrlb_inv_clk_y_tg_d_ctrlb_tg_fbm_ctrl_tg_fbs_ctrlb_tg_s_ctrl_y_dup5_t2 r0 *1 0,0
Rclkb_clkb_bridge1_clkb_bridge2_clkb_mid_clkb_w_ctrl_ctrlb_inv_clk_y_tg_d_ctrlb_tg_fbm_ctrl_tg_fbs_ctrlb_tg_s_ctrl_y_dup5_t2
+ clkb|clkb_bridge1|clkb_bridge2|clkb_mid|clkb_w|ctrl|ctrlb|inv_clk_y|tg_d_ctrlb|tg_fbm_ctrl|tg_fbs_ctrlb|tg_s_ctrl|y__t26
+ clkb|clkb_bridge1|clkb_bridge2|clkb_mid|clkb_w|ctrl|ctrlb|inv_clk_y|tg_d_ctrlb|tg_fbm_ctrl|tg_fbs_ctrlb|tg_s_ctrl|y$5
+ 79.6693888508
* device instance clkb_clkb_bridge1_clkb_bridge2_clkb_mid_clkb_w_ctrl_ctrlb_inv_clk_y_tg_d_ctrlb_tg_fbm_ctrl_tg_fbs_ctrlb_tg_s_ctrl_y_dup5_t3 r0 *1 0,0
Rclkb_clkb_bridge1_clkb_bridge2_clkb_mid_clkb_w_ctrl_ctrlb_inv_clk_y_tg_d_ctrlb_tg_fbm_ctrl_tg_fbs_ctrlb_tg_s_ctrl_y_dup5_t3
+ clkb|clkb_bridge1|clkb_bridge2|clkb_mid|clkb_w|ctrl|ctrlb|inv_clk_y|tg_d_ctrlb|tg_fbm_ctrl|tg_fbs_ctrlb|tg_s_ctrl|y__t36
+ clkb|clkb_bridge1|clkb_bridge2|clkb_mid|clkb_w|ctrl|ctrlb|inv_clk_y|tg_d_ctrlb|tg_fbm_ctrl|tg_fbs_ctrlb|tg_s_ctrl|y$5
+ 141.315403239
* device instance clkb_clkb_bridge1_clkb_bridge2_clkb_mid_clkb_w_ctrl_ctrlb_inv_clk_y_tg_d_ctrlb_tg_fbm_ctrl_tg_fbs_ctrlb_tg_s_ctrl_y_dup5_t4 r0 *1 0,0
Rclkb_clkb_bridge1_clkb_bridge2_clkb_mid_clkb_w_ctrl_ctrlb_inv_clk_y_tg_d_ctrlb_tg_fbm_ctrl_tg_fbs_ctrlb_tg_s_ctrl_y_dup5_t4
+ clkb|clkb_bridge1|clkb_bridge2|clkb_mid|clkb_w|ctrl|ctrlb|inv_clk_y|tg_d_ctrlb|tg_fbm_ctrl|tg_fbs_ctrlb|tg_s_ctrl|y__t46
+ clkb|clkb_bridge1|clkb_bridge2|clkb_mid|clkb_w|ctrl|ctrlb|inv_clk_y|tg_d_ctrlb|tg_fbm_ctrl|tg_fbs_ctrlb|tg_s_ctrl|y$5
+ 376.113299304
* device instance clkb_clkb_bridge1_clkb_bridge2_clkb_mid_clkb_w_ctrl_ctrlb_inv_clk_y_tg_d_ctrlb_tg_fbm_ctrl_tg_fbs_ctrlb_tg_s_ctrl_y_dup5_t5 r0 *1 0,0
Rclkb_clkb_bridge1_clkb_bridge2_clkb_mid_clkb_w_ctrl_ctrlb_inv_clk_y_tg_d_ctrlb_tg_fbm_ctrl_tg_fbs_ctrlb_tg_s_ctrl_y_dup5_t5
+ clkb|clkb_bridge1|clkb_bridge2|clkb_mid|clkb_w|ctrl|ctrlb|inv_clk_y|tg_d_ctrlb|tg_fbm_ctrl|tg_fbs_ctrlb|tg_s_ctrl|y__t56
+ clkb|clkb_bridge1|clkb_bridge2|clkb_mid|clkb_w|ctrl|ctrlb|inv_clk_y|tg_d_ctrlb|tg_fbm_ctrl|tg_fbs_ctrlb|tg_s_ctrl|y$5
+ 159.961351597
* device instance clkb_clkb_bridge1_clkb_bridge2_clkb_mid_clkb_w_ctrl_ctrlb_inv_clk_y_tg_d_ctrlb_tg_fbm_ctrl_tg_fbs_ctrlb_tg_s_ctrl_y_dup5 r0 *1 0,0
Cclkb_clkb_bridge1_clkb_bridge2_clkb_mid_clkb_w_ctrl_ctrlb_inv_clk_y_tg_d_ctrlb_tg_fbm_ctrl_tg_fbs_ctrlb_tg_s_ctrl_y_dup5
+ clkb|clkb_bridge1|clkb_bridge2|clkb_mid|clkb_w|ctrl|ctrlb|inv_clk_y|tg_d_ctrlb|tg_fbm_ctrl|tg_fbs_ctrlb|tg_s_ctrl|y$5
+ vsubs 6.914554e-15
* device instance en_en1_g_en_t0 r0 *1 0,0
Ren_en1_g_en_t0 en|en1|g_en__t0 en|en1|g_en 259.452
* device instance en_en1_g_en_t1 r0 *1 0,0
Ren_en1_g_en_t1 en|en1|g_en__t1 en|en1|g_en 259.452
* device instance en_en1_g_en r0 *1 0,0
Cen_en1_g_en en|en1|g_en vsubs 7.37613e-16
* device instance en_en2_g_en_t0 r0 *1 0,0
Ren_en2_g_en_t0 en|en2|g_en__t0 en|en2|g_en 259.452
* device instance en_en2_g_en_t1 r0 *1 0,0
Ren_en2_g_en_t1 en|en2|g_en__t1 en|en2|g_en 259.452
* device instance en_en2_g_en r0 *1 0,0
Cen_en2_g_en en|en2|g_en vsubs 7.37613e-16
* device instance en_en3_g_en_t0 r0 *1 0,0
Ren_en3_g_en_t0 en|en3|g_en__t0 en|en3|g_en 259.452
* device instance en_en3_g_en_t1 r0 *1 0,0
Ren_en3_g_en_t1 en|en3|g_en__t1 en|en3|g_en 259.452
* device instance en_en3_g_en r0 *1 0,0
Cen_en3_g_en en|en3|g_en vsubs 7.37613e-16
* device instance en_en4_g_en_t0 r0 *1 0,0
Ren_en4_g_en_t0 en|en4|g_en__t0 en|en4|g_en 259.452
* device instance en_en4_g_en_t1 r0 *1 0,0
Ren_en4_g_en_t1 en|en4|g_en__t1 en|en4|g_en 259.452
* device instance en_en4_g_en r0 *1 0,0
Cen_en4_g_en en|en4|g_en vsubs 7.37613e-16
* device instance en_nand_m_en_nand_m_en_via_nand_s2_en_nand_s2_en_via_rst_n_t0 r0 *1 0,0
Ren_nand_m_en_nand_m_en_via_nand_s2_en_nand_s2_en_via_rst_n_t0
+ en|nand_m_en|nand_m_en_via|nand_s2_en|nand_s2_en_via|rst_n__t0
+ en|nand_m_en|nand_m_en_via|nand_s2_en|nand_s2_en_via|rst_n 508.887095444
* device instance en_nand_m_en_nand_m_en_via_nand_s2_en_nand_s2_en_via_rst_n_t1 r0 *1 0,0
Ren_nand_m_en_nand_m_en_via_nand_s2_en_nand_s2_en_via_rst_n_t1
+ en|nand_m_en|nand_m_en_via|nand_s2_en|nand_s2_en_via|rst_n__t1
+ en|nand_m_en|nand_m_en_via|nand_s2_en|nand_s2_en_via|rst_n 40.6685547659
* device instance en_nand_m_en_nand_m_en_via_nand_s2_en_nand_s2_en_via_rst_n_t2 r0 *1 0,0
Ren_nand_m_en_nand_m_en_via_nand_s2_en_nand_s2_en_via_rst_n_t2
+ en|nand_m_en|nand_m_en_via|nand_s2_en|nand_s2_en_via|rst_n__t2
+ en|nand_m_en|nand_m_en_via|nand_s2_en|nand_s2_en_via|rst_n 508.887095444
* device instance en_nand_m_en_nand_m_en_via_nand_s2_en_nand_s2_en_via_rst_n_t3 r0 *1 0,0
Ren_nand_m_en_nand_m_en_via_nand_s2_en_nand_s2_en_via_rst_n_t3
+ en|nand_m_en|nand_m_en_via|nand_s2_en|nand_s2_en_via|rst_n__t3
+ en|nand_m_en|nand_m_en_via|nand_s2_en|nand_s2_en_via|rst_n 407.164961817
* device instance en_nand_m_en_nand_m_en_via_nand_s2_en_nand_s2_en_via_rst_n_t4 r0 *1 0,0
Ren_nand_m_en_nand_m_en_via_nand_s2_en_nand_s2_en_via_rst_n_t4
+ en|nand_m_en|nand_m_en_via|nand_s2_en|nand_s2_en_via|rst_n__t4
+ en|nand_m_en|nand_m_en_via|nand_s2_en|nand_s2_en_via|rst_n 325.422862766
* device instance en_nand_m_en_nand_m_en_via_nand_s2_en_nand_s2_en_via_rst_n_t5 r0 *1 0,0
Ren_nand_m_en_nand_m_en_via_nand_s2_en_nand_s2_en_via_rst_n_t5
+ en|nand_m_en|nand_m_en_via|nand_s2_en|nand_s2_en_via|rst_n__t5
+ en|nand_m_en|nand_m_en_via|nand_s2_en|nand_s2_en_via|rst_n 142.020251455
* device instance en_nand_m_en_nand_m_en_via_nand_s2_en_nand_s2_en_via_rst_n_t6 r0 *1 0,0
Ren_nand_m_en_nand_m_en_via_nand_s2_en_nand_s2_en_via_rst_n_t6
+ en|nand_m_en|nand_m_en_via|nand_s2_en|nand_s2_en_via|rst_n__t6
+ en|nand_m_en|nand_m_en_via|nand_s2_en|nand_s2_en_via|rst_n 223.72023709
* device instance en_nand_m_en_nand_m_en_via_nand_s2_en_nand_s2_en_via_rst_n_t7 r0 *1 0,0
Ren_nand_m_en_nand_m_en_via_nand_s2_en_nand_s2_en_via_rst_n_t7
+ en|nand_m_en|nand_m_en_via|nand_s2_en|nand_s2_en_via|rst_n__t7
+ en|nand_m_en|nand_m_en_via|nand_s2_en|nand_s2_en_via|rst_n 225.203067879
* device instance en_nand_m_en_nand_m_en_via_nand_s2_en_nand_s2_en_via_rst_n_t8 r0 *1 0,0
Ren_nand_m_en_nand_m_en_via_nand_s2_en_nand_s2_en_via_rst_n_t8
+ en|nand_m_en|nand_m_en_via|nand_s2_en|nand_s2_en_via|rst_n__t8
+ en|nand_m_en|nand_m_en_via|nand_s2_en|nand_s2_en_via|rst_n 143.502148838
* device instance en_nand_m_en_nand_m_en_via_nand_s2_en_nand_s2_en_via_rst_n_t9 r0 *1 0,0
Ren_nand_m_en_nand_m_en_via_nand_s2_en_nand_s2_en_via_rst_n_t9
+ en|nand_m_en|nand_m_en_via|nand_s2_en|nand_s2_en_via|rst_n__t9
+ en|nand_m_en|nand_m_en_via|nand_s2_en|nand_s2_en_via|rst_n 510.37043704
* device instance en_nand_m_en_nand_m_en_via_nand_s2_en_nand_s2_en_via_rst_n_t10 r0 *1 0,0
Ren_nand_m_en_nand_m_en_via_nand_s2_en_nand_s2_en_via_rst_n_t10
+ en|nand_m_en|nand_m_en_via|nand_s2_en|nand_s2_en_via|rst_n__t10
+ en|nand_m_en|nand_m_en_via|nand_s2_en|nand_s2_en_via|rst_n 42.1332712618
* device instance en_nand_m_en_nand_m_en_via_nand_s2_en_nand_s2_en_via_rst_n_t11 r0 *1 0,0
Ren_nand_m_en_nand_m_en_via_nand_s2_en_nand_s2_en_via_rst_n_t11
+ en|nand_m_en|nand_m_en_via|nand_s2_en|nand_s2_en_via|rst_n__t11
+ en|nand_m_en|nand_m_en_via|nand_s2_en|nand_s2_en_via|rst_n 408.648234462
* device instance en_nand_m_en_nand_m_en_via_nand_s2_en_nand_s2_en_via_rst_n_t12 r0 *1 0,0
Ren_nand_m_en_nand_m_en_via_nand_s2_en_nand_s2_en_via_rst_n_t12
+ en|nand_m_en|nand_m_en_via|nand_s2_en|nand_s2_en_via|rst_n__t12
+ en|nand_m_en|nand_m_en_via|nand_s2_en|nand_s2_en_via|rst_n 326.906027181
* device instance en_nand_m_en_nand_m_en_via_nand_s2_en_nand_s2_en_via_rst_n_t13 r0 *1 0,0
Ren_nand_m_en_nand_m_en_via_nand_s2_en_nand_s2_en_via_rst_n_t13
+ en|nand_m_en|nand_m_en_via|nand_s2_en|nand_s2_en_via|rst_n__t13
+ en|nand_m_en|nand_m_en_via|nand_s2_en|nand_s2_en_via|rst_n 143.502148838
* device instance en_nand_m_en_nand_m_en_via_nand_s2_en_nand_s2_en_via_rst_n_t14 r0 *1 0,0
Ren_nand_m_en_nand_m_en_via_nand_s2_en_nand_s2_en_via_rst_n_t14
+ en|nand_m_en|nand_m_en_via|nand_s2_en|nand_s2_en_via|rst_n__t14
+ en|nand_m_en|nand_m_en_via|nand_s2_en|nand_s2_en_via|rst_n 225.203067879
* device instance en_nand_m_en_nand_m_en_via_nand_s2_en_nand_s2_en_via_rst_n_t15 r0 *1 0,0
Ren_nand_m_en_nand_m_en_via_nand_s2_en_nand_s2_en_via_rst_n_t15
+ en|nand_m_en|nand_m_en_via|nand_s2_en|nand_s2_en_via|rst_n__t15
+ en|nand_m_en|nand_m_en_via|nand_s2_en|nand_s2_en_via|rst_n 326.906027181
* device instance en_nand_m_en_nand_m_en_via_nand_s2_en_nand_s2_en_via_rst_n_t16 r0 *1 0,0
Ren_nand_m_en_nand_m_en_via_nand_s2_en_nand_s2_en_via_rst_n_t16
+ en|nand_m_en|nand_m_en_via|nand_s2_en|nand_s2_en_via|rst_n__t16
+ en|nand_m_en|nand_m_en_via|nand_s2_en|nand_s2_en_via|rst_n 408.648234462
* device instance en_nand_m_en_nand_m_en_via_nand_s2_en_nand_s2_en_via_rst_n_t17 r0 *1 0,0
Ren_nand_m_en_nand_m_en_via_nand_s2_en_nand_s2_en_via_rst_n_t17
+ en|nand_m_en|nand_m_en_via|nand_s2_en|nand_s2_en_via|rst_n__t17
+ en|nand_m_en|nand_m_en_via|nand_s2_en|nand_s2_en_via|rst_n 510.37043704
* device instance en_nand_m_en_nand_m_en_via_nand_s2_en_nand_s2_en_via_rst_n_t18 r0 *1 0,0
Ren_nand_m_en_nand_m_en_via_nand_s2_en_nand_s2_en_via_rst_n_t18
+ en|nand_m_en|nand_m_en_via|nand_s2_en|nand_s2_en_via|rst_n__t18
+ en|nand_m_en|nand_m_en_via|nand_s2_en|nand_s2_en_via|rst_n 42.1332712618
* device instance en_nand_m_en_nand_m_en_via_nand_s2_en_nand_s2_en_via_rst_n_t19 r0 *1 0,0
Ren_nand_m_en_nand_m_en_via_nand_s2_en_nand_s2_en_via_rst_n_t19
+ en|nand_m_en|nand_m_en_via|nand_s2_en|nand_s2_en_via|rst_n__t19
+ en|nand_m_en|nand_m_en_via|nand_s2_en|nand_s2_en_via|rst_n 40.6685547659
* device instance en_nand_m_en_nand_m_en_via_nand_s2_en_nand_s2_en_via_rst_n_t20 r0 *1 0,0
Ren_nand_m_en_nand_m_en_via_nand_s2_en_nand_s2_en_via_rst_n_t20
+ en|nand_m_en|nand_m_en_via|nand_s2_en|nand_s2_en_via|rst_n__t20
+ en|nand_m_en|nand_m_en_via|nand_s2_en|nand_s2_en_via|rst_n 142.020251455
* device instance en_nand_m_en_nand_m_en_via_nand_s2_en_nand_s2_en_via_rst_n_t21 r0 *1 0,0
Ren_nand_m_en_nand_m_en_via_nand_s2_en_nand_s2_en_via_rst_n_t21
+ en|nand_m_en|nand_m_en_via|nand_s2_en|nand_s2_en_via|rst_n__t21
+ en|nand_m_en|nand_m_en_via|nand_s2_en|nand_s2_en_via|rst_n 223.72023709
* device instance en_nand_m_en_nand_m_en_via_nand_s2_en_nand_s2_en_via_rst_n_t22 r0 *1 0,0
Ren_nand_m_en_nand_m_en_via_nand_s2_en_nand_s2_en_via_rst_n_t22
+ en|nand_m_en|nand_m_en_via|nand_s2_en|nand_s2_en_via|rst_n__t22
+ en|nand_m_en|nand_m_en_via|nand_s2_en|nand_s2_en_via|rst_n 407.164961817
* device instance en_nand_m_en_nand_m_en_via_nand_s2_en_nand_s2_en_via_rst_n_t23 r0 *1 0,0
Ren_nand_m_en_nand_m_en_via_nand_s2_en_nand_s2_en_via_rst_n_t23
+ en|nand_m_en|nand_m_en_via|nand_s2_en|nand_s2_en_via|rst_n__t23
+ en|nand_m_en|nand_m_en_via|nand_s2_en|nand_s2_en_via|rst_n 325.422862766
* device instance en_nand_m_en_nand_m_en_via_nand_s2_en_nand_s2_en_via_rst_n r0 *1 0,0
Cen_nand_m_en_nand_m_en_via_nand_s2_en_nand_s2_en_via_rst_n
+ en|nand_m_en|nand_m_en_via|nand_s2_en|nand_s2_en_via|rst_n vsubs 4.799164e-14
* device instance g_vddr_m1_mnt_g_s1_vddr_m1_s2_vddr_m1_s3_vddr_m1_s4_vddr_m1_vddr_vddr1_t0 r0 *1 0,0
Rg_vddr_m1_mnt_g_s1_vddr_m1_s2_vddr_m1_s3_vddr_m1_s4_vddr_m1_vddr_vddr1_t0
+ g_vddr_m1|mnt_g|s1_vddr_m1|s2_vddr_m1|s3_vddr_m1|s4_vddr_m1|vddr|vddr1__t0
+ g_vddr_m1|mnt_g|s1_vddr_m1|s2_vddr_m1|s3_vddr_m1|s4_vddr_m1|vddr|vddr1
+ 548.247137452
* device instance g_vddr_m1_mnt_g_s1_vddr_m1_s2_vddr_m1_s3_vddr_m1_s4_vddr_m1_vddr_vddr1_t1 r0 *1 0,0
Rg_vddr_m1_mnt_g_s1_vddr_m1_s2_vddr_m1_s3_vddr_m1_s4_vddr_m1_vddr_vddr1_t1
+ g_vddr_m1|mnt_g|s1_vddr_m1|s2_vddr_m1|s3_vddr_m1|s4_vddr_m1|vddr|vddr1__t1
+ g_vddr_m1|mnt_g|s1_vddr_m1|s2_vddr_m1|s3_vddr_m1|s4_vddr_m1|vddr|vddr1
+ 542.513498718
* device instance g_vddr_m1_mnt_g_s1_vddr_m1_s2_vddr_m1_s3_vddr_m1_s4_vddr_m1_vddr_vddr1_t2 r0 *1 0,0
Rg_vddr_m1_mnt_g_s1_vddr_m1_s2_vddr_m1_s3_vddr_m1_s4_vddr_m1_vddr_vddr1_t2
+ g_vddr_m1|mnt_g|s1_vddr_m1|s2_vddr_m1|s3_vddr_m1|s4_vddr_m1|vddr|vddr1__t2
+ g_vddr_m1|mnt_g|s1_vddr_m1|s2_vddr_m1|s3_vddr_m1|s4_vddr_m1|vddr|vddr1
+ 542.513498718
* device instance g_vddr_m1_mnt_g_s1_vddr_m1_s2_vddr_m1_s3_vddr_m1_s4_vddr_m1_vddr_vddr1_t3 r0 *1 0,0
Rg_vddr_m1_mnt_g_s1_vddr_m1_s2_vddr_m1_s3_vddr_m1_s4_vddr_m1_vddr_vddr1_t3
+ g_vddr_m1|mnt_g|s1_vddr_m1|s2_vddr_m1|s3_vddr_m1|s4_vddr_m1|vddr|vddr1__t3
+ g_vddr_m1|mnt_g|s1_vddr_m1|s2_vddr_m1|s3_vddr_m1|s4_vddr_m1|vddr|vddr1
+ 248.149615946
* device instance g_vddr_m1_mnt_g_s1_vddr_m1_s2_vddr_m1_s3_vddr_m1_s4_vddr_m1_vddr_vddr1_t4 r0 *1 0,0
Rg_vddr_m1_mnt_g_s1_vddr_m1_s2_vddr_m1_s3_vddr_m1_s4_vddr_m1_vddr_vddr1_t4
+ g_vddr_m1|mnt_g|s1_vddr_m1|s2_vddr_m1|s3_vddr_m1|s4_vddr_m1|vddr|vddr1__t4
+ g_vddr_m1|mnt_g|s1_vddr_m1|s2_vddr_m1|s3_vddr_m1|s4_vddr_m1|vddr|vddr1
+ 529.307929685
* device instance g_vddr_m1_mnt_g_s1_vddr_m1_s2_vddr_m1_s3_vddr_m1_s4_vddr_m1_vddr_vddr1_t5 r0 *1 0,0
Rg_vddr_m1_mnt_g_s1_vddr_m1_s2_vddr_m1_s3_vddr_m1_s4_vddr_m1_vddr_vddr1_t5
+ g_vddr_m1|mnt_g|s1_vddr_m1|s2_vddr_m1|s3_vddr_m1|s4_vddr_m1|vddr|vddr1__t5
+ g_vddr_m1|mnt_g|s1_vddr_m1|s2_vddr_m1|s3_vddr_m1|s4_vddr_m1|vddr|vddr1
+ 26.5392771065
* device instance g_vddr_m1_mnt_g_s1_vddr_m1_s2_vddr_m1_s3_vddr_m1_s4_vddr_m1_vddr_vddr1_t6 r0 *1 0,0
Rg_vddr_m1_mnt_g_s1_vddr_m1_s2_vddr_m1_s3_vddr_m1_s4_vddr_m1_vddr_vddr1_t6
+ g_vddr_m1|mnt_g|s1_vddr_m1|s2_vddr_m1|s3_vddr_m1|s4_vddr_m1|vddr|vddr1__t6
+ g_vddr_m1|mnt_g|s1_vddr_m1|s2_vddr_m1|s3_vddr_m1|s4_vddr_m1|vddr|vddr1
+ 271.232773475
* device instance g_vddr_m1_mnt_g_s1_vddr_m1_s2_vddr_m1_s3_vddr_m1_s4_vddr_m1_vddr_vddr1_t7 r0 *1 0,0
Rg_vddr_m1_mnt_g_s1_vddr_m1_s2_vddr_m1_s3_vddr_m1_s4_vddr_m1_vddr_vddr1_t7
+ g_vddr_m1|mnt_g|s1_vddr_m1|s2_vddr_m1|s3_vddr_m1|s4_vddr_m1|vddr|vddr1__t7
+ g_vddr_m1|mnt_g|s1_vddr_m1|s2_vddr_m1|s3_vddr_m1|s4_vddr_m1|vddr|vddr1
+ 248.149615946
* device instance g_vddr_m1_mnt_g_s1_vddr_m1_s2_vddr_m1_s3_vddr_m1_s4_vddr_m1_vddr_vddr1_t8 r0 *1 0,0
Rg_vddr_m1_mnt_g_s1_vddr_m1_s2_vddr_m1_s3_vddr_m1_s4_vddr_m1_vddr_vddr1_t8
+ g_vddr_m1|mnt_g|s1_vddr_m1|s2_vddr_m1|s3_vddr_m1|s4_vddr_m1|vddr|vddr1__t8
+ g_vddr_m1|mnt_g|s1_vddr_m1|s2_vddr_m1|s3_vddr_m1|s4_vddr_m1|vddr|vddr1
+ 529.307929685
* device instance g_vddr_m1_mnt_g_s1_vddr_m1_s2_vddr_m1_s3_vddr_m1_s4_vddr_m1_vddr_vddr1_t9 r0 *1 0,0
Rg_vddr_m1_mnt_g_s1_vddr_m1_s2_vddr_m1_s3_vddr_m1_s4_vddr_m1_vddr_vddr1_t9
+ g_vddr_m1|mnt_g|s1_vddr_m1|s2_vddr_m1|s3_vddr_m1|s4_vddr_m1|vddr|vddr1__t9
+ g_vddr_m1|mnt_g|s1_vddr_m1|s2_vddr_m1|s3_vddr_m1|s4_vddr_m1|vddr|vddr1
+ 26.5392771065
* device instance g_vddr_m1_mnt_g_s1_vddr_m1_s2_vddr_m1_s3_vddr_m1_s4_vddr_m1_vddr_vddr1_t10 r0 *1 0,0
Rg_vddr_m1_mnt_g_s1_vddr_m1_s2_vddr_m1_s3_vddr_m1_s4_vddr_m1_vddr_vddr1_t10
+ g_vddr_m1|mnt_g|s1_vddr_m1|s2_vddr_m1|s3_vddr_m1|s4_vddr_m1|vddr|vddr1__t10
+ g_vddr_m1|mnt_g|s1_vddr_m1|s2_vddr_m1|s3_vddr_m1|s4_vddr_m1|vddr|vddr1
+ 271.232773475
* device instance g_vddr_m1_mnt_g_s1_vddr_m1_s2_vddr_m1_s3_vddr_m1_s4_vddr_m1_vddr_vddr1_t11 r0 *1 0,0
Rg_vddr_m1_mnt_g_s1_vddr_m1_s2_vddr_m1_s3_vddr_m1_s4_vddr_m1_vddr_vddr1_t11
+ g_vddr_m1|mnt_g|s1_vddr_m1|s2_vddr_m1|s3_vddr_m1|s4_vddr_m1|vddr|vddr1__t11
+ g_vddr_m1|mnt_g|s1_vddr_m1|s2_vddr_m1|s3_vddr_m1|s4_vddr_m1|vddr|vddr1
+ 536.006712531
* device instance g_vddr_m1_mnt_g_s1_vddr_m1_s2_vddr_m1_s3_vddr_m1_s4_vddr_m1_vddr_vddr1_t12 r0 *1 0,0
Rg_vddr_m1_mnt_g_s1_vddr_m1_s2_vddr_m1_s3_vddr_m1_s4_vddr_m1_vddr_vddr1_t12
+ g_vddr_m1|mnt_g|s1_vddr_m1|s2_vddr_m1|s3_vddr_m1|s4_vddr_m1|vddr|vddr1__t12
+ g_vddr_m1|mnt_g|s1_vddr_m1|s2_vddr_m1|s3_vddr_m1|s4_vddr_m1|vddr|vddr1
+ 88.5474148697
* device instance g_vddr_m1_mnt_g_s1_vddr_m1_s2_vddr_m1_s3_vddr_m1_s4_vddr_m1_vddr_vddr1_t13 r0 *1 0,0
Rg_vddr_m1_mnt_g_s1_vddr_m1_s2_vddr_m1_s3_vddr_m1_s4_vddr_m1_vddr_vddr1_t13
+ g_vddr_m1|mnt_g|s1_vddr_m1|s2_vddr_m1|s3_vddr_m1|s4_vddr_m1|vddr|vddr1__t13
+ g_vddr_m1|mnt_g|s1_vddr_m1|s2_vddr_m1|s3_vddr_m1|s4_vddr_m1|vddr|vddr1
+ 262.134590134
* device instance g_vddr_m1_mnt_g_s1_vddr_m1_s2_vddr_m1_s3_vddr_m1_s4_vddr_m1_vddr_vddr1_t14 r0 *1 0,0
Rg_vddr_m1_mnt_g_s1_vddr_m1_s2_vddr_m1_s3_vddr_m1_s4_vddr_m1_vddr_vddr1_t14
+ g_vddr_m1|mnt_g|s1_vddr_m1|s2_vddr_m1|s3_vddr_m1|s4_vddr_m1|vddr|vddr1__t14
+ g_vddr_m1|mnt_g|s1_vddr_m1|s2_vddr_m1|s3_vddr_m1|s4_vddr_m1|vddr|vddr1
+ 284.083665243
* device instance g_vddr_m1_mnt_g_s1_vddr_m1_s2_vddr_m1_s3_vddr_m1_s4_vddr_m1_vddr_vddr1_t15 r0 *1 0,0
Rg_vddr_m1_mnt_g_s1_vddr_m1_s2_vddr_m1_s3_vddr_m1_s4_vddr_m1_vddr_vddr1_t15
+ g_vddr_m1|mnt_g|s1_vddr_m1|s2_vddr_m1|s3_vddr_m1|s4_vddr_m1|vddr|vddr1__t15
+ g_vddr_m1|mnt_g|s1_vddr_m1|s2_vddr_m1|s3_vddr_m1|s4_vddr_m1|vddr|vddr1
+ 180.105204003
* device instance g_vddr_m1_mnt_g_s1_vddr_m1_s2_vddr_m1_s3_vddr_m1_s4_vddr_m1_vddr_vddr1_t16 r0 *1 0,0
Rg_vddr_m1_mnt_g_s1_vddr_m1_s2_vddr_m1_s3_vddr_m1_s4_vddr_m1_vddr_vddr1_t16
+ g_vddr_m1|mnt_g|s1_vddr_m1|s2_vddr_m1|s3_vddr_m1|s4_vddr_m1|vddr|vddr1__t16
+ g_vddr_m1|mnt_g|s1_vddr_m1|s2_vddr_m1|s3_vddr_m1|s4_vddr_m1|vddr|vddr1
+ 83.5568030932
* device instance g_vddr_m1_mnt_g_s1_vddr_m1_s2_vddr_m1_s3_vddr_m1_s4_vddr_m1_vddr_vddr1_t17 r0 *1 0,0
Rg_vddr_m1_mnt_g_s1_vddr_m1_s2_vddr_m1_s3_vddr_m1_s4_vddr_m1_vddr_vddr1_t17
+ g_vddr_m1|mnt_g|s1_vddr_m1|s2_vddr_m1|s3_vddr_m1|s4_vddr_m1|vddr|vddr1__t17
+ g_vddr_m1|mnt_g|s1_vddr_m1|s2_vddr_m1|s3_vddr_m1|s4_vddr_m1|vddr|vddr1
+ 474.224411679
* device instance g_vddr_m1_mnt_g_s1_vddr_m1_s2_vddr_m1_s3_vddr_m1_s4_vddr_m1_vddr_vddr1_t18 r0 *1 0,0
Rg_vddr_m1_mnt_g_s1_vddr_m1_s2_vddr_m1_s3_vddr_m1_s4_vddr_m1_vddr_vddr1_t18
+ g_vddr_m1|mnt_g|s1_vddr_m1|s2_vddr_m1|s3_vddr_m1|s4_vddr_m1|vddr|vddr1__t18
+ g_vddr_m1|mnt_g|s1_vddr_m1|s2_vddr_m1|s3_vddr_m1|s4_vddr_m1|vddr|vddr1
+ 339.503132563
* device instance g_vddr_m1_mnt_g_s1_vddr_m1_s2_vddr_m1_s3_vddr_m1_s4_vddr_m1_vddr_vddr1_t19 r0 *1 0,0
Rg_vddr_m1_mnt_g_s1_vddr_m1_s2_vddr_m1_s3_vddr_m1_s4_vddr_m1_vddr_vddr1_t19
+ g_vddr_m1|mnt_g|s1_vddr_m1|s2_vddr_m1|s3_vddr_m1|s4_vddr_m1|vddr|vddr1__t19
+ g_vddr_m1|mnt_g|s1_vddr_m1|s2_vddr_m1|s3_vddr_m1|s4_vddr_m1|vddr|vddr1
+ 597.728866242
* device instance g_vddr_m1_mnt_g_s1_vddr_m1_s2_vddr_m1_s3_vddr_m1_s4_vddr_m1_vddr_vddr1_t20 r0 *1 0,0
Rg_vddr_m1_mnt_g_s1_vddr_m1_s2_vddr_m1_s3_vddr_m1_s4_vddr_m1_vddr_vddr1_t20
+ g_vddr_m1|mnt_g|s1_vddr_m1|s2_vddr_m1|s3_vddr_m1|s4_vddr_m1|vddr|vddr1__t20
+ g_vddr_m1|mnt_g|s1_vddr_m1|s2_vddr_m1|s3_vddr_m1|s4_vddr_m1|vddr|vddr1
+ 433.56387233
* device instance g_vddr_m1_mnt_g_s1_vddr_m1_s2_vddr_m1_s3_vddr_m1_s4_vddr_m1_vddr_vddr1 r0 *1 0,0
Cg_vddr_m1_mnt_g_s1_vddr_m1_s2_vddr_m1_s3_vddr_m1_s4_vddr_m1_vddr_vddr1
+ g_vddr_m1|mnt_g|s1_vddr_m1|s2_vddr_m1|s3_vddr_m1|s4_vddr_m1|vddr|vddr1 vsubs
+ 1.4763978e-14
* device instance g_vddr_m1_mnt_g_s1_vddr_m1_s2_vddr_m1_s3_vddr_m1_s4_vddr_m1_vddr_vddr2_t0 r0 *1 0,0
Rg_vddr_m1_mnt_g_s1_vddr_m1_s2_vddr_m1_s3_vddr_m1_s4_vddr_m1_vddr_vddr2_t0
+ g_vddr_m1|mnt_g|s1_vddr_m1|s2_vddr_m1|s3_vddr_m1|s4_vddr_m1|vddr|vddr2__t0
+ g_vddr_m1|mnt_g|s1_vddr_m1|s2_vddr_m1|s3_vddr_m1|s4_vddr_m1|vddr|vddr2
+ 548.481147289
* device instance g_vddr_m1_mnt_g_s1_vddr_m1_s2_vddr_m1_s3_vddr_m1_s4_vddr_m1_vddr_vddr2_t1 r0 *1 0,0
Rg_vddr_m1_mnt_g_s1_vddr_m1_s2_vddr_m1_s3_vddr_m1_s4_vddr_m1_vddr_vddr2_t1
+ g_vddr_m1|mnt_g|s1_vddr_m1|s2_vddr_m1|s3_vddr_m1|s4_vddr_m1|vddr|vddr2__t1
+ g_vddr_m1|mnt_g|s1_vddr_m1|s2_vddr_m1|s3_vddr_m1|s4_vddr_m1|vddr|vddr2
+ 542.74506125
* device instance g_vddr_m1_mnt_g_s1_vddr_m1_s2_vddr_m1_s3_vddr_m1_s4_vddr_m1_vddr_vddr2_t2 r0 *1 0,0
Rg_vddr_m1_mnt_g_s1_vddr_m1_s2_vddr_m1_s3_vddr_m1_s4_vddr_m1_vddr_vddr2_t2
+ g_vddr_m1|mnt_g|s1_vddr_m1|s2_vddr_m1|s3_vddr_m1|s4_vddr_m1|vddr|vddr2__t2
+ g_vddr_m1|mnt_g|s1_vddr_m1|s2_vddr_m1|s3_vddr_m1|s4_vddr_m1|vddr|vddr2
+ 542.74506125
* device instance g_vddr_m1_mnt_g_s1_vddr_m1_s2_vddr_m1_s3_vddr_m1_s4_vddr_m1_vddr_vddr2_t3 r0 *1 0,0
Rg_vddr_m1_mnt_g_s1_vddr_m1_s2_vddr_m1_s3_vddr_m1_s4_vddr_m1_vddr_vddr2_t3
+ g_vddr_m1|mnt_g|s1_vddr_m1|s2_vddr_m1|s3_vddr_m1|s4_vddr_m1|vddr|vddr2__t3
+ g_vddr_m1|mnt_g|s1_vddr_m1|s2_vddr_m1|s3_vddr_m1|s4_vddr_m1|vddr|vddr2
+ 248.25553433
* device instance g_vddr_m1_mnt_g_s1_vddr_m1_s2_vddr_m1_s3_vddr_m1_s4_vddr_m1_vddr_vddr2_t4 r0 *1 0,0
Rg_vddr_m1_mnt_g_s1_vddr_m1_s2_vddr_m1_s3_vddr_m1_s4_vddr_m1_vddr_vddr2_t4
+ g_vddr_m1|mnt_g|s1_vddr_m1|s2_vddr_m1|s3_vddr_m1|s4_vddr_m1|vddr|vddr2__t4
+ g_vddr_m1|mnt_g|s1_vddr_m1|s2_vddr_m1|s3_vddr_m1|s4_vddr_m1|vddr|vddr2
+ 26.5506049392
* device instance g_vddr_m1_mnt_g_s1_vddr_m1_s2_vddr_m1_s3_vddr_m1_s4_vddr_m1_vddr_vddr2_t5 r0 *1 0,0
Rg_vddr_m1_mnt_g_s1_vddr_m1_s2_vddr_m1_s3_vddr_m1_s4_vddr_m1_vddr_vddr2_t5
+ g_vddr_m1|mnt_g|s1_vddr_m1|s2_vddr_m1|s3_vddr_m1|s4_vddr_m1|vddr|vddr2__t5
+ g_vddr_m1|mnt_g|s1_vddr_m1|s2_vddr_m1|s3_vddr_m1|s4_vddr_m1|vddr|vddr2
+ 529.533855647
* device instance g_vddr_m1_mnt_g_s1_vddr_m1_s2_vddr_m1_s3_vddr_m1_s4_vddr_m1_vddr_vddr2_t6 r0 *1 0,0
Rg_vddr_m1_mnt_g_s1_vddr_m1_s2_vddr_m1_s3_vddr_m1_s4_vddr_m1_vddr_vddr2_t6
+ g_vddr_m1|mnt_g|s1_vddr_m1|s2_vddr_m1|s3_vddr_m1|s4_vddr_m1|vddr|vddr2__t6
+ g_vddr_m1|mnt_g|s1_vddr_m1|s2_vddr_m1|s3_vddr_m1|s4_vddr_m1|vddr|vddr2
+ 271.348544507
* device instance g_vddr_m1_mnt_g_s1_vddr_m1_s2_vddr_m1_s3_vddr_m1_s4_vddr_m1_vddr_vddr2_t7 r0 *1 0,0
Rg_vddr_m1_mnt_g_s1_vddr_m1_s2_vddr_m1_s3_vddr_m1_s4_vddr_m1_vddr_vddr2_t7
+ g_vddr_m1|mnt_g|s1_vddr_m1|s2_vddr_m1|s3_vddr_m1|s4_vddr_m1|vddr|vddr2__t7
+ g_vddr_m1|mnt_g|s1_vddr_m1|s2_vddr_m1|s3_vddr_m1|s4_vddr_m1|vddr|vddr2
+ 248.25553433
* device instance g_vddr_m1_mnt_g_s1_vddr_m1_s2_vddr_m1_s3_vddr_m1_s4_vddr_m1_vddr_vddr2_t8 r0 *1 0,0
Rg_vddr_m1_mnt_g_s1_vddr_m1_s2_vddr_m1_s3_vddr_m1_s4_vddr_m1_vddr_vddr2_t8
+ g_vddr_m1|mnt_g|s1_vddr_m1|s2_vddr_m1|s3_vddr_m1|s4_vddr_m1|vddr|vddr2__t8
+ g_vddr_m1|mnt_g|s1_vddr_m1|s2_vddr_m1|s3_vddr_m1|s4_vddr_m1|vddr|vddr2
+ 26.5506049392
* device instance g_vddr_m1_mnt_g_s1_vddr_m1_s2_vddr_m1_s3_vddr_m1_s4_vddr_m1_vddr_vddr2_t9 r0 *1 0,0
Rg_vddr_m1_mnt_g_s1_vddr_m1_s2_vddr_m1_s3_vddr_m1_s4_vddr_m1_vddr_vddr2_t9
+ g_vddr_m1|mnt_g|s1_vddr_m1|s2_vddr_m1|s3_vddr_m1|s4_vddr_m1|vddr|vddr2__t9
+ g_vddr_m1|mnt_g|s1_vddr_m1|s2_vddr_m1|s3_vddr_m1|s4_vddr_m1|vddr|vddr2
+ 529.533855647
* device instance g_vddr_m1_mnt_g_s1_vddr_m1_s2_vddr_m1_s3_vddr_m1_s4_vddr_m1_vddr_vddr2_t10 r0 *1 0,0
Rg_vddr_m1_mnt_g_s1_vddr_m1_s2_vddr_m1_s3_vddr_m1_s4_vddr_m1_vddr_vddr2_t10
+ g_vddr_m1|mnt_g|s1_vddr_m1|s2_vddr_m1|s3_vddr_m1|s4_vddr_m1|vddr|vddr2__t10
+ g_vddr_m1|mnt_g|s1_vddr_m1|s2_vddr_m1|s3_vddr_m1|s4_vddr_m1|vddr|vddr2
+ 271.348544507
* device instance g_vddr_m1_mnt_g_s1_vddr_m1_s2_vddr_m1_s3_vddr_m1_s4_vddr_m1_vddr_vddr2_t11 r0 *1 0,0
Rg_vddr_m1_mnt_g_s1_vddr_m1_s2_vddr_m1_s3_vddr_m1_s4_vddr_m1_vddr_vddr2_t11
+ g_vddr_m1|mnt_g|s1_vddr_m1|s2_vddr_m1|s3_vddr_m1|s4_vddr_m1|vddr|vddr2__t11
+ g_vddr_m1|mnt_g|s1_vddr_m1|s2_vddr_m1|s3_vddr_m1|s4_vddr_m1|vddr|vddr2
+ 536.235497753
* device instance g_vddr_m1_mnt_g_s1_vddr_m1_s2_vddr_m1_s3_vddr_m1_s4_vddr_m1_vddr_vddr2_t12 r0 *1 0,0
Rg_vddr_m1_mnt_g_s1_vddr_m1_s2_vddr_m1_s3_vddr_m1_s4_vddr_m1_vddr_vddr2_t12
+ g_vddr_m1|mnt_g|s1_vddr_m1|s2_vddr_m1|s3_vddr_m1|s4_vddr_m1|vddr|vddr2__t12
+ g_vddr_m1|mnt_g|s1_vddr_m1|s2_vddr_m1|s3_vddr_m1|s4_vddr_m1|vddr|vddr2
+ 88.5852098068
* device instance g_vddr_m1_mnt_g_s1_vddr_m1_s2_vddr_m1_s3_vddr_m1_s4_vddr_m1_vddr_vddr2_t13 r0 *1 0,0
Rg_vddr_m1_mnt_g_s1_vddr_m1_s2_vddr_m1_s3_vddr_m1_s4_vddr_m1_vddr_vddr2_t13
+ g_vddr_m1|mnt_g|s1_vddr_m1|s2_vddr_m1|s3_vddr_m1|s4_vddr_m1|vddr|vddr2__t13
+ g_vddr_m1|mnt_g|s1_vddr_m1|s2_vddr_m1|s3_vddr_m1|s4_vddr_m1|vddr|vddr2
+ 262.246477764
* device instance g_vddr_m1_mnt_g_s1_vddr_m1_s2_vddr_m1_s3_vddr_m1_s4_vddr_m1_vddr_vddr2_t14 r0 *1 0,0
Rg_vddr_m1_mnt_g_s1_vddr_m1_s2_vddr_m1_s3_vddr_m1_s4_vddr_m1_vddr_vddr2_t14
+ g_vddr_m1|mnt_g|s1_vddr_m1|s2_vddr_m1|s3_vddr_m1|s4_vddr_m1|vddr|vddr2__t14
+ g_vddr_m1|mnt_g|s1_vddr_m1|s2_vddr_m1|s3_vddr_m1|s4_vddr_m1|vddr|vddr2
+ 284.204921457
* device instance g_vddr_m1_mnt_g_s1_vddr_m1_s2_vddr_m1_s3_vddr_m1_s4_vddr_m1_vddr_vddr2_t15 r0 *1 0,0
Rg_vddr_m1_mnt_g_s1_vddr_m1_s2_vddr_m1_s3_vddr_m1_s4_vddr_m1_vddr_vddr2_t15
+ g_vddr_m1|mnt_g|s1_vddr_m1|s2_vddr_m1|s3_vddr_m1|s4_vddr_m1|vddr|vddr2__t15
+ g_vddr_m1|mnt_g|s1_vddr_m1|s2_vddr_m1|s3_vddr_m1|s4_vddr_m1|vddr|vddr2
+ 597.983996501
* device instance g_vddr_m1_mnt_g_s1_vddr_m1_s2_vddr_m1_s3_vddr_m1_s4_vddr_m1_vddr_vddr2_t16 r0 *1 0,0
Rg_vddr_m1_mnt_g_s1_vddr_m1_s2_vddr_m1_s3_vddr_m1_s4_vddr_m1_vddr_vddr2_t16
+ g_vddr_m1|mnt_g|s1_vddr_m1|s2_vddr_m1|s3_vddr_m1|s4_vddr_m1|vddr|vddr2__t16
+ g_vddr_m1|mnt_g|s1_vddr_m1|s2_vddr_m1|s3_vddr_m1|s4_vddr_m1|vddr|vddr2
+ 339.64804362
* device instance g_vddr_m1_mnt_g_s1_vddr_m1_s2_vddr_m1_s3_vddr_m1_s4_vddr_m1_vddr_vddr2_t17 r0 *1 0,0
Rg_vddr_m1_mnt_g_s1_vddr_m1_s2_vddr_m1_s3_vddr_m1_s4_vddr_m1_vddr_vddr2_t17
+ g_vddr_m1|mnt_g|s1_vddr_m1|s2_vddr_m1|s3_vddr_m1|s4_vddr_m1|vddr|vddr2__t17
+ g_vddr_m1|mnt_g|s1_vddr_m1|s2_vddr_m1|s3_vddr_m1|s4_vddr_m1|vddr|vddr2
+ 474.426826191
* device instance g_vddr_m1_mnt_g_s1_vddr_m1_s2_vddr_m1_s3_vddr_m1_s4_vddr_m1_vddr_vddr2_t18 r0 *1 0,0
Rg_vddr_m1_mnt_g_s1_vddr_m1_s2_vddr_m1_s3_vddr_m1_s4_vddr_m1_vddr_vddr2_t18
+ g_vddr_m1|mnt_g|s1_vddr_m1|s2_vddr_m1|s3_vddr_m1|s4_vddr_m1|vddr|vddr2__t18
+ g_vddr_m1|mnt_g|s1_vddr_m1|s2_vddr_m1|s3_vddr_m1|s4_vddr_m1|vddr|vddr2
+ 433.748931592
* device instance g_vddr_m1_mnt_g_s1_vddr_m1_s2_vddr_m1_s3_vddr_m1_s4_vddr_m1_vddr_vddr2_t19 r0 *1 0,0
Rg_vddr_m1_mnt_g_s1_vddr_m1_s2_vddr_m1_s3_vddr_m1_s4_vddr_m1_vddr_vddr2_t19
+ g_vddr_m1|mnt_g|s1_vddr_m1|s2_vddr_m1|s3_vddr_m1|s4_vddr_m1|vddr|vddr2__t19
+ g_vddr_m1|mnt_g|s1_vddr_m1|s2_vddr_m1|s3_vddr_m1|s4_vddr_m1|vddr|vddr2
+ 180.182078803
* device instance g_vddr_m1_mnt_g_s1_vddr_m1_s2_vddr_m1_s3_vddr_m1_s4_vddr_m1_vddr_vddr2_t20 r0 *1 0,0
Rg_vddr_m1_mnt_g_s1_vddr_m1_s2_vddr_m1_s3_vddr_m1_s4_vddr_m1_vddr_vddr2_t20
+ g_vddr_m1|mnt_g|s1_vddr_m1|s2_vddr_m1|s3_vddr_m1|s4_vddr_m1|vddr|vddr2__t20
+ g_vddr_m1|mnt_g|s1_vddr_m1|s2_vddr_m1|s3_vddr_m1|s4_vddr_m1|vddr|vddr2
+ 83.5924678737
* device instance g_vddr_m1_mnt_g_s1_vddr_m1_s2_vddr_m1_s3_vddr_m1_s4_vddr_m1_vddr_vddr2 r0 *1 0,0
Cg_vddr_m1_mnt_g_s1_vddr_m1_s2_vddr_m1_s3_vddr_m1_s4_vddr_m1_vddr_vddr2
+ g_vddr_m1|mnt_g|s1_vddr_m1|s2_vddr_m1|s3_vddr_m1|s4_vddr_m1|vddr|vddr2 vsubs
+ 1.4773157e-14
* device instance g_vddr_m1_mnt_g_s1_vddr_m1_s2_vddr_m1_s3_vddr_m1_s4_vddr_m1_vddr_vddr3_t0 r0 *1 0,0
Rg_vddr_m1_mnt_g_s1_vddr_m1_s2_vddr_m1_s3_vddr_m1_s4_vddr_m1_vddr_vddr3_t0
+ g_vddr_m1|mnt_g|s1_vddr_m1|s2_vddr_m1|s3_vddr_m1|s4_vddr_m1|vddr|vddr3__t0
+ g_vddr_m1|mnt_g|s1_vddr_m1|s2_vddr_m1|s3_vddr_m1|s4_vddr_m1|vddr|vddr3
+ 548.715164888
* device instance g_vddr_m1_mnt_g_s1_vddr_m1_s2_vddr_m1_s3_vddr_m1_s4_vddr_m1_vddr_vddr3_t1 r0 *1 0,0
Rg_vddr_m1_mnt_g_s1_vddr_m1_s2_vddr_m1_s3_vddr_m1_s4_vddr_m1_vddr_vddr3_t1
+ g_vddr_m1|mnt_g|s1_vddr_m1|s2_vddr_m1|s3_vddr_m1|s4_vddr_m1|vddr|vddr3__t1
+ g_vddr_m1|mnt_g|s1_vddr_m1|s2_vddr_m1|s3_vddr_m1|s4_vddr_m1|vddr|vddr3
+ 542.976631462
* device instance g_vddr_m1_mnt_g_s1_vddr_m1_s2_vddr_m1_s3_vddr_m1_s4_vddr_m1_vddr_vddr3_t2 r0 *1 0,0
Rg_vddr_m1_mnt_g_s1_vddr_m1_s2_vddr_m1_s3_vddr_m1_s4_vddr_m1_vddr_vddr3_t2
+ g_vddr_m1|mnt_g|s1_vddr_m1|s2_vddr_m1|s3_vddr_m1|s4_vddr_m1|vddr|vddr3__t2
+ g_vddr_m1|mnt_g|s1_vddr_m1|s2_vddr_m1|s3_vddr_m1|s4_vddr_m1|vddr|vddr3
+ 542.976631462
* device instance g_vddr_m1_mnt_g_s1_vddr_m1_s2_vddr_m1_s3_vddr_m1_s4_vddr_m1_vddr_vddr3_t3 r0 *1 0,0
Rg_vddr_m1_mnt_g_s1_vddr_m1_s2_vddr_m1_s3_vddr_m1_s4_vddr_m1_vddr_vddr3_t3
+ g_vddr_m1|mnt_g|s1_vddr_m1|s2_vddr_m1|s3_vddr_m1|s4_vddr_m1|vddr|vddr3__t3
+ g_vddr_m1|mnt_g|s1_vddr_m1|s2_vddr_m1|s3_vddr_m1|s4_vddr_m1|vddr|vddr3
+ 248.361456228
* device instance g_vddr_m1_mnt_g_s1_vddr_m1_s2_vddr_m1_s3_vddr_m1_s4_vddr_m1_vddr_vddr3_t4 r0 *1 0,0
Rg_vddr_m1_mnt_g_s1_vddr_m1_s2_vddr_m1_s3_vddr_m1_s4_vddr_m1_vddr_vddr3_t4
+ g_vddr_m1|mnt_g|s1_vddr_m1|s2_vddr_m1|s3_vddr_m1|s4_vddr_m1|vddr|vddr3__t4
+ g_vddr_m1|mnt_g|s1_vddr_m1|s2_vddr_m1|s3_vddr_m1|s4_vddr_m1|vddr|vddr3
+ 26.5619331478
* device instance g_vddr_m1_mnt_g_s1_vddr_m1_s2_vddr_m1_s3_vddr_m1_s4_vddr_m1_vddr_vddr3_t5 r0 *1 0,0
Rg_vddr_m1_mnt_g_s1_vddr_m1_s2_vddr_m1_s3_vddr_m1_s4_vddr_m1_vddr_vddr3_t5
+ g_vddr_m1|mnt_g|s1_vddr_m1|s2_vddr_m1|s3_vddr_m1|s4_vddr_m1|vddr|vddr3__t5
+ g_vddr_m1|mnt_g|s1_vddr_m1|s2_vddr_m1|s3_vddr_m1|s4_vddr_m1|vddr|vddr3
+ 271.46431938
* device instance g_vddr_m1_mnt_g_s1_vddr_m1_s2_vddr_m1_s3_vddr_m1_s4_vddr_m1_vddr_vddr3_t6 r0 *1 0,0
Rg_vddr_m1_mnt_g_s1_vddr_m1_s2_vddr_m1_s3_vddr_m1_s4_vddr_m1_vddr_vddr3_t6
+ g_vddr_m1|mnt_g|s1_vddr_m1|s2_vddr_m1|s3_vddr_m1|s4_vddr_m1|vddr|vddr3__t6
+ g_vddr_m1|mnt_g|s1_vddr_m1|s2_vddr_m1|s3_vddr_m1|s4_vddr_m1|vddr|vddr3
+ 529.759789104
* device instance g_vddr_m1_mnt_g_s1_vddr_m1_s2_vddr_m1_s3_vddr_m1_s4_vddr_m1_vddr_vddr3_t7 r0 *1 0,0
Rg_vddr_m1_mnt_g_s1_vddr_m1_s2_vddr_m1_s3_vddr_m1_s4_vddr_m1_vddr_vddr3_t7
+ g_vddr_m1|mnt_g|s1_vddr_m1|s2_vddr_m1|s3_vddr_m1|s4_vddr_m1|vddr|vddr3__t7
+ g_vddr_m1|mnt_g|s1_vddr_m1|s2_vddr_m1|s3_vddr_m1|s4_vddr_m1|vddr|vddr3
+ 248.361456228
* device instance g_vddr_m1_mnt_g_s1_vddr_m1_s2_vddr_m1_s3_vddr_m1_s4_vddr_m1_vddr_vddr3_t8 r0 *1 0,0
Rg_vddr_m1_mnt_g_s1_vddr_m1_s2_vddr_m1_s3_vddr_m1_s4_vddr_m1_vddr_vddr3_t8
+ g_vddr_m1|mnt_g|s1_vddr_m1|s2_vddr_m1|s3_vddr_m1|s4_vddr_m1|vddr|vddr3__t8
+ g_vddr_m1|mnt_g|s1_vddr_m1|s2_vddr_m1|s3_vddr_m1|s4_vddr_m1|vddr|vddr3
+ 26.5619331478
* device instance g_vddr_m1_mnt_g_s1_vddr_m1_s2_vddr_m1_s3_vddr_m1_s4_vddr_m1_vddr_vddr3_t9 r0 *1 0,0
Rg_vddr_m1_mnt_g_s1_vddr_m1_s2_vddr_m1_s3_vddr_m1_s4_vddr_m1_vddr_vddr3_t9
+ g_vddr_m1|mnt_g|s1_vddr_m1|s2_vddr_m1|s3_vddr_m1|s4_vddr_m1|vddr|vddr3__t9
+ g_vddr_m1|mnt_g|s1_vddr_m1|s2_vddr_m1|s3_vddr_m1|s4_vddr_m1|vddr|vddr3
+ 271.46431938
* device instance g_vddr_m1_mnt_g_s1_vddr_m1_s2_vddr_m1_s3_vddr_m1_s4_vddr_m1_vddr_vddr3_t10 r0 *1 0,0
Rg_vddr_m1_mnt_g_s1_vddr_m1_s2_vddr_m1_s3_vddr_m1_s4_vddr_m1_vddr_vddr3_t10
+ g_vddr_m1|mnt_g|s1_vddr_m1|s2_vddr_m1|s3_vddr_m1|s4_vddr_m1|vddr|vddr3__t10
+ g_vddr_m1|mnt_g|s1_vddr_m1|s2_vddr_m1|s3_vddr_m1|s4_vddr_m1|vddr|vddr3
+ 529.759789104
* device instance g_vddr_m1_mnt_g_s1_vddr_m1_s2_vddr_m1_s3_vddr_m1_s4_vddr_m1_vddr_vddr3_t11 r0 *1 0,0
Rg_vddr_m1_mnt_g_s1_vddr_m1_s2_vddr_m1_s3_vddr_m1_s4_vddr_m1_vddr_vddr3_t11
+ g_vddr_m1|mnt_g|s1_vddr_m1|s2_vddr_m1|s3_vddr_m1|s4_vddr_m1|vddr|vddr3__t11
+ g_vddr_m1|mnt_g|s1_vddr_m1|s2_vddr_m1|s3_vddr_m1|s4_vddr_m1|vddr|vddr3
+ 262.358369105
* device instance g_vddr_m1_mnt_g_s1_vddr_m1_s2_vddr_m1_s3_vddr_m1_s4_vddr_m1_vddr_vddr3_t12 r0 *1 0,0
Rg_vddr_m1_mnt_g_s1_vddr_m1_s2_vddr_m1_s3_vddr_m1_s4_vddr_m1_vddr_vddr3_t12
+ g_vddr_m1|mnt_g|s1_vddr_m1|s2_vddr_m1|s3_vddr_m1|s4_vddr_m1|vddr|vddr3__t12
+ g_vddr_m1|mnt_g|s1_vddr_m1|s2_vddr_m1|s3_vddr_m1|s4_vddr_m1|vddr|vddr3
+ 88.6230059976
* device instance g_vddr_m1_mnt_g_s1_vddr_m1_s2_vddr_m1_s3_vddr_m1_s4_vddr_m1_vddr_vddr3_t13 r0 *1 0,0
Rg_vddr_m1_mnt_g_s1_vddr_m1_s2_vddr_m1_s3_vddr_m1_s4_vddr_m1_vddr_vddr3_t13
+ g_vddr_m1|mnt_g|s1_vddr_m1|s2_vddr_m1|s3_vddr_m1|s4_vddr_m1|vddr|vddr3__t13
+ g_vddr_m1|mnt_g|s1_vddr_m1|s2_vddr_m1|s3_vddr_m1|s4_vddr_m1|vddr|vddr3
+ 284.326181692
* device instance g_vddr_m1_mnt_g_s1_vddr_m1_s2_vddr_m1_s3_vddr_m1_s4_vddr_m1_vddr_vddr3_t14 r0 *1 0,0
Rg_vddr_m1_mnt_g_s1_vddr_m1_s2_vddr_m1_s3_vddr_m1_s4_vddr_m1_vddr_vddr3_t14
+ g_vddr_m1|mnt_g|s1_vddr_m1|s2_vddr_m1|s3_vddr_m1|s4_vddr_m1|vddr|vddr3__t14
+ g_vddr_m1|mnt_g|s1_vddr_m1|s2_vddr_m1|s3_vddr_m1|s4_vddr_m1|vddr|vddr3
+ 536.464290564
* device instance g_vddr_m1_mnt_g_s1_vddr_m1_s2_vddr_m1_s3_vddr_m1_s4_vddr_m1_vddr_vddr3_t15 r0 *1 0,0
Rg_vddr_m1_mnt_g_s1_vddr_m1_s2_vddr_m1_s3_vddr_m1_s4_vddr_m1_vddr_vddr3_t15
+ g_vddr_m1|mnt_g|s1_vddr_m1|s2_vddr_m1|s3_vddr_m1|s4_vddr_m1|vddr|vddr3__t15
+ g_vddr_m1|mnt_g|s1_vddr_m1|s2_vddr_m1|s3_vddr_m1|s4_vddr_m1|vddr|vddr3
+ 598.239135223
* device instance g_vddr_m1_mnt_g_s1_vddr_m1_s2_vddr_m1_s3_vddr_m1_s4_vddr_m1_vddr_vddr3_t16 r0 *1 0,0
Rg_vddr_m1_mnt_g_s1_vddr_m1_s2_vddr_m1_s3_vddr_m1_s4_vddr_m1_vddr_vddr3_t16
+ g_vddr_m1|mnt_g|s1_vddr_m1|s2_vddr_m1|s3_vddr_m1|s4_vddr_m1|vddr|vddr3__t16
+ g_vddr_m1|mnt_g|s1_vddr_m1|s2_vddr_m1|s3_vddr_m1|s4_vddr_m1|vddr|vddr3
+ 339.792959485
* device instance g_vddr_m1_mnt_g_s1_vddr_m1_s2_vddr_m1_s3_vddr_m1_s4_vddr_m1_vddr_vddr3_t17 r0 *1 0,0
Rg_vddr_m1_mnt_g_s1_vddr_m1_s2_vddr_m1_s3_vddr_m1_s4_vddr_m1_vddr_vddr3_t17
+ g_vddr_m1|mnt_g|s1_vddr_m1|s2_vddr_m1|s3_vddr_m1|s4_vddr_m1|vddr|vddr3__t17
+ g_vddr_m1|mnt_g|s1_vddr_m1|s2_vddr_m1|s3_vddr_m1|s4_vddr_m1|vddr|vddr3
+ 83.6281338372
* device instance g_vddr_m1_mnt_g_s1_vddr_m1_s2_vddr_m1_s3_vddr_m1_s4_vddr_m1_vddr_vddr3_t18 r0 *1 0,0
Rg_vddr_m1_mnt_g_s1_vddr_m1_s2_vddr_m1_s3_vddr_m1_s4_vddr_m1_vddr_vddr3_t18
+ g_vddr_m1|mnt_g|s1_vddr_m1|s2_vddr_m1|s3_vddr_m1|s4_vddr_m1|vddr|vddr3__t18
+ g_vddr_m1|mnt_g|s1_vddr_m1|s2_vddr_m1|s3_vddr_m1|s4_vddr_m1|vddr|vddr3
+ 180.258956154
* device instance g_vddr_m1_mnt_g_s1_vddr_m1_s2_vddr_m1_s3_vddr_m1_s4_vddr_m1_vddr_vddr3_t19 r0 *1 0,0
Rg_vddr_m1_mnt_g_s1_vddr_m1_s2_vddr_m1_s3_vddr_m1_s4_vddr_m1_vddr_vddr3_t19
+ g_vddr_m1|mnt_g|s1_vddr_m1|s2_vddr_m1|s3_vddr_m1|s4_vddr_m1|vddr|vddr3__t19
+ g_vddr_m1|mnt_g|s1_vddr_m1|s2_vddr_m1|s3_vddr_m1|s4_vddr_m1|vddr|vddr3
+ 433.933996993
* device instance g_vddr_m1_mnt_g_s1_vddr_m1_s2_vddr_m1_s3_vddr_m1_s4_vddr_m1_vddr_vddr3_t20 r0 *1 0,0
Rg_vddr_m1_mnt_g_s1_vddr_m1_s2_vddr_m1_s3_vddr_m1_s4_vddr_m1_vddr_vddr3_t20
+ g_vddr_m1|mnt_g|s1_vddr_m1|s2_vddr_m1|s3_vddr_m1|s4_vddr_m1|vddr|vddr3__t20
+ g_vddr_m1|mnt_g|s1_vddr_m1|s2_vddr_m1|s3_vddr_m1|s4_vddr_m1|vddr|vddr3
+ 474.629247418
* device instance g_vddr_m1_mnt_g_s1_vddr_m1_s2_vddr_m1_s3_vddr_m1_s4_vddr_m1_vddr_vddr3 r0 *1 0,0
Cg_vddr_m1_mnt_g_s1_vddr_m1_s2_vddr_m1_s3_vddr_m1_s4_vddr_m1_vddr_vddr3
+ g_vddr_m1|mnt_g|s1_vddr_m1|s2_vddr_m1|s3_vddr_m1|s4_vddr_m1|vddr|vddr3 vsubs
+ 1.4778441e-14
* device instance g_vddr_m1_mnt_g_s1_vddr_m1_s2_vddr_m1_s3_vddr_m1_s4_vddr_m1_vddr_vddr4_t0 r0 *1 0,0
Rg_vddr_m1_mnt_g_s1_vddr_m1_s2_vddr_m1_s3_vddr_m1_s4_vddr_m1_vddr_vddr4_t0
+ g_vddr_m1|mnt_g|s1_vddr_m1|s2_vddr_m1|s3_vddr_m1|s4_vddr_m1|vddr|vddr4__t0
+ g_vddr_m1|mnt_g|s1_vddr_m1|s2_vddr_m1|s3_vddr_m1|s4_vddr_m1|vddr|vddr4
+ 548.949174724
* device instance g_vddr_m1_mnt_g_s1_vddr_m1_s2_vddr_m1_s3_vddr_m1_s4_vddr_m1_vddr_vddr4_t1 r0 *1 0,0
Rg_vddr_m1_mnt_g_s1_vddr_m1_s2_vddr_m1_s3_vddr_m1_s4_vddr_m1_vddr_vddr4_t1
+ g_vddr_m1|mnt_g|s1_vddr_m1|s2_vddr_m1|s3_vddr_m1|s4_vddr_m1|vddr|vddr4__t1
+ g_vddr_m1|mnt_g|s1_vddr_m1|s2_vddr_m1|s3_vddr_m1|s4_vddr_m1|vddr|vddr4
+ 543.208193994
* device instance g_vddr_m1_mnt_g_s1_vddr_m1_s2_vddr_m1_s3_vddr_m1_s4_vddr_m1_vddr_vddr4_t2 r0 *1 0,0
Rg_vddr_m1_mnt_g_s1_vddr_m1_s2_vddr_m1_s3_vddr_m1_s4_vddr_m1_vddr_vddr4_t2
+ g_vddr_m1|mnt_g|s1_vddr_m1|s2_vddr_m1|s3_vddr_m1|s4_vddr_m1|vddr|vddr4__t2
+ g_vddr_m1|mnt_g|s1_vddr_m1|s2_vddr_m1|s3_vddr_m1|s4_vddr_m1|vddr|vddr4
+ 543.208193994
* device instance g_vddr_m1_mnt_g_s1_vddr_m1_s2_vddr_m1_s3_vddr_m1_s4_vddr_m1_vddr_vddr4_t3 r0 *1 0,0
Rg_vddr_m1_mnt_g_s1_vddr_m1_s2_vddr_m1_s3_vddr_m1_s4_vddr_m1_vddr_vddr4_t3
+ g_vddr_m1|mnt_g|s1_vddr_m1|s2_vddr_m1|s3_vddr_m1|s4_vddr_m1|vddr|vddr4__t3
+ g_vddr_m1|mnt_g|s1_vddr_m1|s2_vddr_m1|s3_vddr_m1|s4_vddr_m1|vddr|vddr4
+ 26.5732609806
* device instance g_vddr_m1_mnt_g_s1_vddr_m1_s2_vddr_m1_s3_vddr_m1_s4_vddr_m1_vddr_vddr4_t4 r0 *1 0,0
Rg_vddr_m1_mnt_g_s1_vddr_m1_s2_vddr_m1_s3_vddr_m1_s4_vddr_m1_vddr_vddr4_t4
+ g_vddr_m1|mnt_g|s1_vddr_m1|s2_vddr_m1|s3_vddr_m1|s4_vddr_m1|vddr|vddr4__t4
+ g_vddr_m1|mnt_g|s1_vddr_m1|s2_vddr_m1|s3_vddr_m1|s4_vddr_m1|vddr|vddr4
+ 248.467374613
* device instance g_vddr_m1_mnt_g_s1_vddr_m1_s2_vddr_m1_s3_vddr_m1_s4_vddr_m1_vddr_vddr4_t5 r0 *1 0,0
Rg_vddr_m1_mnt_g_s1_vddr_m1_s2_vddr_m1_s3_vddr_m1_s4_vddr_m1_vddr_vddr4_t5
+ g_vddr_m1|mnt_g|s1_vddr_m1|s2_vddr_m1|s3_vddr_m1|s4_vddr_m1|vddr|vddr4__t5
+ g_vddr_m1|mnt_g|s1_vddr_m1|s2_vddr_m1|s3_vddr_m1|s4_vddr_m1|vddr|vddr4
+ 529.985715066
* device instance g_vddr_m1_mnt_g_s1_vddr_m1_s2_vddr_m1_s3_vddr_m1_s4_vddr_m1_vddr_vddr4_t6 r0 *1 0,0
Rg_vddr_m1_mnt_g_s1_vddr_m1_s2_vddr_m1_s3_vddr_m1_s4_vddr_m1_vddr_vddr4_t6
+ g_vddr_m1|mnt_g|s1_vddr_m1|s2_vddr_m1|s3_vddr_m1|s4_vddr_m1|vddr|vddr4__t6
+ g_vddr_m1|mnt_g|s1_vddr_m1|s2_vddr_m1|s3_vddr_m1|s4_vddr_m1|vddr|vddr4
+ 271.580090412
* device instance g_vddr_m1_mnt_g_s1_vddr_m1_s2_vddr_m1_s3_vddr_m1_s4_vddr_m1_vddr_vddr4_t7 r0 *1 0,0
Rg_vddr_m1_mnt_g_s1_vddr_m1_s2_vddr_m1_s3_vddr_m1_s4_vddr_m1_vddr_vddr4_t7
+ g_vddr_m1|mnt_g|s1_vddr_m1|s2_vddr_m1|s3_vddr_m1|s4_vddr_m1|vddr|vddr4__t7
+ g_vddr_m1|mnt_g|s1_vddr_m1|s2_vddr_m1|s3_vddr_m1|s4_vddr_m1|vddr|vddr4
+ 26.5732609806
* device instance g_vddr_m1_mnt_g_s1_vddr_m1_s2_vddr_m1_s3_vddr_m1_s4_vddr_m1_vddr_vddr4_t8 r0 *1 0,0
Rg_vddr_m1_mnt_g_s1_vddr_m1_s2_vddr_m1_s3_vddr_m1_s4_vddr_m1_vddr_vddr4_t8
+ g_vddr_m1|mnt_g|s1_vddr_m1|s2_vddr_m1|s3_vddr_m1|s4_vddr_m1|vddr|vddr4__t8
+ g_vddr_m1|mnt_g|s1_vddr_m1|s2_vddr_m1|s3_vddr_m1|s4_vddr_m1|vddr|vddr4
+ 248.467374613
* device instance g_vddr_m1_mnt_g_s1_vddr_m1_s2_vddr_m1_s3_vddr_m1_s4_vddr_m1_vddr_vddr4_t9 r0 *1 0,0
Rg_vddr_m1_mnt_g_s1_vddr_m1_s2_vddr_m1_s3_vddr_m1_s4_vddr_m1_vddr_vddr4_t9
+ g_vddr_m1|mnt_g|s1_vddr_m1|s2_vddr_m1|s3_vddr_m1|s4_vddr_m1|vddr|vddr4__t9
+ g_vddr_m1|mnt_g|s1_vddr_m1|s2_vddr_m1|s3_vddr_m1|s4_vddr_m1|vddr|vddr4
+ 529.985715066
* device instance g_vddr_m1_mnt_g_s1_vddr_m1_s2_vddr_m1_s3_vddr_m1_s4_vddr_m1_vddr_vddr4_t10 r0 *1 0,0
Rg_vddr_m1_mnt_g_s1_vddr_m1_s2_vddr_m1_s3_vddr_m1_s4_vddr_m1_vddr_vddr4_t10
+ g_vddr_m1|mnt_g|s1_vddr_m1|s2_vddr_m1|s3_vddr_m1|s4_vddr_m1|vddr|vddr4__t10
+ g_vddr_m1|mnt_g|s1_vddr_m1|s2_vddr_m1|s3_vddr_m1|s4_vddr_m1|vddr|vddr4
+ 271.580090412
* device instance g_vddr_m1_mnt_g_s1_vddr_m1_s2_vddr_m1_s3_vddr_m1_s4_vddr_m1_vddr_vddr4_t11 r0 *1 0,0
Rg_vddr_m1_mnt_g_s1_vddr_m1_s2_vddr_m1_s3_vddr_m1_s4_vddr_m1_vddr_vddr4_t11
+ g_vddr_m1|mnt_g|s1_vddr_m1|s2_vddr_m1|s3_vddr_m1|s4_vddr_m1|vddr|vddr4__t11
+ g_vddr_m1|mnt_g|s1_vddr_m1|s2_vddr_m1|s3_vddr_m1|s4_vddr_m1|vddr|vddr4
+ 536.693075787
* device instance g_vddr_m1_mnt_g_s1_vddr_m1_s2_vddr_m1_s3_vddr_m1_s4_vddr_m1_vddr_vddr4_t12 r0 *1 0,0
Rg_vddr_m1_mnt_g_s1_vddr_m1_s2_vddr_m1_s3_vddr_m1_s4_vddr_m1_vddr_vddr4_t12
+ g_vddr_m1|mnt_g|s1_vddr_m1|s2_vddr_m1|s3_vddr_m1|s4_vddr_m1|vddr|vddr4__t12
+ g_vddr_m1|mnt_g|s1_vddr_m1|s2_vddr_m1|s3_vddr_m1|s4_vddr_m1|vddr|vddr4
+ 284.447437906
* device instance g_vddr_m1_mnt_g_s1_vddr_m1_s2_vddr_m1_s3_vddr_m1_s4_vddr_m1_vddr_vddr4_t13 r0 *1 0,0
Rg_vddr_m1_mnt_g_s1_vddr_m1_s2_vddr_m1_s3_vddr_m1_s4_vddr_m1_vddr_vddr4_t13
+ g_vddr_m1|mnt_g|s1_vddr_m1|s2_vddr_m1|s3_vddr_m1|s4_vddr_m1|vddr|vddr4__t13
+ g_vddr_m1|mnt_g|s1_vddr_m1|s2_vddr_m1|s3_vddr_m1|s4_vddr_m1|vddr|vddr4
+ 88.6608009347
* device instance g_vddr_m1_mnt_g_s1_vddr_m1_s2_vddr_m1_s3_vddr_m1_s4_vddr_m1_vddr_vddr4_t14 r0 *1 0,0
Rg_vddr_m1_mnt_g_s1_vddr_m1_s2_vddr_m1_s3_vddr_m1_s4_vddr_m1_vddr_vddr4_t14
+ g_vddr_m1|mnt_g|s1_vddr_m1|s2_vddr_m1|s3_vddr_m1|s4_vddr_m1|vddr|vddr4__t14
+ g_vddr_m1|mnt_g|s1_vddr_m1|s2_vddr_m1|s3_vddr_m1|s4_vddr_m1|vddr|vddr4
+ 262.470256734
* device instance g_vddr_m1_mnt_g_s1_vddr_m1_s2_vddr_m1_s3_vddr_m1_s4_vddr_m1_vddr_vddr4_t15 r0 *1 0,0
Rg_vddr_m1_mnt_g_s1_vddr_m1_s2_vddr_m1_s3_vddr_m1_s4_vddr_m1_vddr_vddr4_t15
+ g_vddr_m1|mnt_g|s1_vddr_m1|s2_vddr_m1|s3_vddr_m1|s4_vddr_m1|vddr|vddr4__t15
+ g_vddr_m1|mnt_g|s1_vddr_m1|s2_vddr_m1|s3_vddr_m1|s4_vddr_m1|vddr|vddr4
+ 180.335830955
* device instance g_vddr_m1_mnt_g_s1_vddr_m1_s2_vddr_m1_s3_vddr_m1_s4_vddr_m1_vddr_vddr4_t16 r0 *1 0,0
Rg_vddr_m1_mnt_g_s1_vddr_m1_s2_vddr_m1_s3_vddr_m1_s4_vddr_m1_vddr_vddr4_t16
+ g_vddr_m1|mnt_g|s1_vddr_m1|s2_vddr_m1|s3_vddr_m1|s4_vddr_m1|vddr|vddr4__t16
+ g_vddr_m1|mnt_g|s1_vddr_m1|s2_vddr_m1|s3_vddr_m1|s4_vddr_m1|vddr|vddr4
+ 83.6637986178
* device instance g_vddr_m1_mnt_g_s1_vddr_m1_s2_vddr_m1_s3_vddr_m1_s4_vddr_m1_vddr_vddr4_t17 r0 *1 0,0
Rg_vddr_m1_mnt_g_s1_vddr_m1_s2_vddr_m1_s3_vddr_m1_s4_vddr_m1_vddr_vddr4_t17
+ g_vddr_m1|mnt_g|s1_vddr_m1|s2_vddr_m1|s3_vddr_m1|s4_vddr_m1|vddr|vddr4__t17
+ g_vddr_m1|mnt_g|s1_vddr_m1|s2_vddr_m1|s3_vddr_m1|s4_vddr_m1|vddr|vddr4
+ 434.119056256
* device instance g_vddr_m1_mnt_g_s1_vddr_m1_s2_vddr_m1_s3_vddr_m1_s4_vddr_m1_vddr_vddr4_t18 r0 *1 0,0
Rg_vddr_m1_mnt_g_s1_vddr_m1_s2_vddr_m1_s3_vddr_m1_s4_vddr_m1_vddr_vddr4_t18
+ g_vddr_m1|mnt_g|s1_vddr_m1|s2_vddr_m1|s3_vddr_m1|s4_vddr_m1|vddr|vddr4__t18
+ g_vddr_m1|mnt_g|s1_vddr_m1|s2_vddr_m1|s3_vddr_m1|s4_vddr_m1|vddr|vddr4
+ 474.831661931
* device instance g_vddr_m1_mnt_g_s1_vddr_m1_s2_vddr_m1_s3_vddr_m1_s4_vddr_m1_vddr_vddr4_t19 r0 *1 0,0
Rg_vddr_m1_mnt_g_s1_vddr_m1_s2_vddr_m1_s3_vddr_m1_s4_vddr_m1_vddr_vddr4_t19
+ g_vddr_m1|mnt_g|s1_vddr_m1|s2_vddr_m1|s3_vddr_m1|s4_vddr_m1|vddr|vddr4__t19
+ g_vddr_m1|mnt_g|s1_vddr_m1|s2_vddr_m1|s3_vddr_m1|s4_vddr_m1|vddr|vddr4
+ 598.494265483
* device instance g_vddr_m1_mnt_g_s1_vddr_m1_s2_vddr_m1_s3_vddr_m1_s4_vddr_m1_vddr_vddr4_t20 r0 *1 0,0
Rg_vddr_m1_mnt_g_s1_vddr_m1_s2_vddr_m1_s3_vddr_m1_s4_vddr_m1_vddr_vddr4_t20
+ g_vddr_m1|mnt_g|s1_vddr_m1|s2_vddr_m1|s3_vddr_m1|s4_vddr_m1|vddr|vddr4__t20
+ g_vddr_m1|mnt_g|s1_vddr_m1|s2_vddr_m1|s3_vddr_m1|s4_vddr_m1|vddr|vddr4
+ 339.937870542
* device instance g_vddr_m1_mnt_g_s1_vddr_m1_s2_vddr_m1_s3_vddr_m1_s4_vddr_m1_vddr_vddr4 r0 *1 0,0
Cg_vddr_m1_mnt_g_s1_vddr_m1_s2_vddr_m1_s3_vddr_m1_s4_vddr_m1_vddr_vddr4
+ g_vddr_m1|mnt_g|s1_vddr_m1|s2_vddr_m1|s3_vddr_m1|s4_vddr_m1|vddr|vddr4 vsubs
+ 1.4783725e-14
* device instance g_vss_m1_inv_clk_vss_inv_mc_vss_inv_q_vss_mph_g_nand_m_vss_nand_s2_vss_s1_vss_m1_s2_vss_m1_s3_vss_m1_s4_vss_m1_sb_vss_sr1_vss_sr2_vss_sr3_vss_sr4_vss_sv_vss_tg_d_vss_tg_fbm_vss_tg_fbs_vss_tg_s_vss_vss_vss_link_vss_link_bridge_vss_link_dip_vss_link_m1_vss_x1_vss_x2_vss_x3_t0 r0 *1 0,0
Rg_vss_m1_inv_clk_vss_inv_mc_vss_inv_q_vss_mph_g_nand_m_vss_nand_s2_vss_s1_vss_m1_s2_vss_m1_s3_vss_m1_s4_vss_m1_sb_vss_sr1_vss_sr2_vss_sr3_vss_sr4_vss_sv_vss_tg_d_vss_tg_fbm_vss_tg_fbs_vss_tg_s_vss_vss_vss_link_vss_link_bridge_vss_link_dip_vss_link_m1_vss_x1_vss_x2_vss_x3_t0
+ g_vss_m1|inv_clk_vss|inv_mc_vss|inv_q_vss|mph_g|nand_m_vss|nand_s2_vss|s1_vss_m1|s2_vss_m1|s3_vss_m1|s4_vss_m1|sb_vss|sr1_vss|sr2_vss|sr3_vss|sr4_vss|sv_vss|tg_d_vss|tg_fbm_vss|tg_fbs_vss|tg_s_vss|vss|vss_link|vss_link_bridge|vss_link_dip|vss_link_m1|vss_x1|vss_x2|vss_x3__t0
+ g_vss_m1|inv_clk_vss|inv_mc_vss|inv_q_vss|mph_g|nand_m_vss|nand_s2_vss|s1_vss_m1|s2_vss_m1|s3_vss_m1|s4_vss_m1|sb_vss|sr1_vss|sr2_vss|sr3_vss|sr4_vss|sv_vss|tg_d_vss|tg_fbm_vss|tg_fbs_vss|tg_s_vss|vss|vss_link|vss_link_bridge|vss_link_dip|vss_link_m1|vss_x1|vss_x2|vss_x3
+ 307.732923931
* device instance g_vss_m1_inv_clk_vss_inv_mc_vss_inv_q_vss_mph_g_nand_m_vss_nand_s2_vss_s1_vss_m1_s2_vss_m1_s3_vss_m1_s4_vss_m1_sb_vss_sr1_vss_sr2_vss_sr3_vss_sr4_vss_sv_vss_tg_d_vss_tg_fbm_vss_tg_fbs_vss_tg_s_vss_vss_vss_link_vss_link_bridge_vss_link_dip_vss_link_m1_vss_x1_vss_x2_vss_x3_t1 r0 *1 0,0
Rg_vss_m1_inv_clk_vss_inv_mc_vss_inv_q_vss_mph_g_nand_m_vss_nand_s2_vss_s1_vss_m1_s2_vss_m1_s3_vss_m1_s4_vss_m1_sb_vss_sr1_vss_sr2_vss_sr3_vss_sr4_vss_sv_vss_tg_d_vss_tg_fbm_vss_tg_fbs_vss_tg_s_vss_vss_vss_link_vss_link_bridge_vss_link_dip_vss_link_m1_vss_x1_vss_x2_vss_x3_t1
+ g_vss_m1|inv_clk_vss|inv_mc_vss|inv_q_vss|mph_g|nand_m_vss|nand_s2_vss|s1_vss_m1|s2_vss_m1|s3_vss_m1|s4_vss_m1|sb_vss|sr1_vss|sr2_vss|sr3_vss|sr4_vss|sv_vss|tg_d_vss|tg_fbm_vss|tg_fbs_vss|tg_s_vss|vss|vss_link|vss_link_bridge|vss_link_dip|vss_link_m1|vss_x1|vss_x2|vss_x3__t1
+ g_vss_m1|inv_clk_vss|inv_mc_vss|inv_q_vss|mph_g|nand_m_vss|nand_s2_vss|s1_vss_m1|s2_vss_m1|s3_vss_m1|s4_vss_m1|sb_vss|sr1_vss|sr2_vss|sr3_vss|sr4_vss|sv_vss|tg_d_vss|tg_fbm_vss|tg_fbs_vss|tg_s_vss|vss|vss_link|vss_link_bridge|vss_link_dip|vss_link_m1|vss_x1|vss_x2|vss_x3
+ 340.723725532
* device instance g_vss_m1_inv_clk_vss_inv_mc_vss_inv_q_vss_mph_g_nand_m_vss_nand_s2_vss_s1_vss_m1_s2_vss_m1_s3_vss_m1_s4_vss_m1_sb_vss_sr1_vss_sr2_vss_sr3_vss_sr4_vss_sv_vss_tg_d_vss_tg_fbm_vss_tg_fbs_vss_tg_s_vss_vss_vss_link_vss_link_bridge_vss_link_dip_vss_link_m1_vss_x1_vss_x2_vss_x3_t2 r0 *1 0,0
Rg_vss_m1_inv_clk_vss_inv_mc_vss_inv_q_vss_mph_g_nand_m_vss_nand_s2_vss_s1_vss_m1_s2_vss_m1_s3_vss_m1_s4_vss_m1_sb_vss_sr1_vss_sr2_vss_sr3_vss_sr4_vss_sv_vss_tg_d_vss_tg_fbm_vss_tg_fbs_vss_tg_s_vss_vss_vss_link_vss_link_bridge_vss_link_dip_vss_link_m1_vss_x1_vss_x2_vss_x3_t2
+ g_vss_m1|inv_clk_vss|inv_mc_vss|inv_q_vss|mph_g|nand_m_vss|nand_s2_vss|s1_vss_m1|s2_vss_m1|s3_vss_m1|s4_vss_m1|sb_vss|sr1_vss|sr2_vss|sr3_vss|sr4_vss|sv_vss|tg_d_vss|tg_fbm_vss|tg_fbs_vss|tg_s_vss|vss|vss_link|vss_link_bridge|vss_link_dip|vss_link_m1|vss_x1|vss_x2|vss_x3__t2
+ g_vss_m1|inv_clk_vss|inv_mc_vss|inv_q_vss|mph_g|nand_m_vss|nand_s2_vss|s1_vss_m1|s2_vss_m1|s3_vss_m1|s4_vss_m1|sb_vss|sr1_vss|sr2_vss|sr3_vss|sr4_vss|sv_vss|tg_d_vss|tg_fbm_vss|tg_fbs_vss|tg_s_vss|vss|vss_link|vss_link_bridge|vss_link_dip|vss_link_m1|vss_x1|vss_x2|vss_x3
+ 330.123479448
* device instance g_vss_m1_inv_clk_vss_inv_mc_vss_inv_q_vss_mph_g_nand_m_vss_nand_s2_vss_s1_vss_m1_s2_vss_m1_s3_vss_m1_s4_vss_m1_sb_vss_sr1_vss_sr2_vss_sr3_vss_sr4_vss_sv_vss_tg_d_vss_tg_fbm_vss_tg_fbs_vss_tg_s_vss_vss_vss_link_vss_link_bridge_vss_link_dip_vss_link_m1_vss_x1_vss_x2_vss_x3_t3 r0 *1 0,0
Rg_vss_m1_inv_clk_vss_inv_mc_vss_inv_q_vss_mph_g_nand_m_vss_nand_s2_vss_s1_vss_m1_s2_vss_m1_s3_vss_m1_s4_vss_m1_sb_vss_sr1_vss_sr2_vss_sr3_vss_sr4_vss_sv_vss_tg_d_vss_tg_fbm_vss_tg_fbs_vss_tg_s_vss_vss_vss_link_vss_link_bridge_vss_link_dip_vss_link_m1_vss_x1_vss_x2_vss_x3_t3
+ g_vss_m1|inv_clk_vss|inv_mc_vss|inv_q_vss|mph_g|nand_m_vss|nand_s2_vss|s1_vss_m1|s2_vss_m1|s3_vss_m1|s4_vss_m1|sb_vss|sr1_vss|sr2_vss|sr3_vss|sr4_vss|sv_vss|tg_d_vss|tg_fbm_vss|tg_fbs_vss|tg_s_vss|vss|vss_link|vss_link_bridge|vss_link_dip|vss_link_m1|vss_x1|vss_x2|vss_x3__t3
+ g_vss_m1|inv_clk_vss|inv_mc_vss|inv_q_vss|mph_g|nand_m_vss|nand_s2_vss|s1_vss_m1|s2_vss_m1|s3_vss_m1|s4_vss_m1|sb_vss|sr1_vss|sr2_vss|sr3_vss|sr4_vss|sv_vss|tg_d_vss|tg_fbm_vss|tg_fbs_vss|tg_s_vss|vss|vss_link|vss_link_bridge|vss_link_dip|vss_link_m1|vss_x1|vss_x2|vss_x3
+ 177.55440599
* device instance g_vss_m1_inv_clk_vss_inv_mc_vss_inv_q_vss_mph_g_nand_m_vss_nand_s2_vss_s1_vss_m1_s2_vss_m1_s3_vss_m1_s4_vss_m1_sb_vss_sr1_vss_sr2_vss_sr3_vss_sr4_vss_sv_vss_tg_d_vss_tg_fbm_vss_tg_fbs_vss_tg_s_vss_vss_vss_link_vss_link_bridge_vss_link_dip_vss_link_m1_vss_x1_vss_x2_vss_x3_t4 r0 *1 0,0
Rg_vss_m1_inv_clk_vss_inv_mc_vss_inv_q_vss_mph_g_nand_m_vss_nand_s2_vss_s1_vss_m1_s2_vss_m1_s3_vss_m1_s4_vss_m1_sb_vss_sr1_vss_sr2_vss_sr3_vss_sr4_vss_sv_vss_tg_d_vss_tg_fbm_vss_tg_fbs_vss_tg_s_vss_vss_vss_link_vss_link_bridge_vss_link_dip_vss_link_m1_vss_x1_vss_x2_vss_x3_t4
+ g_vss_m1|inv_clk_vss|inv_mc_vss|inv_q_vss|mph_g|nand_m_vss|nand_s2_vss|s1_vss_m1|s2_vss_m1|s3_vss_m1|s4_vss_m1|sb_vss|sr1_vss|sr2_vss|sr3_vss|sr4_vss|sv_vss|tg_d_vss|tg_fbm_vss|tg_fbs_vss|tg_s_vss|vss|vss_link|vss_link_bridge|vss_link_dip|vss_link_m1|vss_x1|vss_x2|vss_x3__t4
+ g_vss_m1|inv_clk_vss|inv_mc_vss|inv_q_vss|mph_g|nand_m_vss|nand_s2_vss|s1_vss_m1|s2_vss_m1|s3_vss_m1|s4_vss_m1|sb_vss|sr1_vss|sr2_vss|sr3_vss|sr4_vss|sv_vss|tg_d_vss|tg_fbm_vss|tg_fbs_vss|tg_s_vss|vss|vss_link|vss_link_bridge|vss_link_dip|vss_link_m1|vss_x1|vss_x2|vss_x3
+ 31.6462135368
* device instance g_vss_m1_inv_clk_vss_inv_mc_vss_inv_q_vss_mph_g_nand_m_vss_nand_s2_vss_s1_vss_m1_s2_vss_m1_s3_vss_m1_s4_vss_m1_sb_vss_sr1_vss_sr2_vss_sr3_vss_sr4_vss_sv_vss_tg_d_vss_tg_fbm_vss_tg_fbs_vss_tg_s_vss_vss_vss_link_vss_link_bridge_vss_link_dip_vss_link_m1_vss_x1_vss_x2_vss_x3_t5 r0 *1 0,0
Rg_vss_m1_inv_clk_vss_inv_mc_vss_inv_q_vss_mph_g_nand_m_vss_nand_s2_vss_s1_vss_m1_s2_vss_m1_s3_vss_m1_s4_vss_m1_sb_vss_sr1_vss_sr2_vss_sr3_vss_sr4_vss_sv_vss_tg_d_vss_tg_fbm_vss_tg_fbs_vss_tg_s_vss_vss_vss_link_vss_link_bridge_vss_link_dip_vss_link_m1_vss_x1_vss_x2_vss_x3_t5
+ g_vss_m1|inv_clk_vss|inv_mc_vss|inv_q_vss|mph_g|nand_m_vss|nand_s2_vss|s1_vss_m1|s2_vss_m1|s3_vss_m1|s4_vss_m1|sb_vss|sr1_vss|sr2_vss|sr3_vss|sr4_vss|sv_vss|tg_d_vss|tg_fbm_vss|tg_fbs_vss|tg_s_vss|vss|vss_link|vss_link_bridge|vss_link_dip|vss_link_m1|vss_x1|vss_x2|vss_x3__t5
+ g_vss_m1|inv_clk_vss|inv_mc_vss|inv_q_vss|mph_g|nand_m_vss|nand_s2_vss|s1_vss_m1|s2_vss_m1|s3_vss_m1|s4_vss_m1|sb_vss|sr1_vss|sr2_vss|sr3_vss|sr4_vss|sv_vss|tg_d_vss|tg_fbm_vss|tg_fbs_vss|tg_s_vss|vss|vss_link|vss_link_bridge|vss_link_dip|vss_link_m1|vss_x1|vss_x2|vss_x3
+ 131.944150749
* device instance g_vss_m1_inv_clk_vss_inv_mc_vss_inv_q_vss_mph_g_nand_m_vss_nand_s2_vss_s1_vss_m1_s2_vss_m1_s3_vss_m1_s4_vss_m1_sb_vss_sr1_vss_sr2_vss_sr3_vss_sr4_vss_sv_vss_tg_d_vss_tg_fbm_vss_tg_fbs_vss_tg_s_vss_vss_vss_link_vss_link_bridge_vss_link_dip_vss_link_m1_vss_x1_vss_x2_vss_x3_t6 r0 *1 0,0
Rg_vss_m1_inv_clk_vss_inv_mc_vss_inv_q_vss_mph_g_nand_m_vss_nand_s2_vss_s1_vss_m1_s2_vss_m1_s3_vss_m1_s4_vss_m1_sb_vss_sr1_vss_sr2_vss_sr3_vss_sr4_vss_sv_vss_tg_d_vss_tg_fbm_vss_tg_fbs_vss_tg_s_vss_vss_vss_link_vss_link_bridge_vss_link_dip_vss_link_m1_vss_x1_vss_x2_vss_x3_t6
+ g_vss_m1|inv_clk_vss|inv_mc_vss|inv_q_vss|mph_g|nand_m_vss|nand_s2_vss|s1_vss_m1|s2_vss_m1|s3_vss_m1|s4_vss_m1|sb_vss|sr1_vss|sr2_vss|sr3_vss|sr4_vss|sv_vss|tg_d_vss|tg_fbm_vss|tg_fbs_vss|tg_s_vss|vss|vss_link|vss_link_bridge|vss_link_dip|vss_link_m1|vss_x1|vss_x2|vss_x3__t6
+ g_vss_m1|inv_clk_vss|inv_mc_vss|inv_q_vss|mph_g|nand_m_vss|nand_s2_vss|s1_vss_m1|s2_vss_m1|s3_vss_m1|s4_vss_m1|sb_vss|sr1_vss|sr2_vss|sr3_vss|sr4_vss|sv_vss|tg_d_vss|tg_fbm_vss|tg_fbs_vss|tg_s_vss|vss|vss_link|vss_link_bridge|vss_link_dip|vss_link_m1|vss_x1|vss_x2|vss_x3
+ 331.030916868
* device instance g_vss_m1_inv_clk_vss_inv_mc_vss_inv_q_vss_mph_g_nand_m_vss_nand_s2_vss_s1_vss_m1_s2_vss_m1_s3_vss_m1_s4_vss_m1_sb_vss_sr1_vss_sr2_vss_sr3_vss_sr4_vss_sv_vss_tg_d_vss_tg_fbm_vss_tg_fbs_vss_tg_s_vss_vss_vss_link_vss_link_bridge_vss_link_dip_vss_link_m1_vss_x1_vss_x2_vss_x3_t7 r0 *1 0,0
Rg_vss_m1_inv_clk_vss_inv_mc_vss_inv_q_vss_mph_g_nand_m_vss_nand_s2_vss_s1_vss_m1_s2_vss_m1_s3_vss_m1_s4_vss_m1_sb_vss_sr1_vss_sr2_vss_sr3_vss_sr4_vss_sv_vss_tg_d_vss_tg_fbm_vss_tg_fbs_vss_tg_s_vss_vss_vss_link_vss_link_bridge_vss_link_dip_vss_link_m1_vss_x1_vss_x2_vss_x3_t7
+ g_vss_m1|inv_clk_vss|inv_mc_vss|inv_q_vss|mph_g|nand_m_vss|nand_s2_vss|s1_vss_m1|s2_vss_m1|s3_vss_m1|s4_vss_m1|sb_vss|sr1_vss|sr2_vss|sr3_vss|sr4_vss|sv_vss|tg_d_vss|tg_fbm_vss|tg_fbs_vss|tg_s_vss|vss|vss_link|vss_link_bridge|vss_link_dip|vss_link_m1|vss_x1|vss_x2|vss_x3__t7
+ g_vss_m1|inv_clk_vss|inv_mc_vss|inv_q_vss|mph_g|nand_m_vss|nand_s2_vss|s1_vss_m1|s2_vss_m1|s3_vss_m1|s4_vss_m1|sb_vss|sr1_vss|sr2_vss|sr3_vss|sr4_vss|sv_vss|tg_d_vss|tg_fbm_vss|tg_fbs_vss|tg_s_vss|vss|vss_link|vss_link_bridge|vss_link_dip|vss_link_m1|vss_x1|vss_x2|vss_x3
+ 179.235943175
* device instance g_vss_m1_inv_clk_vss_inv_mc_vss_inv_q_vss_mph_g_nand_m_vss_nand_s2_vss_s1_vss_m1_s2_vss_m1_s3_vss_m1_s4_vss_m1_sb_vss_sr1_vss_sr2_vss_sr3_vss_sr4_vss_sv_vss_tg_d_vss_tg_fbm_vss_tg_fbs_vss_tg_s_vss_vss_vss_link_vss_link_bridge_vss_link_dip_vss_link_m1_vss_x1_vss_x2_vss_x3_t8 r0 *1 0,0
Rg_vss_m1_inv_clk_vss_inv_mc_vss_inv_q_vss_mph_g_nand_m_vss_nand_s2_vss_s1_vss_m1_s2_vss_m1_s3_vss_m1_s4_vss_m1_sb_vss_sr1_vss_sr2_vss_sr3_vss_sr4_vss_sv_vss_tg_d_vss_tg_fbm_vss_tg_fbs_vss_tg_s_vss_vss_vss_link_vss_link_bridge_vss_link_dip_vss_link_m1_vss_x1_vss_x2_vss_x3_t8
+ g_vss_m1|inv_clk_vss|inv_mc_vss|inv_q_vss|mph_g|nand_m_vss|nand_s2_vss|s1_vss_m1|s2_vss_m1|s3_vss_m1|s4_vss_m1|sb_vss|sr1_vss|sr2_vss|sr3_vss|sr4_vss|sv_vss|tg_d_vss|tg_fbm_vss|tg_fbs_vss|tg_s_vss|vss|vss_link|vss_link_bridge|vss_link_dip|vss_link_m1|vss_x1|vss_x2|vss_x3__t8
+ g_vss_m1|inv_clk_vss|inv_mc_vss|inv_q_vss|mph_g|nand_m_vss|nand_s2_vss|s1_vss_m1|s2_vss_m1|s3_vss_m1|s4_vss_m1|sb_vss|sr1_vss|sr2_vss|sr3_vss|sr4_vss|sv_vss|tg_d_vss|tg_fbm_vss|tg_fbs_vss|tg_s_vss|vss|vss_link|vss_link_bridge|vss_link_dip|vss_link_m1|vss_x1|vss_x2|vss_x3
+ 40.0179843408
* device instance g_vss_m1_inv_clk_vss_inv_mc_vss_inv_q_vss_mph_g_nand_m_vss_nand_s2_vss_s1_vss_m1_s2_vss_m1_s3_vss_m1_s4_vss_m1_sb_vss_sr1_vss_sr2_vss_sr3_vss_sr4_vss_sv_vss_tg_d_vss_tg_fbm_vss_tg_fbs_vss_tg_s_vss_vss_vss_link_vss_link_bridge_vss_link_dip_vss_link_m1_vss_x1_vss_x2_vss_x3_t9 r0 *1 0,0
Rg_vss_m1_inv_clk_vss_inv_mc_vss_inv_q_vss_mph_g_nand_m_vss_nand_s2_vss_s1_vss_m1_s2_vss_m1_s3_vss_m1_s4_vss_m1_sb_vss_sr1_vss_sr2_vss_sr3_vss_sr4_vss_sv_vss_tg_d_vss_tg_fbm_vss_tg_fbs_vss_tg_s_vss_vss_vss_link_vss_link_bridge_vss_link_dip_vss_link_m1_vss_x1_vss_x2_vss_x3_t9
+ g_vss_m1|inv_clk_vss|inv_mc_vss|inv_q_vss|mph_g|nand_m_vss|nand_s2_vss|s1_vss_m1|s2_vss_m1|s3_vss_m1|s4_vss_m1|sb_vss|sr1_vss|sr2_vss|sr3_vss|sr4_vss|sv_vss|tg_d_vss|tg_fbm_vss|tg_fbs_vss|tg_s_vss|vss|vss_link|vss_link_bridge|vss_link_dip|vss_link_m1|vss_x1|vss_x2|vss_x3__t9
+ g_vss_m1|inv_clk_vss|inv_mc_vss|inv_q_vss|mph_g|nand_m_vss|nand_s2_vss|s1_vss_m1|s2_vss_m1|s3_vss_m1|s4_vss_m1|sb_vss|sr1_vss|sr2_vss|sr3_vss|sr4_vss|sv_vss|tg_d_vss|tg_fbm_vss|tg_fbs_vss|tg_s_vss|vss|vss_link|vss_link_bridge|vss_link_dip|vss_link_m1|vss_x1|vss_x2|vss_x3
+ 134.198417116
* device instance g_vss_m1_inv_clk_vss_inv_mc_vss_inv_q_vss_mph_g_nand_m_vss_nand_s2_vss_s1_vss_m1_s2_vss_m1_s3_vss_m1_s4_vss_m1_sb_vss_sr1_vss_sr2_vss_sr3_vss_sr4_vss_sv_vss_tg_d_vss_tg_fbm_vss_tg_fbs_vss_tg_s_vss_vss_vss_link_vss_link_bridge_vss_link_dip_vss_link_m1_vss_x1_vss_x2_vss_x3_t10 r0 *1 0,0
Rg_vss_m1_inv_clk_vss_inv_mc_vss_inv_q_vss_mph_g_nand_m_vss_nand_s2_vss_s1_vss_m1_s2_vss_m1_s3_vss_m1_s4_vss_m1_sb_vss_sr1_vss_sr2_vss_sr3_vss_sr4_vss_sv_vss_tg_d_vss_tg_fbm_vss_tg_fbs_vss_tg_s_vss_vss_vss_link_vss_link_bridge_vss_link_dip_vss_link_m1_vss_x1_vss_x2_vss_x3_t10
+ g_vss_m1|inv_clk_vss|inv_mc_vss|inv_q_vss|mph_g|nand_m_vss|nand_s2_vss|s1_vss_m1|s2_vss_m1|s3_vss_m1|s4_vss_m1|sb_vss|sr1_vss|sr2_vss|sr3_vss|sr4_vss|sv_vss|tg_d_vss|tg_fbm_vss|tg_fbs_vss|tg_s_vss|vss|vss_link|vss_link_bridge|vss_link_dip|vss_link_m1|vss_x1|vss_x2|vss_x3__t10
+ g_vss_m1|inv_clk_vss|inv_mc_vss|inv_q_vss|mph_g|nand_m_vss|nand_s2_vss|s1_vss_m1|s2_vss_m1|s3_vss_m1|s4_vss_m1|sb_vss|sr1_vss|sr2_vss|sr3_vss|sr4_vss|sv_vss|tg_d_vss|tg_fbm_vss|tg_fbs_vss|tg_s_vss|vss|vss_link|vss_link_bridge|vss_link_dip|vss_link_m1|vss_x1|vss_x2|vss_x3
+ 181.308286261
* device instance g_vss_m1_inv_clk_vss_inv_mc_vss_inv_q_vss_mph_g_nand_m_vss_nand_s2_vss_s1_vss_m1_s2_vss_m1_s3_vss_m1_s4_vss_m1_sb_vss_sr1_vss_sr2_vss_sr3_vss_sr4_vss_sv_vss_tg_d_vss_tg_fbm_vss_tg_fbs_vss_tg_s_vss_vss_vss_link_vss_link_bridge_vss_link_dip_vss_link_m1_vss_x1_vss_x2_vss_x3_t11 r0 *1 0,0
Rg_vss_m1_inv_clk_vss_inv_mc_vss_inv_q_vss_mph_g_nand_m_vss_nand_s2_vss_s1_vss_m1_s2_vss_m1_s3_vss_m1_s4_vss_m1_sb_vss_sr1_vss_sr2_vss_sr3_vss_sr4_vss_sv_vss_tg_d_vss_tg_fbm_vss_tg_fbs_vss_tg_s_vss_vss_vss_link_vss_link_bridge_vss_link_dip_vss_link_m1_vss_x1_vss_x2_vss_x3_t11
+ g_vss_m1|inv_clk_vss|inv_mc_vss|inv_q_vss|mph_g|nand_m_vss|nand_s2_vss|s1_vss_m1|s2_vss_m1|s3_vss_m1|s4_vss_m1|sb_vss|sr1_vss|sr2_vss|sr3_vss|sr4_vss|sv_vss|tg_d_vss|tg_fbm_vss|tg_fbs_vss|tg_s_vss|vss|vss_link|vss_link_bridge|vss_link_dip|vss_link_m1|vss_x1|vss_x2|vss_x3__t11
+ g_vss_m1|inv_clk_vss|inv_mc_vss|inv_q_vss|mph_g|nand_m_vss|nand_s2_vss|s1_vss_m1|s2_vss_m1|s3_vss_m1|s4_vss_m1|sb_vss|sr1_vss|sr2_vss|sr3_vss|sr4_vss|sv_vss|tg_d_vss|tg_fbm_vss|tg_fbs_vss|tg_s_vss|vss|vss_link|vss_link_bridge|vss_link_dip|vss_link_m1|vss_x1|vss_x2|vss_x3
+ 159.055236498
* device instance g_vss_m1_inv_clk_vss_inv_mc_vss_inv_q_vss_mph_g_nand_m_vss_nand_s2_vss_s1_vss_m1_s2_vss_m1_s3_vss_m1_s4_vss_m1_sb_vss_sr1_vss_sr2_vss_sr3_vss_sr4_vss_sv_vss_tg_d_vss_tg_fbm_vss_tg_fbs_vss_tg_s_vss_vss_vss_link_vss_link_bridge_vss_link_dip_vss_link_m1_vss_x1_vss_x2_vss_x3_t12 r0 *1 0,0
Rg_vss_m1_inv_clk_vss_inv_mc_vss_inv_q_vss_mph_g_nand_m_vss_nand_s2_vss_s1_vss_m1_s2_vss_m1_s3_vss_m1_s4_vss_m1_sb_vss_sr1_vss_sr2_vss_sr3_vss_sr4_vss_sv_vss_tg_d_vss_tg_fbm_vss_tg_fbs_vss_tg_s_vss_vss_vss_link_vss_link_bridge_vss_link_dip_vss_link_m1_vss_x1_vss_x2_vss_x3_t12
+ g_vss_m1|inv_clk_vss|inv_mc_vss|inv_q_vss|mph_g|nand_m_vss|nand_s2_vss|s1_vss_m1|s2_vss_m1|s3_vss_m1|s4_vss_m1|sb_vss|sr1_vss|sr2_vss|sr3_vss|sr4_vss|sv_vss|tg_d_vss|tg_fbm_vss|tg_fbs_vss|tg_s_vss|vss|vss_link|vss_link_bridge|vss_link_dip|vss_link_m1|vss_x1|vss_x2|vss_x3__t12
+ g_vss_m1|inv_clk_vss|inv_mc_vss|inv_q_vss|mph_g|nand_m_vss|nand_s2_vss|s1_vss_m1|s2_vss_m1|s3_vss_m1|s4_vss_m1|sb_vss|sr1_vss|sr2_vss|sr3_vss|sr4_vss|sv_vss|tg_d_vss|tg_fbm_vss|tg_fbs_vss|tg_s_vss|vss|vss_link|vss_link_bridge|vss_link_dip|vss_link_m1|vss_x1|vss_x2|vss_x3
+ 226.048344123
* device instance g_vss_m1_inv_clk_vss_inv_mc_vss_inv_q_vss_mph_g_nand_m_vss_nand_s2_vss_s1_vss_m1_s2_vss_m1_s3_vss_m1_s4_vss_m1_sb_vss_sr1_vss_sr2_vss_sr3_vss_sr4_vss_sv_vss_tg_d_vss_tg_fbm_vss_tg_fbs_vss_tg_s_vss_vss_vss_link_vss_link_bridge_vss_link_dip_vss_link_m1_vss_x1_vss_x2_vss_x3_t13 r0 *1 0,0
Rg_vss_m1_inv_clk_vss_inv_mc_vss_inv_q_vss_mph_g_nand_m_vss_nand_s2_vss_s1_vss_m1_s2_vss_m1_s3_vss_m1_s4_vss_m1_sb_vss_sr1_vss_sr2_vss_sr3_vss_sr4_vss_sv_vss_tg_d_vss_tg_fbm_vss_tg_fbs_vss_tg_s_vss_vss_vss_link_vss_link_bridge_vss_link_dip_vss_link_m1_vss_x1_vss_x2_vss_x3_t13
+ g_vss_m1|inv_clk_vss|inv_mc_vss|inv_q_vss|mph_g|nand_m_vss|nand_s2_vss|s1_vss_m1|s2_vss_m1|s3_vss_m1|s4_vss_m1|sb_vss|sr1_vss|sr2_vss|sr3_vss|sr4_vss|sv_vss|tg_d_vss|tg_fbm_vss|tg_fbs_vss|tg_s_vss|vss|vss_link|vss_link_bridge|vss_link_dip|vss_link_m1|vss_x1|vss_x2|vss_x3__t13
+ g_vss_m1|inv_clk_vss|inv_mc_vss|inv_q_vss|mph_g|nand_m_vss|nand_s2_vss|s1_vss_m1|s2_vss_m1|s3_vss_m1|s4_vss_m1|sb_vss|sr1_vss|sr2_vss|sr3_vss|sr4_vss|sv_vss|tg_d_vss|tg_fbm_vss|tg_fbs_vss|tg_s_vss|vss|vss_link|vss_link_bridge|vss_link_dip|vss_link_m1|vss_x1|vss_x2|vss_x3
+ 203.647873894
* device instance g_vss_m1_inv_clk_vss_inv_mc_vss_inv_q_vss_mph_g_nand_m_vss_nand_s2_vss_s1_vss_m1_s2_vss_m1_s3_vss_m1_s4_vss_m1_sb_vss_sr1_vss_sr2_vss_sr3_vss_sr4_vss_sv_vss_tg_d_vss_tg_fbm_vss_tg_fbs_vss_tg_s_vss_vss_vss_link_vss_link_bridge_vss_link_dip_vss_link_m1_vss_x1_vss_x2_vss_x3_t14 r0 *1 0,0
Rg_vss_m1_inv_clk_vss_inv_mc_vss_inv_q_vss_mph_g_nand_m_vss_nand_s2_vss_s1_vss_m1_s2_vss_m1_s3_vss_m1_s4_vss_m1_sb_vss_sr1_vss_sr2_vss_sr3_vss_sr4_vss_sv_vss_tg_d_vss_tg_fbm_vss_tg_fbs_vss_tg_s_vss_vss_vss_link_vss_link_bridge_vss_link_dip_vss_link_m1_vss_x1_vss_x2_vss_x3_t14
+ g_vss_m1|inv_clk_vss|inv_mc_vss|inv_q_vss|mph_g|nand_m_vss|nand_s2_vss|s1_vss_m1|s2_vss_m1|s3_vss_m1|s4_vss_m1|sb_vss|sr1_vss|sr2_vss|sr3_vss|sr4_vss|sv_vss|tg_d_vss|tg_fbm_vss|tg_fbs_vss|tg_s_vss|vss|vss_link|vss_link_bridge|vss_link_dip|vss_link_m1|vss_x1|vss_x2|vss_x3__t14
+ g_vss_m1|inv_clk_vss|inv_mc_vss|inv_q_vss|mph_g|nand_m_vss|nand_s2_vss|s1_vss_m1|s2_vss_m1|s3_vss_m1|s4_vss_m1|sb_vss|sr1_vss|sr2_vss|sr3_vss|sr4_vss|sv_vss|tg_d_vss|tg_fbm_vss|tg_fbs_vss|tg_s_vss|vss|vss_link|vss_link_bridge|vss_link_dip|vss_link_m1|vss_x1|vss_x2|vss_x3
+ 31.592599314
* device instance g_vss_m1_inv_clk_vss_inv_mc_vss_inv_q_vss_mph_g_nand_m_vss_nand_s2_vss_s1_vss_m1_s2_vss_m1_s3_vss_m1_s4_vss_m1_sb_vss_sr1_vss_sr2_vss_sr3_vss_sr4_vss_sv_vss_tg_d_vss_tg_fbm_vss_tg_fbs_vss_tg_s_vss_vss_vss_link_vss_link_bridge_vss_link_dip_vss_link_m1_vss_x1_vss_x2_vss_x3_t15 r0 *1 0,0
Rg_vss_m1_inv_clk_vss_inv_mc_vss_inv_q_vss_mph_g_nand_m_vss_nand_s2_vss_s1_vss_m1_s2_vss_m1_s3_vss_m1_s4_vss_m1_sb_vss_sr1_vss_sr2_vss_sr3_vss_sr4_vss_sv_vss_tg_d_vss_tg_fbm_vss_tg_fbs_vss_tg_s_vss_vss_vss_link_vss_link_bridge_vss_link_dip_vss_link_m1_vss_x1_vss_x2_vss_x3_t15
+ g_vss_m1|inv_clk_vss|inv_mc_vss|inv_q_vss|mph_g|nand_m_vss|nand_s2_vss|s1_vss_m1|s2_vss_m1|s3_vss_m1|s4_vss_m1|sb_vss|sr1_vss|sr2_vss|sr3_vss|sr4_vss|sv_vss|tg_d_vss|tg_fbm_vss|tg_fbs_vss|tg_s_vss|vss|vss_link|vss_link_bridge|vss_link_dip|vss_link_m1|vss_x1|vss_x2|vss_x3__t15
+ g_vss_m1|inv_clk_vss|inv_mc_vss|inv_q_vss|mph_g|nand_m_vss|nand_s2_vss|s1_vss_m1|s2_vss_m1|s3_vss_m1|s4_vss_m1|sb_vss|sr1_vss|sr2_vss|sr3_vss|sr4_vss|sv_vss|tg_d_vss|tg_fbm_vss|tg_fbs_vss|tg_s_vss|vss|vss_link|vss_link_bridge|vss_link_dip|vss_link_m1|vss_x1|vss_x2|vss_x3
+ 40.4262412057
* device instance g_vss_m1_inv_clk_vss_inv_mc_vss_inv_q_vss_mph_g_nand_m_vss_nand_s2_vss_s1_vss_m1_s2_vss_m1_s3_vss_m1_s4_vss_m1_sb_vss_sr1_vss_sr2_vss_sr3_vss_sr4_vss_sv_vss_tg_d_vss_tg_fbm_vss_tg_fbs_vss_tg_s_vss_vss_vss_link_vss_link_bridge_vss_link_dip_vss_link_m1_vss_x1_vss_x2_vss_x3_t16 r0 *1 0,0
Rg_vss_m1_inv_clk_vss_inv_mc_vss_inv_q_vss_mph_g_nand_m_vss_nand_s2_vss_s1_vss_m1_s2_vss_m1_s3_vss_m1_s4_vss_m1_sb_vss_sr1_vss_sr2_vss_sr3_vss_sr4_vss_sv_vss_tg_d_vss_tg_fbm_vss_tg_fbs_vss_tg_s_vss_vss_vss_link_vss_link_bridge_vss_link_dip_vss_link_m1_vss_x1_vss_x2_vss_x3_t16
+ g_vss_m1|inv_clk_vss|inv_mc_vss|inv_q_vss|mph_g|nand_m_vss|nand_s2_vss|s1_vss_m1|s2_vss_m1|s3_vss_m1|s4_vss_m1|sb_vss|sr1_vss|sr2_vss|sr3_vss|sr4_vss|sv_vss|tg_d_vss|tg_fbm_vss|tg_fbs_vss|tg_s_vss|vss|vss_link|vss_link_bridge|vss_link_dip|vss_link_m1|vss_x1|vss_x2|vss_x3__t16
+ g_vss_m1|inv_clk_vss|inv_mc_vss|inv_q_vss|mph_g|nand_m_vss|nand_s2_vss|s1_vss_m1|s2_vss_m1|s3_vss_m1|s4_vss_m1|sb_vss|sr1_vss|sr2_vss|sr3_vss|sr4_vss|sv_vss|tg_d_vss|tg_fbm_vss|tg_fbs_vss|tg_s_vss|vss|vss_link|vss_link_bridge|vss_link_dip|vss_link_m1|vss_x1|vss_x2|vss_x3
+ 57.4117156125
* device instance g_vss_m1_inv_clk_vss_inv_mc_vss_inv_q_vss_mph_g_nand_m_vss_nand_s2_vss_s1_vss_m1_s2_vss_m1_s3_vss_m1_s4_vss_m1_sb_vss_sr1_vss_sr2_vss_sr3_vss_sr4_vss_sv_vss_tg_d_vss_tg_fbm_vss_tg_fbs_vss_tg_s_vss_vss_vss_link_vss_link_bridge_vss_link_dip_vss_link_m1_vss_x1_vss_x2_vss_x3_t17 r0 *1 0,0
Rg_vss_m1_inv_clk_vss_inv_mc_vss_inv_q_vss_mph_g_nand_m_vss_nand_s2_vss_s1_vss_m1_s2_vss_m1_s3_vss_m1_s4_vss_m1_sb_vss_sr1_vss_sr2_vss_sr3_vss_sr4_vss_sv_vss_tg_d_vss_tg_fbm_vss_tg_fbs_vss_tg_s_vss_vss_vss_link_vss_link_bridge_vss_link_dip_vss_link_m1_vss_x1_vss_x2_vss_x3_t17
+ g_vss_m1|inv_clk_vss|inv_mc_vss|inv_q_vss|mph_g|nand_m_vss|nand_s2_vss|s1_vss_m1|s2_vss_m1|s3_vss_m1|s4_vss_m1|sb_vss|sr1_vss|sr2_vss|sr3_vss|sr4_vss|sv_vss|tg_d_vss|tg_fbm_vss|tg_fbs_vss|tg_s_vss|vss|vss_link|vss_link_bridge|vss_link_dip|vss_link_m1|vss_x1|vss_x2|vss_x3__t17
+ g_vss_m1|inv_clk_vss|inv_mc_vss|inv_q_vss|mph_g|nand_m_vss|nand_s2_vss|s1_vss_m1|s2_vss_m1|s3_vss_m1|s4_vss_m1|sb_vss|sr1_vss|sr2_vss|sr3_vss|sr4_vss|sv_vss|tg_d_vss|tg_fbm_vss|tg_fbs_vss|tg_s_vss|vss|vss_link|vss_link_bridge|vss_link_dip|vss_link_m1|vss_x1|vss_x2|vss_x3
+ 77.3535045494
* device instance g_vss_m1_inv_clk_vss_inv_mc_vss_inv_q_vss_mph_g_nand_m_vss_nand_s2_vss_s1_vss_m1_s2_vss_m1_s3_vss_m1_s4_vss_m1_sb_vss_sr1_vss_sr2_vss_sr3_vss_sr4_vss_sv_vss_tg_d_vss_tg_fbm_vss_tg_fbs_vss_tg_s_vss_vss_vss_link_vss_link_bridge_vss_link_dip_vss_link_m1_vss_x1_vss_x2_vss_x3_t18 r0 *1 0,0
Rg_vss_m1_inv_clk_vss_inv_mc_vss_inv_q_vss_mph_g_nand_m_vss_nand_s2_vss_s1_vss_m1_s2_vss_m1_s3_vss_m1_s4_vss_m1_sb_vss_sr1_vss_sr2_vss_sr3_vss_sr4_vss_sv_vss_tg_d_vss_tg_fbm_vss_tg_fbs_vss_tg_s_vss_vss_vss_link_vss_link_bridge_vss_link_dip_vss_link_m1_vss_x1_vss_x2_vss_x3_t18
+ g_vss_m1|inv_clk_vss|inv_mc_vss|inv_q_vss|mph_g|nand_m_vss|nand_s2_vss|s1_vss_m1|s2_vss_m1|s3_vss_m1|s4_vss_m1|sb_vss|sr1_vss|sr2_vss|sr3_vss|sr4_vss|sv_vss|tg_d_vss|tg_fbm_vss|tg_fbs_vss|tg_s_vss|vss|vss_link|vss_link_bridge|vss_link_dip|vss_link_m1|vss_x1|vss_x2|vss_x3__t18
+ g_vss_m1|inv_clk_vss|inv_mc_vss|inv_q_vss|mph_g|nand_m_vss|nand_s2_vss|s1_vss_m1|s2_vss_m1|s3_vss_m1|s4_vss_m1|sb_vss|sr1_vss|sr2_vss|sr3_vss|sr4_vss|sv_vss|tg_d_vss|tg_fbm_vss|tg_fbs_vss|tg_s_vss|vss|vss_link|vss_link_bridge|vss_link_dip|vss_link_m1|vss_x1|vss_x2|vss_x3
+ 153.718823657
* device instance g_vss_m1_inv_clk_vss_inv_mc_vss_inv_q_vss_mph_g_nand_m_vss_nand_s2_vss_s1_vss_m1_s2_vss_m1_s3_vss_m1_s4_vss_m1_sb_vss_sr1_vss_sr2_vss_sr3_vss_sr4_vss_sv_vss_tg_d_vss_tg_fbm_vss_tg_fbs_vss_tg_s_vss_vss_vss_link_vss_link_bridge_vss_link_dip_vss_link_m1_vss_x1_vss_x2_vss_x3_t19 r0 *1 0,0
Rg_vss_m1_inv_clk_vss_inv_mc_vss_inv_q_vss_mph_g_nand_m_vss_nand_s2_vss_s1_vss_m1_s2_vss_m1_s3_vss_m1_s4_vss_m1_sb_vss_sr1_vss_sr2_vss_sr3_vss_sr4_vss_sv_vss_tg_d_vss_tg_fbm_vss_tg_fbs_vss_tg_s_vss_vss_vss_link_vss_link_bridge_vss_link_dip_vss_link_m1_vss_x1_vss_x2_vss_x3_t19
+ g_vss_m1|inv_clk_vss|inv_mc_vss|inv_q_vss|mph_g|nand_m_vss|nand_s2_vss|s1_vss_m1|s2_vss_m1|s3_vss_m1|s4_vss_m1|sb_vss|sr1_vss|sr2_vss|sr3_vss|sr4_vss|sv_vss|tg_d_vss|tg_fbm_vss|tg_fbs_vss|tg_s_vss|vss|vss_link|vss_link_bridge|vss_link_dip|vss_link_m1|vss_x1|vss_x2|vss_x3__t19
+ g_vss_m1|inv_clk_vss|inv_mc_vss|inv_q_vss|mph_g|nand_m_vss|nand_s2_vss|s1_vss_m1|s2_vss_m1|s3_vss_m1|s4_vss_m1|sb_vss|sr1_vss|sr2_vss|sr3_vss|sr4_vss|sv_vss|tg_d_vss|tg_fbm_vss|tg_fbs_vss|tg_s_vss|vss|vss_link|vss_link_bridge|vss_link_dip|vss_link_m1|vss_x1|vss_x2|vss_x3
+ 131.634826813
* device instance g_vss_m1_inv_clk_vss_inv_mc_vss_inv_q_vss_mph_g_nand_m_vss_nand_s2_vss_s1_vss_m1_s2_vss_m1_s3_vss_m1_s4_vss_m1_sb_vss_sr1_vss_sr2_vss_sr3_vss_sr4_vss_sv_vss_tg_d_vss_tg_fbm_vss_tg_fbs_vss_tg_s_vss_vss_vss_link_vss_link_bridge_vss_link_dip_vss_link_m1_vss_x1_vss_x2_vss_x3_t20 r0 *1 0,0
Rg_vss_m1_inv_clk_vss_inv_mc_vss_inv_q_vss_mph_g_nand_m_vss_nand_s2_vss_s1_vss_m1_s2_vss_m1_s3_vss_m1_s4_vss_m1_sb_vss_sr1_vss_sr2_vss_sr3_vss_sr4_vss_sv_vss_tg_d_vss_tg_fbm_vss_tg_fbs_vss_tg_s_vss_vss_vss_link_vss_link_bridge_vss_link_dip_vss_link_m1_vss_x1_vss_x2_vss_x3_t20
+ g_vss_m1|inv_clk_vss|inv_mc_vss|inv_q_vss|mph_g|nand_m_vss|nand_s2_vss|s1_vss_m1|s2_vss_m1|s3_vss_m1|s4_vss_m1|sb_vss|sr1_vss|sr2_vss|sr3_vss|sr4_vss|sv_vss|tg_d_vss|tg_fbm_vss|tg_fbs_vss|tg_s_vss|vss|vss_link|vss_link_bridge|vss_link_dip|vss_link_m1|vss_x1|vss_x2|vss_x3__t20
+ g_vss_m1|inv_clk_vss|inv_mc_vss|inv_q_vss|mph_g|nand_m_vss|nand_s2_vss|s1_vss_m1|s2_vss_m1|s3_vss_m1|s4_vss_m1|sb_vss|sr1_vss|sr2_vss|sr3_vss|sr4_vss|sv_vss|tg_d_vss|tg_fbm_vss|tg_fbs_vss|tg_s_vss|vss|vss_link|vss_link_bridge|vss_link_dip|vss_link_m1|vss_x1|vss_x2|vss_x3
+ 88.3240385873
* device instance g_vss_m1_inv_clk_vss_inv_mc_vss_inv_q_vss_mph_g_nand_m_vss_nand_s2_vss_s1_vss_m1_s2_vss_m1_s3_vss_m1_s4_vss_m1_sb_vss_sr1_vss_sr2_vss_sr3_vss_sr4_vss_sv_vss_tg_d_vss_tg_fbm_vss_tg_fbs_vss_tg_s_vss_vss_vss_link_vss_link_bridge_vss_link_dip_vss_link_m1_vss_x1_vss_x2_vss_x3_t21 r0 *1 0,0
Rg_vss_m1_inv_clk_vss_inv_mc_vss_inv_q_vss_mph_g_nand_m_vss_nand_s2_vss_s1_vss_m1_s2_vss_m1_s3_vss_m1_s4_vss_m1_sb_vss_sr1_vss_sr2_vss_sr3_vss_sr4_vss_sv_vss_tg_d_vss_tg_fbm_vss_tg_fbs_vss_tg_s_vss_vss_vss_link_vss_link_bridge_vss_link_dip_vss_link_m1_vss_x1_vss_x2_vss_x3_t21
+ g_vss_m1|inv_clk_vss|inv_mc_vss|inv_q_vss|mph_g|nand_m_vss|nand_s2_vss|s1_vss_m1|s2_vss_m1|s3_vss_m1|s4_vss_m1|sb_vss|sr1_vss|sr2_vss|sr3_vss|sr4_vss|sv_vss|tg_d_vss|tg_fbm_vss|tg_fbs_vss|tg_s_vss|vss|vss_link|vss_link_bridge|vss_link_dip|vss_link_m1|vss_x1|vss_x2|vss_x3__t21
+ g_vss_m1|inv_clk_vss|inv_mc_vss|inv_q_vss|mph_g|nand_m_vss|nand_s2_vss|s1_vss_m1|s2_vss_m1|s3_vss_m1|s4_vss_m1|sb_vss|sr1_vss|sr2_vss|sr3_vss|sr4_vss|sv_vss|tg_d_vss|tg_fbm_vss|tg_fbs_vss|tg_s_vss|vss|vss_link|vss_link_bridge|vss_link_dip|vss_link_m1|vss_x1|vss_x2|vss_x3
+ 109.779843226
* device instance g_vss_m1_inv_clk_vss_inv_mc_vss_inv_q_vss_mph_g_nand_m_vss_nand_s2_vss_s1_vss_m1_s2_vss_m1_s3_vss_m1_s4_vss_m1_sb_vss_sr1_vss_sr2_vss_sr3_vss_sr4_vss_sv_vss_tg_d_vss_tg_fbm_vss_tg_fbs_vss_tg_s_vss_vss_vss_link_vss_link_bridge_vss_link_dip_vss_link_m1_vss_x1_vss_x2_vss_x3_t22 r0 *1 0,0
Rg_vss_m1_inv_clk_vss_inv_mc_vss_inv_q_vss_mph_g_nand_m_vss_nand_s2_vss_s1_vss_m1_s2_vss_m1_s3_vss_m1_s4_vss_m1_sb_vss_sr1_vss_sr2_vss_sr3_vss_sr4_vss_sv_vss_tg_d_vss_tg_fbm_vss_tg_fbs_vss_tg_s_vss_vss_vss_link_vss_link_bridge_vss_link_dip_vss_link_m1_vss_x1_vss_x2_vss_x3_t22
+ g_vss_m1|inv_clk_vss|inv_mc_vss|inv_q_vss|mph_g|nand_m_vss|nand_s2_vss|s1_vss_m1|s2_vss_m1|s3_vss_m1|s4_vss_m1|sb_vss|sr1_vss|sr2_vss|sr3_vss|sr4_vss|sv_vss|tg_d_vss|tg_fbm_vss|tg_fbs_vss|tg_s_vss|vss|vss_link|vss_link_bridge|vss_link_dip|vss_link_m1|vss_x1|vss_x2|vss_x3__t22
+ g_vss_m1|inv_clk_vss|inv_mc_vss|inv_q_vss|mph_g|nand_m_vss|nand_s2_vss|s1_vss_m1|s2_vss_m1|s3_vss_m1|s4_vss_m1|sb_vss|sr1_vss|sr2_vss|sr3_vss|sr4_vss|sv_vss|tg_d_vss|tg_fbm_vss|tg_fbs_vss|tg_s_vss|vss|vss_link|vss_link_bridge|vss_link_dip|vss_link_m1|vss_x1|vss_x2|vss_x3
+ 305.274829461
* device instance g_vss_m1_inv_clk_vss_inv_mc_vss_inv_q_vss_mph_g_nand_m_vss_nand_s2_vss_s1_vss_m1_s2_vss_m1_s3_vss_m1_s4_vss_m1_sb_vss_sr1_vss_sr2_vss_sr3_vss_sr4_vss_sv_vss_tg_d_vss_tg_fbm_vss_tg_fbs_vss_tg_s_vss_vss_vss_link_vss_link_bridge_vss_link_dip_vss_link_m1_vss_x1_vss_x2_vss_x3_t23 r0 *1 0,0
Rg_vss_m1_inv_clk_vss_inv_mc_vss_inv_q_vss_mph_g_nand_m_vss_nand_s2_vss_s1_vss_m1_s2_vss_m1_s3_vss_m1_s4_vss_m1_sb_vss_sr1_vss_sr2_vss_sr3_vss_sr4_vss_sv_vss_tg_d_vss_tg_fbm_vss_tg_fbs_vss_tg_s_vss_vss_vss_link_vss_link_bridge_vss_link_dip_vss_link_m1_vss_x1_vss_x2_vss_x3_t23
+ g_vss_m1|inv_clk_vss|inv_mc_vss|inv_q_vss|mph_g|nand_m_vss|nand_s2_vss|s1_vss_m1|s2_vss_m1|s3_vss_m1|s4_vss_m1|sb_vss|sr1_vss|sr2_vss|sr3_vss|sr4_vss|sv_vss|tg_d_vss|tg_fbm_vss|tg_fbs_vss|tg_s_vss|vss|vss_link|vss_link_bridge|vss_link_dip|vss_link_m1|vss_x1|vss_x2|vss_x3__t23
+ g_vss_m1|inv_clk_vss|inv_mc_vss|inv_q_vss|mph_g|nand_m_vss|nand_s2_vss|s1_vss_m1|s2_vss_m1|s3_vss_m1|s4_vss_m1|sb_vss|sr1_vss|sr2_vss|sr3_vss|sr4_vss|sv_vss|tg_d_vss|tg_fbm_vss|tg_fbs_vss|tg_s_vss|vss|vss_link|vss_link_bridge|vss_link_dip|vss_link_m1|vss_x1|vss_x2|vss_x3
+ 237.803631721
* device instance g_vss_m1_inv_clk_vss_inv_mc_vss_inv_q_vss_mph_g_nand_m_vss_nand_s2_vss_s1_vss_m1_s2_vss_m1_s3_vss_m1_s4_vss_m1_sb_vss_sr1_vss_sr2_vss_sr3_vss_sr4_vss_sv_vss_tg_d_vss_tg_fbm_vss_tg_fbs_vss_tg_s_vss_vss_vss_link_vss_link_bridge_vss_link_dip_vss_link_m1_vss_x1_vss_x2_vss_x3_t24 r0 *1 0,0
Rg_vss_m1_inv_clk_vss_inv_mc_vss_inv_q_vss_mph_g_nand_m_vss_nand_s2_vss_s1_vss_m1_s2_vss_m1_s3_vss_m1_s4_vss_m1_sb_vss_sr1_vss_sr2_vss_sr3_vss_sr4_vss_sv_vss_tg_d_vss_tg_fbm_vss_tg_fbs_vss_tg_s_vss_vss_vss_link_vss_link_bridge_vss_link_dip_vss_link_m1_vss_x1_vss_x2_vss_x3_t24
+ g_vss_m1|inv_clk_vss|inv_mc_vss|inv_q_vss|mph_g|nand_m_vss|nand_s2_vss|s1_vss_m1|s2_vss_m1|s3_vss_m1|s4_vss_m1|sb_vss|sr1_vss|sr2_vss|sr3_vss|sr4_vss|sv_vss|tg_d_vss|tg_fbm_vss|tg_fbs_vss|tg_s_vss|vss|vss_link|vss_link_bridge|vss_link_dip|vss_link_m1|vss_x1|vss_x2|vss_x3__t24
+ g_vss_m1|inv_clk_vss|inv_mc_vss|inv_q_vss|mph_g|nand_m_vss|nand_s2_vss|s1_vss_m1|s2_vss_m1|s3_vss_m1|s4_vss_m1|sb_vss|sr1_vss|sr2_vss|sr3_vss|sr4_vss|sv_vss|tg_d_vss|tg_fbm_vss|tg_fbs_vss|tg_s_vss|vss|vss_link|vss_link_bridge|vss_link_dip|vss_link_m1|vss_x1|vss_x2|vss_x3
+ 282.759676445
* device instance g_vss_m1_inv_clk_vss_inv_mc_vss_inv_q_vss_mph_g_nand_m_vss_nand_s2_vss_s1_vss_m1_s2_vss_m1_s3_vss_m1_s4_vss_m1_sb_vss_sr1_vss_sr2_vss_sr3_vss_sr4_vss_sv_vss_tg_d_vss_tg_fbm_vss_tg_fbs_vss_tg_s_vss_vss_vss_link_vss_link_bridge_vss_link_dip_vss_link_m1_vss_x1_vss_x2_vss_x3_t25 r0 *1 0,0
Rg_vss_m1_inv_clk_vss_inv_mc_vss_inv_q_vss_mph_g_nand_m_vss_nand_s2_vss_s1_vss_m1_s2_vss_m1_s3_vss_m1_s4_vss_m1_sb_vss_sr1_vss_sr2_vss_sr3_vss_sr4_vss_sv_vss_tg_d_vss_tg_fbm_vss_tg_fbs_vss_tg_s_vss_vss_vss_link_vss_link_bridge_vss_link_dip_vss_link_m1_vss_x1_vss_x2_vss_x3_t25
+ g_vss_m1|inv_clk_vss|inv_mc_vss|inv_q_vss|mph_g|nand_m_vss|nand_s2_vss|s1_vss_m1|s2_vss_m1|s3_vss_m1|s4_vss_m1|sb_vss|sr1_vss|sr2_vss|sr3_vss|sr4_vss|sv_vss|tg_d_vss|tg_fbm_vss|tg_fbs_vss|tg_s_vss|vss|vss_link|vss_link_bridge|vss_link_dip|vss_link_m1|vss_x1|vss_x2|vss_x3__t25
+ g_vss_m1|inv_clk_vss|inv_mc_vss|inv_q_vss|mph_g|nand_m_vss|nand_s2_vss|s1_vss_m1|s2_vss_m1|s3_vss_m1|s4_vss_m1|sb_vss|sr1_vss|sr2_vss|sr3_vss|sr4_vss|sv_vss|tg_d_vss|tg_fbm_vss|tg_fbs_vss|tg_s_vss|vss|vss_link|vss_link_bridge|vss_link_dip|vss_link_m1|vss_x1|vss_x2|vss_x3
+ 260.267138166
* device instance g_vss_m1_inv_clk_vss_inv_mc_vss_inv_q_vss_mph_g_nand_m_vss_nand_s2_vss_s1_vss_m1_s2_vss_m1_s3_vss_m1_s4_vss_m1_sb_vss_sr1_vss_sr2_vss_sr3_vss_sr4_vss_sv_vss_tg_d_vss_tg_fbm_vss_tg_fbs_vss_tg_s_vss_vss_vss_link_vss_link_bridge_vss_link_dip_vss_link_m1_vss_x1_vss_x2_vss_x3_t26 r0 *1 0,0
Rg_vss_m1_inv_clk_vss_inv_mc_vss_inv_q_vss_mph_g_nand_m_vss_nand_s2_vss_s1_vss_m1_s2_vss_m1_s3_vss_m1_s4_vss_m1_sb_vss_sr1_vss_sr2_vss_sr3_vss_sr4_vss_sv_vss_tg_d_vss_tg_fbm_vss_tg_fbs_vss_tg_s_vss_vss_vss_link_vss_link_bridge_vss_link_dip_vss_link_m1_vss_x1_vss_x2_vss_x3_t26
+ g_vss_m1|inv_clk_vss|inv_mc_vss|inv_q_vss|mph_g|nand_m_vss|nand_s2_vss|s1_vss_m1|s2_vss_m1|s3_vss_m1|s4_vss_m1|sb_vss|sr1_vss|sr2_vss|sr3_vss|sr4_vss|sv_vss|tg_d_vss|tg_fbm_vss|tg_fbs_vss|tg_s_vss|vss|vss_link|vss_link_bridge|vss_link_dip|vss_link_m1|vss_x1|vss_x2|vss_x3__t26
+ g_vss_m1|inv_clk_vss|inv_mc_vss|inv_q_vss|mph_g|nand_m_vss|nand_s2_vss|s1_vss_m1|s2_vss_m1|s3_vss_m1|s4_vss_m1|sb_vss|sr1_vss|sr2_vss|sr3_vss|sr4_vss|sv_vss|tg_d_vss|tg_fbm_vss|tg_fbs_vss|tg_s_vss|vss|vss_link|vss_link_bridge|vss_link_dip|vss_link_m1|vss_x1|vss_x2|vss_x3
+ 224.895355835
* device instance g_vss_m1_inv_clk_vss_inv_mc_vss_inv_q_vss_mph_g_nand_m_vss_nand_s2_vss_s1_vss_m1_s2_vss_m1_s3_vss_m1_s4_vss_m1_sb_vss_sr1_vss_sr2_vss_sr3_vss_sr4_vss_sv_vss_tg_d_vss_tg_fbm_vss_tg_fbs_vss_tg_s_vss_vss_vss_link_vss_link_bridge_vss_link_dip_vss_link_m1_vss_x1_vss_x2_vss_x3_t27 r0 *1 0,0
Rg_vss_m1_inv_clk_vss_inv_mc_vss_inv_q_vss_mph_g_nand_m_vss_nand_s2_vss_s1_vss_m1_s2_vss_m1_s3_vss_m1_s4_vss_m1_sb_vss_sr1_vss_sr2_vss_sr3_vss_sr4_vss_sv_vss_tg_d_vss_tg_fbm_vss_tg_fbs_vss_tg_s_vss_vss_vss_link_vss_link_bridge_vss_link_dip_vss_link_m1_vss_x1_vss_x2_vss_x3_t27
+ g_vss_m1|inv_clk_vss|inv_mc_vss|inv_q_vss|mph_g|nand_m_vss|nand_s2_vss|s1_vss_m1|s2_vss_m1|s3_vss_m1|s4_vss_m1|sb_vss|sr1_vss|sr2_vss|sr3_vss|sr4_vss|sv_vss|tg_d_vss|tg_fbm_vss|tg_fbs_vss|tg_s_vss|vss|vss_link|vss_link_bridge|vss_link_dip|vss_link_m1|vss_x1|vss_x2|vss_x3__t27
+ g_vss_m1|inv_clk_vss|inv_mc_vss|inv_q_vss|mph_g|nand_m_vss|nand_s2_vss|s1_vss_m1|s2_vss_m1|s3_vss_m1|s4_vss_m1|sb_vss|sr1_vss|sr2_vss|sr3_vss|sr4_vss|sv_vss|tg_d_vss|tg_fbm_vss|tg_fbs_vss|tg_s_vss|vss|vss_link|vss_link_bridge|vss_link_dip|vss_link_m1|vss_x1|vss_x2|vss_x3
+ 202.36729908
* device instance g_vss_m1_inv_clk_vss_inv_mc_vss_inv_q_vss_mph_g_nand_m_vss_nand_s2_vss_s1_vss_m1_s2_vss_m1_s3_vss_m1_s4_vss_m1_sb_vss_sr1_vss_sr2_vss_sr3_vss_sr4_vss_sv_vss_tg_d_vss_tg_fbm_vss_tg_fbs_vss_tg_s_vss_vss_vss_link_vss_link_bridge_vss_link_dip_vss_link_m1_vss_x1_vss_x2_vss_x3_t28 r0 *1 0,0
Rg_vss_m1_inv_clk_vss_inv_mc_vss_inv_q_vss_mph_g_nand_m_vss_nand_s2_vss_s1_vss_m1_s2_vss_m1_s3_vss_m1_s4_vss_m1_sb_vss_sr1_vss_sr2_vss_sr3_vss_sr4_vss_sv_vss_tg_d_vss_tg_fbm_vss_tg_fbs_vss_tg_s_vss_vss_vss_link_vss_link_bridge_vss_link_dip_vss_link_m1_vss_x1_vss_x2_vss_x3_t28
+ g_vss_m1|inv_clk_vss|inv_mc_vss|inv_q_vss|mph_g|nand_m_vss|nand_s2_vss|s1_vss_m1|s2_vss_m1|s3_vss_m1|s4_vss_m1|sb_vss|sr1_vss|sr2_vss|sr3_vss|sr4_vss|sv_vss|tg_d_vss|tg_fbm_vss|tg_fbs_vss|tg_s_vss|vss|vss_link|vss_link_bridge|vss_link_dip|vss_link_m1|vss_x1|vss_x2|vss_x3__t28
+ g_vss_m1|inv_clk_vss|inv_mc_vss|inv_q_vss|mph_g|nand_m_vss|nand_s2_vss|s1_vss_m1|s2_vss_m1|s3_vss_m1|s4_vss_m1|sb_vss|sr1_vss|sr2_vss|sr3_vss|sr4_vss|sv_vss|tg_d_vss|tg_fbm_vss|tg_fbs_vss|tg_s_vss|vss|vss_link|vss_link_bridge|vss_link_dip|vss_link_m1|vss_x1|vss_x2|vss_x3
+ 179.868735089
* device instance g_vss_m1_inv_clk_vss_inv_mc_vss_inv_q_vss_mph_g_nand_m_vss_nand_s2_vss_s1_vss_m1_s2_vss_m1_s3_vss_m1_s4_vss_m1_sb_vss_sr1_vss_sr2_vss_sr3_vss_sr4_vss_sv_vss_tg_d_vss_tg_fbm_vss_tg_fbs_vss_tg_s_vss_vss_vss_link_vss_link_bridge_vss_link_dip_vss_link_m1_vss_x1_vss_x2_vss_x3_t29 r0 *1 0,0
Rg_vss_m1_inv_clk_vss_inv_mc_vss_inv_q_vss_mph_g_nand_m_vss_nand_s2_vss_s1_vss_m1_s2_vss_m1_s3_vss_m1_s4_vss_m1_sb_vss_sr1_vss_sr2_vss_sr3_vss_sr4_vss_sv_vss_tg_d_vss_tg_fbm_vss_tg_fbs_vss_tg_s_vss_vss_vss_link_vss_link_bridge_vss_link_dip_vss_link_m1_vss_x1_vss_x2_vss_x3_t29
+ g_vss_m1|inv_clk_vss|inv_mc_vss|inv_q_vss|mph_g|nand_m_vss|nand_s2_vss|s1_vss_m1|s2_vss_m1|s3_vss_m1|s4_vss_m1|sb_vss|sr1_vss|sr2_vss|sr3_vss|sr4_vss|sv_vss|tg_d_vss|tg_fbm_vss|tg_fbs_vss|tg_s_vss|vss|vss_link|vss_link_bridge|vss_link_dip|vss_link_m1|vss_x1|vss_x2|vss_x3__t29
+ g_vss_m1|inv_clk_vss|inv_mc_vss|inv_q_vss|mph_g|nand_m_vss|nand_s2_vss|s1_vss_m1|s2_vss_m1|s3_vss_m1|s4_vss_m1|sb_vss|sr1_vss|sr2_vss|sr3_vss|sr4_vss|sv_vss|tg_d_vss|tg_fbm_vss|tg_fbs_vss|tg_s_vss|vss|vss_link|vss_link_bridge|vss_link_dip|vss_link_m1|vss_x1|vss_x2|vss_x3
+ 157.41231036
* device instance g_vss_m1_inv_clk_vss_inv_mc_vss_inv_q_vss_mph_g_nand_m_vss_nand_s2_vss_s1_vss_m1_s2_vss_m1_s3_vss_m1_s4_vss_m1_sb_vss_sr1_vss_sr2_vss_sr3_vss_sr4_vss_sv_vss_tg_d_vss_tg_fbm_vss_tg_fbs_vss_tg_s_vss_vss_vss_link_vss_link_bridge_vss_link_dip_vss_link_m1_vss_x1_vss_x2_vss_x3_t30 r0 *1 0,0
Rg_vss_m1_inv_clk_vss_inv_mc_vss_inv_q_vss_mph_g_nand_m_vss_nand_s2_vss_s1_vss_m1_s2_vss_m1_s3_vss_m1_s4_vss_m1_sb_vss_sr1_vss_sr2_vss_sr3_vss_sr4_vss_sv_vss_tg_d_vss_tg_fbm_vss_tg_fbs_vss_tg_s_vss_vss_vss_link_vss_link_bridge_vss_link_dip_vss_link_m1_vss_x1_vss_x2_vss_x3_t30
+ g_vss_m1|inv_clk_vss|inv_mc_vss|inv_q_vss|mph_g|nand_m_vss|nand_s2_vss|s1_vss_m1|s2_vss_m1|s3_vss_m1|s4_vss_m1|sb_vss|sr1_vss|sr2_vss|sr3_vss|sr4_vss|sv_vss|tg_d_vss|tg_fbm_vss|tg_fbs_vss|tg_s_vss|vss|vss_link|vss_link_bridge|vss_link_dip|vss_link_m1|vss_x1|vss_x2|vss_x3__t30
+ g_vss_m1|inv_clk_vss|inv_mc_vss|inv_q_vss|mph_g|nand_m_vss|nand_s2_vss|s1_vss_m1|s2_vss_m1|s3_vss_m1|s4_vss_m1|sb_vss|sr1_vss|sr2_vss|sr3_vss|sr4_vss|sv_vss|tg_d_vss|tg_fbm_vss|tg_fbs_vss|tg_s_vss|vss|vss_link|vss_link_bridge|vss_link_dip|vss_link_m1|vss_x1|vss_x2|vss_x3
+ 21.866859099
* device instance g_vss_m1_inv_clk_vss_inv_mc_vss_inv_q_vss_mph_g_nand_m_vss_nand_s2_vss_s1_vss_m1_s2_vss_m1_s3_vss_m1_s4_vss_m1_sb_vss_sr1_vss_sr2_vss_sr3_vss_sr4_vss_sv_vss_tg_d_vss_tg_fbm_vss_tg_fbs_vss_tg_s_vss_vss_vss_link_vss_link_bridge_vss_link_dip_vss_link_m1_vss_x1_vss_x2_vss_x3_t31 r0 *1 0,0
Rg_vss_m1_inv_clk_vss_inv_mc_vss_inv_q_vss_mph_g_nand_m_vss_nand_s2_vss_s1_vss_m1_s2_vss_m1_s3_vss_m1_s4_vss_m1_sb_vss_sr1_vss_sr2_vss_sr3_vss_sr4_vss_sv_vss_tg_d_vss_tg_fbm_vss_tg_fbs_vss_tg_s_vss_vss_vss_link_vss_link_bridge_vss_link_dip_vss_link_m1_vss_x1_vss_x2_vss_x3_t31
+ g_vss_m1|inv_clk_vss|inv_mc_vss|inv_q_vss|mph_g|nand_m_vss|nand_s2_vss|s1_vss_m1|s2_vss_m1|s3_vss_m1|s4_vss_m1|sb_vss|sr1_vss|sr2_vss|sr3_vss|sr4_vss|sv_vss|tg_d_vss|tg_fbm_vss|tg_fbs_vss|tg_s_vss|vss|vss_link|vss_link_bridge|vss_link_dip|vss_link_m1|vss_x1|vss_x2|vss_x3__t31
+ g_vss_m1|inv_clk_vss|inv_mc_vss|inv_q_vss|mph_g|nand_m_vss|nand_s2_vss|s1_vss_m1|s2_vss_m1|s3_vss_m1|s4_vss_m1|sb_vss|sr1_vss|sr2_vss|sr3_vss|sr4_vss|sv_vss|tg_d_vss|tg_fbm_vss|tg_fbs_vss|tg_s_vss|vss|vss_link|vss_link_bridge|vss_link_dip|vss_link_m1|vss_x1|vss_x2|vss_x3
+ 33.3818539549
* device instance g_vss_m1_inv_clk_vss_inv_mc_vss_inv_q_vss_mph_g_nand_m_vss_nand_s2_vss_s1_vss_m1_s2_vss_m1_s3_vss_m1_s4_vss_m1_sb_vss_sr1_vss_sr2_vss_sr3_vss_sr4_vss_sv_vss_tg_d_vss_tg_fbm_vss_tg_fbs_vss_tg_s_vss_vss_vss_link_vss_link_bridge_vss_link_dip_vss_link_m1_vss_x1_vss_x2_vss_x3_t32 r0 *1 0,0
Rg_vss_m1_inv_clk_vss_inv_mc_vss_inv_q_vss_mph_g_nand_m_vss_nand_s2_vss_s1_vss_m1_s2_vss_m1_s3_vss_m1_s4_vss_m1_sb_vss_sr1_vss_sr2_vss_sr3_vss_sr4_vss_sv_vss_tg_d_vss_tg_fbm_vss_tg_fbs_vss_tg_s_vss_vss_vss_link_vss_link_bridge_vss_link_dip_vss_link_m1_vss_x1_vss_x2_vss_x3_t32
+ g_vss_m1|inv_clk_vss|inv_mc_vss|inv_q_vss|mph_g|nand_m_vss|nand_s2_vss|s1_vss_m1|s2_vss_m1|s3_vss_m1|s4_vss_m1|sb_vss|sr1_vss|sr2_vss|sr3_vss|sr4_vss|sv_vss|tg_d_vss|tg_fbm_vss|tg_fbs_vss|tg_s_vss|vss|vss_link|vss_link_bridge|vss_link_dip|vss_link_m1|vss_x1|vss_x2|vss_x3__t32
+ g_vss_m1|inv_clk_vss|inv_mc_vss|inv_q_vss|mph_g|nand_m_vss|nand_s2_vss|s1_vss_m1|s2_vss_m1|s3_vss_m1|s4_vss_m1|sb_vss|sr1_vss|sr2_vss|sr3_vss|sr4_vss|sv_vss|tg_d_vss|tg_fbm_vss|tg_fbs_vss|tg_s_vss|vss|vss_link|vss_link_bridge|vss_link_dip|vss_link_m1|vss_x1|vss_x2|vss_x3
+ 52.6893944264
* device instance g_vss_m1_inv_clk_vss_inv_mc_vss_inv_q_vss_mph_g_nand_m_vss_nand_s2_vss_s1_vss_m1_s2_vss_m1_s3_vss_m1_s4_vss_m1_sb_vss_sr1_vss_sr2_vss_sr3_vss_sr4_vss_sv_vss_tg_d_vss_tg_fbm_vss_tg_fbs_vss_tg_s_vss_vss_vss_link_vss_link_bridge_vss_link_dip_vss_link_m1_vss_x1_vss_x2_vss_x3_t33 r0 *1 0,0
Rg_vss_m1_inv_clk_vss_inv_mc_vss_inv_q_vss_mph_g_nand_m_vss_nand_s2_vss_s1_vss_m1_s2_vss_m1_s3_vss_m1_s4_vss_m1_sb_vss_sr1_vss_sr2_vss_sr3_vss_sr4_vss_sv_vss_tg_d_vss_tg_fbm_vss_tg_fbs_vss_tg_s_vss_vss_vss_link_vss_link_bridge_vss_link_dip_vss_link_m1_vss_x1_vss_x2_vss_x3_t33
+ g_vss_m1|inv_clk_vss|inv_mc_vss|inv_q_vss|mph_g|nand_m_vss|nand_s2_vss|s1_vss_m1|s2_vss_m1|s3_vss_m1|s4_vss_m1|sb_vss|sr1_vss|sr2_vss|sr3_vss|sr4_vss|sv_vss|tg_d_vss|tg_fbm_vss|tg_fbs_vss|tg_s_vss|vss|vss_link|vss_link_bridge|vss_link_dip|vss_link_m1|vss_x1|vss_x2|vss_x3__t33
+ g_vss_m1|inv_clk_vss|inv_mc_vss|inv_q_vss|mph_g|nand_m_vss|nand_s2_vss|s1_vss_m1|s2_vss_m1|s3_vss_m1|s4_vss_m1|sb_vss|sr1_vss|sr2_vss|sr3_vss|sr4_vss|sv_vss|tg_d_vss|tg_fbm_vss|tg_fbs_vss|tg_s_vss|vss|vss_link|vss_link_bridge|vss_link_dip|vss_link_m1|vss_x1|vss_x2|vss_x3
+ 73.9163842563
* device instance g_vss_m1_inv_clk_vss_inv_mc_vss_inv_q_vss_mph_g_nand_m_vss_nand_s2_vss_s1_vss_m1_s2_vss_m1_s3_vss_m1_s4_vss_m1_sb_vss_sr1_vss_sr2_vss_sr3_vss_sr4_vss_sv_vss_tg_d_vss_tg_fbm_vss_tg_fbs_vss_tg_s_vss_vss_vss_link_vss_link_bridge_vss_link_dip_vss_link_m1_vss_x1_vss_x2_vss_x3_t34 r0 *1 0,0
Rg_vss_m1_inv_clk_vss_inv_mc_vss_inv_q_vss_mph_g_nand_m_vss_nand_s2_vss_s1_vss_m1_s2_vss_m1_s3_vss_m1_s4_vss_m1_sb_vss_sr1_vss_sr2_vss_sr3_vss_sr4_vss_sv_vss_tg_d_vss_tg_fbm_vss_tg_fbs_vss_tg_s_vss_vss_vss_link_vss_link_bridge_vss_link_dip_vss_link_m1_vss_x1_vss_x2_vss_x3_t34
+ g_vss_m1|inv_clk_vss|inv_mc_vss|inv_q_vss|mph_g|nand_m_vss|nand_s2_vss|s1_vss_m1|s2_vss_m1|s3_vss_m1|s4_vss_m1|sb_vss|sr1_vss|sr2_vss|sr3_vss|sr4_vss|sv_vss|tg_d_vss|tg_fbm_vss|tg_fbs_vss|tg_s_vss|vss|vss_link|vss_link_bridge|vss_link_dip|vss_link_m1|vss_x1|vss_x2|vss_x3__t34
+ g_vss_m1|inv_clk_vss|inv_mc_vss|inv_q_vss|mph_g|nand_m_vss|nand_s2_vss|s1_vss_m1|s2_vss_m1|s3_vss_m1|s4_vss_m1|sb_vss|sr1_vss|sr2_vss|sr3_vss|sr4_vss|sv_vss|tg_d_vss|tg_fbm_vss|tg_fbs_vss|tg_s_vss|vss|vss_link|vss_link_bridge|vss_link_dip|vss_link_m1|vss_x1|vss_x2|vss_x3
+ 85.329965357
* device instance g_vss_m1_inv_clk_vss_inv_mc_vss_inv_q_vss_mph_g_nand_m_vss_nand_s2_vss_s1_vss_m1_s2_vss_m1_s3_vss_m1_s4_vss_m1_sb_vss_sr1_vss_sr2_vss_sr3_vss_sr4_vss_sv_vss_tg_d_vss_tg_fbm_vss_tg_fbs_vss_tg_s_vss_vss_vss_link_vss_link_bridge_vss_link_dip_vss_link_m1_vss_x1_vss_x2_vss_x3_t35 r0 *1 0,0
Rg_vss_m1_inv_clk_vss_inv_mc_vss_inv_q_vss_mph_g_nand_m_vss_nand_s2_vss_s1_vss_m1_s2_vss_m1_s3_vss_m1_s4_vss_m1_sb_vss_sr1_vss_sr2_vss_sr3_vss_sr4_vss_sv_vss_tg_d_vss_tg_fbm_vss_tg_fbs_vss_tg_s_vss_vss_vss_link_vss_link_bridge_vss_link_dip_vss_link_m1_vss_x1_vss_x2_vss_x3_t35
+ g_vss_m1|inv_clk_vss|inv_mc_vss|inv_q_vss|mph_g|nand_m_vss|nand_s2_vss|s1_vss_m1|s2_vss_m1|s3_vss_m1|s4_vss_m1|sb_vss|sr1_vss|sr2_vss|sr3_vss|sr4_vss|sv_vss|tg_d_vss|tg_fbm_vss|tg_fbs_vss|tg_s_vss|vss|vss_link|vss_link_bridge|vss_link_dip|vss_link_m1|vss_x1|vss_x2|vss_x3__t35
+ g_vss_m1|inv_clk_vss|inv_mc_vss|inv_q_vss|mph_g|nand_m_vss|nand_s2_vss|s1_vss_m1|s2_vss_m1|s3_vss_m1|s4_vss_m1|sb_vss|sr1_vss|sr2_vss|sr3_vss|sr4_vss|sv_vss|tg_d_vss|tg_fbm_vss|tg_fbs_vss|tg_s_vss|vss|vss_link|vss_link_bridge|vss_link_dip|vss_link_m1|vss_x1|vss_x2|vss_x3
+ 129.644879673
* device instance g_vss_m1_inv_clk_vss_inv_mc_vss_inv_q_vss_mph_g_nand_m_vss_nand_s2_vss_s1_vss_m1_s2_vss_m1_s3_vss_m1_s4_vss_m1_sb_vss_sr1_vss_sr2_vss_sr3_vss_sr4_vss_sv_vss_tg_d_vss_tg_fbm_vss_tg_fbs_vss_tg_s_vss_vss_vss_link_vss_link_bridge_vss_link_dip_vss_link_m1_vss_x1_vss_x2_vss_x3_t36 r0 *1 0,0
Rg_vss_m1_inv_clk_vss_inv_mc_vss_inv_q_vss_mph_g_nand_m_vss_nand_s2_vss_s1_vss_m1_s2_vss_m1_s3_vss_m1_s4_vss_m1_sb_vss_sr1_vss_sr2_vss_sr3_vss_sr4_vss_sv_vss_tg_d_vss_tg_fbm_vss_tg_fbs_vss_tg_s_vss_vss_vss_link_vss_link_bridge_vss_link_dip_vss_link_m1_vss_x1_vss_x2_vss_x3_t36
+ g_vss_m1|inv_clk_vss|inv_mc_vss|inv_q_vss|mph_g|nand_m_vss|nand_s2_vss|s1_vss_m1|s2_vss_m1|s3_vss_m1|s4_vss_m1|sb_vss|sr1_vss|sr2_vss|sr3_vss|sr4_vss|sv_vss|tg_d_vss|tg_fbm_vss|tg_fbs_vss|tg_s_vss|vss|vss_link|vss_link_bridge|vss_link_dip|vss_link_m1|vss_x1|vss_x2|vss_x3__t36
+ g_vss_m1|inv_clk_vss|inv_mc_vss|inv_q_vss|mph_g|nand_m_vss|nand_s2_vss|s1_vss_m1|s2_vss_m1|s3_vss_m1|s4_vss_m1|sb_vss|sr1_vss|sr2_vss|sr3_vss|sr4_vss|sv_vss|tg_d_vss|tg_fbm_vss|tg_fbs_vss|tg_s_vss|vss|vss_link|vss_link_bridge|vss_link_dip|vss_link_m1|vss_x1|vss_x2|vss_x3
+ 152.018235557
* device instance g_vss_m1_inv_clk_vss_inv_mc_vss_inv_q_vss_mph_g_nand_m_vss_nand_s2_vss_s1_vss_m1_s2_vss_m1_s3_vss_m1_s4_vss_m1_sb_vss_sr1_vss_sr2_vss_sr3_vss_sr4_vss_sv_vss_tg_d_vss_tg_fbm_vss_tg_fbs_vss_tg_s_vss_vss_vss_link_vss_link_bridge_vss_link_dip_vss_link_m1_vss_x1_vss_x2_vss_x3_t37 r0 *1 0,0
Rg_vss_m1_inv_clk_vss_inv_mc_vss_inv_q_vss_mph_g_nand_m_vss_nand_s2_vss_s1_vss_m1_s2_vss_m1_s3_vss_m1_s4_vss_m1_sb_vss_sr1_vss_sr2_vss_sr3_vss_sr4_vss_sv_vss_tg_d_vss_tg_fbm_vss_tg_fbs_vss_tg_s_vss_vss_vss_link_vss_link_bridge_vss_link_dip_vss_link_m1_vss_x1_vss_x2_vss_x3_t37
+ g_vss_m1|inv_clk_vss|inv_mc_vss|inv_q_vss|mph_g|nand_m_vss|nand_s2_vss|s1_vss_m1|s2_vss_m1|s3_vss_m1|s4_vss_m1|sb_vss|sr1_vss|sr2_vss|sr3_vss|sr4_vss|sv_vss|tg_d_vss|tg_fbm_vss|tg_fbs_vss|tg_s_vss|vss|vss_link|vss_link_bridge|vss_link_dip|vss_link_m1|vss_x1|vss_x2|vss_x3__t37
+ g_vss_m1|inv_clk_vss|inv_mc_vss|inv_q_vss|mph_g|nand_m_vss|nand_s2_vss|s1_vss_m1|s2_vss_m1|s3_vss_m1|s4_vss_m1|sb_vss|sr1_vss|sr2_vss|sr3_vss|sr4_vss|sv_vss|tg_d_vss|tg_fbm_vss|tg_fbs_vss|tg_s_vss|vss|vss_link|vss_link_bridge|vss_link_dip|vss_link_m1|vss_x1|vss_x2|vss_x3
+ 107.38566559
* device instance g_vss_m1_inv_clk_vss_inv_mc_vss_inv_q_vss_mph_g_nand_m_vss_nand_s2_vss_s1_vss_m1_s2_vss_m1_s3_vss_m1_s4_vss_m1_sb_vss_sr1_vss_sr2_vss_sr3_vss_sr4_vss_sv_vss_tg_d_vss_tg_fbm_vss_tg_fbs_vss_tg_s_vss_vss_vss_link_vss_link_bridge_vss_link_dip_vss_link_m1_vss_x1_vss_x2_vss_x3_t38 r0 *1 0,0
Rg_vss_m1_inv_clk_vss_inv_mc_vss_inv_q_vss_mph_g_nand_m_vss_nand_s2_vss_s1_vss_m1_s2_vss_m1_s3_vss_m1_s4_vss_m1_sb_vss_sr1_vss_sr2_vss_sr3_vss_sr4_vss_sv_vss_tg_d_vss_tg_fbm_vss_tg_fbs_vss_tg_s_vss_vss_vss_link_vss_link_bridge_vss_link_dip_vss_link_m1_vss_x1_vss_x2_vss_x3_t38
+ g_vss_m1|inv_clk_vss|inv_mc_vss|inv_q_vss|mph_g|nand_m_vss|nand_s2_vss|s1_vss_m1|s2_vss_m1|s3_vss_m1|s4_vss_m1|sb_vss|sr1_vss|sr2_vss|sr3_vss|sr4_vss|sv_vss|tg_d_vss|tg_fbm_vss|tg_fbs_vss|tg_s_vss|vss|vss_link|vss_link_bridge|vss_link_dip|vss_link_m1|vss_x1|vss_x2|vss_x3__t38
+ g_vss_m1|inv_clk_vss|inv_mc_vss|inv_q_vss|mph_g|nand_m_vss|nand_s2_vss|s1_vss_m1|s2_vss_m1|s3_vss_m1|s4_vss_m1|sb_vss|sr1_vss|sr2_vss|sr3_vss|sr4_vss|sv_vss|tg_d_vss|tg_fbm_vss|tg_fbs_vss|tg_s_vss|vss|vss_link|vss_link_bridge|vss_link_dip|vss_link_m1|vss_x1|vss_x2|vss_x3
+ 236.707909574
* device instance g_vss_m1_inv_clk_vss_inv_mc_vss_inv_q_vss_mph_g_nand_m_vss_nand_s2_vss_s1_vss_m1_s2_vss_m1_s3_vss_m1_s4_vss_m1_sb_vss_sr1_vss_sr2_vss_sr3_vss_sr4_vss_sv_vss_tg_d_vss_tg_fbm_vss_tg_fbs_vss_tg_s_vss_vss_vss_link_vss_link_bridge_vss_link_dip_vss_link_m1_vss_x1_vss_x2_vss_x3_t39 r0 *1 0,0
Rg_vss_m1_inv_clk_vss_inv_mc_vss_inv_q_vss_mph_g_nand_m_vss_nand_s2_vss_s1_vss_m1_s2_vss_m1_s3_vss_m1_s4_vss_m1_sb_vss_sr1_vss_sr2_vss_sr3_vss_sr4_vss_sv_vss_tg_d_vss_tg_fbm_vss_tg_fbs_vss_tg_s_vss_vss_vss_link_vss_link_bridge_vss_link_dip_vss_link_m1_vss_x1_vss_x2_vss_x3_t39
+ g_vss_m1|inv_clk_vss|inv_mc_vss|inv_q_vss|mph_g|nand_m_vss|nand_s2_vss|s1_vss_m1|s2_vss_m1|s3_vss_m1|s4_vss_m1|sb_vss|sr1_vss|sr2_vss|sr3_vss|sr4_vss|sv_vss|tg_d_vss|tg_fbm_vss|tg_fbs_vss|tg_s_vss|vss|vss_link|vss_link_bridge|vss_link_dip|vss_link_m1|vss_x1|vss_x2|vss_x3__t39
+ g_vss_m1|inv_clk_vss|inv_mc_vss|inv_q_vss|mph_g|nand_m_vss|nand_s2_vss|s1_vss_m1|s2_vss_m1|s3_vss_m1|s4_vss_m1|sb_vss|sr1_vss|sr2_vss|sr3_vss|sr4_vss|sv_vss|tg_d_vss|tg_fbm_vss|tg_fbs_vss|tg_s_vss|vss|vss_link|vss_link_bridge|vss_link_dip|vss_link_m1|vss_x1|vss_x2|vss_x3
+ 281.838786931
* device instance g_vss_m1_inv_clk_vss_inv_mc_vss_inv_q_vss_mph_g_nand_m_vss_nand_s2_vss_s1_vss_m1_s2_vss_m1_s3_vss_m1_s4_vss_m1_sb_vss_sr1_vss_sr2_vss_sr3_vss_sr4_vss_sv_vss_tg_d_vss_tg_fbm_vss_tg_fbs_vss_tg_s_vss_vss_vss_link_vss_link_bridge_vss_link_dip_vss_link_m1_vss_x1_vss_x2_vss_x3_t40 r0 *1 0,0
Rg_vss_m1_inv_clk_vss_inv_mc_vss_inv_q_vss_mph_g_nand_m_vss_nand_s2_vss_s1_vss_m1_s2_vss_m1_s3_vss_m1_s4_vss_m1_sb_vss_sr1_vss_sr2_vss_sr3_vss_sr4_vss_sv_vss_tg_d_vss_tg_fbm_vss_tg_fbs_vss_tg_s_vss_vss_vss_link_vss_link_bridge_vss_link_dip_vss_link_m1_vss_x1_vss_x2_vss_x3_t40
+ g_vss_m1|inv_clk_vss|inv_mc_vss|inv_q_vss|mph_g|nand_m_vss|nand_s2_vss|s1_vss_m1|s2_vss_m1|s3_vss_m1|s4_vss_m1|sb_vss|sr1_vss|sr2_vss|sr3_vss|sr4_vss|sv_vss|tg_d_vss|tg_fbm_vss|tg_fbs_vss|tg_s_vss|vss|vss_link|vss_link_bridge|vss_link_dip|vss_link_m1|vss_x1|vss_x2|vss_x3__t40
+ g_vss_m1|inv_clk_vss|inv_mc_vss|inv_q_vss|mph_g|nand_m_vss|nand_s2_vss|s1_vss_m1|s2_vss_m1|s3_vss_m1|s4_vss_m1|sb_vss|sr1_vss|sr2_vss|sr3_vss|sr4_vss|sv_vss|tg_d_vss|tg_fbm_vss|tg_fbs_vss|tg_s_vss|vss|vss_link|vss_link_bridge|vss_link_dip|vss_link_m1|vss_x1|vss_x2|vss_x3
+ 304.422056852
* device instance g_vss_m1_inv_clk_vss_inv_mc_vss_inv_q_vss_mph_g_nand_m_vss_nand_s2_vss_s1_vss_m1_s2_vss_m1_s3_vss_m1_s4_vss_m1_sb_vss_sr1_vss_sr2_vss_sr3_vss_sr4_vss_sv_vss_tg_d_vss_tg_fbm_vss_tg_fbs_vss_tg_s_vss_vss_vss_link_vss_link_bridge_vss_link_dip_vss_link_m1_vss_x1_vss_x2_vss_x3_t41 r0 *1 0,0
Rg_vss_m1_inv_clk_vss_inv_mc_vss_inv_q_vss_mph_g_nand_m_vss_nand_s2_vss_s1_vss_m1_s2_vss_m1_s3_vss_m1_s4_vss_m1_sb_vss_sr1_vss_sr2_vss_sr3_vss_sr4_vss_sv_vss_tg_d_vss_tg_fbm_vss_tg_fbs_vss_tg_s_vss_vss_vss_link_vss_link_bridge_vss_link_dip_vss_link_m1_vss_x1_vss_x2_vss_x3_t41
+ g_vss_m1|inv_clk_vss|inv_mc_vss|inv_q_vss|mph_g|nand_m_vss|nand_s2_vss|s1_vss_m1|s2_vss_m1|s3_vss_m1|s4_vss_m1|sb_vss|sr1_vss|sr2_vss|sr3_vss|sr4_vss|sv_vss|tg_d_vss|tg_fbm_vss|tg_fbs_vss|tg_s_vss|vss|vss_link|vss_link_bridge|vss_link_dip|vss_link_m1|vss_x1|vss_x2|vss_x3__t41
+ g_vss_m1|inv_clk_vss|inv_mc_vss|inv_q_vss|mph_g|nand_m_vss|nand_s2_vss|s1_vss_m1|s2_vss_m1|s3_vss_m1|s4_vss_m1|sb_vss|sr1_vss|sr2_vss|sr3_vss|sr4_vss|sv_vss|tg_d_vss|tg_fbm_vss|tg_fbs_vss|tg_s_vss|vss|vss_link|vss_link_bridge|vss_link_dip|vss_link_m1|vss_x1|vss_x2|vss_x3
+ 259.266369598
* device instance g_vss_m1_inv_clk_vss_inv_mc_vss_inv_q_vss_mph_g_nand_m_vss_nand_s2_vss_s1_vss_m1_s2_vss_m1_s3_vss_m1_s4_vss_m1_sb_vss_sr1_vss_sr2_vss_sr3_vss_sr4_vss_sv_vss_tg_d_vss_tg_fbm_vss_tg_fbs_vss_tg_s_vss_vss_vss_link_vss_link_bridge_vss_link_dip_vss_link_m1_vss_x1_vss_x2_vss_x3_t42 r0 *1 0,0
Rg_vss_m1_inv_clk_vss_inv_mc_vss_inv_q_vss_mph_g_nand_m_vss_nand_s2_vss_s1_vss_m1_s2_vss_m1_s3_vss_m1_s4_vss_m1_sb_vss_sr1_vss_sr2_vss_sr3_vss_sr4_vss_sv_vss_tg_d_vss_tg_fbm_vss_tg_fbs_vss_tg_s_vss_vss_vss_link_vss_link_bridge_vss_link_dip_vss_link_m1_vss_x1_vss_x2_vss_x3_t42
+ g_vss_m1|inv_clk_vss|inv_mc_vss|inv_q_vss|mph_g|nand_m_vss|nand_s2_vss|s1_vss_m1|s2_vss_m1|s3_vss_m1|s4_vss_m1|sb_vss|sr1_vss|sr2_vss|sr3_vss|sr4_vss|sv_vss|tg_d_vss|tg_fbm_vss|tg_fbs_vss|tg_s_vss|vss|vss_link|vss_link_bridge|vss_link_dip|vss_link_m1|vss_x1|vss_x2|vss_x3__t42
+ g_vss_m1|inv_clk_vss|inv_mc_vss|inv_q_vss|mph_g|nand_m_vss|nand_s2_vss|s1_vss_m1|s2_vss_m1|s3_vss_m1|s4_vss_m1|sb_vss|sr1_vss|sr2_vss|sr3_vss|sr4_vss|sv_vss|tg_d_vss|tg_fbm_vss|tg_fbs_vss|tg_s_vss|vss|vss_link|vss_link_bridge|vss_link_dip|vss_link_m1|vss_x1|vss_x2|vss_x3
+ 335.138754204
* device instance g_vss_m1_inv_clk_vss_inv_mc_vss_inv_q_vss_mph_g_nand_m_vss_nand_s2_vss_s1_vss_m1_s2_vss_m1_s3_vss_m1_s4_vss_m1_sb_vss_sr1_vss_sr2_vss_sr3_vss_sr4_vss_sv_vss_tg_d_vss_tg_fbm_vss_tg_fbs_vss_tg_s_vss_vss_vss_link_vss_link_bridge_vss_link_dip_vss_link_m1_vss_x1_vss_x2_vss_x3_t43 r0 *1 0,0
Rg_vss_m1_inv_clk_vss_inv_mc_vss_inv_q_vss_mph_g_nand_m_vss_nand_s2_vss_s1_vss_m1_s2_vss_m1_s3_vss_m1_s4_vss_m1_sb_vss_sr1_vss_sr2_vss_sr3_vss_sr4_vss_sv_vss_tg_d_vss_tg_fbm_vss_tg_fbs_vss_tg_s_vss_vss_vss_link_vss_link_bridge_vss_link_dip_vss_link_m1_vss_x1_vss_x2_vss_x3_t43
+ g_vss_m1|inv_clk_vss|inv_mc_vss|inv_q_vss|mph_g|nand_m_vss|nand_s2_vss|s1_vss_m1|s2_vss_m1|s3_vss_m1|s4_vss_m1|sb_vss|sr1_vss|sr2_vss|sr3_vss|sr4_vss|sv_vss|tg_d_vss|tg_fbm_vss|tg_fbs_vss|tg_s_vss|vss|vss_link|vss_link_bridge|vss_link_dip|vss_link_m1|vss_x1|vss_x2|vss_x3__t43
+ g_vss_m1|inv_clk_vss|inv_mc_vss|inv_q_vss|mph_g|nand_m_vss|nand_s2_vss|s1_vss_m1|s2_vss_m1|s3_vss_m1|s4_vss_m1|sb_vss|sr1_vss|sr2_vss|sr3_vss|sr4_vss|sv_vss|tg_d_vss|tg_fbm_vss|tg_fbs_vss|tg_s_vss|vss|vss_link|vss_link_bridge|vss_link_dip|vss_link_m1|vss_x1|vss_x2|vss_x3
+ 282.247818296
* device instance g_vss_m1_inv_clk_vss_inv_mc_vss_inv_q_vss_mph_g_nand_m_vss_nand_s2_vss_s1_vss_m1_s2_vss_m1_s3_vss_m1_s4_vss_m1_sb_vss_sr1_vss_sr2_vss_sr3_vss_sr4_vss_sv_vss_tg_d_vss_tg_fbm_vss_tg_fbs_vss_tg_s_vss_vss_vss_link_vss_link_bridge_vss_link_dip_vss_link_m1_vss_x1_vss_x2_vss_x3_t44 r0 *1 0,0
Rg_vss_m1_inv_clk_vss_inv_mc_vss_inv_q_vss_mph_g_nand_m_vss_nand_s2_vss_s1_vss_m1_s2_vss_m1_s3_vss_m1_s4_vss_m1_sb_vss_sr1_vss_sr2_vss_sr3_vss_sr4_vss_sv_vss_tg_d_vss_tg_fbm_vss_tg_fbs_vss_tg_s_vss_vss_vss_link_vss_link_bridge_vss_link_dip_vss_link_m1_vss_x1_vss_x2_vss_x3_t44
+ g_vss_m1|inv_clk_vss|inv_mc_vss|inv_q_vss|mph_g|nand_m_vss|nand_s2_vss|s1_vss_m1|s2_vss_m1|s3_vss_m1|s4_vss_m1|sb_vss|sr1_vss|sr2_vss|sr3_vss|sr4_vss|sv_vss|tg_d_vss|tg_fbm_vss|tg_fbs_vss|tg_s_vss|vss|vss_link|vss_link_bridge|vss_link_dip|vss_link_m1|vss_x1|vss_x2|vss_x3__t44
+ g_vss_m1|inv_clk_vss|inv_mc_vss|inv_q_vss|mph_g|nand_m_vss|nand_s2_vss|s1_vss_m1|s2_vss_m1|s3_vss_m1|s4_vss_m1|sb_vss|sr1_vss|sr2_vss|sr3_vss|sr4_vss|sv_vss|tg_d_vss|tg_fbm_vss|tg_fbs_vss|tg_s_vss|vss|vss_link|vss_link_bridge|vss_link_dip|vss_link_m1|vss_x1|vss_x2|vss_x3
+ 228.602921778
* device instance g_vss_m1_inv_clk_vss_inv_mc_vss_inv_q_vss_mph_g_nand_m_vss_nand_s2_vss_s1_vss_m1_s2_vss_m1_s3_vss_m1_s4_vss_m1_sb_vss_sr1_vss_sr2_vss_sr3_vss_sr4_vss_sv_vss_tg_d_vss_tg_fbm_vss_tg_fbs_vss_tg_s_vss_vss_vss_link_vss_link_bridge_vss_link_dip_vss_link_m1_vss_x1_vss_x2_vss_x3_t45 r0 *1 0,0
Rg_vss_m1_inv_clk_vss_inv_mc_vss_inv_q_vss_mph_g_nand_m_vss_nand_s2_vss_s1_vss_m1_s2_vss_m1_s3_vss_m1_s4_vss_m1_sb_vss_sr1_vss_sr2_vss_sr3_vss_sr4_vss_sv_vss_tg_d_vss_tg_fbm_vss_tg_fbs_vss_tg_s_vss_vss_vss_link_vss_link_bridge_vss_link_dip_vss_link_m1_vss_x1_vss_x2_vss_x3_t45
+ g_vss_m1|inv_clk_vss|inv_mc_vss|inv_q_vss|mph_g|nand_m_vss|nand_s2_vss|s1_vss_m1|s2_vss_m1|s3_vss_m1|s4_vss_m1|sb_vss|sr1_vss|sr2_vss|sr3_vss|sr4_vss|sv_vss|tg_d_vss|tg_fbm_vss|tg_fbs_vss|tg_s_vss|vss|vss_link|vss_link_bridge|vss_link_dip|vss_link_m1|vss_x1|vss_x2|vss_x3__t45
+ g_vss_m1|inv_clk_vss|inv_mc_vss|inv_q_vss|mph_g|nand_m_vss|nand_s2_vss|s1_vss_m1|s2_vss_m1|s3_vss_m1|s4_vss_m1|sb_vss|sr1_vss|sr2_vss|sr3_vss|sr4_vss|sv_vss|tg_d_vss|tg_fbm_vss|tg_fbs_vss|tg_s_vss|vss|vss_link|vss_link_bridge|vss_link_dip|vss_link_m1|vss_x1|vss_x2|vss_x3
+ 183.385616322
* device instance g_vss_m1_inv_clk_vss_inv_mc_vss_inv_q_vss_mph_g_nand_m_vss_nand_s2_vss_s1_vss_m1_s2_vss_m1_s3_vss_m1_s4_vss_m1_sb_vss_sr1_vss_sr2_vss_sr3_vss_sr4_vss_sv_vss_tg_d_vss_tg_fbm_vss_tg_fbs_vss_tg_s_vss_vss_vss_link_vss_link_bridge_vss_link_dip_vss_link_m1_vss_x1_vss_x2_vss_x3_t46 r0 *1 0,0
Rg_vss_m1_inv_clk_vss_inv_mc_vss_inv_q_vss_mph_g_nand_m_vss_nand_s2_vss_s1_vss_m1_s2_vss_m1_s3_vss_m1_s4_vss_m1_sb_vss_sr1_vss_sr2_vss_sr3_vss_sr4_vss_sv_vss_tg_d_vss_tg_fbm_vss_tg_fbs_vss_tg_s_vss_vss_vss_link_vss_link_bridge_vss_link_dip_vss_link_m1_vss_x1_vss_x2_vss_x3_t46
+ g_vss_m1|inv_clk_vss|inv_mc_vss|inv_q_vss|mph_g|nand_m_vss|nand_s2_vss|s1_vss_m1|s2_vss_m1|s3_vss_m1|s4_vss_m1|sb_vss|sr1_vss|sr2_vss|sr3_vss|sr4_vss|sv_vss|tg_d_vss|tg_fbm_vss|tg_fbs_vss|tg_s_vss|vss|vss_link|vss_link_bridge|vss_link_dip|vss_link_m1|vss_x1|vss_x2|vss_x3__t46
+ g_vss_m1|inv_clk_vss|inv_mc_vss|inv_q_vss|mph_g|nand_m_vss|nand_s2_vss|s1_vss_m1|s2_vss_m1|s3_vss_m1|s4_vss_m1|sb_vss|sr1_vss|sr2_vss|sr3_vss|sr4_vss|sv_vss|tg_d_vss|tg_fbm_vss|tg_fbs_vss|tg_s_vss|vss|vss_link|vss_link_bridge|vss_link_dip|vss_link_m1|vss_x1|vss_x2|vss_x3
+ 132.112421684
* device instance g_vss_m1_inv_clk_vss_inv_mc_vss_inv_q_vss_mph_g_nand_m_vss_nand_s2_vss_s1_vss_m1_s2_vss_m1_s3_vss_m1_s4_vss_m1_sb_vss_sr1_vss_sr2_vss_sr3_vss_sr4_vss_sv_vss_tg_d_vss_tg_fbm_vss_tg_fbs_vss_tg_s_vss_vss_vss_link_vss_link_bridge_vss_link_dip_vss_link_m1_vss_x1_vss_x2_vss_x3_t47 r0 *1 0,0
Rg_vss_m1_inv_clk_vss_inv_mc_vss_inv_q_vss_mph_g_nand_m_vss_nand_s2_vss_s1_vss_m1_s2_vss_m1_s3_vss_m1_s4_vss_m1_sb_vss_sr1_vss_sr2_vss_sr3_vss_sr4_vss_sv_vss_tg_d_vss_tg_fbm_vss_tg_fbs_vss_tg_s_vss_vss_vss_link_vss_link_bridge_vss_link_dip_vss_link_m1_vss_x1_vss_x2_vss_x3_t47
+ g_vss_m1|inv_clk_vss|inv_mc_vss|inv_q_vss|mph_g|nand_m_vss|nand_s2_vss|s1_vss_m1|s2_vss_m1|s3_vss_m1|s4_vss_m1|sb_vss|sr1_vss|sr2_vss|sr3_vss|sr4_vss|sv_vss|tg_d_vss|tg_fbm_vss|tg_fbs_vss|tg_s_vss|vss|vss_link|vss_link_bridge|vss_link_dip|vss_link_m1|vss_x1|vss_x2|vss_x3__t47
+ g_vss_m1|inv_clk_vss|inv_mc_vss|inv_q_vss|mph_g|nand_m_vss|nand_s2_vss|s1_vss_m1|s2_vss_m1|s3_vss_m1|s4_vss_m1|sb_vss|sr1_vss|sr2_vss|sr3_vss|sr4_vss|sv_vss|tg_d_vss|tg_fbm_vss|tg_fbs_vss|tg_s_vss|vss|vss_link|vss_link_bridge|vss_link_dip|vss_link_m1|vss_x1|vss_x2|vss_x3
+ 256.414180866
* device instance g_vss_m1_inv_clk_vss_inv_mc_vss_inv_q_vss_mph_g_nand_m_vss_nand_s2_vss_s1_vss_m1_s2_vss_m1_s3_vss_m1_s4_vss_m1_sb_vss_sr1_vss_sr2_vss_sr3_vss_sr4_vss_sv_vss_tg_d_vss_tg_fbm_vss_tg_fbs_vss_tg_s_vss_vss_vss_link_vss_link_bridge_vss_link_dip_vss_link_m1_vss_x1_vss_x2_vss_x3_t48 r0 *1 0,0
Rg_vss_m1_inv_clk_vss_inv_mc_vss_inv_q_vss_mph_g_nand_m_vss_nand_s2_vss_s1_vss_m1_s2_vss_m1_s3_vss_m1_s4_vss_m1_sb_vss_sr1_vss_sr2_vss_sr3_vss_sr4_vss_sv_vss_tg_d_vss_tg_fbm_vss_tg_fbs_vss_tg_s_vss_vss_vss_link_vss_link_bridge_vss_link_dip_vss_link_m1_vss_x1_vss_x2_vss_x3_t48
+ g_vss_m1|inv_clk_vss|inv_mc_vss|inv_q_vss|mph_g|nand_m_vss|nand_s2_vss|s1_vss_m1|s2_vss_m1|s3_vss_m1|s4_vss_m1|sb_vss|sr1_vss|sr2_vss|sr3_vss|sr4_vss|sv_vss|tg_d_vss|tg_fbm_vss|tg_fbs_vss|tg_s_vss|vss|vss_link|vss_link_bridge|vss_link_dip|vss_link_m1|vss_x1|vss_x2|vss_x3__t48
+ g_vss_m1|inv_clk_vss|inv_mc_vss|inv_q_vss|mph_g|nand_m_vss|nand_s2_vss|s1_vss_m1|s2_vss_m1|s3_vss_m1|s4_vss_m1|sb_vss|sr1_vss|sr2_vss|sr3_vss|sr4_vss|sv_vss|tg_d_vss|tg_fbm_vss|tg_fbs_vss|tg_s_vss|vss|vss_link|vss_link_bridge|vss_link_dip|vss_link_m1|vss_x1|vss_x2|vss_x3
+ 534.534407231
* device instance g_vss_m1_inv_clk_vss_inv_mc_vss_inv_q_vss_mph_g_nand_m_vss_nand_s2_vss_s1_vss_m1_s2_vss_m1_s3_vss_m1_s4_vss_m1_sb_vss_sr1_vss_sr2_vss_sr3_vss_sr4_vss_sv_vss_tg_d_vss_tg_fbm_vss_tg_fbs_vss_tg_s_vss_vss_vss_link_vss_link_bridge_vss_link_dip_vss_link_m1_vss_x1_vss_x2_vss_x3_t49 r0 *1 0,0
Rg_vss_m1_inv_clk_vss_inv_mc_vss_inv_q_vss_mph_g_nand_m_vss_nand_s2_vss_s1_vss_m1_s2_vss_m1_s3_vss_m1_s4_vss_m1_sb_vss_sr1_vss_sr2_vss_sr3_vss_sr4_vss_sv_vss_tg_d_vss_tg_fbm_vss_tg_fbs_vss_tg_s_vss_vss_vss_link_vss_link_bridge_vss_link_dip_vss_link_m1_vss_x1_vss_x2_vss_x3_t49
+ g_vss_m1|inv_clk_vss|inv_mc_vss|inv_q_vss|mph_g|nand_m_vss|nand_s2_vss|s1_vss_m1|s2_vss_m1|s3_vss_m1|s4_vss_m1|sb_vss|sr1_vss|sr2_vss|sr3_vss|sr4_vss|sv_vss|tg_d_vss|tg_fbm_vss|tg_fbs_vss|tg_s_vss|vss|vss_link|vss_link_bridge|vss_link_dip|vss_link_m1|vss_x1|vss_x2|vss_x3__t49
+ g_vss_m1|inv_clk_vss|inv_mc_vss|inv_q_vss|mph_g|nand_m_vss|nand_s2_vss|s1_vss_m1|s2_vss_m1|s3_vss_m1|s4_vss_m1|sb_vss|sr1_vss|sr2_vss|sr3_vss|sr4_vss|sv_vss|tg_d_vss|tg_fbm_vss|tg_fbs_vss|tg_s_vss|vss|vss_link|vss_link_bridge|vss_link_dip|vss_link_m1|vss_x1|vss_x2|vss_x3
+ 381.078358966
* device instance g_vss_m1_inv_clk_vss_inv_mc_vss_inv_q_vss_mph_g_nand_m_vss_nand_s2_vss_s1_vss_m1_s2_vss_m1_s3_vss_m1_s4_vss_m1_sb_vss_sr1_vss_sr2_vss_sr3_vss_sr4_vss_sv_vss_tg_d_vss_tg_fbm_vss_tg_fbs_vss_tg_s_vss_vss_vss_link_vss_link_bridge_vss_link_dip_vss_link_m1_vss_x1_vss_x2_vss_x3_t50 r0 *1 0,0
Rg_vss_m1_inv_clk_vss_inv_mc_vss_inv_q_vss_mph_g_nand_m_vss_nand_s2_vss_s1_vss_m1_s2_vss_m1_s3_vss_m1_s4_vss_m1_sb_vss_sr1_vss_sr2_vss_sr3_vss_sr4_vss_sv_vss_tg_d_vss_tg_fbm_vss_tg_fbs_vss_tg_s_vss_vss_vss_link_vss_link_bridge_vss_link_dip_vss_link_m1_vss_x1_vss_x2_vss_x3_t50
+ g_vss_m1|inv_clk_vss|inv_mc_vss|inv_q_vss|mph_g|nand_m_vss|nand_s2_vss|s1_vss_m1|s2_vss_m1|s3_vss_m1|s4_vss_m1|sb_vss|sr1_vss|sr2_vss|sr3_vss|sr4_vss|sv_vss|tg_d_vss|tg_fbm_vss|tg_fbs_vss|tg_s_vss|vss|vss_link|vss_link_bridge|vss_link_dip|vss_link_m1|vss_x1|vss_x2|vss_x3__t50
+ g_vss_m1|inv_clk_vss|inv_mc_vss|inv_q_vss|mph_g|nand_m_vss|nand_s2_vss|s1_vss_m1|s2_vss_m1|s3_vss_m1|s4_vss_m1|sb_vss|sr1_vss|sr2_vss|sr3_vss|sr4_vss|sv_vss|tg_d_vss|tg_fbm_vss|tg_fbs_vss|tg_s_vss|vss|vss_link|vss_link_bridge|vss_link_dip|vss_link_m1|vss_x1|vss_x2|vss_x3
+ 435.22277849
* device instance g_vss_m1_inv_clk_vss_inv_mc_vss_inv_q_vss_mph_g_nand_m_vss_nand_s2_vss_s1_vss_m1_s2_vss_m1_s3_vss_m1_s4_vss_m1_sb_vss_sr1_vss_sr2_vss_sr3_vss_sr4_vss_sv_vss_tg_d_vss_tg_fbm_vss_tg_fbs_vss_tg_s_vss_vss_vss_link_vss_link_bridge_vss_link_dip_vss_link_m1_vss_x1_vss_x2_vss_x3_t51 r0 *1 0,0
Rg_vss_m1_inv_clk_vss_inv_mc_vss_inv_q_vss_mph_g_nand_m_vss_nand_s2_vss_s1_vss_m1_s2_vss_m1_s3_vss_m1_s4_vss_m1_sb_vss_sr1_vss_sr2_vss_sr3_vss_sr4_vss_sv_vss_tg_d_vss_tg_fbm_vss_tg_fbs_vss_tg_s_vss_vss_vss_link_vss_link_bridge_vss_link_dip_vss_link_m1_vss_x1_vss_x2_vss_x3_t51
+ g_vss_m1|inv_clk_vss|inv_mc_vss|inv_q_vss|mph_g|nand_m_vss|nand_s2_vss|s1_vss_m1|s2_vss_m1|s3_vss_m1|s4_vss_m1|sb_vss|sr1_vss|sr2_vss|sr3_vss|sr4_vss|sv_vss|tg_d_vss|tg_fbm_vss|tg_fbs_vss|tg_s_vss|vss|vss_link|vss_link_bridge|vss_link_dip|vss_link_m1|vss_x1|vss_x2|vss_x3__t51
+ g_vss_m1|inv_clk_vss|inv_mc_vss|inv_q_vss|mph_g|nand_m_vss|nand_s2_vss|s1_vss_m1|s2_vss_m1|s3_vss_m1|s4_vss_m1|sb_vss|sr1_vss|sr2_vss|sr3_vss|sr4_vss|sv_vss|tg_d_vss|tg_fbm_vss|tg_fbs_vss|tg_s_vss|vss|vss_link|vss_link_bridge|vss_link_dip|vss_link_m1|vss_x1|vss_x2|vss_x3
+ 488.41640214
* device instance g_vss_m1_inv_clk_vss_inv_mc_vss_inv_q_vss_mph_g_nand_m_vss_nand_s2_vss_s1_vss_m1_s2_vss_m1_s3_vss_m1_s4_vss_m1_sb_vss_sr1_vss_sr2_vss_sr3_vss_sr4_vss_sv_vss_tg_d_vss_tg_fbm_vss_tg_fbs_vss_tg_s_vss_vss_vss_link_vss_link_bridge_vss_link_dip_vss_link_m1_vss_x1_vss_x2_vss_x3_t52 r0 *1 0,0
Rg_vss_m1_inv_clk_vss_inv_mc_vss_inv_q_vss_mph_g_nand_m_vss_nand_s2_vss_s1_vss_m1_s2_vss_m1_s3_vss_m1_s4_vss_m1_sb_vss_sr1_vss_sr2_vss_sr3_vss_sr4_vss_sv_vss_tg_d_vss_tg_fbm_vss_tg_fbs_vss_tg_s_vss_vss_vss_link_vss_link_bridge_vss_link_dip_vss_link_m1_vss_x1_vss_x2_vss_x3_t52
+ g_vss_m1|inv_clk_vss|inv_mc_vss|inv_q_vss|mph_g|nand_m_vss|nand_s2_vss|s1_vss_m1|s2_vss_m1|s3_vss_m1|s4_vss_m1|sb_vss|sr1_vss|sr2_vss|sr3_vss|sr4_vss|sv_vss|tg_d_vss|tg_fbm_vss|tg_fbs_vss|tg_s_vss|vss|vss_link|vss_link_bridge|vss_link_dip|vss_link_m1|vss_x1|vss_x2|vss_x3__t52
+ g_vss_m1|inv_clk_vss|inv_mc_vss|inv_q_vss|mph_g|nand_m_vss|nand_s2_vss|s1_vss_m1|s2_vss_m1|s3_vss_m1|s4_vss_m1|sb_vss|sr1_vss|sr2_vss|sr3_vss|sr4_vss|sv_vss|tg_d_vss|tg_fbm_vss|tg_fbs_vss|tg_s_vss|vss|vss_link|vss_link_bridge|vss_link_dip|vss_link_m1|vss_x1|vss_x2|vss_x3
+ 287.813421287
* device instance g_vss_m1_inv_clk_vss_inv_mc_vss_inv_q_vss_mph_g_nand_m_vss_nand_s2_vss_s1_vss_m1_s2_vss_m1_s3_vss_m1_s4_vss_m1_sb_vss_sr1_vss_sr2_vss_sr3_vss_sr4_vss_sv_vss_tg_d_vss_tg_fbm_vss_tg_fbs_vss_tg_s_vss_vss_vss_link_vss_link_bridge_vss_link_dip_vss_link_m1_vss_x1_vss_x2_vss_x3_t53 r0 *1 0,0
Rg_vss_m1_inv_clk_vss_inv_mc_vss_inv_q_vss_mph_g_nand_m_vss_nand_s2_vss_s1_vss_m1_s2_vss_m1_s3_vss_m1_s4_vss_m1_sb_vss_sr1_vss_sr2_vss_sr3_vss_sr4_vss_sv_vss_tg_d_vss_tg_fbm_vss_tg_fbs_vss_tg_s_vss_vss_vss_link_vss_link_bridge_vss_link_dip_vss_link_m1_vss_x1_vss_x2_vss_x3_t53
+ g_vss_m1|inv_clk_vss|inv_mc_vss|inv_q_vss|mph_g|nand_m_vss|nand_s2_vss|s1_vss_m1|s2_vss_m1|s3_vss_m1|s4_vss_m1|sb_vss|sr1_vss|sr2_vss|sr3_vss|sr4_vss|sv_vss|tg_d_vss|tg_fbm_vss|tg_fbs_vss|tg_s_vss|vss|vss_link|vss_link_bridge|vss_link_dip|vss_link_m1|vss_x1|vss_x2|vss_x3__t53
+ g_vss_m1|inv_clk_vss|inv_mc_vss|inv_q_vss|mph_g|nand_m_vss|nand_s2_vss|s1_vss_m1|s2_vss_m1|s3_vss_m1|s4_vss_m1|sb_vss|sr1_vss|sr2_vss|sr3_vss|sr4_vss|sv_vss|tg_d_vss|tg_fbm_vss|tg_fbs_vss|tg_s_vss|vss|vss_link|vss_link_bridge|vss_link_dip|vss_link_m1|vss_x1|vss_x2|vss_x3
+ 242.166096824
* device instance g_vss_m1_inv_clk_vss_inv_mc_vss_inv_q_vss_mph_g_nand_m_vss_nand_s2_vss_s1_vss_m1_s2_vss_m1_s3_vss_m1_s4_vss_m1_sb_vss_sr1_vss_sr2_vss_sr3_vss_sr4_vss_sv_vss_tg_d_vss_tg_fbm_vss_tg_fbs_vss_tg_s_vss_vss_vss_link_vss_link_bridge_vss_link_dip_vss_link_m1_vss_x1_vss_x2_vss_x3_t54 r0 *1 0,0
Rg_vss_m1_inv_clk_vss_inv_mc_vss_inv_q_vss_mph_g_nand_m_vss_nand_s2_vss_s1_vss_m1_s2_vss_m1_s3_vss_m1_s4_vss_m1_sb_vss_sr1_vss_sr2_vss_sr3_vss_sr4_vss_sv_vss_tg_d_vss_tg_fbm_vss_tg_fbs_vss_tg_s_vss_vss_vss_link_vss_link_bridge_vss_link_dip_vss_link_m1_vss_x1_vss_x2_vss_x3_t54
+ g_vss_m1|inv_clk_vss|inv_mc_vss|inv_q_vss|mph_g|nand_m_vss|nand_s2_vss|s1_vss_m1|s2_vss_m1|s3_vss_m1|s4_vss_m1|sb_vss|sr1_vss|sr2_vss|sr3_vss|sr4_vss|sv_vss|tg_d_vss|tg_fbm_vss|tg_fbs_vss|tg_s_vss|vss|vss_link|vss_link_bridge|vss_link_dip|vss_link_m1|vss_x1|vss_x2|vss_x3__t54
+ g_vss_m1|inv_clk_vss|inv_mc_vss|inv_q_vss|mph_g|nand_m_vss|nand_s2_vss|s1_vss_m1|s2_vss_m1|s3_vss_m1|s4_vss_m1|sb_vss|sr1_vss|sr2_vss|sr3_vss|sr4_vss|sv_vss|tg_d_vss|tg_fbm_vss|tg_fbs_vss|tg_s_vss|vss|vss_link|vss_link_bridge|vss_link_dip|vss_link_m1|vss_x1|vss_x2|vss_x3
+ 188.860014474
* device instance g_vss_m1_inv_clk_vss_inv_mc_vss_inv_q_vss_mph_g_nand_m_vss_nand_s2_vss_s1_vss_m1_s2_vss_m1_s3_vss_m1_s4_vss_m1_sb_vss_sr1_vss_sr2_vss_sr3_vss_sr4_vss_sv_vss_tg_d_vss_tg_fbm_vss_tg_fbs_vss_tg_s_vss_vss_vss_link_vss_link_bridge_vss_link_dip_vss_link_m1_vss_x1_vss_x2_vss_x3_t55 r0 *1 0,0
Rg_vss_m1_inv_clk_vss_inv_mc_vss_inv_q_vss_mph_g_nand_m_vss_nand_s2_vss_s1_vss_m1_s2_vss_m1_s3_vss_m1_s4_vss_m1_sb_vss_sr1_vss_sr2_vss_sr3_vss_sr4_vss_sv_vss_tg_d_vss_tg_fbm_vss_tg_fbs_vss_tg_s_vss_vss_vss_link_vss_link_bridge_vss_link_dip_vss_link_m1_vss_x1_vss_x2_vss_x3_t55
+ g_vss_m1|inv_clk_vss|inv_mc_vss|inv_q_vss|mph_g|nand_m_vss|nand_s2_vss|s1_vss_m1|s2_vss_m1|s3_vss_m1|s4_vss_m1|sb_vss|sr1_vss|sr2_vss|sr3_vss|sr4_vss|sv_vss|tg_d_vss|tg_fbm_vss|tg_fbs_vss|tg_s_vss|vss|vss_link|vss_link_bridge|vss_link_dip|vss_link_m1|vss_x1|vss_x2|vss_x3__t55
+ g_vss_m1|inv_clk_vss|inv_mc_vss|inv_q_vss|mph_g|nand_m_vss|nand_s2_vss|s1_vss_m1|s2_vss_m1|s3_vss_m1|s4_vss_m1|sb_vss|sr1_vss|sr2_vss|sr3_vss|sr4_vss|sv_vss|tg_d_vss|tg_fbm_vss|tg_fbs_vss|tg_s_vss|vss|vss_link|vss_link_bridge|vss_link_dip|vss_link_m1|vss_x1|vss_x2|vss_x3
+ 49.8746528061
* device instance g_vss_m1_inv_clk_vss_inv_mc_vss_inv_q_vss_mph_g_nand_m_vss_nand_s2_vss_s1_vss_m1_s2_vss_m1_s3_vss_m1_s4_vss_m1_sb_vss_sr1_vss_sr2_vss_sr3_vss_sr4_vss_sv_vss_tg_d_vss_tg_fbm_vss_tg_fbs_vss_tg_s_vss_vss_vss_link_vss_link_bridge_vss_link_dip_vss_link_m1_vss_x1_vss_x2_vss_x3_t56 r0 *1 0,0
Rg_vss_m1_inv_clk_vss_inv_mc_vss_inv_q_vss_mph_g_nand_m_vss_nand_s2_vss_s1_vss_m1_s2_vss_m1_s3_vss_m1_s4_vss_m1_sb_vss_sr1_vss_sr2_vss_sr3_vss_sr4_vss_sv_vss_tg_d_vss_tg_fbm_vss_tg_fbs_vss_tg_s_vss_vss_vss_link_vss_link_bridge_vss_link_dip_vss_link_m1_vss_x1_vss_x2_vss_x3_t56
+ g_vss_m1|inv_clk_vss|inv_mc_vss|inv_q_vss|mph_g|nand_m_vss|nand_s2_vss|s1_vss_m1|s2_vss_m1|s3_vss_m1|s4_vss_m1|sb_vss|sr1_vss|sr2_vss|sr3_vss|sr4_vss|sv_vss|tg_d_vss|tg_fbm_vss|tg_fbs_vss|tg_s_vss|vss|vss_link|vss_link_bridge|vss_link_dip|vss_link_m1|vss_x1|vss_x2|vss_x3__t56
+ g_vss_m1|inv_clk_vss|inv_mc_vss|inv_q_vss|mph_g|nand_m_vss|nand_s2_vss|s1_vss_m1|s2_vss_m1|s3_vss_m1|s4_vss_m1|sb_vss|sr1_vss|sr2_vss|sr3_vss|sr4_vss|sv_vss|tg_d_vss|tg_fbm_vss|tg_fbs_vss|tg_s_vss|vss|vss_link|vss_link_bridge|vss_link_dip|vss_link_m1|vss_x1|vss_x2|vss_x3
+ 205.213370832
* device instance g_vss_m1_inv_clk_vss_inv_mc_vss_inv_q_vss_mph_g_nand_m_vss_nand_s2_vss_s1_vss_m1_s2_vss_m1_s3_vss_m1_s4_vss_m1_sb_vss_sr1_vss_sr2_vss_sr3_vss_sr4_vss_sv_vss_tg_d_vss_tg_fbm_vss_tg_fbs_vss_tg_s_vss_vss_vss_link_vss_link_bridge_vss_link_dip_vss_link_m1_vss_x1_vss_x2_vss_x3_t57 r0 *1 0,0
Rg_vss_m1_inv_clk_vss_inv_mc_vss_inv_q_vss_mph_g_nand_m_vss_nand_s2_vss_s1_vss_m1_s2_vss_m1_s3_vss_m1_s4_vss_m1_sb_vss_sr1_vss_sr2_vss_sr3_vss_sr4_vss_sv_vss_tg_d_vss_tg_fbm_vss_tg_fbs_vss_tg_s_vss_vss_vss_link_vss_link_bridge_vss_link_dip_vss_link_m1_vss_x1_vss_x2_vss_x3_t57
+ g_vss_m1|inv_clk_vss|inv_mc_vss|inv_q_vss|mph_g|nand_m_vss|nand_s2_vss|s1_vss_m1|s2_vss_m1|s3_vss_m1|s4_vss_m1|sb_vss|sr1_vss|sr2_vss|sr3_vss|sr4_vss|sv_vss|tg_d_vss|tg_fbm_vss|tg_fbs_vss|tg_s_vss|vss|vss_link|vss_link_bridge|vss_link_dip|vss_link_m1|vss_x1|vss_x2|vss_x3__t57
+ g_vss_m1|inv_clk_vss|inv_mc_vss|inv_q_vss|mph_g|nand_m_vss|nand_s2_vss|s1_vss_m1|s2_vss_m1|s3_vss_m1|s4_vss_m1|sb_vss|sr1_vss|sr2_vss|sr3_vss|sr4_vss|sv_vss|tg_d_vss|tg_fbm_vss|tg_fbs_vss|tg_s_vss|vss|vss_link|vss_link_bridge|vss_link_dip|vss_link_m1|vss_x1|vss_x2|vss_x3
+ 82.7210555587
* device instance g_vss_m1_inv_clk_vss_inv_mc_vss_inv_q_vss_mph_g_nand_m_vss_nand_s2_vss_s1_vss_m1_s2_vss_m1_s3_vss_m1_s4_vss_m1_sb_vss_sr1_vss_sr2_vss_sr3_vss_sr4_vss_sv_vss_tg_d_vss_tg_fbm_vss_tg_fbs_vss_tg_s_vss_vss_vss_link_vss_link_bridge_vss_link_dip_vss_link_m1_vss_x1_vss_x2_vss_x3_t58 r0 *1 0,0
Rg_vss_m1_inv_clk_vss_inv_mc_vss_inv_q_vss_mph_g_nand_m_vss_nand_s2_vss_s1_vss_m1_s2_vss_m1_s3_vss_m1_s4_vss_m1_sb_vss_sr1_vss_sr2_vss_sr3_vss_sr4_vss_sv_vss_tg_d_vss_tg_fbm_vss_tg_fbs_vss_tg_s_vss_vss_vss_link_vss_link_bridge_vss_link_dip_vss_link_m1_vss_x1_vss_x2_vss_x3_t58
+ g_vss_m1|inv_clk_vss|inv_mc_vss|inv_q_vss|mph_g|nand_m_vss|nand_s2_vss|s1_vss_m1|s2_vss_m1|s3_vss_m1|s4_vss_m1|sb_vss|sr1_vss|sr2_vss|sr3_vss|sr4_vss|sv_vss|tg_d_vss|tg_fbm_vss|tg_fbs_vss|tg_s_vss|vss|vss_link|vss_link_bridge|vss_link_dip|vss_link_m1|vss_x1|vss_x2|vss_x3__t58
+ g_vss_m1|inv_clk_vss|inv_mc_vss|inv_q_vss|mph_g|nand_m_vss|nand_s2_vss|s1_vss_m1|s2_vss_m1|s3_vss_m1|s4_vss_m1|sb_vss|sr1_vss|sr2_vss|sr3_vss|sr4_vss|sv_vss|tg_d_vss|tg_fbm_vss|tg_fbs_vss|tg_s_vss|vss|vss_link|vss_link_bridge|vss_link_dip|vss_link_m1|vss_x1|vss_x2|vss_x3
+ 137.439349262
* device instance g_vss_m1_inv_clk_vss_inv_mc_vss_inv_q_vss_mph_g_nand_m_vss_nand_s2_vss_s1_vss_m1_s2_vss_m1_s3_vss_m1_s4_vss_m1_sb_vss_sr1_vss_sr2_vss_sr3_vss_sr4_vss_sv_vss_tg_d_vss_tg_fbm_vss_tg_fbs_vss_tg_s_vss_vss_vss_link_vss_link_bridge_vss_link_dip_vss_link_m1_vss_x1_vss_x2_vss_x3_t59 r0 *1 0,0
Rg_vss_m1_inv_clk_vss_inv_mc_vss_inv_q_vss_mph_g_nand_m_vss_nand_s2_vss_s1_vss_m1_s2_vss_m1_s3_vss_m1_s4_vss_m1_sb_vss_sr1_vss_sr2_vss_sr3_vss_sr4_vss_sv_vss_tg_d_vss_tg_fbm_vss_tg_fbs_vss_tg_s_vss_vss_vss_link_vss_link_bridge_vss_link_dip_vss_link_m1_vss_x1_vss_x2_vss_x3_t59
+ g_vss_m1|inv_clk_vss|inv_mc_vss|inv_q_vss|mph_g|nand_m_vss|nand_s2_vss|s1_vss_m1|s2_vss_m1|s3_vss_m1|s4_vss_m1|sb_vss|sr1_vss|sr2_vss|sr3_vss|sr4_vss|sv_vss|tg_d_vss|tg_fbm_vss|tg_fbs_vss|tg_s_vss|vss|vss_link|vss_link_bridge|vss_link_dip|vss_link_m1|vss_x1|vss_x2|vss_x3__t59
+ g_vss_m1|inv_clk_vss|inv_mc_vss|inv_q_vss|mph_g|nand_m_vss|nand_s2_vss|s1_vss_m1|s2_vss_m1|s3_vss_m1|s4_vss_m1|sb_vss|sr1_vss|sr2_vss|sr3_vss|sr4_vss|sv_vss|tg_d_vss|tg_fbm_vss|tg_fbs_vss|tg_s_vss|vss|vss_link|vss_link_bridge|vss_link_dip|vss_link_m1|vss_x1|vss_x2|vss_x3
+ 94.7161403067
* device instance g_vss_m1_inv_clk_vss_inv_mc_vss_inv_q_vss_mph_g_nand_m_vss_nand_s2_vss_s1_vss_m1_s2_vss_m1_s3_vss_m1_s4_vss_m1_sb_vss_sr1_vss_sr2_vss_sr3_vss_sr4_vss_sv_vss_tg_d_vss_tg_fbm_vss_tg_fbs_vss_tg_s_vss_vss_vss_link_vss_link_bridge_vss_link_dip_vss_link_m1_vss_x1_vss_x2_vss_x3_t60 r0 *1 0,0
Rg_vss_m1_inv_clk_vss_inv_mc_vss_inv_q_vss_mph_g_nand_m_vss_nand_s2_vss_s1_vss_m1_s2_vss_m1_s3_vss_m1_s4_vss_m1_sb_vss_sr1_vss_sr2_vss_sr3_vss_sr4_vss_sv_vss_tg_d_vss_tg_fbm_vss_tg_fbs_vss_tg_s_vss_vss_vss_link_vss_link_bridge_vss_link_dip_vss_link_m1_vss_x1_vss_x2_vss_x3_t60
+ g_vss_m1|inv_clk_vss|inv_mc_vss|inv_q_vss|mph_g|nand_m_vss|nand_s2_vss|s1_vss_m1|s2_vss_m1|s3_vss_m1|s4_vss_m1|sb_vss|sr1_vss|sr2_vss|sr3_vss|sr4_vss|sv_vss|tg_d_vss|tg_fbm_vss|tg_fbs_vss|tg_s_vss|vss|vss_link|vss_link_bridge|vss_link_dip|vss_link_m1|vss_x1|vss_x2|vss_x3__t60
+ g_vss_m1|inv_clk_vss|inv_mc_vss|inv_q_vss|mph_g|nand_m_vss|nand_s2_vss|s1_vss_m1|s2_vss_m1|s3_vss_m1|s4_vss_m1|sb_vss|sr1_vss|sr2_vss|sr3_vss|sr4_vss|sv_vss|tg_d_vss|tg_fbm_vss|tg_fbs_vss|tg_s_vss|vss|vss_link|vss_link_bridge|vss_link_dip|vss_link_m1|vss_x1|vss_x2|vss_x3
+ 52.8057762744
* device instance g_vss_m1_inv_clk_vss_inv_mc_vss_inv_q_vss_mph_g_nand_m_vss_nand_s2_vss_s1_vss_m1_s2_vss_m1_s3_vss_m1_s4_vss_m1_sb_vss_sr1_vss_sr2_vss_sr3_vss_sr4_vss_sv_vss_tg_d_vss_tg_fbm_vss_tg_fbs_vss_tg_s_vss_vss_vss_link_vss_link_bridge_vss_link_dip_vss_link_m1_vss_x1_vss_x2_vss_x3_t61 r0 *1 0,0
Rg_vss_m1_inv_clk_vss_inv_mc_vss_inv_q_vss_mph_g_nand_m_vss_nand_s2_vss_s1_vss_m1_s2_vss_m1_s3_vss_m1_s4_vss_m1_sb_vss_sr1_vss_sr2_vss_sr3_vss_sr4_vss_sv_vss_tg_d_vss_tg_fbm_vss_tg_fbs_vss_tg_s_vss_vss_vss_link_vss_link_bridge_vss_link_dip_vss_link_m1_vss_x1_vss_x2_vss_x3_t61
+ g_vss_m1|inv_clk_vss|inv_mc_vss|inv_q_vss|mph_g|nand_m_vss|nand_s2_vss|s1_vss_m1|s2_vss_m1|s3_vss_m1|s4_vss_m1|sb_vss|sr1_vss|sr2_vss|sr3_vss|sr4_vss|sv_vss|tg_d_vss|tg_fbm_vss|tg_fbs_vss|tg_s_vss|vss|vss_link|vss_link_bridge|vss_link_dip|vss_link_m1|vss_x1|vss_x2|vss_x3__t61
+ g_vss_m1|inv_clk_vss|inv_mc_vss|inv_q_vss|mph_g|nand_m_vss|nand_s2_vss|s1_vss_m1|s2_vss_m1|s3_vss_m1|s4_vss_m1|sb_vss|sr1_vss|sr2_vss|sr3_vss|sr4_vss|sv_vss|tg_d_vss|tg_fbm_vss|tg_fbs_vss|tg_s_vss|vss|vss_link|vss_link_bridge|vss_link_dip|vss_link_m1|vss_x1|vss_x2|vss_x3
+ 138.443030519
* device instance g_vss_m1_inv_clk_vss_inv_mc_vss_inv_q_vss_mph_g_nand_m_vss_nand_s2_vss_s1_vss_m1_s2_vss_m1_s3_vss_m1_s4_vss_m1_sb_vss_sr1_vss_sr2_vss_sr3_vss_sr4_vss_sv_vss_tg_d_vss_tg_fbm_vss_tg_fbs_vss_tg_s_vss_vss_vss_link_vss_link_bridge_vss_link_dip_vss_link_m1_vss_x1_vss_x2_vss_x3_t62 r0 *1 0,0
Rg_vss_m1_inv_clk_vss_inv_mc_vss_inv_q_vss_mph_g_nand_m_vss_nand_s2_vss_s1_vss_m1_s2_vss_m1_s3_vss_m1_s4_vss_m1_sb_vss_sr1_vss_sr2_vss_sr3_vss_sr4_vss_sv_vss_tg_d_vss_tg_fbm_vss_tg_fbs_vss_tg_s_vss_vss_vss_link_vss_link_bridge_vss_link_dip_vss_link_m1_vss_x1_vss_x2_vss_x3_t62
+ g_vss_m1|inv_clk_vss|inv_mc_vss|inv_q_vss|mph_g|nand_m_vss|nand_s2_vss|s1_vss_m1|s2_vss_m1|s3_vss_m1|s4_vss_m1|sb_vss|sr1_vss|sr2_vss|sr3_vss|sr4_vss|sv_vss|tg_d_vss|tg_fbm_vss|tg_fbs_vss|tg_s_vss|vss|vss_link|vss_link_bridge|vss_link_dip|vss_link_m1|vss_x1|vss_x2|vss_x3__t62
+ g_vss_m1|inv_clk_vss|inv_mc_vss|inv_q_vss|mph_g|nand_m_vss|nand_s2_vss|s1_vss_m1|s2_vss_m1|s3_vss_m1|s4_vss_m1|sb_vss|sr1_vss|sr2_vss|sr3_vss|sr4_vss|sv_vss|tg_d_vss|tg_fbm_vss|tg_fbs_vss|tg_s_vss|vss|vss_link|vss_link_bridge|vss_link_dip|vss_link_m1|vss_x1|vss_x2|vss_x3
+ 337.361037403
* device instance g_vss_m1_inv_clk_vss_inv_mc_vss_inv_q_vss_mph_g_nand_m_vss_nand_s2_vss_s1_vss_m1_s2_vss_m1_s3_vss_m1_s4_vss_m1_sb_vss_sr1_vss_sr2_vss_sr3_vss_sr4_vss_sv_vss_tg_d_vss_tg_fbm_vss_tg_fbs_vss_tg_s_vss_vss_vss_link_vss_link_bridge_vss_link_dip_vss_link_m1_vss_x1_vss_x2_vss_x3_t63 r0 *1 0,0
Rg_vss_m1_inv_clk_vss_inv_mc_vss_inv_q_vss_mph_g_nand_m_vss_nand_s2_vss_s1_vss_m1_s2_vss_m1_s3_vss_m1_s4_vss_m1_sb_vss_sr1_vss_sr2_vss_sr3_vss_sr4_vss_sv_vss_tg_d_vss_tg_fbm_vss_tg_fbs_vss_tg_s_vss_vss_vss_link_vss_link_bridge_vss_link_dip_vss_link_m1_vss_x1_vss_x2_vss_x3_t63
+ g_vss_m1|inv_clk_vss|inv_mc_vss|inv_q_vss|mph_g|nand_m_vss|nand_s2_vss|s1_vss_m1|s2_vss_m1|s3_vss_m1|s4_vss_m1|sb_vss|sr1_vss|sr2_vss|sr3_vss|sr4_vss|sv_vss|tg_d_vss|tg_fbm_vss|tg_fbs_vss|tg_s_vss|vss|vss_link|vss_link_bridge|vss_link_dip|vss_link_m1|vss_x1|vss_x2|vss_x3__t63
+ g_vss_m1|inv_clk_vss|inv_mc_vss|inv_q_vss|mph_g|nand_m_vss|nand_s2_vss|s1_vss_m1|s2_vss_m1|s3_vss_m1|s4_vss_m1|sb_vss|sr1_vss|sr2_vss|sr3_vss|sr4_vss|sv_vss|tg_d_vss|tg_fbm_vss|tg_fbs_vss|tg_s_vss|vss|vss_link|vss_link_bridge|vss_link_dip|vss_link_m1|vss_x1|vss_x2|vss_x3
+ 288.326263217
* device instance g_vss_m1_inv_clk_vss_inv_mc_vss_inv_q_vss_mph_g_nand_m_vss_nand_s2_vss_s1_vss_m1_s2_vss_m1_s3_vss_m1_s4_vss_m1_sb_vss_sr1_vss_sr2_vss_sr3_vss_sr4_vss_sv_vss_tg_d_vss_tg_fbm_vss_tg_fbs_vss_tg_s_vss_vss_vss_link_vss_link_bridge_vss_link_dip_vss_link_m1_vss_x1_vss_x2_vss_x3_t64 r0 *1 0,0
Rg_vss_m1_inv_clk_vss_inv_mc_vss_inv_q_vss_mph_g_nand_m_vss_nand_s2_vss_s1_vss_m1_s2_vss_m1_s3_vss_m1_s4_vss_m1_sb_vss_sr1_vss_sr2_vss_sr3_vss_sr4_vss_sv_vss_tg_d_vss_tg_fbm_vss_tg_fbs_vss_tg_s_vss_vss_vss_link_vss_link_bridge_vss_link_dip_vss_link_m1_vss_x1_vss_x2_vss_x3_t64
+ g_vss_m1|inv_clk_vss|inv_mc_vss|inv_q_vss|mph_g|nand_m_vss|nand_s2_vss|s1_vss_m1|s2_vss_m1|s3_vss_m1|s4_vss_m1|sb_vss|sr1_vss|sr2_vss|sr3_vss|sr4_vss|sv_vss|tg_d_vss|tg_fbm_vss|tg_fbs_vss|tg_s_vss|vss|vss_link|vss_link_bridge|vss_link_dip|vss_link_m1|vss_x1|vss_x2|vss_x3__t64
+ g_vss_m1|inv_clk_vss|inv_mc_vss|inv_q_vss|mph_g|nand_m_vss|nand_s2_vss|s1_vss_m1|s2_vss_m1|s3_vss_m1|s4_vss_m1|sb_vss|sr1_vss|sr2_vss|sr3_vss|sr4_vss|sv_vss|tg_d_vss|tg_fbm_vss|tg_fbs_vss|tg_s_vss|vss|vss_link|vss_link_bridge|vss_link_dip|vss_link_m1|vss_x1|vss_x2|vss_x3
+ 259.440105674
* device instance g_vss_m1_inv_clk_vss_inv_mc_vss_inv_q_vss_mph_g_nand_m_vss_nand_s2_vss_s1_vss_m1_s2_vss_m1_s3_vss_m1_s4_vss_m1_sb_vss_sr1_vss_sr2_vss_sr3_vss_sr4_vss_sv_vss_tg_d_vss_tg_fbm_vss_tg_fbs_vss_tg_s_vss_vss_vss_link_vss_link_bridge_vss_link_dip_vss_link_m1_vss_x1_vss_x2_vss_x3_t65 r0 *1 0,0
Rg_vss_m1_inv_clk_vss_inv_mc_vss_inv_q_vss_mph_g_nand_m_vss_nand_s2_vss_s1_vss_m1_s2_vss_m1_s3_vss_m1_s4_vss_m1_sb_vss_sr1_vss_sr2_vss_sr3_vss_sr4_vss_sv_vss_tg_d_vss_tg_fbm_vss_tg_fbs_vss_tg_s_vss_vss_vss_link_vss_link_bridge_vss_link_dip_vss_link_m1_vss_x1_vss_x2_vss_x3_t65
+ g_vss_m1|inv_clk_vss|inv_mc_vss|inv_q_vss|mph_g|nand_m_vss|nand_s2_vss|s1_vss_m1|s2_vss_m1|s3_vss_m1|s4_vss_m1|sb_vss|sr1_vss|sr2_vss|sr3_vss|sr4_vss|sv_vss|tg_d_vss|tg_fbm_vss|tg_fbs_vss|tg_s_vss|vss|vss_link|vss_link_bridge|vss_link_dip|vss_link_m1|vss_x1|vss_x2|vss_x3__t65
+ g_vss_m1|inv_clk_vss|inv_mc_vss|inv_q_vss|mph_g|nand_m_vss|nand_s2_vss|s1_vss_m1|s2_vss_m1|s3_vss_m1|s4_vss_m1|sb_vss|sr1_vss|sr2_vss|sr3_vss|sr4_vss|sv_vss|tg_d_vss|tg_fbm_vss|tg_fbs_vss|tg_s_vss|vss|vss_link|vss_link_bridge|vss_link_dip|vss_link_m1|vss_x1|vss_x2|vss_x3
+ 183.536990297
* device instance g_vss_m1_inv_clk_vss_inv_mc_vss_inv_q_vss_mph_g_nand_m_vss_nand_s2_vss_s1_vss_m1_s2_vss_m1_s3_vss_m1_s4_vss_m1_sb_vss_sr1_vss_sr2_vss_sr3_vss_sr4_vss_sv_vss_tg_d_vss_tg_fbm_vss_tg_fbs_vss_tg_s_vss_vss_vss_link_vss_link_bridge_vss_link_dip_vss_link_m1_vss_x1_vss_x2_vss_x3_t66 r0 *1 0,0
Rg_vss_m1_inv_clk_vss_inv_mc_vss_inv_q_vss_mph_g_nand_m_vss_nand_s2_vss_s1_vss_m1_s2_vss_m1_s3_vss_m1_s4_vss_m1_sb_vss_sr1_vss_sr2_vss_sr3_vss_sr4_vss_sv_vss_tg_d_vss_tg_fbm_vss_tg_fbs_vss_tg_s_vss_vss_vss_link_vss_link_bridge_vss_link_dip_vss_link_m1_vss_x1_vss_x2_vss_x3_t66
+ g_vss_m1|inv_clk_vss|inv_mc_vss|inv_q_vss|mph_g|nand_m_vss|nand_s2_vss|s1_vss_m1|s2_vss_m1|s3_vss_m1|s4_vss_m1|sb_vss|sr1_vss|sr2_vss|sr3_vss|sr4_vss|sv_vss|tg_d_vss|tg_fbm_vss|tg_fbs_vss|tg_s_vss|vss|vss_link|vss_link_bridge|vss_link_dip|vss_link_m1|vss_x1|vss_x2|vss_x3__t66
+ g_vss_m1|inv_clk_vss|inv_mc_vss|inv_q_vss|mph_g|nand_m_vss|nand_s2_vss|s1_vss_m1|s2_vss_m1|s3_vss_m1|s4_vss_m1|sb_vss|sr1_vss|sr2_vss|sr3_vss|sr4_vss|sv_vss|tg_d_vss|tg_fbm_vss|tg_fbs_vss|tg_s_vss|vss|vss_link|vss_link_bridge|vss_link_dip|vss_link_m1|vss_x1|vss_x2|vss_x3
+ 104.583954862
* device instance g_vss_m1_inv_clk_vss_inv_mc_vss_inv_q_vss_mph_g_nand_m_vss_nand_s2_vss_s1_vss_m1_s2_vss_m1_s3_vss_m1_s4_vss_m1_sb_vss_sr1_vss_sr2_vss_sr3_vss_sr4_vss_sv_vss_tg_d_vss_tg_fbm_vss_tg_fbs_vss_tg_s_vss_vss_vss_link_vss_link_bridge_vss_link_dip_vss_link_m1_vss_x1_vss_x2_vss_x3_t67 r0 *1 0,0
Rg_vss_m1_inv_clk_vss_inv_mc_vss_inv_q_vss_mph_g_nand_m_vss_nand_s2_vss_s1_vss_m1_s2_vss_m1_s3_vss_m1_s4_vss_m1_sb_vss_sr1_vss_sr2_vss_sr3_vss_sr4_vss_sv_vss_tg_d_vss_tg_fbm_vss_tg_fbs_vss_tg_s_vss_vss_vss_link_vss_link_bridge_vss_link_dip_vss_link_m1_vss_x1_vss_x2_vss_x3_t67
+ g_vss_m1|inv_clk_vss|inv_mc_vss|inv_q_vss|mph_g|nand_m_vss|nand_s2_vss|s1_vss_m1|s2_vss_m1|s3_vss_m1|s4_vss_m1|sb_vss|sr1_vss|sr2_vss|sr3_vss|sr4_vss|sv_vss|tg_d_vss|tg_fbm_vss|tg_fbs_vss|tg_s_vss|vss|vss_link|vss_link_bridge|vss_link_dip|vss_link_m1|vss_x1|vss_x2|vss_x3__t67
+ g_vss_m1|inv_clk_vss|inv_mc_vss|inv_q_vss|mph_g|nand_m_vss|nand_s2_vss|s1_vss_m1|s2_vss_m1|s3_vss_m1|s4_vss_m1|sb_vss|sr1_vss|sr2_vss|sr3_vss|sr4_vss|sv_vss|tg_d_vss|tg_fbm_vss|tg_fbs_vss|tg_s_vss|vss|vss_link|vss_link_bridge|vss_link_dip|vss_link_m1|vss_x1|vss_x2|vss_x3
+ 55.3103554581
* device instance g_vss_m1_inv_clk_vss_inv_mc_vss_inv_q_vss_mph_g_nand_m_vss_nand_s2_vss_s1_vss_m1_s2_vss_m1_s3_vss_m1_s4_vss_m1_sb_vss_sr1_vss_sr2_vss_sr3_vss_sr4_vss_sv_vss_tg_d_vss_tg_fbm_vss_tg_fbs_vss_tg_s_vss_vss_vss_link_vss_link_bridge_vss_link_dip_vss_link_m1_vss_x1_vss_x2_vss_x3_t68 r0 *1 0,0
Rg_vss_m1_inv_clk_vss_inv_mc_vss_inv_q_vss_mph_g_nand_m_vss_nand_s2_vss_s1_vss_m1_s2_vss_m1_s3_vss_m1_s4_vss_m1_sb_vss_sr1_vss_sr2_vss_sr3_vss_sr4_vss_sv_vss_tg_d_vss_tg_fbm_vss_tg_fbs_vss_tg_s_vss_vss_vss_link_vss_link_bridge_vss_link_dip_vss_link_m1_vss_x1_vss_x2_vss_x3_t68
+ g_vss_m1|inv_clk_vss|inv_mc_vss|inv_q_vss|mph_g|nand_m_vss|nand_s2_vss|s1_vss_m1|s2_vss_m1|s3_vss_m1|s4_vss_m1|sb_vss|sr1_vss|sr2_vss|sr3_vss|sr4_vss|sv_vss|tg_d_vss|tg_fbm_vss|tg_fbs_vss|tg_s_vss|vss|vss_link|vss_link_bridge|vss_link_dip|vss_link_m1|vss_x1|vss_x2|vss_x3__t68
+ g_vss_m1|inv_clk_vss|inv_mc_vss|inv_q_vss|mph_g|nand_m_vss|nand_s2_vss|s1_vss_m1|s2_vss_m1|s3_vss_m1|s4_vss_m1|sb_vss|sr1_vss|sr2_vss|sr3_vss|sr4_vss|sv_vss|tg_d_vss|tg_fbm_vss|tg_fbs_vss|tg_s_vss|vss|vss_link|vss_link_bridge|vss_link_dip|vss_link_m1|vss_x1|vss_x2|vss_x3
+ 211.445675363
* device instance g_vss_m1_inv_clk_vss_inv_mc_vss_inv_q_vss_mph_g_nand_m_vss_nand_s2_vss_s1_vss_m1_s2_vss_m1_s3_vss_m1_s4_vss_m1_sb_vss_sr1_vss_sr2_vss_sr3_vss_sr4_vss_sv_vss_tg_d_vss_tg_fbm_vss_tg_fbs_vss_tg_s_vss_vss_vss_link_vss_link_bridge_vss_link_dip_vss_link_m1_vss_x1_vss_x2_vss_x3_t69 r0 *1 0,0
Rg_vss_m1_inv_clk_vss_inv_mc_vss_inv_q_vss_mph_g_nand_m_vss_nand_s2_vss_s1_vss_m1_s2_vss_m1_s3_vss_m1_s4_vss_m1_sb_vss_sr1_vss_sr2_vss_sr3_vss_sr4_vss_sv_vss_tg_d_vss_tg_fbm_vss_tg_fbs_vss_tg_s_vss_vss_vss_link_vss_link_bridge_vss_link_dip_vss_link_m1_vss_x1_vss_x2_vss_x3_t69
+ g_vss_m1|inv_clk_vss|inv_mc_vss|inv_q_vss|mph_g|nand_m_vss|nand_s2_vss|s1_vss_m1|s2_vss_m1|s3_vss_m1|s4_vss_m1|sb_vss|sr1_vss|sr2_vss|sr3_vss|sr4_vss|sv_vss|tg_d_vss|tg_fbm_vss|tg_fbs_vss|tg_s_vss|vss|vss_link|vss_link_bridge|vss_link_dip|vss_link_m1|vss_x1|vss_x2|vss_x3__t69
+ g_vss_m1|inv_clk_vss|inv_mc_vss|inv_q_vss|mph_g|nand_m_vss|nand_s2_vss|s1_vss_m1|s2_vss_m1|s3_vss_m1|s4_vss_m1|sb_vss|sr1_vss|sr2_vss|sr3_vss|sr4_vss|sv_vss|tg_d_vss|tg_fbm_vss|tg_fbs_vss|tg_s_vss|vss|vss_link|vss_link_bridge|vss_link_dip|vss_link_m1|vss_x1|vss_x2|vss_x3
+ 150.530719956
* device instance g_vss_m1_inv_clk_vss_inv_mc_vss_inv_q_vss_mph_g_nand_m_vss_nand_s2_vss_s1_vss_m1_s2_vss_m1_s3_vss_m1_s4_vss_m1_sb_vss_sr1_vss_sr2_vss_sr3_vss_sr4_vss_sv_vss_tg_d_vss_tg_fbm_vss_tg_fbs_vss_tg_s_vss_vss_vss_link_vss_link_bridge_vss_link_dip_vss_link_m1_vss_x1_vss_x2_vss_x3_t70 r0 *1 0,0
Rg_vss_m1_inv_clk_vss_inv_mc_vss_inv_q_vss_mph_g_nand_m_vss_nand_s2_vss_s1_vss_m1_s2_vss_m1_s3_vss_m1_s4_vss_m1_sb_vss_sr1_vss_sr2_vss_sr3_vss_sr4_vss_sv_vss_tg_d_vss_tg_fbm_vss_tg_fbs_vss_tg_s_vss_vss_vss_link_vss_link_bridge_vss_link_dip_vss_link_m1_vss_x1_vss_x2_vss_x3_t70
+ g_vss_m1|inv_clk_vss|inv_mc_vss|inv_q_vss|mph_g|nand_m_vss|nand_s2_vss|s1_vss_m1|s2_vss_m1|s3_vss_m1|s4_vss_m1|sb_vss|sr1_vss|sr2_vss|sr3_vss|sr4_vss|sv_vss|tg_d_vss|tg_fbm_vss|tg_fbs_vss|tg_s_vss|vss|vss_link|vss_link_bridge|vss_link_dip|vss_link_m1|vss_x1|vss_x2|vss_x3__t70
+ g_vss_m1|inv_clk_vss|inv_mc_vss|inv_q_vss|mph_g|nand_m_vss|nand_s2_vss|s1_vss_m1|s2_vss_m1|s3_vss_m1|s4_vss_m1|sb_vss|sr1_vss|sr2_vss|sr3_vss|sr4_vss|sv_vss|tg_d_vss|tg_fbm_vss|tg_fbs_vss|tg_s_vss|vss|vss_link|vss_link_bridge|vss_link_dip|vss_link_m1|vss_x1|vss_x2|vss_x3
+ 322.475355178
* device instance g_vss_m1_inv_clk_vss_inv_mc_vss_inv_q_vss_mph_g_nand_m_vss_nand_s2_vss_s1_vss_m1_s2_vss_m1_s3_vss_m1_s4_vss_m1_sb_vss_sr1_vss_sr2_vss_sr3_vss_sr4_vss_sv_vss_tg_d_vss_tg_fbm_vss_tg_fbs_vss_tg_s_vss_vss_vss_link_vss_link_bridge_vss_link_dip_vss_link_m1_vss_x1_vss_x2_vss_x3_t71 r0 *1 0,0
Rg_vss_m1_inv_clk_vss_inv_mc_vss_inv_q_vss_mph_g_nand_m_vss_nand_s2_vss_s1_vss_m1_s2_vss_m1_s3_vss_m1_s4_vss_m1_sb_vss_sr1_vss_sr2_vss_sr3_vss_sr4_vss_sv_vss_tg_d_vss_tg_fbm_vss_tg_fbs_vss_tg_s_vss_vss_vss_link_vss_link_bridge_vss_link_dip_vss_link_m1_vss_x1_vss_x2_vss_x3_t71
+ g_vss_m1|inv_clk_vss|inv_mc_vss|inv_q_vss|mph_g|nand_m_vss|nand_s2_vss|s1_vss_m1|s2_vss_m1|s3_vss_m1|s4_vss_m1|sb_vss|sr1_vss|sr2_vss|sr3_vss|sr4_vss|sv_vss|tg_d_vss|tg_fbm_vss|tg_fbs_vss|tg_s_vss|vss|vss_link|vss_link_bridge|vss_link_dip|vss_link_m1|vss_x1|vss_x2|vss_x3__t71
+ g_vss_m1|inv_clk_vss|inv_mc_vss|inv_q_vss|mph_g|nand_m_vss|nand_s2_vss|s1_vss_m1|s2_vss_m1|s3_vss_m1|s4_vss_m1|sb_vss|sr1_vss|sr2_vss|sr3_vss|sr4_vss|sv_vss|tg_d_vss|tg_fbm_vss|tg_fbs_vss|tg_s_vss|vss|vss_link|vss_link_bridge|vss_link_dip|vss_link_m1|vss_x1|vss_x2|vss_x3
+ 303.498565649
* device instance g_vss_m1_inv_clk_vss_inv_mc_vss_inv_q_vss_mph_g_nand_m_vss_nand_s2_vss_s1_vss_m1_s2_vss_m1_s3_vss_m1_s4_vss_m1_sb_vss_sr1_vss_sr2_vss_sr3_vss_sr4_vss_sv_vss_tg_d_vss_tg_fbm_vss_tg_fbs_vss_tg_s_vss_vss_vss_link_vss_link_bridge_vss_link_dip_vss_link_m1_vss_x1_vss_x2_vss_x3_t72 r0 *1 0,0
Rg_vss_m1_inv_clk_vss_inv_mc_vss_inv_q_vss_mph_g_nand_m_vss_nand_s2_vss_s1_vss_m1_s2_vss_m1_s3_vss_m1_s4_vss_m1_sb_vss_sr1_vss_sr2_vss_sr3_vss_sr4_vss_sv_vss_tg_d_vss_tg_fbm_vss_tg_fbs_vss_tg_s_vss_vss_vss_link_vss_link_bridge_vss_link_dip_vss_link_m1_vss_x1_vss_x2_vss_x3_t72
+ g_vss_m1|inv_clk_vss|inv_mc_vss|inv_q_vss|mph_g|nand_m_vss|nand_s2_vss|s1_vss_m1|s2_vss_m1|s3_vss_m1|s4_vss_m1|sb_vss|sr1_vss|sr2_vss|sr3_vss|sr4_vss|sv_vss|tg_d_vss|tg_fbm_vss|tg_fbs_vss|tg_s_vss|vss|vss_link|vss_link_bridge|vss_link_dip|vss_link_m1|vss_x1|vss_x2|vss_x3__t72
+ g_vss_m1|inv_clk_vss|inv_mc_vss|inv_q_vss|mph_g|nand_m_vss|nand_s2_vss|s1_vss_m1|s2_vss_m1|s3_vss_m1|s4_vss_m1|sb_vss|sr1_vss|sr2_vss|sr3_vss|sr4_vss|sv_vss|tg_d_vss|tg_fbm_vss|tg_fbs_vss|tg_s_vss|vss|vss_link|vss_link_bridge|vss_link_dip|vss_link_m1|vss_x1|vss_x2|vss_x3
+ 168.268008042
* device instance g_vss_m1_inv_clk_vss_inv_mc_vss_inv_q_vss_mph_g_nand_m_vss_nand_s2_vss_s1_vss_m1_s2_vss_m1_s3_vss_m1_s4_vss_m1_sb_vss_sr1_vss_sr2_vss_sr3_vss_sr4_vss_sv_vss_tg_d_vss_tg_fbm_vss_tg_fbs_vss_tg_s_vss_vss_vss_link_vss_link_bridge_vss_link_dip_vss_link_m1_vss_x1_vss_x2_vss_x3_t73 r0 *1 0,0
Rg_vss_m1_inv_clk_vss_inv_mc_vss_inv_q_vss_mph_g_nand_m_vss_nand_s2_vss_s1_vss_m1_s2_vss_m1_s3_vss_m1_s4_vss_m1_sb_vss_sr1_vss_sr2_vss_sr3_vss_sr4_vss_sv_vss_tg_d_vss_tg_fbm_vss_tg_fbs_vss_tg_s_vss_vss_vss_link_vss_link_bridge_vss_link_dip_vss_link_m1_vss_x1_vss_x2_vss_x3_t73
+ g_vss_m1|inv_clk_vss|inv_mc_vss|inv_q_vss|mph_g|nand_m_vss|nand_s2_vss|s1_vss_m1|s2_vss_m1|s3_vss_m1|s4_vss_m1|sb_vss|sr1_vss|sr2_vss|sr3_vss|sr4_vss|sv_vss|tg_d_vss|tg_fbm_vss|tg_fbs_vss|tg_s_vss|vss|vss_link|vss_link_bridge|vss_link_dip|vss_link_m1|vss_x1|vss_x2|vss_x3__t73
+ g_vss_m1|inv_clk_vss|inv_mc_vss|inv_q_vss|mph_g|nand_m_vss|nand_s2_vss|s1_vss_m1|s2_vss_m1|s3_vss_m1|s4_vss_m1|sb_vss|sr1_vss|sr2_vss|sr3_vss|sr4_vss|sv_vss|tg_d_vss|tg_fbm_vss|tg_fbs_vss|tg_s_vss|vss|vss_link|vss_link_bridge|vss_link_dip|vss_link_m1|vss_x1|vss_x2|vss_x3
+ 225.711007155
* device instance g_vss_m1_inv_clk_vss_inv_mc_vss_inv_q_vss_mph_g_nand_m_vss_nand_s2_vss_s1_vss_m1_s2_vss_m1_s3_vss_m1_s4_vss_m1_sb_vss_sr1_vss_sr2_vss_sr3_vss_sr4_vss_sv_vss_tg_d_vss_tg_fbm_vss_tg_fbs_vss_tg_s_vss_vss_vss_link_vss_link_bridge_vss_link_dip_vss_link_m1_vss_x1_vss_x2_vss_x3_t74 r0 *1 0,0
Rg_vss_m1_inv_clk_vss_inv_mc_vss_inv_q_vss_mph_g_nand_m_vss_nand_s2_vss_s1_vss_m1_s2_vss_m1_s3_vss_m1_s4_vss_m1_sb_vss_sr1_vss_sr2_vss_sr3_vss_sr4_vss_sv_vss_tg_d_vss_tg_fbm_vss_tg_fbs_vss_tg_s_vss_vss_vss_link_vss_link_bridge_vss_link_dip_vss_link_m1_vss_x1_vss_x2_vss_x3_t74
+ g_vss_m1|inv_clk_vss|inv_mc_vss|inv_q_vss|mph_g|nand_m_vss|nand_s2_vss|s1_vss_m1|s2_vss_m1|s3_vss_m1|s4_vss_m1|sb_vss|sr1_vss|sr2_vss|sr3_vss|sr4_vss|sv_vss|tg_d_vss|tg_fbm_vss|tg_fbs_vss|tg_s_vss|vss|vss_link|vss_link_bridge|vss_link_dip|vss_link_m1|vss_x1|vss_x2|vss_x3__t74
+ g_vss_m1|inv_clk_vss|inv_mc_vss|inv_q_vss|mph_g|nand_m_vss|nand_s2_vss|s1_vss_m1|s2_vss_m1|s3_vss_m1|s4_vss_m1|sb_vss|sr1_vss|sr2_vss|sr3_vss|sr4_vss|sv_vss|tg_d_vss|tg_fbm_vss|tg_fbs_vss|tg_s_vss|vss|vss_link|vss_link_bridge|vss_link_dip|vss_link_m1|vss_x1|vss_x2|vss_x3
+ 244.360919264
* device instance g_vss_m1_inv_clk_vss_inv_mc_vss_inv_q_vss_mph_g_nand_m_vss_nand_s2_vss_s1_vss_m1_s2_vss_m1_s3_vss_m1_s4_vss_m1_sb_vss_sr1_vss_sr2_vss_sr3_vss_sr4_vss_sv_vss_tg_d_vss_tg_fbm_vss_tg_fbs_vss_tg_s_vss_vss_vss_link_vss_link_bridge_vss_link_dip_vss_link_m1_vss_x1_vss_x2_vss_x3_t75 r0 *1 0,0
Rg_vss_m1_inv_clk_vss_inv_mc_vss_inv_q_vss_mph_g_nand_m_vss_nand_s2_vss_s1_vss_m1_s2_vss_m1_s3_vss_m1_s4_vss_m1_sb_vss_sr1_vss_sr2_vss_sr3_vss_sr4_vss_sv_vss_tg_d_vss_tg_fbm_vss_tg_fbs_vss_tg_s_vss_vss_vss_link_vss_link_bridge_vss_link_dip_vss_link_m1_vss_x1_vss_x2_vss_x3_t75
+ g_vss_m1|inv_clk_vss|inv_mc_vss|inv_q_vss|mph_g|nand_m_vss|nand_s2_vss|s1_vss_m1|s2_vss_m1|s3_vss_m1|s4_vss_m1|sb_vss|sr1_vss|sr2_vss|sr3_vss|sr4_vss|sv_vss|tg_d_vss|tg_fbm_vss|tg_fbs_vss|tg_s_vss|vss|vss_link|vss_link_bridge|vss_link_dip|vss_link_m1|vss_x1|vss_x2|vss_x3__t75
+ g_vss_m1|inv_clk_vss|inv_mc_vss|inv_q_vss|mph_g|nand_m_vss|nand_s2_vss|s1_vss_m1|s2_vss_m1|s3_vss_m1|s4_vss_m1|sb_vss|sr1_vss|sr2_vss|sr3_vss|sr4_vss|sv_vss|tg_d_vss|tg_fbm_vss|tg_fbs_vss|tg_s_vss|vss|vss_link|vss_link_bridge|vss_link_dip|vss_link_m1|vss_x1|vss_x2|vss_x3
+ 247.335390253
* device instance g_vss_m1_inv_clk_vss_inv_mc_vss_inv_q_vss_mph_g_nand_m_vss_nand_s2_vss_s1_vss_m1_s2_vss_m1_s3_vss_m1_s4_vss_m1_sb_vss_sr1_vss_sr2_vss_sr3_vss_sr4_vss_sv_vss_tg_d_vss_tg_fbm_vss_tg_fbs_vss_tg_s_vss_vss_vss_link_vss_link_bridge_vss_link_dip_vss_link_m1_vss_x1_vss_x2_vss_x3_t76 r0 *1 0,0
Rg_vss_m1_inv_clk_vss_inv_mc_vss_inv_q_vss_mph_g_nand_m_vss_nand_s2_vss_s1_vss_m1_s2_vss_m1_s3_vss_m1_s4_vss_m1_sb_vss_sr1_vss_sr2_vss_sr3_vss_sr4_vss_sv_vss_tg_d_vss_tg_fbm_vss_tg_fbs_vss_tg_s_vss_vss_vss_link_vss_link_bridge_vss_link_dip_vss_link_m1_vss_x1_vss_x2_vss_x3_t76
+ g_vss_m1|inv_clk_vss|inv_mc_vss|inv_q_vss|mph_g|nand_m_vss|nand_s2_vss|s1_vss_m1|s2_vss_m1|s3_vss_m1|s4_vss_m1|sb_vss|sr1_vss|sr2_vss|sr3_vss|sr4_vss|sv_vss|tg_d_vss|tg_fbm_vss|tg_fbs_vss|tg_s_vss|vss|vss_link|vss_link_bridge|vss_link_dip|vss_link_m1|vss_x1|vss_x2|vss_x3__t76
+ g_vss_m1|inv_clk_vss|inv_mc_vss|inv_q_vss|mph_g|nand_m_vss|nand_s2_vss|s1_vss_m1|s2_vss_m1|s3_vss_m1|s4_vss_m1|sb_vss|sr1_vss|sr2_vss|sr3_vss|sr4_vss|sv_vss|tg_d_vss|tg_fbm_vss|tg_fbs_vss|tg_s_vss|vss|vss_link|vss_link_bridge|vss_link_dip|vss_link_m1|vss_x1|vss_x2|vss_x3
+ 315.183708737
* device instance g_vss_m1_inv_clk_vss_inv_mc_vss_inv_q_vss_mph_g_nand_m_vss_nand_s2_vss_s1_vss_m1_s2_vss_m1_s3_vss_m1_s4_vss_m1_sb_vss_sr1_vss_sr2_vss_sr3_vss_sr4_vss_sv_vss_tg_d_vss_tg_fbm_vss_tg_fbs_vss_tg_s_vss_vss_vss_link_vss_link_bridge_vss_link_dip_vss_link_m1_vss_x1_vss_x2_vss_x3_t77 r0 *1 0,0
Rg_vss_m1_inv_clk_vss_inv_mc_vss_inv_q_vss_mph_g_nand_m_vss_nand_s2_vss_s1_vss_m1_s2_vss_m1_s3_vss_m1_s4_vss_m1_sb_vss_sr1_vss_sr2_vss_sr3_vss_sr4_vss_sv_vss_tg_d_vss_tg_fbm_vss_tg_fbs_vss_tg_s_vss_vss_vss_link_vss_link_bridge_vss_link_dip_vss_link_m1_vss_x1_vss_x2_vss_x3_t77
+ g_vss_m1|inv_clk_vss|inv_mc_vss|inv_q_vss|mph_g|nand_m_vss|nand_s2_vss|s1_vss_m1|s2_vss_m1|s3_vss_m1|s4_vss_m1|sb_vss|sr1_vss|sr2_vss|sr3_vss|sr4_vss|sv_vss|tg_d_vss|tg_fbm_vss|tg_fbs_vss|tg_s_vss|vss|vss_link|vss_link_bridge|vss_link_dip|vss_link_m1|vss_x1|vss_x2|vss_x3__t77
+ g_vss_m1|inv_clk_vss|inv_mc_vss|inv_q_vss|mph_g|nand_m_vss|nand_s2_vss|s1_vss_m1|s2_vss_m1|s3_vss_m1|s4_vss_m1|sb_vss|sr1_vss|sr2_vss|sr3_vss|sr4_vss|sv_vss|tg_d_vss|tg_fbm_vss|tg_fbs_vss|tg_s_vss|vss|vss_link|vss_link_bridge|vss_link_dip|vss_link_m1|vss_x1|vss_x2|vss_x3
+ 400.016407853
* device instance g_vss_m1_inv_clk_vss_inv_mc_vss_inv_q_vss_mph_g_nand_m_vss_nand_s2_vss_s1_vss_m1_s2_vss_m1_s3_vss_m1_s4_vss_m1_sb_vss_sr1_vss_sr2_vss_sr3_vss_sr4_vss_sv_vss_tg_d_vss_tg_fbm_vss_tg_fbs_vss_tg_s_vss_vss_vss_link_vss_link_bridge_vss_link_dip_vss_link_m1_vss_x1_vss_x2_vss_x3_t78 r0 *1 0,0
Rg_vss_m1_inv_clk_vss_inv_mc_vss_inv_q_vss_mph_g_nand_m_vss_nand_s2_vss_s1_vss_m1_s2_vss_m1_s3_vss_m1_s4_vss_m1_sb_vss_sr1_vss_sr2_vss_sr3_vss_sr4_vss_sv_vss_tg_d_vss_tg_fbm_vss_tg_fbs_vss_tg_s_vss_vss_vss_link_vss_link_bridge_vss_link_dip_vss_link_m1_vss_x1_vss_x2_vss_x3_t78
+ g_vss_m1|inv_clk_vss|inv_mc_vss|inv_q_vss|mph_g|nand_m_vss|nand_s2_vss|s1_vss_m1|s2_vss_m1|s3_vss_m1|s4_vss_m1|sb_vss|sr1_vss|sr2_vss|sr3_vss|sr4_vss|sv_vss|tg_d_vss|tg_fbm_vss|tg_fbs_vss|tg_s_vss|vss|vss_link|vss_link_bridge|vss_link_dip|vss_link_m1|vss_x1|vss_x2|vss_x3__t78
+ g_vss_m1|inv_clk_vss|inv_mc_vss|inv_q_vss|mph_g|nand_m_vss|nand_s2_vss|s1_vss_m1|s2_vss_m1|s3_vss_m1|s4_vss_m1|sb_vss|sr1_vss|sr2_vss|sr3_vss|sr4_vss|sv_vss|tg_d_vss|tg_fbm_vss|tg_fbs_vss|tg_s_vss|vss|vss_link|vss_link_bridge|vss_link_dip|vss_link_m1|vss_x1|vss_x2|vss_x3
+ 468.362378116
* device instance g_vss_m1_inv_clk_vss_inv_mc_vss_inv_q_vss_mph_g_nand_m_vss_nand_s2_vss_s1_vss_m1_s2_vss_m1_s3_vss_m1_s4_vss_m1_sb_vss_sr1_vss_sr2_vss_sr3_vss_sr4_vss_sv_vss_tg_d_vss_tg_fbm_vss_tg_fbs_vss_tg_s_vss_vss_vss_link_vss_link_bridge_vss_link_dip_vss_link_m1_vss_x1_vss_x2_vss_x3_t79 r0 *1 0,0
Rg_vss_m1_inv_clk_vss_inv_mc_vss_inv_q_vss_mph_g_nand_m_vss_nand_s2_vss_s1_vss_m1_s2_vss_m1_s3_vss_m1_s4_vss_m1_sb_vss_sr1_vss_sr2_vss_sr3_vss_sr4_vss_sv_vss_tg_d_vss_tg_fbm_vss_tg_fbs_vss_tg_s_vss_vss_vss_link_vss_link_bridge_vss_link_dip_vss_link_m1_vss_x1_vss_x2_vss_x3_t79
+ g_vss_m1|inv_clk_vss|inv_mc_vss|inv_q_vss|mph_g|nand_m_vss|nand_s2_vss|s1_vss_m1|s2_vss_m1|s3_vss_m1|s4_vss_m1|sb_vss|sr1_vss|sr2_vss|sr3_vss|sr4_vss|sv_vss|tg_d_vss|tg_fbm_vss|tg_fbs_vss|tg_s_vss|vss|vss_link|vss_link_bridge|vss_link_dip|vss_link_m1|vss_x1|vss_x2|vss_x3__t79
+ g_vss_m1|inv_clk_vss|inv_mc_vss|inv_q_vss|mph_g|nand_m_vss|nand_s2_vss|s1_vss_m1|s2_vss_m1|s3_vss_m1|s4_vss_m1|sb_vss|sr1_vss|sr2_vss|sr3_vss|sr4_vss|sv_vss|tg_d_vss|tg_fbm_vss|tg_fbs_vss|tg_s_vss|vss|vss_link|vss_link_bridge|vss_link_dip|vss_link_m1|vss_x1|vss_x2|vss_x3
+ 553.530807494
* device instance g_vss_m1_inv_clk_vss_inv_mc_vss_inv_q_vss_mph_g_nand_m_vss_nand_s2_vss_s1_vss_m1_s2_vss_m1_s3_vss_m1_s4_vss_m1_sb_vss_sr1_vss_sr2_vss_sr3_vss_sr4_vss_sv_vss_tg_d_vss_tg_fbm_vss_tg_fbs_vss_tg_s_vss_vss_vss_link_vss_link_bridge_vss_link_dip_vss_link_m1_vss_x1_vss_x2_vss_x3_t80 r0 *1 0,0
Rg_vss_m1_inv_clk_vss_inv_mc_vss_inv_q_vss_mph_g_nand_m_vss_nand_s2_vss_s1_vss_m1_s2_vss_m1_s3_vss_m1_s4_vss_m1_sb_vss_sr1_vss_sr2_vss_sr3_vss_sr4_vss_sv_vss_tg_d_vss_tg_fbm_vss_tg_fbs_vss_tg_s_vss_vss_vss_link_vss_link_bridge_vss_link_dip_vss_link_m1_vss_x1_vss_x2_vss_x3_t80
+ g_vss_m1|inv_clk_vss|inv_mc_vss|inv_q_vss|mph_g|nand_m_vss|nand_s2_vss|s1_vss_m1|s2_vss_m1|s3_vss_m1|s4_vss_m1|sb_vss|sr1_vss|sr2_vss|sr3_vss|sr4_vss|sv_vss|tg_d_vss|tg_fbm_vss|tg_fbs_vss|tg_s_vss|vss|vss_link|vss_link_bridge|vss_link_dip|vss_link_m1|vss_x1|vss_x2|vss_x3__t80
+ g_vss_m1|inv_clk_vss|inv_mc_vss|inv_q_vss|mph_g|nand_m_vss|nand_s2_vss|s1_vss_m1|s2_vss_m1|s3_vss_m1|s4_vss_m1|sb_vss|sr1_vss|sr2_vss|sr3_vss|sr4_vss|sv_vss|tg_d_vss|tg_fbm_vss|tg_fbs_vss|tg_s_vss|vss|vss_link|vss_link_bridge|vss_link_dip|vss_link_m1|vss_x1|vss_x2|vss_x3
+ 163.899726315
* device instance g_vss_m1_inv_clk_vss_inv_mc_vss_inv_q_vss_mph_g_nand_m_vss_nand_s2_vss_s1_vss_m1_s2_vss_m1_s3_vss_m1_s4_vss_m1_sb_vss_sr1_vss_sr2_vss_sr3_vss_sr4_vss_sv_vss_tg_d_vss_tg_fbm_vss_tg_fbs_vss_tg_s_vss_vss_vss_link_vss_link_bridge_vss_link_dip_vss_link_m1_vss_x1_vss_x2_vss_x3_t81 r0 *1 0,0
Rg_vss_m1_inv_clk_vss_inv_mc_vss_inv_q_vss_mph_g_nand_m_vss_nand_s2_vss_s1_vss_m1_s2_vss_m1_s3_vss_m1_s4_vss_m1_sb_vss_sr1_vss_sr2_vss_sr3_vss_sr4_vss_sv_vss_tg_d_vss_tg_fbm_vss_tg_fbs_vss_tg_s_vss_vss_vss_link_vss_link_bridge_vss_link_dip_vss_link_m1_vss_x1_vss_x2_vss_x3_t81
+ g_vss_m1|inv_clk_vss|inv_mc_vss|inv_q_vss|mph_g|nand_m_vss|nand_s2_vss|s1_vss_m1|s2_vss_m1|s3_vss_m1|s4_vss_m1|sb_vss|sr1_vss|sr2_vss|sr3_vss|sr4_vss|sv_vss|tg_d_vss|tg_fbm_vss|tg_fbs_vss|tg_s_vss|vss|vss_link|vss_link_bridge|vss_link_dip|vss_link_m1|vss_x1|vss_x2|vss_x3__t81
+ g_vss_m1|inv_clk_vss|inv_mc_vss|inv_q_vss|mph_g|nand_m_vss|nand_s2_vss|s1_vss_m1|s2_vss_m1|s3_vss_m1|s4_vss_m1|sb_vss|sr1_vss|sr2_vss|sr3_vss|sr4_vss|sv_vss|tg_d_vss|tg_fbm_vss|tg_fbs_vss|tg_s_vss|vss|vss_link|vss_link_bridge|vss_link_dip|vss_link_m1|vss_x1|vss_x2|vss_x3
+ 99.4050351164
* device instance g_vss_m1_inv_clk_vss_inv_mc_vss_inv_q_vss_mph_g_nand_m_vss_nand_s2_vss_s1_vss_m1_s2_vss_m1_s3_vss_m1_s4_vss_m1_sb_vss_sr1_vss_sr2_vss_sr3_vss_sr4_vss_sv_vss_tg_d_vss_tg_fbm_vss_tg_fbs_vss_tg_s_vss_vss_vss_link_vss_link_bridge_vss_link_dip_vss_link_m1_vss_x1_vss_x2_vss_x3_t82 r0 *1 0,0
Rg_vss_m1_inv_clk_vss_inv_mc_vss_inv_q_vss_mph_g_nand_m_vss_nand_s2_vss_s1_vss_m1_s2_vss_m1_s3_vss_m1_s4_vss_m1_sb_vss_sr1_vss_sr2_vss_sr3_vss_sr4_vss_sv_vss_tg_d_vss_tg_fbm_vss_tg_fbs_vss_tg_s_vss_vss_vss_link_vss_link_bridge_vss_link_dip_vss_link_m1_vss_x1_vss_x2_vss_x3_t82
+ g_vss_m1|inv_clk_vss|inv_mc_vss|inv_q_vss|mph_g|nand_m_vss|nand_s2_vss|s1_vss_m1|s2_vss_m1|s3_vss_m1|s4_vss_m1|sb_vss|sr1_vss|sr2_vss|sr3_vss|sr4_vss|sv_vss|tg_d_vss|tg_fbm_vss|tg_fbs_vss|tg_s_vss|vss|vss_link|vss_link_bridge|vss_link_dip|vss_link_m1|vss_x1|vss_x2|vss_x3__t82
+ g_vss_m1|inv_clk_vss|inv_mc_vss|inv_q_vss|mph_g|nand_m_vss|nand_s2_vss|s1_vss_m1|s2_vss_m1|s3_vss_m1|s4_vss_m1|sb_vss|sr1_vss|sr2_vss|sr3_vss|sr4_vss|sv_vss|tg_d_vss|tg_fbm_vss|tg_fbs_vss|tg_s_vss|vss|vss_link|vss_link_bridge|vss_link_dip|vss_link_m1|vss_x1|vss_x2|vss_x3
+ 43.9359458016
* device instance g_vss_m1_inv_clk_vss_inv_mc_vss_inv_q_vss_mph_g_nand_m_vss_nand_s2_vss_s1_vss_m1_s2_vss_m1_s3_vss_m1_s4_vss_m1_sb_vss_sr1_vss_sr2_vss_sr3_vss_sr4_vss_sv_vss_tg_d_vss_tg_fbm_vss_tg_fbs_vss_tg_s_vss_vss_vss_link_vss_link_bridge_vss_link_dip_vss_link_m1_vss_x1_vss_x2_vss_x3_t83 r0 *1 0,0
Rg_vss_m1_inv_clk_vss_inv_mc_vss_inv_q_vss_mph_g_nand_m_vss_nand_s2_vss_s1_vss_m1_s2_vss_m1_s3_vss_m1_s4_vss_m1_sb_vss_sr1_vss_sr2_vss_sr3_vss_sr4_vss_sv_vss_tg_d_vss_tg_fbm_vss_tg_fbs_vss_tg_s_vss_vss_vss_link_vss_link_bridge_vss_link_dip_vss_link_m1_vss_x1_vss_x2_vss_x3_t83
+ g_vss_m1|inv_clk_vss|inv_mc_vss|inv_q_vss|mph_g|nand_m_vss|nand_s2_vss|s1_vss_m1|s2_vss_m1|s3_vss_m1|s4_vss_m1|sb_vss|sr1_vss|sr2_vss|sr3_vss|sr4_vss|sv_vss|tg_d_vss|tg_fbm_vss|tg_fbs_vss|tg_s_vss|vss|vss_link|vss_link_bridge|vss_link_dip|vss_link_m1|vss_x1|vss_x2|vss_x3__t83
+ g_vss_m1|inv_clk_vss|inv_mc_vss|inv_q_vss|mph_g|nand_m_vss|nand_s2_vss|s1_vss_m1|s2_vss_m1|s3_vss_m1|s4_vss_m1|sb_vss|sr1_vss|sr2_vss|sr3_vss|sr4_vss|sv_vss|tg_d_vss|tg_fbm_vss|tg_fbs_vss|tg_s_vss|vss|vss_link|vss_link_bridge|vss_link_dip|vss_link_m1|vss_x1|vss_x2|vss_x3
+ 78.3123474019
* device instance g_vss_m1_inv_clk_vss_inv_mc_vss_inv_q_vss_mph_g_nand_m_vss_nand_s2_vss_s1_vss_m1_s2_vss_m1_s3_vss_m1_s4_vss_m1_sb_vss_sr1_vss_sr2_vss_sr3_vss_sr4_vss_sv_vss_tg_d_vss_tg_fbm_vss_tg_fbs_vss_tg_s_vss_vss_vss_link_vss_link_bridge_vss_link_dip_vss_link_m1_vss_x1_vss_x2_vss_x3_t84 r0 *1 0,0
Rg_vss_m1_inv_clk_vss_inv_mc_vss_inv_q_vss_mph_g_nand_m_vss_nand_s2_vss_s1_vss_m1_s2_vss_m1_s3_vss_m1_s4_vss_m1_sb_vss_sr1_vss_sr2_vss_sr3_vss_sr4_vss_sv_vss_tg_d_vss_tg_fbm_vss_tg_fbs_vss_tg_s_vss_vss_vss_link_vss_link_bridge_vss_link_dip_vss_link_m1_vss_x1_vss_x2_vss_x3_t84
+ g_vss_m1|inv_clk_vss|inv_mc_vss|inv_q_vss|mph_g|nand_m_vss|nand_s2_vss|s1_vss_m1|s2_vss_m1|s3_vss_m1|s4_vss_m1|sb_vss|sr1_vss|sr2_vss|sr3_vss|sr4_vss|sv_vss|tg_d_vss|tg_fbm_vss|tg_fbs_vss|tg_s_vss|vss|vss_link|vss_link_bridge|vss_link_dip|vss_link_m1|vss_x1|vss_x2|vss_x3__t84
+ g_vss_m1|inv_clk_vss|inv_mc_vss|inv_q_vss|mph_g|nand_m_vss|nand_s2_vss|s1_vss_m1|s2_vss_m1|s3_vss_m1|s4_vss_m1|sb_vss|sr1_vss|sr2_vss|sr3_vss|sr4_vss|sv_vss|tg_d_vss|tg_fbm_vss|tg_fbs_vss|tg_s_vss|vss|vss_link|vss_link_bridge|vss_link_dip|vss_link_m1|vss_x1|vss_x2|vss_x3
+ 223.448391176
* device instance g_vss_m1_inv_clk_vss_inv_mc_vss_inv_q_vss_mph_g_nand_m_vss_nand_s2_vss_s1_vss_m1_s2_vss_m1_s3_vss_m1_s4_vss_m1_sb_vss_sr1_vss_sr2_vss_sr3_vss_sr4_vss_sv_vss_tg_d_vss_tg_fbm_vss_tg_fbs_vss_tg_s_vss_vss_vss_link_vss_link_bridge_vss_link_dip_vss_link_m1_vss_x1_vss_x2_vss_x3_t85 r0 *1 0,0
Rg_vss_m1_inv_clk_vss_inv_mc_vss_inv_q_vss_mph_g_nand_m_vss_nand_s2_vss_s1_vss_m1_s2_vss_m1_s3_vss_m1_s4_vss_m1_sb_vss_sr1_vss_sr2_vss_sr3_vss_sr4_vss_sv_vss_tg_d_vss_tg_fbm_vss_tg_fbs_vss_tg_s_vss_vss_vss_link_vss_link_bridge_vss_link_dip_vss_link_m1_vss_x1_vss_x2_vss_x3_t85
+ g_vss_m1|inv_clk_vss|inv_mc_vss|inv_q_vss|mph_g|nand_m_vss|nand_s2_vss|s1_vss_m1|s2_vss_m1|s3_vss_m1|s4_vss_m1|sb_vss|sr1_vss|sr2_vss|sr3_vss|sr4_vss|sv_vss|tg_d_vss|tg_fbm_vss|tg_fbs_vss|tg_s_vss|vss|vss_link|vss_link_bridge|vss_link_dip|vss_link_m1|vss_x1|vss_x2|vss_x3__t85
+ g_vss_m1|inv_clk_vss|inv_mc_vss|inv_q_vss|mph_g|nand_m_vss|nand_s2_vss|s1_vss_m1|s2_vss_m1|s3_vss_m1|s4_vss_m1|sb_vss|sr1_vss|sr2_vss|sr3_vss|sr4_vss|sv_vss|tg_d_vss|tg_fbm_vss|tg_fbs_vss|tg_s_vss|vss|vss_link|vss_link_bridge|vss_link_dip|vss_link_m1|vss_x1|vss_x2|vss_x3
+ 156.660497239
* device instance g_vss_m1_inv_clk_vss_inv_mc_vss_inv_q_vss_mph_g_nand_m_vss_nand_s2_vss_s1_vss_m1_s2_vss_m1_s3_vss_m1_s4_vss_m1_sb_vss_sr1_vss_sr2_vss_sr3_vss_sr4_vss_sv_vss_tg_d_vss_tg_fbm_vss_tg_fbs_vss_tg_s_vss_vss_vss_link_vss_link_bridge_vss_link_dip_vss_link_m1_vss_x1_vss_x2_vss_x3_t86 r0 *1 0,0
Rg_vss_m1_inv_clk_vss_inv_mc_vss_inv_q_vss_mph_g_nand_m_vss_nand_s2_vss_s1_vss_m1_s2_vss_m1_s3_vss_m1_s4_vss_m1_sb_vss_sr1_vss_sr2_vss_sr3_vss_sr4_vss_sv_vss_tg_d_vss_tg_fbm_vss_tg_fbs_vss_tg_s_vss_vss_vss_link_vss_link_bridge_vss_link_dip_vss_link_m1_vss_x1_vss_x2_vss_x3_t86
+ g_vss_m1|inv_clk_vss|inv_mc_vss|inv_q_vss|mph_g|nand_m_vss|nand_s2_vss|s1_vss_m1|s2_vss_m1|s3_vss_m1|s4_vss_m1|sb_vss|sr1_vss|sr2_vss|sr3_vss|sr4_vss|sv_vss|tg_d_vss|tg_fbm_vss|tg_fbs_vss|tg_s_vss|vss|vss_link|vss_link_bridge|vss_link_dip|vss_link_m1|vss_x1|vss_x2|vss_x3__t86
+ g_vss_m1|inv_clk_vss|inv_mc_vss|inv_q_vss|mph_g|nand_m_vss|nand_s2_vss|s1_vss_m1|s2_vss_m1|s3_vss_m1|s4_vss_m1|sb_vss|sr1_vss|sr2_vss|sr3_vss|sr4_vss|sv_vss|tg_d_vss|tg_fbm_vss|tg_fbs_vss|tg_s_vss|vss|vss_link|vss_link_bridge|vss_link_dip|vss_link_m1|vss_x1|vss_x2|vss_x3
+ 307.732923931
* device instance g_vss_m1_inv_clk_vss_inv_mc_vss_inv_q_vss_mph_g_nand_m_vss_nand_s2_vss_s1_vss_m1_s2_vss_m1_s3_vss_m1_s4_vss_m1_sb_vss_sr1_vss_sr2_vss_sr3_vss_sr4_vss_sv_vss_tg_d_vss_tg_fbm_vss_tg_fbs_vss_tg_s_vss_vss_vss_link_vss_link_bridge_vss_link_dip_vss_link_m1_vss_x1_vss_x2_vss_x3_t87 r0 *1 0,0
Rg_vss_m1_inv_clk_vss_inv_mc_vss_inv_q_vss_mph_g_nand_m_vss_nand_s2_vss_s1_vss_m1_s2_vss_m1_s3_vss_m1_s4_vss_m1_sb_vss_sr1_vss_sr2_vss_sr3_vss_sr4_vss_sv_vss_tg_d_vss_tg_fbm_vss_tg_fbs_vss_tg_s_vss_vss_vss_link_vss_link_bridge_vss_link_dip_vss_link_m1_vss_x1_vss_x2_vss_x3_t87
+ g_vss_m1|inv_clk_vss|inv_mc_vss|inv_q_vss|mph_g|nand_m_vss|nand_s2_vss|s1_vss_m1|s2_vss_m1|s3_vss_m1|s4_vss_m1|sb_vss|sr1_vss|sr2_vss|sr3_vss|sr4_vss|sv_vss|tg_d_vss|tg_fbm_vss|tg_fbs_vss|tg_s_vss|vss|vss_link|vss_link_bridge|vss_link_dip|vss_link_m1|vss_x1|vss_x2|vss_x3__t87
+ g_vss_m1|inv_clk_vss|inv_mc_vss|inv_q_vss|mph_g|nand_m_vss|nand_s2_vss|s1_vss_m1|s2_vss_m1|s3_vss_m1|s4_vss_m1|sb_vss|sr1_vss|sr2_vss|sr3_vss|sr4_vss|sv_vss|tg_d_vss|tg_fbm_vss|tg_fbs_vss|tg_s_vss|vss|vss_link|vss_link_bridge|vss_link_dip|vss_link_m1|vss_x1|vss_x2|vss_x3
+ 223.448391176
* device instance g_vss_m1_inv_clk_vss_inv_mc_vss_inv_q_vss_mph_g_nand_m_vss_nand_s2_vss_s1_vss_m1_s2_vss_m1_s3_vss_m1_s4_vss_m1_sb_vss_sr1_vss_sr2_vss_sr3_vss_sr4_vss_sv_vss_tg_d_vss_tg_fbm_vss_tg_fbs_vss_tg_s_vss_vss_vss_link_vss_link_bridge_vss_link_dip_vss_link_m1_vss_x1_vss_x2_vss_x3_t88 r0 *1 0,0
Rg_vss_m1_inv_clk_vss_inv_mc_vss_inv_q_vss_mph_g_nand_m_vss_nand_s2_vss_s1_vss_m1_s2_vss_m1_s3_vss_m1_s4_vss_m1_sb_vss_sr1_vss_sr2_vss_sr3_vss_sr4_vss_sv_vss_tg_d_vss_tg_fbm_vss_tg_fbs_vss_tg_s_vss_vss_vss_link_vss_link_bridge_vss_link_dip_vss_link_m1_vss_x1_vss_x2_vss_x3_t88
+ g_vss_m1|inv_clk_vss|inv_mc_vss|inv_q_vss|mph_g|nand_m_vss|nand_s2_vss|s1_vss_m1|s2_vss_m1|s3_vss_m1|s4_vss_m1|sb_vss|sr1_vss|sr2_vss|sr3_vss|sr4_vss|sv_vss|tg_d_vss|tg_fbm_vss|tg_fbs_vss|tg_s_vss|vss|vss_link|vss_link_bridge|vss_link_dip|vss_link_m1|vss_x1|vss_x2|vss_x3__t88
+ g_vss_m1|inv_clk_vss|inv_mc_vss|inv_q_vss|mph_g|nand_m_vss|nand_s2_vss|s1_vss_m1|s2_vss_m1|s3_vss_m1|s4_vss_m1|sb_vss|sr1_vss|sr2_vss|sr3_vss|sr4_vss|sv_vss|tg_d_vss|tg_fbm_vss|tg_fbs_vss|tg_s_vss|vss|vss_link|vss_link_bridge|vss_link_dip|vss_link_m1|vss_x1|vss_x2|vss_x3
+ 156.660497239
* device instance g_vss_m1_inv_clk_vss_inv_mc_vss_inv_q_vss_mph_g_nand_m_vss_nand_s2_vss_s1_vss_m1_s2_vss_m1_s3_vss_m1_s4_vss_m1_sb_vss_sr1_vss_sr2_vss_sr3_vss_sr4_vss_sv_vss_tg_d_vss_tg_fbm_vss_tg_fbs_vss_tg_s_vss_vss_vss_link_vss_link_bridge_vss_link_dip_vss_link_m1_vss_x1_vss_x2_vss_x3_t89 r0 *1 0,0
Rg_vss_m1_inv_clk_vss_inv_mc_vss_inv_q_vss_mph_g_nand_m_vss_nand_s2_vss_s1_vss_m1_s2_vss_m1_s3_vss_m1_s4_vss_m1_sb_vss_sr1_vss_sr2_vss_sr3_vss_sr4_vss_sv_vss_tg_d_vss_tg_fbm_vss_tg_fbs_vss_tg_s_vss_vss_vss_link_vss_link_bridge_vss_link_dip_vss_link_m1_vss_x1_vss_x2_vss_x3_t89
+ g_vss_m1|inv_clk_vss|inv_mc_vss|inv_q_vss|mph_g|nand_m_vss|nand_s2_vss|s1_vss_m1|s2_vss_m1|s3_vss_m1|s4_vss_m1|sb_vss|sr1_vss|sr2_vss|sr3_vss|sr4_vss|sv_vss|tg_d_vss|tg_fbm_vss|tg_fbs_vss|tg_s_vss|vss|vss_link|vss_link_bridge|vss_link_dip|vss_link_m1|vss_x1|vss_x2|vss_x3__t89
+ g_vss_m1|inv_clk_vss|inv_mc_vss|inv_q_vss|mph_g|nand_m_vss|nand_s2_vss|s1_vss_m1|s2_vss_m1|s3_vss_m1|s4_vss_m1|sb_vss|sr1_vss|sr2_vss|sr3_vss|sr4_vss|sv_vss|tg_d_vss|tg_fbm_vss|tg_fbs_vss|tg_s_vss|vss|vss_link|vss_link_bridge|vss_link_dip|vss_link_m1|vss_x1|vss_x2|vss_x3
+ 78.3123474019
* device instance g_vss_m1_inv_clk_vss_inv_mc_vss_inv_q_vss_mph_g_nand_m_vss_nand_s2_vss_s1_vss_m1_s2_vss_m1_s3_vss_m1_s4_vss_m1_sb_vss_sr1_vss_sr2_vss_sr3_vss_sr4_vss_sv_vss_tg_d_vss_tg_fbm_vss_tg_fbs_vss_tg_s_vss_vss_vss_link_vss_link_bridge_vss_link_dip_vss_link_m1_vss_x1_vss_x2_vss_x3_t90 r0 *1 0,0
Rg_vss_m1_inv_clk_vss_inv_mc_vss_inv_q_vss_mph_g_nand_m_vss_nand_s2_vss_s1_vss_m1_s2_vss_m1_s3_vss_m1_s4_vss_m1_sb_vss_sr1_vss_sr2_vss_sr3_vss_sr4_vss_sv_vss_tg_d_vss_tg_fbm_vss_tg_fbs_vss_tg_s_vss_vss_vss_link_vss_link_bridge_vss_link_dip_vss_link_m1_vss_x1_vss_x2_vss_x3_t90
+ g_vss_m1|inv_clk_vss|inv_mc_vss|inv_q_vss|mph_g|nand_m_vss|nand_s2_vss|s1_vss_m1|s2_vss_m1|s3_vss_m1|s4_vss_m1|sb_vss|sr1_vss|sr2_vss|sr3_vss|sr4_vss|sv_vss|tg_d_vss|tg_fbm_vss|tg_fbs_vss|tg_s_vss|vss|vss_link|vss_link_bridge|vss_link_dip|vss_link_m1|vss_x1|vss_x2|vss_x3__t90
+ g_vss_m1|inv_clk_vss|inv_mc_vss|inv_q_vss|mph_g|nand_m_vss|nand_s2_vss|s1_vss_m1|s2_vss_m1|s3_vss_m1|s4_vss_m1|sb_vss|sr1_vss|sr2_vss|sr3_vss|sr4_vss|sv_vss|tg_d_vss|tg_fbm_vss|tg_fbs_vss|tg_s_vss|vss|vss_link|vss_link_bridge|vss_link_dip|vss_link_m1|vss_x1|vss_x2|vss_x3
+ 43.9359458016
* device instance g_vss_m1_inv_clk_vss_inv_mc_vss_inv_q_vss_mph_g_nand_m_vss_nand_s2_vss_s1_vss_m1_s2_vss_m1_s3_vss_m1_s4_vss_m1_sb_vss_sr1_vss_sr2_vss_sr3_vss_sr4_vss_sv_vss_tg_d_vss_tg_fbm_vss_tg_fbs_vss_tg_s_vss_vss_vss_link_vss_link_bridge_vss_link_dip_vss_link_m1_vss_x1_vss_x2_vss_x3_t91 r0 *1 0,0
Rg_vss_m1_inv_clk_vss_inv_mc_vss_inv_q_vss_mph_g_nand_m_vss_nand_s2_vss_s1_vss_m1_s2_vss_m1_s3_vss_m1_s4_vss_m1_sb_vss_sr1_vss_sr2_vss_sr3_vss_sr4_vss_sv_vss_tg_d_vss_tg_fbm_vss_tg_fbs_vss_tg_s_vss_vss_vss_link_vss_link_bridge_vss_link_dip_vss_link_m1_vss_x1_vss_x2_vss_x3_t91
+ g_vss_m1|inv_clk_vss|inv_mc_vss|inv_q_vss|mph_g|nand_m_vss|nand_s2_vss|s1_vss_m1|s2_vss_m1|s3_vss_m1|s4_vss_m1|sb_vss|sr1_vss|sr2_vss|sr3_vss|sr4_vss|sv_vss|tg_d_vss|tg_fbm_vss|tg_fbs_vss|tg_s_vss|vss|vss_link|vss_link_bridge|vss_link_dip|vss_link_m1|vss_x1|vss_x2|vss_x3__t91
+ g_vss_m1|inv_clk_vss|inv_mc_vss|inv_q_vss|mph_g|nand_m_vss|nand_s2_vss|s1_vss_m1|s2_vss_m1|s3_vss_m1|s4_vss_m1|sb_vss|sr1_vss|sr2_vss|sr3_vss|sr4_vss|sv_vss|tg_d_vss|tg_fbm_vss|tg_fbs_vss|tg_s_vss|vss|vss_link|vss_link_bridge|vss_link_dip|vss_link_m1|vss_x1|vss_x2|vss_x3
+ 99.4050351164
* device instance g_vss_m1_inv_clk_vss_inv_mc_vss_inv_q_vss_mph_g_nand_m_vss_nand_s2_vss_s1_vss_m1_s2_vss_m1_s3_vss_m1_s4_vss_m1_sb_vss_sr1_vss_sr2_vss_sr3_vss_sr4_vss_sv_vss_tg_d_vss_tg_fbm_vss_tg_fbs_vss_tg_s_vss_vss_vss_link_vss_link_bridge_vss_link_dip_vss_link_m1_vss_x1_vss_x2_vss_x3_t92 r0 *1 0,0
Rg_vss_m1_inv_clk_vss_inv_mc_vss_inv_q_vss_mph_g_nand_m_vss_nand_s2_vss_s1_vss_m1_s2_vss_m1_s3_vss_m1_s4_vss_m1_sb_vss_sr1_vss_sr2_vss_sr3_vss_sr4_vss_sv_vss_tg_d_vss_tg_fbm_vss_tg_fbs_vss_tg_s_vss_vss_vss_link_vss_link_bridge_vss_link_dip_vss_link_m1_vss_x1_vss_x2_vss_x3_t92
+ g_vss_m1|inv_clk_vss|inv_mc_vss|inv_q_vss|mph_g|nand_m_vss|nand_s2_vss|s1_vss_m1|s2_vss_m1|s3_vss_m1|s4_vss_m1|sb_vss|sr1_vss|sr2_vss|sr3_vss|sr4_vss|sv_vss|tg_d_vss|tg_fbm_vss|tg_fbs_vss|tg_s_vss|vss|vss_link|vss_link_bridge|vss_link_dip|vss_link_m1|vss_x1|vss_x2|vss_x3__t92
+ g_vss_m1|inv_clk_vss|inv_mc_vss|inv_q_vss|mph_g|nand_m_vss|nand_s2_vss|s1_vss_m1|s2_vss_m1|s3_vss_m1|s4_vss_m1|sb_vss|sr1_vss|sr2_vss|sr3_vss|sr4_vss|sv_vss|tg_d_vss|tg_fbm_vss|tg_fbs_vss|tg_s_vss|vss|vss_link|vss_link_bridge|vss_link_dip|vss_link_m1|vss_x1|vss_x2|vss_x3
+ 163.899726315
* device instance g_vss_m1_inv_clk_vss_inv_mc_vss_inv_q_vss_mph_g_nand_m_vss_nand_s2_vss_s1_vss_m1_s2_vss_m1_s3_vss_m1_s4_vss_m1_sb_vss_sr1_vss_sr2_vss_sr3_vss_sr4_vss_sv_vss_tg_d_vss_tg_fbm_vss_tg_fbs_vss_tg_s_vss_vss_vss_link_vss_link_bridge_vss_link_dip_vss_link_m1_vss_x1_vss_x2_vss_x3_t93 r0 *1 0,0
Rg_vss_m1_inv_clk_vss_inv_mc_vss_inv_q_vss_mph_g_nand_m_vss_nand_s2_vss_s1_vss_m1_s2_vss_m1_s3_vss_m1_s4_vss_m1_sb_vss_sr1_vss_sr2_vss_sr3_vss_sr4_vss_sv_vss_tg_d_vss_tg_fbm_vss_tg_fbs_vss_tg_s_vss_vss_vss_link_vss_link_bridge_vss_link_dip_vss_link_m1_vss_x1_vss_x2_vss_x3_t93
+ g_vss_m1|inv_clk_vss|inv_mc_vss|inv_q_vss|mph_g|nand_m_vss|nand_s2_vss|s1_vss_m1|s2_vss_m1|s3_vss_m1|s4_vss_m1|sb_vss|sr1_vss|sr2_vss|sr3_vss|sr4_vss|sv_vss|tg_d_vss|tg_fbm_vss|tg_fbs_vss|tg_s_vss|vss|vss_link|vss_link_bridge|vss_link_dip|vss_link_m1|vss_x1|vss_x2|vss_x3__t93
+ g_vss_m1|inv_clk_vss|inv_mc_vss|inv_q_vss|mph_g|nand_m_vss|nand_s2_vss|s1_vss_m1|s2_vss_m1|s3_vss_m1|s4_vss_m1|sb_vss|sr1_vss|sr2_vss|sr3_vss|sr4_vss|sv_vss|tg_d_vss|tg_fbm_vss|tg_fbs_vss|tg_s_vss|vss|vss_link|vss_link_bridge|vss_link_dip|vss_link_m1|vss_x1|vss_x2|vss_x3
+ 247.335390253
* device instance g_vss_m1_inv_clk_vss_inv_mc_vss_inv_q_vss_mph_g_nand_m_vss_nand_s2_vss_s1_vss_m1_s2_vss_m1_s3_vss_m1_s4_vss_m1_sb_vss_sr1_vss_sr2_vss_sr3_vss_sr4_vss_sv_vss_tg_d_vss_tg_fbm_vss_tg_fbs_vss_tg_s_vss_vss_vss_link_vss_link_bridge_vss_link_dip_vss_link_m1_vss_x1_vss_x2_vss_x3_t94 r0 *1 0,0
Rg_vss_m1_inv_clk_vss_inv_mc_vss_inv_q_vss_mph_g_nand_m_vss_nand_s2_vss_s1_vss_m1_s2_vss_m1_s3_vss_m1_s4_vss_m1_sb_vss_sr1_vss_sr2_vss_sr3_vss_sr4_vss_sv_vss_tg_d_vss_tg_fbm_vss_tg_fbs_vss_tg_s_vss_vss_vss_link_vss_link_bridge_vss_link_dip_vss_link_m1_vss_x1_vss_x2_vss_x3_t94
+ g_vss_m1|inv_clk_vss|inv_mc_vss|inv_q_vss|mph_g|nand_m_vss|nand_s2_vss|s1_vss_m1|s2_vss_m1|s3_vss_m1|s4_vss_m1|sb_vss|sr1_vss|sr2_vss|sr3_vss|sr4_vss|sv_vss|tg_d_vss|tg_fbm_vss|tg_fbs_vss|tg_s_vss|vss|vss_link|vss_link_bridge|vss_link_dip|vss_link_m1|vss_x1|vss_x2|vss_x3__t94
+ g_vss_m1|inv_clk_vss|inv_mc_vss|inv_q_vss|mph_g|nand_m_vss|nand_s2_vss|s1_vss_m1|s2_vss_m1|s3_vss_m1|s4_vss_m1|sb_vss|sr1_vss|sr2_vss|sr3_vss|sr4_vss|sv_vss|tg_d_vss|tg_fbm_vss|tg_fbs_vss|tg_s_vss|vss|vss_link|vss_link_bridge|vss_link_dip|vss_link_m1|vss_x1|vss_x2|vss_x3
+ 315.183708737
* device instance g_vss_m1_inv_clk_vss_inv_mc_vss_inv_q_vss_mph_g_nand_m_vss_nand_s2_vss_s1_vss_m1_s2_vss_m1_s3_vss_m1_s4_vss_m1_sb_vss_sr1_vss_sr2_vss_sr3_vss_sr4_vss_sv_vss_tg_d_vss_tg_fbm_vss_tg_fbs_vss_tg_s_vss_vss_vss_link_vss_link_bridge_vss_link_dip_vss_link_m1_vss_x1_vss_x2_vss_x3_t95 r0 *1 0,0
Rg_vss_m1_inv_clk_vss_inv_mc_vss_inv_q_vss_mph_g_nand_m_vss_nand_s2_vss_s1_vss_m1_s2_vss_m1_s3_vss_m1_s4_vss_m1_sb_vss_sr1_vss_sr2_vss_sr3_vss_sr4_vss_sv_vss_tg_d_vss_tg_fbm_vss_tg_fbs_vss_tg_s_vss_vss_vss_link_vss_link_bridge_vss_link_dip_vss_link_m1_vss_x1_vss_x2_vss_x3_t95
+ g_vss_m1|inv_clk_vss|inv_mc_vss|inv_q_vss|mph_g|nand_m_vss|nand_s2_vss|s1_vss_m1|s2_vss_m1|s3_vss_m1|s4_vss_m1|sb_vss|sr1_vss|sr2_vss|sr3_vss|sr4_vss|sv_vss|tg_d_vss|tg_fbm_vss|tg_fbs_vss|tg_s_vss|vss|vss_link|vss_link_bridge|vss_link_dip|vss_link_m1|vss_x1|vss_x2|vss_x3__t95
+ g_vss_m1|inv_clk_vss|inv_mc_vss|inv_q_vss|mph_g|nand_m_vss|nand_s2_vss|s1_vss_m1|s2_vss_m1|s3_vss_m1|s4_vss_m1|sb_vss|sr1_vss|sr2_vss|sr3_vss|sr4_vss|sv_vss|tg_d_vss|tg_fbm_vss|tg_fbs_vss|tg_s_vss|vss|vss_link|vss_link_bridge|vss_link_dip|vss_link_m1|vss_x1|vss_x2|vss_x3
+ 400.016407853
* device instance g_vss_m1_inv_clk_vss_inv_mc_vss_inv_q_vss_mph_g_nand_m_vss_nand_s2_vss_s1_vss_m1_s2_vss_m1_s3_vss_m1_s4_vss_m1_sb_vss_sr1_vss_sr2_vss_sr3_vss_sr4_vss_sv_vss_tg_d_vss_tg_fbm_vss_tg_fbs_vss_tg_s_vss_vss_vss_link_vss_link_bridge_vss_link_dip_vss_link_m1_vss_x1_vss_x2_vss_x3_t96 r0 *1 0,0
Rg_vss_m1_inv_clk_vss_inv_mc_vss_inv_q_vss_mph_g_nand_m_vss_nand_s2_vss_s1_vss_m1_s2_vss_m1_s3_vss_m1_s4_vss_m1_sb_vss_sr1_vss_sr2_vss_sr3_vss_sr4_vss_sv_vss_tg_d_vss_tg_fbm_vss_tg_fbs_vss_tg_s_vss_vss_vss_link_vss_link_bridge_vss_link_dip_vss_link_m1_vss_x1_vss_x2_vss_x3_t96
+ g_vss_m1|inv_clk_vss|inv_mc_vss|inv_q_vss|mph_g|nand_m_vss|nand_s2_vss|s1_vss_m1|s2_vss_m1|s3_vss_m1|s4_vss_m1|sb_vss|sr1_vss|sr2_vss|sr3_vss|sr4_vss|sv_vss|tg_d_vss|tg_fbm_vss|tg_fbs_vss|tg_s_vss|vss|vss_link|vss_link_bridge|vss_link_dip|vss_link_m1|vss_x1|vss_x2|vss_x3__t96
+ g_vss_m1|inv_clk_vss|inv_mc_vss|inv_q_vss|mph_g|nand_m_vss|nand_s2_vss|s1_vss_m1|s2_vss_m1|s3_vss_m1|s4_vss_m1|sb_vss|sr1_vss|sr2_vss|sr3_vss|sr4_vss|sv_vss|tg_d_vss|tg_fbm_vss|tg_fbs_vss|tg_s_vss|vss|vss_link|vss_link_bridge|vss_link_dip|vss_link_m1|vss_x1|vss_x2|vss_x3
+ 468.362378116
* device instance g_vss_m1_inv_clk_vss_inv_mc_vss_inv_q_vss_mph_g_nand_m_vss_nand_s2_vss_s1_vss_m1_s2_vss_m1_s3_vss_m1_s4_vss_m1_sb_vss_sr1_vss_sr2_vss_sr3_vss_sr4_vss_sv_vss_tg_d_vss_tg_fbm_vss_tg_fbs_vss_tg_s_vss_vss_vss_link_vss_link_bridge_vss_link_dip_vss_link_m1_vss_x1_vss_x2_vss_x3_t97 r0 *1 0,0
Rg_vss_m1_inv_clk_vss_inv_mc_vss_inv_q_vss_mph_g_nand_m_vss_nand_s2_vss_s1_vss_m1_s2_vss_m1_s3_vss_m1_s4_vss_m1_sb_vss_sr1_vss_sr2_vss_sr3_vss_sr4_vss_sv_vss_tg_d_vss_tg_fbm_vss_tg_fbs_vss_tg_s_vss_vss_vss_link_vss_link_bridge_vss_link_dip_vss_link_m1_vss_x1_vss_x2_vss_x3_t97
+ g_vss_m1|inv_clk_vss|inv_mc_vss|inv_q_vss|mph_g|nand_m_vss|nand_s2_vss|s1_vss_m1|s2_vss_m1|s3_vss_m1|s4_vss_m1|sb_vss|sr1_vss|sr2_vss|sr3_vss|sr4_vss|sv_vss|tg_d_vss|tg_fbm_vss|tg_fbs_vss|tg_s_vss|vss|vss_link|vss_link_bridge|vss_link_dip|vss_link_m1|vss_x1|vss_x2|vss_x3__t97
+ g_vss_m1|inv_clk_vss|inv_mc_vss|inv_q_vss|mph_g|nand_m_vss|nand_s2_vss|s1_vss_m1|s2_vss_m1|s3_vss_m1|s4_vss_m1|sb_vss|sr1_vss|sr2_vss|sr3_vss|sr4_vss|sv_vss|tg_d_vss|tg_fbm_vss|tg_fbs_vss|tg_s_vss|vss|vss_link|vss_link_bridge|vss_link_dip|vss_link_m1|vss_x1|vss_x2|vss_x3
+ 553.530807494
* device instance g_vss_m1_inv_clk_vss_inv_mc_vss_inv_q_vss_mph_g_nand_m_vss_nand_s2_vss_s1_vss_m1_s2_vss_m1_s3_vss_m1_s4_vss_m1_sb_vss_sr1_vss_sr2_vss_sr3_vss_sr4_vss_sv_vss_tg_d_vss_tg_fbm_vss_tg_fbs_vss_tg_s_vss_vss_vss_link_vss_link_bridge_vss_link_dip_vss_link_m1_vss_x1_vss_x2_vss_x3_t98 r0 *1 0,0
Rg_vss_m1_inv_clk_vss_inv_mc_vss_inv_q_vss_mph_g_nand_m_vss_nand_s2_vss_s1_vss_m1_s2_vss_m1_s3_vss_m1_s4_vss_m1_sb_vss_sr1_vss_sr2_vss_sr3_vss_sr4_vss_sv_vss_tg_d_vss_tg_fbm_vss_tg_fbs_vss_tg_s_vss_vss_vss_link_vss_link_bridge_vss_link_dip_vss_link_m1_vss_x1_vss_x2_vss_x3_t98
+ g_vss_m1|inv_clk_vss|inv_mc_vss|inv_q_vss|mph_g|nand_m_vss|nand_s2_vss|s1_vss_m1|s2_vss_m1|s3_vss_m1|s4_vss_m1|sb_vss|sr1_vss|sr2_vss|sr3_vss|sr4_vss|sv_vss|tg_d_vss|tg_fbm_vss|tg_fbs_vss|tg_s_vss|vss|vss_link|vss_link_bridge|vss_link_dip|vss_link_m1|vss_x1|vss_x2|vss_x3__t98
+ g_vss_m1|inv_clk_vss|inv_mc_vss|inv_q_vss|mph_g|nand_m_vss|nand_s2_vss|s1_vss_m1|s2_vss_m1|s3_vss_m1|s4_vss_m1|sb_vss|sr1_vss|sr2_vss|sr3_vss|sr4_vss|sv_vss|tg_d_vss|tg_fbm_vss|tg_fbs_vss|tg_s_vss|vss|vss_link|vss_link_bridge|vss_link_dip|vss_link_m1|vss_x1|vss_x2|vss_x3
+ 322.895708619
* device instance g_vss_m1_inv_clk_vss_inv_mc_vss_inv_q_vss_mph_g_nand_m_vss_nand_s2_vss_s1_vss_m1_s2_vss_m1_s3_vss_m1_s4_vss_m1_sb_vss_sr1_vss_sr2_vss_sr3_vss_sr4_vss_sv_vss_tg_d_vss_tg_fbm_vss_tg_fbs_vss_tg_s_vss_vss_vss_link_vss_link_bridge_vss_link_dip_vss_link_m1_vss_x1_vss_x2_vss_x3_t99 r0 *1 0,0
Rg_vss_m1_inv_clk_vss_inv_mc_vss_inv_q_vss_mph_g_nand_m_vss_nand_s2_vss_s1_vss_m1_s2_vss_m1_s3_vss_m1_s4_vss_m1_sb_vss_sr1_vss_sr2_vss_sr3_vss_sr4_vss_sv_vss_tg_d_vss_tg_fbm_vss_tg_fbs_vss_tg_s_vss_vss_vss_link_vss_link_bridge_vss_link_dip_vss_link_m1_vss_x1_vss_x2_vss_x3_t99
+ g_vss_m1|inv_clk_vss|inv_mc_vss|inv_q_vss|mph_g|nand_m_vss|nand_s2_vss|s1_vss_m1|s2_vss_m1|s3_vss_m1|s4_vss_m1|sb_vss|sr1_vss|sr2_vss|sr3_vss|sr4_vss|sv_vss|tg_d_vss|tg_fbm_vss|tg_fbs_vss|tg_s_vss|vss|vss_link|vss_link_bridge|vss_link_dip|vss_link_m1|vss_x1|vss_x2|vss_x3__t99
+ g_vss_m1|inv_clk_vss|inv_mc_vss|inv_q_vss|mph_g|nand_m_vss|nand_s2_vss|s1_vss_m1|s2_vss_m1|s3_vss_m1|s4_vss_m1|sb_vss|sr1_vss|sr2_vss|sr3_vss|sr4_vss|sv_vss|tg_d_vss|tg_fbm_vss|tg_fbs_vss|tg_s_vss|vss|vss_link|vss_link_bridge|vss_link_dip|vss_link_m1|vss_x1|vss_x2|vss_x3
+ 170.367207688
* device instance g_vss_m1_inv_clk_vss_inv_mc_vss_inv_q_vss_mph_g_nand_m_vss_nand_s2_vss_s1_vss_m1_s2_vss_m1_s3_vss_m1_s4_vss_m1_sb_vss_sr1_vss_sr2_vss_sr3_vss_sr4_vss_sv_vss_tg_d_vss_tg_fbm_vss_tg_fbs_vss_tg_s_vss_vss_vss_link_vss_link_bridge_vss_link_dip_vss_link_m1_vss_x1_vss_x2_vss_x3_t100 r0 *1 0,0
Rg_vss_m1_inv_clk_vss_inv_mc_vss_inv_q_vss_mph_g_nand_m_vss_nand_s2_vss_s1_vss_m1_s2_vss_m1_s3_vss_m1_s4_vss_m1_sb_vss_sr1_vss_sr2_vss_sr3_vss_sr4_vss_sv_vss_tg_d_vss_tg_fbm_vss_tg_fbs_vss_tg_s_vss_vss_vss_link_vss_link_bridge_vss_link_dip_vss_link_m1_vss_x1_vss_x2_vss_x3_t100
+ g_vss_m1|inv_clk_vss|inv_mc_vss|inv_q_vss|mph_g|nand_m_vss|nand_s2_vss|s1_vss_m1|s2_vss_m1|s3_vss_m1|s4_vss_m1|sb_vss|sr1_vss|sr2_vss|sr3_vss|sr4_vss|sv_vss|tg_d_vss|tg_fbm_vss|tg_fbs_vss|tg_s_vss|vss|vss_link|vss_link_bridge|vss_link_dip|vss_link_m1|vss_x1|vss_x2|vss_x3__t100
+ g_vss_m1|inv_clk_vss|inv_mc_vss|inv_q_vss|mph_g|nand_m_vss|nand_s2_vss|s1_vss_m1|s2_vss_m1|s3_vss_m1|s4_vss_m1|sb_vss|sr1_vss|sr2_vss|sr3_vss|sr4_vss|sv_vss|tg_d_vss|tg_fbm_vss|tg_fbs_vss|tg_s_vss|vss|vss_link|vss_link_bridge|vss_link_dip|vss_link_m1|vss_x1|vss_x2|vss_x3
+ 26.8364045034
* device instance g_vss_m1_inv_clk_vss_inv_mc_vss_inv_q_vss_mph_g_nand_m_vss_nand_s2_vss_s1_vss_m1_s2_vss_m1_s3_vss_m1_s4_vss_m1_sb_vss_sr1_vss_sr2_vss_sr3_vss_sr4_vss_sv_vss_tg_d_vss_tg_fbm_vss_tg_fbs_vss_tg_s_vss_vss_vss_link_vss_link_bridge_vss_link_dip_vss_link_m1_vss_x1_vss_x2_vss_x3_t101 r0 *1 0,0
Rg_vss_m1_inv_clk_vss_inv_mc_vss_inv_q_vss_mph_g_nand_m_vss_nand_s2_vss_s1_vss_m1_s2_vss_m1_s3_vss_m1_s4_vss_m1_sb_vss_sr1_vss_sr2_vss_sr3_vss_sr4_vss_sv_vss_tg_d_vss_tg_fbm_vss_tg_fbs_vss_tg_s_vss_vss_vss_link_vss_link_bridge_vss_link_dip_vss_link_m1_vss_x1_vss_x2_vss_x3_t101
+ g_vss_m1|inv_clk_vss|inv_mc_vss|inv_q_vss|mph_g|nand_m_vss|nand_s2_vss|s1_vss_m1|s2_vss_m1|s3_vss_m1|s4_vss_m1|sb_vss|sr1_vss|sr2_vss|sr3_vss|sr4_vss|sv_vss|tg_d_vss|tg_fbm_vss|tg_fbs_vss|tg_s_vss|vss|vss_link|vss_link_bridge|vss_link_dip|vss_link_m1|vss_x1|vss_x2|vss_x3__t101
+ g_vss_m1|inv_clk_vss|inv_mc_vss|inv_q_vss|mph_g|nand_m_vss|nand_s2_vss|s1_vss_m1|s2_vss_m1|s3_vss_m1|s4_vss_m1|sb_vss|sr1_vss|sr2_vss|sr3_vss|sr4_vss|sv_vss|tg_d_vss|tg_fbm_vss|tg_fbs_vss|tg_s_vss|vss|vss_link|vss_link_bridge|vss_link_dip|vss_link_m1|vss_x1|vss_x2|vss_x3
+ 139.094428713
* device instance g_vss_m1_inv_clk_vss_inv_mc_vss_inv_q_vss_mph_g_nand_m_vss_nand_s2_vss_s1_vss_m1_s2_vss_m1_s3_vss_m1_s4_vss_m1_sb_vss_sr1_vss_sr2_vss_sr3_vss_sr4_vss_sv_vss_tg_d_vss_tg_fbm_vss_tg_fbs_vss_tg_s_vss_vss_vss_link_vss_link_bridge_vss_link_dip_vss_link_m1_vss_x1_vss_x2_vss_x3_t102 r0 *1 0,0
Rg_vss_m1_inv_clk_vss_inv_mc_vss_inv_q_vss_mph_g_nand_m_vss_nand_s2_vss_s1_vss_m1_s2_vss_m1_s3_vss_m1_s4_vss_m1_sb_vss_sr1_vss_sr2_vss_sr3_vss_sr4_vss_sv_vss_tg_d_vss_tg_fbm_vss_tg_fbs_vss_tg_s_vss_vss_vss_link_vss_link_bridge_vss_link_dip_vss_link_m1_vss_x1_vss_x2_vss_x3_t102
+ g_vss_m1|inv_clk_vss|inv_mc_vss|inv_q_vss|mph_g|nand_m_vss|nand_s2_vss|s1_vss_m1|s2_vss_m1|s3_vss_m1|s4_vss_m1|sb_vss|sr1_vss|sr2_vss|sr3_vss|sr4_vss|sv_vss|tg_d_vss|tg_fbm_vss|tg_fbs_vss|tg_s_vss|vss|vss_link|vss_link_bridge|vss_link_dip|vss_link_m1|vss_x1|vss_x2|vss_x3__t102
+ g_vss_m1|inv_clk_vss|inv_mc_vss|inv_q_vss|mph_g|nand_m_vss|nand_s2_vss|s1_vss_m1|s2_vss_m1|s3_vss_m1|s4_vss_m1|sb_vss|sr1_vss|sr2_vss|sr3_vss|sr4_vss|sv_vss|tg_d_vss|tg_fbm_vss|tg_fbs_vss|tg_s_vss|vss|vss_link|vss_link_bridge|vss_link_dip|vss_link_m1|vss_x1|vss_x2|vss_x3
+ 324.294272449
* device instance g_vss_m1_inv_clk_vss_inv_mc_vss_inv_q_vss_mph_g_nand_m_vss_nand_s2_vss_s1_vss_m1_s2_vss_m1_s3_vss_m1_s4_vss_m1_sb_vss_sr1_vss_sr2_vss_sr3_vss_sr4_vss_sv_vss_tg_d_vss_tg_fbm_vss_tg_fbs_vss_tg_s_vss_vss_vss_link_vss_link_bridge_vss_link_dip_vss_link_m1_vss_x1_vss_x2_vss_x3_t103 r0 *1 0,0
Rg_vss_m1_inv_clk_vss_inv_mc_vss_inv_q_vss_mph_g_nand_m_vss_nand_s2_vss_s1_vss_m1_s2_vss_m1_s3_vss_m1_s4_vss_m1_sb_vss_sr1_vss_sr2_vss_sr3_vss_sr4_vss_sv_vss_tg_d_vss_tg_fbm_vss_tg_fbs_vss_tg_s_vss_vss_vss_link_vss_link_bridge_vss_link_dip_vss_link_m1_vss_x1_vss_x2_vss_x3_t103
+ g_vss_m1|inv_clk_vss|inv_mc_vss|inv_q_vss|mph_g|nand_m_vss|nand_s2_vss|s1_vss_m1|s2_vss_m1|s3_vss_m1|s4_vss_m1|sb_vss|sr1_vss|sr2_vss|sr3_vss|sr4_vss|sv_vss|tg_d_vss|tg_fbm_vss|tg_fbs_vss|tg_s_vss|vss|vss_link|vss_link_bridge|vss_link_dip|vss_link_m1|vss_x1|vss_x2|vss_x3__t103
+ g_vss_m1|inv_clk_vss|inv_mc_vss|inv_q_vss|mph_g|nand_m_vss|nand_s2_vss|s1_vss_m1|s2_vss_m1|s3_vss_m1|s4_vss_m1|sb_vss|sr1_vss|sr2_vss|sr3_vss|sr4_vss|sv_vss|tg_d_vss|tg_fbm_vss|tg_fbs_vss|tg_s_vss|vss|vss_link|vss_link_bridge|vss_link_dip|vss_link_m1|vss_x1|vss_x2|vss_x3
+ 305.312664918
* device instance g_vss_m1_inv_clk_vss_inv_mc_vss_inv_q_vss_mph_g_nand_m_vss_nand_s2_vss_s1_vss_m1_s2_vss_m1_s3_vss_m1_s4_vss_m1_sb_vss_sr1_vss_sr2_vss_sr3_vss_sr4_vss_sv_vss_tg_d_vss_tg_fbm_vss_tg_fbs_vss_tg_s_vss_vss_vss_link_vss_link_bridge_vss_link_dip_vss_link_m1_vss_x1_vss_x2_vss_x3_t104 r0 *1 0,0
Rg_vss_m1_inv_clk_vss_inv_mc_vss_inv_q_vss_mph_g_nand_m_vss_nand_s2_vss_s1_vss_m1_s2_vss_m1_s3_vss_m1_s4_vss_m1_sb_vss_sr1_vss_sr2_vss_sr3_vss_sr4_vss_sv_vss_tg_d_vss_tg_fbm_vss_tg_fbs_vss_tg_s_vss_vss_vss_link_vss_link_bridge_vss_link_dip_vss_link_m1_vss_x1_vss_x2_vss_x3_t104
+ g_vss_m1|inv_clk_vss|inv_mc_vss|inv_q_vss|mph_g|nand_m_vss|nand_s2_vss|s1_vss_m1|s2_vss_m1|s3_vss_m1|s4_vss_m1|sb_vss|sr1_vss|sr2_vss|sr3_vss|sr4_vss|sv_vss|tg_d_vss|tg_fbm_vss|tg_fbs_vss|tg_s_vss|vss|vss_link|vss_link_bridge|vss_link_dip|vss_link_m1|vss_x1|vss_x2|vss_x3__t104
+ g_vss_m1|inv_clk_vss|inv_mc_vss|inv_q_vss|mph_g|nand_m_vss|nand_s2_vss|s1_vss_m1|s2_vss_m1|s3_vss_m1|s4_vss_m1|sb_vss|sr1_vss|sr2_vss|sr3_vss|sr4_vss|sv_vss|tg_d_vss|tg_fbm_vss|tg_fbs_vss|tg_s_vss|vss|vss_link|vss_link_bridge|vss_link_dip|vss_link_m1|vss_x1|vss_x2|vss_x3
+ 246.15198492
* device instance g_vss_m1_inv_clk_vss_inv_mc_vss_inv_q_vss_mph_g_nand_m_vss_nand_s2_vss_s1_vss_m1_s2_vss_m1_s3_vss_m1_s4_vss_m1_sb_vss_sr1_vss_sr2_vss_sr3_vss_sr4_vss_sv_vss_tg_d_vss_tg_fbm_vss_tg_fbs_vss_tg_s_vss_vss_vss_link_vss_link_bridge_vss_link_dip_vss_link_m1_vss_x1_vss_x2_vss_x3_t105 r0 *1 0,0
Rg_vss_m1_inv_clk_vss_inv_mc_vss_inv_q_vss_mph_g_nand_m_vss_nand_s2_vss_s1_vss_m1_s2_vss_m1_s3_vss_m1_s4_vss_m1_sb_vss_sr1_vss_sr2_vss_sr3_vss_sr4_vss_sv_vss_tg_d_vss_tg_fbm_vss_tg_fbs_vss_tg_s_vss_vss_vss_link_vss_link_bridge_vss_link_dip_vss_link_m1_vss_x1_vss_x2_vss_x3_t105
+ g_vss_m1|inv_clk_vss|inv_mc_vss|inv_q_vss|mph_g|nand_m_vss|nand_s2_vss|s1_vss_m1|s2_vss_m1|s3_vss_m1|s4_vss_m1|sb_vss|sr1_vss|sr2_vss|sr3_vss|sr4_vss|sv_vss|tg_d_vss|tg_fbm_vss|tg_fbs_vss|tg_s_vss|vss|vss_link|vss_link_bridge|vss_link_dip|vss_link_m1|vss_x1|vss_x2|vss_x3__t105
+ g_vss_m1|inv_clk_vss|inv_mc_vss|inv_q_vss|mph_g|nand_m_vss|nand_s2_vss|s1_vss_m1|s2_vss_m1|s3_vss_m1|s4_vss_m1|sb_vss|sr1_vss|sr2_vss|sr3_vss|sr4_vss|sv_vss|tg_d_vss|tg_fbm_vss|tg_fbs_vss|tg_s_vss|vss|vss_link|vss_link_bridge|vss_link_dip|vss_link_m1|vss_x1|vss_x2|vss_x3
+ 227.490709984
* device instance g_vss_m1_inv_clk_vss_inv_mc_vss_inv_q_vss_mph_g_nand_m_vss_nand_s2_vss_s1_vss_m1_s2_vss_m1_s3_vss_m1_s4_vss_m1_sb_vss_sr1_vss_sr2_vss_sr3_vss_sr4_vss_sv_vss_tg_d_vss_tg_fbm_vss_tg_fbs_vss_tg_s_vss_vss_vss_link_vss_link_bridge_vss_link_dip_vss_link_m1_vss_x1_vss_x2_vss_x3_t106 r0 *1 0,0
Rg_vss_m1_inv_clk_vss_inv_mc_vss_inv_q_vss_mph_g_nand_m_vss_nand_s2_vss_s1_vss_m1_s2_vss_m1_s3_vss_m1_s4_vss_m1_sb_vss_sr1_vss_sr2_vss_sr3_vss_sr4_vss_sv_vss_tg_d_vss_tg_fbm_vss_tg_fbs_vss_tg_s_vss_vss_vss_link_vss_link_bridge_vss_link_dip_vss_link_m1_vss_x1_vss_x2_vss_x3_t106
+ g_vss_m1|inv_clk_vss|inv_mc_vss|inv_q_vss|mph_g|nand_m_vss|nand_s2_vss|s1_vss_m1|s2_vss_m1|s3_vss_m1|s4_vss_m1|sb_vss|sr1_vss|sr2_vss|sr3_vss|sr4_vss|sv_vss|tg_d_vss|tg_fbm_vss|tg_fbs_vss|tg_s_vss|vss|vss_link|vss_link_bridge|vss_link_dip|vss_link_m1|vss_x1|vss_x2|vss_x3__t106
+ g_vss_m1|inv_clk_vss|inv_mc_vss|inv_q_vss|mph_g|nand_m_vss|nand_s2_vss|s1_vss_m1|s2_vss_m1|s3_vss_m1|s4_vss_m1|sb_vss|sr1_vss|sr2_vss|sr3_vss|sr4_vss|sv_vss|tg_d_vss|tg_fbm_vss|tg_fbs_vss|tg_s_vss|vss|vss_link|vss_link_bridge|vss_link_dip|vss_link_m1|vss_x1|vss_x2|vss_x3
+ 169.9846573
* device instance g_vss_m1_inv_clk_vss_inv_mc_vss_inv_q_vss_mph_g_nand_m_vss_nand_s2_vss_s1_vss_m1_s2_vss_m1_s3_vss_m1_s4_vss_m1_sb_vss_sr1_vss_sr2_vss_sr3_vss_sr4_vss_sv_vss_tg_d_vss_tg_fbm_vss_tg_fbs_vss_tg_s_vss_vss_vss_link_vss_link_bridge_vss_link_dip_vss_link_m1_vss_x1_vss_x2_vss_x3_t107 r0 *1 0,0
Rg_vss_m1_inv_clk_vss_inv_mc_vss_inv_q_vss_mph_g_nand_m_vss_nand_s2_vss_s1_vss_m1_s2_vss_m1_s3_vss_m1_s4_vss_m1_sb_vss_sr1_vss_sr2_vss_sr3_vss_sr4_vss_sv_vss_tg_d_vss_tg_fbm_vss_tg_fbs_vss_tg_s_vss_vss_vss_link_vss_link_bridge_vss_link_dip_vss_link_m1_vss_x1_vss_x2_vss_x3_t107
+ g_vss_m1|inv_clk_vss|inv_mc_vss|inv_q_vss|mph_g|nand_m_vss|nand_s2_vss|s1_vss_m1|s2_vss_m1|s3_vss_m1|s4_vss_m1|sb_vss|sr1_vss|sr2_vss|sr3_vss|sr4_vss|sv_vss|tg_d_vss|tg_fbm_vss|tg_fbs_vss|tg_s_vss|vss|vss_link|vss_link_bridge|vss_link_dip|vss_link_m1|vss_x1|vss_x2|vss_x3__t107
+ g_vss_m1|inv_clk_vss|inv_mc_vss|inv_q_vss|mph_g|nand_m_vss|nand_s2_vss|s1_vss_m1|s2_vss_m1|s3_vss_m1|s4_vss_m1|sb_vss|sr1_vss|sr2_vss|sr3_vss|sr4_vss|sv_vss|tg_d_vss|tg_fbm_vss|tg_fbs_vss|tg_s_vss|vss|vss_link|vss_link_bridge|vss_link_dip|vss_link_m1|vss_x1|vss_x2|vss_x3
+ 152.210979892
* device instance g_vss_m1_inv_clk_vss_inv_mc_vss_inv_q_vss_mph_g_nand_m_vss_nand_s2_vss_s1_vss_m1_s2_vss_m1_s3_vss_m1_s4_vss_m1_sb_vss_sr1_vss_sr2_vss_sr3_vss_sr4_vss_sv_vss_tg_d_vss_tg_fbm_vss_tg_fbs_vss_tg_s_vss_vss_vss_link_vss_link_bridge_vss_link_dip_vss_link_m1_vss_x1_vss_x2_vss_x3_t108 r0 *1 0,0
Rg_vss_m1_inv_clk_vss_inv_mc_vss_inv_q_vss_mph_g_nand_m_vss_nand_s2_vss_s1_vss_m1_s2_vss_m1_s3_vss_m1_s4_vss_m1_sb_vss_sr1_vss_sr2_vss_sr3_vss_sr4_vss_sv_vss_tg_d_vss_tg_fbm_vss_tg_fbs_vss_tg_s_vss_vss_vss_link_vss_link_bridge_vss_link_dip_vss_link_m1_vss_x1_vss_x2_vss_x3_t108
+ g_vss_m1|inv_clk_vss|inv_mc_vss|inv_q_vss|mph_g|nand_m_vss|nand_s2_vss|s1_vss_m1|s2_vss_m1|s3_vss_m1|s4_vss_m1|sb_vss|sr1_vss|sr2_vss|sr3_vss|sr4_vss|sv_vss|tg_d_vss|tg_fbm_vss|tg_fbs_vss|tg_s_vss|vss|vss_link|vss_link_bridge|vss_link_dip|vss_link_m1|vss_x1|vss_x2|vss_x3__t108
+ g_vss_m1|inv_clk_vss|inv_mc_vss|inv_q_vss|mph_g|nand_m_vss|nand_s2_vss|s1_vss_m1|s2_vss_m1|s3_vss_m1|s4_vss_m1|sb_vss|sr1_vss|sr2_vss|sr3_vss|sr4_vss|sv_vss|tg_d_vss|tg_fbm_vss|tg_fbs_vss|tg_s_vss|vss|vss_link|vss_link_bridge|vss_link_dip|vss_link_m1|vss_x1|vss_x2|vss_x3
+ 305.895951366
* device instance g_vss_m1_inv_clk_vss_inv_mc_vss_inv_q_vss_mph_g_nand_m_vss_nand_s2_vss_s1_vss_m1_s2_vss_m1_s3_vss_m1_s4_vss_m1_sb_vss_sr1_vss_sr2_vss_sr3_vss_sr4_vss_sv_vss_tg_d_vss_tg_fbm_vss_tg_fbs_vss_tg_s_vss_vss_vss_link_vss_link_bridge_vss_link_dip_vss_link_m1_vss_x1_vss_x2_vss_x3_t109 r0 *1 0,0
Rg_vss_m1_inv_clk_vss_inv_mc_vss_inv_q_vss_mph_g_nand_m_vss_nand_s2_vss_s1_vss_m1_s2_vss_m1_s3_vss_m1_s4_vss_m1_sb_vss_sr1_vss_sr2_vss_sr3_vss_sr4_vss_sv_vss_tg_d_vss_tg_fbm_vss_tg_fbs_vss_tg_s_vss_vss_vss_link_vss_link_bridge_vss_link_dip_vss_link_m1_vss_x1_vss_x2_vss_x3_t109
+ g_vss_m1|inv_clk_vss|inv_mc_vss|inv_q_vss|mph_g|nand_m_vss|nand_s2_vss|s1_vss_m1|s2_vss_m1|s3_vss_m1|s4_vss_m1|sb_vss|sr1_vss|sr2_vss|sr3_vss|sr4_vss|sv_vss|tg_d_vss|tg_fbm_vss|tg_fbs_vss|tg_s_vss|vss|vss_link|vss_link_bridge|vss_link_dip|vss_link_m1|vss_x1|vss_x2|vss_x3__t109
+ g_vss_m1|inv_clk_vss|inv_mc_vss|inv_q_vss|mph_g|nand_m_vss|nand_s2_vss|s1_vss_m1|s2_vss_m1|s3_vss_m1|s4_vss_m1|sb_vss|sr1_vss|sr2_vss|sr3_vss|sr4_vss|sv_vss|tg_d_vss|tg_fbm_vss|tg_fbs_vss|tg_s_vss|vss|vss_link|vss_link_bridge|vss_link_dip|vss_link_m1|vss_x1|vss_x2|vss_x3
+ 221.628692586
* device instance g_vss_m1_inv_clk_vss_inv_mc_vss_inv_q_vss_mph_g_nand_m_vss_nand_s2_vss_s1_vss_m1_s2_vss_m1_s3_vss_m1_s4_vss_m1_sb_vss_sr1_vss_sr2_vss_sr3_vss_sr4_vss_sv_vss_tg_d_vss_tg_fbm_vss_tg_fbs_vss_tg_s_vss_vss_vss_link_vss_link_bridge_vss_link_dip_vss_link_m1_vss_x1_vss_x2_vss_x3_t110 r0 *1 0,0
Rg_vss_m1_inv_clk_vss_inv_mc_vss_inv_q_vss_mph_g_nand_m_vss_nand_s2_vss_s1_vss_m1_s2_vss_m1_s3_vss_m1_s4_vss_m1_sb_vss_sr1_vss_sr2_vss_sr3_vss_sr4_vss_sv_vss_tg_d_vss_tg_fbm_vss_tg_fbs_vss_tg_s_vss_vss_vss_link_vss_link_bridge_vss_link_dip_vss_link_m1_vss_x1_vss_x2_vss_x3_t110
+ g_vss_m1|inv_clk_vss|inv_mc_vss|inv_q_vss|mph_g|nand_m_vss|nand_s2_vss|s1_vss_m1|s2_vss_m1|s3_vss_m1|s4_vss_m1|sb_vss|sr1_vss|sr2_vss|sr3_vss|sr4_vss|sv_vss|tg_d_vss|tg_fbm_vss|tg_fbs_vss|tg_s_vss|vss|vss_link|vss_link_bridge|vss_link_dip|vss_link_m1|vss_x1|vss_x2|vss_x3__t110
+ g_vss_m1|inv_clk_vss|inv_mc_vss|inv_q_vss|mph_g|nand_m_vss|nand_s2_vss|s1_vss_m1|s2_vss_m1|s3_vss_m1|s4_vss_m1|sb_vss|sr1_vss|sr2_vss|sr3_vss|sr4_vss|sv_vss|tg_d_vss|tg_fbm_vss|tg_fbs_vss|tg_s_vss|vss|vss_link|vss_link_bridge|vss_link_dip|vss_link_m1|vss_x1|vss_x2|vss_x3
+ 154.879332032
* device instance g_vss_m1_inv_clk_vss_inv_mc_vss_inv_q_vss_mph_g_nand_m_vss_nand_s2_vss_s1_vss_m1_s2_vss_m1_s3_vss_m1_s4_vss_m1_sb_vss_sr1_vss_sr2_vss_sr3_vss_sr4_vss_sv_vss_tg_d_vss_tg_fbm_vss_tg_fbs_vss_tg_s_vss_vss_vss_link_vss_link_bridge_vss_link_dip_vss_link_m1_vss_x1_vss_x2_vss_x3_t111 r0 *1 0,0
Rg_vss_m1_inv_clk_vss_inv_mc_vss_inv_q_vss_mph_g_nand_m_vss_nand_s2_vss_s1_vss_m1_s2_vss_m1_s3_vss_m1_s4_vss_m1_sb_vss_sr1_vss_sr2_vss_sr3_vss_sr4_vss_sv_vss_tg_d_vss_tg_fbm_vss_tg_fbs_vss_tg_s_vss_vss_vss_link_vss_link_bridge_vss_link_dip_vss_link_m1_vss_x1_vss_x2_vss_x3_t111
+ g_vss_m1|inv_clk_vss|inv_mc_vss|inv_q_vss|mph_g|nand_m_vss|nand_s2_vss|s1_vss_m1|s2_vss_m1|s3_vss_m1|s4_vss_m1|sb_vss|sr1_vss|sr2_vss|sr3_vss|sr4_vss|sv_vss|tg_d_vss|tg_fbm_vss|tg_fbs_vss|tg_s_vss|vss|vss_link|vss_link_bridge|vss_link_dip|vss_link_m1|vss_x1|vss_x2|vss_x3__t111
+ g_vss_m1|inv_clk_vss|inv_mc_vss|inv_q_vss|mph_g|nand_m_vss|nand_s2_vss|s1_vss_m1|s2_vss_m1|s3_vss_m1|s4_vss_m1|sb_vss|sr1_vss|sr2_vss|sr3_vss|sr4_vss|sv_vss|tg_d_vss|tg_fbm_vss|tg_fbs_vss|tg_s_vss|vss|vss_link|vss_link_bridge|vss_link_dip|vss_link_m1|vss_x1|vss_x2|vss_x3
+ 76.7804214546
* device instance g_vss_m1_inv_clk_vss_inv_mc_vss_inv_q_vss_mph_g_nand_m_vss_nand_s2_vss_s1_vss_m1_s2_vss_m1_s3_vss_m1_s4_vss_m1_sb_vss_sr1_vss_sr2_vss_sr3_vss_sr4_vss_sv_vss_tg_d_vss_tg_fbm_vss_tg_fbs_vss_tg_s_vss_vss_vss_link_vss_link_bridge_vss_link_dip_vss_link_m1_vss_x1_vss_x2_vss_x3_t112 r0 *1 0,0
Rg_vss_m1_inv_clk_vss_inv_mc_vss_inv_q_vss_mph_g_nand_m_vss_nand_s2_vss_s1_vss_m1_s2_vss_m1_s3_vss_m1_s4_vss_m1_sb_vss_sr1_vss_sr2_vss_sr3_vss_sr4_vss_sv_vss_tg_d_vss_tg_fbm_vss_tg_fbs_vss_tg_s_vss_vss_vss_link_vss_link_bridge_vss_link_dip_vss_link_m1_vss_x1_vss_x2_vss_x3_t112
+ g_vss_m1|inv_clk_vss|inv_mc_vss|inv_q_vss|mph_g|nand_m_vss|nand_s2_vss|s1_vss_m1|s2_vss_m1|s3_vss_m1|s4_vss_m1|sb_vss|sr1_vss|sr2_vss|sr3_vss|sr4_vss|sv_vss|tg_d_vss|tg_fbm_vss|tg_fbs_vss|tg_s_vss|vss|vss_link|vss_link_bridge|vss_link_dip|vss_link_m1|vss_x1|vss_x2|vss_x3__t112
+ g_vss_m1|inv_clk_vss|inv_mc_vss|inv_q_vss|mph_g|nand_m_vss|nand_s2_vss|s1_vss_m1|s2_vss_m1|s3_vss_m1|s4_vss_m1|sb_vss|sr1_vss|sr2_vss|sr3_vss|sr4_vss|sv_vss|tg_d_vss|tg_fbm_vss|tg_fbs_vss|tg_s_vss|vss|vss_link|vss_link_bridge|vss_link_dip|vss_link_m1|vss_x1|vss_x2|vss_x3
+ 44.1336485437
* device instance g_vss_m1_inv_clk_vss_inv_mc_vss_inv_q_vss_mph_g_nand_m_vss_nand_s2_vss_s1_vss_m1_s2_vss_m1_s3_vss_m1_s4_vss_m1_sb_vss_sr1_vss_sr2_vss_sr3_vss_sr4_vss_sv_vss_tg_d_vss_tg_fbm_vss_tg_fbs_vss_tg_s_vss_vss_vss_link_vss_link_bridge_vss_link_dip_vss_link_m1_vss_x1_vss_x2_vss_x3_t113 r0 *1 0,0
Rg_vss_m1_inv_clk_vss_inv_mc_vss_inv_q_vss_mph_g_nand_m_vss_nand_s2_vss_s1_vss_m1_s2_vss_m1_s3_vss_m1_s4_vss_m1_sb_vss_sr1_vss_sr2_vss_sr3_vss_sr4_vss_sv_vss_tg_d_vss_tg_fbm_vss_tg_fbs_vss_tg_s_vss_vss_vss_link_vss_link_bridge_vss_link_dip_vss_link_m1_vss_x1_vss_x2_vss_x3_t113
+ g_vss_m1|inv_clk_vss|inv_mc_vss|inv_q_vss|mph_g|nand_m_vss|nand_s2_vss|s1_vss_m1|s2_vss_m1|s3_vss_m1|s4_vss_m1|sb_vss|sr1_vss|sr2_vss|sr3_vss|sr4_vss|sv_vss|tg_d_vss|tg_fbm_vss|tg_fbs_vss|tg_s_vss|vss|vss_link|vss_link_bridge|vss_link_dip|vss_link_m1|vss_x1|vss_x2|vss_x3__t113
+ g_vss_m1|inv_clk_vss|inv_mc_vss|inv_q_vss|mph_g|nand_m_vss|nand_s2_vss|s1_vss_m1|s2_vss_m1|s3_vss_m1|s4_vss_m1|sb_vss|sr1_vss|sr2_vss|sr3_vss|sr4_vss|sv_vss|tg_d_vss|tg_fbm_vss|tg_fbs_vss|tg_s_vss|vss|vss_link|vss_link_bridge|vss_link_dip|vss_link_m1|vss_x1|vss_x2|vss_x3
+ 101.074654956
* device instance g_vss_m1_inv_clk_vss_inv_mc_vss_inv_q_vss_mph_g_nand_m_vss_nand_s2_vss_s1_vss_m1_s2_vss_m1_s3_vss_m1_s4_vss_m1_sb_vss_sr1_vss_sr2_vss_sr3_vss_sr4_vss_sv_vss_tg_d_vss_tg_fbm_vss_tg_fbs_vss_tg_s_vss_vss_vss_link_vss_link_bridge_vss_link_dip_vss_link_m1_vss_x1_vss_x2_vss_x3_t114 r0 *1 0,0
Rg_vss_m1_inv_clk_vss_inv_mc_vss_inv_q_vss_mph_g_nand_m_vss_nand_s2_vss_s1_vss_m1_s2_vss_m1_s3_vss_m1_s4_vss_m1_sb_vss_sr1_vss_sr2_vss_sr3_vss_sr4_vss_sv_vss_tg_d_vss_tg_fbm_vss_tg_fbs_vss_tg_s_vss_vss_vss_link_vss_link_bridge_vss_link_dip_vss_link_m1_vss_x1_vss_x2_vss_x3_t114
+ g_vss_m1|inv_clk_vss|inv_mc_vss|inv_q_vss|mph_g|nand_m_vss|nand_s2_vss|s1_vss_m1|s2_vss_m1|s3_vss_m1|s4_vss_m1|sb_vss|sr1_vss|sr2_vss|sr3_vss|sr4_vss|sv_vss|tg_d_vss|tg_fbm_vss|tg_fbs_vss|tg_s_vss|vss|vss_link|vss_link_bridge|vss_link_dip|vss_link_m1|vss_x1|vss_x2|vss_x3__t114
+ g_vss_m1|inv_clk_vss|inv_mc_vss|inv_q_vss|mph_g|nand_m_vss|nand_s2_vss|s1_vss_m1|s2_vss_m1|s3_vss_m1|s4_vss_m1|sb_vss|sr1_vss|sr2_vss|sr3_vss|sr4_vss|sv_vss|tg_d_vss|tg_fbm_vss|tg_fbs_vss|tg_s_vss|vss|vss_link|vss_link_bridge|vss_link_dip|vss_link_m1|vss_x1|vss_x2|vss_x3
+ 165.689008058
* device instance g_vss_m1_inv_clk_vss_inv_mc_vss_inv_q_vss_mph_g_nand_m_vss_nand_s2_vss_s1_vss_m1_s2_vss_m1_s3_vss_m1_s4_vss_m1_sb_vss_sr1_vss_sr2_vss_sr3_vss_sr4_vss_sv_vss_tg_d_vss_tg_fbm_vss_tg_fbs_vss_tg_s_vss_vss_vss_link_vss_link_bridge_vss_link_dip_vss_link_m1_vss_x1_vss_x2_vss_x3_t115 r0 *1 0,0
Rg_vss_m1_inv_clk_vss_inv_mc_vss_inv_q_vss_mph_g_nand_m_vss_nand_s2_vss_s1_vss_m1_s2_vss_m1_s3_vss_m1_s4_vss_m1_sb_vss_sr1_vss_sr2_vss_sr3_vss_sr4_vss_sv_vss_tg_d_vss_tg_fbm_vss_tg_fbs_vss_tg_s_vss_vss_vss_link_vss_link_bridge_vss_link_dip_vss_link_m1_vss_x1_vss_x2_vss_x3_t115
+ g_vss_m1|inv_clk_vss|inv_mc_vss|inv_q_vss|mph_g|nand_m_vss|nand_s2_vss|s1_vss_m1|s2_vss_m1|s3_vss_m1|s4_vss_m1|sb_vss|sr1_vss|sr2_vss|sr3_vss|sr4_vss|sv_vss|tg_d_vss|tg_fbm_vss|tg_fbs_vss|tg_s_vss|vss|vss_link|vss_link_bridge|vss_link_dip|vss_link_m1|vss_x1|vss_x2|vss_x3__t115
+ g_vss_m1|inv_clk_vss|inv_mc_vss|inv_q_vss|mph_g|nand_m_vss|nand_s2_vss|s1_vss_m1|s2_vss_m1|s3_vss_m1|s4_vss_m1|sb_vss|sr1_vss|sr2_vss|sr3_vss|sr4_vss|sv_vss|tg_d_vss|tg_fbm_vss|tg_fbs_vss|tg_s_vss|vss|vss_link|vss_link_bridge|vss_link_dip|vss_link_m1|vss_x1|vss_x2|vss_x3
+ 249.162267698
* device instance g_vss_m1_inv_clk_vss_inv_mc_vss_inv_q_vss_mph_g_nand_m_vss_nand_s2_vss_s1_vss_m1_s2_vss_m1_s3_vss_m1_s4_vss_m1_sb_vss_sr1_vss_sr2_vss_sr3_vss_sr4_vss_sv_vss_tg_d_vss_tg_fbm_vss_tg_fbs_vss_tg_s_vss_vss_vss_link_vss_link_bridge_vss_link_dip_vss_link_m1_vss_x1_vss_x2_vss_x3_t116 r0 *1 0,0
Rg_vss_m1_inv_clk_vss_inv_mc_vss_inv_q_vss_mph_g_nand_m_vss_nand_s2_vss_s1_vss_m1_s2_vss_m1_s3_vss_m1_s4_vss_m1_sb_vss_sr1_vss_sr2_vss_sr3_vss_sr4_vss_sv_vss_tg_d_vss_tg_fbm_vss_tg_fbs_vss_tg_s_vss_vss_vss_link_vss_link_bridge_vss_link_dip_vss_link_m1_vss_x1_vss_x2_vss_x3_t116
+ g_vss_m1|inv_clk_vss|inv_mc_vss|inv_q_vss|mph_g|nand_m_vss|nand_s2_vss|s1_vss_m1|s2_vss_m1|s3_vss_m1|s4_vss_m1|sb_vss|sr1_vss|sr2_vss|sr3_vss|sr4_vss|sv_vss|tg_d_vss|tg_fbm_vss|tg_fbs_vss|tg_s_vss|vss|vss_link|vss_link_bridge|vss_link_dip|vss_link_m1|vss_x1|vss_x2|vss_x3__t116
+ g_vss_m1|inv_clk_vss|inv_mc_vss|inv_q_vss|mph_g|nand_m_vss|nand_s2_vss|s1_vss_m1|s2_vss_m1|s3_vss_m1|s4_vss_m1|sb_vss|sr1_vss|sr2_vss|sr3_vss|sr4_vss|sv_vss|tg_d_vss|tg_fbm_vss|tg_fbs_vss|tg_s_vss|vss|vss_link|vss_link_bridge|vss_link_dip|vss_link_m1|vss_x1|vss_x2|vss_x3
+ 317.021786101
* device instance g_vss_m1_inv_clk_vss_inv_mc_vss_inv_q_vss_mph_g_nand_m_vss_nand_s2_vss_s1_vss_m1_s2_vss_m1_s3_vss_m1_s4_vss_m1_sb_vss_sr1_vss_sr2_vss_sr3_vss_sr4_vss_sv_vss_tg_d_vss_tg_fbm_vss_tg_fbs_vss_tg_s_vss_vss_vss_link_vss_link_bridge_vss_link_dip_vss_link_m1_vss_x1_vss_x2_vss_x3_t117 r0 *1 0,0
Rg_vss_m1_inv_clk_vss_inv_mc_vss_inv_q_vss_mph_g_nand_m_vss_nand_s2_vss_s1_vss_m1_s2_vss_m1_s3_vss_m1_s4_vss_m1_sb_vss_sr1_vss_sr2_vss_sr3_vss_sr4_vss_sv_vss_tg_d_vss_tg_fbm_vss_tg_fbs_vss_tg_s_vss_vss_vss_link_vss_link_bridge_vss_link_dip_vss_link_m1_vss_x1_vss_x2_vss_x3_t117
+ g_vss_m1|inv_clk_vss|inv_mc_vss|inv_q_vss|mph_g|nand_m_vss|nand_s2_vss|s1_vss_m1|s2_vss_m1|s3_vss_m1|s4_vss_m1|sb_vss|sr1_vss|sr2_vss|sr3_vss|sr4_vss|sv_vss|tg_d_vss|tg_fbm_vss|tg_fbs_vss|tg_s_vss|vss|vss_link|vss_link_bridge|vss_link_dip|vss_link_m1|vss_x1|vss_x2|vss_x3__t117
+ g_vss_m1|inv_clk_vss|inv_mc_vss|inv_q_vss|mph_g|nand_m_vss|nand_s2_vss|s1_vss_m1|s2_vss_m1|s3_vss_m1|s4_vss_m1|sb_vss|sr1_vss|sr2_vss|sr3_vss|sr4_vss|sv_vss|tg_d_vss|tg_fbm_vss|tg_fbs_vss|tg_s_vss|vss|vss_link|vss_link_bridge|vss_link_dip|vss_link_m1|vss_x1|vss_x2|vss_x3
+ 401.861272617
* device instance g_vss_m1_inv_clk_vss_inv_mc_vss_inv_q_vss_mph_g_nand_m_vss_nand_s2_vss_s1_vss_m1_s2_vss_m1_s3_vss_m1_s4_vss_m1_sb_vss_sr1_vss_sr2_vss_sr3_vss_sr4_vss_sv_vss_tg_d_vss_tg_fbm_vss_tg_fbs_vss_tg_s_vss_vss_vss_link_vss_link_bridge_vss_link_dip_vss_link_m1_vss_x1_vss_x2_vss_x3_t118 r0 *1 0,0
Rg_vss_m1_inv_clk_vss_inv_mc_vss_inv_q_vss_mph_g_nand_m_vss_nand_s2_vss_s1_vss_m1_s2_vss_m1_s3_vss_m1_s4_vss_m1_sb_vss_sr1_vss_sr2_vss_sr3_vss_sr4_vss_sv_vss_tg_d_vss_tg_fbm_vss_tg_fbs_vss_tg_s_vss_vss_vss_link_vss_link_bridge_vss_link_dip_vss_link_m1_vss_x1_vss_x2_vss_x3_t118
+ g_vss_m1|inv_clk_vss|inv_mc_vss|inv_q_vss|mph_g|nand_m_vss|nand_s2_vss|s1_vss_m1|s2_vss_m1|s3_vss_m1|s4_vss_m1|sb_vss|sr1_vss|sr2_vss|sr3_vss|sr4_vss|sv_vss|tg_d_vss|tg_fbm_vss|tg_fbs_vss|tg_s_vss|vss|vss_link|vss_link_bridge|vss_link_dip|vss_link_m1|vss_x1|vss_x2|vss_x3__t118
+ g_vss_m1|inv_clk_vss|inv_mc_vss|inv_q_vss|mph_g|nand_m_vss|nand_s2_vss|s1_vss_m1|s2_vss_m1|s3_vss_m1|s4_vss_m1|sb_vss|sr1_vss|sr2_vss|sr3_vss|sr4_vss|sv_vss|tg_d_vss|tg_fbm_vss|tg_fbs_vss|tg_s_vss|vss|vss_link|vss_link_bridge|vss_link_dip|vss_link_m1|vss_x1|vss_x2|vss_x3
+ 470.2102459
* device instance g_vss_m1_inv_clk_vss_inv_mc_vss_inv_q_vss_mph_g_nand_m_vss_nand_s2_vss_s1_vss_m1_s2_vss_m1_s3_vss_m1_s4_vss_m1_sb_vss_sr1_vss_sr2_vss_sr3_vss_sr4_vss_sv_vss_tg_d_vss_tg_fbm_vss_tg_fbs_vss_tg_s_vss_vss_vss_link_vss_link_bridge_vss_link_dip_vss_link_m1_vss_x1_vss_x2_vss_x3_t119 r0 *1 0,0
Rg_vss_m1_inv_clk_vss_inv_mc_vss_inv_q_vss_mph_g_nand_m_vss_nand_s2_vss_s1_vss_m1_s2_vss_m1_s3_vss_m1_s4_vss_m1_sb_vss_sr1_vss_sr2_vss_sr3_vss_sr4_vss_sv_vss_tg_d_vss_tg_fbm_vss_tg_fbs_vss_tg_s_vss_vss_vss_link_vss_link_bridge_vss_link_dip_vss_link_m1_vss_x1_vss_x2_vss_x3_t119
+ g_vss_m1|inv_clk_vss|inv_mc_vss|inv_q_vss|mph_g|nand_m_vss|nand_s2_vss|s1_vss_m1|s2_vss_m1|s3_vss_m1|s4_vss_m1|sb_vss|sr1_vss|sr2_vss|sr3_vss|sr4_vss|sv_vss|tg_d_vss|tg_fbm_vss|tg_fbs_vss|tg_s_vss|vss|vss_link|vss_link_bridge|vss_link_dip|vss_link_m1|vss_x1|vss_x2|vss_x3__t119
+ g_vss_m1|inv_clk_vss|inv_mc_vss|inv_q_vss|mph_g|nand_m_vss|nand_s2_vss|s1_vss_m1|s2_vss_m1|s3_vss_m1|s4_vss_m1|sb_vss|sr1_vss|sr2_vss|sr3_vss|sr4_vss|sv_vss|tg_d_vss|tg_fbm_vss|tg_fbs_vss|tg_s_vss|vss|vss_link|vss_link_bridge|vss_link_dip|vss_link_m1|vss_x1|vss_x2|vss_x3
+ 555.380973952
* device instance g_vss_m1_inv_clk_vss_inv_mc_vss_inv_q_vss_mph_g_nand_m_vss_nand_s2_vss_s1_vss_m1_s2_vss_m1_s3_vss_m1_s4_vss_m1_sb_vss_sr1_vss_sr2_vss_sr3_vss_sr4_vss_sv_vss_tg_d_vss_tg_fbm_vss_tg_fbs_vss_tg_s_vss_vss_vss_link_vss_link_bridge_vss_link_dip_vss_link_m1_vss_x1_vss_x2_vss_x3_t120 r0 *1 0,0
Rg_vss_m1_inv_clk_vss_inv_mc_vss_inv_q_vss_mph_g_nand_m_vss_nand_s2_vss_s1_vss_m1_s2_vss_m1_s3_vss_m1_s4_vss_m1_sb_vss_sr1_vss_sr2_vss_sr3_vss_sr4_vss_sv_vss_tg_d_vss_tg_fbm_vss_tg_fbs_vss_tg_s_vss_vss_vss_link_vss_link_bridge_vss_link_dip_vss_link_m1_vss_x1_vss_x2_vss_x3_t120
+ g_vss_m1|inv_clk_vss|inv_mc_vss|inv_q_vss|mph_g|nand_m_vss|nand_s2_vss|s1_vss_m1|s2_vss_m1|s3_vss_m1|s4_vss_m1|sb_vss|sr1_vss|sr2_vss|sr3_vss|sr4_vss|sv_vss|tg_d_vss|tg_fbm_vss|tg_fbs_vss|tg_s_vss|vss|vss_link|vss_link_bridge|vss_link_dip|vss_link_m1|vss_x1|vss_x2|vss_x3__t120
+ g_vss_m1|inv_clk_vss|inv_mc_vss|inv_q_vss|mph_g|nand_m_vss|nand_s2_vss|s1_vss_m1|s2_vss_m1|s3_vss_m1|s4_vss_m1|sb_vss|sr1_vss|sr2_vss|sr3_vss|sr4_vss|sv_vss|tg_d_vss|tg_fbm_vss|tg_fbs_vss|tg_s_vss|vss|vss_link|vss_link_bridge|vss_link_dip|vss_link_m1|vss_x1|vss_x2|vss_x3
+ 321.043967623
* device instance g_vss_m1_inv_clk_vss_inv_mc_vss_inv_q_vss_mph_g_nand_m_vss_nand_s2_vss_s1_vss_m1_s2_vss_m1_s3_vss_m1_s4_vss_m1_sb_vss_sr1_vss_sr2_vss_sr3_vss_sr4_vss_sv_vss_tg_d_vss_tg_fbm_vss_tg_fbs_vss_tg_s_vss_vss_vss_link_vss_link_bridge_vss_link_dip_vss_link_m1_vss_x1_vss_x2_vss_x3_t121 r0 *1 0,0
Rg_vss_m1_inv_clk_vss_inv_mc_vss_inv_q_vss_mph_g_nand_m_vss_nand_s2_vss_s1_vss_m1_s2_vss_m1_s3_vss_m1_s4_vss_m1_sb_vss_sr1_vss_sr2_vss_sr3_vss_sr4_vss_sv_vss_tg_d_vss_tg_fbm_vss_tg_fbs_vss_tg_s_vss_vss_vss_link_vss_link_bridge_vss_link_dip_vss_link_m1_vss_x1_vss_x2_vss_x3_t121
+ g_vss_m1|inv_clk_vss|inv_mc_vss|inv_q_vss|mph_g|nand_m_vss|nand_s2_vss|s1_vss_m1|s2_vss_m1|s3_vss_m1|s4_vss_m1|sb_vss|sr1_vss|sr2_vss|sr3_vss|sr4_vss|sv_vss|tg_d_vss|tg_fbm_vss|tg_fbs_vss|tg_s_vss|vss|vss_link|vss_link_bridge|vss_link_dip|vss_link_m1|vss_x1|vss_x2|vss_x3__t121
+ g_vss_m1|inv_clk_vss|inv_mc_vss|inv_q_vss|mph_g|nand_m_vss|nand_s2_vss|s1_vss_m1|s2_vss_m1|s3_vss_m1|s4_vss_m1|sb_vss|sr1_vss|sr2_vss|sr3_vss|sr4_vss|sv_vss|tg_d_vss|tg_fbm_vss|tg_fbs_vss|tg_s_vss|vss|vss_link|vss_link_bridge|vss_link_dip|vss_link_m1|vss_x1|vss_x2|vss_x3
+ 168.52652556
* device instance g_vss_m1_inv_clk_vss_inv_mc_vss_inv_q_vss_mph_g_nand_m_vss_nand_s2_vss_s1_vss_m1_s2_vss_m1_s3_vss_m1_s4_vss_m1_sb_vss_sr1_vss_sr2_vss_sr3_vss_sr4_vss_sv_vss_tg_d_vss_tg_fbm_vss_tg_fbs_vss_tg_s_vss_vss_vss_link_vss_link_bridge_vss_link_dip_vss_link_m1_vss_x1_vss_x2_vss_x3_t122 r0 *1 0,0
Rg_vss_m1_inv_clk_vss_inv_mc_vss_inv_q_vss_mph_g_nand_m_vss_nand_s2_vss_s1_vss_m1_s2_vss_m1_s3_vss_m1_s4_vss_m1_sb_vss_sr1_vss_sr2_vss_sr3_vss_sr4_vss_sv_vss_tg_d_vss_tg_fbm_vss_tg_fbs_vss_tg_s_vss_vss_vss_link_vss_link_bridge_vss_link_dip_vss_link_m1_vss_x1_vss_x2_vss_x3_t122
+ g_vss_m1|inv_clk_vss|inv_mc_vss|inv_q_vss|mph_g|nand_m_vss|nand_s2_vss|s1_vss_m1|s2_vss_m1|s3_vss_m1|s4_vss_m1|sb_vss|sr1_vss|sr2_vss|sr3_vss|sr4_vss|sv_vss|tg_d_vss|tg_fbm_vss|tg_fbs_vss|tg_s_vss|vss|vss_link|vss_link_bridge|vss_link_dip|vss_link_m1|vss_x1|vss_x2|vss_x3__t122
+ g_vss_m1|inv_clk_vss|inv_mc_vss|inv_q_vss|mph_g|nand_m_vss|nand_s2_vss|s1_vss_m1|s2_vss_m1|s3_vss_m1|s4_vss_m1|sb_vss|sr1_vss|sr2_vss|sr3_vss|sr4_vss|sv_vss|tg_d_vss|tg_fbm_vss|tg_fbs_vss|tg_s_vss|vss|vss_link|vss_link_bridge|vss_link_dip|vss_link_m1|vss_x1|vss_x2|vss_x3
+ 25.7878038647
* device instance g_vss_m1_inv_clk_vss_inv_mc_vss_inv_q_vss_mph_g_nand_m_vss_nand_s2_vss_s1_vss_m1_s2_vss_m1_s3_vss_m1_s4_vss_m1_sb_vss_sr1_vss_sr2_vss_sr3_vss_sr4_vss_sv_vss_tg_d_vss_tg_fbm_vss_tg_fbs_vss_tg_s_vss_vss_vss_link_vss_link_bridge_vss_link_dip_vss_link_m1_vss_x1_vss_x2_vss_x3_t123 r0 *1 0,0
Rg_vss_m1_inv_clk_vss_inv_mc_vss_inv_q_vss_mph_g_nand_m_vss_nand_s2_vss_s1_vss_m1_s2_vss_m1_s3_vss_m1_s4_vss_m1_sb_vss_sr1_vss_sr2_vss_sr3_vss_sr4_vss_sv_vss_tg_d_vss_tg_fbm_vss_tg_fbs_vss_tg_s_vss_vss_vss_link_vss_link_bridge_vss_link_dip_vss_link_m1_vss_x1_vss_x2_vss_x3_t123
+ g_vss_m1|inv_clk_vss|inv_mc_vss|inv_q_vss|mph_g|nand_m_vss|nand_s2_vss|s1_vss_m1|s2_vss_m1|s3_vss_m1|s4_vss_m1|sb_vss|sr1_vss|sr2_vss|sr3_vss|sr4_vss|sv_vss|tg_d_vss|tg_fbm_vss|tg_fbs_vss|tg_s_vss|vss|vss_link|vss_link_bridge|vss_link_dip|vss_link_m1|vss_x1|vss_x2|vss_x3__t123
+ g_vss_m1|inv_clk_vss|inv_mc_vss|inv_q_vss|mph_g|nand_m_vss|nand_s2_vss|s1_vss_m1|s2_vss_m1|s3_vss_m1|s4_vss_m1|sb_vss|sr1_vss|sr2_vss|sr3_vss|sr4_vss|sv_vss|tg_d_vss|tg_fbm_vss|tg_fbs_vss|tg_s_vss|vss|vss_link|vss_link_bridge|vss_link_dip|vss_link_m1|vss_x1|vss_x2|vss_x3
+ 140.927968055
* device instance g_vss_m1_inv_clk_vss_inv_mc_vss_inv_q_vss_mph_g_nand_m_vss_nand_s2_vss_s1_vss_m1_s2_vss_m1_s3_vss_m1_s4_vss_m1_sb_vss_sr1_vss_sr2_vss_sr3_vss_sr4_vss_sv_vss_tg_d_vss_tg_fbm_vss_tg_fbs_vss_tg_s_vss_vss_vss_link_vss_link_bridge_vss_link_dip_vss_link_m1_vss_x1_vss_x2_vss_x3_t124 r0 *1 0,0
Rg_vss_m1_inv_clk_vss_inv_mc_vss_inv_q_vss_mph_g_nand_m_vss_nand_s2_vss_s1_vss_m1_s2_vss_m1_s3_vss_m1_s4_vss_m1_sb_vss_sr1_vss_sr2_vss_sr3_vss_sr4_vss_sv_vss_tg_d_vss_tg_fbm_vss_tg_fbs_vss_tg_s_vss_vss_vss_link_vss_link_bridge_vss_link_dip_vss_link_m1_vss_x1_vss_x2_vss_x3_t124
+ g_vss_m1|inv_clk_vss|inv_mc_vss|inv_q_vss|mph_g|nand_m_vss|nand_s2_vss|s1_vss_m1|s2_vss_m1|s3_vss_m1|s4_vss_m1|sb_vss|sr1_vss|sr2_vss|sr3_vss|sr4_vss|sv_vss|tg_d_vss|tg_fbm_vss|tg_fbs_vss|tg_s_vss|vss|vss_link|vss_link_bridge|vss_link_dip|vss_link_m1|vss_x1|vss_x2|vss_x3__t124
+ g_vss_m1|inv_clk_vss|inv_mc_vss|inv_q_vss|mph_g|nand_m_vss|nand_s2_vss|s1_vss_m1|s2_vss_m1|s3_vss_m1|s4_vss_m1|sb_vss|sr1_vss|sr2_vss|sr3_vss|sr4_vss|sv_vss|tg_d_vss|tg_fbm_vss|tg_fbs_vss|tg_s_vss|vss|vss_link|vss_link_bridge|vss_link_dip|vss_link_m1|vss_x1|vss_x2|vss_x3
+ 322.475355178
* device instance g_vss_m1_inv_clk_vss_inv_mc_vss_inv_q_vss_mph_g_nand_m_vss_nand_s2_vss_s1_vss_m1_s2_vss_m1_s3_vss_m1_s4_vss_m1_sb_vss_sr1_vss_sr2_vss_sr3_vss_sr4_vss_sv_vss_tg_d_vss_tg_fbm_vss_tg_fbs_vss_tg_s_vss_vss_vss_link_vss_link_bridge_vss_link_dip_vss_link_m1_vss_x1_vss_x2_vss_x3_t125 r0 *1 0,0
Rg_vss_m1_inv_clk_vss_inv_mc_vss_inv_q_vss_mph_g_nand_m_vss_nand_s2_vss_s1_vss_m1_s2_vss_m1_s3_vss_m1_s4_vss_m1_sb_vss_sr1_vss_sr2_vss_sr3_vss_sr4_vss_sv_vss_tg_d_vss_tg_fbm_vss_tg_fbs_vss_tg_s_vss_vss_vss_link_vss_link_bridge_vss_link_dip_vss_link_m1_vss_x1_vss_x2_vss_x3_t125
+ g_vss_m1|inv_clk_vss|inv_mc_vss|inv_q_vss|mph_g|nand_m_vss|nand_s2_vss|s1_vss_m1|s2_vss_m1|s3_vss_m1|s4_vss_m1|sb_vss|sr1_vss|sr2_vss|sr3_vss|sr4_vss|sv_vss|tg_d_vss|tg_fbm_vss|tg_fbs_vss|tg_s_vss|vss|vss_link|vss_link_bridge|vss_link_dip|vss_link_m1|vss_x1|vss_x2|vss_x3__t125
+ g_vss_m1|inv_clk_vss|inv_mc_vss|inv_q_vss|mph_g|nand_m_vss|nand_s2_vss|s1_vss_m1|s2_vss_m1|s3_vss_m1|s4_vss_m1|sb_vss|sr1_vss|sr2_vss|sr3_vss|sr4_vss|sv_vss|tg_d_vss|tg_fbm_vss|tg_fbs_vss|tg_s_vss|vss|vss_link|vss_link_bridge|vss_link_dip|vss_link_m1|vss_x1|vss_x2|vss_x3
+ 303.498565649
* device instance g_vss_m1_inv_clk_vss_inv_mc_vss_inv_q_vss_mph_g_nand_m_vss_nand_s2_vss_s1_vss_m1_s2_vss_m1_s3_vss_m1_s4_vss_m1_sb_vss_sr1_vss_sr2_vss_sr3_vss_sr4_vss_sv_vss_tg_d_vss_tg_fbm_vss_tg_fbs_vss_tg_s_vss_vss_vss_link_vss_link_bridge_vss_link_dip_vss_link_m1_vss_x1_vss_x2_vss_x3_t126 r0 *1 0,0
Rg_vss_m1_inv_clk_vss_inv_mc_vss_inv_q_vss_mph_g_nand_m_vss_nand_s2_vss_s1_vss_m1_s2_vss_m1_s3_vss_m1_s4_vss_m1_sb_vss_sr1_vss_sr2_vss_sr3_vss_sr4_vss_sv_vss_tg_d_vss_tg_fbm_vss_tg_fbs_vss_tg_s_vss_vss_vss_link_vss_link_bridge_vss_link_dip_vss_link_m1_vss_x1_vss_x2_vss_x3_t126
+ g_vss_m1|inv_clk_vss|inv_mc_vss|inv_q_vss|mph_g|nand_m_vss|nand_s2_vss|s1_vss_m1|s2_vss_m1|s3_vss_m1|s4_vss_m1|sb_vss|sr1_vss|sr2_vss|sr3_vss|sr4_vss|sv_vss|tg_d_vss|tg_fbm_vss|tg_fbs_vss|tg_s_vss|vss|vss_link|vss_link_bridge|vss_link_dip|vss_link_m1|vss_x1|vss_x2|vss_x3__t126
+ g_vss_m1|inv_clk_vss|inv_mc_vss|inv_q_vss|mph_g|nand_m_vss|nand_s2_vss|s1_vss_m1|s2_vss_m1|s3_vss_m1|s4_vss_m1|sb_vss|sr1_vss|sr2_vss|sr3_vss|sr4_vss|sv_vss|tg_d_vss|tg_fbm_vss|tg_fbs_vss|tg_s_vss|vss|vss_link|vss_link_bridge|vss_link_dip|vss_link_m1|vss_x1|vss_x2|vss_x3
+ 244.360919264
* device instance g_vss_m1_inv_clk_vss_inv_mc_vss_inv_q_vss_mph_g_nand_m_vss_nand_s2_vss_s1_vss_m1_s2_vss_m1_s3_vss_m1_s4_vss_m1_sb_vss_sr1_vss_sr2_vss_sr3_vss_sr4_vss_sv_vss_tg_d_vss_tg_fbm_vss_tg_fbs_vss_tg_s_vss_vss_vss_link_vss_link_bridge_vss_link_dip_vss_link_m1_vss_x1_vss_x2_vss_x3_t127 r0 *1 0,0
Rg_vss_m1_inv_clk_vss_inv_mc_vss_inv_q_vss_mph_g_nand_m_vss_nand_s2_vss_s1_vss_m1_s2_vss_m1_s3_vss_m1_s4_vss_m1_sb_vss_sr1_vss_sr2_vss_sr3_vss_sr4_vss_sv_vss_tg_d_vss_tg_fbm_vss_tg_fbs_vss_tg_s_vss_vss_vss_link_vss_link_bridge_vss_link_dip_vss_link_m1_vss_x1_vss_x2_vss_x3_t127
+ g_vss_m1|inv_clk_vss|inv_mc_vss|inv_q_vss|mph_g|nand_m_vss|nand_s2_vss|s1_vss_m1|s2_vss_m1|s3_vss_m1|s4_vss_m1|sb_vss|sr1_vss|sr2_vss|sr3_vss|sr4_vss|sv_vss|tg_d_vss|tg_fbm_vss|tg_fbs_vss|tg_s_vss|vss|vss_link|vss_link_bridge|vss_link_dip|vss_link_m1|vss_x1|vss_x2|vss_x3__t127
+ g_vss_m1|inv_clk_vss|inv_mc_vss|inv_q_vss|mph_g|nand_m_vss|nand_s2_vss|s1_vss_m1|s2_vss_m1|s3_vss_m1|s4_vss_m1|sb_vss|sr1_vss|sr2_vss|sr3_vss|sr4_vss|sv_vss|tg_d_vss|tg_fbm_vss|tg_fbs_vss|tg_s_vss|vss|vss_link|vss_link_bridge|vss_link_dip|vss_link_m1|vss_x1|vss_x2|vss_x3
+ 225.711007155
* device instance g_vss_m1_inv_clk_vss_inv_mc_vss_inv_q_vss_mph_g_nand_m_vss_nand_s2_vss_s1_vss_m1_s2_vss_m1_s3_vss_m1_s4_vss_m1_sb_vss_sr1_vss_sr2_vss_sr3_vss_sr4_vss_sv_vss_tg_d_vss_tg_fbm_vss_tg_fbs_vss_tg_s_vss_vss_vss_link_vss_link_bridge_vss_link_dip_vss_link_m1_vss_x1_vss_x2_vss_x3_t128 r0 *1 0,0
Rg_vss_m1_inv_clk_vss_inv_mc_vss_inv_q_vss_mph_g_nand_m_vss_nand_s2_vss_s1_vss_m1_s2_vss_m1_s3_vss_m1_s4_vss_m1_sb_vss_sr1_vss_sr2_vss_sr3_vss_sr4_vss_sv_vss_tg_d_vss_tg_fbm_vss_tg_fbs_vss_tg_s_vss_vss_vss_link_vss_link_bridge_vss_link_dip_vss_link_m1_vss_x1_vss_x2_vss_x3_t128
+ g_vss_m1|inv_clk_vss|inv_mc_vss|inv_q_vss|mph_g|nand_m_vss|nand_s2_vss|s1_vss_m1|s2_vss_m1|s3_vss_m1|s4_vss_m1|sb_vss|sr1_vss|sr2_vss|sr3_vss|sr4_vss|sv_vss|tg_d_vss|tg_fbm_vss|tg_fbs_vss|tg_s_vss|vss|vss_link|vss_link_bridge|vss_link_dip|vss_link_m1|vss_x1|vss_x2|vss_x3__t128
+ g_vss_m1|inv_clk_vss|inv_mc_vss|inv_q_vss|mph_g|nand_m_vss|nand_s2_vss|s1_vss_m1|s2_vss_m1|s3_vss_m1|s4_vss_m1|sb_vss|sr1_vss|sr2_vss|sr3_vss|sr4_vss|sv_vss|tg_d_vss|tg_fbm_vss|tg_fbs_vss|tg_s_vss|vss|vss_link|vss_link_bridge|vss_link_dip|vss_link_m1|vss_x1|vss_x2|vss_x3
+ 168.268008042
* device instance g_vss_m1_inv_clk_vss_inv_mc_vss_inv_q_vss_mph_g_nand_m_vss_nand_s2_vss_s1_vss_m1_s2_vss_m1_s3_vss_m1_s4_vss_m1_sb_vss_sr1_vss_sr2_vss_sr3_vss_sr4_vss_sv_vss_tg_d_vss_tg_fbm_vss_tg_fbs_vss_tg_s_vss_vss_vss_link_vss_link_bridge_vss_link_dip_vss_link_m1_vss_x1_vss_x2_vss_x3_t129 r0 *1 0,0
Rg_vss_m1_inv_clk_vss_inv_mc_vss_inv_q_vss_mph_g_nand_m_vss_nand_s2_vss_s1_vss_m1_s2_vss_m1_s3_vss_m1_s4_vss_m1_sb_vss_sr1_vss_sr2_vss_sr3_vss_sr4_vss_sv_vss_tg_d_vss_tg_fbm_vss_tg_fbs_vss_tg_s_vss_vss_vss_link_vss_link_bridge_vss_link_dip_vss_link_m1_vss_x1_vss_x2_vss_x3_t129
+ g_vss_m1|inv_clk_vss|inv_mc_vss|inv_q_vss|mph_g|nand_m_vss|nand_s2_vss|s1_vss_m1|s2_vss_m1|s3_vss_m1|s4_vss_m1|sb_vss|sr1_vss|sr2_vss|sr3_vss|sr4_vss|sv_vss|tg_d_vss|tg_fbm_vss|tg_fbs_vss|tg_s_vss|vss|vss_link|vss_link_bridge|vss_link_dip|vss_link_m1|vss_x1|vss_x2|vss_x3__t129
+ g_vss_m1|inv_clk_vss|inv_mc_vss|inv_q_vss|mph_g|nand_m_vss|nand_s2_vss|s1_vss_m1|s2_vss_m1|s3_vss_m1|s4_vss_m1|sb_vss|sr1_vss|sr2_vss|sr3_vss|sr4_vss|sv_vss|tg_d_vss|tg_fbm_vss|tg_fbs_vss|tg_s_vss|vss|vss_link|vss_link_bridge|vss_link_dip|vss_link_m1|vss_x1|vss_x2|vss_x3
+ 150.530719956
* device instance g_vss_m1_inv_clk_vss_inv_mc_vss_inv_q_vss_mph_g_nand_m_vss_nand_s2_vss_s1_vss_m1_s2_vss_m1_s3_vss_m1_s4_vss_m1_sb_vss_sr1_vss_sr2_vss_sr3_vss_sr4_vss_sv_vss_tg_d_vss_tg_fbm_vss_tg_fbs_vss_tg_s_vss_vss_vss_link_vss_link_bridge_vss_link_dip_vss_link_m1_vss_x1_vss_x2_vss_x3_t130 r0 *1 0,0
Rg_vss_m1_inv_clk_vss_inv_mc_vss_inv_q_vss_mph_g_nand_m_vss_nand_s2_vss_s1_vss_m1_s2_vss_m1_s3_vss_m1_s4_vss_m1_sb_vss_sr1_vss_sr2_vss_sr3_vss_sr4_vss_sv_vss_tg_d_vss_tg_fbm_vss_tg_fbs_vss_tg_s_vss_vss_vss_link_vss_link_bridge_vss_link_dip_vss_link_m1_vss_x1_vss_x2_vss_x3_t130
+ g_vss_m1|inv_clk_vss|inv_mc_vss|inv_q_vss|mph_g|nand_m_vss|nand_s2_vss|s1_vss_m1|s2_vss_m1|s3_vss_m1|s4_vss_m1|sb_vss|sr1_vss|sr2_vss|sr3_vss|sr4_vss|sv_vss|tg_d_vss|tg_fbm_vss|tg_fbs_vss|tg_s_vss|vss|vss_link|vss_link_bridge|vss_link_dip|vss_link_m1|vss_x1|vss_x2|vss_x3__t130
+ g_vss_m1|inv_clk_vss|inv_mc_vss|inv_q_vss|mph_g|nand_m_vss|nand_s2_vss|s1_vss_m1|s2_vss_m1|s3_vss_m1|s4_vss_m1|sb_vss|sr1_vss|sr2_vss|sr3_vss|sr4_vss|sv_vss|tg_d_vss|tg_fbm_vss|tg_fbs_vss|tg_s_vss|vss|vss_link|vss_link_bridge|vss_link_dip|vss_link_m1|vss_x1|vss_x2|vss_x3
+ 340.723725532
* device instance g_vss_m1_inv_clk_vss_inv_mc_vss_inv_q_vss_mph_g_nand_m_vss_nand_s2_vss_s1_vss_m1_s2_vss_m1_s3_vss_m1_s4_vss_m1_sb_vss_sr1_vss_sr2_vss_sr3_vss_sr4_vss_sv_vss_tg_d_vss_tg_fbm_vss_tg_fbs_vss_tg_s_vss_vss_vss_link_vss_link_bridge_vss_link_dip_vss_link_m1_vss_x1_vss_x2_vss_x3_t131 r0 *1 0,0
Rg_vss_m1_inv_clk_vss_inv_mc_vss_inv_q_vss_mph_g_nand_m_vss_nand_s2_vss_s1_vss_m1_s2_vss_m1_s3_vss_m1_s4_vss_m1_sb_vss_sr1_vss_sr2_vss_sr3_vss_sr4_vss_sv_vss_tg_d_vss_tg_fbm_vss_tg_fbs_vss_tg_s_vss_vss_vss_link_vss_link_bridge_vss_link_dip_vss_link_m1_vss_x1_vss_x2_vss_x3_t131
+ g_vss_m1|inv_clk_vss|inv_mc_vss|inv_q_vss|mph_g|nand_m_vss|nand_s2_vss|s1_vss_m1|s2_vss_m1|s3_vss_m1|s4_vss_m1|sb_vss|sr1_vss|sr2_vss|sr3_vss|sr4_vss|sv_vss|tg_d_vss|tg_fbm_vss|tg_fbs_vss|tg_s_vss|vss|vss_link|vss_link_bridge|vss_link_dip|vss_link_m1|vss_x1|vss_x2|vss_x3__t131
+ g_vss_m1|inv_clk_vss|inv_mc_vss|inv_q_vss|mph_g|nand_m_vss|nand_s2_vss|s1_vss_m1|s2_vss_m1|s3_vss_m1|s4_vss_m1|sb_vss|sr1_vss|sr2_vss|sr3_vss|sr4_vss|sv_vss|tg_d_vss|tg_fbm_vss|tg_fbs_vss|tg_s_vss|vss|vss_link|vss_link_bridge|vss_link_dip|vss_link_m1|vss_x1|vss_x2|vss_x3
+ 327.638026688
* device instance g_vss_m1_inv_clk_vss_inv_mc_vss_inv_q_vss_mph_g_nand_m_vss_nand_s2_vss_s1_vss_m1_s2_vss_m1_s3_vss_m1_s4_vss_m1_sb_vss_sr1_vss_sr2_vss_sr3_vss_sr4_vss_sv_vss_tg_d_vss_tg_fbm_vss_tg_fbs_vss_tg_s_vss_vss_vss_link_vss_link_bridge_vss_link_dip_vss_link_m1_vss_x1_vss_x2_vss_x3_t132 r0 *1 0,0
Rg_vss_m1_inv_clk_vss_inv_mc_vss_inv_q_vss_mph_g_nand_m_vss_nand_s2_vss_s1_vss_m1_s2_vss_m1_s3_vss_m1_s4_vss_m1_sb_vss_sr1_vss_sr2_vss_sr3_vss_sr4_vss_sv_vss_tg_d_vss_tg_fbm_vss_tg_fbs_vss_tg_s_vss_vss_vss_link_vss_link_bridge_vss_link_dip_vss_link_m1_vss_x1_vss_x2_vss_x3_t132
+ g_vss_m1|inv_clk_vss|inv_mc_vss|inv_q_vss|mph_g|nand_m_vss|nand_s2_vss|s1_vss_m1|s2_vss_m1|s3_vss_m1|s4_vss_m1|sb_vss|sr1_vss|sr2_vss|sr3_vss|sr4_vss|sv_vss|tg_d_vss|tg_fbm_vss|tg_fbs_vss|tg_s_vss|vss|vss_link|vss_link_bridge|vss_link_dip|vss_link_m1|vss_x1|vss_x2|vss_x3__t132
+ g_vss_m1|inv_clk_vss|inv_mc_vss|inv_q_vss|mph_g|nand_m_vss|nand_s2_vss|s1_vss_m1|s2_vss_m1|s3_vss_m1|s4_vss_m1|sb_vss|sr1_vss|sr2_vss|sr3_vss|sr4_vss|sv_vss|tg_d_vss|tg_fbm_vss|tg_fbs_vss|tg_s_vss|vss|vss_link|vss_link_bridge|vss_link_dip|vss_link_m1|vss_x1|vss_x2|vss_x3
+ 287.813421287
* device instance g_vss_m1_inv_clk_vss_inv_mc_vss_inv_q_vss_mph_g_nand_m_vss_nand_s2_vss_s1_vss_m1_s2_vss_m1_s3_vss_m1_s4_vss_m1_sb_vss_sr1_vss_sr2_vss_sr3_vss_sr4_vss_sv_vss_tg_d_vss_tg_fbm_vss_tg_fbs_vss_tg_s_vss_vss_vss_link_vss_link_bridge_vss_link_dip_vss_link_m1_vss_x1_vss_x2_vss_x3_t133 r0 *1 0,0
Rg_vss_m1_inv_clk_vss_inv_mc_vss_inv_q_vss_mph_g_nand_m_vss_nand_s2_vss_s1_vss_m1_s2_vss_m1_s3_vss_m1_s4_vss_m1_sb_vss_sr1_vss_sr2_vss_sr3_vss_sr4_vss_sv_vss_tg_d_vss_tg_fbm_vss_tg_fbs_vss_tg_s_vss_vss_vss_link_vss_link_bridge_vss_link_dip_vss_link_m1_vss_x1_vss_x2_vss_x3_t133
+ g_vss_m1|inv_clk_vss|inv_mc_vss|inv_q_vss|mph_g|nand_m_vss|nand_s2_vss|s1_vss_m1|s2_vss_m1|s3_vss_m1|s4_vss_m1|sb_vss|sr1_vss|sr2_vss|sr3_vss|sr4_vss|sv_vss|tg_d_vss|tg_fbm_vss|tg_fbs_vss|tg_s_vss|vss|vss_link|vss_link_bridge|vss_link_dip|vss_link_m1|vss_x1|vss_x2|vss_x3__t133
+ g_vss_m1|inv_clk_vss|inv_mc_vss|inv_q_vss|mph_g|nand_m_vss|nand_s2_vss|s1_vss_m1|s2_vss_m1|s3_vss_m1|s4_vss_m1|sb_vss|sr1_vss|sr2_vss|sr3_vss|sr4_vss|sv_vss|tg_d_vss|tg_fbm_vss|tg_fbs_vss|tg_s_vss|vss|vss_link|vss_link_bridge|vss_link_dip|vss_link_m1|vss_x1|vss_x2|vss_x3
+ 274.77484113
* device instance g_vss_m1_inv_clk_vss_inv_mc_vss_inv_q_vss_mph_g_nand_m_vss_nand_s2_vss_s1_vss_m1_s2_vss_m1_s3_vss_m1_s4_vss_m1_sb_vss_sr1_vss_sr2_vss_sr3_vss_sr4_vss_sv_vss_tg_d_vss_tg_fbm_vss_tg_fbs_vss_tg_s_vss_vss_vss_link_vss_link_bridge_vss_link_dip_vss_link_m1_vss_x1_vss_x2_vss_x3_t134 r0 *1 0,0
Rg_vss_m1_inv_clk_vss_inv_mc_vss_inv_q_vss_mph_g_nand_m_vss_nand_s2_vss_s1_vss_m1_s2_vss_m1_s3_vss_m1_s4_vss_m1_sb_vss_sr1_vss_sr2_vss_sr3_vss_sr4_vss_sv_vss_tg_d_vss_tg_fbm_vss_tg_fbs_vss_tg_s_vss_vss_vss_link_vss_link_bridge_vss_link_dip_vss_link_m1_vss_x1_vss_x2_vss_x3_t134
+ g_vss_m1|inv_clk_vss|inv_mc_vss|inv_q_vss|mph_g|nand_m_vss|nand_s2_vss|s1_vss_m1|s2_vss_m1|s3_vss_m1|s4_vss_m1|sb_vss|sr1_vss|sr2_vss|sr3_vss|sr4_vss|sv_vss|tg_d_vss|tg_fbm_vss|tg_fbs_vss|tg_s_vss|vss|vss_link|vss_link_bridge|vss_link_dip|vss_link_m1|vss_x1|vss_x2|vss_x3__t134
+ g_vss_m1|inv_clk_vss|inv_mc_vss|inv_q_vss|mph_g|nand_m_vss|nand_s2_vss|s1_vss_m1|s2_vss_m1|s3_vss_m1|s4_vss_m1|sb_vss|sr1_vss|sr2_vss|sr3_vss|sr4_vss|sv_vss|tg_d_vss|tg_fbm_vss|tg_fbs_vss|tg_s_vss|vss|vss_link|vss_link_bridge|vss_link_dip|vss_link_m1|vss_x1|vss_x2|vss_x3
+ 260.728293364
* device instance g_vss_m1_inv_clk_vss_inv_mc_vss_inv_q_vss_mph_g_nand_m_vss_nand_s2_vss_s1_vss_m1_s2_vss_m1_s3_vss_m1_s4_vss_m1_sb_vss_sr1_vss_sr2_vss_sr3_vss_sr4_vss_sv_vss_tg_d_vss_tg_fbm_vss_tg_fbs_vss_tg_s_vss_vss_vss_link_vss_link_bridge_vss_link_dip_vss_link_m1_vss_x1_vss_x2_vss_x3_t135 r0 *1 0,0
Rg_vss_m1_inv_clk_vss_inv_mc_vss_inv_q_vss_mph_g_nand_m_vss_nand_s2_vss_s1_vss_m1_s2_vss_m1_s3_vss_m1_s4_vss_m1_sb_vss_sr1_vss_sr2_vss_sr3_vss_sr4_vss_sv_vss_tg_d_vss_tg_fbm_vss_tg_fbs_vss_tg_s_vss_vss_vss_link_vss_link_bridge_vss_link_dip_vss_link_m1_vss_x1_vss_x2_vss_x3_t135
+ g_vss_m1|inv_clk_vss|inv_mc_vss|inv_q_vss|mph_g|nand_m_vss|nand_s2_vss|s1_vss_m1|s2_vss_m1|s3_vss_m1|s4_vss_m1|sb_vss|sr1_vss|sr2_vss|sr3_vss|sr4_vss|sv_vss|tg_d_vss|tg_fbm_vss|tg_fbs_vss|tg_s_vss|vss|vss_link|vss_link_bridge|vss_link_dip|vss_link_m1|vss_x1|vss_x2|vss_x3__t135
+ g_vss_m1|inv_clk_vss|inv_mc_vss|inv_q_vss|mph_g|nand_m_vss|nand_s2_vss|s1_vss_m1|s2_vss_m1|s3_vss_m1|s4_vss_m1|sb_vss|sr1_vss|sr2_vss|sr3_vss|sr4_vss|sv_vss|tg_d_vss|tg_fbm_vss|tg_fbs_vss|tg_s_vss|vss|vss_link|vss_link_bridge|vss_link_dip|vss_link_m1|vss_x1|vss_x2|vss_x3
+ 242.166096824
* device instance g_vss_m1_inv_clk_vss_inv_mc_vss_inv_q_vss_mph_g_nand_m_vss_nand_s2_vss_s1_vss_m1_s2_vss_m1_s3_vss_m1_s4_vss_m1_sb_vss_sr1_vss_sr2_vss_sr3_vss_sr4_vss_sv_vss_tg_d_vss_tg_fbm_vss_tg_fbs_vss_tg_s_vss_vss_vss_link_vss_link_bridge_vss_link_dip_vss_link_m1_vss_x1_vss_x2_vss_x3_t136 r0 *1 0,0
Rg_vss_m1_inv_clk_vss_inv_mc_vss_inv_q_vss_mph_g_nand_m_vss_nand_s2_vss_s1_vss_m1_s2_vss_m1_s3_vss_m1_s4_vss_m1_sb_vss_sr1_vss_sr2_vss_sr3_vss_sr4_vss_sv_vss_tg_d_vss_tg_fbm_vss_tg_fbs_vss_tg_s_vss_vss_vss_link_vss_link_bridge_vss_link_dip_vss_link_m1_vss_x1_vss_x2_vss_x3_t136
+ g_vss_m1|inv_clk_vss|inv_mc_vss|inv_q_vss|mph_g|nand_m_vss|nand_s2_vss|s1_vss_m1|s2_vss_m1|s3_vss_m1|s4_vss_m1|sb_vss|sr1_vss|sr2_vss|sr3_vss|sr4_vss|sv_vss|tg_d_vss|tg_fbm_vss|tg_fbs_vss|tg_s_vss|vss|vss_link|vss_link_bridge|vss_link_dip|vss_link_m1|vss_x1|vss_x2|vss_x3__t136
+ g_vss_m1|inv_clk_vss|inv_mc_vss|inv_q_vss|mph_g|nand_m_vss|nand_s2_vss|s1_vss_m1|s2_vss_m1|s3_vss_m1|s4_vss_m1|sb_vss|sr1_vss|sr2_vss|sr3_vss|sr4_vss|sv_vss|tg_d_vss|tg_fbm_vss|tg_fbs_vss|tg_s_vss|vss|vss_link|vss_link_bridge|vss_link_dip|vss_link_m1|vss_x1|vss_x2|vss_x3
+ 208.245110245
* device instance g_vss_m1_inv_clk_vss_inv_mc_vss_inv_q_vss_mph_g_nand_m_vss_nand_s2_vss_s1_vss_m1_s2_vss_m1_s3_vss_m1_s4_vss_m1_sb_vss_sr1_vss_sr2_vss_sr3_vss_sr4_vss_sv_vss_tg_d_vss_tg_fbm_vss_tg_fbs_vss_tg_s_vss_vss_vss_link_vss_link_bridge_vss_link_dip_vss_link_m1_vss_x1_vss_x2_vss_x3_t137 r0 *1 0,0
Rg_vss_m1_inv_clk_vss_inv_mc_vss_inv_q_vss_mph_g_nand_m_vss_nand_s2_vss_s1_vss_m1_s2_vss_m1_s3_vss_m1_s4_vss_m1_sb_vss_sr1_vss_sr2_vss_sr3_vss_sr4_vss_sv_vss_tg_d_vss_tg_fbm_vss_tg_fbs_vss_tg_s_vss_vss_vss_link_vss_link_bridge_vss_link_dip_vss_link_m1_vss_x1_vss_x2_vss_x3_t137
+ g_vss_m1|inv_clk_vss|inv_mc_vss|inv_q_vss|mph_g|nand_m_vss|nand_s2_vss|s1_vss_m1|s2_vss_m1|s3_vss_m1|s4_vss_m1|sb_vss|sr1_vss|sr2_vss|sr3_vss|sr4_vss|sv_vss|tg_d_vss|tg_fbm_vss|tg_fbs_vss|tg_s_vss|vss|vss_link|vss_link_bridge|vss_link_dip|vss_link_m1|vss_x1|vss_x2|vss_x3__t137
+ g_vss_m1|inv_clk_vss|inv_mc_vss|inv_q_vss|mph_g|nand_m_vss|nand_s2_vss|s1_vss_m1|s2_vss_m1|s3_vss_m1|s4_vss_m1|sb_vss|sr1_vss|sr2_vss|sr3_vss|sr4_vss|sv_vss|tg_d_vss|tg_fbm_vss|tg_fbs_vss|tg_s_vss|vss|vss_link|vss_link_bridge|vss_link_dip|vss_link_m1|vss_x1|vss_x2|vss_x3
+ 188.860014474
* device instance g_vss_m1_inv_clk_vss_inv_mc_vss_inv_q_vss_mph_g_nand_m_vss_nand_s2_vss_s1_vss_m1_s2_vss_m1_s3_vss_m1_s4_vss_m1_sb_vss_sr1_vss_sr2_vss_sr3_vss_sr4_vss_sv_vss_tg_d_vss_tg_fbm_vss_tg_fbs_vss_tg_s_vss_vss_vss_link_vss_link_bridge_vss_link_dip_vss_link_m1_vss_x1_vss_x2_vss_x3_t138 r0 *1 0,0
Rg_vss_m1_inv_clk_vss_inv_mc_vss_inv_q_vss_mph_g_nand_m_vss_nand_s2_vss_s1_vss_m1_s2_vss_m1_s3_vss_m1_s4_vss_m1_sb_vss_sr1_vss_sr2_vss_sr3_vss_sr4_vss_sv_vss_tg_d_vss_tg_fbm_vss_tg_fbs_vss_tg_s_vss_vss_vss_link_vss_link_bridge_vss_link_dip_vss_link_m1_vss_x1_vss_x2_vss_x3_t138
+ g_vss_m1|inv_clk_vss|inv_mc_vss|inv_q_vss|mph_g|nand_m_vss|nand_s2_vss|s1_vss_m1|s2_vss_m1|s3_vss_m1|s4_vss_m1|sb_vss|sr1_vss|sr2_vss|sr3_vss|sr4_vss|sv_vss|tg_d_vss|tg_fbm_vss|tg_fbs_vss|tg_s_vss|vss|vss_link|vss_link_bridge|vss_link_dip|vss_link_m1|vss_x1|vss_x2|vss_x3__t138
+ g_vss_m1|inv_clk_vss|inv_mc_vss|inv_q_vss|mph_g|nand_m_vss|nand_s2_vss|s1_vss_m1|s2_vss_m1|s3_vss_m1|s4_vss_m1|sb_vss|sr1_vss|sr2_vss|sr3_vss|sr4_vss|sv_vss|tg_d_vss|tg_fbm_vss|tg_fbs_vss|tg_s_vss|vss|vss_link|vss_link_bridge|vss_link_dip|vss_link_m1|vss_x1|vss_x2|vss_x3
+ 176.046579521
* device instance g_vss_m1_inv_clk_vss_inv_mc_vss_inv_q_vss_mph_g_nand_m_vss_nand_s2_vss_s1_vss_m1_s2_vss_m1_s3_vss_m1_s4_vss_m1_sb_vss_sr1_vss_sr2_vss_sr3_vss_sr4_vss_sv_vss_tg_d_vss_tg_fbm_vss_tg_fbs_vss_tg_s_vss_vss_vss_link_vss_link_bridge_vss_link_dip_vss_link_m1_vss_x1_vss_x2_vss_x3_t139 r0 *1 0,0
Rg_vss_m1_inv_clk_vss_inv_mc_vss_inv_q_vss_mph_g_nand_m_vss_nand_s2_vss_s1_vss_m1_s2_vss_m1_s3_vss_m1_s4_vss_m1_sb_vss_sr1_vss_sr2_vss_sr3_vss_sr4_vss_sv_vss_tg_d_vss_tg_fbm_vss_tg_fbs_vss_tg_s_vss_vss_vss_link_vss_link_bridge_vss_link_dip_vss_link_m1_vss_x1_vss_x2_vss_x3_t139
+ g_vss_m1|inv_clk_vss|inv_mc_vss|inv_q_vss|mph_g|nand_m_vss|nand_s2_vss|s1_vss_m1|s2_vss_m1|s3_vss_m1|s4_vss_m1|sb_vss|sr1_vss|sr2_vss|sr3_vss|sr4_vss|sv_vss|tg_d_vss|tg_fbm_vss|tg_fbs_vss|tg_s_vss|vss|vss_link|vss_link_bridge|vss_link_dip|vss_link_m1|vss_x1|vss_x2|vss_x3__t139
+ g_vss_m1|inv_clk_vss|inv_mc_vss|inv_q_vss|mph_g|nand_m_vss|nand_s2_vss|s1_vss_m1|s2_vss_m1|s3_vss_m1|s4_vss_m1|sb_vss|sr1_vss|sr2_vss|sr3_vss|sr4_vss|sv_vss|tg_d_vss|tg_fbm_vss|tg_fbs_vss|tg_s_vss|vss|vss_link|vss_link_bridge|vss_link_dip|vss_link_m1|vss_x1|vss_x2|vss_x3
+ 137.439349262
* device instance g_vss_m1_inv_clk_vss_inv_mc_vss_inv_q_vss_mph_g_nand_m_vss_nand_s2_vss_s1_vss_m1_s2_vss_m1_s3_vss_m1_s4_vss_m1_sb_vss_sr1_vss_sr2_vss_sr3_vss_sr4_vss_sv_vss_tg_d_vss_tg_fbm_vss_tg_fbs_vss_tg_s_vss_vss_vss_link_vss_link_bridge_vss_link_dip_vss_link_m1_vss_x1_vss_x2_vss_x3_t140 r0 *1 0,0
Rg_vss_m1_inv_clk_vss_inv_mc_vss_inv_q_vss_mph_g_nand_m_vss_nand_s2_vss_s1_vss_m1_s2_vss_m1_s3_vss_m1_s4_vss_m1_sb_vss_sr1_vss_sr2_vss_sr3_vss_sr4_vss_sv_vss_tg_d_vss_tg_fbm_vss_tg_fbs_vss_tg_s_vss_vss_vss_link_vss_link_bridge_vss_link_dip_vss_link_m1_vss_x1_vss_x2_vss_x3_t140
+ g_vss_m1|inv_clk_vss|inv_mc_vss|inv_q_vss|mph_g|nand_m_vss|nand_s2_vss|s1_vss_m1|s2_vss_m1|s3_vss_m1|s4_vss_m1|sb_vss|sr1_vss|sr2_vss|sr3_vss|sr4_vss|sv_vss|tg_d_vss|tg_fbm_vss|tg_fbs_vss|tg_s_vss|vss|vss_link|vss_link_bridge|vss_link_dip|vss_link_m1|vss_x1|vss_x2|vss_x3__t140
+ g_vss_m1|inv_clk_vss|inv_mc_vss|inv_q_vss|mph_g|nand_m_vss|nand_s2_vss|s1_vss_m1|s2_vss_m1|s3_vss_m1|s4_vss_m1|sb_vss|sr1_vss|sr2_vss|sr3_vss|sr4_vss|sv_vss|tg_d_vss|tg_fbm_vss|tg_fbs_vss|tg_s_vss|vss|vss_link|vss_link_bridge|vss_link_dip|vss_link_m1|vss_x1|vss_x2|vss_x3
+ 124.997985075
* device instance g_vss_m1_inv_clk_vss_inv_mc_vss_inv_q_vss_mph_g_nand_m_vss_nand_s2_vss_s1_vss_m1_s2_vss_m1_s3_vss_m1_s4_vss_m1_sb_vss_sr1_vss_sr2_vss_sr3_vss_sr4_vss_sv_vss_tg_d_vss_tg_fbm_vss_tg_fbs_vss_tg_s_vss_vss_vss_link_vss_link_bridge_vss_link_dip_vss_link_m1_vss_x1_vss_x2_vss_x3_t141 r0 *1 0,0
Rg_vss_m1_inv_clk_vss_inv_mc_vss_inv_q_vss_mph_g_nand_m_vss_nand_s2_vss_s1_vss_m1_s2_vss_m1_s3_vss_m1_s4_vss_m1_sb_vss_sr1_vss_sr2_vss_sr3_vss_sr4_vss_sv_vss_tg_d_vss_tg_fbm_vss_tg_fbs_vss_tg_s_vss_vss_vss_link_vss_link_bridge_vss_link_dip_vss_link_m1_vss_x1_vss_x2_vss_x3_t141
+ g_vss_m1|inv_clk_vss|inv_mc_vss|inv_q_vss|mph_g|nand_m_vss|nand_s2_vss|s1_vss_m1|s2_vss_m1|s3_vss_m1|s4_vss_m1|sb_vss|sr1_vss|sr2_vss|sr3_vss|sr4_vss|sv_vss|tg_d_vss|tg_fbm_vss|tg_fbs_vss|tg_s_vss|vss|vss_link|vss_link_bridge|vss_link_dip|vss_link_m1|vss_x1|vss_x2|vss_x3__t141
+ g_vss_m1|inv_clk_vss|inv_mc_vss|inv_q_vss|mph_g|nand_m_vss|nand_s2_vss|s1_vss_m1|s2_vss_m1|s3_vss_m1|s4_vss_m1|sb_vss|sr1_vss|sr2_vss|sr3_vss|sr4_vss|sv_vss|tg_d_vss|tg_fbm_vss|tg_fbs_vss|tg_s_vss|vss|vss_link|vss_link_bridge|vss_link_dip|vss_link_m1|vss_x1|vss_x2|vss_x3
+ 111.772650769
* device instance g_vss_m1_inv_clk_vss_inv_mc_vss_inv_q_vss_mph_g_nand_m_vss_nand_s2_vss_s1_vss_m1_s2_vss_m1_s3_vss_m1_s4_vss_m1_sb_vss_sr1_vss_sr2_vss_sr3_vss_sr4_vss_sv_vss_tg_d_vss_tg_fbm_vss_tg_fbs_vss_tg_s_vss_vss_vss_link_vss_link_bridge_vss_link_dip_vss_link_m1_vss_x1_vss_x2_vss_x3_t142 r0 *1 0,0
Rg_vss_m1_inv_clk_vss_inv_mc_vss_inv_q_vss_mph_g_nand_m_vss_nand_s2_vss_s1_vss_m1_s2_vss_m1_s3_vss_m1_s4_vss_m1_sb_vss_sr1_vss_sr2_vss_sr3_vss_sr4_vss_sv_vss_tg_d_vss_tg_fbm_vss_tg_fbs_vss_tg_s_vss_vss_vss_link_vss_link_bridge_vss_link_dip_vss_link_m1_vss_x1_vss_x2_vss_x3_t142
+ g_vss_m1|inv_clk_vss|inv_mc_vss|inv_q_vss|mph_g|nand_m_vss|nand_s2_vss|s1_vss_m1|s2_vss_m1|s3_vss_m1|s4_vss_m1|sb_vss|sr1_vss|sr2_vss|sr3_vss|sr4_vss|sv_vss|tg_d_vss|tg_fbm_vss|tg_fbs_vss|tg_s_vss|vss|vss_link|vss_link_bridge|vss_link_dip|vss_link_m1|vss_x1|vss_x2|vss_x3__t142
+ g_vss_m1|inv_clk_vss|inv_mc_vss|inv_q_vss|mph_g|nand_m_vss|nand_s2_vss|s1_vss_m1|s2_vss_m1|s3_vss_m1|s4_vss_m1|sb_vss|sr1_vss|sr2_vss|sr3_vss|sr4_vss|sv_vss|tg_d_vss|tg_fbm_vss|tg_fbs_vss|tg_s_vss|vss|vss_link|vss_link_bridge|vss_link_dip|vss_link_m1|vss_x1|vss_x2|vss_x3
+ 94.7161403067
* device instance g_vss_m1_inv_clk_vss_inv_mc_vss_inv_q_vss_mph_g_nand_m_vss_nand_s2_vss_s1_vss_m1_s2_vss_m1_s3_vss_m1_s4_vss_m1_sb_vss_sr1_vss_sr2_vss_sr3_vss_sr4_vss_sv_vss_tg_d_vss_tg_fbm_vss_tg_fbs_vss_tg_s_vss_vss_vss_link_vss_link_bridge_vss_link_dip_vss_link_m1_vss_x1_vss_x2_vss_x3_t143 r0 *1 0,0
Rg_vss_m1_inv_clk_vss_inv_mc_vss_inv_q_vss_mph_g_nand_m_vss_nand_s2_vss_s1_vss_m1_s2_vss_m1_s3_vss_m1_s4_vss_m1_sb_vss_sr1_vss_sr2_vss_sr3_vss_sr4_vss_sv_vss_tg_d_vss_tg_fbm_vss_tg_fbs_vss_tg_s_vss_vss_vss_link_vss_link_bridge_vss_link_dip_vss_link_m1_vss_x1_vss_x2_vss_x3_t143
+ g_vss_m1|inv_clk_vss|inv_mc_vss|inv_q_vss|mph_g|nand_m_vss|nand_s2_vss|s1_vss_m1|s2_vss_m1|s3_vss_m1|s4_vss_m1|sb_vss|sr1_vss|sr2_vss|sr3_vss|sr4_vss|sv_vss|tg_d_vss|tg_fbm_vss|tg_fbs_vss|tg_s_vss|vss|vss_link|vss_link_bridge|vss_link_dip|vss_link_m1|vss_x1|vss_x2|vss_x3__t143
+ g_vss_m1|inv_clk_vss|inv_mc_vss|inv_q_vss|mph_g|nand_m_vss|nand_s2_vss|s1_vss_m1|s2_vss_m1|s3_vss_m1|s4_vss_m1|sb_vss|sr1_vss|sr2_vss|sr3_vss|sr4_vss|sv_vss|tg_d_vss|tg_fbm_vss|tg_fbs_vss|tg_s_vss|vss|vss_link|vss_link_bridge|vss_link_dip|vss_link_m1|vss_x1|vss_x2|vss_x3
+ 66.0111336556
* device instance g_vss_m1_inv_clk_vss_inv_mc_vss_inv_q_vss_mph_g_nand_m_vss_nand_s2_vss_s1_vss_m1_s2_vss_m1_s3_vss_m1_s4_vss_m1_sb_vss_sr1_vss_sr2_vss_sr3_vss_sr4_vss_sv_vss_tg_d_vss_tg_fbm_vss_tg_fbs_vss_tg_s_vss_vss_vss_link_vss_link_bridge_vss_link_dip_vss_link_m1_vss_x1_vss_x2_vss_x3_t144 r0 *1 0,0
Rg_vss_m1_inv_clk_vss_inv_mc_vss_inv_q_vss_mph_g_nand_m_vss_nand_s2_vss_s1_vss_m1_s2_vss_m1_s3_vss_m1_s4_vss_m1_sb_vss_sr1_vss_sr2_vss_sr3_vss_sr4_vss_sv_vss_tg_d_vss_tg_fbm_vss_tg_fbs_vss_tg_s_vss_vss_vss_link_vss_link_bridge_vss_link_dip_vss_link_m1_vss_x1_vss_x2_vss_x3_t144
+ g_vss_m1|inv_clk_vss|inv_mc_vss|inv_q_vss|mph_g|nand_m_vss|nand_s2_vss|s1_vss_m1|s2_vss_m1|s3_vss_m1|s4_vss_m1|sb_vss|sr1_vss|sr2_vss|sr3_vss|sr4_vss|sv_vss|tg_d_vss|tg_fbm_vss|tg_fbs_vss|tg_s_vss|vss|vss_link|vss_link_bridge|vss_link_dip|vss_link_m1|vss_x1|vss_x2|vss_x3__t144
+ g_vss_m1|inv_clk_vss|inv_mc_vss|inv_q_vss|mph_g|nand_m_vss|nand_s2_vss|s1_vss_m1|s2_vss_m1|s3_vss_m1|s4_vss_m1|sb_vss|sr1_vss|sr2_vss|sr3_vss|sr4_vss|sv_vss|tg_d_vss|tg_fbm_vss|tg_fbs_vss|tg_s_vss|vss|vss_link|vss_link_bridge|vss_link_dip|vss_link_m1|vss_x1|vss_x2|vss_x3
+ 52.8057762744
* device instance g_vss_m1_inv_clk_vss_inv_mc_vss_inv_q_vss_mph_g_nand_m_vss_nand_s2_vss_s1_vss_m1_s2_vss_m1_s3_vss_m1_s4_vss_m1_sb_vss_sr1_vss_sr2_vss_sr3_vss_sr4_vss_sv_vss_tg_d_vss_tg_fbm_vss_tg_fbs_vss_tg_s_vss_vss_vss_link_vss_link_bridge_vss_link_dip_vss_link_m1_vss_x1_vss_x2_vss_x3_t145 r0 *1 0,0
Rg_vss_m1_inv_clk_vss_inv_mc_vss_inv_q_vss_mph_g_nand_m_vss_nand_s2_vss_s1_vss_m1_s2_vss_m1_s3_vss_m1_s4_vss_m1_sb_vss_sr1_vss_sr2_vss_sr3_vss_sr4_vss_sv_vss_tg_d_vss_tg_fbm_vss_tg_fbs_vss_tg_s_vss_vss_vss_link_vss_link_bridge_vss_link_dip_vss_link_m1_vss_x1_vss_x2_vss_x3_t145
+ g_vss_m1|inv_clk_vss|inv_mc_vss|inv_q_vss|mph_g|nand_m_vss|nand_s2_vss|s1_vss_m1|s2_vss_m1|s3_vss_m1|s4_vss_m1|sb_vss|sr1_vss|sr2_vss|sr3_vss|sr4_vss|sv_vss|tg_d_vss|tg_fbm_vss|tg_fbs_vss|tg_s_vss|vss|vss_link|vss_link_bridge|vss_link_dip|vss_link_m1|vss_x1|vss_x2|vss_x3__t145
+ g_vss_m1|inv_clk_vss|inv_mc_vss|inv_q_vss|mph_g|nand_m_vss|nand_s2_vss|s1_vss_m1|s2_vss_m1|s3_vss_m1|s4_vss_m1|sb_vss|sr1_vss|sr2_vss|sr3_vss|sr4_vss|sv_vss|tg_d_vss|tg_fbm_vss|tg_fbs_vss|tg_s_vss|vss|vss_link|vss_link_bridge|vss_link_dip|vss_link_m1|vss_x1|vss_x2|vss_x3
+ 46.7227653733
* device instance g_vss_m1_inv_clk_vss_inv_mc_vss_inv_q_vss_mph_g_nand_m_vss_nand_s2_vss_s1_vss_m1_s2_vss_m1_s3_vss_m1_s4_vss_m1_sb_vss_sr1_vss_sr2_vss_sr3_vss_sr4_vss_sv_vss_tg_d_vss_tg_fbm_vss_tg_fbs_vss_tg_s_vss_vss_vss_link_vss_link_bridge_vss_link_dip_vss_link_m1_vss_x1_vss_x2_vss_x3_t146 r0 *1 0,0
Rg_vss_m1_inv_clk_vss_inv_mc_vss_inv_q_vss_mph_g_nand_m_vss_nand_s2_vss_s1_vss_m1_s2_vss_m1_s3_vss_m1_s4_vss_m1_sb_vss_sr1_vss_sr2_vss_sr3_vss_sr4_vss_sv_vss_tg_d_vss_tg_fbm_vss_tg_fbs_vss_tg_s_vss_vss_vss_link_vss_link_bridge_vss_link_dip_vss_link_m1_vss_x1_vss_x2_vss_x3_t146
+ g_vss_m1|inv_clk_vss|inv_mc_vss|inv_q_vss|mph_g|nand_m_vss|nand_s2_vss|s1_vss_m1|s2_vss_m1|s3_vss_m1|s4_vss_m1|sb_vss|sr1_vss|sr2_vss|sr3_vss|sr4_vss|sv_vss|tg_d_vss|tg_fbm_vss|tg_fbs_vss|tg_s_vss|vss|vss_link|vss_link_bridge|vss_link_dip|vss_link_m1|vss_x1|vss_x2|vss_x3__t146
+ g_vss_m1|inv_clk_vss|inv_mc_vss|inv_q_vss|mph_g|nand_m_vss|nand_s2_vss|s1_vss_m1|s2_vss_m1|s3_vss_m1|s4_vss_m1|sb_vss|sr1_vss|sr2_vss|sr3_vss|sr4_vss|sv_vss|tg_d_vss|tg_fbm_vss|tg_fbs_vss|tg_s_vss|vss|vss_link|vss_link_bridge|vss_link_dip|vss_link_m1|vss_x1|vss_x2|vss_x3
+ 49.8746528061
* device instance g_vss_m1_inv_clk_vss_inv_mc_vss_inv_q_vss_mph_g_nand_m_vss_nand_s2_vss_s1_vss_m1_s2_vss_m1_s3_vss_m1_s4_vss_m1_sb_vss_sr1_vss_sr2_vss_sr3_vss_sr4_vss_sv_vss_tg_d_vss_tg_fbm_vss_tg_fbs_vss_tg_s_vss_vss_vss_link_vss_link_bridge_vss_link_dip_vss_link_m1_vss_x1_vss_x2_vss_x3_t147 r0 *1 0,0
Rg_vss_m1_inv_clk_vss_inv_mc_vss_inv_q_vss_mph_g_nand_m_vss_nand_s2_vss_s1_vss_m1_s2_vss_m1_s3_vss_m1_s4_vss_m1_sb_vss_sr1_vss_sr2_vss_sr3_vss_sr4_vss_sv_vss_tg_d_vss_tg_fbm_vss_tg_fbs_vss_tg_s_vss_vss_vss_link_vss_link_bridge_vss_link_dip_vss_link_m1_vss_x1_vss_x2_vss_x3_t147
+ g_vss_m1|inv_clk_vss|inv_mc_vss|inv_q_vss|mph_g|nand_m_vss|nand_s2_vss|s1_vss_m1|s2_vss_m1|s3_vss_m1|s4_vss_m1|sb_vss|sr1_vss|sr2_vss|sr3_vss|sr4_vss|sv_vss|tg_d_vss|tg_fbm_vss|tg_fbs_vss|tg_s_vss|vss|vss_link|vss_link_bridge|vss_link_dip|vss_link_m1|vss_x1|vss_x2|vss_x3__t147
+ g_vss_m1|inv_clk_vss|inv_mc_vss|inv_q_vss|mph_g|nand_m_vss|nand_s2_vss|s1_vss_m1|s2_vss_m1|s3_vss_m1|s4_vss_m1|sb_vss|sr1_vss|sr2_vss|sr3_vss|sr4_vss|sv_vss|tg_d_vss|tg_fbm_vss|tg_fbs_vss|tg_s_vss|vss|vss_link|vss_link_bridge|vss_link_dip|vss_link_m1|vss_x1|vss_x2|vss_x3
+ 57.3818459285
* device instance g_vss_m1_inv_clk_vss_inv_mc_vss_inv_q_vss_mph_g_nand_m_vss_nand_s2_vss_s1_vss_m1_s2_vss_m1_s3_vss_m1_s4_vss_m1_sb_vss_sr1_vss_sr2_vss_sr3_vss_sr4_vss_sv_vss_tg_d_vss_tg_fbm_vss_tg_fbs_vss_tg_s_vss_vss_vss_link_vss_link_bridge_vss_link_dip_vss_link_m1_vss_x1_vss_x2_vss_x3_t148 r0 *1 0,0
Rg_vss_m1_inv_clk_vss_inv_mc_vss_inv_q_vss_mph_g_nand_m_vss_nand_s2_vss_s1_vss_m1_s2_vss_m1_s3_vss_m1_s4_vss_m1_sb_vss_sr1_vss_sr2_vss_sr3_vss_sr4_vss_sv_vss_tg_d_vss_tg_fbm_vss_tg_fbs_vss_tg_s_vss_vss_vss_link_vss_link_bridge_vss_link_dip_vss_link_m1_vss_x1_vss_x2_vss_x3_t148
+ g_vss_m1|inv_clk_vss|inv_mc_vss|inv_q_vss|mph_g|nand_m_vss|nand_s2_vss|s1_vss_m1|s2_vss_m1|s3_vss_m1|s4_vss_m1|sb_vss|sr1_vss|sr2_vss|sr3_vss|sr4_vss|sv_vss|tg_d_vss|tg_fbm_vss|tg_fbs_vss|tg_s_vss|vss|vss_link|vss_link_bridge|vss_link_dip|vss_link_m1|vss_x1|vss_x2|vss_x3__t148
+ g_vss_m1|inv_clk_vss|inv_mc_vss|inv_q_vss|mph_g|nand_m_vss|nand_s2_vss|s1_vss_m1|s2_vss_m1|s3_vss_m1|s4_vss_m1|sb_vss|sr1_vss|sr2_vss|sr3_vss|sr4_vss|sv_vss|tg_d_vss|tg_fbm_vss|tg_fbs_vss|tg_s_vss|vss|vss_link|vss_link_bridge|vss_link_dip|vss_link_m1|vss_x1|vss_x2|vss_x3
+ 67.4678069432
* device instance g_vss_m1_inv_clk_vss_inv_mc_vss_inv_q_vss_mph_g_nand_m_vss_nand_s2_vss_s1_vss_m1_s2_vss_m1_s3_vss_m1_s4_vss_m1_sb_vss_sr1_vss_sr2_vss_sr3_vss_sr4_vss_sv_vss_tg_d_vss_tg_fbm_vss_tg_fbs_vss_tg_s_vss_vss_vss_link_vss_link_bridge_vss_link_dip_vss_link_m1_vss_x1_vss_x2_vss_x3_t149 r0 *1 0,0
Rg_vss_m1_inv_clk_vss_inv_mc_vss_inv_q_vss_mph_g_nand_m_vss_nand_s2_vss_s1_vss_m1_s2_vss_m1_s3_vss_m1_s4_vss_m1_sb_vss_sr1_vss_sr2_vss_sr3_vss_sr4_vss_sv_vss_tg_d_vss_tg_fbm_vss_tg_fbs_vss_tg_s_vss_vss_vss_link_vss_link_bridge_vss_link_dip_vss_link_m1_vss_x1_vss_x2_vss_x3_t149
+ g_vss_m1|inv_clk_vss|inv_mc_vss|inv_q_vss|mph_g|nand_m_vss|nand_s2_vss|s1_vss_m1|s2_vss_m1|s3_vss_m1|s4_vss_m1|sb_vss|sr1_vss|sr2_vss|sr3_vss|sr4_vss|sv_vss|tg_d_vss|tg_fbm_vss|tg_fbs_vss|tg_s_vss|vss|vss_link|vss_link_bridge|vss_link_dip|vss_link_m1|vss_x1|vss_x2|vss_x3__t149
+ g_vss_m1|inv_clk_vss|inv_mc_vss|inv_q_vss|mph_g|nand_m_vss|nand_s2_vss|s1_vss_m1|s2_vss_m1|s3_vss_m1|s4_vss_m1|sb_vss|sr1_vss|sr2_vss|sr3_vss|sr4_vss|sv_vss|tg_d_vss|tg_fbm_vss|tg_fbs_vss|tg_s_vss|vss|vss_link|vss_link_bridge|vss_link_dip|vss_link_m1|vss_x1|vss_x2|vss_x3
+ 82.7210555587
* device instance g_vss_m1_inv_clk_vss_inv_mc_vss_inv_q_vss_mph_g_nand_m_vss_nand_s2_vss_s1_vss_m1_s2_vss_m1_s3_vss_m1_s4_vss_m1_sb_vss_sr1_vss_sr2_vss_sr3_vss_sr4_vss_sv_vss_tg_d_vss_tg_fbm_vss_tg_fbs_vss_tg_s_vss_vss_vss_link_vss_link_bridge_vss_link_dip_vss_link_m1_vss_x1_vss_x2_vss_x3_t150 r0 *1 0,0
Rg_vss_m1_inv_clk_vss_inv_mc_vss_inv_q_vss_mph_g_nand_m_vss_nand_s2_vss_s1_vss_m1_s2_vss_m1_s3_vss_m1_s4_vss_m1_sb_vss_sr1_vss_sr2_vss_sr3_vss_sr4_vss_sv_vss_tg_d_vss_tg_fbm_vss_tg_fbs_vss_tg_s_vss_vss_vss_link_vss_link_bridge_vss_link_dip_vss_link_m1_vss_x1_vss_x2_vss_x3_t150
+ g_vss_m1|inv_clk_vss|inv_mc_vss|inv_q_vss|mph_g|nand_m_vss|nand_s2_vss|s1_vss_m1|s2_vss_m1|s3_vss_m1|s4_vss_m1|sb_vss|sr1_vss|sr2_vss|sr3_vss|sr4_vss|sv_vss|tg_d_vss|tg_fbm_vss|tg_fbs_vss|tg_s_vss|vss|vss_link|vss_link_bridge|vss_link_dip|vss_link_m1|vss_x1|vss_x2|vss_x3__t150
+ g_vss_m1|inv_clk_vss|inv_mc_vss|inv_q_vss|mph_g|nand_m_vss|nand_s2_vss|s1_vss_m1|s2_vss_m1|s3_vss_m1|s4_vss_m1|sb_vss|sr1_vss|sr2_vss|sr3_vss|sr4_vss|sv_vss|tg_d_vss|tg_fbm_vss|tg_fbs_vss|tg_s_vss|vss|vss_link|vss_link_bridge|vss_link_dip|vss_link_m1|vss_x1|vss_x2|vss_x3
+ 113.550916361
* device instance g_vss_m1_inv_clk_vss_inv_mc_vss_inv_q_vss_mph_g_nand_m_vss_nand_s2_vss_s1_vss_m1_s2_vss_m1_s3_vss_m1_s4_vss_m1_sb_vss_sr1_vss_sr2_vss_sr3_vss_sr4_vss_sv_vss_tg_d_vss_tg_fbm_vss_tg_fbs_vss_tg_s_vss_vss_vss_link_vss_link_bridge_vss_link_dip_vss_link_m1_vss_x1_vss_x2_vss_x3_t151 r0 *1 0,0
Rg_vss_m1_inv_clk_vss_inv_mc_vss_inv_q_vss_mph_g_nand_m_vss_nand_s2_vss_s1_vss_m1_s2_vss_m1_s3_vss_m1_s4_vss_m1_sb_vss_sr1_vss_sr2_vss_sr3_vss_sr4_vss_sv_vss_tg_d_vss_tg_fbm_vss_tg_fbs_vss_tg_s_vss_vss_vss_link_vss_link_bridge_vss_link_dip_vss_link_m1_vss_x1_vss_x2_vss_x3_t151
+ g_vss_m1|inv_clk_vss|inv_mc_vss|inv_q_vss|mph_g|nand_m_vss|nand_s2_vss|s1_vss_m1|s2_vss_m1|s3_vss_m1|s4_vss_m1|sb_vss|sr1_vss|sr2_vss|sr3_vss|sr4_vss|sv_vss|tg_d_vss|tg_fbm_vss|tg_fbs_vss|tg_s_vss|vss|vss_link|vss_link_bridge|vss_link_dip|vss_link_m1|vss_x1|vss_x2|vss_x3__t151
+ g_vss_m1|inv_clk_vss|inv_mc_vss|inv_q_vss|mph_g|nand_m_vss|nand_s2_vss|s1_vss_m1|s2_vss_m1|s3_vss_m1|s4_vss_m1|sb_vss|sr1_vss|sr2_vss|sr3_vss|sr4_vss|sv_vss|tg_d_vss|tg_fbm_vss|tg_fbs_vss|tg_s_vss|vss|vss_link|vss_link_bridge|vss_link_dip|vss_link_m1|vss_x1|vss_x2|vss_x3
+ 132.112421684
* device instance g_vss_m1_inv_clk_vss_inv_mc_vss_inv_q_vss_mph_g_nand_m_vss_nand_s2_vss_s1_vss_m1_s2_vss_m1_s3_vss_m1_s4_vss_m1_sb_vss_sr1_vss_sr2_vss_sr3_vss_sr4_vss_sv_vss_tg_d_vss_tg_fbm_vss_tg_fbs_vss_tg_s_vss_vss_vss_link_vss_link_bridge_vss_link_dip_vss_link_m1_vss_x1_vss_x2_vss_x3_t152 r0 *1 0,0
Rg_vss_m1_inv_clk_vss_inv_mc_vss_inv_q_vss_mph_g_nand_m_vss_nand_s2_vss_s1_vss_m1_s2_vss_m1_s3_vss_m1_s4_vss_m1_sb_vss_sr1_vss_sr2_vss_sr3_vss_sr4_vss_sv_vss_tg_d_vss_tg_fbm_vss_tg_fbs_vss_tg_s_vss_vss_vss_link_vss_link_bridge_vss_link_dip_vss_link_m1_vss_x1_vss_x2_vss_x3_t152
+ g_vss_m1|inv_clk_vss|inv_mc_vss|inv_q_vss|mph_g|nand_m_vss|nand_s2_vss|s1_vss_m1|s2_vss_m1|s3_vss_m1|s4_vss_m1|sb_vss|sr1_vss|sr2_vss|sr3_vss|sr4_vss|sv_vss|tg_d_vss|tg_fbm_vss|tg_fbs_vss|tg_s_vss|vss|vss_link|vss_link_bridge|vss_link_dip|vss_link_m1|vss_x1|vss_x2|vss_x3__t152
+ g_vss_m1|inv_clk_vss|inv_mc_vss|inv_q_vss|mph_g|nand_m_vss|nand_s2_vss|s1_vss_m1|s2_vss_m1|s3_vss_m1|s4_vss_m1|sb_vss|sr1_vss|sr2_vss|sr3_vss|sr4_vss|sv_vss|tg_d_vss|tg_fbm_vss|tg_fbs_vss|tg_s_vss|vss|vss_link|vss_link_bridge|vss_link_dip|vss_link_m1|vss_x1|vss_x2|vss_x3
+ 144.632404605
* device instance g_vss_m1_inv_clk_vss_inv_mc_vss_inv_q_vss_mph_g_nand_m_vss_nand_s2_vss_s1_vss_m1_s2_vss_m1_s3_vss_m1_s4_vss_m1_sb_vss_sr1_vss_sr2_vss_sr3_vss_sr4_vss_sv_vss_tg_d_vss_tg_fbm_vss_tg_fbs_vss_tg_s_vss_vss_vss_link_vss_link_bridge_vss_link_dip_vss_link_m1_vss_x1_vss_x2_vss_x3_t153 r0 *1 0,0
Rg_vss_m1_inv_clk_vss_inv_mc_vss_inv_q_vss_mph_g_nand_m_vss_nand_s2_vss_s1_vss_m1_s2_vss_m1_s3_vss_m1_s4_vss_m1_sb_vss_sr1_vss_sr2_vss_sr3_vss_sr4_vss_sv_vss_tg_d_vss_tg_fbm_vss_tg_fbs_vss_tg_s_vss_vss_vss_link_vss_link_bridge_vss_link_dip_vss_link_m1_vss_x1_vss_x2_vss_x3_t153
+ g_vss_m1|inv_clk_vss|inv_mc_vss|inv_q_vss|mph_g|nand_m_vss|nand_s2_vss|s1_vss_m1|s2_vss_m1|s3_vss_m1|s4_vss_m1|sb_vss|sr1_vss|sr2_vss|sr3_vss|sr4_vss|sv_vss|tg_d_vss|tg_fbm_vss|tg_fbs_vss|tg_s_vss|vss|vss_link|vss_link_bridge|vss_link_dip|vss_link_m1|vss_x1|vss_x2|vss_x3__t153
+ g_vss_m1|inv_clk_vss|inv_mc_vss|inv_q_vss|mph_g|nand_m_vss|nand_s2_vss|s1_vss_m1|s2_vss_m1|s3_vss_m1|s4_vss_m1|sb_vss|sr1_vss|sr2_vss|sr3_vss|sr4_vss|sv_vss|tg_d_vss|tg_fbm_vss|tg_fbs_vss|tg_s_vss|vss|vss_link|vss_link_bridge|vss_link_dip|vss_link_m1|vss_x1|vss_x2|vss_x3
+ 183.385616322
* device instance g_vss_m1_inv_clk_vss_inv_mc_vss_inv_q_vss_mph_g_nand_m_vss_nand_s2_vss_s1_vss_m1_s2_vss_m1_s3_vss_m1_s4_vss_m1_sb_vss_sr1_vss_sr2_vss_sr3_vss_sr4_vss_sv_vss_tg_d_vss_tg_fbm_vss_tg_fbs_vss_tg_s_vss_vss_vss_link_vss_link_bridge_vss_link_dip_vss_link_m1_vss_x1_vss_x2_vss_x3_t154 r0 *1 0,0
Rg_vss_m1_inv_clk_vss_inv_mc_vss_inv_q_vss_mph_g_nand_m_vss_nand_s2_vss_s1_vss_m1_s2_vss_m1_s3_vss_m1_s4_vss_m1_sb_vss_sr1_vss_sr2_vss_sr3_vss_sr4_vss_sv_vss_tg_d_vss_tg_fbm_vss_tg_fbs_vss_tg_s_vss_vss_vss_link_vss_link_bridge_vss_link_dip_vss_link_m1_vss_x1_vss_x2_vss_x3_t154
+ g_vss_m1|inv_clk_vss|inv_mc_vss|inv_q_vss|mph_g|nand_m_vss|nand_s2_vss|s1_vss_m1|s2_vss_m1|s3_vss_m1|s4_vss_m1|sb_vss|sr1_vss|sr2_vss|sr3_vss|sr4_vss|sv_vss|tg_d_vss|tg_fbm_vss|tg_fbs_vss|tg_s_vss|vss|vss_link|vss_link_bridge|vss_link_dip|vss_link_m1|vss_x1|vss_x2|vss_x3__t154
+ g_vss_m1|inv_clk_vss|inv_mc_vss|inv_q_vss|mph_g|nand_m_vss|nand_s2_vss|s1_vss_m1|s2_vss_m1|s3_vss_m1|s4_vss_m1|sb_vss|sr1_vss|sr2_vss|sr3_vss|sr4_vss|sv_vss|tg_d_vss|tg_fbm_vss|tg_fbs_vss|tg_s_vss|vss|vss_link|vss_link_bridge|vss_link_dip|vss_link_m1|vss_x1|vss_x2|vss_x3
+ 196.228828733
* device instance g_vss_m1_inv_clk_vss_inv_mc_vss_inv_q_vss_mph_g_nand_m_vss_nand_s2_vss_s1_vss_m1_s2_vss_m1_s3_vss_m1_s4_vss_m1_sb_vss_sr1_vss_sr2_vss_sr3_vss_sr4_vss_sv_vss_tg_d_vss_tg_fbm_vss_tg_fbs_vss_tg_s_vss_vss_vss_link_vss_link_bridge_vss_link_dip_vss_link_m1_vss_x1_vss_x2_vss_x3_t155 r0 *1 0,0
Rg_vss_m1_inv_clk_vss_inv_mc_vss_inv_q_vss_mph_g_nand_m_vss_nand_s2_vss_s1_vss_m1_s2_vss_m1_s3_vss_m1_s4_vss_m1_sb_vss_sr1_vss_sr2_vss_sr3_vss_sr4_vss_sv_vss_tg_d_vss_tg_fbm_vss_tg_fbs_vss_tg_s_vss_vss_vss_link_vss_link_bridge_vss_link_dip_vss_link_m1_vss_x1_vss_x2_vss_x3_t155
+ g_vss_m1|inv_clk_vss|inv_mc_vss|inv_q_vss|mph_g|nand_m_vss|nand_s2_vss|s1_vss_m1|s2_vss_m1|s3_vss_m1|s4_vss_m1|sb_vss|sr1_vss|sr2_vss|sr3_vss|sr4_vss|sv_vss|tg_d_vss|tg_fbm_vss|tg_fbs_vss|tg_s_vss|vss|vss_link|vss_link_bridge|vss_link_dip|vss_link_m1|vss_x1|vss_x2|vss_x3__t155
+ g_vss_m1|inv_clk_vss|inv_mc_vss|inv_q_vss|mph_g|nand_m_vss|nand_s2_vss|s1_vss_m1|s2_vss_m1|s3_vss_m1|s4_vss_m1|sb_vss|sr1_vss|sr2_vss|sr3_vss|sr4_vss|sv_vss|tg_d_vss|tg_fbm_vss|tg_fbs_vss|tg_s_vss|vss|vss_link|vss_link_bridge|vss_link_dip|vss_link_m1|vss_x1|vss_x2|vss_x3
+ 210.132295238
* device instance g_vss_m1_inv_clk_vss_inv_mc_vss_inv_q_vss_mph_g_nand_m_vss_nand_s2_vss_s1_vss_m1_s2_vss_m1_s3_vss_m1_s4_vss_m1_sb_vss_sr1_vss_sr2_vss_sr3_vss_sr4_vss_sv_vss_tg_d_vss_tg_fbm_vss_tg_fbs_vss_tg_s_vss_vss_vss_link_vss_link_bridge_vss_link_dip_vss_link_m1_vss_x1_vss_x2_vss_x3_t156 r0 *1 0,0
Rg_vss_m1_inv_clk_vss_inv_mc_vss_inv_q_vss_mph_g_nand_m_vss_nand_s2_vss_s1_vss_m1_s2_vss_m1_s3_vss_m1_s4_vss_m1_sb_vss_sr1_vss_sr2_vss_sr3_vss_sr4_vss_sv_vss_tg_d_vss_tg_fbm_vss_tg_fbs_vss_tg_s_vss_vss_vss_link_vss_link_bridge_vss_link_dip_vss_link_m1_vss_x1_vss_x2_vss_x3_t156
+ g_vss_m1|inv_clk_vss|inv_mc_vss|inv_q_vss|mph_g|nand_m_vss|nand_s2_vss|s1_vss_m1|s2_vss_m1|s3_vss_m1|s4_vss_m1|sb_vss|sr1_vss|sr2_vss|sr3_vss|sr4_vss|sv_vss|tg_d_vss|tg_fbm_vss|tg_fbs_vss|tg_s_vss|vss|vss_link|vss_link_bridge|vss_link_dip|vss_link_m1|vss_x1|vss_x2|vss_x3__t156
+ g_vss_m1|inv_clk_vss|inv_mc_vss|inv_q_vss|mph_g|nand_m_vss|nand_s2_vss|s1_vss_m1|s2_vss_m1|s3_vss_m1|s4_vss_m1|sb_vss|sr1_vss|sr2_vss|sr3_vss|sr4_vss|sv_vss|tg_d_vss|tg_fbm_vss|tg_fbs_vss|tg_s_vss|vss|vss_link|vss_link_bridge|vss_link_dip|vss_link_m1|vss_x1|vss_x2|vss_x3
+ 228.602921778
* device instance g_vss_m1_inv_clk_vss_inv_mc_vss_inv_q_vss_mph_g_nand_m_vss_nand_s2_vss_s1_vss_m1_s2_vss_m1_s3_vss_m1_s4_vss_m1_sb_vss_sr1_vss_sr2_vss_sr3_vss_sr4_vss_sv_vss_tg_d_vss_tg_fbm_vss_tg_fbs_vss_tg_s_vss_vss_vss_link_vss_link_bridge_vss_link_dip_vss_link_m1_vss_x1_vss_x2_vss_x3_t157 r0 *1 0,0
Rg_vss_m1_inv_clk_vss_inv_mc_vss_inv_q_vss_mph_g_nand_m_vss_nand_s2_vss_s1_vss_m1_s2_vss_m1_s3_vss_m1_s4_vss_m1_sb_vss_sr1_vss_sr2_vss_sr3_vss_sr4_vss_sv_vss_tg_d_vss_tg_fbm_vss_tg_fbs_vss_tg_s_vss_vss_vss_link_vss_link_bridge_vss_link_dip_vss_link_m1_vss_x1_vss_x2_vss_x3_t157
+ g_vss_m1|inv_clk_vss|inv_mc_vss|inv_q_vss|mph_g|nand_m_vss|nand_s2_vss|s1_vss_m1|s2_vss_m1|s3_vss_m1|s4_vss_m1|sb_vss|sr1_vss|sr2_vss|sr3_vss|sr4_vss|sv_vss|tg_d_vss|tg_fbm_vss|tg_fbs_vss|tg_s_vss|vss|vss_link|vss_link_bridge|vss_link_dip|vss_link_m1|vss_x1|vss_x2|vss_x3__t157
+ g_vss_m1|inv_clk_vss|inv_mc_vss|inv_q_vss|mph_g|nand_m_vss|nand_s2_vss|s1_vss_m1|s2_vss_m1|s3_vss_m1|s4_vss_m1|sb_vss|sr1_vss|sr2_vss|sr3_vss|sr4_vss|sv_vss|tg_d_vss|tg_fbm_vss|tg_fbs_vss|tg_s_vss|vss|vss_link|vss_link_bridge|vss_link_dip|vss_link_m1|vss_x1|vss_x2|vss_x3
+ 262.631011993
* device instance g_vss_m1_inv_clk_vss_inv_mc_vss_inv_q_vss_mph_g_nand_m_vss_nand_s2_vss_s1_vss_m1_s2_vss_m1_s3_vss_m1_s4_vss_m1_sb_vss_sr1_vss_sr2_vss_sr3_vss_sr4_vss_sv_vss_tg_d_vss_tg_fbm_vss_tg_fbs_vss_tg_s_vss_vss_vss_link_vss_link_bridge_vss_link_dip_vss_link_m1_vss_x1_vss_x2_vss_x3_t158 r0 *1 0,0
Rg_vss_m1_inv_clk_vss_inv_mc_vss_inv_q_vss_mph_g_nand_m_vss_nand_s2_vss_s1_vss_m1_s2_vss_m1_s3_vss_m1_s4_vss_m1_sb_vss_sr1_vss_sr2_vss_sr3_vss_sr4_vss_sv_vss_tg_d_vss_tg_fbm_vss_tg_fbs_vss_tg_s_vss_vss_vss_link_vss_link_bridge_vss_link_dip_vss_link_m1_vss_x1_vss_x2_vss_x3_t158
+ g_vss_m1|inv_clk_vss|inv_mc_vss|inv_q_vss|mph_g|nand_m_vss|nand_s2_vss|s1_vss_m1|s2_vss_m1|s3_vss_m1|s4_vss_m1|sb_vss|sr1_vss|sr2_vss|sr3_vss|sr4_vss|sv_vss|tg_d_vss|tg_fbm_vss|tg_fbs_vss|tg_s_vss|vss|vss_link|vss_link_bridge|vss_link_dip|vss_link_m1|vss_x1|vss_x2|vss_x3__t158
+ g_vss_m1|inv_clk_vss|inv_mc_vss|inv_q_vss|mph_g|nand_m_vss|nand_s2_vss|s1_vss_m1|s2_vss_m1|s3_vss_m1|s4_vss_m1|sb_vss|sr1_vss|sr2_vss|sr3_vss|sr4_vss|sv_vss|tg_d_vss|tg_fbm_vss|tg_fbs_vss|tg_s_vss|vss|vss_link|vss_link_bridge|vss_link_dip|vss_link_m1|vss_x1|vss_x2|vss_x3
+ 282.247818296
* device instance g_vss_m1_inv_clk_vss_inv_mc_vss_inv_q_vss_mph_g_nand_m_vss_nand_s2_vss_s1_vss_m1_s2_vss_m1_s3_vss_m1_s4_vss_m1_sb_vss_sr1_vss_sr2_vss_sr3_vss_sr4_vss_sv_vss_tg_d_vss_tg_fbm_vss_tg_fbs_vss_tg_s_vss_vss_vss_link_vss_link_bridge_vss_link_dip_vss_link_m1_vss_x1_vss_x2_vss_x3_t159 r0 *1 0,0
Rg_vss_m1_inv_clk_vss_inv_mc_vss_inv_q_vss_mph_g_nand_m_vss_nand_s2_vss_s1_vss_m1_s2_vss_m1_s3_vss_m1_s4_vss_m1_sb_vss_sr1_vss_sr2_vss_sr3_vss_sr4_vss_sv_vss_tg_d_vss_tg_fbm_vss_tg_fbs_vss_tg_s_vss_vss_vss_link_vss_link_bridge_vss_link_dip_vss_link_m1_vss_x1_vss_x2_vss_x3_t159
+ g_vss_m1|inv_clk_vss|inv_mc_vss|inv_q_vss|mph_g|nand_m_vss|nand_s2_vss|s1_vss_m1|s2_vss_m1|s3_vss_m1|s4_vss_m1|sb_vss|sr1_vss|sr2_vss|sr3_vss|sr4_vss|sv_vss|tg_d_vss|tg_fbm_vss|tg_fbs_vss|tg_s_vss|vss|vss_link|vss_link_bridge|vss_link_dip|vss_link_m1|vss_x1|vss_x2|vss_x3__t159
+ g_vss_m1|inv_clk_vss|inv_mc_vss|inv_q_vss|mph_g|nand_m_vss|nand_s2_vss|s1_vss_m1|s2_vss_m1|s3_vss_m1|s4_vss_m1|sb_vss|sr1_vss|sr2_vss|sr3_vss|sr4_vss|sv_vss|tg_d_vss|tg_fbm_vss|tg_fbs_vss|tg_s_vss|vss|vss_link|vss_link_bridge|vss_link_dip|vss_link_m1|vss_x1|vss_x2|vss_x3
+ 295.294675085
* device instance g_vss_m1_inv_clk_vss_inv_mc_vss_inv_q_vss_mph_g_nand_m_vss_nand_s2_vss_s1_vss_m1_s2_vss_m1_s3_vss_m1_s4_vss_m1_sb_vss_sr1_vss_sr2_vss_sr3_vss_sr4_vss_sv_vss_tg_d_vss_tg_fbm_vss_tg_fbs_vss_tg_s_vss_vss_vss_link_vss_link_bridge_vss_link_dip_vss_link_m1_vss_x1_vss_x2_vss_x3_t160 r0 *1 0,0
Rg_vss_m1_inv_clk_vss_inv_mc_vss_inv_q_vss_mph_g_nand_m_vss_nand_s2_vss_s1_vss_m1_s2_vss_m1_s3_vss_m1_s4_vss_m1_sb_vss_sr1_vss_sr2_vss_sr3_vss_sr4_vss_sv_vss_tg_d_vss_tg_fbm_vss_tg_fbs_vss_tg_s_vss_vss_vss_link_vss_link_bridge_vss_link_dip_vss_link_m1_vss_x1_vss_x2_vss_x3_t160
+ g_vss_m1|inv_clk_vss|inv_mc_vss|inv_q_vss|mph_g|nand_m_vss|nand_s2_vss|s1_vss_m1|s2_vss_m1|s3_vss_m1|s4_vss_m1|sb_vss|sr1_vss|sr2_vss|sr3_vss|sr4_vss|sv_vss|tg_d_vss|tg_fbm_vss|tg_fbs_vss|tg_s_vss|vss|vss_link|vss_link_bridge|vss_link_dip|vss_link_m1|vss_x1|vss_x2|vss_x3__t160
+ g_vss_m1|inv_clk_vss|inv_mc_vss|inv_q_vss|mph_g|nand_m_vss|nand_s2_vss|s1_vss_m1|s2_vss_m1|s3_vss_m1|s4_vss_m1|sb_vss|sr1_vss|sr2_vss|sr3_vss|sr4_vss|sv_vss|tg_d_vss|tg_fbm_vss|tg_fbs_vss|tg_s_vss|vss|vss_link|vss_link_bridge|vss_link_dip|vss_link_m1|vss_x1|vss_x2|vss_x3
+ 335.138754204
* device instance g_vss_m1_inv_clk_vss_inv_mc_vss_inv_q_vss_mph_g_nand_m_vss_nand_s2_vss_s1_vss_m1_s2_vss_m1_s3_vss_m1_s4_vss_m1_sb_vss_sr1_vss_sr2_vss_sr3_vss_sr4_vss_sv_vss_tg_d_vss_tg_fbm_vss_tg_fbs_vss_tg_s_vss_vss_vss_link_vss_link_bridge_vss_link_dip_vss_link_m1_vss_x1_vss_x2_vss_x3_t161 r0 *1 0,0
Rg_vss_m1_inv_clk_vss_inv_mc_vss_inv_q_vss_mph_g_nand_m_vss_nand_s2_vss_s1_vss_m1_s2_vss_m1_s3_vss_m1_s4_vss_m1_sb_vss_sr1_vss_sr2_vss_sr3_vss_sr4_vss_sv_vss_tg_d_vss_tg_fbm_vss_tg_fbs_vss_tg_s_vss_vss_vss_link_vss_link_bridge_vss_link_dip_vss_link_m1_vss_x1_vss_x2_vss_x3_t161
+ g_vss_m1|inv_clk_vss|inv_mc_vss|inv_q_vss|mph_g|nand_m_vss|nand_s2_vss|s1_vss_m1|s2_vss_m1|s3_vss_m1|s4_vss_m1|sb_vss|sr1_vss|sr2_vss|sr3_vss|sr4_vss|sv_vss|tg_d_vss|tg_fbm_vss|tg_fbs_vss|tg_s_vss|vss|vss_link|vss_link_bridge|vss_link_dip|vss_link_m1|vss_x1|vss_x2|vss_x3__t161
+ g_vss_m1|inv_clk_vss|inv_mc_vss|inv_q_vss|mph_g|nand_m_vss|nand_s2_vss|s1_vss_m1|s2_vss_m1|s3_vss_m1|s4_vss_m1|sb_vss|sr1_vss|sr2_vss|sr3_vss|sr4_vss|sv_vss|tg_d_vss|tg_fbm_vss|tg_fbs_vss|tg_s_vss|vss|vss_link|vss_link_bridge|vss_link_dip|vss_link_m1|vss_x1|vss_x2|vss_x3
+ 348.229417516
* device instance g_vss_m1_inv_clk_vss_inv_mc_vss_inv_q_vss_mph_g_nand_m_vss_nand_s2_vss_s1_vss_m1_s2_vss_m1_s3_vss_m1_s4_vss_m1_sb_vss_sr1_vss_sr2_vss_sr3_vss_sr4_vss_sv_vss_tg_d_vss_tg_fbm_vss_tg_fbs_vss_tg_s_vss_vss_vss_link_vss_link_bridge_vss_link_dip_vss_link_m1_vss_x1_vss_x2_vss_x3_t162 r0 *1 0,0
Rg_vss_m1_inv_clk_vss_inv_mc_vss_inv_q_vss_mph_g_nand_m_vss_nand_s2_vss_s1_vss_m1_s2_vss_m1_s3_vss_m1_s4_vss_m1_sb_vss_sr1_vss_sr2_vss_sr3_vss_sr4_vss_sv_vss_tg_d_vss_tg_fbm_vss_tg_fbs_vss_tg_s_vss_vss_vss_link_vss_link_bridge_vss_link_dip_vss_link_m1_vss_x1_vss_x2_vss_x3_t162
+ g_vss_m1|inv_clk_vss|inv_mc_vss|inv_q_vss|mph_g|nand_m_vss|nand_s2_vss|s1_vss_m1|s2_vss_m1|s3_vss_m1|s4_vss_m1|sb_vss|sr1_vss|sr2_vss|sr3_vss|sr4_vss|sv_vss|tg_d_vss|tg_fbm_vss|tg_fbs_vss|tg_s_vss|vss|vss_link|vss_link_bridge|vss_link_dip|vss_link_m1|vss_x1|vss_x2|vss_x3__t162
+ g_vss_m1|inv_clk_vss|inv_mc_vss|inv_q_vss|mph_g|nand_m_vss|nand_s2_vss|s1_vss_m1|s2_vss_m1|s3_vss_m1|s4_vss_m1|sb_vss|sr1_vss|sr2_vss|sr3_vss|sr4_vss|sv_vss|tg_d_vss|tg_fbm_vss|tg_fbs_vss|tg_s_vss|vss|vss_link|vss_link_bridge|vss_link_dip|vss_link_m1|vss_x1|vss_x2|vss_x3
+ 362.359152009
* device instance g_vss_m1_inv_clk_vss_inv_mc_vss_inv_q_vss_mph_g_nand_m_vss_nand_s2_vss_s1_vss_m1_s2_vss_m1_s3_vss_m1_s4_vss_m1_sb_vss_sr1_vss_sr2_vss_sr3_vss_sr4_vss_sv_vss_tg_d_vss_tg_fbm_vss_tg_fbs_vss_tg_s_vss_vss_vss_link_vss_link_bridge_vss_link_dip_vss_link_m1_vss_x1_vss_x2_vss_x3_t163 r0 *1 0,0
Rg_vss_m1_inv_clk_vss_inv_mc_vss_inv_q_vss_mph_g_nand_m_vss_nand_s2_vss_s1_vss_m1_s2_vss_m1_s3_vss_m1_s4_vss_m1_sb_vss_sr1_vss_sr2_vss_sr3_vss_sr4_vss_sv_vss_tg_d_vss_tg_fbm_vss_tg_fbs_vss_tg_s_vss_vss_vss_link_vss_link_bridge_vss_link_dip_vss_link_m1_vss_x1_vss_x2_vss_x3_t163
+ g_vss_m1|inv_clk_vss|inv_mc_vss|inv_q_vss|mph_g|nand_m_vss|nand_s2_vss|s1_vss_m1|s2_vss_m1|s3_vss_m1|s4_vss_m1|sb_vss|sr1_vss|sr2_vss|sr3_vss|sr4_vss|sv_vss|tg_d_vss|tg_fbm_vss|tg_fbs_vss|tg_s_vss|vss|vss_link|vss_link_bridge|vss_link_dip|vss_link_m1|vss_x1|vss_x2|vss_x3__t163
+ g_vss_m1|inv_clk_vss|inv_mc_vss|inv_q_vss|mph_g|nand_m_vss|nand_s2_vss|s1_vss_m1|s2_vss_m1|s3_vss_m1|s4_vss_m1|sb_vss|sr1_vss|sr2_vss|sr3_vss|sr4_vss|sv_vss|tg_d_vss|tg_fbm_vss|tg_fbs_vss|tg_s_vss|vss|vss_link|vss_link_bridge|vss_link_dip|vss_link_m1|vss_x1|vss_x2|vss_x3
+ 381.078358966
* device instance g_vss_m1_inv_clk_vss_inv_mc_vss_inv_q_vss_mph_g_nand_m_vss_nand_s2_vss_s1_vss_m1_s2_vss_m1_s3_vss_m1_s4_vss_m1_sb_vss_sr1_vss_sr2_vss_sr3_vss_sr4_vss_sv_vss_tg_d_vss_tg_fbm_vss_tg_fbs_vss_tg_s_vss_vss_vss_link_vss_link_bridge_vss_link_dip_vss_link_m1_vss_x1_vss_x2_vss_x3_t164 r0 *1 0,0
Rg_vss_m1_inv_clk_vss_inv_mc_vss_inv_q_vss_mph_g_nand_m_vss_nand_s2_vss_s1_vss_m1_s2_vss_m1_s3_vss_m1_s4_vss_m1_sb_vss_sr1_vss_sr2_vss_sr3_vss_sr4_vss_sv_vss_tg_d_vss_tg_fbm_vss_tg_fbs_vss_tg_s_vss_vss_vss_link_vss_link_bridge_vss_link_dip_vss_link_m1_vss_x1_vss_x2_vss_x3_t164
+ g_vss_m1|inv_clk_vss|inv_mc_vss|inv_q_vss|mph_g|nand_m_vss|nand_s2_vss|s1_vss_m1|s2_vss_m1|s3_vss_m1|s4_vss_m1|sb_vss|sr1_vss|sr2_vss|sr3_vss|sr4_vss|sv_vss|tg_d_vss|tg_fbm_vss|tg_fbs_vss|tg_s_vss|vss|vss_link|vss_link_bridge|vss_link_dip|vss_link_m1|vss_x1|vss_x2|vss_x3__t164
+ g_vss_m1|inv_clk_vss|inv_mc_vss|inv_q_vss|mph_g|nand_m_vss|nand_s2_vss|s1_vss_m1|s2_vss_m1|s3_vss_m1|s4_vss_m1|sb_vss|sr1_vss|sr2_vss|sr3_vss|sr4_vss|sv_vss|tg_d_vss|tg_fbm_vss|tg_fbs_vss|tg_s_vss|vss|vss_link|vss_link_bridge|vss_link_dip|vss_link_m1|vss_x1|vss_x2|vss_x3
+ 415.452985703
* device instance g_vss_m1_inv_clk_vss_inv_mc_vss_inv_q_vss_mph_g_nand_m_vss_nand_s2_vss_s1_vss_m1_s2_vss_m1_s3_vss_m1_s4_vss_m1_sb_vss_sr1_vss_sr2_vss_sr3_vss_sr4_vss_sv_vss_tg_d_vss_tg_fbm_vss_tg_fbs_vss_tg_s_vss_vss_vss_link_vss_link_bridge_vss_link_dip_vss_link_m1_vss_x1_vss_x2_vss_x3_t165 r0 *1 0,0
Rg_vss_m1_inv_clk_vss_inv_mc_vss_inv_q_vss_mph_g_nand_m_vss_nand_s2_vss_s1_vss_m1_s2_vss_m1_s3_vss_m1_s4_vss_m1_sb_vss_sr1_vss_sr2_vss_sr3_vss_sr4_vss_sv_vss_tg_d_vss_tg_fbm_vss_tg_fbs_vss_tg_s_vss_vss_vss_link_vss_link_bridge_vss_link_dip_vss_link_m1_vss_x1_vss_x2_vss_x3_t165
+ g_vss_m1|inv_clk_vss|inv_mc_vss|inv_q_vss|mph_g|nand_m_vss|nand_s2_vss|s1_vss_m1|s2_vss_m1|s3_vss_m1|s4_vss_m1|sb_vss|sr1_vss|sr2_vss|sr3_vss|sr4_vss|sv_vss|tg_d_vss|tg_fbm_vss|tg_fbs_vss|tg_s_vss|vss|vss_link|vss_link_bridge|vss_link_dip|vss_link_m1|vss_x1|vss_x2|vss_x3__t165
+ g_vss_m1|inv_clk_vss|inv_mc_vss|inv_q_vss|mph_g|nand_m_vss|nand_s2_vss|s1_vss_m1|s2_vss_m1|s3_vss_m1|s4_vss_m1|sb_vss|sr1_vss|sr2_vss|sr3_vss|sr4_vss|sv_vss|tg_d_vss|tg_fbm_vss|tg_fbs_vss|tg_s_vss|vss|vss_link|vss_link_bridge|vss_link_dip|vss_link_m1|vss_x1|vss_x2|vss_x3
+ 435.22277849
* device instance g_vss_m1_inv_clk_vss_inv_mc_vss_inv_q_vss_mph_g_nand_m_vss_nand_s2_vss_s1_vss_m1_s2_vss_m1_s3_vss_m1_s4_vss_m1_sb_vss_sr1_vss_sr2_vss_sr3_vss_sr4_vss_sv_vss_tg_d_vss_tg_fbm_vss_tg_fbs_vss_tg_s_vss_vss_vss_link_vss_link_bridge_vss_link_dip_vss_link_m1_vss_x1_vss_x2_vss_x3_t166 r0 *1 0,0
Rg_vss_m1_inv_clk_vss_inv_mc_vss_inv_q_vss_mph_g_nand_m_vss_nand_s2_vss_s1_vss_m1_s2_vss_m1_s3_vss_m1_s4_vss_m1_sb_vss_sr1_vss_sr2_vss_sr3_vss_sr4_vss_sv_vss_tg_d_vss_tg_fbm_vss_tg_fbs_vss_tg_s_vss_vss_vss_link_vss_link_bridge_vss_link_dip_vss_link_m1_vss_x1_vss_x2_vss_x3_t166
+ g_vss_m1|inv_clk_vss|inv_mc_vss|inv_q_vss|mph_g|nand_m_vss|nand_s2_vss|s1_vss_m1|s2_vss_m1|s3_vss_m1|s4_vss_m1|sb_vss|sr1_vss|sr2_vss|sr3_vss|sr4_vss|sv_vss|tg_d_vss|tg_fbm_vss|tg_fbs_vss|tg_s_vss|vss|vss_link|vss_link_bridge|vss_link_dip|vss_link_m1|vss_x1|vss_x2|vss_x3__t166
+ g_vss_m1|inv_clk_vss|inv_mc_vss|inv_q_vss|mph_g|nand_m_vss|nand_s2_vss|s1_vss_m1|s2_vss_m1|s3_vss_m1|s4_vss_m1|sb_vss|sr1_vss|sr2_vss|sr3_vss|sr4_vss|sv_vss|tg_d_vss|tg_fbm_vss|tg_fbs_vss|tg_s_vss|vss|vss_link|vss_link_bridge|vss_link_dip|vss_link_m1|vss_x1|vss_x2|vss_x3
+ 448.357284785
* device instance g_vss_m1_inv_clk_vss_inv_mc_vss_inv_q_vss_mph_g_nand_m_vss_nand_s2_vss_s1_vss_m1_s2_vss_m1_s3_vss_m1_s4_vss_m1_sb_vss_sr1_vss_sr2_vss_sr3_vss_sr4_vss_sv_vss_tg_d_vss_tg_fbm_vss_tg_fbs_vss_tg_s_vss_vss_vss_link_vss_link_bridge_vss_link_dip_vss_link_m1_vss_x1_vss_x2_vss_x3_t167 r0 *1 0,0
Rg_vss_m1_inv_clk_vss_inv_mc_vss_inv_q_vss_mph_g_nand_m_vss_nand_s2_vss_s1_vss_m1_s2_vss_m1_s3_vss_m1_s4_vss_m1_sb_vss_sr1_vss_sr2_vss_sr3_vss_sr4_vss_sv_vss_tg_d_vss_tg_fbm_vss_tg_fbs_vss_tg_s_vss_vss_vss_link_vss_link_bridge_vss_link_dip_vss_link_m1_vss_x1_vss_x2_vss_x3_t167
+ g_vss_m1|inv_clk_vss|inv_mc_vss|inv_q_vss|mph_g|nand_m_vss|nand_s2_vss|s1_vss_m1|s2_vss_m1|s3_vss_m1|s4_vss_m1|sb_vss|sr1_vss|sr2_vss|sr3_vss|sr4_vss|sv_vss|tg_d_vss|tg_fbm_vss|tg_fbs_vss|tg_s_vss|vss|vss_link|vss_link_bridge|vss_link_dip|vss_link_m1|vss_x1|vss_x2|vss_x3__t167
+ g_vss_m1|inv_clk_vss|inv_mc_vss|inv_q_vss|mph_g|nand_m_vss|nand_s2_vss|s1_vss_m1|s2_vss_m1|s3_vss_m1|s4_vss_m1|sb_vss|sr1_vss|sr2_vss|sr3_vss|sr4_vss|sv_vss|tg_d_vss|tg_fbm_vss|tg_fbs_vss|tg_s_vss|vss|vss_link|vss_link_bridge|vss_link_dip|vss_link_m1|vss_x1|vss_x2|vss_x3
+ 488.41640214
* device instance g_vss_m1_inv_clk_vss_inv_mc_vss_inv_q_vss_mph_g_nand_m_vss_nand_s2_vss_s1_vss_m1_s2_vss_m1_s3_vss_m1_s4_vss_m1_sb_vss_sr1_vss_sr2_vss_sr3_vss_sr4_vss_sv_vss_tg_d_vss_tg_fbm_vss_tg_fbs_vss_tg_s_vss_vss_vss_link_vss_link_bridge_vss_link_dip_vss_link_m1_vss_x1_vss_x2_vss_x3_t168 r0 *1 0,0
Rg_vss_m1_inv_clk_vss_inv_mc_vss_inv_q_vss_mph_g_nand_m_vss_nand_s2_vss_s1_vss_m1_s2_vss_m1_s3_vss_m1_s4_vss_m1_sb_vss_sr1_vss_sr2_vss_sr3_vss_sr4_vss_sv_vss_tg_d_vss_tg_fbm_vss_tg_fbs_vss_tg_s_vss_vss_vss_link_vss_link_bridge_vss_link_dip_vss_link_m1_vss_x1_vss_x2_vss_x3_t168
+ g_vss_m1|inv_clk_vss|inv_mc_vss|inv_q_vss|mph_g|nand_m_vss|nand_s2_vss|s1_vss_m1|s2_vss_m1|s3_vss_m1|s4_vss_m1|sb_vss|sr1_vss|sr2_vss|sr3_vss|sr4_vss|sv_vss|tg_d_vss|tg_fbm_vss|tg_fbs_vss|tg_s_vss|vss|vss_link|vss_link_bridge|vss_link_dip|vss_link_m1|vss_x1|vss_x2|vss_x3__t168
+ g_vss_m1|inv_clk_vss|inv_mc_vss|inv_q_vss|mph_g|nand_m_vss|nand_s2_vss|s1_vss_m1|s2_vss_m1|s3_vss_m1|s4_vss_m1|sb_vss|sr1_vss|sr2_vss|sr3_vss|sr4_vss|sv_vss|tg_d_vss|tg_fbm_vss|tg_fbs_vss|tg_s_vss|vss|vss_link|vss_link_bridge|vss_link_dip|vss_link_m1|vss_x1|vss_x2|vss_x3
+ 501.564151666
* device instance g_vss_m1_inv_clk_vss_inv_mc_vss_inv_q_vss_mph_g_nand_m_vss_nand_s2_vss_s1_vss_m1_s2_vss_m1_s3_vss_m1_s4_vss_m1_sb_vss_sr1_vss_sr2_vss_sr3_vss_sr4_vss_sv_vss_tg_d_vss_tg_fbm_vss_tg_fbs_vss_tg_s_vss_vss_vss_link_vss_link_bridge_vss_link_dip_vss_link_m1_vss_x1_vss_x2_vss_x3_t169 r0 *1 0,0
Rg_vss_m1_inv_clk_vss_inv_mc_vss_inv_q_vss_mph_g_nand_m_vss_nand_s2_vss_s1_vss_m1_s2_vss_m1_s3_vss_m1_s4_vss_m1_sb_vss_sr1_vss_sr2_vss_sr3_vss_sr4_vss_sv_vss_tg_d_vss_tg_fbm_vss_tg_fbs_vss_tg_s_vss_vss_vss_link_vss_link_bridge_vss_link_dip_vss_link_m1_vss_x1_vss_x2_vss_x3_t169
+ g_vss_m1|inv_clk_vss|inv_mc_vss|inv_q_vss|mph_g|nand_m_vss|nand_s2_vss|s1_vss_m1|s2_vss_m1|s3_vss_m1|s4_vss_m1|sb_vss|sr1_vss|sr2_vss|sr3_vss|sr4_vss|sv_vss|tg_d_vss|tg_fbm_vss|tg_fbs_vss|tg_s_vss|vss|vss_link|vss_link_bridge|vss_link_dip|vss_link_m1|vss_x1|vss_x2|vss_x3__t169
+ g_vss_m1|inv_clk_vss|inv_mc_vss|inv_q_vss|mph_g|nand_m_vss|nand_s2_vss|s1_vss_m1|s2_vss_m1|s3_vss_m1|s4_vss_m1|sb_vss|sr1_vss|sr2_vss|sr3_vss|sr4_vss|sv_vss|tg_d_vss|tg_fbm_vss|tg_fbs_vss|tg_s_vss|vss|vss_link|vss_link_bridge|vss_link_dip|vss_link_m1|vss_x1|vss_x2|vss_x3
+ 515.749576443
* device instance g_vss_m1_inv_clk_vss_inv_mc_vss_inv_q_vss_mph_g_nand_m_vss_nand_s2_vss_s1_vss_m1_s2_vss_m1_s3_vss_m1_s4_vss_m1_sb_vss_sr1_vss_sr2_vss_sr3_vss_sr4_vss_sv_vss_tg_d_vss_tg_fbm_vss_tg_fbs_vss_tg_s_vss_vss_vss_link_vss_link_bridge_vss_link_dip_vss_link_m1_vss_x1_vss_x2_vss_x3_t170 r0 *1 0,0
Rg_vss_m1_inv_clk_vss_inv_mc_vss_inv_q_vss_mph_g_nand_m_vss_nand_s2_vss_s1_vss_m1_s2_vss_m1_s3_vss_m1_s4_vss_m1_sb_vss_sr1_vss_sr2_vss_sr3_vss_sr4_vss_sv_vss_tg_d_vss_tg_fbm_vss_tg_fbs_vss_tg_s_vss_vss_vss_link_vss_link_bridge_vss_link_dip_vss_link_m1_vss_x1_vss_x2_vss_x3_t170
+ g_vss_m1|inv_clk_vss|inv_mc_vss|inv_q_vss|mph_g|nand_m_vss|nand_s2_vss|s1_vss_m1|s2_vss_m1|s3_vss_m1|s4_vss_m1|sb_vss|sr1_vss|sr2_vss|sr3_vss|sr4_vss|sv_vss|tg_d_vss|tg_fbm_vss|tg_fbs_vss|tg_s_vss|vss|vss_link|vss_link_bridge|vss_link_dip|vss_link_m1|vss_x1|vss_x2|vss_x3__t170
+ g_vss_m1|inv_clk_vss|inv_mc_vss|inv_q_vss|mph_g|nand_m_vss|nand_s2_vss|s1_vss_m1|s2_vss_m1|s3_vss_m1|s4_vss_m1|sb_vss|sr1_vss|sr2_vss|sr3_vss|sr4_vss|sv_vss|tg_d_vss|tg_fbm_vss|tg_fbs_vss|tg_s_vss|vss|vss_link|vss_link_bridge|vss_link_dip|vss_link_m1|vss_x1|vss_x2|vss_x3
+ 534.534407231
* device instance g_vss_m1_inv_clk_vss_inv_mc_vss_inv_q_vss_mph_g_nand_m_vss_nand_s2_vss_s1_vss_m1_s2_vss_m1_s3_vss_m1_s4_vss_m1_sb_vss_sr1_vss_sr2_vss_sr3_vss_sr4_vss_sv_vss_tg_d_vss_tg_fbm_vss_tg_fbs_vss_tg_s_vss_vss_vss_link_vss_link_bridge_vss_link_dip_vss_link_m1_vss_x1_vss_x2_vss_x3_t171 r0 *1 0,0
Rg_vss_m1_inv_clk_vss_inv_mc_vss_inv_q_vss_mph_g_nand_m_vss_nand_s2_vss_s1_vss_m1_s2_vss_m1_s3_vss_m1_s4_vss_m1_sb_vss_sr1_vss_sr2_vss_sr3_vss_sr4_vss_sv_vss_tg_d_vss_tg_fbm_vss_tg_fbs_vss_tg_s_vss_vss_vss_link_vss_link_bridge_vss_link_dip_vss_link_m1_vss_x1_vss_x2_vss_x3_t171
+ g_vss_m1|inv_clk_vss|inv_mc_vss|inv_q_vss|mph_g|nand_m_vss|nand_s2_vss|s1_vss_m1|s2_vss_m1|s3_vss_m1|s4_vss_m1|sb_vss|sr1_vss|sr2_vss|sr3_vss|sr4_vss|sv_vss|tg_d_vss|tg_fbm_vss|tg_fbs_vss|tg_s_vss|vss|vss_link|vss_link_bridge|vss_link_dip|vss_link_m1|vss_x1|vss_x2|vss_x3__t171
+ g_vss_m1|inv_clk_vss|inv_mc_vss|inv_q_vss|mph_g|nand_m_vss|nand_s2_vss|s1_vss_m1|s2_vss_m1|s3_vss_m1|s4_vss_m1|sb_vss|sr1_vss|sr2_vss|sr3_vss|sr4_vss|sv_vss|tg_d_vss|tg_fbm_vss|tg_fbs_vss|tg_s_vss|vss|vss_link|vss_link_bridge|vss_link_dip|vss_link_m1|vss_x1|vss_x2|vss_x3
+ 569.00985511
* device instance g_vss_m1_inv_clk_vss_inv_mc_vss_inv_q_vss_mph_g_nand_m_vss_nand_s2_vss_s1_vss_m1_s2_vss_m1_s3_vss_m1_s4_vss_m1_sb_vss_sr1_vss_sr2_vss_sr3_vss_sr4_vss_sv_vss_tg_d_vss_tg_fbm_vss_tg_fbs_vss_tg_s_vss_vss_vss_link_vss_link_bridge_vss_link_dip_vss_link_m1_vss_x1_vss_x2_vss_x3_t172 r0 *1 0,0
Rg_vss_m1_inv_clk_vss_inv_mc_vss_inv_q_vss_mph_g_nand_m_vss_nand_s2_vss_s1_vss_m1_s2_vss_m1_s3_vss_m1_s4_vss_m1_sb_vss_sr1_vss_sr2_vss_sr3_vss_sr4_vss_sv_vss_tg_d_vss_tg_fbm_vss_tg_fbs_vss_tg_s_vss_vss_vss_link_vss_link_bridge_vss_link_dip_vss_link_m1_vss_x1_vss_x2_vss_x3_t172
+ g_vss_m1|inv_clk_vss|inv_mc_vss|inv_q_vss|mph_g|nand_m_vss|nand_s2_vss|s1_vss_m1|s2_vss_m1|s3_vss_m1|s4_vss_m1|sb_vss|sr1_vss|sr2_vss|sr3_vss|sr4_vss|sv_vss|tg_d_vss|tg_fbm_vss|tg_fbs_vss|tg_s_vss|vss|vss_link|vss_link_bridge|vss_link_dip|vss_link_m1|vss_x1|vss_x2|vss_x3__t172
+ g_vss_m1|inv_clk_vss|inv_mc_vss|inv_q_vss|mph_g|nand_m_vss|nand_s2_vss|s1_vss_m1|s2_vss_m1|s3_vss_m1|s4_vss_m1|sb_vss|sr1_vss|sr2_vss|sr3_vss|sr4_vss|sv_vss|tg_d_vss|tg_fbm_vss|tg_fbs_vss|tg_s_vss|vss|vss_link|vss_link_bridge|vss_link_dip|vss_link_m1|vss_x1|vss_x2|vss_x3
+ 297.224770109
* device instance g_vss_m1_inv_clk_vss_inv_mc_vss_inv_q_vss_mph_g_nand_m_vss_nand_s2_vss_s1_vss_m1_s2_vss_m1_s3_vss_m1_s4_vss_m1_sb_vss_sr1_vss_sr2_vss_sr3_vss_sr4_vss_sv_vss_tg_d_vss_tg_fbm_vss_tg_fbs_vss_tg_s_vss_vss_vss_link_vss_link_bridge_vss_link_dip_vss_link_m1_vss_x1_vss_x2_vss_x3_t173 r0 *1 0,0
Rg_vss_m1_inv_clk_vss_inv_mc_vss_inv_q_vss_mph_g_nand_m_vss_nand_s2_vss_s1_vss_m1_s2_vss_m1_s3_vss_m1_s4_vss_m1_sb_vss_sr1_vss_sr2_vss_sr3_vss_sr4_vss_sv_vss_tg_d_vss_tg_fbm_vss_tg_fbs_vss_tg_s_vss_vss_vss_link_vss_link_bridge_vss_link_dip_vss_link_m1_vss_x1_vss_x2_vss_x3_t173
+ g_vss_m1|inv_clk_vss|inv_mc_vss|inv_q_vss|mph_g|nand_m_vss|nand_s2_vss|s1_vss_m1|s2_vss_m1|s3_vss_m1|s4_vss_m1|sb_vss|sr1_vss|sr2_vss|sr3_vss|sr4_vss|sv_vss|tg_d_vss|tg_fbm_vss|tg_fbs_vss|tg_s_vss|vss|vss_link|vss_link_bridge|vss_link_dip|vss_link_m1|vss_x1|vss_x2|vss_x3__t173
+ g_vss_m1|inv_clk_vss|inv_mc_vss|inv_q_vss|mph_g|nand_m_vss|nand_s2_vss|s1_vss_m1|s2_vss_m1|s3_vss_m1|s4_vss_m1|sb_vss|sr1_vss|sr2_vss|sr3_vss|sr4_vss|sv_vss|tg_d_vss|tg_fbm_vss|tg_fbs_vss|tg_s_vss|vss|vss_link|vss_link_bridge|vss_link_dip|vss_link_m1|vss_x1|vss_x2|vss_x3
+ 274.644680225
* device instance g_vss_m1_inv_clk_vss_inv_mc_vss_inv_q_vss_mph_g_nand_m_vss_nand_s2_vss_s1_vss_m1_s2_vss_m1_s3_vss_m1_s4_vss_m1_sb_vss_sr1_vss_sr2_vss_sr3_vss_sr4_vss_sv_vss_tg_d_vss_tg_fbm_vss_tg_fbs_vss_tg_s_vss_vss_vss_link_vss_link_bridge_vss_link_dip_vss_link_m1_vss_x1_vss_x2_vss_x3_t174 r0 *1 0,0
Rg_vss_m1_inv_clk_vss_inv_mc_vss_inv_q_vss_mph_g_nand_m_vss_nand_s2_vss_s1_vss_m1_s2_vss_m1_s3_vss_m1_s4_vss_m1_sb_vss_sr1_vss_sr2_vss_sr3_vss_sr4_vss_sv_vss_tg_d_vss_tg_fbm_vss_tg_fbs_vss_tg_s_vss_vss_vss_link_vss_link_bridge_vss_link_dip_vss_link_m1_vss_x1_vss_x2_vss_x3_t174
+ g_vss_m1|inv_clk_vss|inv_mc_vss|inv_q_vss|mph_g|nand_m_vss|nand_s2_vss|s1_vss_m1|s2_vss_m1|s3_vss_m1|s4_vss_m1|sb_vss|sr1_vss|sr2_vss|sr3_vss|sr4_vss|sv_vss|tg_d_vss|tg_fbm_vss|tg_fbs_vss|tg_s_vss|vss|vss_link|vss_link_bridge|vss_link_dip|vss_link_m1|vss_x1|vss_x2|vss_x3__t174
+ g_vss_m1|inv_clk_vss|inv_mc_vss|inv_q_vss|mph_g|nand_m_vss|nand_s2_vss|s1_vss_m1|s2_vss_m1|s3_vss_m1|s4_vss_m1|sb_vss|sr1_vss|sr2_vss|sr3_vss|sr4_vss|sv_vss|tg_d_vss|tg_fbm_vss|tg_fbs_vss|tg_s_vss|vss|vss_link|vss_link_bridge|vss_link_dip|vss_link_m1|vss_x1|vss_x2|vss_x3
+ 252.076322273
* device instance g_vss_m1_inv_clk_vss_inv_mc_vss_inv_q_vss_mph_g_nand_m_vss_nand_s2_vss_s1_vss_m1_s2_vss_m1_s3_vss_m1_s4_vss_m1_sb_vss_sr1_vss_sr2_vss_sr3_vss_sr4_vss_sv_vss_tg_d_vss_tg_fbm_vss_tg_fbs_vss_tg_s_vss_vss_vss_link_vss_link_bridge_vss_link_dip_vss_link_m1_vss_x1_vss_x2_vss_x3_t175 r0 *1 0,0
Rg_vss_m1_inv_clk_vss_inv_mc_vss_inv_q_vss_mph_g_nand_m_vss_nand_s2_vss_s1_vss_m1_s2_vss_m1_s3_vss_m1_s4_vss_m1_sb_vss_sr1_vss_sr2_vss_sr3_vss_sr4_vss_sv_vss_tg_d_vss_tg_fbm_vss_tg_fbs_vss_tg_s_vss_vss_vss_link_vss_link_bridge_vss_link_dip_vss_link_m1_vss_x1_vss_x2_vss_x3_t175
+ g_vss_m1|inv_clk_vss|inv_mc_vss|inv_q_vss|mph_g|nand_m_vss|nand_s2_vss|s1_vss_m1|s2_vss_m1|s3_vss_m1|s4_vss_m1|sb_vss|sr1_vss|sr2_vss|sr3_vss|sr4_vss|sv_vss|tg_d_vss|tg_fbm_vss|tg_fbs_vss|tg_s_vss|vss|vss_link|vss_link_bridge|vss_link_dip|vss_link_m1|vss_x1|vss_x2|vss_x3__t175
+ g_vss_m1|inv_clk_vss|inv_mc_vss|inv_q_vss|mph_g|nand_m_vss|nand_s2_vss|s1_vss_m1|s2_vss_m1|s3_vss_m1|s4_vss_m1|sb_vss|sr1_vss|sr2_vss|sr3_vss|sr4_vss|sv_vss|tg_d_vss|tg_fbm_vss|tg_fbs_vss|tg_s_vss|vss|vss_link|vss_link_bridge|vss_link_dip|vss_link_m1|vss_x1|vss_x2|vss_x3
+ 229.52315698
* device instance g_vss_m1_inv_clk_vss_inv_mc_vss_inv_q_vss_mph_g_nand_m_vss_nand_s2_vss_s1_vss_m1_s2_vss_m1_s3_vss_m1_s4_vss_m1_sb_vss_sr1_vss_sr2_vss_sr3_vss_sr4_vss_sv_vss_tg_d_vss_tg_fbm_vss_tg_fbs_vss_tg_s_vss_vss_vss_link_vss_link_bridge_vss_link_dip_vss_link_m1_vss_x1_vss_x2_vss_x3_t176 r0 *1 0,0
Rg_vss_m1_inv_clk_vss_inv_mc_vss_inv_q_vss_mph_g_nand_m_vss_nand_s2_vss_s1_vss_m1_s2_vss_m1_s3_vss_m1_s4_vss_m1_sb_vss_sr1_vss_sr2_vss_sr3_vss_sr4_vss_sv_vss_tg_d_vss_tg_fbm_vss_tg_fbs_vss_tg_s_vss_vss_vss_link_vss_link_bridge_vss_link_dip_vss_link_m1_vss_x1_vss_x2_vss_x3_t176
+ g_vss_m1|inv_clk_vss|inv_mc_vss|inv_q_vss|mph_g|nand_m_vss|nand_s2_vss|s1_vss_m1|s2_vss_m1|s3_vss_m1|s4_vss_m1|sb_vss|sr1_vss|sr2_vss|sr3_vss|sr4_vss|sv_vss|tg_d_vss|tg_fbm_vss|tg_fbs_vss|tg_s_vss|vss|vss_link|vss_link_bridge|vss_link_dip|vss_link_m1|vss_x1|vss_x2|vss_x3__t176
+ g_vss_m1|inv_clk_vss|inv_mc_vss|inv_q_vss|mph_g|nand_m_vss|nand_s2_vss|s1_vss_m1|s2_vss_m1|s3_vss_m1|s4_vss_m1|sb_vss|sr1_vss|sr2_vss|sr3_vss|sr4_vss|sv_vss|tg_d_vss|tg_fbm_vss|tg_fbs_vss|tg_s_vss|vss|vss_link|vss_link_bridge|vss_link_dip|vss_link_m1|vss_x1|vss_x2|vss_x3
+ 205.213370832
* device instance g_vss_m1_inv_clk_vss_inv_mc_vss_inv_q_vss_mph_g_nand_m_vss_nand_s2_vss_s1_vss_m1_s2_vss_m1_s3_vss_m1_s4_vss_m1_sb_vss_sr1_vss_sr2_vss_sr3_vss_sr4_vss_sv_vss_tg_d_vss_tg_fbm_vss_tg_fbs_vss_tg_s_vss_vss_vss_link_vss_link_bridge_vss_link_dip_vss_link_m1_vss_x1_vss_x2_vss_x3_t177 r0 *1 0,0
Rg_vss_m1_inv_clk_vss_inv_mc_vss_inv_q_vss_mph_g_nand_m_vss_nand_s2_vss_s1_vss_m1_s2_vss_m1_s3_vss_m1_s4_vss_m1_sb_vss_sr1_vss_sr2_vss_sr3_vss_sr4_vss_sv_vss_tg_d_vss_tg_fbm_vss_tg_fbs_vss_tg_s_vss_vss_vss_link_vss_link_bridge_vss_link_dip_vss_link_m1_vss_x1_vss_x2_vss_x3_t177
+ g_vss_m1|inv_clk_vss|inv_mc_vss|inv_q_vss|mph_g|nand_m_vss|nand_s2_vss|s1_vss_m1|s2_vss_m1|s3_vss_m1|s4_vss_m1|sb_vss|sr1_vss|sr2_vss|sr3_vss|sr4_vss|sv_vss|tg_d_vss|tg_fbm_vss|tg_fbs_vss|tg_s_vss|vss|vss_link|vss_link_bridge|vss_link_dip|vss_link_m1|vss_x1|vss_x2|vss_x3__t177
+ g_vss_m1|inv_clk_vss|inv_mc_vss|inv_q_vss|mph_g|nand_m_vss|nand_s2_vss|s1_vss_m1|s2_vss_m1|s3_vss_m1|s4_vss_m1|sb_vss|sr1_vss|sr2_vss|sr3_vss|sr4_vss|sv_vss|tg_d_vss|tg_fbm_vss|tg_fbs_vss|tg_s_vss|vss|vss_link|vss_link_bridge|vss_link_dip|vss_link_m1|vss_x1|vss_x2|vss_x3
+ 144.879687476
* device instance g_vss_m1_inv_clk_vss_inv_mc_vss_inv_q_vss_mph_g_nand_m_vss_nand_s2_vss_s1_vss_m1_s2_vss_m1_s3_vss_m1_s4_vss_m1_sb_vss_sr1_vss_sr2_vss_sr3_vss_sr4_vss_sv_vss_tg_d_vss_tg_fbm_vss_tg_fbs_vss_tg_s_vss_vss_vss_link_vss_link_bridge_vss_link_dip_vss_link_m1_vss_x1_vss_x2_vss_x3_t178 r0 *1 0,0
Rg_vss_m1_inv_clk_vss_inv_mc_vss_inv_q_vss_mph_g_nand_m_vss_nand_s2_vss_s1_vss_m1_s2_vss_m1_s3_vss_m1_s4_vss_m1_sb_vss_sr1_vss_sr2_vss_sr3_vss_sr4_vss_sv_vss_tg_d_vss_tg_fbm_vss_tg_fbs_vss_tg_s_vss_vss_vss_link_vss_link_bridge_vss_link_dip_vss_link_m1_vss_x1_vss_x2_vss_x3_t178
+ g_vss_m1|inv_clk_vss|inv_mc_vss|inv_q_vss|mph_g|nand_m_vss|nand_s2_vss|s1_vss_m1|s2_vss_m1|s3_vss_m1|s4_vss_m1|sb_vss|sr1_vss|sr2_vss|sr3_vss|sr4_vss|sv_vss|tg_d_vss|tg_fbm_vss|tg_fbs_vss|tg_s_vss|vss|vss_link|vss_link_bridge|vss_link_dip|vss_link_m1|vss_x1|vss_x2|vss_x3__t178
+ g_vss_m1|inv_clk_vss|inv_mc_vss|inv_q_vss|mph_g|nand_m_vss|nand_s2_vss|s1_vss_m1|s2_vss_m1|s3_vss_m1|s4_vss_m1|sb_vss|sr1_vss|sr2_vss|sr3_vss|sr4_vss|sv_vss|tg_d_vss|tg_fbm_vss|tg_fbs_vss|tg_s_vss|vss|vss_link|vss_link_bridge|vss_link_dip|vss_link_m1|vss_x1|vss_x2|vss_x3
+ 122.53651707
* device instance g_vss_m1_inv_clk_vss_inv_mc_vss_inv_q_vss_mph_g_nand_m_vss_nand_s2_vss_s1_vss_m1_s2_vss_m1_s3_vss_m1_s4_vss_m1_sb_vss_sr1_vss_sr2_vss_sr3_vss_sr4_vss_sv_vss_tg_d_vss_tg_fbm_vss_tg_fbs_vss_tg_s_vss_vss_vss_link_vss_link_bridge_vss_link_dip_vss_link_m1_vss_x1_vss_x2_vss_x3_t179 r0 *1 0,0
Rg_vss_m1_inv_clk_vss_inv_mc_vss_inv_q_vss_mph_g_nand_m_vss_nand_s2_vss_s1_vss_m1_s2_vss_m1_s3_vss_m1_s4_vss_m1_sb_vss_sr1_vss_sr2_vss_sr3_vss_sr4_vss_sv_vss_tg_d_vss_tg_fbm_vss_tg_fbs_vss_tg_s_vss_vss_vss_link_vss_link_bridge_vss_link_dip_vss_link_m1_vss_x1_vss_x2_vss_x3_t179
+ g_vss_m1|inv_clk_vss|inv_mc_vss|inv_q_vss|mph_g|nand_m_vss|nand_s2_vss|s1_vss_m1|s2_vss_m1|s3_vss_m1|s4_vss_m1|sb_vss|sr1_vss|sr2_vss|sr3_vss|sr4_vss|sv_vss|tg_d_vss|tg_fbm_vss|tg_fbs_vss|tg_s_vss|vss|vss_link|vss_link_bridge|vss_link_dip|vss_link_m1|vss_x1|vss_x2|vss_x3__t179
+ g_vss_m1|inv_clk_vss|inv_mc_vss|inv_q_vss|mph_g|nand_m_vss|nand_s2_vss|s1_vss_m1|s2_vss_m1|s3_vss_m1|s4_vss_m1|sb_vss|sr1_vss|sr2_vss|sr3_vss|sr4_vss|sv_vss|tg_d_vss|tg_fbm_vss|tg_fbs_vss|tg_s_vss|vss|vss_link|vss_link_bridge|vss_link_dip|vss_link_m1|vss_x1|vss_x2|vss_x3
+ 100.32899707
* device instance g_vss_m1_inv_clk_vss_inv_mc_vss_inv_q_vss_mph_g_nand_m_vss_nand_s2_vss_s1_vss_m1_s2_vss_m1_s3_vss_m1_s4_vss_m1_sb_vss_sr1_vss_sr2_vss_sr3_vss_sr4_vss_sv_vss_tg_d_vss_tg_fbm_vss_tg_fbs_vss_tg_s_vss_vss_vss_link_vss_link_bridge_vss_link_dip_vss_link_m1_vss_x1_vss_x2_vss_x3_t180 r0 *1 0,0
Rg_vss_m1_inv_clk_vss_inv_mc_vss_inv_q_vss_mph_g_nand_m_vss_nand_s2_vss_s1_vss_m1_s2_vss_m1_s3_vss_m1_s4_vss_m1_sb_vss_sr1_vss_sr2_vss_sr3_vss_sr4_vss_sv_vss_tg_d_vss_tg_fbm_vss_tg_fbs_vss_tg_s_vss_vss_vss_link_vss_link_bridge_vss_link_dip_vss_link_m1_vss_x1_vss_x2_vss_x3_t180
+ g_vss_m1|inv_clk_vss|inv_mc_vss|inv_q_vss|mph_g|nand_m_vss|nand_s2_vss|s1_vss_m1|s2_vss_m1|s3_vss_m1|s4_vss_m1|sb_vss|sr1_vss|sr2_vss|sr3_vss|sr4_vss|sv_vss|tg_d_vss|tg_fbm_vss|tg_fbs_vss|tg_s_vss|vss|vss_link|vss_link_bridge|vss_link_dip|vss_link_m1|vss_x1|vss_x2|vss_x3__t180
+ g_vss_m1|inv_clk_vss|inv_mc_vss|inv_q_vss|mph_g|nand_m_vss|nand_s2_vss|s1_vss_m1|s2_vss_m1|s3_vss_m1|s4_vss_m1|sb_vss|sr1_vss|sr2_vss|sr3_vss|sr4_vss|sv_vss|tg_d_vss|tg_fbm_vss|tg_fbs_vss|tg_s_vss|vss|vss_link|vss_link_bridge|vss_link_dip|vss_link_m1|vss_x1|vss_x2|vss_x3
+ 78.3725255147
* device instance g_vss_m1_inv_clk_vss_inv_mc_vss_inv_q_vss_mph_g_nand_m_vss_nand_s2_vss_s1_vss_m1_s2_vss_m1_s3_vss_m1_s4_vss_m1_sb_vss_sr1_vss_sr2_vss_sr3_vss_sr4_vss_sv_vss_tg_d_vss_tg_fbm_vss_tg_fbs_vss_tg_s_vss_vss_vss_link_vss_link_bridge_vss_link_dip_vss_link_m1_vss_x1_vss_x2_vss_x3_t181 r0 *1 0,0
Rg_vss_m1_inv_clk_vss_inv_mc_vss_inv_q_vss_mph_g_nand_m_vss_nand_s2_vss_s1_vss_m1_s2_vss_m1_s3_vss_m1_s4_vss_m1_sb_vss_sr1_vss_sr2_vss_sr3_vss_sr4_vss_sv_vss_tg_d_vss_tg_fbm_vss_tg_fbs_vss_tg_s_vss_vss_vss_link_vss_link_bridge_vss_link_dip_vss_link_m1_vss_x1_vss_x2_vss_x3_t181
+ g_vss_m1|inv_clk_vss|inv_mc_vss|inv_q_vss|mph_g|nand_m_vss|nand_s2_vss|s1_vss_m1|s2_vss_m1|s3_vss_m1|s4_vss_m1|sb_vss|sr1_vss|sr2_vss|sr3_vss|sr4_vss|sv_vss|tg_d_vss|tg_fbm_vss|tg_fbs_vss|tg_s_vss|vss|vss_link|vss_link_bridge|vss_link_dip|vss_link_m1|vss_x1|vss_x2|vss_x3__t181
+ g_vss_m1|inv_clk_vss|inv_mc_vss|inv_q_vss|mph_g|nand_m_vss|nand_s2_vss|s1_vss_m1|s2_vss_m1|s3_vss_m1|s4_vss_m1|sb_vss|sr1_vss|sr2_vss|sr3_vss|sr4_vss|sv_vss|tg_d_vss|tg_fbm_vss|tg_fbs_vss|tg_s_vss|vss|vss_link|vss_link_bridge|vss_link_dip|vss_link_m1|vss_x1|vss_x2|vss_x3
+ 55.3103554581
* device instance g_vss_m1_inv_clk_vss_inv_mc_vss_inv_q_vss_mph_g_nand_m_vss_nand_s2_vss_s1_vss_m1_s2_vss_m1_s3_vss_m1_s4_vss_m1_sb_vss_sr1_vss_sr2_vss_sr3_vss_sr4_vss_sv_vss_tg_d_vss_tg_fbm_vss_tg_fbs_vss_tg_s_vss_vss_vss_link_vss_link_bridge_vss_link_dip_vss_link_m1_vss_x1_vss_x2_vss_x3_t182 r0 *1 0,0
Rg_vss_m1_inv_clk_vss_inv_mc_vss_inv_q_vss_mph_g_nand_m_vss_nand_s2_vss_s1_vss_m1_s2_vss_m1_s3_vss_m1_s4_vss_m1_sb_vss_sr1_vss_sr2_vss_sr3_vss_sr4_vss_sv_vss_tg_d_vss_tg_fbm_vss_tg_fbs_vss_tg_s_vss_vss_vss_link_vss_link_bridge_vss_link_dip_vss_link_m1_vss_x1_vss_x2_vss_x3_t182
+ g_vss_m1|inv_clk_vss|inv_mc_vss|inv_q_vss|mph_g|nand_m_vss|nand_s2_vss|s1_vss_m1|s2_vss_m1|s3_vss_m1|s4_vss_m1|sb_vss|sr1_vss|sr2_vss|sr3_vss|sr4_vss|sv_vss|tg_d_vss|tg_fbm_vss|tg_fbs_vss|tg_s_vss|vss|vss_link|vss_link_bridge|vss_link_dip|vss_link_m1|vss_x1|vss_x2|vss_x3__t182
+ g_vss_m1|inv_clk_vss|inv_mc_vss|inv_q_vss|mph_g|nand_m_vss|nand_s2_vss|s1_vss_m1|s2_vss_m1|s3_vss_m1|s4_vss_m1|sb_vss|sr1_vss|sr2_vss|sr3_vss|sr4_vss|sv_vss|tg_d_vss|tg_fbm_vss|tg_fbs_vss|tg_s_vss|vss|vss_link|vss_link_bridge|vss_link_dip|vss_link_m1|vss_x1|vss_x2|vss_x3
+ 23.8651222667
* device instance g_vss_m1_inv_clk_vss_inv_mc_vss_inv_q_vss_mph_g_nand_m_vss_nand_s2_vss_s1_vss_m1_s2_vss_m1_s3_vss_m1_s4_vss_m1_sb_vss_sr1_vss_sr2_vss_sr3_vss_sr4_vss_sv_vss_tg_d_vss_tg_fbm_vss_tg_fbs_vss_tg_s_vss_vss_vss_link_vss_link_bridge_vss_link_dip_vss_link_m1_vss_x1_vss_x2_vss_x3_t183 r0 *1 0,0
Rg_vss_m1_inv_clk_vss_inv_mc_vss_inv_q_vss_mph_g_nand_m_vss_nand_s2_vss_s1_vss_m1_s2_vss_m1_s3_vss_m1_s4_vss_m1_sb_vss_sr1_vss_sr2_vss_sr3_vss_sr4_vss_sv_vss_tg_d_vss_tg_fbm_vss_tg_fbs_vss_tg_s_vss_vss_vss_link_vss_link_bridge_vss_link_dip_vss_link_m1_vss_x1_vss_x2_vss_x3_t183
+ g_vss_m1|inv_clk_vss|inv_mc_vss|inv_q_vss|mph_g|nand_m_vss|nand_s2_vss|s1_vss_m1|s2_vss_m1|s3_vss_m1|s4_vss_m1|sb_vss|sr1_vss|sr2_vss|sr3_vss|sr4_vss|sv_vss|tg_d_vss|tg_fbm_vss|tg_fbs_vss|tg_s_vss|vss|vss_link|vss_link_bridge|vss_link_dip|vss_link_m1|vss_x1|vss_x2|vss_x3__t183
+ g_vss_m1|inv_clk_vss|inv_mc_vss|inv_q_vss|mph_g|nand_m_vss|nand_s2_vss|s1_vss_m1|s2_vss_m1|s3_vss_m1|s4_vss_m1|sb_vss|sr1_vss|sr2_vss|sr3_vss|sr4_vss|sv_vss|tg_d_vss|tg_fbm_vss|tg_fbs_vss|tg_s_vss|vss|vss_link|vss_link_bridge|vss_link_dip|vss_link_m1|vss_x1|vss_x2|vss_x3
+ 39.1478734575
* device instance g_vss_m1_inv_clk_vss_inv_mc_vss_inv_q_vss_mph_g_nand_m_vss_nand_s2_vss_s1_vss_m1_s2_vss_m1_s3_vss_m1_s4_vss_m1_sb_vss_sr1_vss_sr2_vss_sr3_vss_sr4_vss_sv_vss_tg_d_vss_tg_fbm_vss_tg_fbs_vss_tg_s_vss_vss_vss_link_vss_link_bridge_vss_link_dip_vss_link_m1_vss_x1_vss_x2_vss_x3_t184 r0 *1 0,0
Rg_vss_m1_inv_clk_vss_inv_mc_vss_inv_q_vss_mph_g_nand_m_vss_nand_s2_vss_s1_vss_m1_s2_vss_m1_s3_vss_m1_s4_vss_m1_sb_vss_sr1_vss_sr2_vss_sr3_vss_sr4_vss_sv_vss_tg_d_vss_tg_fbm_vss_tg_fbs_vss_tg_s_vss_vss_vss_link_vss_link_bridge_vss_link_dip_vss_link_m1_vss_x1_vss_x2_vss_x3_t184
+ g_vss_m1|inv_clk_vss|inv_mc_vss|inv_q_vss|mph_g|nand_m_vss|nand_s2_vss|s1_vss_m1|s2_vss_m1|s3_vss_m1|s4_vss_m1|sb_vss|sr1_vss|sr2_vss|sr3_vss|sr4_vss|sv_vss|tg_d_vss|tg_fbm_vss|tg_fbs_vss|tg_s_vss|vss|vss_link|vss_link_bridge|vss_link_dip|vss_link_m1|vss_x1|vss_x2|vss_x3__t184
+ g_vss_m1|inv_clk_vss|inv_mc_vss|inv_q_vss|mph_g|nand_m_vss|nand_s2_vss|s1_vss_m1|s2_vss_m1|s3_vss_m1|s4_vss_m1|sb_vss|sr1_vss|sr2_vss|sr3_vss|sr4_vss|sv_vss|tg_d_vss|tg_fbm_vss|tg_fbs_vss|tg_s_vss|vss|vss_link|vss_link_bridge|vss_link_dip|vss_link_m1|vss_x1|vss_x2|vss_x3
+ 59.3397286531
* device instance g_vss_m1_inv_clk_vss_inv_mc_vss_inv_q_vss_mph_g_nand_m_vss_nand_s2_vss_s1_vss_m1_s2_vss_m1_s3_vss_m1_s4_vss_m1_sb_vss_sr1_vss_sr2_vss_sr3_vss_sr4_vss_sv_vss_tg_d_vss_tg_fbm_vss_tg_fbs_vss_tg_s_vss_vss_vss_link_vss_link_bridge_vss_link_dip_vss_link_m1_vss_x1_vss_x2_vss_x3_t185 r0 *1 0,0
Rg_vss_m1_inv_clk_vss_inv_mc_vss_inv_q_vss_mph_g_nand_m_vss_nand_s2_vss_s1_vss_m1_s2_vss_m1_s3_vss_m1_s4_vss_m1_sb_vss_sr1_vss_sr2_vss_sr3_vss_sr4_vss_sv_vss_tg_d_vss_tg_fbm_vss_tg_fbs_vss_tg_s_vss_vss_vss_link_vss_link_bridge_vss_link_dip_vss_link_m1_vss_x1_vss_x2_vss_x3_t185
+ g_vss_m1|inv_clk_vss|inv_mc_vss|inv_q_vss|mph_g|nand_m_vss|nand_s2_vss|s1_vss_m1|s2_vss_m1|s3_vss_m1|s4_vss_m1|sb_vss|sr1_vss|sr2_vss|sr3_vss|sr4_vss|sv_vss|tg_d_vss|tg_fbm_vss|tg_fbs_vss|tg_s_vss|vss|vss_link|vss_link_bridge|vss_link_dip|vss_link_m1|vss_x1|vss_x2|vss_x3__t185
+ g_vss_m1|inv_clk_vss|inv_mc_vss|inv_q_vss|mph_g|nand_m_vss|nand_s2_vss|s1_vss_m1|s2_vss_m1|s3_vss_m1|s4_vss_m1|sb_vss|sr1_vss|sr2_vss|sr3_vss|sr4_vss|sv_vss|tg_d_vss|tg_fbm_vss|tg_fbs_vss|tg_s_vss|vss|vss_link|vss_link_bridge|vss_link_dip|vss_link_m1|vss_x1|vss_x2|vss_x3
+ 80.8423543816
* device instance g_vss_m1_inv_clk_vss_inv_mc_vss_inv_q_vss_mph_g_nand_m_vss_nand_s2_vss_s1_vss_m1_s2_vss_m1_s3_vss_m1_s4_vss_m1_sb_vss_sr1_vss_sr2_vss_sr3_vss_sr4_vss_sv_vss_tg_d_vss_tg_fbm_vss_tg_fbs_vss_tg_s_vss_vss_vss_link_vss_link_bridge_vss_link_dip_vss_link_m1_vss_x1_vss_x2_vss_x3_t186 r0 *1 0,0
Rg_vss_m1_inv_clk_vss_inv_mc_vss_inv_q_vss_mph_g_nand_m_vss_nand_s2_vss_s1_vss_m1_s2_vss_m1_s3_vss_m1_s4_vss_m1_sb_vss_sr1_vss_sr2_vss_sr3_vss_sr4_vss_sv_vss_tg_d_vss_tg_fbm_vss_tg_fbs_vss_tg_s_vss_vss_vss_link_vss_link_bridge_vss_link_dip_vss_link_m1_vss_x1_vss_x2_vss_x3_t186
+ g_vss_m1|inv_clk_vss|inv_mc_vss|inv_q_vss|mph_g|nand_m_vss|nand_s2_vss|s1_vss_m1|s2_vss_m1|s3_vss_m1|s4_vss_m1|sb_vss|sr1_vss|sr2_vss|sr3_vss|sr4_vss|sv_vss|tg_d_vss|tg_fbm_vss|tg_fbs_vss|tg_s_vss|vss|vss_link|vss_link_bridge|vss_link_dip|vss_link_m1|vss_x1|vss_x2|vss_x3__t186
+ g_vss_m1|inv_clk_vss|inv_mc_vss|inv_q_vss|mph_g|nand_m_vss|nand_s2_vss|s1_vss_m1|s2_vss_m1|s3_vss_m1|s4_vss_m1|sb_vss|sr1_vss|sr2_vss|sr3_vss|sr4_vss|sv_vss|tg_d_vss|tg_fbm_vss|tg_fbs_vss|tg_s_vss|vss|vss_link|vss_link_bridge|vss_link_dip|vss_link_m1|vss_x1|vss_x2|vss_x3
+ 104.583954862
* device instance g_vss_m1_inv_clk_vss_inv_mc_vss_inv_q_vss_mph_g_nand_m_vss_nand_s2_vss_s1_vss_m1_s2_vss_m1_s3_vss_m1_s4_vss_m1_sb_vss_sr1_vss_sr2_vss_sr3_vss_sr4_vss_sv_vss_tg_d_vss_tg_fbm_vss_tg_fbs_vss_tg_s_vss_vss_vss_link_vss_link_bridge_vss_link_dip_vss_link_m1_vss_x1_vss_x2_vss_x3_t187 r0 *1 0,0
Rg_vss_m1_inv_clk_vss_inv_mc_vss_inv_q_vss_mph_g_nand_m_vss_nand_s2_vss_s1_vss_m1_s2_vss_m1_s3_vss_m1_s4_vss_m1_sb_vss_sr1_vss_sr2_vss_sr3_vss_sr4_vss_sv_vss_tg_d_vss_tg_fbm_vss_tg_fbs_vss_tg_s_vss_vss_vss_link_vss_link_bridge_vss_link_dip_vss_link_m1_vss_x1_vss_x2_vss_x3_t187
+ g_vss_m1|inv_clk_vss|inv_mc_vss|inv_q_vss|mph_g|nand_m_vss|nand_s2_vss|s1_vss_m1|s2_vss_m1|s3_vss_m1|s4_vss_m1|sb_vss|sr1_vss|sr2_vss|sr3_vss|sr4_vss|sv_vss|tg_d_vss|tg_fbm_vss|tg_fbs_vss|tg_s_vss|vss|vss_link|vss_link_bridge|vss_link_dip|vss_link_m1|vss_x1|vss_x2|vss_x3__t187
+ g_vss_m1|inv_clk_vss|inv_mc_vss|inv_q_vss|mph_g|nand_m_vss|nand_s2_vss|s1_vss_m1|s2_vss_m1|s3_vss_m1|s4_vss_m1|sb_vss|sr1_vss|sr2_vss|sr3_vss|sr4_vss|sv_vss|tg_d_vss|tg_fbm_vss|tg_fbs_vss|tg_s_vss|vss|vss_link|vss_link_bridge|vss_link_dip|vss_link_m1|vss_x1|vss_x2|vss_x3
+ 164.562524955
* device instance g_vss_m1_inv_clk_vss_inv_mc_vss_inv_q_vss_mph_g_nand_m_vss_nand_s2_vss_s1_vss_m1_s2_vss_m1_s3_vss_m1_s4_vss_m1_sb_vss_sr1_vss_sr2_vss_sr3_vss_sr4_vss_sv_vss_tg_d_vss_tg_fbm_vss_tg_fbs_vss_tg_s_vss_vss_vss_link_vss_link_bridge_vss_link_dip_vss_link_m1_vss_x1_vss_x2_vss_x3_t188 r0 *1 0,0
Rg_vss_m1_inv_clk_vss_inv_mc_vss_inv_q_vss_mph_g_nand_m_vss_nand_s2_vss_s1_vss_m1_s2_vss_m1_s3_vss_m1_s4_vss_m1_sb_vss_sr1_vss_sr2_vss_sr3_vss_sr4_vss_sv_vss_tg_d_vss_tg_fbm_vss_tg_fbs_vss_tg_s_vss_vss_vss_link_vss_link_bridge_vss_link_dip_vss_link_m1_vss_x1_vss_x2_vss_x3_t188
+ g_vss_m1|inv_clk_vss|inv_mc_vss|inv_q_vss|mph_g|nand_m_vss|nand_s2_vss|s1_vss_m1|s2_vss_m1|s3_vss_m1|s4_vss_m1|sb_vss|sr1_vss|sr2_vss|sr3_vss|sr4_vss|sv_vss|tg_d_vss|tg_fbm_vss|tg_fbs_vss|tg_s_vss|vss|vss_link|vss_link_bridge|vss_link_dip|vss_link_m1|vss_x1|vss_x2|vss_x3__t188
+ g_vss_m1|inv_clk_vss|inv_mc_vss|inv_q_vss|mph_g|nand_m_vss|nand_s2_vss|s1_vss_m1|s2_vss_m1|s3_vss_m1|s4_vss_m1|sb_vss|sr1_vss|sr2_vss|sr3_vss|sr4_vss|sv_vss|tg_d_vss|tg_fbm_vss|tg_fbs_vss|tg_s_vss|vss|vss_link|vss_link_bridge|vss_link_dip|vss_link_m1|vss_x1|vss_x2|vss_x3
+ 187.034152811
* device instance g_vss_m1_inv_clk_vss_inv_mc_vss_inv_q_vss_mph_g_nand_m_vss_nand_s2_vss_s1_vss_m1_s2_vss_m1_s3_vss_m1_s4_vss_m1_sb_vss_sr1_vss_sr2_vss_sr3_vss_sr4_vss_sv_vss_tg_d_vss_tg_fbm_vss_tg_fbs_vss_tg_s_vss_vss_vss_link_vss_link_bridge_vss_link_dip_vss_link_m1_vss_x1_vss_x2_vss_x3_t189 r0 *1 0,0
Rg_vss_m1_inv_clk_vss_inv_mc_vss_inv_q_vss_mph_g_nand_m_vss_nand_s2_vss_s1_vss_m1_s2_vss_m1_s3_vss_m1_s4_vss_m1_sb_vss_sr1_vss_sr2_vss_sr3_vss_sr4_vss_sv_vss_tg_d_vss_tg_fbm_vss_tg_fbs_vss_tg_s_vss_vss_vss_link_vss_link_bridge_vss_link_dip_vss_link_m1_vss_x1_vss_x2_vss_x3_t189
+ g_vss_m1|inv_clk_vss|inv_mc_vss|inv_q_vss|mph_g|nand_m_vss|nand_s2_vss|s1_vss_m1|s2_vss_m1|s3_vss_m1|s4_vss_m1|sb_vss|sr1_vss|sr2_vss|sr3_vss|sr4_vss|sv_vss|tg_d_vss|tg_fbm_vss|tg_fbs_vss|tg_s_vss|vss|vss_link|vss_link_bridge|vss_link_dip|vss_link_m1|vss_x1|vss_x2|vss_x3__t189
+ g_vss_m1|inv_clk_vss|inv_mc_vss|inv_q_vss|mph_g|nand_m_vss|nand_s2_vss|s1_vss_m1|s2_vss_m1|s3_vss_m1|s4_vss_m1|sb_vss|sr1_vss|sr2_vss|sr3_vss|sr4_vss|sv_vss|tg_d_vss|tg_fbm_vss|tg_fbs_vss|tg_s_vss|vss|vss_link|vss_link_bridge|vss_link_dip|vss_link_m1|vss_x1|vss_x2|vss_x3
+ 209.543216261
* device instance g_vss_m1_inv_clk_vss_inv_mc_vss_inv_q_vss_mph_g_nand_m_vss_nand_s2_vss_s1_vss_m1_s2_vss_m1_s3_vss_m1_s4_vss_m1_sb_vss_sr1_vss_sr2_vss_sr3_vss_sr4_vss_sv_vss_tg_d_vss_tg_fbm_vss_tg_fbs_vss_tg_s_vss_vss_vss_link_vss_link_bridge_vss_link_dip_vss_link_m1_vss_x1_vss_x2_vss_x3_t190 r0 *1 0,0
Rg_vss_m1_inv_clk_vss_inv_mc_vss_inv_q_vss_mph_g_nand_m_vss_nand_s2_vss_s1_vss_m1_s2_vss_m1_s3_vss_m1_s4_vss_m1_sb_vss_sr1_vss_sr2_vss_sr3_vss_sr4_vss_sv_vss_tg_d_vss_tg_fbm_vss_tg_fbs_vss_tg_s_vss_vss_vss_link_vss_link_bridge_vss_link_dip_vss_link_m1_vss_x1_vss_x2_vss_x3_t190
+ g_vss_m1|inv_clk_vss|inv_mc_vss|inv_q_vss|mph_g|nand_m_vss|nand_s2_vss|s1_vss_m1|s2_vss_m1|s3_vss_m1|s4_vss_m1|sb_vss|sr1_vss|sr2_vss|sr3_vss|sr4_vss|sv_vss|tg_d_vss|tg_fbm_vss|tg_fbs_vss|tg_s_vss|vss|vss_link|vss_link_bridge|vss_link_dip|vss_link_m1|vss_x1|vss_x2|vss_x3__t190
+ g_vss_m1|inv_clk_vss|inv_mc_vss|inv_q_vss|mph_g|nand_m_vss|nand_s2_vss|s1_vss_m1|s2_vss_m1|s3_vss_m1|s4_vss_m1|sb_vss|sr1_vss|sr2_vss|sr3_vss|sr4_vss|sv_vss|tg_d_vss|tg_fbm_vss|tg_fbs_vss|tg_s_vss|vss|vss_link|vss_link_bridge|vss_link_dip|vss_link_m1|vss_x1|vss_x2|vss_x3
+ 232.078823052
* device instance g_vss_m1_inv_clk_vss_inv_mc_vss_inv_q_vss_mph_g_nand_m_vss_nand_s2_vss_s1_vss_m1_s2_vss_m1_s3_vss_m1_s4_vss_m1_sb_vss_sr1_vss_sr2_vss_sr3_vss_sr4_vss_sv_vss_tg_d_vss_tg_fbm_vss_tg_fbs_vss_tg_s_vss_vss_vss_link_vss_link_bridge_vss_link_dip_vss_link_m1_vss_x1_vss_x2_vss_x3_t191 r0 *1 0,0
Rg_vss_m1_inv_clk_vss_inv_mc_vss_inv_q_vss_mph_g_nand_m_vss_nand_s2_vss_s1_vss_m1_s2_vss_m1_s3_vss_m1_s4_vss_m1_sb_vss_sr1_vss_sr2_vss_sr3_vss_sr4_vss_sv_vss_tg_d_vss_tg_fbm_vss_tg_fbs_vss_tg_s_vss_vss_vss_link_vss_link_bridge_vss_link_dip_vss_link_m1_vss_x1_vss_x2_vss_x3_t191
+ g_vss_m1|inv_clk_vss|inv_mc_vss|inv_q_vss|mph_g|nand_m_vss|nand_s2_vss|s1_vss_m1|s2_vss_m1|s3_vss_m1|s4_vss_m1|sb_vss|sr1_vss|sr2_vss|sr3_vss|sr4_vss|sv_vss|tg_d_vss|tg_fbm_vss|tg_fbs_vss|tg_s_vss|vss|vss_link|vss_link_bridge|vss_link_dip|vss_link_m1|vss_x1|vss_x2|vss_x3__t191
+ g_vss_m1|inv_clk_vss|inv_mc_vss|inv_q_vss|mph_g|nand_m_vss|nand_s2_vss|s1_vss_m1|s2_vss_m1|s3_vss_m1|s4_vss_m1|sb_vss|sr1_vss|sr2_vss|sr3_vss|sr4_vss|sv_vss|tg_d_vss|tg_fbm_vss|tg_fbs_vss|tg_s_vss|vss|vss_link|vss_link_bridge|vss_link_dip|vss_link_m1|vss_x1|vss_x2|vss_x3
+ 256.414180866
* device instance g_vss_m1_inv_clk_vss_inv_mc_vss_inv_q_vss_mph_g_nand_m_vss_nand_s2_vss_s1_vss_m1_s2_vss_m1_s3_vss_m1_s4_vss_m1_sb_vss_sr1_vss_sr2_vss_sr3_vss_sr4_vss_sv_vss_tg_d_vss_tg_fbm_vss_tg_fbs_vss_tg_s_vss_vss_vss_link_vss_link_bridge_vss_link_dip_vss_link_m1_vss_x1_vss_x2_vss_x3_t192 r0 *1 0,0
Rg_vss_m1_inv_clk_vss_inv_mc_vss_inv_q_vss_mph_g_nand_m_vss_nand_s2_vss_s1_vss_m1_s2_vss_m1_s3_vss_m1_s4_vss_m1_sb_vss_sr1_vss_sr2_vss_sr3_vss_sr4_vss_sv_vss_tg_d_vss_tg_fbm_vss_tg_fbs_vss_tg_s_vss_vss_vss_link_vss_link_bridge_vss_link_dip_vss_link_m1_vss_x1_vss_x2_vss_x3_t192
+ g_vss_m1|inv_clk_vss|inv_mc_vss|inv_q_vss|mph_g|nand_m_vss|nand_s2_vss|s1_vss_m1|s2_vss_m1|s3_vss_m1|s4_vss_m1|sb_vss|sr1_vss|sr2_vss|sr3_vss|sr4_vss|sv_vss|tg_d_vss|tg_fbm_vss|tg_fbs_vss|tg_s_vss|vss|vss_link|vss_link_bridge|vss_link_dip|vss_link_m1|vss_x1|vss_x2|vss_x3__t192
+ g_vss_m1|inv_clk_vss|inv_mc_vss|inv_q_vss|mph_g|nand_m_vss|nand_s2_vss|s1_vss_m1|s2_vss_m1|s3_vss_m1|s4_vss_m1|sb_vss|sr1_vss|sr2_vss|sr3_vss|sr4_vss|sv_vss|tg_d_vss|tg_fbm_vss|tg_fbs_vss|tg_s_vss|vss|vss_link|vss_link_bridge|vss_link_dip|vss_link_m1|vss_x1|vss_x2|vss_x3
+ 337.361037403
* device instance g_vss_m1_inv_clk_vss_inv_mc_vss_inv_q_vss_mph_g_nand_m_vss_nand_s2_vss_s1_vss_m1_s2_vss_m1_s3_vss_m1_s4_vss_m1_sb_vss_sr1_vss_sr2_vss_sr3_vss_sr4_vss_sv_vss_tg_d_vss_tg_fbm_vss_tg_fbs_vss_tg_s_vss_vss_vss_link_vss_link_bridge_vss_link_dip_vss_link_m1_vss_x1_vss_x2_vss_x3_t193 r0 *1 0,0
Rg_vss_m1_inv_clk_vss_inv_mc_vss_inv_q_vss_mph_g_nand_m_vss_nand_s2_vss_s1_vss_m1_s2_vss_m1_s3_vss_m1_s4_vss_m1_sb_vss_sr1_vss_sr2_vss_sr3_vss_sr4_vss_sv_vss_tg_d_vss_tg_fbm_vss_tg_fbs_vss_tg_s_vss_vss_vss_link_vss_link_bridge_vss_link_dip_vss_link_m1_vss_x1_vss_x2_vss_x3_t193
+ g_vss_m1|inv_clk_vss|inv_mc_vss|inv_q_vss|mph_g|nand_m_vss|nand_s2_vss|s1_vss_m1|s2_vss_m1|s3_vss_m1|s4_vss_m1|sb_vss|sr1_vss|sr2_vss|sr3_vss|sr4_vss|sv_vss|tg_d_vss|tg_fbm_vss|tg_fbs_vss|tg_s_vss|vss|vss_link|vss_link_bridge|vss_link_dip|vss_link_m1|vss_x1|vss_x2|vss_x3__t193
+ g_vss_m1|inv_clk_vss|inv_mc_vss|inv_q_vss|mph_g|nand_m_vss|nand_s2_vss|s1_vss_m1|s2_vss_m1|s3_vss_m1|s4_vss_m1|sb_vss|sr1_vss|sr2_vss|sr3_vss|sr4_vss|sv_vss|tg_d_vss|tg_fbm_vss|tg_fbs_vss|tg_s_vss|vss|vss_link|vss_link_bridge|vss_link_dip|vss_link_m1|vss_x1|vss_x2|vss_x3
+ 288.326263217
* device instance g_vss_m1_inv_clk_vss_inv_mc_vss_inv_q_vss_mph_g_nand_m_vss_nand_s2_vss_s1_vss_m1_s2_vss_m1_s3_vss_m1_s4_vss_m1_sb_vss_sr1_vss_sr2_vss_sr3_vss_sr4_vss_sv_vss_tg_d_vss_tg_fbm_vss_tg_fbs_vss_tg_s_vss_vss_vss_link_vss_link_bridge_vss_link_dip_vss_link_m1_vss_x1_vss_x2_vss_x3_t194 r0 *1 0,0
Rg_vss_m1_inv_clk_vss_inv_mc_vss_inv_q_vss_mph_g_nand_m_vss_nand_s2_vss_s1_vss_m1_s2_vss_m1_s3_vss_m1_s4_vss_m1_sb_vss_sr1_vss_sr2_vss_sr3_vss_sr4_vss_sv_vss_tg_d_vss_tg_fbm_vss_tg_fbs_vss_tg_s_vss_vss_vss_link_vss_link_bridge_vss_link_dip_vss_link_m1_vss_x1_vss_x2_vss_x3_t194
+ g_vss_m1|inv_clk_vss|inv_mc_vss|inv_q_vss|mph_g|nand_m_vss|nand_s2_vss|s1_vss_m1|s2_vss_m1|s3_vss_m1|s4_vss_m1|sb_vss|sr1_vss|sr2_vss|sr3_vss|sr4_vss|sv_vss|tg_d_vss|tg_fbm_vss|tg_fbs_vss|tg_s_vss|vss|vss_link|vss_link_bridge|vss_link_dip|vss_link_m1|vss_x1|vss_x2|vss_x3__t194
+ g_vss_m1|inv_clk_vss|inv_mc_vss|inv_q_vss|mph_g|nand_m_vss|nand_s2_vss|s1_vss_m1|s2_vss_m1|s3_vss_m1|s4_vss_m1|sb_vss|sr1_vss|sr2_vss|sr3_vss|sr4_vss|sv_vss|tg_d_vss|tg_fbm_vss|tg_fbs_vss|tg_s_vss|vss|vss_link|vss_link_bridge|vss_link_dip|vss_link_m1|vss_x1|vss_x2|vss_x3
+ 259.440105674
* device instance g_vss_m1_inv_clk_vss_inv_mc_vss_inv_q_vss_mph_g_nand_m_vss_nand_s2_vss_s1_vss_m1_s2_vss_m1_s3_vss_m1_s4_vss_m1_sb_vss_sr1_vss_sr2_vss_sr3_vss_sr4_vss_sv_vss_tg_d_vss_tg_fbm_vss_tg_fbs_vss_tg_s_vss_vss_vss_link_vss_link_bridge_vss_link_dip_vss_link_m1_vss_x1_vss_x2_vss_x3_t195 r0 *1 0,0
Rg_vss_m1_inv_clk_vss_inv_mc_vss_inv_q_vss_mph_g_nand_m_vss_nand_s2_vss_s1_vss_m1_s2_vss_m1_s3_vss_m1_s4_vss_m1_sb_vss_sr1_vss_sr2_vss_sr3_vss_sr4_vss_sv_vss_tg_d_vss_tg_fbm_vss_tg_fbs_vss_tg_s_vss_vss_vss_link_vss_link_bridge_vss_link_dip_vss_link_m1_vss_x1_vss_x2_vss_x3_t195
+ g_vss_m1|inv_clk_vss|inv_mc_vss|inv_q_vss|mph_g|nand_m_vss|nand_s2_vss|s1_vss_m1|s2_vss_m1|s3_vss_m1|s4_vss_m1|sb_vss|sr1_vss|sr2_vss|sr3_vss|sr4_vss|sv_vss|tg_d_vss|tg_fbm_vss|tg_fbs_vss|tg_s_vss|vss|vss_link|vss_link_bridge|vss_link_dip|vss_link_m1|vss_x1|vss_x2|vss_x3__t195
+ g_vss_m1|inv_clk_vss|inv_mc_vss|inv_q_vss|mph_g|nand_m_vss|nand_s2_vss|s1_vss_m1|s2_vss_m1|s3_vss_m1|s4_vss_m1|sb_vss|sr1_vss|sr2_vss|sr3_vss|sr4_vss|sv_vss|tg_d_vss|tg_fbm_vss|tg_fbs_vss|tg_s_vss|vss|vss_link|vss_link_bridge|vss_link_dip|vss_link_m1|vss_x1|vss_x2|vss_x3
+ 211.445675363
* device instance g_vss_m1_inv_clk_vss_inv_mc_vss_inv_q_vss_mph_g_nand_m_vss_nand_s2_vss_s1_vss_m1_s2_vss_m1_s3_vss_m1_s4_vss_m1_sb_vss_sr1_vss_sr2_vss_sr3_vss_sr4_vss_sv_vss_tg_d_vss_tg_fbm_vss_tg_fbs_vss_tg_s_vss_vss_vss_link_vss_link_bridge_vss_link_dip_vss_link_m1_vss_x1_vss_x2_vss_x3_t196 r0 *1 0,0
Rg_vss_m1_inv_clk_vss_inv_mc_vss_inv_q_vss_mph_g_nand_m_vss_nand_s2_vss_s1_vss_m1_s2_vss_m1_s3_vss_m1_s4_vss_m1_sb_vss_sr1_vss_sr2_vss_sr3_vss_sr4_vss_sv_vss_tg_d_vss_tg_fbm_vss_tg_fbs_vss_tg_s_vss_vss_vss_link_vss_link_bridge_vss_link_dip_vss_link_m1_vss_x1_vss_x2_vss_x3_t196
+ g_vss_m1|inv_clk_vss|inv_mc_vss|inv_q_vss|mph_g|nand_m_vss|nand_s2_vss|s1_vss_m1|s2_vss_m1|s3_vss_m1|s4_vss_m1|sb_vss|sr1_vss|sr2_vss|sr3_vss|sr4_vss|sv_vss|tg_d_vss|tg_fbm_vss|tg_fbs_vss|tg_s_vss|vss|vss_link|vss_link_bridge|vss_link_dip|vss_link_m1|vss_x1|vss_x2|vss_x3__t196
+ g_vss_m1|inv_clk_vss|inv_mc_vss|inv_q_vss|mph_g|nand_m_vss|nand_s2_vss|s1_vss_m1|s2_vss_m1|s3_vss_m1|s4_vss_m1|sb_vss|sr1_vss|sr2_vss|sr3_vss|sr4_vss|sv_vss|tg_d_vss|tg_fbm_vss|tg_fbs_vss|tg_s_vss|vss|vss_link|vss_link_bridge|vss_link_dip|vss_link_m1|vss_x1|vss_x2|vss_x3
+ 183.536990297
* device instance g_vss_m1_inv_clk_vss_inv_mc_vss_inv_q_vss_mph_g_nand_m_vss_nand_s2_vss_s1_vss_m1_s2_vss_m1_s3_vss_m1_s4_vss_m1_sb_vss_sr1_vss_sr2_vss_sr3_vss_sr4_vss_sv_vss_tg_d_vss_tg_fbm_vss_tg_fbs_vss_tg_s_vss_vss_vss_link_vss_link_bridge_vss_link_dip_vss_link_m1_vss_x1_vss_x2_vss_x3_t197 r0 *1 0,0
Rg_vss_m1_inv_clk_vss_inv_mc_vss_inv_q_vss_mph_g_nand_m_vss_nand_s2_vss_s1_vss_m1_s2_vss_m1_s3_vss_m1_s4_vss_m1_sb_vss_sr1_vss_sr2_vss_sr3_vss_sr4_vss_sv_vss_tg_d_vss_tg_fbm_vss_tg_fbs_vss_tg_s_vss_vss_vss_link_vss_link_bridge_vss_link_dip_vss_link_m1_vss_x1_vss_x2_vss_x3_t197
+ g_vss_m1|inv_clk_vss|inv_mc_vss|inv_q_vss|mph_g|nand_m_vss|nand_s2_vss|s1_vss_m1|s2_vss_m1|s3_vss_m1|s4_vss_m1|sb_vss|sr1_vss|sr2_vss|sr3_vss|sr4_vss|sv_vss|tg_d_vss|tg_fbm_vss|tg_fbs_vss|tg_s_vss|vss|vss_link|vss_link_bridge|vss_link_dip|vss_link_m1|vss_x1|vss_x2|vss_x3__t197
+ g_vss_m1|inv_clk_vss|inv_mc_vss|inv_q_vss|mph_g|nand_m_vss|nand_s2_vss|s1_vss_m1|s2_vss_m1|s3_vss_m1|s4_vss_m1|sb_vss|sr1_vss|sr2_vss|sr3_vss|sr4_vss|sv_vss|tg_d_vss|tg_fbm_vss|tg_fbs_vss|tg_s_vss|vss|vss_link|vss_link_bridge|vss_link_dip|vss_link_m1|vss_x1|vss_x2|vss_x3
+ 138.443030519
* device instance g_vss_m1_inv_clk_vss_inv_mc_vss_inv_q_vss_mph_g_nand_m_vss_nand_s2_vss_s1_vss_m1_s2_vss_m1_s3_vss_m1_s4_vss_m1_sb_vss_sr1_vss_sr2_vss_sr3_vss_sr4_vss_sv_vss_tg_d_vss_tg_fbm_vss_tg_fbs_vss_tg_s_vss_vss_vss_link_vss_link_bridge_vss_link_dip_vss_link_m1_vss_x1_vss_x2_vss_x3_t198 r0 *1 0,0
Rg_vss_m1_inv_clk_vss_inv_mc_vss_inv_q_vss_mph_g_nand_m_vss_nand_s2_vss_s1_vss_m1_s2_vss_m1_s3_vss_m1_s4_vss_m1_sb_vss_sr1_vss_sr2_vss_sr3_vss_sr4_vss_sv_vss_tg_d_vss_tg_fbm_vss_tg_fbs_vss_tg_s_vss_vss_vss_link_vss_link_bridge_vss_link_dip_vss_link_m1_vss_x1_vss_x2_vss_x3_t198
+ g_vss_m1|inv_clk_vss|inv_mc_vss|inv_q_vss|mph_g|nand_m_vss|nand_s2_vss|s1_vss_m1|s2_vss_m1|s3_vss_m1|s4_vss_m1|sb_vss|sr1_vss|sr2_vss|sr3_vss|sr4_vss|sv_vss|tg_d_vss|tg_fbm_vss|tg_fbs_vss|tg_s_vss|vss|vss_link|vss_link_bridge|vss_link_dip|vss_link_m1|vss_x1|vss_x2|vss_x3__t198
+ g_vss_m1|inv_clk_vss|inv_mc_vss|inv_q_vss|mph_g|nand_m_vss|nand_s2_vss|s1_vss_m1|s2_vss_m1|s3_vss_m1|s4_vss_m1|sb_vss|sr1_vss|sr2_vss|sr3_vss|sr4_vss|sv_vss|tg_d_vss|tg_fbm_vss|tg_fbs_vss|tg_s_vss|vss|vss_link|vss_link_bridge|vss_link_dip|vss_link_m1|vss_x1|vss_x2|vss_x3
+ 330.123479448
* device instance g_vss_m1_inv_clk_vss_inv_mc_vss_inv_q_vss_mph_g_nand_m_vss_nand_s2_vss_s1_vss_m1_s2_vss_m1_s3_vss_m1_s4_vss_m1_sb_vss_sr1_vss_sr2_vss_sr3_vss_sr4_vss_sv_vss_tg_d_vss_tg_fbm_vss_tg_fbs_vss_tg_s_vss_vss_vss_link_vss_link_bridge_vss_link_dip_vss_link_m1_vss_x1_vss_x2_vss_x3_t199 r0 *1 0,0
Rg_vss_m1_inv_clk_vss_inv_mc_vss_inv_q_vss_mph_g_nand_m_vss_nand_s2_vss_s1_vss_m1_s2_vss_m1_s3_vss_m1_s4_vss_m1_sb_vss_sr1_vss_sr2_vss_sr3_vss_sr4_vss_sv_vss_tg_d_vss_tg_fbm_vss_tg_fbs_vss_tg_s_vss_vss_vss_link_vss_link_bridge_vss_link_dip_vss_link_m1_vss_x1_vss_x2_vss_x3_t199
+ g_vss_m1|inv_clk_vss|inv_mc_vss|inv_q_vss|mph_g|nand_m_vss|nand_s2_vss|s1_vss_m1|s2_vss_m1|s3_vss_m1|s4_vss_m1|sb_vss|sr1_vss|sr2_vss|sr3_vss|sr4_vss|sv_vss|tg_d_vss|tg_fbm_vss|tg_fbs_vss|tg_s_vss|vss|vss_link|vss_link_bridge|vss_link_dip|vss_link_m1|vss_x1|vss_x2|vss_x3__t199
+ g_vss_m1|inv_clk_vss|inv_mc_vss|inv_q_vss|mph_g|nand_m_vss|nand_s2_vss|s1_vss_m1|s2_vss_m1|s3_vss_m1|s4_vss_m1|sb_vss|sr1_vss|sr2_vss|sr3_vss|sr4_vss|sv_vss|tg_d_vss|tg_fbm_vss|tg_fbs_vss|tg_s_vss|vss|vss_link|vss_link_bridge|vss_link_dip|vss_link_m1|vss_x1|vss_x2|vss_x3
+ 304.422056852
* device instance g_vss_m1_inv_clk_vss_inv_mc_vss_inv_q_vss_mph_g_nand_m_vss_nand_s2_vss_s1_vss_m1_s2_vss_m1_s3_vss_m1_s4_vss_m1_sb_vss_sr1_vss_sr2_vss_sr3_vss_sr4_vss_sv_vss_tg_d_vss_tg_fbm_vss_tg_fbs_vss_tg_s_vss_vss_vss_link_vss_link_bridge_vss_link_dip_vss_link_m1_vss_x1_vss_x2_vss_x3_t200 r0 *1 0,0
Rg_vss_m1_inv_clk_vss_inv_mc_vss_inv_q_vss_mph_g_nand_m_vss_nand_s2_vss_s1_vss_m1_s2_vss_m1_s3_vss_m1_s4_vss_m1_sb_vss_sr1_vss_sr2_vss_sr3_vss_sr4_vss_sv_vss_tg_d_vss_tg_fbm_vss_tg_fbs_vss_tg_s_vss_vss_vss_link_vss_link_bridge_vss_link_dip_vss_link_m1_vss_x1_vss_x2_vss_x3_t200
+ g_vss_m1|inv_clk_vss|inv_mc_vss|inv_q_vss|mph_g|nand_m_vss|nand_s2_vss|s1_vss_m1|s2_vss_m1|s3_vss_m1|s4_vss_m1|sb_vss|sr1_vss|sr2_vss|sr3_vss|sr4_vss|sv_vss|tg_d_vss|tg_fbm_vss|tg_fbs_vss|tg_s_vss|vss|vss_link|vss_link_bridge|vss_link_dip|vss_link_m1|vss_x1|vss_x2|vss_x3__t200
+ g_vss_m1|inv_clk_vss|inv_mc_vss|inv_q_vss|mph_g|nand_m_vss|nand_s2_vss|s1_vss_m1|s2_vss_m1|s3_vss_m1|s4_vss_m1|sb_vss|sr1_vss|sr2_vss|sr3_vss|sr4_vss|sv_vss|tg_d_vss|tg_fbm_vss|tg_fbs_vss|tg_s_vss|vss|vss_link|vss_link_bridge|vss_link_dip|vss_link_m1|vss_x1|vss_x2|vss_x3
+ 281.838786931
* device instance g_vss_m1_inv_clk_vss_inv_mc_vss_inv_q_vss_mph_g_nand_m_vss_nand_s2_vss_s1_vss_m1_s2_vss_m1_s3_vss_m1_s4_vss_m1_sb_vss_sr1_vss_sr2_vss_sr3_vss_sr4_vss_sv_vss_tg_d_vss_tg_fbm_vss_tg_fbs_vss_tg_s_vss_vss_vss_link_vss_link_bridge_vss_link_dip_vss_link_m1_vss_x1_vss_x2_vss_x3_t201 r0 *1 0,0
Rg_vss_m1_inv_clk_vss_inv_mc_vss_inv_q_vss_mph_g_nand_m_vss_nand_s2_vss_s1_vss_m1_s2_vss_m1_s3_vss_m1_s4_vss_m1_sb_vss_sr1_vss_sr2_vss_sr3_vss_sr4_vss_sv_vss_tg_d_vss_tg_fbm_vss_tg_fbs_vss_tg_s_vss_vss_vss_link_vss_link_bridge_vss_link_dip_vss_link_m1_vss_x1_vss_x2_vss_x3_t201
+ g_vss_m1|inv_clk_vss|inv_mc_vss|inv_q_vss|mph_g|nand_m_vss|nand_s2_vss|s1_vss_m1|s2_vss_m1|s3_vss_m1|s4_vss_m1|sb_vss|sr1_vss|sr2_vss|sr3_vss|sr4_vss|sv_vss|tg_d_vss|tg_fbm_vss|tg_fbs_vss|tg_s_vss|vss|vss_link|vss_link_bridge|vss_link_dip|vss_link_m1|vss_x1|vss_x2|vss_x3__t201
+ g_vss_m1|inv_clk_vss|inv_mc_vss|inv_q_vss|mph_g|nand_m_vss|nand_s2_vss|s1_vss_m1|s2_vss_m1|s3_vss_m1|s4_vss_m1|sb_vss|sr1_vss|sr2_vss|sr3_vss|sr4_vss|sv_vss|tg_d_vss|tg_fbm_vss|tg_fbs_vss|tg_s_vss|vss|vss_link|vss_link_bridge|vss_link_dip|vss_link_m1|vss_x1|vss_x2|vss_x3
+ 259.266369598
* device instance g_vss_m1_inv_clk_vss_inv_mc_vss_inv_q_vss_mph_g_nand_m_vss_nand_s2_vss_s1_vss_m1_s2_vss_m1_s3_vss_m1_s4_vss_m1_sb_vss_sr1_vss_sr2_vss_sr3_vss_sr4_vss_sv_vss_tg_d_vss_tg_fbm_vss_tg_fbs_vss_tg_s_vss_vss_vss_link_vss_link_bridge_vss_link_dip_vss_link_m1_vss_x1_vss_x2_vss_x3_t202 r0 *1 0,0
Rg_vss_m1_inv_clk_vss_inv_mc_vss_inv_q_vss_mph_g_nand_m_vss_nand_s2_vss_s1_vss_m1_s2_vss_m1_s3_vss_m1_s4_vss_m1_sb_vss_sr1_vss_sr2_vss_sr3_vss_sr4_vss_sv_vss_tg_d_vss_tg_fbm_vss_tg_fbs_vss_tg_s_vss_vss_vss_link_vss_link_bridge_vss_link_dip_vss_link_m1_vss_x1_vss_x2_vss_x3_t202
+ g_vss_m1|inv_clk_vss|inv_mc_vss|inv_q_vss|mph_g|nand_m_vss|nand_s2_vss|s1_vss_m1|s2_vss_m1|s3_vss_m1|s4_vss_m1|sb_vss|sr1_vss|sr2_vss|sr3_vss|sr4_vss|sv_vss|tg_d_vss|tg_fbm_vss|tg_fbs_vss|tg_s_vss|vss|vss_link|vss_link_bridge|vss_link_dip|vss_link_m1|vss_x1|vss_x2|vss_x3__t202
+ g_vss_m1|inv_clk_vss|inv_mc_vss|inv_q_vss|mph_g|nand_m_vss|nand_s2_vss|s1_vss_m1|s2_vss_m1|s3_vss_m1|s4_vss_m1|sb_vss|sr1_vss|sr2_vss|sr3_vss|sr4_vss|sv_vss|tg_d_vss|tg_fbm_vss|tg_fbs_vss|tg_s_vss|vss|vss_link|vss_link_bridge|vss_link_dip|vss_link_m1|vss_x1|vss_x2|vss_x3
+ 236.707909574
* device instance g_vss_m1_inv_clk_vss_inv_mc_vss_inv_q_vss_mph_g_nand_m_vss_nand_s2_vss_s1_vss_m1_s2_vss_m1_s3_vss_m1_s4_vss_m1_sb_vss_sr1_vss_sr2_vss_sr3_vss_sr4_vss_sv_vss_tg_d_vss_tg_fbm_vss_tg_fbs_vss_tg_s_vss_vss_vss_link_vss_link_bridge_vss_link_dip_vss_link_m1_vss_x1_vss_x2_vss_x3_t203 r0 *1 0,0
Rg_vss_m1_inv_clk_vss_inv_mc_vss_inv_q_vss_mph_g_nand_m_vss_nand_s2_vss_s1_vss_m1_s2_vss_m1_s3_vss_m1_s4_vss_m1_sb_vss_sr1_vss_sr2_vss_sr3_vss_sr4_vss_sv_vss_tg_d_vss_tg_fbm_vss_tg_fbs_vss_tg_s_vss_vss_vss_link_vss_link_bridge_vss_link_dip_vss_link_m1_vss_x1_vss_x2_vss_x3_t203
+ g_vss_m1|inv_clk_vss|inv_mc_vss|inv_q_vss|mph_g|nand_m_vss|nand_s2_vss|s1_vss_m1|s2_vss_m1|s3_vss_m1|s4_vss_m1|sb_vss|sr1_vss|sr2_vss|sr3_vss|sr4_vss|sv_vss|tg_d_vss|tg_fbm_vss|tg_fbs_vss|tg_s_vss|vss|vss_link|vss_link_bridge|vss_link_dip|vss_link_m1|vss_x1|vss_x2|vss_x3__t203
+ g_vss_m1|inv_clk_vss|inv_mc_vss|inv_q_vss|mph_g|nand_m_vss|nand_s2_vss|s1_vss_m1|s2_vss_m1|s3_vss_m1|s4_vss_m1|sb_vss|sr1_vss|sr2_vss|sr3_vss|sr4_vss|sv_vss|tg_d_vss|tg_fbm_vss|tg_fbs_vss|tg_s_vss|vss|vss_link|vss_link_bridge|vss_link_dip|vss_link_m1|vss_x1|vss_x2|vss_x3
+ 177.55440599
* device instance g_vss_m1_inv_clk_vss_inv_mc_vss_inv_q_vss_mph_g_nand_m_vss_nand_s2_vss_s1_vss_m1_s2_vss_m1_s3_vss_m1_s4_vss_m1_sb_vss_sr1_vss_sr2_vss_sr3_vss_sr4_vss_sv_vss_tg_d_vss_tg_fbm_vss_tg_fbs_vss_tg_s_vss_vss_vss_link_vss_link_bridge_vss_link_dip_vss_link_m1_vss_x1_vss_x2_vss_x3_t204 r0 *1 0,0
Rg_vss_m1_inv_clk_vss_inv_mc_vss_inv_q_vss_mph_g_nand_m_vss_nand_s2_vss_s1_vss_m1_s2_vss_m1_s3_vss_m1_s4_vss_m1_sb_vss_sr1_vss_sr2_vss_sr3_vss_sr4_vss_sv_vss_tg_d_vss_tg_fbm_vss_tg_fbs_vss_tg_s_vss_vss_vss_link_vss_link_bridge_vss_link_dip_vss_link_m1_vss_x1_vss_x2_vss_x3_t204
+ g_vss_m1|inv_clk_vss|inv_mc_vss|inv_q_vss|mph_g|nand_m_vss|nand_s2_vss|s1_vss_m1|s2_vss_m1|s3_vss_m1|s4_vss_m1|sb_vss|sr1_vss|sr2_vss|sr3_vss|sr4_vss|sv_vss|tg_d_vss|tg_fbm_vss|tg_fbs_vss|tg_s_vss|vss|vss_link|vss_link_bridge|vss_link_dip|vss_link_m1|vss_x1|vss_x2|vss_x3__t204
+ g_vss_m1|inv_clk_vss|inv_mc_vss|inv_q_vss|mph_g|nand_m_vss|nand_s2_vss|s1_vss_m1|s2_vss_m1|s3_vss_m1|s4_vss_m1|sb_vss|sr1_vss|sr2_vss|sr3_vss|sr4_vss|sv_vss|tg_d_vss|tg_fbm_vss|tg_fbs_vss|tg_s_vss|vss|vss_link|vss_link_bridge|vss_link_dip|vss_link_m1|vss_x1|vss_x2|vss_x3
+ 152.018235557
* device instance g_vss_m1_inv_clk_vss_inv_mc_vss_inv_q_vss_mph_g_nand_m_vss_nand_s2_vss_s1_vss_m1_s2_vss_m1_s3_vss_m1_s4_vss_m1_sb_vss_sr1_vss_sr2_vss_sr3_vss_sr4_vss_sv_vss_tg_d_vss_tg_fbm_vss_tg_fbs_vss_tg_s_vss_vss_vss_link_vss_link_bridge_vss_link_dip_vss_link_m1_vss_x1_vss_x2_vss_x3_t205 r0 *1 0,0
Rg_vss_m1_inv_clk_vss_inv_mc_vss_inv_q_vss_mph_g_nand_m_vss_nand_s2_vss_s1_vss_m1_s2_vss_m1_s3_vss_m1_s4_vss_m1_sb_vss_sr1_vss_sr2_vss_sr3_vss_sr4_vss_sv_vss_tg_d_vss_tg_fbm_vss_tg_fbs_vss_tg_s_vss_vss_vss_link_vss_link_bridge_vss_link_dip_vss_link_m1_vss_x1_vss_x2_vss_x3_t205
+ g_vss_m1|inv_clk_vss|inv_mc_vss|inv_q_vss|mph_g|nand_m_vss|nand_s2_vss|s1_vss_m1|s2_vss_m1|s3_vss_m1|s4_vss_m1|sb_vss|sr1_vss|sr2_vss|sr3_vss|sr4_vss|sv_vss|tg_d_vss|tg_fbm_vss|tg_fbs_vss|tg_s_vss|vss|vss_link|vss_link_bridge|vss_link_dip|vss_link_m1|vss_x1|vss_x2|vss_x3__t205
+ g_vss_m1|inv_clk_vss|inv_mc_vss|inv_q_vss|mph_g|nand_m_vss|nand_s2_vss|s1_vss_m1|s2_vss_m1|s3_vss_m1|s4_vss_m1|sb_vss|sr1_vss|sr2_vss|sr3_vss|sr4_vss|sv_vss|tg_d_vss|tg_fbm_vss|tg_fbs_vss|tg_s_vss|vss|vss_link|vss_link_bridge|vss_link_dip|vss_link_m1|vss_x1|vss_x2|vss_x3
+ 129.644879673
* device instance g_vss_m1_inv_clk_vss_inv_mc_vss_inv_q_vss_mph_g_nand_m_vss_nand_s2_vss_s1_vss_m1_s2_vss_m1_s3_vss_m1_s4_vss_m1_sb_vss_sr1_vss_sr2_vss_sr3_vss_sr4_vss_sv_vss_tg_d_vss_tg_fbm_vss_tg_fbs_vss_tg_s_vss_vss_vss_link_vss_link_bridge_vss_link_dip_vss_link_m1_vss_x1_vss_x2_vss_x3_t206 r0 *1 0,0
Rg_vss_m1_inv_clk_vss_inv_mc_vss_inv_q_vss_mph_g_nand_m_vss_nand_s2_vss_s1_vss_m1_s2_vss_m1_s3_vss_m1_s4_vss_m1_sb_vss_sr1_vss_sr2_vss_sr3_vss_sr4_vss_sv_vss_tg_d_vss_tg_fbm_vss_tg_fbs_vss_tg_s_vss_vss_vss_link_vss_link_bridge_vss_link_dip_vss_link_m1_vss_x1_vss_x2_vss_x3_t206
+ g_vss_m1|inv_clk_vss|inv_mc_vss|inv_q_vss|mph_g|nand_m_vss|nand_s2_vss|s1_vss_m1|s2_vss_m1|s3_vss_m1|s4_vss_m1|sb_vss|sr1_vss|sr2_vss|sr3_vss|sr4_vss|sv_vss|tg_d_vss|tg_fbm_vss|tg_fbs_vss|tg_s_vss|vss|vss_link|vss_link_bridge|vss_link_dip|vss_link_m1|vss_x1|vss_x2|vss_x3__t206
+ g_vss_m1|inv_clk_vss|inv_mc_vss|inv_q_vss|mph_g|nand_m_vss|nand_s2_vss|s1_vss_m1|s2_vss_m1|s3_vss_m1|s4_vss_m1|sb_vss|sr1_vss|sr2_vss|sr3_vss|sr4_vss|sv_vss|tg_d_vss|tg_fbm_vss|tg_fbs_vss|tg_s_vss|vss|vss_link|vss_link_bridge|vss_link_dip|vss_link_m1|vss_x1|vss_x2|vss_x3
+ 107.38566559
* device instance g_vss_m1_inv_clk_vss_inv_mc_vss_inv_q_vss_mph_g_nand_m_vss_nand_s2_vss_s1_vss_m1_s2_vss_m1_s3_vss_m1_s4_vss_m1_sb_vss_sr1_vss_sr2_vss_sr3_vss_sr4_vss_sv_vss_tg_d_vss_tg_fbm_vss_tg_fbs_vss_tg_s_vss_vss_vss_link_vss_link_bridge_vss_link_dip_vss_link_m1_vss_x1_vss_x2_vss_x3_t207 r0 *1 0,0
Rg_vss_m1_inv_clk_vss_inv_mc_vss_inv_q_vss_mph_g_nand_m_vss_nand_s2_vss_s1_vss_m1_s2_vss_m1_s3_vss_m1_s4_vss_m1_sb_vss_sr1_vss_sr2_vss_sr3_vss_sr4_vss_sv_vss_tg_d_vss_tg_fbm_vss_tg_fbs_vss_tg_s_vss_vss_vss_link_vss_link_bridge_vss_link_dip_vss_link_m1_vss_x1_vss_x2_vss_x3_t207
+ g_vss_m1|inv_clk_vss|inv_mc_vss|inv_q_vss|mph_g|nand_m_vss|nand_s2_vss|s1_vss_m1|s2_vss_m1|s3_vss_m1|s4_vss_m1|sb_vss|sr1_vss|sr2_vss|sr3_vss|sr4_vss|sv_vss|tg_d_vss|tg_fbm_vss|tg_fbs_vss|tg_s_vss|vss|vss_link|vss_link_bridge|vss_link_dip|vss_link_m1|vss_x1|vss_x2|vss_x3__t207
+ g_vss_m1|inv_clk_vss|inv_mc_vss|inv_q_vss|mph_g|nand_m_vss|nand_s2_vss|s1_vss_m1|s2_vss_m1|s3_vss_m1|s4_vss_m1|sb_vss|sr1_vss|sr2_vss|sr3_vss|sr4_vss|sv_vss|tg_d_vss|tg_fbm_vss|tg_fbs_vss|tg_s_vss|vss|vss_link|vss_link_bridge|vss_link_dip|vss_link_m1|vss_x1|vss_x2|vss_x3
+ 85.329965357
* device instance g_vss_m1_inv_clk_vss_inv_mc_vss_inv_q_vss_mph_g_nand_m_vss_nand_s2_vss_s1_vss_m1_s2_vss_m1_s3_vss_m1_s4_vss_m1_sb_vss_sr1_vss_sr2_vss_sr3_vss_sr4_vss_sv_vss_tg_d_vss_tg_fbm_vss_tg_fbs_vss_tg_s_vss_vss_vss_link_vss_link_bridge_vss_link_dip_vss_link_m1_vss_x1_vss_x2_vss_x3_t208 r0 *1 0,0
Rg_vss_m1_inv_clk_vss_inv_mc_vss_inv_q_vss_mph_g_nand_m_vss_nand_s2_vss_s1_vss_m1_s2_vss_m1_s3_vss_m1_s4_vss_m1_sb_vss_sr1_vss_sr2_vss_sr3_vss_sr4_vss_sv_vss_tg_d_vss_tg_fbm_vss_tg_fbs_vss_tg_s_vss_vss_vss_link_vss_link_bridge_vss_link_dip_vss_link_m1_vss_x1_vss_x2_vss_x3_t208
+ g_vss_m1|inv_clk_vss|inv_mc_vss|inv_q_vss|mph_g|nand_m_vss|nand_s2_vss|s1_vss_m1|s2_vss_m1|s3_vss_m1|s4_vss_m1|sb_vss|sr1_vss|sr2_vss|sr3_vss|sr4_vss|sv_vss|tg_d_vss|tg_fbm_vss|tg_fbs_vss|tg_s_vss|vss|vss_link|vss_link_bridge|vss_link_dip|vss_link_m1|vss_x1|vss_x2|vss_x3__t208
+ g_vss_m1|inv_clk_vss|inv_mc_vss|inv_q_vss|mph_g|nand_m_vss|nand_s2_vss|s1_vss_m1|s2_vss_m1|s3_vss_m1|s4_vss_m1|sb_vss|sr1_vss|sr2_vss|sr3_vss|sr4_vss|sv_vss|tg_d_vss|tg_fbm_vss|tg_fbs_vss|tg_s_vss|vss|vss_link|vss_link_bridge|vss_link_dip|vss_link_m1|vss_x1|vss_x2|vss_x3
+ 31.6462135368
* device instance g_vss_m1_inv_clk_vss_inv_mc_vss_inv_q_vss_mph_g_nand_m_vss_nand_s2_vss_s1_vss_m1_s2_vss_m1_s3_vss_m1_s4_vss_m1_sb_vss_sr1_vss_sr2_vss_sr3_vss_sr4_vss_sv_vss_tg_d_vss_tg_fbm_vss_tg_fbs_vss_tg_s_vss_vss_vss_link_vss_link_bridge_vss_link_dip_vss_link_m1_vss_x1_vss_x2_vss_x3_t209 r0 *1 0,0
Rg_vss_m1_inv_clk_vss_inv_mc_vss_inv_q_vss_mph_g_nand_m_vss_nand_s2_vss_s1_vss_m1_s2_vss_m1_s3_vss_m1_s4_vss_m1_sb_vss_sr1_vss_sr2_vss_sr3_vss_sr4_vss_sv_vss_tg_d_vss_tg_fbm_vss_tg_fbs_vss_tg_s_vss_vss_vss_link_vss_link_bridge_vss_link_dip_vss_link_m1_vss_x1_vss_x2_vss_x3_t209
+ g_vss_m1|inv_clk_vss|inv_mc_vss|inv_q_vss|mph_g|nand_m_vss|nand_s2_vss|s1_vss_m1|s2_vss_m1|s3_vss_m1|s4_vss_m1|sb_vss|sr1_vss|sr2_vss|sr3_vss|sr4_vss|sv_vss|tg_d_vss|tg_fbm_vss|tg_fbs_vss|tg_s_vss|vss|vss_link|vss_link_bridge|vss_link_dip|vss_link_m1|vss_x1|vss_x2|vss_x3__t209
+ g_vss_m1|inv_clk_vss|inv_mc_vss|inv_q_vss|mph_g|nand_m_vss|nand_s2_vss|s1_vss_m1|s2_vss_m1|s3_vss_m1|s4_vss_m1|sb_vss|sr1_vss|sr2_vss|sr3_vss|sr4_vss|sv_vss|tg_d_vss|tg_fbm_vss|tg_fbs_vss|tg_s_vss|vss|vss_link|vss_link_bridge|vss_link_dip|vss_link_m1|vss_x1|vss_x2|vss_x3
+ 21.866859099
* device instance g_vss_m1_inv_clk_vss_inv_mc_vss_inv_q_vss_mph_g_nand_m_vss_nand_s2_vss_s1_vss_m1_s2_vss_m1_s3_vss_m1_s4_vss_m1_sb_vss_sr1_vss_sr2_vss_sr3_vss_sr4_vss_sv_vss_tg_d_vss_tg_fbm_vss_tg_fbs_vss_tg_s_vss_vss_vss_link_vss_link_bridge_vss_link_dip_vss_link_m1_vss_x1_vss_x2_vss_x3_t210 r0 *1 0,0
Rg_vss_m1_inv_clk_vss_inv_mc_vss_inv_q_vss_mph_g_nand_m_vss_nand_s2_vss_s1_vss_m1_s2_vss_m1_s3_vss_m1_s4_vss_m1_sb_vss_sr1_vss_sr2_vss_sr3_vss_sr4_vss_sv_vss_tg_d_vss_tg_fbm_vss_tg_fbs_vss_tg_s_vss_vss_vss_link_vss_link_bridge_vss_link_dip_vss_link_m1_vss_x1_vss_x2_vss_x3_t210
+ g_vss_m1|inv_clk_vss|inv_mc_vss|inv_q_vss|mph_g|nand_m_vss|nand_s2_vss|s1_vss_m1|s2_vss_m1|s3_vss_m1|s4_vss_m1|sb_vss|sr1_vss|sr2_vss|sr3_vss|sr4_vss|sv_vss|tg_d_vss|tg_fbm_vss|tg_fbs_vss|tg_s_vss|vss|vss_link|vss_link_bridge|vss_link_dip|vss_link_m1|vss_x1|vss_x2|vss_x3__t210
+ g_vss_m1|inv_clk_vss|inv_mc_vss|inv_q_vss|mph_g|nand_m_vss|nand_s2_vss|s1_vss_m1|s2_vss_m1|s3_vss_m1|s4_vss_m1|sb_vss|sr1_vss|sr2_vss|sr3_vss|sr4_vss|sv_vss|tg_d_vss|tg_fbm_vss|tg_fbs_vss|tg_s_vss|vss|vss_link|vss_link_bridge|vss_link_dip|vss_link_m1|vss_x1|vss_x2|vss_x3
+ 33.3818539549
* device instance g_vss_m1_inv_clk_vss_inv_mc_vss_inv_q_vss_mph_g_nand_m_vss_nand_s2_vss_s1_vss_m1_s2_vss_m1_s3_vss_m1_s4_vss_m1_sb_vss_sr1_vss_sr2_vss_sr3_vss_sr4_vss_sv_vss_tg_d_vss_tg_fbm_vss_tg_fbs_vss_tg_s_vss_vss_vss_link_vss_link_bridge_vss_link_dip_vss_link_m1_vss_x1_vss_x2_vss_x3_t211 r0 *1 0,0
Rg_vss_m1_inv_clk_vss_inv_mc_vss_inv_q_vss_mph_g_nand_m_vss_nand_s2_vss_s1_vss_m1_s2_vss_m1_s3_vss_m1_s4_vss_m1_sb_vss_sr1_vss_sr2_vss_sr3_vss_sr4_vss_sv_vss_tg_d_vss_tg_fbm_vss_tg_fbs_vss_tg_s_vss_vss_vss_link_vss_link_bridge_vss_link_dip_vss_link_m1_vss_x1_vss_x2_vss_x3_t211
+ g_vss_m1|inv_clk_vss|inv_mc_vss|inv_q_vss|mph_g|nand_m_vss|nand_s2_vss|s1_vss_m1|s2_vss_m1|s3_vss_m1|s4_vss_m1|sb_vss|sr1_vss|sr2_vss|sr3_vss|sr4_vss|sv_vss|tg_d_vss|tg_fbm_vss|tg_fbs_vss|tg_s_vss|vss|vss_link|vss_link_bridge|vss_link_dip|vss_link_m1|vss_x1|vss_x2|vss_x3__t211
+ g_vss_m1|inv_clk_vss|inv_mc_vss|inv_q_vss|mph_g|nand_m_vss|nand_s2_vss|s1_vss_m1|s2_vss_m1|s3_vss_m1|s4_vss_m1|sb_vss|sr1_vss|sr2_vss|sr3_vss|sr4_vss|sv_vss|tg_d_vss|tg_fbm_vss|tg_fbs_vss|tg_s_vss|vss|vss_link|vss_link_bridge|vss_link_dip|vss_link_m1|vss_x1|vss_x2|vss_x3
+ 52.6893944264
* device instance g_vss_m1_inv_clk_vss_inv_mc_vss_inv_q_vss_mph_g_nand_m_vss_nand_s2_vss_s1_vss_m1_s2_vss_m1_s3_vss_m1_s4_vss_m1_sb_vss_sr1_vss_sr2_vss_sr3_vss_sr4_vss_sv_vss_tg_d_vss_tg_fbm_vss_tg_fbs_vss_tg_s_vss_vss_vss_link_vss_link_bridge_vss_link_dip_vss_link_m1_vss_x1_vss_x2_vss_x3_t212 r0 *1 0,0
Rg_vss_m1_inv_clk_vss_inv_mc_vss_inv_q_vss_mph_g_nand_m_vss_nand_s2_vss_s1_vss_m1_s2_vss_m1_s3_vss_m1_s4_vss_m1_sb_vss_sr1_vss_sr2_vss_sr3_vss_sr4_vss_sv_vss_tg_d_vss_tg_fbm_vss_tg_fbs_vss_tg_s_vss_vss_vss_link_vss_link_bridge_vss_link_dip_vss_link_m1_vss_x1_vss_x2_vss_x3_t212
+ g_vss_m1|inv_clk_vss|inv_mc_vss|inv_q_vss|mph_g|nand_m_vss|nand_s2_vss|s1_vss_m1|s2_vss_m1|s3_vss_m1|s4_vss_m1|sb_vss|sr1_vss|sr2_vss|sr3_vss|sr4_vss|sv_vss|tg_d_vss|tg_fbm_vss|tg_fbs_vss|tg_s_vss|vss|vss_link|vss_link_bridge|vss_link_dip|vss_link_m1|vss_x1|vss_x2|vss_x3__t212
+ g_vss_m1|inv_clk_vss|inv_mc_vss|inv_q_vss|mph_g|nand_m_vss|nand_s2_vss|s1_vss_m1|s2_vss_m1|s3_vss_m1|s4_vss_m1|sb_vss|sr1_vss|sr2_vss|sr3_vss|sr4_vss|sv_vss|tg_d_vss|tg_fbm_vss|tg_fbs_vss|tg_s_vss|vss|vss_link|vss_link_bridge|vss_link_dip|vss_link_m1|vss_x1|vss_x2|vss_x3
+ 73.9163842563
* device instance g_vss_m1_inv_clk_vss_inv_mc_vss_inv_q_vss_mph_g_nand_m_vss_nand_s2_vss_s1_vss_m1_s2_vss_m1_s3_vss_m1_s4_vss_m1_sb_vss_sr1_vss_sr2_vss_sr3_vss_sr4_vss_sv_vss_tg_d_vss_tg_fbm_vss_tg_fbs_vss_tg_s_vss_vss_vss_link_vss_link_bridge_vss_link_dip_vss_link_m1_vss_x1_vss_x2_vss_x3_t213 r0 *1 0,0
Rg_vss_m1_inv_clk_vss_inv_mc_vss_inv_q_vss_mph_g_nand_m_vss_nand_s2_vss_s1_vss_m1_s2_vss_m1_s3_vss_m1_s4_vss_m1_sb_vss_sr1_vss_sr2_vss_sr3_vss_sr4_vss_sv_vss_tg_d_vss_tg_fbm_vss_tg_fbs_vss_tg_s_vss_vss_vss_link_vss_link_bridge_vss_link_dip_vss_link_m1_vss_x1_vss_x2_vss_x3_t213
+ g_vss_m1|inv_clk_vss|inv_mc_vss|inv_q_vss|mph_g|nand_m_vss|nand_s2_vss|s1_vss_m1|s2_vss_m1|s3_vss_m1|s4_vss_m1|sb_vss|sr1_vss|sr2_vss|sr3_vss|sr4_vss|sv_vss|tg_d_vss|tg_fbm_vss|tg_fbs_vss|tg_s_vss|vss|vss_link|vss_link_bridge|vss_link_dip|vss_link_m1|vss_x1|vss_x2|vss_x3__t213
+ g_vss_m1|inv_clk_vss|inv_mc_vss|inv_q_vss|mph_g|nand_m_vss|nand_s2_vss|s1_vss_m1|s2_vss_m1|s3_vss_m1|s4_vss_m1|sb_vss|sr1_vss|sr2_vss|sr3_vss|sr4_vss|sv_vss|tg_d_vss|tg_fbm_vss|tg_fbs_vss|tg_s_vss|vss|vss_link|vss_link_bridge|vss_link_dip|vss_link_m1|vss_x1|vss_x2|vss_x3
+ 131.944150749
* device instance g_vss_m1_inv_clk_vss_inv_mc_vss_inv_q_vss_mph_g_nand_m_vss_nand_s2_vss_s1_vss_m1_s2_vss_m1_s3_vss_m1_s4_vss_m1_sb_vss_sr1_vss_sr2_vss_sr3_vss_sr4_vss_sv_vss_tg_d_vss_tg_fbm_vss_tg_fbs_vss_tg_s_vss_vss_vss_link_vss_link_bridge_vss_link_dip_vss_link_m1_vss_x1_vss_x2_vss_x3_t214 r0 *1 0,0
Rg_vss_m1_inv_clk_vss_inv_mc_vss_inv_q_vss_mph_g_nand_m_vss_nand_s2_vss_s1_vss_m1_s2_vss_m1_s3_vss_m1_s4_vss_m1_sb_vss_sr1_vss_sr2_vss_sr3_vss_sr4_vss_sv_vss_tg_d_vss_tg_fbm_vss_tg_fbs_vss_tg_s_vss_vss_vss_link_vss_link_bridge_vss_link_dip_vss_link_m1_vss_x1_vss_x2_vss_x3_t214
+ g_vss_m1|inv_clk_vss|inv_mc_vss|inv_q_vss|mph_g|nand_m_vss|nand_s2_vss|s1_vss_m1|s2_vss_m1|s3_vss_m1|s4_vss_m1|sb_vss|sr1_vss|sr2_vss|sr3_vss|sr4_vss|sv_vss|tg_d_vss|tg_fbm_vss|tg_fbs_vss|tg_s_vss|vss|vss_link|vss_link_bridge|vss_link_dip|vss_link_m1|vss_x1|vss_x2|vss_x3__t214
+ g_vss_m1|inv_clk_vss|inv_mc_vss|inv_q_vss|mph_g|nand_m_vss|nand_s2_vss|s1_vss_m1|s2_vss_m1|s3_vss_m1|s4_vss_m1|sb_vss|sr1_vss|sr2_vss|sr3_vss|sr4_vss|sv_vss|tg_d_vss|tg_fbm_vss|tg_fbs_vss|tg_s_vss|vss|vss_link|vss_link_bridge|vss_link_dip|vss_link_m1|vss_x1|vss_x2|vss_x3
+ 157.41231036
* device instance g_vss_m1_inv_clk_vss_inv_mc_vss_inv_q_vss_mph_g_nand_m_vss_nand_s2_vss_s1_vss_m1_s2_vss_m1_s3_vss_m1_s4_vss_m1_sb_vss_sr1_vss_sr2_vss_sr3_vss_sr4_vss_sv_vss_tg_d_vss_tg_fbm_vss_tg_fbs_vss_tg_s_vss_vss_vss_link_vss_link_bridge_vss_link_dip_vss_link_m1_vss_x1_vss_x2_vss_x3_t215 r0 *1 0,0
Rg_vss_m1_inv_clk_vss_inv_mc_vss_inv_q_vss_mph_g_nand_m_vss_nand_s2_vss_s1_vss_m1_s2_vss_m1_s3_vss_m1_s4_vss_m1_sb_vss_sr1_vss_sr2_vss_sr3_vss_sr4_vss_sv_vss_tg_d_vss_tg_fbm_vss_tg_fbs_vss_tg_s_vss_vss_vss_link_vss_link_bridge_vss_link_dip_vss_link_m1_vss_x1_vss_x2_vss_x3_t215
+ g_vss_m1|inv_clk_vss|inv_mc_vss|inv_q_vss|mph_g|nand_m_vss|nand_s2_vss|s1_vss_m1|s2_vss_m1|s3_vss_m1|s4_vss_m1|sb_vss|sr1_vss|sr2_vss|sr3_vss|sr4_vss|sv_vss|tg_d_vss|tg_fbm_vss|tg_fbs_vss|tg_s_vss|vss|vss_link|vss_link_bridge|vss_link_dip|vss_link_m1|vss_x1|vss_x2|vss_x3__t215
+ g_vss_m1|inv_clk_vss|inv_mc_vss|inv_q_vss|mph_g|nand_m_vss|nand_s2_vss|s1_vss_m1|s2_vss_m1|s3_vss_m1|s4_vss_m1|sb_vss|sr1_vss|sr2_vss|sr3_vss|sr4_vss|sv_vss|tg_d_vss|tg_fbm_vss|tg_fbs_vss|tg_s_vss|vss|vss_link|vss_link_bridge|vss_link_dip|vss_link_m1|vss_x1|vss_x2|vss_x3
+ 179.868735089
* device instance g_vss_m1_inv_clk_vss_inv_mc_vss_inv_q_vss_mph_g_nand_m_vss_nand_s2_vss_s1_vss_m1_s2_vss_m1_s3_vss_m1_s4_vss_m1_sb_vss_sr1_vss_sr2_vss_sr3_vss_sr4_vss_sv_vss_tg_d_vss_tg_fbm_vss_tg_fbs_vss_tg_s_vss_vss_vss_link_vss_link_bridge_vss_link_dip_vss_link_m1_vss_x1_vss_x2_vss_x3_t216 r0 *1 0,0
Rg_vss_m1_inv_clk_vss_inv_mc_vss_inv_q_vss_mph_g_nand_m_vss_nand_s2_vss_s1_vss_m1_s2_vss_m1_s3_vss_m1_s4_vss_m1_sb_vss_sr1_vss_sr2_vss_sr3_vss_sr4_vss_sv_vss_tg_d_vss_tg_fbm_vss_tg_fbs_vss_tg_s_vss_vss_vss_link_vss_link_bridge_vss_link_dip_vss_link_m1_vss_x1_vss_x2_vss_x3_t216
+ g_vss_m1|inv_clk_vss|inv_mc_vss|inv_q_vss|mph_g|nand_m_vss|nand_s2_vss|s1_vss_m1|s2_vss_m1|s3_vss_m1|s4_vss_m1|sb_vss|sr1_vss|sr2_vss|sr3_vss|sr4_vss|sv_vss|tg_d_vss|tg_fbm_vss|tg_fbs_vss|tg_s_vss|vss|vss_link|vss_link_bridge|vss_link_dip|vss_link_m1|vss_x1|vss_x2|vss_x3__t216
+ g_vss_m1|inv_clk_vss|inv_mc_vss|inv_q_vss|mph_g|nand_m_vss|nand_s2_vss|s1_vss_m1|s2_vss_m1|s3_vss_m1|s4_vss_m1|sb_vss|sr1_vss|sr2_vss|sr3_vss|sr4_vss|sv_vss|tg_d_vss|tg_fbm_vss|tg_fbs_vss|tg_s_vss|vss|vss_link|vss_link_bridge|vss_link_dip|vss_link_m1|vss_x1|vss_x2|vss_x3
+ 202.36729908
* device instance g_vss_m1_inv_clk_vss_inv_mc_vss_inv_q_vss_mph_g_nand_m_vss_nand_s2_vss_s1_vss_m1_s2_vss_m1_s3_vss_m1_s4_vss_m1_sb_vss_sr1_vss_sr2_vss_sr3_vss_sr4_vss_sv_vss_tg_d_vss_tg_fbm_vss_tg_fbs_vss_tg_s_vss_vss_vss_link_vss_link_bridge_vss_link_dip_vss_link_m1_vss_x1_vss_x2_vss_x3_t217 r0 *1 0,0
Rg_vss_m1_inv_clk_vss_inv_mc_vss_inv_q_vss_mph_g_nand_m_vss_nand_s2_vss_s1_vss_m1_s2_vss_m1_s3_vss_m1_s4_vss_m1_sb_vss_sr1_vss_sr2_vss_sr3_vss_sr4_vss_sv_vss_tg_d_vss_tg_fbm_vss_tg_fbs_vss_tg_s_vss_vss_vss_link_vss_link_bridge_vss_link_dip_vss_link_m1_vss_x1_vss_x2_vss_x3_t217
+ g_vss_m1|inv_clk_vss|inv_mc_vss|inv_q_vss|mph_g|nand_m_vss|nand_s2_vss|s1_vss_m1|s2_vss_m1|s3_vss_m1|s4_vss_m1|sb_vss|sr1_vss|sr2_vss|sr3_vss|sr4_vss|sv_vss|tg_d_vss|tg_fbm_vss|tg_fbs_vss|tg_s_vss|vss|vss_link|vss_link_bridge|vss_link_dip|vss_link_m1|vss_x1|vss_x2|vss_x3__t217
+ g_vss_m1|inv_clk_vss|inv_mc_vss|inv_q_vss|mph_g|nand_m_vss|nand_s2_vss|s1_vss_m1|s2_vss_m1|s3_vss_m1|s4_vss_m1|sb_vss|sr1_vss|sr2_vss|sr3_vss|sr4_vss|sv_vss|tg_d_vss|tg_fbm_vss|tg_fbs_vss|tg_s_vss|vss|vss_link|vss_link_bridge|vss_link_dip|vss_link_m1|vss_x1|vss_x2|vss_x3
+ 224.895355835
* device instance g_vss_m1_inv_clk_vss_inv_mc_vss_inv_q_vss_mph_g_nand_m_vss_nand_s2_vss_s1_vss_m1_s2_vss_m1_s3_vss_m1_s4_vss_m1_sb_vss_sr1_vss_sr2_vss_sr3_vss_sr4_vss_sv_vss_tg_d_vss_tg_fbm_vss_tg_fbs_vss_tg_s_vss_vss_vss_link_vss_link_bridge_vss_link_dip_vss_link_m1_vss_x1_vss_x2_vss_x3 r0 *1 0,0
Cg_vss_m1_inv_clk_vss_inv_mc_vss_inv_q_vss_mph_g_nand_m_vss_nand_s2_vss_s1_vss_m1_s2_vss_m1_s3_vss_m1_s4_vss_m1_sb_vss_sr1_vss_sr2_vss_sr3_vss_sr4_vss_sv_vss_tg_d_vss_tg_fbm_vss_tg_fbs_vss_tg_s_vss_vss_vss_link_vss_link_bridge_vss_link_dip_vss_link_m1_vss_x1_vss_x2_vss_x3
+ g_vss_m1|inv_clk_vss|inv_mc_vss|inv_q_vss|mph_g|nand_m_vss|nand_s2_vss|s1_vss_m1|s2_vss_m1|s3_vss_m1|s4_vss_m1|sb_vss|sr1_vss|sr2_vss|sr3_vss|sr4_vss|sv_vss|tg_d_vss|tg_fbm_vss|tg_fbs_vss|tg_s_vss|vss|vss_link|vss_link_bridge|vss_link_dip|vss_link_m1|vss_x1|vss_x2|vss_x3
+ vsubs 1.89378194e-13
* device instance mid_t0 r0 *1 0,0
Rmid_t0 mid__t0 mid 149.893184895
* device instance mid_t1 r0 *1 0,0
Rmid_t1 mid__t1 mid 180.889615105
* device instance mid_t2 r0 *1 0,0
Rmid_t2 mid__t2 mid 149.893184895
* device instance mid_t3 r0 *1 0,0
Rmid_t3 mid__t3 mid 180.889615105
* device instance mid r0 *1 0,0
Cmid mid vsubs 1.103314e-15
* device instance mid_dup1_t0 r0 *1 0,0
Rmid_dup1_t0 mid__t02 mid$1 149.893184895
* device instance mid_dup1_t1 r0 *1 0,0
Rmid_dup1_t1 mid__t12 mid$1 180.889615105
* device instance mid_dup1_t2 r0 *1 0,0
Rmid_dup1_t2 mid__t22 mid$1 180.889615105
* device instance mid_dup1_t3 r0 *1 0,0
Rmid_dup1_t3 mid__t32 mid$1 149.893184895
* device instance mid_dup1 r0 *1 0,0
Cmid_dup1 mid$1 vsubs 1.101742e-15
* device instance mid_dup2_t0 r0 *1 0,0
Rmid_dup2_t0 mid__t03 mid$2 149.893184895
* device instance mid_dup2_t1 r0 *1 0,0
Rmid_dup2_t1 mid__t13 mid$2 180.889615105
* device instance mid_dup2_t2 r0 *1 0,0
Rmid_dup2_t2 mid__t23 mid$2 180.889615105
* device instance mid_dup2_t3 r0 *1 0,0
Rmid_dup2_t3 mid__t33 mid$2 149.893184895
* device instance mid_dup2 r0 *1 0,0
Cmid_dup2 mid$2 vsubs 1.101742e-15
* device instance mpa_py_mpb_py_mph_py_py_t0 r0 *1 0,0
Rmpa_py_mpb_py_mph_py_py_t0 mpa_py|mpb_py|mph_py|py__t0 mpa_py|mpb_py|mph_py|py
+ 33.64835
* device instance mpa_py_mpb_py_mph_py_py_t1 r0 *1 0,0
Rmpa_py_mpb_py_mph_py_py_t1 mpa_py|mpb_py|mph_py|py__t1 mpa_py|mpb_py|mph_py|py
+ 28.4095054715
* device instance mpa_py_mpb_py_mph_py_py_t2 r0 *1 0,0
Rmpa_py_mpb_py_mph_py_py_t2 mpa_py|mpb_py|mph_py|py__t2 mpa_py|mpb_py|mph_py|py
+ 5.23884452847
* device instance mpa_py_mpb_py_mph_py_py r0 *1 0,0
Cmpa_py_mpb_py_mph_py_py mpa_py|mpb_py|mph_py|py vsubs 7.94002e-16
* device instance mpa_py_mpb_py_mph_py_py_dup1_t0 r0 *1 0,0
Rmpa_py_mpb_py_mph_py_py_dup1_t0 mpa_py|mpb_py|mph_py|py__t02
+ mpa_py|mpb_py|mph_py|py$1 33.9531
* device instance mpa_py_mpb_py_mph_py_py_dup1_t1 r0 *1 0,0
Rmpa_py_mpb_py_mph_py_py_dup1_t1 mpa_py|mpb_py|mph_py|py__t12
+ mpa_py|mpb_py|mph_py|py$1 28.6668077402
* device instance mpa_py_mpb_py_mph_py_py_dup1_t2 r0 *1 0,0
Rmpa_py_mpb_py_mph_py_py_dup1_t2 mpa_py|mpb_py|mph_py|py__t22
+ mpa_py|mpb_py|mph_py|py$1 5.28629225979
* device instance mpa_py_mpb_py_mph_py_py_dup1 r0 *1 0,0
Cmpa_py_mpb_py_mph_py_py_dup1 mpa_py|mpb_py|mph_py|py$1 vsubs 7.95941e-16
* device instance mpa_py_mpb_py_mph_py_py_dup2_t0 r0 *1 0,0
Rmpa_py_mpb_py_mph_py_py_dup2_t0 mpa_py|mpb_py|mph_py|py__t03
+ mpa_py|mpb_py|mph_py|py$2 34.25785
* device instance mpa_py_mpb_py_mph_py_py_dup2_t1 r0 *1 0,0
Rmpa_py_mpb_py_mph_py_py_dup2_t1 mpa_py|mpb_py|mph_py|py__t13
+ mpa_py|mpb_py|mph_py|py$2 28.9241100089
* device instance mpa_py_mpb_py_mph_py_py_dup2_t2 r0 *1 0,0
Rmpa_py_mpb_py_mph_py_py_dup2_t2 mpa_py|mpb_py|mph_py|py__t23
+ mpa_py|mpb_py|mph_py|py$2 5.3337399911
* device instance mpa_py_mpb_py_mph_py_py_dup2 r0 *1 0,0
Cmpa_py_mpb_py_mph_py_py_dup2 mpa_py|mpb_py|mph_py|py$2 vsubs 7.9788e-16
* device instance mpa_py_mpb_py_mph_py_py_dup3_t0 r0 *1 0,0
Rmpa_py_mpb_py_mph_py_py_dup3_t0 mpa_py|mpb_py|mph_py|py__t04
+ mpa_py|mpb_py|mph_py|py$3 34.5626
* device instance mpa_py_mpb_py_mph_py_py_dup3_t1 r0 *1 0,0
Rmpa_py_mpb_py_mph_py_py_dup3_t1 mpa_py|mpb_py|mph_py|py__t14
+ mpa_py|mpb_py|mph_py|py$3 29.1814122776
* device instance mpa_py_mpb_py_mph_py_py_dup3_t2 r0 *1 0,0
Rmpa_py_mpb_py_mph_py_py_dup3_t2 mpa_py|mpb_py|mph_py|py__t24
+ mpa_py|mpb_py|mph_py|py$3 5.38118772242
* device instance mpa_py_mpb_py_mph_py_py_dup3 r0 *1 0,0
Cmpa_py_mpb_py_mph_py_py_dup3 mpa_py|mpb_py|mph_py|py$3 vsubs 7.99818e-16
* device instance ny_t0 r0 *1 0,0
Rny_t0 ny__t0 ny 53.0227
* device instance ny_t1 r0 *1 0,0
Rny_t1 ny__t1 ny 53.0227
* device instance ny r0 *1 0,0
Cny ny vsubs 2.33681e-16
* device instance ny_dup1_t0 r0 *1 0,0
Rny_dup1_t0 ny__t02 ny$1 50.4787
* device instance ny_dup1_t1 r0 *1 0,0
Rny_dup1_t1 ny__t12 ny$1 50.4787
* device instance ny_dup1 r0 *1 0,0
Cny_dup1 ny$1 vsubs 1.89586e-16
* device instance ny_dup2_t0 r0 *1 0,0
Rny_dup2_t0 ny__t03 ny$2 50.4787
* device instance ny_dup2_t1 r0 *1 0,0
Rny_dup2_t1 ny__t13 ny$2 50.4787
* device instance ny_dup2 r0 *1 0,0
Cny_dup2 ny$2 vsubs 1.89586e-16
* device instance ny_dup3_t0 r0 *1 0,0
Rny_dup3_t0 ny__t04 ny$3 50.4787
* device instance ny_dup3_t1 r0 *1 0,0
Rny_dup3_t1 ny__t14 ny$3 50.4787
* device instance ny_dup3 r0 *1 0,0
Cny_dup3 ny$3 vsubs 1.89586e-16
* device instance ny_dup4_t0 r0 *1 0,0
Rny_dup4_t0 ny__t05 ny$4 50.4787
* device instance ny_dup4_t1 r0 *1 0,0
Rny_dup4_t1 ny__t15 ny$4 50.4787
* device instance ny_dup4 r0 *1 0,0
Cny_dup4 ny$4 vsubs 1.89586e-16
* device instance ny_dup5_t0 r0 *1 0,0
Rny_dup5_t0 ny__t06 ny$5 53.185
* device instance ny_dup5_t1 r0 *1 0,0
Rny_dup5_t1 ny__t16 ny$5 53.185
* device instance ny_dup5 r0 *1 0,0
Cny_dup5 ny$5 vsubs 2.3562e-16
* device instance ny_dup6_t0 r0 *1 0,0
Rny_dup6_t0 ny__t07 ny$6 50.51025
* device instance ny_dup6_t1 r0 *1 0,0
Rny_dup6_t1 ny__t17 ny$6 50.51025
* device instance ny_dup6 r0 *1 0,0
Cny_dup6 ny$6 vsubs 1.91525e-16
* device instance ny_dup7_t0 r0 *1 0,0
Rny_dup7_t0 ny__t08 ny$7 50.51025
* device instance ny_dup7_t1 r0 *1 0,0
Rny_dup7_t1 ny__t18 ny$7 50.51025
* device instance ny_dup7 r0 *1 0,0
Cny_dup7 ny$7 vsubs 1.91525e-16
* device instance ny_dup8_t0 r0 *1 0,0
Rny_dup8_t0 ny__t09 ny$8 50.51025
* device instance ny_dup8_t1 r0 *1 0,0
Rny_dup8_t1 ny__t19 ny$8 50.51025
* device instance ny_dup8 r0 *1 0,0
Cny_dup8 ny$8 vsubs 1.91525e-16
* device instance ny_dup9_t0 r0 *1 0,0
Rny_dup9_t0 ny__t010 ny$9 50.51025
* device instance ny_dup9_t1 r0 *1 0,0
Rny_dup9_t1 ny__t110 ny$9 50.51025
* device instance ny_dup9 r0 *1 0,0
Cny_dup9 ny$9 vsubs 1.91525e-16
* device instance ny_dup10_t0 r0 *1 0,0
Rny_dup10_t0 ny__t011 ny$10 53.351
* device instance ny_dup10_t1 r0 *1 0,0
Rny_dup10_t1 ny__t111 ny$10 53.351
* device instance ny_dup10 r0 *1 0,0
Cny_dup10 ny$10 vsubs 2.37559e-16
* device instance ny_dup11_t0 r0 *1 0,0
Rny_dup11_t0 ny__t012 ny$11 50.5516
* device instance ny_dup11_t1 r0 *1 0,0
Rny_dup11_t1 ny__t112 ny$11 50.5516
* device instance ny_dup11 r0 *1 0,0
Cny_dup11 ny$11 vsubs 1.93464e-16
* device instance ny_dup12_t0 r0 *1 0,0
Rny_dup12_t0 ny__t013 ny$12 50.5516
* device instance ny_dup12_t1 r0 *1 0,0
Rny_dup12_t1 ny__t113 ny$12 50.5516
* device instance ny_dup12 r0 *1 0,0
Cny_dup12 ny$12 vsubs 1.93464e-16
* device instance ny_dup13_t0 r0 *1 0,0
Rny_dup13_t0 ny__t014 ny$13 50.5516
* device instance ny_dup13_t1 r0 *1 0,0
Rny_dup13_t1 ny__t114 ny$13 50.5516
* device instance ny_dup13 r0 *1 0,0
Cny_dup13 ny$13 vsubs 1.93464e-16
* device instance ny_dup14_t0 r0 *1 0,0
Rny_dup14_t0 ny__t015 ny$14 50.5516
* device instance ny_dup14_t1 r0 *1 0,0
Rny_dup14_t1 ny__t115 ny$14 50.5516
* device instance ny_dup14 r0 *1 0,0
Cny_dup14 ny$14 vsubs 1.93464e-16
* device instance ny_dup15_t0 r0 *1 0,0
Rny_dup15_t0 ny__t016 ny$15 53.52065
* device instance ny_dup15_t1 r0 *1 0,0
Rny_dup15_t1 ny__t116 ny$15 53.52065
* device instance ny_dup15 r0 *1 0,0
Cny_dup15 ny$15 vsubs 2.39497e-16
* device instance ny_dup16_t0 r0 *1 0,0
Rny_dup16_t0 ny__t017 ny$16 50.6022
* device instance ny_dup16_t1 r0 *1 0,0
Rny_dup16_t1 ny__t117 ny$16 50.6022
* device instance ny_dup16 r0 *1 0,0
Cny_dup16 ny$16 vsubs 1.95403e-16
* device instance ny_dup17_t0 r0 *1 0,0
Rny_dup17_t0 ny__t018 ny$17 50.6022
* device instance ny_dup17_t1 r0 *1 0,0
Rny_dup17_t1 ny__t118 ny$17 50.6022
* device instance ny_dup17 r0 *1 0,0
Cny_dup17 ny$17 vsubs 1.95403e-16
* device instance ny_dup18_t0 r0 *1 0,0
Rny_dup18_t0 ny__t019 ny$18 50.6022
* device instance ny_dup18_t1 r0 *1 0,0
Rny_dup18_t1 ny__t119 ny$18 50.6022
* device instance ny_dup18 r0 *1 0,0
Cny_dup18 ny$18 vsubs 1.95403e-16
* device instance ny_dup19_t0 r0 *1 0,0
Rny_dup19_t0 ny__t020 ny$19 50.6022
* device instance ny_dup19_t1 r0 *1 0,0
Rny_dup19_t1 ny__t120 ny$19 50.6022
* device instance ny_dup19 r0 *1 0,0
Cny_dup19 ny$19 vsubs 1.95403e-16
* device instance py_t0 r0 *1 0,0
Rpy_t0 py__t0 py 37.6683
* device instance py_t1 r0 *1 0,0
Rpy_t1 py__t1 py 37.6683
* device instance py r0 *1 0,0
Cpy py vsubs 1.9321e-16
* device instance py_dup1_t0 r0 *1 0,0
Rpy_dup1_t0 py__t02 py$1 37.6683
* device instance py_dup1_t1 r0 *1 0,0
Rpy_dup1_t1 py__t12 py$1 37.6683
* device instance py_dup1 r0 *1 0,0
Cpy_dup1 py$1 vsubs 1.9321e-16
* device instance py_dup2_t0 r0 *1 0,0
Rpy_dup2_t0 py__t03 py$2 37.6683
* device instance py_dup2_t1 r0 *1 0,0
Rpy_dup2_t1 py__t13 py$2 37.6683
* device instance py_dup2 r0 *1 0,0
Cpy_dup2 py$2 vsubs 1.9321e-16
* device instance py_dup3_t0 r0 *1 0,0
Rpy_dup3_t0 py__t04 py$3 37.6683
* device instance py_dup3_t1 r0 *1 0,0
Rpy_dup3_t1 py__t14 py$3 37.6683
* device instance py_dup3 r0 *1 0,0
Cpy_dup3 py$3 vsubs 1.9321e-16
* device instance py_dup4_t0 r0 *1 0,0
Rpy_dup4_t0 py__t05 py$4 37.875
* device instance py_dup4_t1 r0 *1 0,0
Rpy_dup4_t1 py__t15 py$4 37.875
* device instance py_dup4 r0 *1 0,0
Cpy_dup4 py$4 vsubs 1.95101e-16
* device instance py_dup5_t0 r0 *1 0,0
Rpy_dup5_t0 py__t06 py$5 37.875
* device instance py_dup5_t1 r0 *1 0,0
Rpy_dup5_t1 py__t16 py$5 37.875
* device instance py_dup5 r0 *1 0,0
Cpy_dup5 py$5 vsubs 1.95101e-16
* device instance py_dup6_t0 r0 *1 0,0
Rpy_dup6_t0 py__t07 py$6 37.875
* device instance py_dup6_t1 r0 *1 0,0
Rpy_dup6_t1 py__t17 py$6 37.875
* device instance py_dup6 r0 *1 0,0
Cpy_dup6 py$6 vsubs 1.95101e-16
* device instance py_dup7_t0 r0 *1 0,0
Rpy_dup7_t0 py__t08 py$7 37.875
* device instance py_dup7_t1 r0 *1 0,0
Rpy_dup7_t1 py__t18 py$7 37.875
* device instance py_dup7 r0 *1 0,0
Cpy_dup7 py$7 vsubs 1.95101e-16
* device instance py_dup8_t0 r0 *1 0,0
Rpy_dup8_t0 py__t09 py$8 38.0848
* device instance py_dup8_t1 r0 *1 0,0
Rpy_dup8_t1 py__t19 py$8 38.0848
* device instance py_dup8 r0 *1 0,0
Cpy_dup8 py$8 vsubs 1.96992e-16
* device instance py_dup9_t0 r0 *1 0,0
Rpy_dup9_t0 py__t010 py$9 38.0848
* device instance py_dup9_t1 r0 *1 0,0
Rpy_dup9_t1 py__t110 py$9 38.0848
* device instance py_dup9 r0 *1 0,0
Cpy_dup9 py$9 vsubs 1.96992e-16
* device instance py_dup10_t0 r0 *1 0,0
Rpy_dup10_t0 py__t011 py$10 38.0848
* device instance py_dup10_t1 r0 *1 0,0
Rpy_dup10_t1 py__t111 py$10 38.0848
* device instance py_dup10 r0 *1 0,0
Cpy_dup10 py$10 vsubs 1.96992e-16
* device instance py_dup11_t0 r0 *1 0,0
Rpy_dup11_t0 py__t012 py$11 38.0848
* device instance py_dup11_t1 r0 *1 0,0
Rpy_dup11_t1 py__t112 py$11 38.0848
* device instance py_dup11 r0 *1 0,0
Cpy_dup11 py$11 vsubs 1.96992e-16
* device instance py_dup12_t0 r0 *1 0,0
Rpy_dup12_t0 py__t013 py$12 38.29745
* device instance py_dup12_t1 r0 *1 0,0
Rpy_dup12_t1 py__t113 py$12 38.29745
* device instance py_dup12 r0 *1 0,0
Cpy_dup12 py$12 vsubs 1.98882e-16
* device instance py_dup13_t0 r0 *1 0,0
Rpy_dup13_t0 py__t014 py$13 38.29745
* device instance py_dup13_t1 r0 *1 0,0
Rpy_dup13_t1 py__t114 py$13 38.29745
* device instance py_dup13 r0 *1 0,0
Cpy_dup13 py$13 vsubs 1.98882e-16
* device instance py_dup14_t0 r0 *1 0,0
Rpy_dup14_t0 py__t015 py$14 38.29745
* device instance py_dup14_t1 r0 *1 0,0
Rpy_dup14_t1 py__t115 py$14 38.29745
* device instance py_dup14 r0 *1 0,0
Cpy_dup14 py$14 vsubs 1.98882e-16
* device instance py_dup15_t0 r0 *1 0,0
Rpy_dup15_t0 py__t016 py$15 38.29745
* device instance py_dup15_t1 r0 *1 0,0
Rpy_dup15_t1 py__t116 py$15 38.29745
* device instance py_dup15 r0 *1 0,0
Cpy_dup15 py$15 vsubs 1.98882e-16
* device instance cc_a_b_b3_invb_a_mn12_g1_mp24_g0_t2_y_a_d_inva_a_mn12_g0_mp13_g0_ro3_ro3_esc_e_ro3_esc_w_ro3_hop_sr3_d_stub_tg_d_a_y r0 *1 0,0
Ccc_a_b_b3_invb_a_mn12_g1_mp24_g0_t2_y_a_d_inva_a_mn12_g0_mp13_g0_ro3_ro3_esc_e_ro3_esc_w_ro3_hop_sr3_d_stub_tg_d_a_y
+ a|b|b3|invb_a|mn12_g1|mp24_g0|t2|y
+ a|d|inva_a|mn12_g0|mp13_g0|ro3|ro3_esc_e|ro3_esc_w|ro3_hop|sr3_d_stub|tg_d_a|y
+ 3.3e-18
* device instance cc_a_b_b3_invb_a_mn12_g1_mp24_g0_t2_y_a_d_sb_d_stub_tg_d_a_xo_xo_dip_xo_hop_xo_stub_y r0 *1 0,0
Ccc_a_b_b3_invb_a_mn12_g1_mp24_g0_t2_y_a_d_sb_d_stub_tg_d_a_xo_xo_dip_xo_hop_xo_stub_y
+ a|b|b3|invb_a|mn12_g1|mp24_g0|t2|y
+ a|d|sb_d_stub|tg_d_a|xo|xo_dip|xo_hop|xo_stub|y 3.869e-18
* device instance cc_a_b_b3_invb_a_mn12_g1_mp24_g0_t2_y_a_inva_a_mn12_g0_mp13_g0_t1_y r0 *1 0,0
Ccc_a_b_b3_invb_a_mn12_g1_mp24_g0_t2_y_a_inva_a_mn12_g0_mp13_g0_t1_y
+ a|b|b3|invb_a|mn12_g1|mp24_g0|t2|y a|inva_a|mn12_g0|mp13_g0|t1|y 3.869e-18
* device instance cc_a_b_b3_invb_a_mn12_g1_mp24_g0_t2_y_an_inva_y_mn34_g0_mp13_g1_y r0 *1 0,0
Ccc_a_b_b3_invb_a_mn12_g1_mp24_g0_t2_y_an_inva_y_mn34_g0_mp13_g1_y
+ a|b|b3|invb_a|mn12_g1|mp24_g0|t2|y an|inva_y|mn34_g0|mp13_g1|y$2 3.3e-18
* device instance cc_a_b_b3_invb_a_mn12_g1_mp24_g0_t2_y_bn_invb_y_mn34_g1_mp24_g1_y r0 *1 0,0
Ccc_a_b_b3_invb_a_mn12_g1_mp24_g0_t2_y_bn_invb_y_mn34_g1_mp24_g1_y
+ a|b|b3|invb_a|mn12_g1|mp24_g0|t2|y bn|invb_y|mn34_g1|mp24_g1|y$2 1.377e-17
* device instance cc_a_b_b3_invb_a_mn12_g1_mp24_g0_t2_y_g_vss_m1_inv_clk_vss_inv_mc_vss_inv_q_vss_mph_g_nand_m_vss_nand_s2_vss_s1_vss_m1_s2_vss_m1_s3_vss_m1_s4_vss_m1_sb_vss_sr1_vss_sr2_vss_sr3_vss_sr4_vss_sv_vss_tg_d_vss_tg_fbm_vss_tg_fbs_vss_tg_s_vss_vss_vss_link_vss_link_bridge_vss_link_dip_vss_link_m1_vss_x1_vss_x2_vss_x3 r0 *1 0,0
Ccc_a_b_b3_invb_a_mn12_g1_mp24_g0_t2_y_g_vss_m1_inv_clk_vss_inv_mc_vss_inv_q_vss_mph_g_nand_m_vss_nand_s2_vss_s1_vss_m1_s2_vss_m1_s3_vss_m1_s4_vss_m1_sb_vss_sr1_vss_sr2_vss_sr3_vss_sr4_vss_sv_vss_tg_d_vss_tg_fbm_vss_tg_fbs_vss_tg_s_vss_vss_vss_link_vss_link_bridge_vss_link_dip_vss_link_m1_vss_x1_vss_x2_vss_x3
+ a|b|b3|invb_a|mn12_g1|mp24_g0|t2|y
+ g_vss_m1|inv_clk_vss|inv_mc_vss|inv_q_vss|mph_g|nand_m_vss|nand_s2_vss|s1_vss_m1|s2_vss_m1|s3_vss_m1|s4_vss_m1|sb_vss|sr1_vss|sr2_vss|sr3_vss|sr4_vss|sv_vss|tg_d_vss|tg_fbm_vss|tg_fbs_vss|tg_s_vss|vss|vss_link|vss_link_bridge|vss_link_dip|vss_link_m1|vss_x1|vss_x2|vss_x3
+ 7.354e-18
* device instance cc_a_b_b3_invb_a_mn12_g1_mp24_g0_t2_y_mid r0 *1 0,0
Ccc_a_b_b3_invb_a_mn12_g1_mp24_g0_t2_y_mid a|b|b3|invb_a|mn12_g1|mp24_g0|t2|y
+ mid$2 8.154e-18
* device instance cc_a_b_d_invb_a_mn12_g1_mp24_g0_ro2_ro2_esc_sr2_d_stub_tg_d_a_y_a_b_m_east_m_west_nand_m_a_nand_m_a_ext_via_nand_m_a_ext_via2_nand_m_a_stub_tg_d_b_tg_d_b_via_tg_d_b_via2_tg_fbm_b_tg_fbm_b_alt_via_tg_fbm_b_alt_via2 r0 *1 0,0
Ccc_a_b_d_invb_a_mn12_g1_mp24_g0_ro2_ro2_esc_sr2_d_stub_tg_d_a_y_a_b_m_east_m_west_nand_m_a_nand_m_a_ext_via_nand_m_a_ext_via2_nand_m_a_stub_tg_d_b_tg_d_b_via_tg_d_b_via2_tg_fbm_b_tg_fbm_b_alt_via_tg_fbm_b_alt_via2
+ a|b|d|invb_a|mn12_g1|mp24_g0|ro2|ro2_esc|sr2_d_stub|tg_d_a|y
+ a|b|m_east|m_west|nand_m_a|nand_m_a_ext_via|nand_m_a_ext_via2|nand_m_a_stub|tg_d_b|tg_d_b_via|tg_d_b_via2|tg_fbm_b|tg_fbm_b_alt_via|tg_fbm_b_alt_via2$5
+ 3.869e-18
* device instance cc_a_b_d_invb_a_mn12_g1_mp24_g0_ro2_ro2_esc_sr2_d_stub_tg_d_a_y_a_d_inv_clk_vdd_inv_mc_vdd_inv_q_vdd_mpa_py_mpb_py_nand_m_vdd_nand_s2_vdd_nwell_vdd_sb_vdd_sr1_vdd_sr2_vdd_sr3_vdd_sr4_vdd_sv_d_vdd_tie_sv_vdd_tg_d_a_tg_d_vdd_tg_fbm_vdd_tg_fbs_vdd_tg_s_vdd_vdd_vdd_b1_vdd_b2_vdd_b3_vdd_b4_vdd_link_vdd_link_dip_vdd_x1_vdd_x2_vdd_x3 r0 *1 0,0
Ccc_a_b_d_invb_a_mn12_g1_mp24_g0_ro2_ro2_esc_sr2_d_stub_tg_d_a_y_a_d_inv_clk_vdd_inv_mc_vdd_inv_q_vdd_mpa_py_mpb_py_nand_m_vdd_nand_s2_vdd_nwell_vdd_sb_vdd_sr1_vdd_sr2_vdd_sr3_vdd_sr4_vdd_sv_d_vdd_tie_sv_vdd_tg_d_a_tg_d_vdd_tg_fbm_vdd_tg_fbs_vdd_tg_s_vdd_vdd_vdd_b1_vdd_b2_vdd_b3_vdd_b4_vdd_link_vdd_link_dip_vdd_x1_vdd_x2_vdd_x3
+ a|b|d|invb_a|mn12_g1|mp24_g0|ro2|ro2_esc|sr2_d_stub|tg_d_a|y
+ a|d|inv_clk_vdd|inv_mc_vdd|inv_q_vdd|mpa_py|mpb_py|nand_m_vdd|nand_s2_vdd|nwell_vdd|sb_vdd|sr1_vdd|sr2_vdd|sr3_vdd|sr4_vdd|sv_d_vdd_tie|sv_vdd|tg_d_a|tg_d_vdd|tg_fbm_vdd|tg_fbs_vdd|tg_s_vdd|vdd|vdd_b1|vdd_b2|vdd_b3|vdd_b4|vdd_link|vdd_link_dip|vdd_x1|vdd_x2|vdd_x3
+ 2.2984e-17
* device instance cc_a_b_d_invb_a_mn12_g1_mp24_g0_ro2_ro2_esc_sr2_d_stub_tg_d_a_y_a_d_inva_a_mn12_g0_mp13_g0_ro1_ro1_esc_sr1_d_stub_tg_d_a_y r0 *1 0,0
Ccc_a_b_d_invb_a_mn12_g1_mp24_g0_ro2_ro2_esc_sr2_d_stub_tg_d_a_y_a_d_inva_a_mn12_g0_mp13_g0_ro1_ro1_esc_sr1_d_stub_tg_d_a_y
+ a|b|d|invb_a|mn12_g1|mp24_g0|ro2|ro2_esc|sr2_d_stub|tg_d_a|y
+ a|d|inva_a|mn12_g0|mp13_g0|ro1|ro1_esc|sr1_d_stub|tg_d_a|y 3.869e-18
* device instance cc_a_b_d_invb_a_mn12_g1_mp24_g0_ro2_ro2_esc_sr2_d_stub_tg_d_a_y_a_d_inva_a_mn12_g0_mp13_g0_ro3_ro3_esc_e_ro3_esc_w_ro3_hop_sr3_d_stub_tg_d_a_y r0 *1 0,0
Ccc_a_b_d_invb_a_mn12_g1_mp24_g0_ro2_ro2_esc_sr2_d_stub_tg_d_a_y_a_d_inva_a_mn12_g0_mp13_g0_ro3_ro3_esc_e_ro3_esc_w_ro3_hop_sr3_d_stub_tg_d_a_y
+ a|b|d|invb_a|mn12_g1|mp24_g0|ro2|ro2_esc|sr2_d_stub|tg_d_a|y
+ a|d|inva_a|mn12_g0|mp13_g0|ro3|ro3_esc_e|ro3_esc_w|ro3_hop|sr3_d_stub|tg_d_a|y
+ 7.737e-18
* device instance cc_a_b_d_invb_a_mn12_g1_mp24_g0_ro2_ro2_esc_sr2_d_stub_tg_d_a_y_clkb_clkb_bridge1_clkb_bridge2_clkb_mid_clkb_w_ctrl_ctrlb_inv_clk_y_tg_d_ctrlb_tg_fbm_ctrl_tg_fbs_ctrlb_tg_s_ctrl_y r0 *1 0,0
Ccc_a_b_d_invb_a_mn12_g1_mp24_g0_ro2_ro2_esc_sr2_d_stub_tg_d_a_y_clkb_clkb_bridge1_clkb_bridge2_clkb_mid_clkb_w_ctrl_ctrlb_inv_clk_y_tg_d_ctrlb_tg_fbm_ctrl_tg_fbs_ctrlb_tg_s_ctrl_y
+ a|b|d|invb_a|mn12_g1|mp24_g0|ro2|ro2_esc|sr2_d_stub|tg_d_a|y
+ clkb|clkb_bridge1|clkb_bridge2|clkb_mid|clkb_w|ctrl|ctrlb|inv_clk_y|tg_d_ctrlb|tg_fbm_ctrl|tg_fbs_ctrlb|tg_s_ctrl|y$5
+ 8.337e-18
* device instance cc_a_b_d_invb_a_mn12_g1_mp24_g0_ro2_ro2_esc_sr2_d_stub_tg_d_a_y_en_nand_m_en_nand_m_en_via_nand_s2_en_nand_s2_en_via_rst_n r0 *1 0,0
Ccc_a_b_d_invb_a_mn12_g1_mp24_g0_ro2_ro2_esc_sr2_d_stub_tg_d_a_y_en_nand_m_en_nand_m_en_via_nand_s2_en_nand_s2_en_via_rst_n
+ a|b|d|invb_a|mn12_g1|mp24_g0|ro2|ro2_esc|sr2_d_stub|tg_d_a|y
+ en|nand_m_en|nand_m_en_via|nand_s2_en|nand_s2_en_via|rst_n 3.869e-18
* device instance cc_a_b_d_invb_a_mn12_g1_mp24_g0_ro2_ro2_esc_sr2_d_stub_tg_d_a_y_g_vddr_m1_mnt_g_s1_vddr_m1_s2_vddr_m1_s3_vddr_m1_s4_vddr_m1_vddr_vddr1 r0 *1 0,0
Ccc_a_b_d_invb_a_mn12_g1_mp24_g0_ro2_ro2_esc_sr2_d_stub_tg_d_a_y_g_vddr_m1_mnt_g_s1_vddr_m1_s2_vddr_m1_s3_vddr_m1_s4_vddr_m1_vddr_vddr1
+ a|b|d|invb_a|mn12_g1|mp24_g0|ro2|ro2_esc|sr2_d_stub|tg_d_a|y
+ g_vddr_m1|mnt_g|s1_vddr_m1|s2_vddr_m1|s3_vddr_m1|s4_vddr_m1|vddr|vddr1
+ 1.6358e-17
* device instance cc_a_b_d_invb_a_mn12_g1_mp24_g0_ro2_ro2_esc_sr2_d_stub_tg_d_a_y_g_vss_m1_inv_clk_vss_inv_mc_vss_inv_q_vss_mph_g_nand_m_vss_nand_s2_vss_s1_vss_m1_s2_vss_m1_s3_vss_m1_s4_vss_m1_sb_vss_sr1_vss_sr2_vss_sr3_vss_sr4_vss_sv_vss_tg_d_vss_tg_fbm_vss_tg_fbs_vss_tg_s_vss_vss_vss_link_vss_link_bridge_vss_link_dip_vss_link_m1_vss_x1_vss_x2_vss_x3 r0 *1 0,0
Ccc_a_b_d_invb_a_mn12_g1_mp24_g0_ro2_ro2_esc_sr2_d_stub_tg_d_a_y_g_vss_m1_inv_clk_vss_inv_mc_vss_inv_q_vss_mph_g_nand_m_vss_nand_s2_vss_s1_vss_m1_s2_vss_m1_s3_vss_m1_s4_vss_m1_sb_vss_sr1_vss_sr2_vss_sr3_vss_sr4_vss_sv_vss_tg_d_vss_tg_fbm_vss_tg_fbs_vss_tg_s_vss_vss_vss_link_vss_link_bridge_vss_link_dip_vss_link_m1_vss_x1_vss_x2_vss_x3
+ a|b|d|invb_a|mn12_g1|mp24_g0|ro2|ro2_esc|sr2_d_stub|tg_d_a|y
+ g_vss_m1|inv_clk_vss|inv_mc_vss|inv_q_vss|mph_g|nand_m_vss|nand_s2_vss|s1_vss_m1|s2_vss_m1|s3_vss_m1|s4_vss_m1|sb_vss|sr1_vss|sr2_vss|sr3_vss|sr4_vss|sv_vss|tg_d_vss|tg_fbm_vss|tg_fbs_vss|tg_s_vss|vss|vss_link|vss_link_bridge|vss_link_dip|vss_link_m1|vss_x1|vss_x2|vss_x3
+ 5.1954e-17
* device instance cc_a_b_d_invb_a_mn12_g1_mp24_g0_ro4_ro4_esc_sr4_d_stub_tg_d_a_y_a_b_m_east_m_west_nand_m_a_nand_m_a_ext_via_nand_m_a_ext_via2_nand_m_a_stub_tg_d_b_tg_d_b_via_tg_d_b_via2_tg_fbm_b_tg_fbm_b_alt_via_tg_fbm_b_alt_via2 r0 *1 0,0
Ccc_a_b_d_invb_a_mn12_g1_mp24_g0_ro4_ro4_esc_sr4_d_stub_tg_d_a_y_a_b_m_east_m_west_nand_m_a_nand_m_a_ext_via_nand_m_a_ext_via2_nand_m_a_stub_tg_d_b_tg_d_b_via_tg_d_b_via2_tg_fbm_b_tg_fbm_b_alt_via_tg_fbm_b_alt_via2
+ a|b|d|invb_a|mn12_g1|mp24_g0|ro4|ro4_esc|sr4_d_stub|tg_d_a|y
+ a|b|m_east|m_west|nand_m_a|nand_m_a_ext_via|nand_m_a_ext_via2|nand_m_a_stub|tg_d_b|tg_d_b_via|tg_d_b_via2|tg_fbm_b|tg_fbm_b_alt_via|tg_fbm_b_alt_via2$5
+ 3.869e-18
* device instance cc_a_b_d_invb_a_mn12_g1_mp24_g0_ro4_ro4_esc_sr4_d_stub_tg_d_a_y_a_d_inv_clk_vdd_inv_mc_vdd_inv_q_vdd_mpa_py_mpb_py_nand_m_vdd_nand_s2_vdd_nwell_vdd_sb_vdd_sr1_vdd_sr2_vdd_sr3_vdd_sr4_vdd_sv_d_vdd_tie_sv_vdd_tg_d_a_tg_d_vdd_tg_fbm_vdd_tg_fbs_vdd_tg_s_vdd_vdd_vdd_b1_vdd_b2_vdd_b3_vdd_b4_vdd_link_vdd_link_dip_vdd_x1_vdd_x2_vdd_x3 r0 *1 0,0
Ccc_a_b_d_invb_a_mn12_g1_mp24_g0_ro4_ro4_esc_sr4_d_stub_tg_d_a_y_a_d_inv_clk_vdd_inv_mc_vdd_inv_q_vdd_mpa_py_mpb_py_nand_m_vdd_nand_s2_vdd_nwell_vdd_sb_vdd_sr1_vdd_sr2_vdd_sr3_vdd_sr4_vdd_sv_d_vdd_tie_sv_vdd_tg_d_a_tg_d_vdd_tg_fbm_vdd_tg_fbs_vdd_tg_s_vdd_vdd_vdd_b1_vdd_b2_vdd_b3_vdd_b4_vdd_link_vdd_link_dip_vdd_x1_vdd_x2_vdd_x3
+ a|b|d|invb_a|mn12_g1|mp24_g0|ro4|ro4_esc|sr4_d_stub|tg_d_a|y
+ a|d|inv_clk_vdd|inv_mc_vdd|inv_q_vdd|mpa_py|mpb_py|nand_m_vdd|nand_s2_vdd|nwell_vdd|sb_vdd|sr1_vdd|sr2_vdd|sr3_vdd|sr4_vdd|sv_d_vdd_tie|sv_vdd|tg_d_a|tg_d_vdd|tg_fbm_vdd|tg_fbs_vdd|tg_s_vdd|vdd|vdd_b1|vdd_b2|vdd_b3|vdd_b4|vdd_link|vdd_link_dip|vdd_x1|vdd_x2|vdd_x3
+ 1.3426e-17
* device instance cc_a_b_d_invb_a_mn12_g1_mp24_g0_ro4_ro4_esc_sr4_d_stub_tg_d_a_y_clkb_clkb_bridge1_clkb_bridge2_clkb_mid_clkb_w_ctrl_ctrlb_inv_clk_y_tg_d_ctrlb_tg_fbm_ctrl_tg_fbs_ctrlb_tg_s_ctrl_y r0 *1 0,0
Ccc_a_b_d_invb_a_mn12_g1_mp24_g0_ro4_ro4_esc_sr4_d_stub_tg_d_a_y_clkb_clkb_bridge1_clkb_bridge2_clkb_mid_clkb_w_ctrl_ctrlb_inv_clk_y_tg_d_ctrlb_tg_fbm_ctrl_tg_fbs_ctrlb_tg_s_ctrl_y
+ a|b|d|invb_a|mn12_g1|mp24_g0|ro4|ro4_esc|sr4_d_stub|tg_d_a|y
+ clkb|clkb_bridge1|clkb_bridge2|clkb_mid|clkb_w|ctrl|ctrlb|inv_clk_y|tg_d_ctrlb|tg_fbm_ctrl|tg_fbs_ctrlb|tg_s_ctrl|y$5
+ 8.337e-18
* device instance cc_a_b_d_invb_a_mn12_g1_mp24_g0_ro4_ro4_esc_sr4_d_stub_tg_d_a_y_en_nand_m_en_nand_m_en_via_nand_s2_en_nand_s2_en_via_rst_n r0 *1 0,0
Ccc_a_b_d_invb_a_mn12_g1_mp24_g0_ro4_ro4_esc_sr4_d_stub_tg_d_a_y_en_nand_m_en_nand_m_en_via_nand_s2_en_nand_s2_en_via_rst_n
+ a|b|d|invb_a|mn12_g1|mp24_g0|ro4|ro4_esc|sr4_d_stub|tg_d_a|y
+ en|nand_m_en|nand_m_en_via|nand_s2_en|nand_s2_en_via|rst_n 3.869e-18
* device instance cc_a_b_d_invb_a_mn12_g1_mp24_g0_ro4_ro4_esc_sr4_d_stub_tg_d_a_y_g_vss_m1_inv_clk_vss_inv_mc_vss_inv_q_vss_mph_g_nand_m_vss_nand_s2_vss_s1_vss_m1_s2_vss_m1_s3_vss_m1_s4_vss_m1_sb_vss_sr1_vss_sr2_vss_sr3_vss_sr4_vss_sv_vss_tg_d_vss_tg_fbm_vss_tg_fbs_vss_tg_s_vss_vss_vss_link_vss_link_bridge_vss_link_dip_vss_link_m1_vss_x1_vss_x2_vss_x3 r0 *1 0,0
Ccc_a_b_d_invb_a_mn12_g1_mp24_g0_ro4_ro4_esc_sr4_d_stub_tg_d_a_y_g_vss_m1_inv_clk_vss_inv_mc_vss_inv_q_vss_mph_g_nand_m_vss_nand_s2_vss_s1_vss_m1_s2_vss_m1_s3_vss_m1_s4_vss_m1_sb_vss_sr1_vss_sr2_vss_sr3_vss_sr4_vss_sv_vss_tg_d_vss_tg_fbm_vss_tg_fbs_vss_tg_s_vss_vss_vss_link_vss_link_bridge_vss_link_dip_vss_link_m1_vss_x1_vss_x2_vss_x3
+ a|b|d|invb_a|mn12_g1|mp24_g0|ro4|ro4_esc|sr4_d_stub|tg_d_a|y
+ g_vss_m1|inv_clk_vss|inv_mc_vss|inv_q_vss|mph_g|nand_m_vss|nand_s2_vss|s1_vss_m1|s2_vss_m1|s3_vss_m1|s4_vss_m1|sb_vss|sr1_vss|sr2_vss|sr3_vss|sr4_vss|sv_vss|tg_d_vss|tg_fbm_vss|tg_fbs_vss|tg_s_vss|vss|vss_link|vss_link_bridge|vss_link_dip|vss_link_m1|vss_x1|vss_x2|vss_x3
+ 8.0252e-17
* device instance cc_a_b_inv_q_a_inv_q_a_via_s_tg_fbs_b_tg_fbs_b_via_tg_s_b_tg_s_b_via_a_inv_mc_a_mb_mnab_y_mpa_y_mpb_y_nand_m_y_tg_s_a_y r0 *1 0,0
Ccc_a_b_inv_q_a_inv_q_a_via_s_tg_fbs_b_tg_fbs_b_via_tg_s_b_tg_s_b_via_a_inv_mc_a_mb_mnab_y_mpa_y_mpb_y_nand_m_y_tg_s_a_y
+ a|b|inv_q_a|inv_q_a_via|s|tg_fbs_b|tg_fbs_b_via|tg_s_b|tg_s_b_via$5
+ a|inv_mc_a|mb|mnab_y|mpa_y|mpb_y|nand_m_y|tg_s_a|y$5 9.1937e-17
* device instance cc_a_b_inv_q_a_inv_q_a_via_s_tg_fbs_b_tg_fbs_b_via_tg_s_b_tg_s_b_via_a_mnab_y_mpa_y_mpb_y_nand_s2_y_qb_tg_fbs_a_y r0 *1 0,0
Ccc_a_b_inv_q_a_inv_q_a_via_s_tg_fbs_b_tg_fbs_b_via_tg_s_b_tg_s_b_via_a_mnab_y_mpa_y_mpb_y_nand_s2_y_qb_tg_fbs_a_y
+ a|b|inv_q_a|inv_q_a_via|s|tg_fbs_b|tg_fbs_b_via|tg_s_b|tg_s_b_via$5
+ a|mnab_y|mpa_y|mpb_y|nand_s2_y|qb|tg_fbs_a|y$5 2.15613e-16
* device instance cc_a_b_inv_q_a_inv_q_a_via_s_tg_fbs_b_tg_fbs_b_via_tg_s_b_tg_s_b_via_clkb_clkb_bridge1_clkb_bridge2_clkb_mid_clkb_w_ctrl_ctrlb_inv_clk_y_tg_d_ctrlb_tg_fbm_ctrl_tg_fbs_ctrlb_tg_s_ctrl_y r0 *1 0,0
Ccc_a_b_inv_q_a_inv_q_a_via_s_tg_fbs_b_tg_fbs_b_via_tg_s_b_tg_s_b_via_clkb_clkb_bridge1_clkb_bridge2_clkb_mid_clkb_w_ctrl_ctrlb_inv_clk_y_tg_d_ctrlb_tg_fbm_ctrl_tg_fbs_ctrlb_tg_s_ctrl_y
+ a|b|inv_q_a|inv_q_a_via|s|tg_fbs_b|tg_fbs_b_via|tg_s_b|tg_s_b_via$5
+ clkb|clkb_bridge1|clkb_bridge2|clkb_mid|clkb_w|ctrl|ctrlb|inv_clk_y|tg_d_ctrlb|tg_fbm_ctrl|tg_fbs_ctrlb|tg_s_ctrl|y$5
+ 9.3033e-17
* device instance cc_a_b_m_east_m_west_nand_m_a_nand_m_a_ext_via_nand_m_a_ext_via2_nand_m_a_stub_tg_d_b_tg_d_b_via_tg_d_b_via2_tg_fbm_b_tg_fbm_b_alt_via_tg_fbm_b_alt_via2_a_d_inv_clk_vdd_inv_mc_vdd_inv_q_vdd_mpa_py_mpb_py_nand_m_vdd_nand_s2_vdd_nwell_vdd_sb_vdd_sr1_vdd_sr2_vdd_sr3_vdd_sr4_vdd_sv_d_vdd_tie_sv_vdd_tg_d_a_tg_d_vdd_tg_fbm_vdd_tg_fbs_vdd_tg_s_vdd_vdd_vdd_b1_vdd_b2_vdd_b3_vdd_b4_vdd_link_vdd_link_dip_vdd_x1_vdd_x2_vdd_x3 r0 *1 0,0
Ccc_a_b_m_east_m_west_nand_m_a_nand_m_a_ext_via_nand_m_a_ext_via2_nand_m_a_stub_tg_d_b_tg_d_b_via_tg_d_b_via2_tg_fbm_b_tg_fbm_b_alt_via_tg_fbm_b_alt_via2_a_d_inv_clk_vdd_inv_mc_vdd_inv_q_vdd_mpa_py_mpb_py_nand_m_vdd_nand_s2_vdd_nwell_vdd_sb_vdd_sr1_vdd_sr2_vdd_sr3_vdd_sr4_vdd_sv_d_vdd_tie_sv_vdd_tg_d_a_tg_d_vdd_tg_fbm_vdd_tg_fbs_vdd_tg_s_vdd_vdd_vdd_b1_vdd_b2_vdd_b3_vdd_b4_vdd_link_vdd_link_dip_vdd_x1_vdd_x2_vdd_x3
+ a|b|m_east|m_west|nand_m_a|nand_m_a_ext_via|nand_m_a_ext_via2|nand_m_a_stub|tg_d_b|tg_d_b_via|tg_d_b_via2|tg_fbm_b|tg_fbm_b_alt_via|tg_fbm_b_alt_via2$5
+ a|d|inv_clk_vdd|inv_mc_vdd|inv_q_vdd|mpa_py|mpb_py|nand_m_vdd|nand_s2_vdd|nwell_vdd|sb_vdd|sr1_vdd|sr2_vdd|sr3_vdd|sr4_vdd|sv_d_vdd_tie|sv_vdd|tg_d_a|tg_d_vdd|tg_fbm_vdd|tg_fbs_vdd|tg_s_vdd|vdd|vdd_b1|vdd_b2|vdd_b3|vdd_b4|vdd_link|vdd_link_dip|vdd_x1|vdd_x2|vdd_x3
+ 3.869e-18
* device instance cc_a_b_m_east_m_west_nand_m_a_nand_m_a_ext_via_nand_m_a_ext_via2_nand_m_a_stub_tg_d_b_tg_d_b_via_tg_d_b_via2_tg_fbm_b_tg_fbm_b_alt_via_tg_fbm_b_alt_via2_a_d_inva_a_mn12_g0_mp13_g0_ro1_ro1_esc_sr1_d_stub_tg_d_a_y r0 *1 0,0
Ccc_a_b_m_east_m_west_nand_m_a_nand_m_a_ext_via_nand_m_a_ext_via2_nand_m_a_stub_tg_d_b_tg_d_b_via_tg_d_b_via2_tg_fbm_b_tg_fbm_b_alt_via_tg_fbm_b_alt_via2_a_d_inva_a_mn12_g0_mp13_g0_ro1_ro1_esc_sr1_d_stub_tg_d_a_y
+ a|b|m_east|m_west|nand_m_a|nand_m_a_ext_via|nand_m_a_ext_via2|nand_m_a_stub|tg_d_b|tg_d_b_via|tg_d_b_via2|tg_fbm_b|tg_fbm_b_alt_via|tg_fbm_b_alt_via2$5
+ a|d|inva_a|mn12_g0|mp13_g0|ro1|ro1_esc|sr1_d_stub|tg_d_a|y 3.869e-18
* device instance cc_a_b_m_east_m_west_nand_m_a_nand_m_a_ext_via_nand_m_a_ext_via2_nand_m_a_stub_tg_d_b_tg_d_b_via_tg_d_b_via2_tg_fbm_b_tg_fbm_b_alt_via_tg_fbm_b_alt_via2_a_d_inva_a_mn12_g0_mp13_g0_ro3_ro3_esc_e_ro3_esc_w_ro3_hop_sr3_d_stub_tg_d_a_y r0 *1 0,0
Ccc_a_b_m_east_m_west_nand_m_a_nand_m_a_ext_via_nand_m_a_ext_via2_nand_m_a_stub_tg_d_b_tg_d_b_via_tg_d_b_via2_tg_fbm_b_tg_fbm_b_alt_via_tg_fbm_b_alt_via2_a_d_inva_a_mn12_g0_mp13_g0_ro3_ro3_esc_e_ro3_esc_w_ro3_hop_sr3_d_stub_tg_d_a_y
+ a|b|m_east|m_west|nand_m_a|nand_m_a_ext_via|nand_m_a_ext_via2|nand_m_a_stub|tg_d_b|tg_d_b_via|tg_d_b_via2|tg_fbm_b|tg_fbm_b_alt_via|tg_fbm_b_alt_via2$5
+ a|d|inva_a|mn12_g0|mp13_g0|ro3|ro3_esc_e|ro3_esc_w|ro3_hop|sr3_d_stub|tg_d_a|y
+ 3.869e-18
* device instance cc_a_b_m_east_m_west_nand_m_a_nand_m_a_ext_via_nand_m_a_ext_via2_nand_m_a_stub_tg_d_b_tg_d_b_via_tg_d_b_via2_tg_fbm_b_tg_fbm_b_alt_via_tg_fbm_b_alt_via2_a_d_sb_d_stub_tg_d_a_xo_xo_dip_xo_hop_xo_stub_y r0 *1 0,0
Ccc_a_b_m_east_m_west_nand_m_a_nand_m_a_ext_via_nand_m_a_ext_via2_nand_m_a_stub_tg_d_b_tg_d_b_via_tg_d_b_via2_tg_fbm_b_tg_fbm_b_alt_via_tg_fbm_b_alt_via2_a_d_sb_d_stub_tg_d_a_xo_xo_dip_xo_hop_xo_stub_y
+ a|b|m_east|m_west|nand_m_a|nand_m_a_ext_via|nand_m_a_ext_via2|nand_m_a_stub|tg_d_b|tg_d_b_via|tg_d_b_via2|tg_fbm_b|tg_fbm_b_alt_via|tg_fbm_b_alt_via2$5
+ a|d|sb_d_stub|tg_d_a|xo|xo_dip|xo_hop|xo_stub|y 3.869e-18
* device instance cc_a_b_m_east_m_west_nand_m_a_nand_m_a_ext_via_nand_m_a_ext_via2_nand_m_a_stub_tg_d_b_tg_d_b_via_tg_d_b_via2_tg_fbm_b_tg_fbm_b_alt_via_tg_fbm_b_alt_via2_a_inv_mc_a_mb_mnab_y_mpa_y_mpb_y_nand_m_y_tg_s_a_y r0 *1 0,0
Ccc_a_b_m_east_m_west_nand_m_a_nand_m_a_ext_via_nand_m_a_ext_via2_nand_m_a_stub_tg_d_b_tg_d_b_via_tg_d_b_via2_tg_fbm_b_tg_fbm_b_alt_via_tg_fbm_b_alt_via2_a_inv_mc_a_mb_mnab_y_mpa_y_mpb_y_nand_m_y_tg_s_a_y
+ a|b|m_east|m_west|nand_m_a|nand_m_a_ext_via|nand_m_a_ext_via2|nand_m_a_stub|tg_d_b|tg_d_b_via|tg_d_b_via2|tg_fbm_b|tg_fbm_b_alt_via|tg_fbm_b_alt_via2$5
+ a|inv_mc_a|mb|mnab_y|mpa_y|mpb_y|nand_m_y|tg_s_a|y$5 1.54907e-16
* device instance cc_a_b_m_east_m_west_nand_m_a_nand_m_a_ext_via_nand_m_a_ext_via2_nand_m_a_stub_tg_d_b_tg_d_b_via_tg_d_b_via2_tg_fbm_b_tg_fbm_b_alt_via_tg_fbm_b_alt_via2_clkb_clkb_bridge1_clkb_bridge2_clkb_mid_clkb_w_ctrl_ctrlb_inv_clk_y_tg_d_ctrlb_tg_fbm_ctrl_tg_fbs_ctrlb_tg_s_ctrl_y r0 *1 0,0
Ccc_a_b_m_east_m_west_nand_m_a_nand_m_a_ext_via_nand_m_a_ext_via2_nand_m_a_stub_tg_d_b_tg_d_b_via_tg_d_b_via2_tg_fbm_b_tg_fbm_b_alt_via_tg_fbm_b_alt_via2_clkb_clkb_bridge1_clkb_bridge2_clkb_mid_clkb_w_ctrl_ctrlb_inv_clk_y_tg_d_ctrlb_tg_fbm_ctrl_tg_fbs_ctrlb_tg_s_ctrl_y
+ a|b|m_east|m_west|nand_m_a|nand_m_a_ext_via|nand_m_a_ext_via2|nand_m_a_stub|tg_d_b|tg_d_b_via|tg_d_b_via2|tg_fbm_b|tg_fbm_b_alt_via|tg_fbm_b_alt_via2$5
+ clkb|clkb_bridge1|clkb_bridge2|clkb_mid|clkb_w|ctrl|ctrlb|inv_clk_y|tg_d_ctrlb|tg_fbm_ctrl|tg_fbs_ctrlb|tg_s_ctrl|y$5
+ 1.00039e-16
* device instance cc_a_clk_ctrl_ctrlb_inv_clk_a_inv_clk_clk_via_tg_d_ctrl_tg_d_ctrl_via_tg_fbm_ctrlb_tg_fbm_ctrlb_via_tg_fbs_ctrl_tg_fbs_ctrl_via_tg_s_ctrlb_tg_s_ctrlb_via_a_mnab_y_mpa_y_mpb_y_nand_s2_y_qb_tg_fbs_a_y r0 *1 0,0
Ccc_a_clk_ctrl_ctrlb_inv_clk_a_inv_clk_clk_via_tg_d_ctrl_tg_d_ctrl_via_tg_fbm_ctrlb_tg_fbm_ctrlb_via_tg_fbs_ctrl_tg_fbs_ctrl_via_tg_s_ctrlb_tg_s_ctrlb_via_a_mnab_y_mpa_y_mpb_y_nand_s2_y_qb_tg_fbs_a_y
+ a|clk|ctrl|ctrlb|inv_clk_a|inv_clk_clk_via|tg_d_ctrl|tg_d_ctrl_via|tg_fbm_ctrlb|tg_fbm_ctrlb_via|tg_fbs_ctrl|tg_fbs_ctrl_via|tg_s_ctrlb|tg_s_ctrlb_via
+ a|mnab_y|mpa_y|mpb_y|nand_s2_y|qb|tg_fbs_a|y$5 2.3211e-17
* device instance cc_a_clk_ctrl_ctrlb_inv_clk_a_inv_clk_clk_via_tg_d_ctrl_tg_d_ctrl_via_tg_fbm_ctrlb_tg_fbm_ctrlb_via_tg_fbs_ctrl_tg_fbs_ctrl_via_tg_s_ctrlb_tg_s_ctrlb_via_clkb_clkb_bridge1_clkb_bridge2_clkb_mid_clkb_w_ctrl_ctrlb_inv_clk_y_tg_d_ctrlb_tg_fbm_ctrl_tg_fbs_ctrlb_tg_s_ctrl_y r0 *1 0,0
Ccc_a_clk_ctrl_ctrlb_inv_clk_a_inv_clk_clk_via_tg_d_ctrl_tg_d_ctrl_via_tg_fbm_ctrlb_tg_fbm_ctrlb_via_tg_fbs_ctrl_tg_fbs_ctrl_via_tg_s_ctrlb_tg_s_ctrlb_via_clkb_clkb_bridge1_clkb_bridge2_clkb_mid_clkb_w_ctrl_ctrlb_inv_clk_y_tg_d_ctrlb_tg_fbm_ctrl_tg_fbs_ctrlb_tg_s_ctrl_y
+ a|clk|ctrl|ctrlb|inv_clk_a|inv_clk_clk_via|tg_d_ctrl|tg_d_ctrl_via|tg_fbm_ctrlb|tg_fbm_ctrlb_via|tg_fbs_ctrl|tg_fbs_ctrl_via|tg_s_ctrlb|tg_s_ctrlb_via
+ clkb|clkb_bridge1|clkb_bridge2|clkb_mid|clkb_w|ctrl|ctrlb|inv_clk_y|tg_d_ctrlb|tg_fbm_ctrl|tg_fbs_ctrlb|tg_s_ctrl|y$5
+ 3.16766e-16
* device instance cc_a_clk_ctrl_ctrlb_inv_clk_a_inv_clk_clk_via_tg_d_ctrl_tg_d_ctrl_via_tg_fbm_ctrlb_tg_fbm_ctrlb_via_tg_fbs_ctrl_tg_fbs_ctrl_via_tg_s_ctrlb_tg_s_ctrlb_via_g_vss_m1_inv_clk_vss_inv_mc_vss_inv_q_vss_mph_g_nand_m_vss_nand_s2_vss_s1_vss_m1_s2_vss_m1_s3_vss_m1_s4_vss_m1_sb_vss_sr1_vss_sr2_vss_sr3_vss_sr4_vss_sv_vss_tg_d_vss_tg_fbm_vss_tg_fbs_vss_tg_s_vss_vss_vss_link_vss_link_bridge_vss_link_dip_vss_link_m1_vss_x1_vss_x2_vss_x3 r0 *1 0,0
Ccc_a_clk_ctrl_ctrlb_inv_clk_a_inv_clk_clk_via_tg_d_ctrl_tg_d_ctrl_via_tg_fbm_ctrlb_tg_fbm_ctrlb_via_tg_fbs_ctrl_tg_fbs_ctrl_via_tg_s_ctrlb_tg_s_ctrlb_via_g_vss_m1_inv_clk_vss_inv_mc_vss_inv_q_vss_mph_g_nand_m_vss_nand_s2_vss_s1_vss_m1_s2_vss_m1_s3_vss_m1_s4_vss_m1_sb_vss_sr1_vss_sr2_vss_sr3_vss_sr4_vss_sv_vss_tg_d_vss_tg_fbm_vss_tg_fbs_vss_tg_s_vss_vss_vss_link_vss_link_bridge_vss_link_dip_vss_link_m1_vss_x1_vss_x2_vss_x3
+ a|clk|ctrl|ctrlb|inv_clk_a|inv_clk_clk_via|tg_d_ctrl|tg_d_ctrl_via|tg_fbm_ctrlb|tg_fbm_ctrlb_via|tg_fbs_ctrl|tg_fbs_ctrl_via|tg_s_ctrlb|tg_s_ctrlb_via
+ g_vss_m1|inv_clk_vss|inv_mc_vss|inv_q_vss|mph_g|nand_m_vss|nand_s2_vss|s1_vss_m1|s2_vss_m1|s3_vss_m1|s4_vss_m1|sb_vss|sr1_vss|sr2_vss|sr3_vss|sr4_vss|sv_vss|tg_d_vss|tg_fbm_vss|tg_fbs_vss|tg_s_vss|vss|vss_link|vss_link_bridge|vss_link_dip|vss_link_m1|vss_x1|vss_x2|vss_x3
+ 1.16057e-16
* device instance cc_a_d_inv_clk_vdd_inv_mc_vdd_inv_q_vdd_mpa_py_mpb_py_nand_m_vdd_nand_s2_vdd_nwell_vdd_sb_vdd_sr1_vdd_sr2_vdd_sr3_vdd_sr4_vdd_sv_d_vdd_tie_sv_vdd_tg_d_a_tg_d_vdd_tg_fbm_vdd_tg_fbs_vdd_tg_s_vdd_vdd_vdd_b1_vdd_b2_vdd_b3_vdd_b4_vdd_link_vdd_link_dip_vdd_x1_vdd_x2_vdd_x3_a_d_inva_a_mn12_g0_mp13_g0_ro1_ro1_esc_sr1_d_stub_tg_d_a_y r0 *1 0,0
Ccc_a_d_inv_clk_vdd_inv_mc_vdd_inv_q_vdd_mpa_py_mpb_py_nand_m_vdd_nand_s2_vdd_nwell_vdd_sb_vdd_sr1_vdd_sr2_vdd_sr3_vdd_sr4_vdd_sv_d_vdd_tie_sv_vdd_tg_d_a_tg_d_vdd_tg_fbm_vdd_tg_fbs_vdd_tg_s_vdd_vdd_vdd_b1_vdd_b2_vdd_b3_vdd_b4_vdd_link_vdd_link_dip_vdd_x1_vdd_x2_vdd_x3_a_d_inva_a_mn12_g0_mp13_g0_ro1_ro1_esc_sr1_d_stub_tg_d_a_y
+ a|d|inv_clk_vdd|inv_mc_vdd|inv_q_vdd|mpa_py|mpb_py|nand_m_vdd|nand_s2_vdd|nwell_vdd|sb_vdd|sr1_vdd|sr2_vdd|sr3_vdd|sr4_vdd|sv_d_vdd_tie|sv_vdd|tg_d_a|tg_d_vdd|tg_fbm_vdd|tg_fbs_vdd|tg_s_vdd|vdd|vdd_b1|vdd_b2|vdd_b3|vdd_b4|vdd_link|vdd_link_dip|vdd_x1|vdd_x2|vdd_x3
+ a|d|inva_a|mn12_g0|mp13_g0|ro1|ro1_esc|sr1_d_stub|tg_d_a|y 4.5399e-17
* device instance cc_a_d_inv_clk_vdd_inv_mc_vdd_inv_q_vdd_mpa_py_mpb_py_nand_m_vdd_nand_s2_vdd_nwell_vdd_sb_vdd_sr1_vdd_sr2_vdd_sr3_vdd_sr4_vdd_sv_d_vdd_tie_sv_vdd_tg_d_a_tg_d_vdd_tg_fbm_vdd_tg_fbs_vdd_tg_s_vdd_vdd_vdd_b1_vdd_b2_vdd_b3_vdd_b4_vdd_link_vdd_link_dip_vdd_x1_vdd_x2_vdd_x3_a_d_inva_a_mn12_g0_mp13_g0_ro3_ro3_esc_e_ro3_esc_w_ro3_hop_sr3_d_stub_tg_d_a_y r0 *1 0,0
Ccc_a_d_inv_clk_vdd_inv_mc_vdd_inv_q_vdd_mpa_py_mpb_py_nand_m_vdd_nand_s2_vdd_nwell_vdd_sb_vdd_sr1_vdd_sr2_vdd_sr3_vdd_sr4_vdd_sv_d_vdd_tie_sv_vdd_tg_d_a_tg_d_vdd_tg_fbm_vdd_tg_fbs_vdd_tg_s_vdd_vdd_vdd_b1_vdd_b2_vdd_b3_vdd_b4_vdd_link_vdd_link_dip_vdd_x1_vdd_x2_vdd_x3_a_d_inva_a_mn12_g0_mp13_g0_ro3_ro3_esc_e_ro3_esc_w_ro3_hop_sr3_d_stub_tg_d_a_y
+ a|d|inv_clk_vdd|inv_mc_vdd|inv_q_vdd|mpa_py|mpb_py|nand_m_vdd|nand_s2_vdd|nwell_vdd|sb_vdd|sr1_vdd|sr2_vdd|sr3_vdd|sr4_vdd|sv_d_vdd_tie|sv_vdd|tg_d_a|tg_d_vdd|tg_fbm_vdd|tg_fbs_vdd|tg_s_vdd|vdd|vdd_b1|vdd_b2|vdd_b3|vdd_b4|vdd_link|vdd_link_dip|vdd_x1|vdd_x2|vdd_x3
+ a|d|inva_a|mn12_g0|mp13_g0|ro3|ro3_esc_e|ro3_esc_w|ro3_hop|sr3_d_stub|tg_d_a|y
+ 4.9268e-17
* device instance cc_a_d_inv_clk_vdd_inv_mc_vdd_inv_q_vdd_mpa_py_mpb_py_nand_m_vdd_nand_s2_vdd_nwell_vdd_sb_vdd_sr1_vdd_sr2_vdd_sr3_vdd_sr4_vdd_sv_d_vdd_tie_sv_vdd_tg_d_a_tg_d_vdd_tg_fbm_vdd_tg_fbs_vdd_tg_s_vdd_vdd_vdd_b1_vdd_b2_vdd_b3_vdd_b4_vdd_link_vdd_link_dip_vdd_x1_vdd_x2_vdd_x3_a_d_sb_d_stub_tg_d_a_xo_xo_dip_xo_hop_xo_stub_y r0 *1 0,0
Ccc_a_d_inv_clk_vdd_inv_mc_vdd_inv_q_vdd_mpa_py_mpb_py_nand_m_vdd_nand_s2_vdd_nwell_vdd_sb_vdd_sr1_vdd_sr2_vdd_sr3_vdd_sr4_vdd_sv_d_vdd_tie_sv_vdd_tg_d_a_tg_d_vdd_tg_fbm_vdd_tg_fbs_vdd_tg_s_vdd_vdd_vdd_b1_vdd_b2_vdd_b3_vdd_b4_vdd_link_vdd_link_dip_vdd_x1_vdd_x2_vdd_x3_a_d_sb_d_stub_tg_d_a_xo_xo_dip_xo_hop_xo_stub_y
+ a|d|inv_clk_vdd|inv_mc_vdd|inv_q_vdd|mpa_py|mpb_py|nand_m_vdd|nand_s2_vdd|nwell_vdd|sb_vdd|sr1_vdd|sr2_vdd|sr3_vdd|sr4_vdd|sv_d_vdd_tie|sv_vdd|tg_d_a|tg_d_vdd|tg_fbm_vdd|tg_fbs_vdd|tg_s_vdd|vdd|vdd_b1|vdd_b2|vdd_b3|vdd_b4|vdd_link|vdd_link_dip|vdd_x1|vdd_x2|vdd_x3
+ a|d|sb_d_stub|tg_d_a|xo|xo_dip|xo_hop|xo_stub|y 3.869e-18
* device instance cc_a_d_inv_clk_vdd_inv_mc_vdd_inv_q_vdd_mpa_py_mpb_py_nand_m_vdd_nand_s2_vdd_nwell_vdd_sb_vdd_sr1_vdd_sr2_vdd_sr3_vdd_sr4_vdd_sv_d_vdd_tie_sv_vdd_tg_d_a_tg_d_vdd_tg_fbm_vdd_tg_fbs_vdd_tg_s_vdd_vdd_vdd_b1_vdd_b2_vdd_b3_vdd_b4_vdd_link_vdd_link_dip_vdd_x1_vdd_x2_vdd_x3_a_g_a_rn4_ro_s4_y_y r0 *1 0,0
Ccc_a_d_inv_clk_vdd_inv_mc_vdd_inv_q_vdd_mpa_py_mpb_py_nand_m_vdd_nand_s2_vdd_nwell_vdd_sb_vdd_sr1_vdd_sr2_vdd_sr3_vdd_sr4_vdd_sv_d_vdd_tie_sv_vdd_tg_d_a_tg_d_vdd_tg_fbm_vdd_tg_fbs_vdd_tg_s_vdd_vdd_vdd_b1_vdd_b2_vdd_b3_vdd_b4_vdd_link_vdd_link_dip_vdd_x1_vdd_x2_vdd_x3_a_g_a_rn4_ro_s4_y_y
+ a|d|inv_clk_vdd|inv_mc_vdd|inv_q_vdd|mpa_py|mpb_py|nand_m_vdd|nand_s2_vdd|nwell_vdd|sb_vdd|sr1_vdd|sr2_vdd|sr3_vdd|sr4_vdd|sv_d_vdd_tie|sv_vdd|tg_d_a|tg_d_vdd|tg_fbm_vdd|tg_fbs_vdd|tg_s_vdd|vdd|vdd_b1|vdd_b2|vdd_b3|vdd_b4|vdd_link|vdd_link_dip|vdd_x1|vdd_x2|vdd_x3
+ a|g_a|rn4|ro|s4_y|y 3.869e-18
* device instance cc_a_d_inv_clk_vdd_inv_mc_vdd_inv_q_vdd_mpa_py_mpb_py_nand_m_vdd_nand_s2_vdd_nwell_vdd_sb_vdd_sr1_vdd_sr2_vdd_sr3_vdd_sr4_vdd_sv_d_vdd_tie_sv_vdd_tg_d_a_tg_d_vdd_tg_fbm_vdd_tg_fbs_vdd_tg_s_vdd_vdd_vdd_b1_vdd_b2_vdd_b3_vdd_b4_vdd_link_vdd_link_dip_vdd_x1_vdd_x2_vdd_x3_a_inva_a_mn12_g0_mp13_g0_t1_y r0 *1 0,0
Ccc_a_d_inv_clk_vdd_inv_mc_vdd_inv_q_vdd_mpa_py_mpb_py_nand_m_vdd_nand_s2_vdd_nwell_vdd_sb_vdd_sr1_vdd_sr2_vdd_sr3_vdd_sr4_vdd_sv_d_vdd_tie_sv_vdd_tg_d_a_tg_d_vdd_tg_fbm_vdd_tg_fbs_vdd_tg_s_vdd_vdd_vdd_b1_vdd_b2_vdd_b3_vdd_b4_vdd_link_vdd_link_dip_vdd_x1_vdd_x2_vdd_x3_a_inva_a_mn12_g0_mp13_g0_t1_y
+ a|d|inv_clk_vdd|inv_mc_vdd|inv_q_vdd|mpa_py|mpb_py|nand_m_vdd|nand_s2_vdd|nwell_vdd|sb_vdd|sr1_vdd|sr2_vdd|sr3_vdd|sr4_vdd|sv_d_vdd_tie|sv_vdd|tg_d_a|tg_d_vdd|tg_fbm_vdd|tg_fbs_vdd|tg_s_vdd|vdd|vdd_b1|vdd_b2|vdd_b3|vdd_b4|vdd_link|vdd_link_dip|vdd_x1|vdd_x2|vdd_x3
+ a|inva_a|mn12_g0|mp13_g0|t1|y 3.5274e-17
* device instance cc_a_d_inv_clk_vdd_inv_mc_vdd_inv_q_vdd_mpa_py_mpb_py_nand_m_vdd_nand_s2_vdd_nwell_vdd_sb_vdd_sr1_vdd_sr2_vdd_sr3_vdd_sr4_vdd_sv_d_vdd_tie_sv_vdd_tg_d_a_tg_d_vdd_tg_fbm_vdd_tg_fbs_vdd_tg_s_vdd_vdd_vdd_b1_vdd_b2_vdd_b3_vdd_b4_vdd_link_vdd_link_dip_vdd_x1_vdd_x2_vdd_x3_an_inva_y_mn34_g0_mp13_g1_y r0 *1 0,0
Ccc_a_d_inv_clk_vdd_inv_mc_vdd_inv_q_vdd_mpa_py_mpb_py_nand_m_vdd_nand_s2_vdd_nwell_vdd_sb_vdd_sr1_vdd_sr2_vdd_sr3_vdd_sr4_vdd_sv_d_vdd_tie_sv_vdd_tg_d_a_tg_d_vdd_tg_fbm_vdd_tg_fbs_vdd_tg_s_vdd_vdd_vdd_b1_vdd_b2_vdd_b3_vdd_b4_vdd_link_vdd_link_dip_vdd_x1_vdd_x2_vdd_x3_an_inva_y_mn34_g0_mp13_g1_y
+ a|d|inv_clk_vdd|inv_mc_vdd|inv_q_vdd|mpa_py|mpb_py|nand_m_vdd|nand_s2_vdd|nwell_vdd|sb_vdd|sr1_vdd|sr2_vdd|sr3_vdd|sr4_vdd|sv_d_vdd_tie|sv_vdd|tg_d_a|tg_d_vdd|tg_fbm_vdd|tg_fbs_vdd|tg_s_vdd|vdd|vdd_b1|vdd_b2|vdd_b3|vdd_b4|vdd_link|vdd_link_dip|vdd_x1|vdd_x2|vdd_x3
+ an|inva_y|mn34_g0|mp13_g1|y$2 2.8673e-17
* device instance cc_a_d_inv_clk_vdd_inv_mc_vdd_inv_q_vdd_mpa_py_mpb_py_nand_m_vdd_nand_s2_vdd_nwell_vdd_sb_vdd_sr1_vdd_sr2_vdd_sr3_vdd_sr4_vdd_sv_d_vdd_tie_sv_vdd_tg_d_a_tg_d_vdd_tg_fbm_vdd_tg_fbs_vdd_tg_s_vdd_vdd_vdd_b1_vdd_b2_vdd_b3_vdd_b4_vdd_link_vdd_link_dip_vdd_x1_vdd_x2_vdd_x3_bn_invb_y_mn34_g1_mp24_g1_y r0 *1 0,0
Ccc_a_d_inv_clk_vdd_inv_mc_vdd_inv_q_vdd_mpa_py_mpb_py_nand_m_vdd_nand_s2_vdd_nwell_vdd_sb_vdd_sr1_vdd_sr2_vdd_sr3_vdd_sr4_vdd_sv_d_vdd_tie_sv_vdd_tg_d_a_tg_d_vdd_tg_fbm_vdd_tg_fbs_vdd_tg_s_vdd_vdd_vdd_b1_vdd_b2_vdd_b3_vdd_b4_vdd_link_vdd_link_dip_vdd_x1_vdd_x2_vdd_x3_bn_invb_y_mn34_g1_mp24_g1_y
+ a|d|inv_clk_vdd|inv_mc_vdd|inv_q_vdd|mpa_py|mpb_py|nand_m_vdd|nand_s2_vdd|nwell_vdd|sb_vdd|sr1_vdd|sr2_vdd|sr3_vdd|sr4_vdd|sv_d_vdd_tie|sv_vdd|tg_d_a|tg_d_vdd|tg_fbm_vdd|tg_fbs_vdd|tg_s_vdd|vdd|vdd_b1|vdd_b2|vdd_b3|vdd_b4|vdd_link|vdd_link_dip|vdd_x1|vdd_x2|vdd_x3
+ bn|invb_y|mn34_g1|mp24_g1|y$2 9.901e-18
* device instance cc_a_d_inv_clk_vdd_inv_mc_vdd_inv_q_vdd_mpa_py_mpb_py_nand_m_vdd_nand_s2_vdd_nwell_vdd_sb_vdd_sr1_vdd_sr2_vdd_sr3_vdd_sr4_vdd_sv_d_vdd_tie_sv_vdd_tg_d_a_tg_d_vdd_tg_fbm_vdd_tg_fbs_vdd_tg_s_vdd_vdd_vdd_b1_vdd_b2_vdd_b3_vdd_b4_vdd_link_vdd_link_dip_vdd_x1_vdd_x2_vdd_x3_clkb_clkb_bridge1_clkb_bridge2_clkb_mid_clkb_w_ctrl_ctrlb_inv_clk_y_tg_d_ctrlb_tg_fbm_ctrl_tg_fbs_ctrlb_tg_s_ctrl_y r0 *1 0,0
Ccc_a_d_inv_clk_vdd_inv_mc_vdd_inv_q_vdd_mpa_py_mpb_py_nand_m_vdd_nand_s2_vdd_nwell_vdd_sb_vdd_sr1_vdd_sr2_vdd_sr3_vdd_sr4_vdd_sv_d_vdd_tie_sv_vdd_tg_d_a_tg_d_vdd_tg_fbm_vdd_tg_fbs_vdd_tg_s_vdd_vdd_vdd_b1_vdd_b2_vdd_b3_vdd_b4_vdd_link_vdd_link_dip_vdd_x1_vdd_x2_vdd_x3_clkb_clkb_bridge1_clkb_bridge2_clkb_mid_clkb_w_ctrl_ctrlb_inv_clk_y_tg_d_ctrlb_tg_fbm_ctrl_tg_fbs_ctrlb_tg_s_ctrl_y
+ a|d|inv_clk_vdd|inv_mc_vdd|inv_q_vdd|mpa_py|mpb_py|nand_m_vdd|nand_s2_vdd|nwell_vdd|sb_vdd|sr1_vdd|sr2_vdd|sr3_vdd|sr4_vdd|sv_d_vdd_tie|sv_vdd|tg_d_a|tg_d_vdd|tg_fbm_vdd|tg_fbs_vdd|tg_s_vdd|vdd|vdd_b1|vdd_b2|vdd_b3|vdd_b4|vdd_link|vdd_link_dip|vdd_x1|vdd_x2|vdd_x3
+ clkb|clkb_bridge1|clkb_bridge2|clkb_mid|clkb_w|ctrl|ctrlb|inv_clk_y|tg_d_ctrlb|tg_fbm_ctrl|tg_fbs_ctrlb|tg_s_ctrl|y$5
+ 8.337e-18
* device instance cc_a_d_inv_clk_vdd_inv_mc_vdd_inv_q_vdd_mpa_py_mpb_py_nand_m_vdd_nand_s2_vdd_nwell_vdd_sb_vdd_sr1_vdd_sr2_vdd_sr3_vdd_sr4_vdd_sv_d_vdd_tie_sv_vdd_tg_d_a_tg_d_vdd_tg_fbm_vdd_tg_fbs_vdd_tg_s_vdd_vdd_vdd_b1_vdd_b2_vdd_b3_vdd_b4_vdd_link_vdd_link_dip_vdd_x1_vdd_x2_vdd_x3_en_nand_m_en_nand_m_en_via_nand_s2_en_nand_s2_en_via_rst_n r0 *1 0,0
Ccc_a_d_inv_clk_vdd_inv_mc_vdd_inv_q_vdd_mpa_py_mpb_py_nand_m_vdd_nand_s2_vdd_nwell_vdd_sb_vdd_sr1_vdd_sr2_vdd_sr3_vdd_sr4_vdd_sv_d_vdd_tie_sv_vdd_tg_d_a_tg_d_vdd_tg_fbm_vdd_tg_fbs_vdd_tg_s_vdd_vdd_vdd_b1_vdd_b2_vdd_b3_vdd_b4_vdd_link_vdd_link_dip_vdd_x1_vdd_x2_vdd_x3_en_nand_m_en_nand_m_en_via_nand_s2_en_nand_s2_en_via_rst_n
+ a|d|inv_clk_vdd|inv_mc_vdd|inv_q_vdd|mpa_py|mpb_py|nand_m_vdd|nand_s2_vdd|nwell_vdd|sb_vdd|sr1_vdd|sr2_vdd|sr3_vdd|sr4_vdd|sv_d_vdd_tie|sv_vdd|tg_d_a|tg_d_vdd|tg_fbm_vdd|tg_fbs_vdd|tg_s_vdd|vdd|vdd_b1|vdd_b2|vdd_b3|vdd_b4|vdd_link|vdd_link_dip|vdd_x1|vdd_x2|vdd_x3
+ en|nand_m_en|nand_m_en_via|nand_s2_en|nand_s2_en_via|rst_n 5.26927e-16
* device instance cc_a_d_inv_clk_vdd_inv_mc_vdd_inv_q_vdd_mpa_py_mpb_py_nand_m_vdd_nand_s2_vdd_nwell_vdd_sb_vdd_sr1_vdd_sr2_vdd_sr3_vdd_sr4_vdd_sv_d_vdd_tie_sv_vdd_tg_d_a_tg_d_vdd_tg_fbm_vdd_tg_fbs_vdd_tg_s_vdd_vdd_vdd_b1_vdd_b2_vdd_b3_vdd_b4_vdd_link_vdd_link_dip_vdd_x1_vdd_x2_vdd_x3_g_vss_m1_inv_clk_vss_inv_mc_vss_inv_q_vss_mph_g_nand_m_vss_nand_s2_vss_s1_vss_m1_s2_vss_m1_s3_vss_m1_s4_vss_m1_sb_vss_sr1_vss_sr2_vss_sr3_vss_sr4_vss_sv_vss_tg_d_vss_tg_fbm_vss_tg_fbs_vss_tg_s_vss_vss_vss_link_vss_link_bridge_vss_link_dip_vss_link_m1_vss_x1_vss_x2_vss_x3 r0 *1 0,0
Ccc_a_d_inv_clk_vdd_inv_mc_vdd_inv_q_vdd_mpa_py_mpb_py_nand_m_vdd_nand_s2_vdd_nwell_vdd_sb_vdd_sr1_vdd_sr2_vdd_sr3_vdd_sr4_vdd_sv_d_vdd_tie_sv_vdd_tg_d_a_tg_d_vdd_tg_fbm_vdd_tg_fbs_vdd_tg_s_vdd_vdd_vdd_b1_vdd_b2_vdd_b3_vdd_b4_vdd_link_vdd_link_dip_vdd_x1_vdd_x2_vdd_x3_g_vss_m1_inv_clk_vss_inv_mc_vss_inv_q_vss_mph_g_nand_m_vss_nand_s2_vss_s1_vss_m1_s2_vss_m1_s3_vss_m1_s4_vss_m1_sb_vss_sr1_vss_sr2_vss_sr3_vss_sr4_vss_sv_vss_tg_d_vss_tg_fbm_vss_tg_fbs_vss_tg_s_vss_vss_vss_link_vss_link_bridge_vss_link_dip_vss_link_m1_vss_x1_vss_x2_vss_x3
+ a|d|inv_clk_vdd|inv_mc_vdd|inv_q_vdd|mpa_py|mpb_py|nand_m_vdd|nand_s2_vdd|nwell_vdd|sb_vdd|sr1_vdd|sr2_vdd|sr3_vdd|sr4_vdd|sv_d_vdd_tie|sv_vdd|tg_d_a|tg_d_vdd|tg_fbm_vdd|tg_fbs_vdd|tg_s_vdd|vdd|vdd_b1|vdd_b2|vdd_b3|vdd_b4|vdd_link|vdd_link_dip|vdd_x1|vdd_x2|vdd_x3
+ g_vss_m1|inv_clk_vss|inv_mc_vss|inv_q_vss|mph_g|nand_m_vss|nand_s2_vss|s1_vss_m1|s2_vss_m1|s3_vss_m1|s4_vss_m1|sb_vss|sr1_vss|sr2_vss|sr3_vss|sr4_vss|sv_vss|tg_d_vss|tg_fbm_vss|tg_fbs_vss|tg_s_vss|vss|vss_link|vss_link_bridge|vss_link_dip|vss_link_m1|vss_x1|vss_x2|vss_x3
+ 7.7757e-17
* device instance cc_a_d_inva_a_mn12_g0_mp13_g0_ro1_ro1_esc_sr1_d_stub_tg_d_a_y_a_d_inva_a_mn12_g0_mp13_g0_ro3_ro3_esc_e_ro3_esc_w_ro3_hop_sr3_d_stub_tg_d_a_y r0 *1 0,0
Ccc_a_d_inva_a_mn12_g0_mp13_g0_ro1_ro1_esc_sr1_d_stub_tg_d_a_y_a_d_inva_a_mn12_g0_mp13_g0_ro3_ro3_esc_e_ro3_esc_w_ro3_hop_sr3_d_stub_tg_d_a_y
+ a|d|inva_a|mn12_g0|mp13_g0|ro1|ro1_esc|sr1_d_stub|tg_d_a|y
+ a|d|inva_a|mn12_g0|mp13_g0|ro3|ro3_esc_e|ro3_esc_w|ro3_hop|sr3_d_stub|tg_d_a|y
+ 3.869e-18
* device instance cc_a_d_inva_a_mn12_g0_mp13_g0_ro1_ro1_esc_sr1_d_stub_tg_d_a_y_a_inva_a_mn12_g0_mp13_g0_t1_y r0 *1 0,0
Ccc_a_d_inva_a_mn12_g0_mp13_g0_ro1_ro1_esc_sr1_d_stub_tg_d_a_y_a_inva_a_mn12_g0_mp13_g0_t1_y
+ a|d|inva_a|mn12_g0|mp13_g0|ro1|ro1_esc|sr1_d_stub|tg_d_a|y
+ a|inva_a|mn12_g0|mp13_g0|t1|y 3.3e-18
* device instance cc_a_d_inva_a_mn12_g0_mp13_g0_ro1_ro1_esc_sr1_d_stub_tg_d_a_y_clkb_clkb_bridge1_clkb_bridge2_clkb_mid_clkb_w_ctrl_ctrlb_inv_clk_y_tg_d_ctrlb_tg_fbm_ctrl_tg_fbs_ctrlb_tg_s_ctrl_y r0 *1 0,0
Ccc_a_d_inva_a_mn12_g0_mp13_g0_ro1_ro1_esc_sr1_d_stub_tg_d_a_y_clkb_clkb_bridge1_clkb_bridge2_clkb_mid_clkb_w_ctrl_ctrlb_inv_clk_y_tg_d_ctrlb_tg_fbm_ctrl_tg_fbs_ctrlb_tg_s_ctrl_y
+ a|d|inva_a|mn12_g0|mp13_g0|ro1|ro1_esc|sr1_d_stub|tg_d_a|y
+ clkb|clkb_bridge1|clkb_bridge2|clkb_mid|clkb_w|ctrl|ctrlb|inv_clk_y|tg_d_ctrlb|tg_fbm_ctrl|tg_fbs_ctrlb|tg_s_ctrl|y$5
+ 8.337e-18
* device instance cc_a_d_inva_a_mn12_g0_mp13_g0_ro1_ro1_esc_sr1_d_stub_tg_d_a_y_en_nand_m_en_nand_m_en_via_nand_s2_en_nand_s2_en_via_rst_n r0 *1 0,0
Ccc_a_d_inva_a_mn12_g0_mp13_g0_ro1_ro1_esc_sr1_d_stub_tg_d_a_y_en_nand_m_en_nand_m_en_via_nand_s2_en_nand_s2_en_via_rst_n
+ a|d|inva_a|mn12_g0|mp13_g0|ro1|ro1_esc|sr1_d_stub|tg_d_a|y
+ en|nand_m_en|nand_m_en_via|nand_s2_en|nand_s2_en_via|rst_n 3.869e-18
* device instance cc_a_d_inva_a_mn12_g0_mp13_g0_ro1_ro1_esc_sr1_d_stub_tg_d_a_y_g_vss_m1_inv_clk_vss_inv_mc_vss_inv_q_vss_mph_g_nand_m_vss_nand_s2_vss_s1_vss_m1_s2_vss_m1_s3_vss_m1_s4_vss_m1_sb_vss_sr1_vss_sr2_vss_sr3_vss_sr4_vss_sv_vss_tg_d_vss_tg_fbm_vss_tg_fbs_vss_tg_s_vss_vss_vss_link_vss_link_bridge_vss_link_dip_vss_link_m1_vss_x1_vss_x2_vss_x3 r0 *1 0,0
Ccc_a_d_inva_a_mn12_g0_mp13_g0_ro1_ro1_esc_sr1_d_stub_tg_d_a_y_g_vss_m1_inv_clk_vss_inv_mc_vss_inv_q_vss_mph_g_nand_m_vss_nand_s2_vss_s1_vss_m1_s2_vss_m1_s3_vss_m1_s4_vss_m1_sb_vss_sr1_vss_sr2_vss_sr3_vss_sr4_vss_sv_vss_tg_d_vss_tg_fbm_vss_tg_fbs_vss_tg_s_vss_vss_vss_link_vss_link_bridge_vss_link_dip_vss_link_m1_vss_x1_vss_x2_vss_x3
+ a|d|inva_a|mn12_g0|mp13_g0|ro1|ro1_esc|sr1_d_stub|tg_d_a|y
+ g_vss_m1|inv_clk_vss|inv_mc_vss|inv_q_vss|mph_g|nand_m_vss|nand_s2_vss|s1_vss_m1|s2_vss_m1|s3_vss_m1|s4_vss_m1|sb_vss|sr1_vss|sr2_vss|sr3_vss|sr4_vss|sv_vss|tg_d_vss|tg_fbm_vss|tg_fbs_vss|tg_s_vss|vss|vss_link|vss_link_bridge|vss_link_dip|vss_link_m1|vss_x1|vss_x2|vss_x3
+ 1.3955e-17
* device instance cc_a_d_inva_a_mn12_g0_mp13_g0_ro3_ro3_esc_e_ro3_esc_w_ro3_hop_sr3_d_stub_tg_d_a_y_clkb_clkb_bridge1_clkb_bridge2_clkb_mid_clkb_w_ctrl_ctrlb_inv_clk_y_tg_d_ctrlb_tg_fbm_ctrl_tg_fbs_ctrlb_tg_s_ctrl_y r0 *1 0,0
Ccc_a_d_inva_a_mn12_g0_mp13_g0_ro3_ro3_esc_e_ro3_esc_w_ro3_hop_sr3_d_stub_tg_d_a_y_clkb_clkb_bridge1_clkb_bridge2_clkb_mid_clkb_w_ctrl_ctrlb_inv_clk_y_tg_d_ctrlb_tg_fbm_ctrl_tg_fbs_ctrlb_tg_s_ctrl_y
+ a|d|inva_a|mn12_g0|mp13_g0|ro3|ro3_esc_e|ro3_esc_w|ro3_hop|sr3_d_stub|tg_d_a|y
+ clkb|clkb_bridge1|clkb_bridge2|clkb_mid|clkb_w|ctrl|ctrlb|inv_clk_y|tg_d_ctrlb|tg_fbm_ctrl|tg_fbs_ctrlb|tg_s_ctrl|y$5
+ 8.337e-18
* device instance cc_a_d_inva_a_mn12_g0_mp13_g0_ro3_ro3_esc_e_ro3_esc_w_ro3_hop_sr3_d_stub_tg_d_a_y_en_nand_m_en_nand_m_en_via_nand_s2_en_nand_s2_en_via_rst_n r0 *1 0,0
Ccc_a_d_inva_a_mn12_g0_mp13_g0_ro3_ro3_esc_e_ro3_esc_w_ro3_hop_sr3_d_stub_tg_d_a_y_en_nand_m_en_nand_m_en_via_nand_s2_en_nand_s2_en_via_rst_n
+ a|d|inva_a|mn12_g0|mp13_g0|ro3|ro3_esc_e|ro3_esc_w|ro3_hop|sr3_d_stub|tg_d_a|y
+ en|nand_m_en|nand_m_en_via|nand_s2_en|nand_s2_en_via|rst_n 3.869e-18
* device instance cc_a_d_inva_a_mn12_g0_mp13_g0_ro3_ro3_esc_e_ro3_esc_w_ro3_hop_sr3_d_stub_tg_d_a_y_g_vddr_m1_mnt_g_s1_vddr_m1_s2_vddr_m1_s3_vddr_m1_s4_vddr_m1_vddr_vddr1 r0 *1 0,0
Ccc_a_d_inva_a_mn12_g0_mp13_g0_ro3_ro3_esc_e_ro3_esc_w_ro3_hop_sr3_d_stub_tg_d_a_y_g_vddr_m1_mnt_g_s1_vddr_m1_s2_vddr_m1_s3_vddr_m1_s4_vddr_m1_vddr_vddr1
+ a|d|inva_a|mn12_g0|mp13_g0|ro3|ro3_esc_e|ro3_esc_w|ro3_hop|sr3_d_stub|tg_d_a|y
+ g_vddr_m1|mnt_g|s1_vddr_m1|s2_vddr_m1|s3_vddr_m1|s4_vddr_m1|vddr|vddr1
+ 3.869e-18
* device instance cc_a_d_inva_a_mn12_g0_mp13_g0_ro3_ro3_esc_e_ro3_esc_w_ro3_hop_sr3_d_stub_tg_d_a_y_g_vss_m1_inv_clk_vss_inv_mc_vss_inv_q_vss_mph_g_nand_m_vss_nand_s2_vss_s1_vss_m1_s2_vss_m1_s3_vss_m1_s4_vss_m1_sb_vss_sr1_vss_sr2_vss_sr3_vss_sr4_vss_sv_vss_tg_d_vss_tg_fbm_vss_tg_fbs_vss_tg_s_vss_vss_vss_link_vss_link_bridge_vss_link_dip_vss_link_m1_vss_x1_vss_x2_vss_x3 r0 *1 0,0
Ccc_a_d_inva_a_mn12_g0_mp13_g0_ro3_ro3_esc_e_ro3_esc_w_ro3_hop_sr3_d_stub_tg_d_a_y_g_vss_m1_inv_clk_vss_inv_mc_vss_inv_q_vss_mph_g_nand_m_vss_nand_s2_vss_s1_vss_m1_s2_vss_m1_s3_vss_m1_s4_vss_m1_sb_vss_sr1_vss_sr2_vss_sr3_vss_sr4_vss_sv_vss_tg_d_vss_tg_fbm_vss_tg_fbs_vss_tg_s_vss_vss_vss_link_vss_link_bridge_vss_link_dip_vss_link_m1_vss_x1_vss_x2_vss_x3
+ a|d|inva_a|mn12_g0|mp13_g0|ro3|ro3_esc_e|ro3_esc_w|ro3_hop|sr3_d_stub|tg_d_a|y
+ g_vss_m1|inv_clk_vss|inv_mc_vss|inv_q_vss|mph_g|nand_m_vss|nand_s2_vss|s1_vss_m1|s2_vss_m1|s3_vss_m1|s4_vss_m1|sb_vss|sr1_vss|sr2_vss|sr3_vss|sr4_vss|sv_vss|tg_d_vss|tg_fbm_vss|tg_fbs_vss|tg_s_vss|vss|vss_link|vss_link_bridge|vss_link_dip|vss_link_m1|vss_x1|vss_x2|vss_x3
+ 3.125e-17
* device instance cc_a_d_sb_d_stub_tg_d_a_xo_xo_dip_xo_hop_xo_stub_y_a_inva_a_mn12_g0_mp13_g0_t1_y r0 *1 0,0
Ccc_a_d_sb_d_stub_tg_d_a_xo_xo_dip_xo_hop_xo_stub_y_a_inva_a_mn12_g0_mp13_g0_t1_y
+ a|d|sb_d_stub|tg_d_a|xo|xo_dip|xo_hop|xo_stub|y a|inva_a|mn12_g0|mp13_g0|t1|y
+ 1.1037e-17
* device instance cc_a_d_sb_d_stub_tg_d_a_xo_xo_dip_xo_hop_xo_stub_y_an_inva_y_mn34_g0_mp13_g1_y r0 *1 0,0
Ccc_a_d_sb_d_stub_tg_d_a_xo_xo_dip_xo_hop_xo_stub_y_an_inva_y_mn34_g0_mp13_g1_y
+ a|d|sb_d_stub|tg_d_a|xo|xo_dip|xo_hop|xo_stub|y an|inva_y|mn34_g0|mp13_g1|y$2
+ 3.3e-18
* device instance cc_a_d_sb_d_stub_tg_d_a_xo_xo_dip_xo_hop_xo_stub_y_bn_invb_y_mn34_g1_mp24_g1_y r0 *1 0,0
Ccc_a_d_sb_d_stub_tg_d_a_xo_xo_dip_xo_hop_xo_stub_y_bn_invb_y_mn34_g1_mp24_g1_y
+ a|d|sb_d_stub|tg_d_a|xo|xo_dip|xo_hop|xo_stub|y bn|invb_y|mn34_g1|mp24_g1|y$2
+ 9.901e-18
* device instance cc_a_d_sb_d_stub_tg_d_a_xo_xo_dip_xo_hop_xo_stub_y_clkb_clkb_bridge1_clkb_bridge2_clkb_mid_clkb_w_ctrl_ctrlb_inv_clk_y_tg_d_ctrlb_tg_fbm_ctrl_tg_fbs_ctrlb_tg_s_ctrl_y r0 *1 0,0
Ccc_a_d_sb_d_stub_tg_d_a_xo_xo_dip_xo_hop_xo_stub_y_clkb_clkb_bridge1_clkb_bridge2_clkb_mid_clkb_w_ctrl_ctrlb_inv_clk_y_tg_d_ctrlb_tg_fbm_ctrl_tg_fbs_ctrlb_tg_s_ctrl_y
+ a|d|sb_d_stub|tg_d_a|xo|xo_dip|xo_hop|xo_stub|y
+ clkb|clkb_bridge1|clkb_bridge2|clkb_mid|clkb_w|ctrl|ctrlb|inv_clk_y|tg_d_ctrlb|tg_fbm_ctrl|tg_fbs_ctrlb|tg_s_ctrl|y$5
+ 8.337e-18
* device instance cc_a_d_sb_d_stub_tg_d_a_xo_xo_dip_xo_hop_xo_stub_y_mid r0 *1 0,0
Ccc_a_d_sb_d_stub_tg_d_a_xo_xo_dip_xo_hop_xo_stub_y_mid
+ a|d|sb_d_stub|tg_d_a|xo|xo_dip|xo_hop|xo_stub|y mid$2 8.154e-18
* device instance cc_a_g_a_rn1_ro_s4_y_y_a_g_y_mnab_y_mpa_y_mpb_y_n1_s1_a_y r0 *1 0,0
Ccc_a_g_a_rn1_ro_s4_y_y_a_g_y_mnab_y_mpa_y_mpb_y_n1_s1_a_y a|g_a|rn1|ro|s4_y|y
+ a|g_y|mnab_y|mpa_y|mpb_y|n1|s1_a|y$3 6.626e-18
* device instance cc_a_g_a_rn1_ro_s4_y_y_g_vddr_m1_mnt_g_s1_vddr_m1_s2_vddr_m1_s3_vddr_m1_s4_vddr_m1_vddr_vddr1 r0 *1 0,0
Ccc_a_g_a_rn1_ro_s4_y_y_g_vddr_m1_mnt_g_s1_vddr_m1_s2_vddr_m1_s3_vddr_m1_s4_vddr_m1_vddr_vddr1
+ a|g_a|rn1|ro|s4_y|y
+ g_vddr_m1|mnt_g|s1_vddr_m1|s2_vddr_m1|s3_vddr_m1|s4_vddr_m1|vddr|vddr1
+ 1.5474e-17
* device instance cc_a_g_a_rn2_ro_s4_y_y_a_g_y_mnab_y_mpa_y_mpb_y_n1_s1_a_y r0 *1 0,0
Ccc_a_g_a_rn2_ro_s4_y_y_a_g_y_mnab_y_mpa_y_mpb_y_n1_s1_a_y a|g_a|rn2|ro|s4_y|y
+ a|g_y|mnab_y|mpa_y|mpb_y|n1|s1_a|y$3 6.626e-18
* device instance cc_a_g_a_rn2_ro_s4_y_y_g_vddr_m1_mnt_g_s1_vddr_m1_s2_vddr_m1_s3_vddr_m1_s4_vddr_m1_vddr_vddr2 r0 *1 0,0
Ccc_a_g_a_rn2_ro_s4_y_y_g_vddr_m1_mnt_g_s1_vddr_m1_s2_vddr_m1_s3_vddr_m1_s4_vddr_m1_vddr_vddr2
+ a|g_a|rn2|ro|s4_y|y
+ g_vddr_m1|mnt_g|s1_vddr_m1|s2_vddr_m1|s3_vddr_m1|s4_vddr_m1|vddr|vddr2
+ 1.5474e-17
* device instance cc_a_g_a_rn3_ro_s4_y_y_a_g_y_mnab_y_mpa_y_mpb_y_n1_s1_a_y r0 *1 0,0
Ccc_a_g_a_rn3_ro_s4_y_y_a_g_y_mnab_y_mpa_y_mpb_y_n1_s1_a_y a|g_a|rn3|ro|s4_y|y
+ a|g_y|mnab_y|mpa_y|mpb_y|n1|s1_a|y$3 6.626e-18
* device instance cc_a_g_a_rn3_ro_s4_y_y_g_vddr_m1_mnt_g_s1_vddr_m1_s2_vddr_m1_s3_vddr_m1_s4_vddr_m1_vddr_vddr3 r0 *1 0,0
Ccc_a_g_a_rn3_ro_s4_y_y_g_vddr_m1_mnt_g_s1_vddr_m1_s2_vddr_m1_s3_vddr_m1_s4_vddr_m1_vddr_vddr3
+ a|g_a|rn3|ro|s4_y|y
+ g_vddr_m1|mnt_g|s1_vddr_m1|s2_vddr_m1|s3_vddr_m1|s4_vddr_m1|vddr|vddr3
+ 1.5474e-17
* device instance cc_a_g_a_rn4_ro_s4_y_y_a_g_y_mnab_y_mpa_y_mpb_y_n1_s1_a_y r0 *1 0,0
Ccc_a_g_a_rn4_ro_s4_y_y_a_g_y_mnab_y_mpa_y_mpb_y_n1_s1_a_y a|g_a|rn4|ro|s4_y|y
+ a|g_y|mnab_y|mpa_y|mpb_y|n1|s1_a|y$3 6.626e-18
* device instance cc_a_g_a_rn4_ro_s4_y_y_g_vddr_m1_mnt_g_s1_vddr_m1_s2_vddr_m1_s3_vddr_m1_s4_vddr_m1_vddr_vddr4 r0 *1 0,0
Ccc_a_g_a_rn4_ro_s4_y_y_g_vddr_m1_mnt_g_s1_vddr_m1_s2_vddr_m1_s3_vddr_m1_s4_vddr_m1_vddr_vddr4
+ a|g_a|rn4|ro|s4_y|y
+ g_vddr_m1|mnt_g|s1_vddr_m1|s2_vddr_m1|s3_vddr_m1|s4_vddr_m1|vddr|vddr4
+ 1.5474e-17
* device instance cc_a_g_a_rn4_ro_s4_y_y_g_vss_m1_inv_clk_vss_inv_mc_vss_inv_q_vss_mph_g_nand_m_vss_nand_s2_vss_s1_vss_m1_s2_vss_m1_s3_vss_m1_s4_vss_m1_sb_vss_sr1_vss_sr2_vss_sr3_vss_sr4_vss_sv_vss_tg_d_vss_tg_fbm_vss_tg_fbs_vss_tg_s_vss_vss_vss_link_vss_link_bridge_vss_link_dip_vss_link_m1_vss_x1_vss_x2_vss_x3 r0 *1 0,0
Ccc_a_g_a_rn4_ro_s4_y_y_g_vss_m1_inv_clk_vss_inv_mc_vss_inv_q_vss_mph_g_nand_m_vss_nand_s2_vss_s1_vss_m1_s2_vss_m1_s3_vss_m1_s4_vss_m1_sb_vss_sr1_vss_sr2_vss_sr3_vss_sr4_vss_sv_vss_tg_d_vss_tg_fbm_vss_tg_fbs_vss_tg_s_vss_vss_vss_link_vss_link_bridge_vss_link_dip_vss_link_m1_vss_x1_vss_x2_vss_x3
+ a|g_a|rn4|ro|s4_y|y
+ g_vss_m1|inv_clk_vss|inv_mc_vss|inv_q_vss|mph_g|nand_m_vss|nand_s2_vss|s1_vss_m1|s2_vss_m1|s3_vss_m1|s4_vss_m1|sb_vss|sr1_vss|sr2_vss|sr3_vss|sr4_vss|sv_vss|tg_d_vss|tg_fbm_vss|tg_fbs_vss|tg_s_vss|vss|vss_link|vss_link_bridge|vss_link_dip|vss_link_m1|vss_x1|vss_x2|vss_x3
+ 2.7612e-17
* device instance cc_a_g_y_mnab_y_mpa_y_mpb_y_n1_s1_a_y_g_vss_m1_inv_clk_vss_inv_mc_vss_inv_q_vss_mph_g_nand_m_vss_nand_s2_vss_s1_vss_m1_s2_vss_m1_s3_vss_m1_s4_vss_m1_sb_vss_sr1_vss_sr2_vss_sr3_vss_sr4_vss_sv_vss_tg_d_vss_tg_fbm_vss_tg_fbs_vss_tg_s_vss_vss_vss_link_vss_link_bridge_vss_link_dip_vss_link_m1_vss_x1_vss_x2_vss_x3 r0 *1 0,0
Ccc_a_g_y_mnab_y_mpa_y_mpb_y_n1_s1_a_y_g_vss_m1_inv_clk_vss_inv_mc_vss_inv_q_vss_mph_g_nand_m_vss_nand_s2_vss_s1_vss_m1_s2_vss_m1_s3_vss_m1_s4_vss_m1_sb_vss_sr1_vss_sr2_vss_sr3_vss_sr4_vss_sv_vss_tg_d_vss_tg_fbm_vss_tg_fbs_vss_tg_s_vss_vss_vss_link_vss_link_bridge_vss_link_dip_vss_link_m1_vss_x1_vss_x2_vss_x3
+ a|g_y|mnab_y|mpa_y|mpb_y|n1|s1_a|y$3
+ g_vss_m1|inv_clk_vss|inv_mc_vss|inv_q_vss|mph_g|nand_m_vss|nand_s2_vss|s1_vss_m1|s2_vss_m1|s3_vss_m1|s4_vss_m1|sb_vss|sr1_vss|sr2_vss|sr3_vss|sr4_vss|sv_vss|tg_d_vss|tg_fbm_vss|tg_fbs_vss|tg_s_vss|vss|vss_link|vss_link_bridge|vss_link_dip|vss_link_m1|vss_x1|vss_x2|vss_x3
+ 1.5474e-17
* device instance cc_a_g_y_mnab_y_mpa_y_mpb_y_n1_s1_a_y_ny r0 *1 0,0
Ccc_a_g_y_mnab_y_mpa_y_mpb_y_n1_s1_a_y_ny a|g_y|mnab_y|mpa_y|mpb_y|n1|s1_a|y$3
+ ny$19 3.0903e-17
* device instance cc_a_inv_mc_a_mb_mnab_y_mpa_y_mpb_y_nand_m_y_tg_s_a_y_a_inv_mc_y_inv_mc_y_via_mc_tg_fbm_a_tg_fbm_a_via_y r0 *1 0,0
Ccc_a_inv_mc_a_mb_mnab_y_mpa_y_mpb_y_nand_m_y_tg_s_a_y_a_inv_mc_y_inv_mc_y_via_mc_tg_fbm_a_tg_fbm_a_via_y
+ a|inv_mc_a|mb|mnab_y|mpa_y|mpb_y|nand_m_y|tg_s_a|y$5
+ a|inv_mc_y|inv_mc_y_via|mc|tg_fbm_a|tg_fbm_a_via|y$5 1.37451e-16
* device instance cc_a_inv_mc_a_mb_mnab_y_mpa_y_mpb_y_nand_m_y_tg_s_a_y_clkb_clkb_bridge1_clkb_bridge2_clkb_mid_clkb_w_ctrl_ctrlb_inv_clk_y_tg_d_ctrlb_tg_fbm_ctrl_tg_fbs_ctrlb_tg_s_ctrl_y r0 *1 0,0
Ccc_a_inv_mc_a_mb_mnab_y_mpa_y_mpb_y_nand_m_y_tg_s_a_y_clkb_clkb_bridge1_clkb_bridge2_clkb_mid_clkb_w_ctrl_ctrlb_inv_clk_y_tg_d_ctrlb_tg_fbm_ctrl_tg_fbs_ctrlb_tg_s_ctrl_y
+ a|inv_mc_a|mb|mnab_y|mpa_y|mpb_y|nand_m_y|tg_s_a|y$5
+ clkb|clkb_bridge1|clkb_bridge2|clkb_mid|clkb_w|ctrl|ctrlb|inv_clk_y|tg_d_ctrlb|tg_fbm_ctrl|tg_fbs_ctrlb|tg_s_ctrl|y$5
+ 7.8925e-17
* device instance cc_a_inv_mc_a_mb_mnab_y_mpa_y_mpb_y_nand_m_y_tg_s_a_y_en_nand_m_en_nand_m_en_via_nand_s2_en_nand_s2_en_via_rst_n r0 *1 0,0
Ccc_a_inv_mc_a_mb_mnab_y_mpa_y_mpb_y_nand_m_y_tg_s_a_y_en_nand_m_en_nand_m_en_via_nand_s2_en_nand_s2_en_via_rst_n
+ a|inv_mc_a|mb|mnab_y|mpa_y|mpb_y|nand_m_y|tg_s_a|y$5
+ en|nand_m_en|nand_m_en_via|nand_s2_en|nand_s2_en_via|rst_n 9.2845e-17
* device instance cc_a_inv_mc_y_inv_mc_y_via_mc_tg_fbm_a_tg_fbm_a_via_y_clkb_clkb_bridge1_clkb_bridge2_clkb_mid_clkb_w_ctrl_ctrlb_inv_clk_y_tg_d_ctrlb_tg_fbm_ctrl_tg_fbs_ctrlb_tg_s_ctrl_y r0 *1 0,0
Ccc_a_inv_mc_y_inv_mc_y_via_mc_tg_fbm_a_tg_fbm_a_via_y_clkb_clkb_bridge1_clkb_bridge2_clkb_mid_clkb_w_ctrl_ctrlb_inv_clk_y_tg_d_ctrlb_tg_fbm_ctrl_tg_fbs_ctrlb_tg_s_ctrl_y
+ a|inv_mc_y|inv_mc_y_via|mc|tg_fbm_a|tg_fbm_a_via|y$5
+ clkb|clkb_bridge1|clkb_bridge2|clkb_mid|clkb_w|ctrl|ctrlb|inv_clk_y|tg_d_ctrlb|tg_fbm_ctrl|tg_fbs_ctrlb|tg_s_ctrl|y$5
+ 1.23251e-16
* device instance cc_a_inv_q_y_inv_q_y_via_inv_q_y_via2_nand_s2_a_nand_s2_a_stub_nand_s2_a_via_nand_s2_a_via2_q_y_a_mnab_y_mpa_y_mpb_y_nand_s2_y_qb_tg_fbs_a_y r0 *1 0,0
Ccc_a_inv_q_y_inv_q_y_via_inv_q_y_via2_nand_s2_a_nand_s2_a_stub_nand_s2_a_via_nand_s2_a_via2_q_y_a_mnab_y_mpa_y_mpb_y_nand_s2_y_qb_tg_fbs_a_y
+ a|inv_q_y|inv_q_y_via|inv_q_y_via2|nand_s2_a|nand_s2_a_stub|nand_s2_a_via|nand_s2_a_via2|q|y$5
+ a|mnab_y|mpa_y|mpb_y|nand_s2_y|qb|tg_fbs_a|y$5 1.09393e-16
* device instance cc_a_inv_q_y_inv_q_y_via_inv_q_y_via2_nand_s2_a_nand_s2_a_stub_nand_s2_a_via_nand_s2_a_via2_q_y_clkb_clkb_bridge1_clkb_bridge2_clkb_mid_clkb_w_ctrl_ctrlb_inv_clk_y_tg_d_ctrlb_tg_fbm_ctrl_tg_fbs_ctrlb_tg_s_ctrl_y r0 *1 0,0
Ccc_a_inv_q_y_inv_q_y_via_inv_q_y_via2_nand_s2_a_nand_s2_a_stub_nand_s2_a_via_nand_s2_a_via2_q_y_clkb_clkb_bridge1_clkb_bridge2_clkb_mid_clkb_w_ctrl_ctrlb_inv_clk_y_tg_d_ctrlb_tg_fbm_ctrl_tg_fbs_ctrlb_tg_s_ctrl_y
+ a|inv_q_y|inv_q_y_via|inv_q_y_via2|nand_s2_a|nand_s2_a_stub|nand_s2_a_via|nand_s2_a_via2|q|y$5
+ clkb|clkb_bridge1|clkb_bridge2|clkb_mid|clkb_w|ctrl|ctrlb|inv_clk_y|tg_d_ctrlb|tg_fbm_ctrl|tg_fbs_ctrlb|tg_s_ctrl|y$5
+ 5.002e-17
* device instance cc_a_inva_a_mn12_g0_mp13_g0_t1_y_an_inva_y_mn34_g0_mp13_g1_y r0 *1 0,0
Ccc_a_inva_a_mn12_g0_mp13_g0_t1_y_an_inva_y_mn34_g0_mp13_g1_y
+ a|inva_a|mn12_g0|mp13_g0|t1|y an|inva_y|mn34_g0|mp13_g1|y$2 3.3e-18
* device instance cc_a_inva_a_mn12_g0_mp13_g0_t1_y_bn_invb_y_mn34_g1_mp24_g1_y r0 *1 0,0
Ccc_a_inva_a_mn12_g0_mp13_g0_t1_y_bn_invb_y_mn34_g1_mp24_g1_y
+ a|inva_a|mn12_g0|mp13_g0|t1|y bn|invb_y|mn34_g1|mp24_g1|y$2 9.901e-18
* device instance cc_a_inva_a_mn12_g0_mp13_g0_t1_y_g_vss_m1_inv_clk_vss_inv_mc_vss_inv_q_vss_mph_g_nand_m_vss_nand_s2_vss_s1_vss_m1_s2_vss_m1_s3_vss_m1_s4_vss_m1_sb_vss_sr1_vss_sr2_vss_sr3_vss_sr4_vss_sv_vss_tg_d_vss_tg_fbm_vss_tg_fbs_vss_tg_s_vss_vss_vss_link_vss_link_bridge_vss_link_dip_vss_link_m1_vss_x1_vss_x2_vss_x3 r0 *1 0,0
Ccc_a_inva_a_mn12_g0_mp13_g0_t1_y_g_vss_m1_inv_clk_vss_inv_mc_vss_inv_q_vss_mph_g_nand_m_vss_nand_s2_vss_s1_vss_m1_s2_vss_m1_s3_vss_m1_s4_vss_m1_sb_vss_sr1_vss_sr2_vss_sr3_vss_sr4_vss_sv_vss_tg_d_vss_tg_fbm_vss_tg_fbs_vss_tg_s_vss_vss_vss_link_vss_link_bridge_vss_link_dip_vss_link_m1_vss_x1_vss_x2_vss_x3
+ a|inva_a|mn12_g0|mp13_g0|t1|y
+ g_vss_m1|inv_clk_vss|inv_mc_vss|inv_q_vss|mph_g|nand_m_vss|nand_s2_vss|s1_vss_m1|s2_vss_m1|s3_vss_m1|s4_vss_m1|sb_vss|sr1_vss|sr2_vss|sr3_vss|sr4_vss|sv_vss|tg_d_vss|tg_fbm_vss|tg_fbs_vss|tg_s_vss|vss|vss_link|vss_link_bridge|vss_link_dip|vss_link_m1|vss_x1|vss_x2|vss_x3
+ 1.3955e-17
* device instance cc_a_inva_a_mn12_g0_mp13_g0_t1_y_mid r0 *1 0,0
Ccc_a_inva_a_mn12_g0_mp13_g0_t1_y_mid a|inva_a|mn12_g0|mp13_g0|t1|y mid$2
+ 3.3e-18
* device instance cc_a_mnab_y_mpa_y_mpb_y_nand_s2_y_qb_tg_fbs_a_y_clkb_clkb_bridge1_clkb_bridge2_clkb_mid_clkb_w_ctrl_ctrlb_inv_clk_y_tg_d_ctrlb_tg_fbm_ctrl_tg_fbs_ctrlb_tg_s_ctrl_y r0 *1 0,0
Ccc_a_mnab_y_mpa_y_mpb_y_nand_s2_y_qb_tg_fbs_a_y_clkb_clkb_bridge1_clkb_bridge2_clkb_mid_clkb_w_ctrl_ctrlb_inv_clk_y_tg_d_ctrlb_tg_fbm_ctrl_tg_fbs_ctrlb_tg_s_ctrl_y
+ a|mnab_y|mpa_y|mpb_y|nand_s2_y|qb|tg_fbs_a|y$5
+ clkb|clkb_bridge1|clkb_bridge2|clkb_mid|clkb_w|ctrl|ctrlb|inv_clk_y|tg_d_ctrlb|tg_fbm_ctrl|tg_fbs_ctrlb|tg_s_ctrl|y$5
+ 5.6964e-17
* device instance cc_a_n2_s1_y_s2_a_y_g_vss_m1_inv_clk_vss_inv_mc_vss_inv_q_vss_mph_g_nand_m_vss_nand_s2_vss_s1_vss_m1_s2_vss_m1_s3_vss_m1_s4_vss_m1_sb_vss_sr1_vss_sr2_vss_sr3_vss_sr4_vss_sv_vss_tg_d_vss_tg_fbm_vss_tg_fbs_vss_tg_s_vss_vss_vss_link_vss_link_bridge_vss_link_dip_vss_link_m1_vss_x1_vss_x2_vss_x3 r0 *1 0,0
Ccc_a_n2_s1_y_s2_a_y_g_vss_m1_inv_clk_vss_inv_mc_vss_inv_q_vss_mph_g_nand_m_vss_nand_s2_vss_s1_vss_m1_s2_vss_m1_s3_vss_m1_s4_vss_m1_sb_vss_sr1_vss_sr2_vss_sr3_vss_sr4_vss_sv_vss_tg_d_vss_tg_fbm_vss_tg_fbs_vss_tg_s_vss_vss_vss_link_vss_link_bridge_vss_link_dip_vss_link_m1_vss_x1_vss_x2_vss_x3
+ a|n2|s1_y|s2_a|y$3
+ g_vss_m1|inv_clk_vss|inv_mc_vss|inv_q_vss|mph_g|nand_m_vss|nand_s2_vss|s1_vss_m1|s2_vss_m1|s3_vss_m1|s4_vss_m1|sb_vss|sr1_vss|sr2_vss|sr3_vss|sr4_vss|sv_vss|tg_d_vss|tg_fbm_vss|tg_fbs_vss|tg_s_vss|vss|vss_link|vss_link_bridge|vss_link_dip|vss_link_m1|vss_x1|vss_x2|vss_x3
+ 1.5474e-17
* device instance cc_a_n2_s1_y_s2_a_y_ny r0 *1 0,0
Ccc_a_n2_s1_y_s2_a_y_ny a|n2|s1_y|s2_a|y$3 ny$19 3.0903e-17
* device instance cc_a_n3_s2_y_s3_a_y_g_vss_m1_inv_clk_vss_inv_mc_vss_inv_q_vss_mph_g_nand_m_vss_nand_s2_vss_s1_vss_m1_s2_vss_m1_s3_vss_m1_s4_vss_m1_sb_vss_sr1_vss_sr2_vss_sr3_vss_sr4_vss_sv_vss_tg_d_vss_tg_fbm_vss_tg_fbs_vss_tg_s_vss_vss_vss_link_vss_link_bridge_vss_link_dip_vss_link_m1_vss_x1_vss_x2_vss_x3 r0 *1 0,0
Ccc_a_n3_s2_y_s3_a_y_g_vss_m1_inv_clk_vss_inv_mc_vss_inv_q_vss_mph_g_nand_m_vss_nand_s2_vss_s1_vss_m1_s2_vss_m1_s3_vss_m1_s4_vss_m1_sb_vss_sr1_vss_sr2_vss_sr3_vss_sr4_vss_sv_vss_tg_d_vss_tg_fbm_vss_tg_fbs_vss_tg_s_vss_vss_vss_link_vss_link_bridge_vss_link_dip_vss_link_m1_vss_x1_vss_x2_vss_x3
+ a|n3|s2_y|s3_a|y$3
+ g_vss_m1|inv_clk_vss|inv_mc_vss|inv_q_vss|mph_g|nand_m_vss|nand_s2_vss|s1_vss_m1|s2_vss_m1|s3_vss_m1|s4_vss_m1|sb_vss|sr1_vss|sr2_vss|sr3_vss|sr4_vss|sv_vss|tg_d_vss|tg_fbm_vss|tg_fbs_vss|tg_s_vss|vss|vss_link|vss_link_bridge|vss_link_dip|vss_link_m1|vss_x1|vss_x2|vss_x3
+ 1.5474e-17
* device instance cc_a_n3_s2_y_s3_a_y_ny r0 *1 0,0
Ccc_a_n3_s2_y_s3_a_y_ny a|n3|s2_y|s3_a|y$3 ny$19 3.0903e-17
* device instance cc_a_n4_s3_y_s4_a_y_g_vss_m1_inv_clk_vss_inv_mc_vss_inv_q_vss_mph_g_nand_m_vss_nand_s2_vss_s1_vss_m1_s2_vss_m1_s3_vss_m1_s4_vss_m1_sb_vss_sr1_vss_sr2_vss_sr3_vss_sr4_vss_sv_vss_tg_d_vss_tg_fbm_vss_tg_fbs_vss_tg_s_vss_vss_vss_link_vss_link_bridge_vss_link_dip_vss_link_m1_vss_x1_vss_x2_vss_x3 r0 *1 0,0
Ccc_a_n4_s3_y_s4_a_y_g_vss_m1_inv_clk_vss_inv_mc_vss_inv_q_vss_mph_g_nand_m_vss_nand_s2_vss_s1_vss_m1_s2_vss_m1_s3_vss_m1_s4_vss_m1_sb_vss_sr1_vss_sr2_vss_sr3_vss_sr4_vss_sv_vss_tg_d_vss_tg_fbm_vss_tg_fbs_vss_tg_s_vss_vss_vss_link_vss_link_bridge_vss_link_dip_vss_link_m1_vss_x1_vss_x2_vss_x3
+ a|n4|s3_y|s4_a|y$3
+ g_vss_m1|inv_clk_vss|inv_mc_vss|inv_q_vss|mph_g|nand_m_vss|nand_s2_vss|s1_vss_m1|s2_vss_m1|s3_vss_m1|s4_vss_m1|sb_vss|sr1_vss|sr2_vss|sr3_vss|sr4_vss|sv_vss|tg_d_vss|tg_fbm_vss|tg_fbs_vss|tg_s_vss|vss|vss_link|vss_link_bridge|vss_link_dip|vss_link_m1|vss_x1|vss_x2|vss_x3
+ 1.5474e-17
* device instance cc_a_n4_s3_y_s4_a_y_ny r0 *1 0,0
Ccc_a_n4_s3_y_s4_a_y_ny a|n4|s3_y|s4_a|y$3 ny$19 3.0903e-17
* device instance cc_bn_invb_y_mn34_g1_mp24_g1_y_mid r0 *1 0,0
Ccc_bn_invb_y_mn34_g1_mp24_g1_y_mid bn|invb_y|mn34_g1|mp24_g1|y$2 mid$2
+ 9.901e-18
* device instance cc_clkb_clkb_bridge1_clkb_bridge2_clkb_mid_clkb_w_ctrl_ctrlb_inv_clk_y_tg_d_ctrlb_tg_fbm_ctrl_tg_fbs_ctrlb_tg_s_ctrl_y_en_nand_m_en_nand_m_en_via_nand_s2_en_nand_s2_en_via_rst_n r0 *1 0,0
Ccc_clkb_clkb_bridge1_clkb_bridge2_clkb_mid_clkb_w_ctrl_ctrlb_inv_clk_y_tg_d_ctrlb_tg_fbm_ctrl_tg_fbs_ctrlb_tg_s_ctrl_y_en_nand_m_en_nand_m_en_via_nand_s2_en_nand_s2_en_via_rst_n
+ clkb|clkb_bridge1|clkb_bridge2|clkb_mid|clkb_w|ctrl|ctrlb|inv_clk_y|tg_d_ctrlb|tg_fbm_ctrl|tg_fbs_ctrlb|tg_s_ctrl|y$5
+ en|nand_m_en|nand_m_en_via|nand_s2_en|nand_s2_en_via|rst_n 5.11091e-16
* device instance cc_clkb_clkb_bridge1_clkb_bridge2_clkb_mid_clkb_w_ctrl_ctrlb_inv_clk_y_tg_d_ctrlb_tg_fbm_ctrl_tg_fbs_ctrlb_tg_s_ctrl_y_g_vss_m1_inv_clk_vss_inv_mc_vss_inv_q_vss_mph_g_nand_m_vss_nand_s2_vss_s1_vss_m1_s2_vss_m1_s3_vss_m1_s4_vss_m1_sb_vss_sr1_vss_sr2_vss_sr3_vss_sr4_vss_sv_vss_tg_d_vss_tg_fbm_vss_tg_fbs_vss_tg_s_vss_vss_vss_link_vss_link_bridge_vss_link_dip_vss_link_m1_vss_x1_vss_x2_vss_x3 r0 *1 0,0
Ccc_clkb_clkb_bridge1_clkb_bridge2_clkb_mid_clkb_w_ctrl_ctrlb_inv_clk_y_tg_d_ctrlb_tg_fbm_ctrl_tg_fbs_ctrlb_tg_s_ctrl_y_g_vss_m1_inv_clk_vss_inv_mc_vss_inv_q_vss_mph_g_nand_m_vss_nand_s2_vss_s1_vss_m1_s2_vss_m1_s3_vss_m1_s4_vss_m1_sb_vss_sr1_vss_sr2_vss_sr3_vss_sr4_vss_sv_vss_tg_d_vss_tg_fbm_vss_tg_fbs_vss_tg_s_vss_vss_vss_link_vss_link_bridge_vss_link_dip_vss_link_m1_vss_x1_vss_x2_vss_x3
+ clkb|clkb_bridge1|clkb_bridge2|clkb_mid|clkb_w|ctrl|ctrlb|inv_clk_y|tg_d_ctrlb|tg_fbm_ctrl|tg_fbs_ctrlb|tg_s_ctrl|y$5
+ g_vss_m1|inv_clk_vss|inv_mc_vss|inv_q_vss|mph_g|nand_m_vss|nand_s2_vss|s1_vss_m1|s2_vss_m1|s3_vss_m1|s4_vss_m1|sb_vss|sr1_vss|sr2_vss|sr3_vss|sr4_vss|sv_vss|tg_d_vss|tg_fbm_vss|tg_fbs_vss|tg_s_vss|vss|vss_link|vss_link_bridge|vss_link_dip|vss_link_m1|vss_x1|vss_x2|vss_x3
+ 5.12256e-16
* device instance cc_en_nand_m_en_nand_m_en_via_nand_s2_en_nand_s2_en_via_rst_n_g_vss_m1_inv_clk_vss_inv_mc_vss_inv_q_vss_mph_g_nand_m_vss_nand_s2_vss_s1_vss_m1_s2_vss_m1_s3_vss_m1_s4_vss_m1_sb_vss_sr1_vss_sr2_vss_sr3_vss_sr4_vss_sv_vss_tg_d_vss_tg_fbm_vss_tg_fbs_vss_tg_s_vss_vss_vss_link_vss_link_bridge_vss_link_dip_vss_link_m1_vss_x1_vss_x2_vss_x3 r0 *1 0,0
Ccc_en_nand_m_en_nand_m_en_via_nand_s2_en_nand_s2_en_via_rst_n_g_vss_m1_inv_clk_vss_inv_mc_vss_inv_q_vss_mph_g_nand_m_vss_nand_s2_vss_s1_vss_m1_s2_vss_m1_s3_vss_m1_s4_vss_m1_sb_vss_sr1_vss_sr2_vss_sr3_vss_sr4_vss_sv_vss_tg_d_vss_tg_fbm_vss_tg_fbs_vss_tg_s_vss_vss_vss_link_vss_link_bridge_vss_link_dip_vss_link_m1_vss_x1_vss_x2_vss_x3
+ en|nand_m_en|nand_m_en_via|nand_s2_en|nand_s2_en_via|rst_n
+ g_vss_m1|inv_clk_vss|inv_mc_vss|inv_q_vss|mph_g|nand_m_vss|nand_s2_vss|s1_vss_m1|s2_vss_m1|s3_vss_m1|s4_vss_m1|sb_vss|sr1_vss|sr2_vss|sr3_vss|sr4_vss|sv_vss|tg_d_vss|tg_fbm_vss|tg_fbs_vss|tg_s_vss|vss|vss_link|vss_link_bridge|vss_link_dip|vss_link_m1|vss_x1|vss_x2|vss_x3
+ 3.869e-18
* device instance cc_g_vddr_m1_mnt_g_s1_vddr_m1_s2_vddr_m1_s3_vddr_m1_s4_vddr_m1_vddr_vddr1_py r0 *1 0,0
Ccc_g_vddr_m1_mnt_g_s1_vddr_m1_s2_vddr_m1_s3_vddr_m1_s4_vddr_m1_vddr_vddr1_py
+ g_vddr_m1|mnt_g|s1_vddr_m1|s2_vddr_m1|s3_vddr_m1|s4_vddr_m1|vddr|vddr1 py$15
+ 1.2471e-17
* device instance cc_g_vddr_m1_mnt_g_s1_vddr_m1_s2_vddr_m1_s3_vddr_m1_s4_vddr_m1_vddr_vddr2_py r0 *1 0,0
Ccc_g_vddr_m1_mnt_g_s1_vddr_m1_s2_vddr_m1_s3_vddr_m1_s4_vddr_m1_vddr_vddr2_py
+ g_vddr_m1|mnt_g|s1_vddr_m1|s2_vddr_m1|s3_vddr_m1|s4_vddr_m1|vddr|vddr2 py$15
+ 1.3064e-17
* device instance cc_g_vddr_m1_mnt_g_s1_vddr_m1_s2_vddr_m1_s3_vddr_m1_s4_vddr_m1_vddr_vddr3_py r0 *1 0,0
Ccc_g_vddr_m1_mnt_g_s1_vddr_m1_s2_vddr_m1_s3_vddr_m1_s4_vddr_m1_vddr_vddr3_py
+ g_vddr_m1|mnt_g|s1_vddr_m1|s2_vddr_m1|s3_vddr_m1|s4_vddr_m1|vddr|vddr3 py$15
+ 1.3658e-17
* device instance cc_g_vddr_m1_mnt_g_s1_vddr_m1_s2_vddr_m1_s3_vddr_m1_s4_vddr_m1_vddr_vddr4_py r0 *1 0,0
Ccc_g_vddr_m1_mnt_g_s1_vddr_m1_s2_vddr_m1_s3_vddr_m1_s4_vddr_m1_vddr_vddr4_py
+ g_vddr_m1|mnt_g|s1_vddr_m1|s2_vddr_m1|s3_vddr_m1|s4_vddr_m1|vddr|vddr4 py$15
+ 1.4252e-17
* device instance vsubs_dctie r0 *1 0,0
Rvsubs_dctie vsubs 0 1e+12
.ENDS sampler_core
