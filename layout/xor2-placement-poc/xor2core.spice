* extracted by klt extract --deck sky130

* cell xor2core
* pin mn12_g0
* pin mn12_g1
* pin mn12_s0
* pin mn12_s1
* pin mn34_g0
* pin mn34_g1
* pin mn34_s0
* pin mn34_s1
* pin mnia_d
* pin mnia_g
* pin mnia_s
* pin mnib_d
* pin mnib_g
* pin mnib_s
* pin mp1_d
* pin mp1_g
* pin mp1_s
* pin mp2_d
* pin mp2_g
* pin mp2_s
* pin mp3_d
* pin mp3_g
* pin mp3_s
* pin mp4_d
* pin mp4_g
* pin mp4_s
* pin mpia_d
* pin mpia_g
* pin mpia_s
* pin mpib_d
* pin mpib_g
* pin mpib_s
* pin psub_tap_n
* pin tap1_s
* pin tap2_s
* pin tap3_s
* pin tap4_s
* pin tapia_e,tapia_n
* pin tapib_e,tapib_n
.SUBCKT xor2core mn12_g0 mn12_g1 mn12_s0 mn12_s1 mn34_g0 mn34_g1 mn34_s0
+ mn34_s1 mnia_d mnia_g mnia_s mnib_d mnib_g mnib_s mp1_d mp1_g mp1_s mp2_d
+ mp2_g mp2_s mp3_d mp3_g mp3_s mp4_d mp4_g mp4_s mpia_d mpia_g mpia_s mpib_d
+ mpib_g mpib_s psub_tap_n tap1_s tap2_s tap3_s tap4_s tapia_e|tapia_n
+ tapib_e|tapib_n
* device instance $1 r0 *1 0.545,0.21 nfet
M$1 mnia_d mnia_g mnia_s psub_tap_n nfet L=0.15U W=0.42U AS=0.1974P AD=0.1974P
+ PS=1.78U PD=1.78U
* device instance $2 r0 *1 8.545,0.21 nfet
M$2 mnib_d mnib_g mnib_s psub_tap_n nfet L=0.15U W=0.42U AS=0.1974P AD=0.1974P
+ PS=1.78U PD=1.78U
* device instance $3 r0 *1 16.545,0.42 nfet
M$3 \$13 mn12_g0 mn12_s0 psub_tap_n nfet L=0.15U W=0.84U AS=0.3948P AD=0.2184P
+ PS=2.62U PD=1.36U
* device instance $4 r0 *1 17.215,0.42 nfet
M$4 mn12_s1 mn12_g1 \$13 psub_tap_n nfet L=0.15U W=0.84U AS=0.2184P AD=0.3948P
+ PS=1.36U PD=2.62U
* device instance $5 r0 *1 28.545,0.42 nfet
M$5 \$16 mn34_g0 mn34_s0 psub_tap_n nfet L=0.15U W=0.84U AS=0.3948P AD=0.2184P
+ PS=2.62U PD=1.36U
* device instance $6 r0 *1 29.215,0.42 nfet
M$6 mn34_s1 mn34_g1 \$16 psub_tap_n nfet L=0.15U W=0.84U AS=0.2184P AD=0.3948P
+ PS=1.36U PD=2.62U
* device instance $7 r0 *1 0.545,10.58 pfet
M$7 mpia_d mpia_g mpia_s tapia_e|tapia_n pfet L=0.15U W=0.84U AS=0.3948P
+ AD=0.3948P PS=2.62U PD=2.62U
* device instance $8 r0 *1 8.545,10.58 pfet
M$8 mpib_d mpib_g mpib_s tapib_e|tapib_n pfet L=0.15U W=0.84U AS=0.3948P
+ AD=0.3948P PS=2.62U PD=2.62U
* device instance $9 r0 *1 16.545,11.84 pfet
M$9 mp1_d mp1_g mp1_s tap1_s pfet L=0.15U W=1.68U AS=0.7896P AD=0.7896P PS=4.3U
+ PD=4.3U
* device instance $10 r0 *1 22.545,11.84 pfet
M$10 mp2_d mp2_g mp2_s tap2_s pfet L=0.15U W=1.68U AS=0.7896P AD=0.7896P
+ PS=4.3U PD=4.3U
* device instance $11 r0 *1 28.545,11.84 pfet
M$11 mp3_d mp3_g mp3_s tap3_s pfet L=0.15U W=1.68U AS=0.7896P AD=0.7896P
+ PS=4.3U PD=4.3U
* device instance $12 r0 *1 34.545,11.84 pfet
M$12 mp4_d mp4_g mp4_s tap4_s pfet L=0.15U W=1.68U AS=0.7896P AD=0.7896P
+ PS=4.3U PD=4.3U
.ENDS xor2core
