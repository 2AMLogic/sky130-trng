* Reference netlist for sampler_dff LVS -- GENERATED by layout/bin/compose-cell.py
* Source: design/sampler_core.spice .subckt sampler_dff
* Only unit spellings (and any substituted subckt parameter)
* differ from the source -- see compose-cell.py's docstring.
.subckt sampler_dff d clk rst_n q vdd vss
*.ipin d
*.ipin clk
*.ipin rst_n
*.opin q
*.iopin vdd
*.iopin vss
XMpc clkb clk vdd vdd sky130_fd_pr__pfet_01v8 L=0.15u W=0.84u nf=1 ad=0.2436 as=0.2436 pd=2.26 ps=2.26
+ nrd=0.345238095238095 nrs=0.345238095238095 sa=0 sb=0 sd=0 mult=1 m=1
XMnc clkb clk vss vss sky130_fd_pr__nfet_01v8 L=0.15u W=0.42u nf=1 ad=0.1218 as=0.1218 pd=1.42 ps=1.42
+ nrd=0.69047619047619 nrs=0.69047619047619 sa=0 sb=0 sd=0 mult=1 m=1
XMtdp d clk m vdd sky130_fd_pr__pfet_01v8 L=0.15u W=0.84u nf=1 ad=0.2436 as=0.2436 pd=2.26 ps=2.26 nrd=0.345238095238095
+ nrs=0.345238095238095 sa=0 sb=0 sd=0 mult=1 m=1
XMtdn d clkb m vss sky130_fd_pr__nfet_01v8 L=0.15u W=0.42u nf=1 ad=0.1218 as=0.1218 pd=1.42 ps=1.42 nrd=0.69047619047619
+ nrs=0.69047619047619 sa=0 sb=0 sd=0 mult=1 m=1
XMimpa mb m vdd vdd sky130_fd_pr__pfet_01v8 L=0.15u W=0.84u nf=1 ad=0.2436 as=0.2436 pd=2.26 ps=2.26 nrd=0.345238095238095
+ nrs=0.345238095238095 sa=0 sb=0 sd=0 mult=1 m=1
XMimpb mb rst_n vdd vdd sky130_fd_pr__pfet_01v8 L=0.15u W=0.84u nf=1 ad=0.2436 as=0.2436 pd=2.26 ps=2.26
+ nrd=0.345238095238095 nrs=0.345238095238095 sa=0 sb=0 sd=0 mult=1 m=1
XMimna mb m mmid vss sky130_fd_pr__nfet_01v8 L=0.15u W=0.84u nf=1 ad=0.2436 as=0.2436 pd=2.26 ps=2.26
+ nrd=0.345238095238095 nrs=0.345238095238095 sa=0 sb=0 sd=0 mult=1 m=1
XMimnb mmid rst_n vss vss sky130_fd_pr__nfet_01v8 L=0.15u W=0.84u nf=1 ad=0.2436 as=0.2436 pd=2.26 ps=2.26
+ nrd=0.345238095238095 nrs=0.345238095238095 sa=0 sb=0 sd=0 mult=1 m=1
XMim2p mc mb vdd vdd sky130_fd_pr__pfet_01v8 L=0.15u W=0.84u nf=1 ad=0.2436 as=0.2436 pd=2.26 ps=2.26
+ nrd=0.345238095238095 nrs=0.345238095238095 sa=0 sb=0 sd=0 mult=1 m=1
XMim2n mc mb vss vss sky130_fd_pr__nfet_01v8 L=0.15u W=0.42u nf=1 ad=0.1218 as=0.1218 pd=1.42 ps=1.42 nrd=0.69047619047619
+ nrs=0.69047619047619 sa=0 sb=0 sd=0 mult=1 m=1
XMfmp mc clkb m vdd sky130_fd_pr__pfet_01v8 L=0.15u W=0.84u nf=1 ad=0.2436 as=0.2436 pd=2.26 ps=2.26 nrd=0.345238095238095
+ nrs=0.345238095238095 sa=0 sb=0 sd=0 mult=1 m=1
XMfmn mc clk m vss sky130_fd_pr__nfet_01v8 L=0.15u W=0.42u nf=1 ad=0.1218 as=0.1218 pd=1.42 ps=1.42 nrd=0.69047619047619
+ nrs=0.69047619047619 sa=0 sb=0 sd=0 mult=1 m=1
XMtsp mb clkb s vdd sky130_fd_pr__pfet_01v8 L=0.15u W=0.84u nf=1 ad=0.2436 as=0.2436 pd=2.26 ps=2.26 nrd=0.345238095238095
+ nrs=0.345238095238095 sa=0 sb=0 sd=0 mult=1 m=1
XMtsn mb clk s vss sky130_fd_pr__nfet_01v8 L=0.15u W=0.42u nf=1 ad=0.1218 as=0.1218 pd=1.42 ps=1.42 nrd=0.69047619047619
+ nrs=0.69047619047619 sa=0 sb=0 sd=0 mult=1 m=1
XMisp q s vdd vdd sky130_fd_pr__pfet_01v8 L=0.15u W=0.84u nf=1 ad=0.2436 as=0.2436 pd=2.26 ps=2.26 nrd=0.345238095238095
+ nrs=0.345238095238095 sa=0 sb=0 sd=0 mult=1 m=1
XMisn q s vss vss sky130_fd_pr__nfet_01v8 L=0.15u W=0.42u nf=1 ad=0.1218 as=0.1218 pd=1.42 ps=1.42 nrd=0.69047619047619
+ nrs=0.69047619047619 sa=0 sb=0 sd=0 mult=1 m=1
XMis2pa qb q vdd vdd sky130_fd_pr__pfet_01v8 L=0.15u W=0.84u nf=1 ad=0.2436 as=0.2436 pd=2.26 ps=2.26
+ nrd=0.345238095238095 nrs=0.345238095238095 sa=0 sb=0 sd=0 mult=1 m=1
XMis2pb qb rst_n vdd vdd sky130_fd_pr__pfet_01v8 L=0.15u W=0.84u nf=1 ad=0.2436 as=0.2436 pd=2.26 ps=2.26
+ nrd=0.345238095238095 nrs=0.345238095238095 sa=0 sb=0 sd=0 mult=1 m=1
XMis2na qb q s2mid vss sky130_fd_pr__nfet_01v8 L=0.15u W=0.84u nf=1 ad=0.2436 as=0.2436 pd=2.26 ps=2.26
+ nrd=0.345238095238095 nrs=0.345238095238095 sa=0 sb=0 sd=0 mult=1 m=1
XMis2nb s2mid rst_n vss vss sky130_fd_pr__nfet_01v8 L=0.15u W=0.84u nf=1 ad=0.2436 as=0.2436 pd=2.26 ps=2.26
+ nrd=0.345238095238095 nrs=0.345238095238095 sa=0 sb=0 sd=0 mult=1 m=1
XMfsp qb clk s vdd sky130_fd_pr__pfet_01v8 L=0.15u W=0.84u nf=1 ad=0.2436 as=0.2436 pd=2.26 ps=2.26 nrd=0.345238095238095
+ nrs=0.345238095238095 sa=0 sb=0 sd=0 mult=1 m=1
XMfsn qb clkb s vss sky130_fd_pr__nfet_01v8 L=0.15u W=0.42u nf=1 ad=0.1218 as=0.1218 pd=1.42 ps=1.42 nrd=0.69047619047619
+ nrs=0.69047619047619 sa=0 sb=0 sd=0 mult=1 m=1
.ends
