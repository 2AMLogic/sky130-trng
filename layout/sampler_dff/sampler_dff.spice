* extracted by klt extract --deck sky130

* cell sampler_dff
* pin a,inv_clk_a
* pin a,inv_mc_a
* pin a,inv_q_a
* pin a,nand_m_a
* pin a,nand_s2_a
* pin a,tg_d_a
* pin a,tg_fbm_a
* pin a,tg_fbs_a
* pin a,tg_s_a
* pin b,tg_d_b
* pin b,tg_fbm_b
* pin b,tg_fbs_b
* pin b,tg_s_b
* pin ctrl,tg_d_ctrl
* pin ctrl,tg_fbm_ctrl
* pin ctrl,tg_fbs_ctrl
* pin ctrl,tg_s_ctrl
* pin ctrlb,tg_d_ctrlb
* pin ctrlb,tg_fbm_ctrlb
* pin ctrlb,tg_fbs_ctrlb
* pin ctrlb,tg_s_ctrlb
* pin en,nand_m_en
* pin en,nand_s2_en
* pin inv_clk_vdd,inv_mc_vdd,inv_q_vdd,mpa_py,mpb_py,nand_m_vdd,nand_s2_vdd,nwell_vdd,tg_d_vdd,tg_fbm_vdd,tg_fbs_vdd,tg_s_vdd,vdd
* pin inv_clk_vss,inv_mc_vss,inv_q_vss,nand_m_vss,nand_s2_vss,tg_d_vss,tg_fbm_vss,tg_fbs_vss,tg_s_vss,vss
* pin inv_clk_y,y
* pin inv_mc_y,y
* pin inv_q_y,y
* pin mnab_y,mpa_y,mpb_y,nand_m_y,y
* pin mnab_y,mpa_y,mpb_y,nand_s2_y,y
.SUBCKT sampler_dff a|inv_clk_a a|inv_mc_a a|inv_q_a a|nand_m_a a|nand_s2_a
+ a|tg_d_a a|tg_fbm_a a|tg_fbs_a a|tg_s_a b|tg_d_b b|tg_fbm_b b|tg_fbs_b
+ b|tg_s_b ctrl|tg_d_ctrl ctrl|tg_fbm_ctrl ctrl|tg_fbs_ctrl ctrl|tg_s_ctrl
+ ctrlb|tg_d_ctrlb ctrlb|tg_fbm_ctrlb ctrlb|tg_fbs_ctrlb ctrlb|tg_s_ctrlb
+ en|nand_m_en en|nand_s2_en
+ inv_clk_vdd|inv_mc_vdd|inv_q_vdd|mpa_py|mpb_py|nand_m_vdd|nand_s2_vdd|nwell_vdd|tg_d_vdd|tg_fbm_vdd|tg_fbs_vdd|tg_s_vdd|vdd
+ inv_clk_vss|inv_mc_vss|inv_q_vss|nand_m_vss|nand_s2_vss|tg_d_vss|tg_fbm_vss|tg_fbs_vss|tg_s_vss|vss
+ inv_clk_y|y inv_mc_y|y inv_q_y|y mnab_y|mpa_y|mpb_y|nand_m_y|y
+ mnab_y|mpa_y|mpb_y|nand_s2_y|y
* device instance $1 r0 *1 0.545,0.21 nfet
M$1 inv_clk_y|y a|inv_clk_a
+ inv_clk_vss|inv_mc_vss|inv_q_vss|nand_m_vss|nand_s2_vss|tg_d_vss|tg_fbm_vss|tg_fbs_vss|tg_s_vss|vss
+ inv_clk_vss|inv_mc_vss|inv_q_vss|nand_m_vss|nand_s2_vss|tg_d_vss|tg_fbm_vss|tg_fbs_vss|tg_s_vss|vss
+ nfet L=0.15U W=0.42U AS=0.1974P AD=0.1974P PS=1.78U PD=1.78U
* device instance $2 r0 *1 5.31,0.21 nfet
M$2 a|tg_d_a ctrlb|tg_d_ctrlb b|tg_d_b
+ inv_clk_vss|inv_mc_vss|inv_q_vss|nand_m_vss|nand_s2_vss|tg_d_vss|tg_fbm_vss|tg_fbs_vss|tg_s_vss|vss
+ nfet L=0.15U W=0.42U AS=0.1974P AD=0.1974P PS=1.78U PD=1.78U
* device instance $3 r0 *1 19.835,0.21 nfet
M$3 inv_mc_y|y a|inv_mc_a
+ inv_clk_vss|inv_mc_vss|inv_q_vss|nand_m_vss|nand_s2_vss|tg_d_vss|tg_fbm_vss|tg_fbs_vss|tg_s_vss|vss
+ inv_clk_vss|inv_mc_vss|inv_q_vss|nand_m_vss|nand_s2_vss|tg_d_vss|tg_fbm_vss|tg_fbs_vss|tg_s_vss|vss
+ nfet L=0.15U W=0.42U AS=0.1974P AD=0.1974P PS=1.78U PD=1.78U
* device instance $4 r0 *1 24.6,0.21 nfet
M$4 a|tg_fbm_a ctrlb|tg_fbm_ctrlb b|tg_fbm_b
+ inv_clk_vss|inv_mc_vss|inv_q_vss|nand_m_vss|nand_s2_vss|tg_d_vss|tg_fbm_vss|tg_fbs_vss|tg_s_vss|vss
+ nfet L=0.15U W=0.42U AS=0.1974P AD=0.1974P PS=1.78U PD=1.78U
* device instance $5 r0 *1 29.74,0.21 nfet
M$5 a|tg_s_a ctrlb|tg_s_ctrlb b|tg_s_b
+ inv_clk_vss|inv_mc_vss|inv_q_vss|nand_m_vss|nand_s2_vss|tg_d_vss|tg_fbm_vss|tg_fbs_vss|tg_s_vss|vss
+ nfet L=0.15U W=0.42U AS=0.1974P AD=0.1974P PS=1.78U PD=1.78U
* device instance $6 r0 *1 36.545,0.21 nfet
M$6 inv_q_y|y a|inv_q_a
+ inv_clk_vss|inv_mc_vss|inv_q_vss|nand_m_vss|nand_s2_vss|tg_d_vss|tg_fbm_vss|tg_fbs_vss|tg_s_vss|vss
+ inv_clk_vss|inv_mc_vss|inv_q_vss|nand_m_vss|nand_s2_vss|tg_d_vss|tg_fbm_vss|tg_fbs_vss|tg_s_vss|vss
+ nfet L=0.15U W=0.42U AS=0.1974P AD=0.1974P PS=1.78U PD=1.78U
* device instance $7 r0 *1 49.03,0.21 nfet
M$7 a|tg_fbs_a ctrlb|tg_fbs_ctrlb b|tg_fbs_b
+ inv_clk_vss|inv_mc_vss|inv_q_vss|nand_m_vss|nand_s2_vss|tg_d_vss|tg_fbm_vss|tg_fbs_vss|tg_s_vss|vss
+ nfet L=0.15U W=0.42U AS=0.1974P AD=0.1974P PS=1.78U PD=1.78U
* device instance $8 r0 *1 12.315,0.21 nfet
M$8 \$13 en|nand_m_en
+ inv_clk_vss|inv_mc_vss|inv_q_vss|nand_m_vss|nand_s2_vss|tg_d_vss|tg_fbm_vss|tg_fbs_vss|tg_s_vss|vss
+ inv_clk_vss|inv_mc_vss|inv_q_vss|nand_m_vss|nand_s2_vss|tg_d_vss|tg_fbm_vss|tg_fbs_vss|tg_s_vss|vss
+ nfet L=0.15U W=0.84U AS=0.3948P AD=0.2184P PS=2.62U PD=1.36U
* device instance $9 r0 *1 12.985,0.21 nfet
M$9 mnab_y|mpa_y|mpb_y|nand_m_y|y a|nand_m_a \$13
+ inv_clk_vss|inv_mc_vss|inv_q_vss|nand_m_vss|nand_s2_vss|tg_d_vss|tg_fbm_vss|tg_fbs_vss|tg_s_vss|vss
+ nfet L=0.15U W=0.84U AS=0.2184P AD=0.3948P PS=1.36U PD=2.62U
* device instance $10 r0 *1 43.175,0.21 nfet
M$10 \$21 en|nand_s2_en
+ inv_clk_vss|inv_mc_vss|inv_q_vss|nand_m_vss|nand_s2_vss|tg_d_vss|tg_fbm_vss|tg_fbs_vss|tg_s_vss|vss
+ inv_clk_vss|inv_mc_vss|inv_q_vss|nand_m_vss|nand_s2_vss|tg_d_vss|tg_fbm_vss|tg_fbs_vss|tg_s_vss|vss
+ nfet L=0.15U W=0.84U AS=0.3948P AD=0.2184P PS=2.62U PD=1.36U
* device instance $11 r0 *1 43.845,0.21 nfet
M$11 mnab_y|mpa_y|mpb_y|nand_s2_y|y a|nand_s2_a \$21
+ inv_clk_vss|inv_mc_vss|inv_q_vss|nand_m_vss|nand_s2_vss|tg_d_vss|tg_fbm_vss|tg_fbs_vss|tg_s_vss|vss
+ nfet L=0.15U W=0.84U AS=0.2184P AD=0.3948P PS=1.36U PD=2.62U
* device instance $12 r0 *1 0.545,3.53 pfet
M$12 inv_clk_y|y a|inv_clk_a
+ inv_clk_vdd|inv_mc_vdd|inv_q_vdd|mpa_py|mpb_py|nand_m_vdd|nand_s2_vdd|nwell_vdd|tg_d_vdd|tg_fbm_vdd|tg_fbs_vdd|tg_s_vdd|vdd
+ inv_clk_vdd|inv_mc_vdd|inv_q_vdd|mpa_py|mpb_py|nand_m_vdd|nand_s2_vdd|nwell_vdd|tg_d_vdd|tg_fbm_vdd|tg_fbs_vdd|tg_s_vdd|vdd
+ pfet L=0.15U W=0.84U AS=0.3948P AD=0.3948P PS=2.62U PD=2.62U
* device instance $13 r0 *1 5.31,3.53 pfet
M$13 a|tg_d_a ctrl|tg_d_ctrl b|tg_d_b
+ inv_clk_vdd|inv_mc_vdd|inv_q_vdd|mpa_py|mpb_py|nand_m_vdd|nand_s2_vdd|nwell_vdd|tg_d_vdd|tg_fbm_vdd|tg_fbs_vdd|tg_s_vdd|vdd
+ pfet L=0.15U W=0.84U AS=0.3948P AD=0.3948P PS=2.62U PD=2.62U
* device instance $14 r0 *1 19.835,3.53 pfet
M$14 inv_mc_y|y a|inv_mc_a
+ inv_clk_vdd|inv_mc_vdd|inv_q_vdd|mpa_py|mpb_py|nand_m_vdd|nand_s2_vdd|nwell_vdd|tg_d_vdd|tg_fbm_vdd|tg_fbs_vdd|tg_s_vdd|vdd
+ inv_clk_vdd|inv_mc_vdd|inv_q_vdd|mpa_py|mpb_py|nand_m_vdd|nand_s2_vdd|nwell_vdd|tg_d_vdd|tg_fbm_vdd|tg_fbs_vdd|tg_s_vdd|vdd
+ pfet L=0.15U W=0.84U AS=0.3948P AD=0.3948P PS=2.62U PD=2.62U
* device instance $15 r0 *1 24.6,3.53 pfet
M$15 a|tg_fbm_a ctrl|tg_fbm_ctrl b|tg_fbm_b
+ inv_clk_vdd|inv_mc_vdd|inv_q_vdd|mpa_py|mpb_py|nand_m_vdd|nand_s2_vdd|nwell_vdd|tg_d_vdd|tg_fbm_vdd|tg_fbs_vdd|tg_s_vdd|vdd
+ pfet L=0.15U W=0.84U AS=0.3948P AD=0.3948P PS=2.62U PD=2.62U
* device instance $16 r0 *1 29.74,3.53 pfet
M$16 a|tg_s_a ctrl|tg_s_ctrl b|tg_s_b
+ inv_clk_vdd|inv_mc_vdd|inv_q_vdd|mpa_py|mpb_py|nand_m_vdd|nand_s2_vdd|nwell_vdd|tg_d_vdd|tg_fbm_vdd|tg_fbs_vdd|tg_s_vdd|vdd
+ pfet L=0.15U W=0.84U AS=0.3948P AD=0.3948P PS=2.62U PD=2.62U
* device instance $17 r0 *1 36.545,3.53 pfet
M$17 inv_q_y|y a|inv_q_a
+ inv_clk_vdd|inv_mc_vdd|inv_q_vdd|mpa_py|mpb_py|nand_m_vdd|nand_s2_vdd|nwell_vdd|tg_d_vdd|tg_fbm_vdd|tg_fbs_vdd|tg_s_vdd|vdd
+ inv_clk_vdd|inv_mc_vdd|inv_q_vdd|mpa_py|mpb_py|nand_m_vdd|nand_s2_vdd|nwell_vdd|tg_d_vdd|tg_fbm_vdd|tg_fbs_vdd|tg_s_vdd|vdd
+ pfet L=0.15U W=0.84U AS=0.3948P AD=0.3948P PS=2.62U PD=2.62U
* device instance $18 r0 *1 49.03,3.53 pfet
M$18 a|tg_fbs_a ctrl|tg_fbs_ctrl b|tg_fbs_b
+ inv_clk_vdd|inv_mc_vdd|inv_q_vdd|mpa_py|mpb_py|nand_m_vdd|nand_s2_vdd|nwell_vdd|tg_d_vdd|tg_fbm_vdd|tg_fbs_vdd|tg_s_vdd|vdd
+ pfet L=0.15U W=0.84U AS=0.3948P AD=0.3948P PS=2.62U PD=2.62U
* device instance $19 r0 *1 12.115,3.74 pfet
M$19 mnab_y|mpa_y|mpb_y|nand_m_y|y en|nand_m_en
+ inv_clk_vdd|inv_mc_vdd|inv_q_vdd|mpa_py|mpb_py|nand_m_vdd|nand_s2_vdd|nwell_vdd|tg_d_vdd|tg_fbm_vdd|tg_fbs_vdd|tg_s_vdd|vdd
+ inv_clk_vdd|inv_mc_vdd|inv_q_vdd|mpa_py|mpb_py|nand_m_vdd|nand_s2_vdd|nwell_vdd|tg_d_vdd|tg_fbm_vdd|tg_fbs_vdd|tg_s_vdd|vdd
+ pfet L=0.15U W=0.84U AS=0.3948P AD=0.3948P PS=2.62U PD=2.62U
* device instance $20 r0 *1 13.405,3.74 pfet
M$20
+ inv_clk_vdd|inv_mc_vdd|inv_q_vdd|mpa_py|mpb_py|nand_m_vdd|nand_s2_vdd|nwell_vdd|tg_d_vdd|tg_fbm_vdd|tg_fbs_vdd|tg_s_vdd|vdd
+ a|nand_m_a mnab_y|mpa_y|mpb_y|nand_m_y|y
+ inv_clk_vdd|inv_mc_vdd|inv_q_vdd|mpa_py|mpb_py|nand_m_vdd|nand_s2_vdd|nwell_vdd|tg_d_vdd|tg_fbm_vdd|tg_fbs_vdd|tg_s_vdd|vdd
+ pfet L=0.15U W=0.84U AS=0.3948P AD=0.3948P PS=2.62U PD=2.62U
* device instance $21 r0 *1 42.975,3.74 pfet
M$21 mnab_y|mpa_y|mpb_y|nand_s2_y|y en|nand_s2_en
+ inv_clk_vdd|inv_mc_vdd|inv_q_vdd|mpa_py|mpb_py|nand_m_vdd|nand_s2_vdd|nwell_vdd|tg_d_vdd|tg_fbm_vdd|tg_fbs_vdd|tg_s_vdd|vdd
+ inv_clk_vdd|inv_mc_vdd|inv_q_vdd|mpa_py|mpb_py|nand_m_vdd|nand_s2_vdd|nwell_vdd|tg_d_vdd|tg_fbm_vdd|tg_fbs_vdd|tg_s_vdd|vdd
+ pfet L=0.15U W=0.84U AS=0.3948P AD=0.3948P PS=2.62U PD=2.62U
* device instance $22 r0 *1 44.265,3.74 pfet
M$22
+ inv_clk_vdd|inv_mc_vdd|inv_q_vdd|mpa_py|mpb_py|nand_m_vdd|nand_s2_vdd|nwell_vdd|tg_d_vdd|tg_fbm_vdd|tg_fbs_vdd|tg_s_vdd|vdd
+ a|nand_s2_a mnab_y|mpa_y|mpb_y|nand_s2_y|y
+ inv_clk_vdd|inv_mc_vdd|inv_q_vdd|mpa_py|mpb_py|nand_m_vdd|nand_s2_vdd|nwell_vdd|tg_d_vdd|tg_fbm_vdd|tg_fbs_vdd|tg_s_vdd|vdd
+ pfet L=0.15U W=0.84U AS=0.3948P AD=0.3948P PS=2.62U PD=2.62U
.ENDS sampler_dff
