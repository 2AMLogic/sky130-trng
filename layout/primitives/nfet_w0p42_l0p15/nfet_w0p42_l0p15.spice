* extracted by klt extract --deck sky130

* cell nfet_w0p42_l0p15
* pin vsubs
.SUBCKT nfet_w0p42_l0p15 vsubs
* device instance $1 r0 *1 0.545,0.21 nfet
M$1 \$2 \$3 \$1 vsubs nfet L=0.15U W=0.42U AS=0.1974P AD=0.1974P PS=1.78U
+ PD=1.78U
.ENDS nfet_w0p42_l0p15
