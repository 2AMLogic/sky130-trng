* extracted by klt extract --deck sky130

* cell pfet_starve_w0p42_l2
.SUBCKT pfet_starve_w0p42_l2
* device instance $1 r0 *1 1.42,0.21 pfet
M$1 \$2 \$3 \$1 \$4 pfet L=2U W=0.42U AS=0.1764P AD=0.1764P PS=1.68U PD=1.68U
.ENDS pfet_starve_w0p42_l2
