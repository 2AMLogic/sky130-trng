* extracted by klt extract --deck sky130

* cell pfet_w0p84_l0p15
.SUBCKT pfet_w0p84_l0p15
* device instance $1 r0 *1 0.545,0.42 pfet
M$1 \$2 \$3 \$1 \$4 pfet L=0.15U W=0.84U AS=0.3948P AD=0.3948P PS=2.62U PD=2.62U
.ENDS pfet_w0p84_l0p15
