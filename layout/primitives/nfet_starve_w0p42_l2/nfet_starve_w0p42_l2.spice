* extracted by klt extract --deck sky130

* cell nfet_starve_w0p42_l2
* pin vsubs
.SUBCKT nfet_starve_w0p42_l2 vsubs
* device instance $1 r0 *1 1.42,0.21 nfet
M$1 \$2 \$3 \$1 vsubs nfet L=2U W=0.42U AS=0.1764P AD=0.1764P PS=1.68U PD=1.68U
.ENDS nfet_starve_w0p42_l2
