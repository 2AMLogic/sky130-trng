* Post-layout (parasitic) subcircuit library -- GENERATED by
* layout/bin/pex-netlist.py from layout/pex/pex-sampler.json. Do not edit by
* hand: `python3 layout/bin/pex-netlist.py layout/pex/pex-sampler.json --check`
* re-extracts every cell from its committed GDS and fails if this file
* and that extraction disagree.
*
* Each cell below is `klt extract --pdk <variant> --parasitics` output
* over a composed, DRC-clean and LVS-clean cell under layout/. --pdk is
* what makes its device cards subcircuit calls on the PDK's own devices
* with unitless geometry (this repo's decks run at .option scale=1u), so
* NO device card, geometry value, R value, C value or connection is
* rewritten here. Two things are: extractor-joined net names are renamed
* to their design-level names, and a design-port-order wrapper is added
* per cell. See layout/bin/pex-netlist.py's module docstring for why,
* and layout/pex/README.md for what the parasitic model does and does
* not contain.
*
* Substrate return node: `vsubs`, declared .global below --
* klayout-tools#1503 (the extractor scopes it per-instance, which
* isolates every ground capacitance behind a 1 TOhm tie once the cell
* is instantiated rather than simulated flat). A deck including this
* library MUST tie the node itself; every sim/ record minted from it
* states which tie it used.

.global vsubs

*-----------------------------------------------------------------------
* sampler_inv_pex -- post-layout, from ../ro_buf/ro_buf.gds
* klt extract --parasitics: 2 devices, 4 nets
*-----------------------------------------------------------------------
.subckt sampler_inv_pex__core a vdd vss y
* device instance $1 r0 *1 0.545,0.21 nfet
Xn1 y__t0 a__t0 vss__t0 vss__t1 sky130_fd_pr__nfet_01v8 L=0.15 W=0.42 AS=0.1974 AD=0.1974 PS=1.78 PD=1.78
* device instance $2 r0 *1 0.545,3.53 pfet
Xn2 y__t1 a__t1 vdd__t0 vdd__t1 sky130_fd_pr__pfet_01v8 L=0.15 W=0.84 AS=0.3948 AD=0.3948 PS=2.62 PD=2.62
* device instance a_t0 r0 *1 0,0
Ra_t0 a__t0 a 228.9579
* device instance a_t1 r0 *1 0,0
Ra_t1 a__t1 a 228.9579
* device instance a r0 *1 0,0
Ca a vsubs 5.75883e-16
* device instance vdd_t0 r0 *1 0,0
Rvdd_t0 vdd__t0 vdd 98.9335
* device instance vdd_t1 r0 *1 0,0
Rvdd_t1 vdd__t1 vdd 98.9335
* device instance vdd r0 *1 0,0
Cvdd vdd vsubs 6.69937e-16
* device instance vss_t0 r0 *1 0,0
Rvss_t0 vss__t0 vss 95.08305
* device instance vss_t1 r0 *1 0,0
Rvss_t1 vss__t1 vss 95.08305
* device instance vss r0 *1 0,0
Cvss vss vsubs 6.37991e-16
* device instance y_t0 r0 *1 0,0
Ry_t0 y__t0 y 207.64565
* device instance y_t1 r0 *1 0,0
Ry_t1 y__t1 y 207.64565
* device instance y r0 *1 0,0
Cy y vsubs 6.09871e-16
* device instance vsubs_dctie r0 *1 0,0
Rvsubs_dctie vsubs 0 1e+12
.ends sampler_inv_pex__core

* sampler_inv_pex -- design-port-order wrapper over sampler_inv_pex__core.
* Promoted-internal layout pins kept local here: (none)
.subckt sampler_inv_pex a y vdd vss
xpex a vdd vss y sampler_inv_pex__core
.ends sampler_inv_pex

*-----------------------------------------------------------------------
* sampler_tg_pex -- post-layout, from ../sampler_tg/sampler_tg.gds
* klt extract --parasitics: 2 devices, 6 nets
*-----------------------------------------------------------------------
.subckt sampler_tg_pex__core a b ctrl ctrlb vdd vss
* device instance $1 r0 *1 0.545,0.21 nfet
Xn1 a__t0 ctrlb__t0 b__t0 vss__t0 sky130_fd_pr__nfet_01v8 L=0.15 W=0.42 AS=0.1974 AD=0.1974 PS=1.78 PD=1.78
* device instance $2 r0 *1 0.545,3.53 pfet
Xn2 a__t1 ctrl__t0 b__t1 vdd__t0 sky130_fd_pr__pfet_01v8 L=0.15 W=0.84 AS=0.3948 AD=0.3948 PS=2.62 PD=2.62
* device instance a_t0 r0 *1 0,0
Ra_t0 a__t0 a 207.64565
* device instance a_t1 r0 *1 0,0
Ra_t1 a__t1 a 207.64565
* device instance a r0 *1 0,0
Ca a vsubs 6.09871e-16
* device instance b_t0 r0 *1 0,0
Rb_t0 b__t0 b 170.151
* device instance b_t1 r0 *1 0,0
Rb_t1 b__t1 b 170.151
* device instance b r0 *1 0,0
Cb b vsubs 5.20427e-16
* device instance ctrl_t0 r0 *1 0,0
Rctrl_t0 ctrl__t0 ctrl 106.9048
* device instance ctrl r0 *1 0,0
Cctrl ctrl vsubs 2.48823e-16
* device instance ctrlb_t0 r0 *1 0,0
Rctrlb_t0 ctrlb__t0 ctrlb 106.9048
* device instance ctrlb r0 *1 0,0
Cctrlb ctrlb vsubs 2.48823e-16
* device instance vdd_t0 r0 *1 0,0
Rvdd_t0 vdd__t0 vdd 146.3855
* device instance vdd r0 *1 0,0
Cvdd vdd vsubs 5.50619e-16
* device instance vss_t0 r0 *1 0,0
Rvss_t0 vss__t0 vss 146.3855
* device instance vss r0 *1 0,0
Cvss vss vsubs 5.50619e-16
* device instance vsubs_dctie r0 *1 0,0
Rvsubs_dctie vsubs 0 1e+12
.ends sampler_tg_pex__core

* sampler_tg_pex -- design-port-order wrapper over sampler_tg_pex__core.
* Promoted-internal layout pins kept local here: (none)
.subckt sampler_tg_pex a b ctrl ctrlb vdd vss
xpex a b ctrl ctrlb vdd vss sampler_tg_pex__core
.ends sampler_tg_pex

*-----------------------------------------------------------------------
* sampler_nand2_pex -- post-layout, from ../sampler_nand2/sampler_nand2.gds
* klt extract --parasitics: 4 devices, 6 nets
*-----------------------------------------------------------------------
.subckt sampler_nand2_pex__core a en y vdd vss
* device instance $1 r0 *1 3.785,0.21 nfet
Xn1 n2__t0 en__t0 vss__t0 vss__t1 sky130_fd_pr__nfet_01v8 L=0.15 W=0.84 AS=0.3948 AD=0.2184 PS=2.62 PD=1.36
* device instance $2 r0 *1 4.455,0.21 nfet
Xn2 y__t0 a__t0 n2__t1 vss__t2 sky130_fd_pr__nfet_01v8 L=0.15 W=0.84 AS=0.2184 AD=0.3948 PS=1.36 PD=2.62
* device instance $3 r0 *1 3.585,3.74 pfet
Xn3 y__t1 en__t1 vdd__t2 vdd__t0 sky130_fd_pr__pfet_01v8 L=0.15 W=0.84 AS=0.3948 AD=0.3948 PS=2.62 PD=2.62
* device instance $4 r0 *1 4.875,3.74 pfet
Xn4 vdd__t3 a__t1 y__t2 vdd__t1 sky130_fd_pr__pfet_01v8 L=0.15 W=0.84 AS=0.3948 AD=0.3948 PS=2.62 PD=2.62
* device instance _2_t0 r0 *1 0,0
R_2_t0 n2__t0 n2 12.8
* device instance _2_t1 r0 *1 0,0
R_2_t1 n2__t1 n2 12.8
* device instance _2 r0 *1 0,0
C_2 n2 vsubs 1.15618e-16
* device instance a_t0 r0 *1 0,0
Ra_t0 a__t0 a 244.4331
* device instance a_t1 r0 *1 0,0
Ra_t1 a__t1 a 244.4331
* device instance a r0 *1 0,0
Ca a vsubs 6.07536e-16
* device instance en_t0 r0 *1 0,0
Ren_t0 en__t0 en 236.31895
* device instance en_t1 r0 *1 0,0
Ren_t1 en__t1 en 236.31895
* device instance en r0 *1 0,0
Cen en vsubs 5.93421e-16
* device instance mnab_y_mpa_y_mpb_y_y_t0 r0 *1 0,0
Rmnab_y_mpa_y_mpb_y_y_t0 y__t0 y 69.9207823784
* device instance mnab_y_mpa_y_mpb_y_y_t1 r0 *1 0,0
Rmnab_y_mpa_y_mpb_y_y_t1 y__t1 y 40.9030288926
* device instance mnab_y_mpa_y_mpb_y_y_t2 r0 *1 0,0
Rmnab_y_mpa_y_mpb_y_y_t2 y__t2 y 38.767688729
* device instance mnab_y_mpa_y_mpb_y_y r0 *1 0,0
Cmnab_y_mpa_y_mpb_y_y y vsubs 8.56767e-16
* device instance mpa_py_mpb_py_nwell_vdd_vdd_t0 r0 *1 0,0
Rmpa_py_mpb_py_nwell_vdd_vdd_t0 vdd__t0 vdd 63.868375
* device instance mpa_py_mpb_py_nwell_vdd_vdd_t1 r0 *1 0,0
Rmpa_py_mpb_py_nwell_vdd_vdd_t1 vdd__t1 vdd 63.868375
* device instance mpa_py_mpb_py_nwell_vdd_vdd_t2 r0 *1 0,0
Rmpa_py_mpb_py_nwell_vdd_vdd_t2 vdd__t2 vdd 63.868375
* device instance mpa_py_mpb_py_nwell_vdd_vdd_t3 r0 *1 0,0
Rmpa_py_mpb_py_nwell_vdd_vdd_t3 vdd__t3 vdd 63.868375
* device instance mpa_py_mpb_py_nwell_vdd_vdd r0 *1 0,0
Cmpa_py_mpb_py_nwell_vdd_vdd vdd vsubs 1.269718e-15
* device instance vss_t0 r0 *1 0,0
Rvss_t0 vss__t0 vss 51.765375
* device instance vss_t1 r0 *1 0,0
Rvss_t1 vss__t1 vss 51.765375
* device instance vss_t2 r0 *1 0,0
Rvss_t2 vss__t2 vss 103.53075
* device instance vss r0 *1 0,0
Cvss vss vsubs 6.85721e-16
* device instance cc_a_mnab_y_mpa_y_mpb_y_y r0 *1 0,0
Ccc_a_mnab_y_mpa_y_mpb_y_y a y 1.5977e-17
* device instance vsubs_dctie r0 *1 0,0
Rvsubs_dctie vsubs 0 1e+12
.ends sampler_nand2_pex__core

* sampler_nand2_pex -- design-port-order wrapper over sampler_nand2_pex__core.
* Promoted-internal layout pins kept local here: (none)
.subckt sampler_nand2_pex a en y vdd vss
xpex a en y vdd vss sampler_nand2_pex__core
.ends sampler_nand2_pex
