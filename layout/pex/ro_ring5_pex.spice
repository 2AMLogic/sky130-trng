* Post-layout (parasitic) subcircuit library -- GENERATED by
* layout/bin/pex-netlist.py from layout/pex/pex.json. Do not edit by
* hand: `python3 layout/bin/pex-netlist.py layout/pex/pex.json --check`
* re-extracts every cell from its committed GDS and fails if this file
* and that extraction disagree.
*
* Each cell below is `klt extract --pdk <variant> --parasitics` output
* over a composed, DRC-clean and LVS-clean cell under layout/. --pdk is
* what makes its device cards subcircuit calls on the PDK's own devices
* with unitless geometry (this repo's decks run at .option scale=1u), so
* NO device card, geometry value, R value, C value or connection is
* rewritten here. Two things are: extractor-joined net names are renamed
* to their design-level names, and a design-port-order wrapper is added
* per cell. See layout/bin/pex-netlist.py's module docstring for why,
* and layout/pex/README.md for what the parasitic model does and does
* not contain.
*
* Substrate return node: `vsubs`, declared .global below --
* klayout-tools#1503 (the extractor scopes it per-instance, which
* isolates every ground capacitance behind a 1 TOhm tie once the cell
* is instantiated rather than simulated flat). A deck including this
* library MUST tie the node itself; every sim/ record minted from it
* states which tie it used.

.global vsubs

*-----------------------------------------------------------------------
* ro_nand2_pex_wstv0p42 -- post-layout, from ../ro_nand2/ro_nand2.gds
* klt extract --parasitics: 6 devices, 8 nets
*-----------------------------------------------------------------------
.subckt ro_nand2_pex_wstv0p42__core a en y vddr py vss ny
* device instance $1 r0 *1 1.42,0.21 nfet
Xn1 ny__t0 vddr__t0 vss__t0 vss__t2 sky130_fd_pr__nfet_01v8 L=2 W=0.42 AS=0.1764 AD=0.1764 PS=1.68 PD=1.68
* device instance $2 r0 *1 3.785,0.21 nfet
Xn2 n3__t0 en__t0 ny__t1 vss__t3 sky130_fd_pr__nfet_01v8 L=0.15 W=0.84 AS=0.3948 AD=0.2184 PS=2.62 PD=1.36
* device instance $3 r0 *1 4.455,0.21 nfet
Xn3 y__t0 a__t0 n3__t1 vss__t4 sky130_fd_pr__nfet_01v8 L=0.15 W=0.84 AS=0.2184 AD=0.3948 PS=1.36 PD=2.62
* device instance $4 r0 *1 1.42,3.74 pfet
Xn4 py__t0 vss__t1 vddr__t1 vddr__t2 sky130_fd_pr__pfet_01v8 L=2 W=0.42 AS=0.1764 AD=0.1764 PS=1.68 PD=1.68
* device instance $5 r0 *1 3.585,3.74 pfet
Xn5 y__t1 en__t1 py__t1 vddr__t3 sky130_fd_pr__pfet_01v8 L=0.15 W=0.84 AS=0.3948 AD=0.3948 PS=2.62 PD=2.62
* device instance $6 r0 *1 4.875,3.74 pfet
Xn6 py__t2 a__t1 y__t2 vddr__t4 sky130_fd_pr__pfet_01v8 L=0.15 W=0.84 AS=0.3948 AD=0.3948 PS=2.62 PD=2.62
* device instance _3_t0 r0 *1 0,0
R_3_t0 n3__t0 n3 12.8
* device instance _3_t1 r0 *1 0,0
R_3_t1 n3__t1 n3 12.8
* device instance _3 r0 *1 0,0
C_3 n3 vsubs 1.15618e-16
* device instance a_t0 r0 *1 0,0
Ra_t0 a__t0 a 175.09895
* device instance a_t1 r0 *1 0,0
Ra_t1 a__t1 a 175.09895
* device instance a r0 *1 0,0
Ca a vsubs 6.07536e-16
* device instance en_t0 r0 *1 0,0
Ren_t0 en__t0 en 166.9848
* device instance en_t1 r0 *1 0,0
Ren_t1 en__t1 en 166.9848
* device instance en r0 *1 0,0
Cen en vsubs 5.93421e-16
* device instance mnab_y_mpa_y_mpb_y_y_t0 r0 *1 0,0
Rmnab_y_mpa_y_mpb_y_y_t0 y__t0 y 37.5392638434
* device instance mnab_y_mpa_y_mpb_y_y_t1 r0 *1 0,0
Rmnab_y_mpa_y_mpb_y_y_t1 y__t1 y 21.9601317572
* device instance mnab_y_mpa_y_mpb_y_y_t2 r0 *1 0,0
Rmnab_y_mpa_y_mpb_y_y_t2 y__t2 y 20.8137043994
* device instance mnab_y_mpa_y_mpb_y_y r0 *1 0,0
Cmnab_y_mpa_y_mpb_y_y y vsubs 8.56767e-16
* device instance mnt_g_vddr_t0 r0 *1 0,0
Rmnt_g_vddr_t0 vddr__t0 vddr 96.5964987762
* device instance mnt_g_vddr_t1 r0 *1 0,0
Rmnt_g_vddr_t1 vddr__t1 vddr 42.1836266243
* device instance mnt_g_vddr_t2 r0 *1 0,0
Rmnt_g_vddr_t2 vddr__t2 vddr 42.1836266243
* device instance mnt_g_vddr_t3 r0 *1 0,0
Rmnt_g_vddr_t3 vddr__t3 vddr 39.9745359616
* device instance mnt_g_vddr_t4 r0 *1 0,0
Rmnt_g_vddr_t4 vddr__t4 vddr 77.4042120137
* device instance mnt_g_vddr r0 *1 0,0
Cmnt_g_vddr vddr vsubs 1.70354e-15
* device instance mpa_py_mpb_py_mph_py_py_t0 r0 *1 0,0
Rmpa_py_mpb_py_mph_py_py_t0 py__t0 py 33.64835
* device instance mpa_py_mpb_py_mph_py_py_t1 r0 *1 0,0
Rmpa_py_mpb_py_mph_py_py_t1 py__t1 py 5.23884452847
* device instance mpa_py_mpb_py_mph_py_py_t2 r0 *1 0,0
Rmpa_py_mpb_py_mph_py_py_t2 py__t2 py 28.4095054715
* device instance mpa_py_mpb_py_mph_py_py r0 *1 0,0
Cmpa_py_mpb_py_mph_py_py py vsubs 7.94002e-16
* device instance mph_g_vss_t0 r0 *1 0,0
Rmph_g_vss_t0 vss__t0 vss 42.3862225375
* device instance mph_g_vss_t1 r0 *1 0,0
Rmph_g_vss_t1 vss__t1 vss 99.3218433158
* device instance mph_g_vss_t2 r0 *1 0,0
Rmph_g_vss_t2 vss__t2 vss 42.3862225375
* device instance mph_g_vss_t3 r0 *1 0,0
Rmph_g_vss_t3 vss__t3 vss 48.1641581156
* device instance mph_g_vss_t4 r0 *1 0,0
Rmph_g_vss_t4 vss__t4 vss 68.2816534936
* device instance mph_g_vss r0 *1 0,0
Cmph_g_vss vss vsubs 1.368791e-15
* device instance ny_t0 r0 *1 0,0
Rny_t0 ny__t0 ny 44.45845
* device instance ny_t1 r0 *1 0,0
Rny_t1 ny__t1 ny 44.45845
* device instance ny r0 *1 0,0
Cny ny vsubs 2.11758e-16
* device instance cc_a_mnab_y_mpa_y_mpb_y_y r0 *1 0,0
Ccc_a_mnab_y_mpa_y_mpb_y_y a y 1.5977e-17
* device instance vsubs_dctie r0 *1 0,0
Rvsubs_dctie vsubs 0 1e+12
.ends ro_nand2_pex_wstv0p42__core

* ro_nand2_pex_wstv0p42 -- design-port-order wrapper over ro_nand2_pex_wstv0p42__core.
* Promoted-internal layout pins kept local here: py, ny
.subckt ro_nand2_pex_wstv0p42 a en y vddr vss
xpex a en y vddr py vss ny ro_nand2_pex_wstv0p42__core
.ends ro_nand2_pex_wstv0p42

*-----------------------------------------------------------------------
* ro_nand2_pex_wstv0p44 -- post-layout, from ../ro_nand2_wstv0p44/ro_nand2_wstv0p44.gds
* klt extract --parasitics: 6 devices, 8 nets
*-----------------------------------------------------------------------
.subckt ro_nand2_pex_wstv0p44__core a en y vddr py vss ny
* device instance $1 r0 *1 1.42,0.21 nfet
Xn1 ny__t0 vddr__t0 vss__t0 vss__t2 sky130_fd_pr__nfet_01v8 L=2 W=0.44 AS=0.1848 AD=0.1848 PS=1.72 PD=1.72
* device instance $2 r0 *1 3.785,0.21 nfet
Xn2 n3__t0 en__t0 ny__t1 vss__t3 sky130_fd_pr__nfet_01v8 L=0.15 W=0.84 AS=0.3948 AD=0.2184 PS=2.62 PD=1.36
* device instance $3 r0 *1 4.455,0.21 nfet
Xn3 y__t0 a__t0 n3__t1 vss__t4 sky130_fd_pr__nfet_01v8 L=0.15 W=0.84 AS=0.2184 AD=0.3948 PS=1.36 PD=2.62
* device instance $4 r0 *1 1.42,3.74 pfet
Xn4 py__t0 vss__t1 vddr__t1 vddr__t2 sky130_fd_pr__pfet_01v8 L=2 W=0.44 AS=0.1848 AD=0.1848 PS=1.72 PD=1.72
* device instance $5 r0 *1 3.585,3.74 pfet
Xn5 y__t1 en__t1 py__t1 vddr__t3 sky130_fd_pr__pfet_01v8 L=0.15 W=0.84 AS=0.3948 AD=0.3948 PS=2.62 PD=2.62
* device instance $6 r0 *1 4.875,3.74 pfet
Xn6 py__t2 a__t1 y__t2 vddr__t4 sky130_fd_pr__pfet_01v8 L=0.15 W=0.84 AS=0.3948 AD=0.3948 PS=2.62 PD=2.62
* device instance _3_t0 r0 *1 0,0
R_3_t0 n3__t0 n3 12.8
* device instance _3_t1 r0 *1 0,0
R_3_t1 n3__t1 n3 12.8
* device instance _3 r0 *1 0,0
C_3 n3 vsubs 1.15618e-16
* device instance a_t0 r0 *1 0,0
Ra_t0 a__t0 a 175.09895
* device instance a_t1 r0 *1 0,0
Ra_t1 a__t1 a 175.09895
* device instance a r0 *1 0,0
Ca a vsubs 6.07536e-16
* device instance en_t0 r0 *1 0,0
Ren_t0 en__t0 en 166.9848
* device instance en_t1 r0 *1 0,0
Ren_t1 en__t1 en 166.9848
* device instance en r0 *1 0,0
Cen en vsubs 5.93421e-16
* device instance mnab_y_mpa_y_mpb_y_y_t0 r0 *1 0,0
Rmnab_y_mpa_y_mpb_y_y_t0 y__t0 y 37.5392638434
* device instance mnab_y_mpa_y_mpb_y_y_t1 r0 *1 0,0
Rmnab_y_mpa_y_mpb_y_y_t1 y__t1 y 21.9601317572
* device instance mnab_y_mpa_y_mpb_y_y_t2 r0 *1 0,0
Rmnab_y_mpa_y_mpb_y_y_t2 y__t2 y 20.8137043994
* device instance mnab_y_mpa_y_mpb_y_y r0 *1 0,0
Cmnab_y_mpa_y_mpb_y_y y vsubs 8.56767e-16
* device instance mnt_g_vddr_t0 r0 *1 0,0
Rmnt_g_vddr_t0 vddr__t0 vddr 96.791704049
* device instance mnt_g_vddr_t1 r0 *1 0,0
Rmnt_g_vddr_t1 vddr__t1 vddr 42.2688726368
* device instance mnt_g_vddr_t2 r0 *1 0,0
Rmnt_g_vddr_t2 vddr__t2 vddr 42.2688726368
* device instance mnt_g_vddr_t3 r0 *1 0,0
Rmnt_g_vddr_t3 vddr__t3 vddr 40.0553177736
* device instance mnt_g_vddr_t4 r0 *1 0,0
Rmnt_g_vddr_t4 vddr__t4 vddr 77.5606329038
* device instance mnt_g_vddr r0 *1 0,0
Cmnt_g_vddr vddr vsubs 1.704624e-15
* device instance mpa_py_mpb_py_mph_py_py_t0 r0 *1 0,0
Rmpa_py_mpb_py_mph_py_py_t0 py__t0 py 33.9531
* device instance mpa_py_mpb_py_mph_py_py_t1 r0 *1 0,0
Rmpa_py_mpb_py_mph_py_py_t1 py__t1 py 5.28629225979
* device instance mpa_py_mpb_py_mph_py_py_t2 r0 *1 0,0
Rmpa_py_mpb_py_mph_py_py_t2 py__t2 py 28.6668077402
* device instance mpa_py_mpb_py_mph_py_py r0 *1 0,0
Cmpa_py_mpb_py_mph_py_py py vsubs 7.95941e-16
* device instance mph_g_vss_t0 r0 *1 0,0
Rmph_g_vss_t0 vss__t0 vss 42.4711388085
* device instance mph_g_vss_t1 r0 *1 0,0
Rmph_g_vss_t1 vss__t1 vss 99.5208240237
* device instance mph_g_vss_t2 r0 *1 0,0
Rmph_g_vss_t2 vss__t2 vss 42.4711388085
* device instance mph_g_vss_t3 r0 *1 0,0
Rmph_g_vss_t3 vss__t3 vss 48.2606498636
* device instance mph_g_vss_t4 r0 *1 0,0
Rmph_g_vss_t4 vss__t4 vss 68.4184484956
* device instance mph_g_vss r0 *1 0,0
Cmph_g_vss vss vsubs 1.369874e-15
* device instance ny_t0 r0 *1 0,0
Rny_t0 ny__t0 ny 44.6445
* device instance ny_t1 r0 *1 0,0
Rny_t1 ny__t1 ny 44.6445
* device instance ny r0 *1 0,0
Cny ny vsubs 2.13697e-16
* device instance cc_a_mnab_y_mpa_y_mpb_y_y r0 *1 0,0
Ccc_a_mnab_y_mpa_y_mpb_y_y a y 1.5977e-17
* device instance vsubs_dctie r0 *1 0,0
Rvsubs_dctie vsubs 0 1e+12
.ends ro_nand2_pex_wstv0p44__core

* ro_nand2_pex_wstv0p44 -- design-port-order wrapper over ro_nand2_pex_wstv0p44__core.
* Promoted-internal layout pins kept local here: py, ny
.subckt ro_nand2_pex_wstv0p44 a en y vddr vss
xpex a en y vddr py vss ny ro_nand2_pex_wstv0p44__core
.ends ro_nand2_pex_wstv0p44

*-----------------------------------------------------------------------
* ro_nand2_pex_wstv0p46 -- post-layout, from ../ro_nand2_wstv0p46/ro_nand2_wstv0p46.gds
* klt extract --parasitics: 6 devices, 8 nets
*-----------------------------------------------------------------------
.subckt ro_nand2_pex_wstv0p46__core a en y vddr py vss ny
* device instance $1 r0 *1 1.42,0.21 nfet
Xn1 ny__t0 vddr__t0 vss__t0 vss__t2 sky130_fd_pr__nfet_01v8 L=2 W=0.46 AS=0.1932 AD=0.1932 PS=1.76 PD=1.76
* device instance $2 r0 *1 3.785,0.21 nfet
Xn2 n3__t0 en__t0 ny__t1 vss__t3 sky130_fd_pr__nfet_01v8 L=0.15 W=0.84 AS=0.3948 AD=0.2184 PS=2.62 PD=1.36
* device instance $3 r0 *1 4.455,0.21 nfet
Xn3 y__t0 a__t0 n3__t1 vss__t4 sky130_fd_pr__nfet_01v8 L=0.15 W=0.84 AS=0.2184 AD=0.3948 PS=1.36 PD=2.62
* device instance $4 r0 *1 1.42,3.74 pfet
Xn4 py__t0 vss__t1 vddr__t1 vddr__t2 sky130_fd_pr__pfet_01v8 L=2 W=0.46 AS=0.1932 AD=0.1932 PS=1.76 PD=1.76
* device instance $5 r0 *1 3.585,3.74 pfet
Xn5 y__t1 en__t1 py__t1 vddr__t3 sky130_fd_pr__pfet_01v8 L=0.15 W=0.84 AS=0.3948 AD=0.3948 PS=2.62 PD=2.62
* device instance $6 r0 *1 4.875,3.74 pfet
Xn6 py__t2 a__t1 y__t2 vddr__t4 sky130_fd_pr__pfet_01v8 L=0.15 W=0.84 AS=0.3948 AD=0.3948 PS=2.62 PD=2.62
* device instance _3_t0 r0 *1 0,0
R_3_t0 n3__t0 n3 12.8
* device instance _3_t1 r0 *1 0,0
R_3_t1 n3__t1 n3 12.8
* device instance _3 r0 *1 0,0
C_3 n3 vsubs 1.15618e-16
* device instance a_t0 r0 *1 0,0
Ra_t0 a__t0 a 175.09895
* device instance a_t1 r0 *1 0,0
Ra_t1 a__t1 a 175.09895
* device instance a r0 *1 0,0
Ca a vsubs 6.07536e-16
* device instance en_t0 r0 *1 0,0
Ren_t0 en__t0 en 166.9848
* device instance en_t1 r0 *1 0,0
Ren_t1 en__t1 en 166.9848
* device instance en r0 *1 0,0
Cen en vsubs 5.93421e-16
* device instance mnab_y_mpa_y_mpb_y_y_t0 r0 *1 0,0
Rmnab_y_mpa_y_mpb_y_y_t0 y__t0 y 37.5392638434
* device instance mnab_y_mpa_y_mpb_y_y_t1 r0 *1 0,0
Rmnab_y_mpa_y_mpb_y_y_t1 y__t1 y 21.9601317572
* device instance mnab_y_mpa_y_mpb_y_y_t2 r0 *1 0,0
Rmnab_y_mpa_y_mpb_y_y_t2 y__t2 y 20.8137043994
* device instance mnab_y_mpa_y_mpb_y_y r0 *1 0,0
Cmnab_y_mpa_y_mpb_y_y y vsubs 8.56767e-16
* device instance mnt_g_vddr_t0 r0 *1 0,0
Rmnt_g_vddr_t0 vddr__t0 vddr 96.9869416995
* device instance mnt_g_vddr_t1 r0 *1 0,0
Rmnt_g_vddr_t1 vddr__t1 vddr 42.3541327887
* device instance mnt_g_vddr_t2 r0 *1 0,0
Rmnt_g_vddr_t2 vddr__t2 vddr 42.3541327887
* device instance mnt_g_vddr_t3 r0 *1 0,0
Rmnt_g_vddr_t3 vddr__t3 vddr 40.1361129844
* device instance mnt_g_vddr_t4 r0 *1 0,0
Rmnt_g_vddr_t4 vddr__t4 vddr 77.7170797387
* device instance mnt_g_vddr r0 *1 0,0
Cmnt_g_vddr vddr vsubs 1.705707e-15
* device instance mpa_py_mpb_py_mph_py_py_t0 r0 *1 0,0
Rmpa_py_mpb_py_mph_py_py_t0 py__t0 py 34.25785
* device instance mpa_py_mpb_py_mph_py_py_t1 r0 *1 0,0
Rmpa_py_mpb_py_mph_py_py_t1 py__t1 py 5.3337399911
* device instance mpa_py_mpb_py_mph_py_py_t2 r0 *1 0,0
Rmpa_py_mpb_py_mph_py_py_t2 py__t2 py 28.9241100089
* device instance mpa_py_mpb_py_mph_py_py r0 *1 0,0
Cmpa_py_mpb_py_mph_py_py py vsubs 7.9788e-16
* device instance mph_g_vss_t0 r0 *1 0,0
Rmph_g_vss_t0 vss__t0 vss 42.5560550796
* device instance mph_g_vss_t1 r0 *1 0,0
Rmph_g_vss_t1 vss__t1 vss 99.7198047316
* device instance mph_g_vss_t2 r0 *1 0,0
Rmph_g_vss_t2 vss__t2 vss 42.5560550796
* device instance mph_g_vss_t3 r0 *1 0,0
Rmph_g_vss_t3 vss__t3 vss 48.3571416117
* device instance mph_g_vss_t4 r0 *1 0,0
Rmph_g_vss_t4 vss__t4 vss 68.5552434976
* device instance mph_g_vss r0 *1 0,0
Cmph_g_vss vss vsubs 1.370958e-15
* device instance ny_t0 r0 *1 0,0
Rny_t0 ny__t0 ny 44.8339
* device instance ny_t1 r0 *1 0,0
Rny_t1 ny__t1 ny 44.8339
* device instance ny r0 *1 0,0
Cny ny vsubs 2.15636e-16
* device instance cc_a_mnab_y_mpa_y_mpb_y_y r0 *1 0,0
Ccc_a_mnab_y_mpa_y_mpb_y_y a y 1.5977e-17
* device instance vsubs_dctie r0 *1 0,0
Rvsubs_dctie vsubs 0 1e+12
.ends ro_nand2_pex_wstv0p46__core

* ro_nand2_pex_wstv0p46 -- design-port-order wrapper over ro_nand2_pex_wstv0p46__core.
* Promoted-internal layout pins kept local here: py, ny
.subckt ro_nand2_pex_wstv0p46 a en y vddr vss
xpex a en y vddr py vss ny ro_nand2_pex_wstv0p46__core
.ends ro_nand2_pex_wstv0p46

*-----------------------------------------------------------------------
* ro_nand2_pex_wstv0p48 -- post-layout, from ../ro_nand2_wstv0p48/ro_nand2_wstv0p48.gds
* klt extract --parasitics: 6 devices, 8 nets
*-----------------------------------------------------------------------
.subckt ro_nand2_pex_wstv0p48__core a en y vddr py vss ny
* device instance $1 r0 *1 1.42,0.21 nfet
Xn1 ny__t0 vddr__t0 vss__t0 vss__t2 sky130_fd_pr__nfet_01v8 L=2 W=0.48 AS=0.2016 AD=0.2016 PS=1.8 PD=1.8
* device instance $2 r0 *1 3.785,0.21 nfet
Xn2 n3__t0 en__t0 ny__t1 vss__t3 sky130_fd_pr__nfet_01v8 L=0.15 W=0.84 AS=0.3948 AD=0.2184 PS=2.62 PD=1.36
* device instance $3 r0 *1 4.455,0.21 nfet
Xn3 y__t0 a__t0 n3__t1 vss__t4 sky130_fd_pr__nfet_01v8 L=0.15 W=0.84 AS=0.2184 AD=0.3948 PS=1.36 PD=2.62
* device instance $4 r0 *1 1.42,3.74 pfet
Xn4 py__t0 vss__t1 vddr__t1 vddr__t2 sky130_fd_pr__pfet_01v8 L=2 W=0.48 AS=0.2016 AD=0.2016 PS=1.8 PD=1.8
* device instance $5 r0 *1 3.585,3.74 pfet
Xn5 y__t1 en__t1 py__t1 vddr__t3 sky130_fd_pr__pfet_01v8 L=0.15 W=0.84 AS=0.3948 AD=0.3948 PS=2.62 PD=2.62
* device instance $6 r0 *1 4.875,3.74 pfet
Xn6 py__t2 a__t1 y__t2 vddr__t4 sky130_fd_pr__pfet_01v8 L=0.15 W=0.84 AS=0.3948 AD=0.3948 PS=2.62 PD=2.62
* device instance _3_t0 r0 *1 0,0
R_3_t0 n3__t0 n3 12.8
* device instance _3_t1 r0 *1 0,0
R_3_t1 n3__t1 n3 12.8
* device instance _3 r0 *1 0,0
C_3 n3 vsubs 1.15618e-16
* device instance a_t0 r0 *1 0,0
Ra_t0 a__t0 a 175.09895
* device instance a_t1 r0 *1 0,0
Ra_t1 a__t1 a 175.09895
* device instance a r0 *1 0,0
Ca a vsubs 6.07536e-16
* device instance en_t0 r0 *1 0,0
Ren_t0 en__t0 en 166.9848
* device instance en_t1 r0 *1 0,0
Ren_t1 en__t1 en 166.9848
* device instance en r0 *1 0,0
Cen en vsubs 5.93421e-16
* device instance mnab_y_mpa_y_mpb_y_y_t0 r0 *1 0,0
Rmnab_y_mpa_y_mpb_y_y_t0 y__t0 y 37.5392638434
* device instance mnab_y_mpa_y_mpb_y_y_t1 r0 *1 0,0
Rmnab_y_mpa_y_mpb_y_y_t1 y__t1 y 21.9601317572
* device instance mnab_y_mpa_y_mpb_y_y_t2 r0 *1 0,0
Rmnab_y_mpa_y_mpb_y_y_t2 y__t2 y 20.8137043994
* device instance mnab_y_mpa_y_mpb_y_y r0 *1 0,0
Cmnab_y_mpa_y_mpb_y_y y vsubs 8.56767e-16
* device instance mnt_g_vddr_t0 r0 *1 0,0
Rmnt_g_vddr_t0 vddr__t0 vddr 97.1821469724
* device instance mnt_g_vddr_t1 r0 *1 0,0
Rmnt_g_vddr_t1 vddr__t1 vddr 42.4393788012
* device instance mnt_g_vddr_t2 r0 *1 0,0
Rmnt_g_vddr_t2 vddr__t2 vddr 42.4393788012
* device instance mnt_g_vddr_t3 r0 *1 0,0
Rmnt_g_vddr_t3 vddr__t3 vddr 40.2168947963
* device instance mnt_g_vddr_t4 r0 *1 0,0
Rmnt_g_vddr_t4 vddr__t4 vddr 77.8735006289
* device instance mnt_g_vddr r0 *1 0,0
Cmnt_g_vddr vddr vsubs 1.706791e-15
* device instance mpa_py_mpb_py_mph_py_py_t0 r0 *1 0,0
Rmpa_py_mpb_py_mph_py_py_t0 py__t0 py 34.5626
* device instance mpa_py_mpb_py_mph_py_py_t1 r0 *1 0,0
Rmpa_py_mpb_py_mph_py_py_t1 py__t1 py 5.38118772242
* device instance mpa_py_mpb_py_mph_py_py_t2 r0 *1 0,0
Rmpa_py_mpb_py_mph_py_py_t2 py__t2 py 29.1814122776
* device instance mpa_py_mpb_py_mph_py_py r0 *1 0,0
Cmpa_py_mpb_py_mph_py_py py vsubs 7.99818e-16
* device instance mph_g_vss_t0 r0 *1 0,0
Rmph_g_vss_t0 vss__t0 vss 42.6409713506
* device instance mph_g_vss_t1 r0 *1 0,0
Rmph_g_vss_t1 vss__t1 vss 99.9187854396
* device instance mph_g_vss_t2 r0 *1 0,0
Rmph_g_vss_t2 vss__t2 vss 42.6409713506
* device instance mph_g_vss_t3 r0 *1 0,0
Rmph_g_vss_t3 vss__t3 vss 48.4536333597
* device instance mph_g_vss_t4 r0 *1 0,0
Rmph_g_vss_t4 vss__t4 vss 68.6920384995
* device instance mph_g_vss r0 *1 0,0
Cmph_g_vss vss vsubs 1.372042e-15
* device instance ny_t0 r0 *1 0,0
Rny_t0 ny__t0 ny 45.02655
* device instance ny_t1 r0 *1 0,0
Rny_t1 ny__t1 ny 45.02655
* device instance ny r0 *1 0,0
Cny ny vsubs 2.17575e-16
* device instance cc_a_mnab_y_mpa_y_mpb_y_y r0 *1 0,0
Ccc_a_mnab_y_mpa_y_mpb_y_y a y 1.5977e-17
* device instance vsubs_dctie r0 *1 0,0
Rvsubs_dctie vsubs 0 1e+12
.ends ro_nand2_pex_wstv0p48__core

* ro_nand2_pex_wstv0p48 -- design-port-order wrapper over ro_nand2_pex_wstv0p48__core.
* Promoted-internal layout pins kept local here: py, ny
.subckt ro_nand2_pex_wstv0p48 a en y vddr vss
xpex a en y vddr py vss ny ro_nand2_pex_wstv0p48__core
.ends ro_nand2_pex_wstv0p48

*-----------------------------------------------------------------------
* ro_stage_pex_wstv0p42 -- post-layout, from ../ro_stage/ro_stage.gds
* klt extract --parasitics: 4 devices, 6 nets
*-----------------------------------------------------------------------
.subckt ro_stage_pex_wstv0p42__core a vddr vss ny py y
* device instance $1 r0 *1 1.42,0.21 nfet
Xn1 ny__t0 vddr__t0 vss__t0 vss__t2 sky130_fd_pr__nfet_01v8 L=2 W=0.42 AS=0.1764 AD=0.1764 PS=1.68 PD=1.68
* device instance $2 r0 *1 3.785,0.21 nfet
Xn2 y__t0 a__t0 ny__t1 vss__t3 sky130_fd_pr__nfet_01v8 L=0.15 W=0.42 AS=0.1974 AD=0.1974 PS=1.78 PD=1.78
* device instance $3 r0 *1 1.42,3.74 pfet
Xn3 py__t0 vss__t1 vddr__t1 vddr__t2 sky130_fd_pr__pfet_01v8 L=2 W=0.42 AS=0.1764 AD=0.1764 PS=1.68 PD=1.68
* device instance $4 r0 *1 3.585,3.74 pfet
Xn4 y__t1 a__t1 py__t1 vddr__t3 sky130_fd_pr__pfet_01v8 L=0.15 W=0.84 AS=0.3948 AD=0.3948 PS=2.62 PD=2.62
* device instance a_t0 r0 *1 0,0
Ra_t0 a__t0 a 174.7298
* device instance a_t1 r0 *1 0,0
Ra_t1 a__t1 a 174.7298
* device instance a r0 *1 0,0
Ca a vsubs 6.11836e-16
* device instance mnt_g_vddr_t0 r0 *1 0,0
Rmnt_g_vddr_t0 vddr__t0 vddr 122.006080691
* device instance mnt_g_vddr_t1 r0 *1 0,0
Rmnt_g_vddr_t1 vddr__t1 vddr 46.7415070546
* device instance mnt_g_vddr_t2 r0 *1 0,0
Rmnt_g_vddr_t2 vddr__t2 vddr 46.7415070546
* device instance mnt_g_vddr_t3 r0 *1 0,0
Rmnt_g_vddr_t3 vddr__t3 vddr 83.4398051993
* device instance mnt_g_vddr r0 *1 0,0
Cmnt_g_vddr vddr vsubs 1.771254e-15
* device instance mph_g_vss_t0 r0 *1 0,0
Rmph_g_vss_t0 vss__t0 vss 46.8219163816
* device instance mph_g_vss_t1 r0 *1 0,0
Rmph_g_vss_t1 vss__t1 vss 119.570879015
* device instance mph_g_vss_t2 r0 *1 0,0
Rmph_g_vss_t2 vss__t2 vss 46.8219163816
* device instance mph_g_vss_t3 r0 *1 0,0
Rmph_g_vss_t3 vss__t3 vss 87.3253882221
* device instance mph_g_vss r0 *1 0,0
Cmph_g_vss vss vsubs 1.368791e-15
* device instance ny_t0 r0 *1 0,0
Rny_t0 ny__t0 ny 41.7022
* device instance ny_t1 r0 *1 0,0
Rny_t1 ny__t1 ny 41.7022
* device instance ny r0 *1 0,0
Cny ny vsubs 1.71044e-16
* device instance py_t0 r0 *1 0,0
Rpy_t0 py__t0 py 37.6683
* device instance py_t1 r0 *1 0,0
Rpy_t1 py__t1 py 37.6683
* device instance py r0 *1 0,0
Cpy py vsubs 1.9321e-16
* device instance y_t0 r0 *1 0,0
Ry_t0 y__t0 y 205.06525
* device instance y_t1 r0 *1 0,0
Ry_t1 y__t1 y 205.06525
* device instance y r0 *1 0,0
Cy y vsubs 6.03733e-16
* device instance cc_mnt_g_vddr_py r0 *1 0,0
Ccc_mnt_g_vddr_py vddr py 3.118e-18
* device instance vsubs_dctie r0 *1 0,0
Rvsubs_dctie vsubs 0 1e+12
.ends ro_stage_pex_wstv0p42__core

* ro_stage_pex_wstv0p42 -- design-port-order wrapper over ro_stage_pex_wstv0p42__core.
* Promoted-internal layout pins kept local here: ny, py
.subckt ro_stage_pex_wstv0p42 a y vddr vss
xpex a vddr vss ny py y ro_stage_pex_wstv0p42__core
.ends ro_stage_pex_wstv0p42

*-----------------------------------------------------------------------
* ro_stage_pex_wstv0p44 -- post-layout, from ../ro_stage_wstv0p44/ro_stage_wstv0p44.gds
* klt extract --parasitics: 4 devices, 6 nets
*-----------------------------------------------------------------------
.subckt ro_stage_pex_wstv0p44__core a vddr vss ny py y
* device instance $1 r0 *1 3.785,0.21 nfet
Xn1 y__t0 a__t0 ny__t0 vss__t2 sky130_fd_pr__nfet_01v8 L=0.15 W=0.42 AS=0.1974 AD=0.1974 PS=1.78 PD=1.78
* device instance $2 r0 *1 1.42,0.21 nfet
Xn2 ny__t1 vddr__t0 vss__t0 vss__t3 sky130_fd_pr__nfet_01v8 L=2 W=0.44 AS=0.1848 AD=0.1848 PS=1.72 PD=1.72
* device instance $3 r0 *1 1.42,3.74 pfet
Xn3 py__t0 vss__t1 vddr__t1 vddr__t2 sky130_fd_pr__pfet_01v8 L=2 W=0.44 AS=0.1848 AD=0.1848 PS=1.72 PD=1.72
* device instance $4 r0 *1 3.585,3.74 pfet
Xn4 y__t1 a__t1 py__t1 vddr__t3 sky130_fd_pr__pfet_01v8 L=0.15 W=0.84 AS=0.3948 AD=0.3948 PS=2.62 PD=2.62
* device instance a_t0 r0 *1 0,0
Ra_t0 a__t0 a 174.7298
* device instance a_t1 r0 *1 0,0
Ra_t1 a__t1 a 174.7298
* device instance a r0 *1 0,0
Ca a vsubs 6.11836e-16
* device instance mnt_g_vddr_t0 r0 *1 0,0
Rmnt_g_vddr_t0 vddr__t0 vddr 122.252150797
* device instance mnt_g_vddr_t1 r0 *1 0,0
Rmnt_g_vddr_t1 vddr__t1 vddr 46.8357784837
* device instance mnt_g_vddr_t2 r0 *1 0,0
Rmnt_g_vddr_t2 vddr__t2 vddr 46.8357784837
* device instance mnt_g_vddr_t3 r0 *1 0,0
Rmnt_g_vddr_t3 vddr__t3 vddr 83.6080922353
* device instance mnt_g_vddr r0 *1 0,0
Cmnt_g_vddr vddr vsubs 1.772304e-15
* device instance mph_g_vss_t0 r0 *1 0,0
Rmph_g_vss_t0 vss__t0 vss 46.9157190917
* device instance mph_g_vss_t1 r0 *1 0,0
Rmph_g_vss_t1 vss__t1 vss 119.810426503
* device instance mph_g_vss_t2 r0 *1 0,0
Rmph_g_vss_t2 vss__t2 vss 87.5003353132
* device instance mph_g_vss_t3 r0 *1 0,0
Rmph_g_vss_t3 vss__t3 vss 46.9157190917
* device instance mph_g_vss r0 *1 0,0
Cmph_g_vss vss vsubs 1.369874e-15
* device instance ny_t0 r0 *1 0,0
Rny_t0 ny__t0 ny 41.76295
* device instance ny_t1 r0 *1 0,0
Rny_t1 ny__t1 ny 41.76295
* device instance ny r0 *1 0,0
Cny ny vsubs 1.72982e-16
* device instance py_t0 r0 *1 0,0
Rpy_t0 py__t0 py 37.875
* device instance py_t1 r0 *1 0,0
Rpy_t1 py__t1 py 37.875
* device instance py r0 *1 0,0
Cpy py vsubs 1.95101e-16
* device instance y_t0 r0 *1 0,0
Ry_t0 y__t0 y 205.06525
* device instance y_t1 r0 *1 0,0
Ry_t1 y__t1 y 205.06525
* device instance y r0 *1 0,0
Cy y vsubs 6.03733e-16
* device instance cc_mnt_g_vddr_py r0 *1 0,0
Ccc_mnt_g_vddr_py vddr py 3.266e-18
* device instance vsubs_dctie r0 *1 0,0
Rvsubs_dctie vsubs 0 1e+12
.ends ro_stage_pex_wstv0p44__core

* ro_stage_pex_wstv0p44 -- design-port-order wrapper over ro_stage_pex_wstv0p44__core.
* Promoted-internal layout pins kept local here: ny, py
.subckt ro_stage_pex_wstv0p44 a y vddr vss
xpex a vddr vss ny py y ro_stage_pex_wstv0p44__core
.ends ro_stage_pex_wstv0p44

*-----------------------------------------------------------------------
* ro_stage_pex_wstv0p46 -- post-layout, from ../ro_stage_wstv0p46/ro_stage_wstv0p46.gds
* klt extract --parasitics: 4 devices, 6 nets
*-----------------------------------------------------------------------
.subckt ro_stage_pex_wstv0p46__core a vddr vss ny py y
* device instance $1 r0 *1 3.785,0.21 nfet
Xn1 y__t0 a__t0 ny__t0 vss__t2 sky130_fd_pr__nfet_01v8 L=0.15 W=0.42 AS=0.1974 AD=0.1974 PS=1.78 PD=1.78
* device instance $2 r0 *1 1.42,0.21 nfet
Xn2 ny__t1 vddr__t0 vss__t0 vss__t3 sky130_fd_pr__nfet_01v8 L=2 W=0.46 AS=0.1932 AD=0.1932 PS=1.76 PD=1.76
* device instance $3 r0 *1 1.42,3.74 pfet
Xn3 py__t0 vss__t1 vddr__t1 vddr__t2 sky130_fd_pr__pfet_01v8 L=2 W=0.46 AS=0.1932 AD=0.1932 PS=1.76 PD=1.76
* device instance $4 r0 *1 3.585,3.74 pfet
Xn4 y__t1 a__t1 py__t1 vddr__t3 sky130_fd_pr__pfet_01v8 L=0.15 W=0.84 AS=0.3948 AD=0.3948 PS=2.62 PD=2.62
* device instance a_t0 r0 *1 0,0
Ra_t0 a__t0 a 174.7298
* device instance a_t1 r0 *1 0,0
Ra_t1 a__t1 a 174.7298
* device instance a r0 *1 0,0
Ca a vsubs 6.11836e-16
* device instance mnt_g_vddr_t0 r0 *1 0,0
Rmnt_g_vddr_t0 vddr__t0 vddr 122.498220903
* device instance mnt_g_vddr_t1 r0 *1 0,0
Rmnt_g_vddr_t1 vddr__t1 vddr 46.9300499128
* device instance mnt_g_vddr_t2 r0 *1 0,0
Rmnt_g_vddr_t2 vddr__t2 vddr 46.9300499128
* device instance mnt_g_vddr_t3 r0 *1 0,0
Rmnt_g_vddr_t3 vddr__t3 vddr 83.7763792713
* device instance mnt_g_vddr r0 *1 0,0
Cmnt_g_vddr vddr vsubs 1.773355e-15
* device instance mph_g_vss_t0 r0 *1 0,0
Rmph_g_vss_t0 vss__t0 vss 47.0095218017
* device instance mph_g_vss_t1 r0 *1 0,0
Rmph_g_vss_t1 vss__t1 vss 120.049973992
* device instance mph_g_vss_t2 r0 *1 0,0
Rmph_g_vss_t2 vss__t2 vss 87.6752824043
* device instance mph_g_vss_t3 r0 *1 0,0
Rmph_g_vss_t3 vss__t3 vss 47.0095218017
* device instance mph_g_vss r0 *1 0,0
Cmph_g_vss vss vsubs 1.370958e-15
* device instance ny_t0 r0 *1 0,0
Rny_t0 ny__t0 ny 41.8333
* device instance ny_t1 r0 *1 0,0
Rny_t1 ny__t1 ny 41.8333
* device instance ny r0 *1 0,0
Cny ny vsubs 1.74921e-16
* device instance py_t0 r0 *1 0,0
Rpy_t0 py__t0 py 38.0848
* device instance py_t1 r0 *1 0,0
Rpy_t1 py__t1 py 38.0848
* device instance py r0 *1 0,0
Cpy py vsubs 1.96992e-16
* device instance y_t0 r0 *1 0,0
Ry_t0 y__t0 y 205.06525
* device instance y_t1 r0 *1 0,0
Ry_t1 y__t1 y 205.06525
* device instance y r0 *1 0,0
Cy y vsubs 6.03733e-16
* device instance cc_mnt_g_vddr_py r0 *1 0,0
Ccc_mnt_g_vddr_py vddr py 3.415e-18
* device instance vsubs_dctie r0 *1 0,0
Rvsubs_dctie vsubs 0 1e+12
.ends ro_stage_pex_wstv0p46__core

* ro_stage_pex_wstv0p46 -- design-port-order wrapper over ro_stage_pex_wstv0p46__core.
* Promoted-internal layout pins kept local here: ny, py
.subckt ro_stage_pex_wstv0p46 a y vddr vss
xpex a vddr vss ny py y ro_stage_pex_wstv0p46__core
.ends ro_stage_pex_wstv0p46

*-----------------------------------------------------------------------
* ro_stage_pex_wstv0p48 -- post-layout, from ../ro_stage_wstv0p48/ro_stage_wstv0p48.gds
* klt extract --parasitics: 4 devices, 6 nets
*-----------------------------------------------------------------------
.subckt ro_stage_pex_wstv0p48__core a vddr vss ny py y
* device instance $1 r0 *1 3.785,0.21 nfet
Xn1 y__t0 a__t0 ny__t0 vss__t2 sky130_fd_pr__nfet_01v8 L=0.15 W=0.42 AS=0.1974 AD=0.1974 PS=1.78 PD=1.78
* device instance $2 r0 *1 1.42,0.21 nfet
Xn2 ny__t1 vddr__t0 vss__t0 vss__t3 sky130_fd_pr__nfet_01v8 L=2 W=0.48 AS=0.2016 AD=0.2016 PS=1.8 PD=1.8
* device instance $3 r0 *1 1.42,3.74 pfet
Xn3 py__t0 vss__t1 vddr__t1 vddr__t2 sky130_fd_pr__pfet_01v8 L=2 W=0.48 AS=0.2016 AD=0.2016 PS=1.8 PD=1.8
* device instance $4 r0 *1 3.585,3.74 pfet
Xn4 y__t1 a__t1 py__t1 vddr__t3 sky130_fd_pr__pfet_01v8 L=0.15 W=0.84 AS=0.3948 AD=0.3948 PS=2.62 PD=2.62
* device instance a_t0 r0 *1 0,0
Ra_t0 a__t0 a 174.7298
* device instance a_t1 r0 *1 0,0
Ra_t1 a__t1 a 174.7298
* device instance a r0 *1 0,0
Ca a vsubs 6.11836e-16
* device instance mnt_g_vddr_t0 r0 *1 0,0
Rmnt_g_vddr_t0 vddr__t0 vddr 122.744331823
* device instance mnt_g_vddr_t1 r0 *1 0,0
Rmnt_g_vddr_t1 vddr__t1 vddr 47.0243369783
* device instance mnt_g_vddr_t2 r0 *1 0,0
Rmnt_g_vddr_t2 vddr__t2 vddr 47.0243369783
* device instance mnt_g_vddr_t3 r0 *1 0,0
Rmnt_g_vddr_t3 vddr__t3 vddr 83.9446942202
* device instance mnt_g_vddr r0 *1 0,0
Cmnt_g_vddr vddr vsubs 1.774405e-15
* device instance mph_g_vss_t0 r0 *1 0,0
Rmph_g_vss_t0 vss__t0 vss 47.1033245117
* device instance mph_g_vss_t1 r0 *1 0,0
Rmph_g_vss_t1 vss__t1 vss 120.289521481
* device instance mph_g_vss_t2 r0 *1 0,0
Rmph_g_vss_t2 vss__t2 vss 87.8502294954
* device instance mph_g_vss_t3 r0 *1 0,0
Rmph_g_vss_t3 vss__t3 vss 47.1033245117
* device instance mph_g_vss r0 *1 0,0
Cmph_g_vss vss vsubs 1.372042e-15
* device instance ny_t0 r0 *1 0,0
Rny_t0 ny__t0 ny 41.9128
* device instance ny_t1 r0 *1 0,0
Rny_t1 ny__t1 ny 41.9128
* device instance ny r0 *1 0,0
Cny ny vsubs 1.7686e-16
* device instance py_t0 r0 *1 0,0
Rpy_t0 py__t0 py 38.29745
* device instance py_t1 r0 *1 0,0
Rpy_t1 py__t1 py 38.29745
* device instance py r0 *1 0,0
Cpy py vsubs 1.98882e-16
* device instance y_t0 r0 *1 0,0
Ry_t0 y__t0 y 205.06525
* device instance y_t1 r0 *1 0,0
Ry_t1 y__t1 y 205.06525
* device instance y r0 *1 0,0
Cy y vsubs 6.03733e-16
* device instance cc_mnt_g_vddr_py r0 *1 0,0
Ccc_mnt_g_vddr_py vddr py 3.563e-18
* device instance vsubs_dctie r0 *1 0,0
Rvsubs_dctie vsubs 0 1e+12
.ends ro_stage_pex_wstv0p48__core

* ro_stage_pex_wstv0p48 -- design-port-order wrapper over ro_stage_pex_wstv0p48__core.
* Promoted-internal layout pins kept local here: ny, py
.subckt ro_stage_pex_wstv0p48 a y vddr vss
xpex a vddr vss ny py y ro_stage_pex_wstv0p48__core
.ends ro_stage_pex_wstv0p48

*-----------------------------------------------------------------------
* ro_buf_pex -- post-layout, from ../ro_buf/ro_buf.gds
* klt extract --parasitics: 2 devices, 4 nets
*-----------------------------------------------------------------------
.subckt ro_buf_pex__core a vdd vss y
* device instance $1 r0 *1 0.545,0.21 nfet
Xn1 y__t0 a__t0 vss__t0 vss__t1 sky130_fd_pr__nfet_01v8 L=0.15 W=0.42 AS=0.1974 AD=0.1974 PS=1.78 PD=1.78
* device instance $2 r0 *1 0.545,3.53 pfet
Xn2 y__t1 a__t1 vdd__t0 vdd__t1 sky130_fd_pr__pfet_01v8 L=0.15 W=0.84 AS=0.3948 AD=0.3948 PS=2.62 PD=2.62
* device instance a_t0 r0 *1 0,0
Ra_t0 a__t0 a 159.62375
* device instance a_t1 r0 *1 0,0
Ra_t1 a__t1 a 159.62375
* device instance a r0 *1 0,0
Ca a vsubs 5.75883e-16
* device instance vdd_t0 r0 *1 0,0
Rvdd_t0 vdd__t0 vdd 98.9335
* device instance vdd_t1 r0 *1 0,0
Rvdd_t1 vdd__t1 vdd 98.9335
* device instance vdd r0 *1 0,0
Cvdd vdd vsubs 6.69937e-16
* device instance vss_t0 r0 *1 0,0
Rvss_t0 vss__t0 vss 95.08305
* device instance vss_t1 r0 *1 0,0
Rvss_t1 vss__t1 vss 95.08305
* device instance vss r0 *1 0,0
Cvss vss vsubs 6.37991e-16
* device instance y_t0 r0 *1 0,0
Ry_t0 y__t0 y 207.64565
* device instance y_t1 r0 *1 0,0
Ry_t1 y__t1 y 207.64565
* device instance y r0 *1 0,0
Cy y vsubs 6.09871e-16
* device instance vsubs_dctie r0 *1 0,0
Rvsubs_dctie vsubs 0 1e+12
.ends ro_buf_pex__core

* ro_buf_pex -- design-port-order wrapper over ro_buf_pex__core.
* Promoted-internal layout pins kept local here: (none)
.subckt ro_buf_pex a y vdd vss
xpex a vdd vss y ro_buf_pex__core
.ends ro_buf_pex
