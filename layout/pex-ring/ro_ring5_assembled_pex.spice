* Post-layout (parasitic) subcircuit library -- GENERATED by
* layout/bin/pex-netlist.py from layout/pex-ring/pex.json. Do not edit by
* hand: `python3 layout/bin/pex-netlist.py layout/pex-ring/pex.json --check`
* re-extracts every cell from its committed GDS and fails if this file
* and that extraction disagree.
*
* Each cell below is `klt extract --pdk <variant> --parasitics` output
* over a composed, DRC-clean and LVS-clean cell under layout/. --pdk is
* what makes its device cards subcircuit calls on the PDK's own devices
* with unitless geometry (this repo's decks run at .option scale=1u), so
* NO device card, geometry value, R value, C value or connection is
* rewritten here. Two things are: extractor-joined net names are renamed
* to their design-level names, and a design-port-order wrapper is added
* per cell. See layout/bin/pex-netlist.py's module docstring for why,
* and layout/pex/README.md for what the parasitic model does and does
* not contain.
*
* Substrate return node: `vsubs`, declared .global below --
* klayout-tools#1503 (the extractor scopes it per-instance, which
* isolates every ground capacitance behind a 1 TOhm tie once the cell
* is instantiated rather than simulated flat). A deck including this
* library MUST tie the node itself; every sim/ record minted from it
* states which tie it used.

.global vsubs

*-----------------------------------------------------------------------
* ro_ring5_assembled_pex_wstv0p42 -- post-layout, from ../ro_ring5/ro_ring5.gds
* klt extract --parasitics: 22 devices, 19 nets
*-----------------------------------------------------------------------
.subckt ro_ring5_assembled_pex_wstv0p42__core ro sig_n1 sig_n2 sig_n3 sig_n4 en vddr vss py_g ny nyn1 nyn2 nyn3 nyn4 py pyn1 pyn2 pyn3
* device instance $1 r0 *1 1.42,0.21 nfet
Xn1 ny__t0 vddr__t0 vss__t0 vss__t10 sky130_fd_pr__nfet_01v8 L=2 W=0.42 AS=0.1764 AD=0.1764 PS=1.68 PD=1.68
* device instance $2 r0 *1 10.72,0.21 nfet
Xn2 ny__t12 vddr__t20 vss__t9 vss__t11 sky130_fd_pr__nfet_01v8 L=2 W=0.42 AS=0.1764 AD=0.1764 PS=1.68 PD=1.68
* device instance $3 r0 *1 13.085,0.21 nfet
Xn3 sig_n2__t0 sig_n1__t0 ny__t02 vss__t15 sky130_fd_pr__nfet_01v8 L=0.15 W=0.42 AS=0.1974 AD=0.1974 PS=1.78 PD=1.78
* device instance $4 r0 *1 18.895,0.21 nfet
Xn4 ny__t13 vddr__t19 vss__t8 vss__t12 sky130_fd_pr__nfet_01v8 L=2 W=0.42 AS=0.1764 AD=0.1764 PS=1.68 PD=1.68
* device instance $5 r0 *1 21.26,0.21 nfet
Xn5 sig_n3__t0 sig_n2__t3 ny__t03 vss__t16 sky130_fd_pr__nfet_01v8 L=0.15 W=0.42 AS=0.1974 AD=0.1974 PS=1.78 PD=1.78
* device instance $6 r0 *1 27.07,0.21 nfet
Xn6 ny__t14 vddr__t18 vss__t7 vss__t13 sky130_fd_pr__nfet_01v8 L=2 W=0.42 AS=0.1764 AD=0.1764 PS=1.68 PD=1.68
* device instance $7 r0 *1 29.435,0.21 nfet
Xn7 sig_n4__t0 sig_n3__t3 ny__t04 vss__t17 sky130_fd_pr__nfet_01v8 L=0.15 W=0.42 AS=0.1974 AD=0.1974 PS=1.78 PD=1.78
* device instance $8 r0 *1 35.245,0.21 nfet
Xn8 ny__t15 vddr__t17 vss__t6 vss__t14 sky130_fd_pr__nfet_01v8 L=2 W=0.42 AS=0.1764 AD=0.1764 PS=1.68 PD=1.68
* device instance $9 r0 *1 37.61,0.21 nfet
Xn9 ro__t1 sig_n4__t3 ny__t05 vss__t18 sky130_fd_pr__nfet_01v8 L=0.15 W=0.42 AS=0.1974 AD=0.1974 PS=1.78 PD=1.78
* device instance $10 r0 *1 3.785,0.21 nfet
Xn10 n6__t0 en__t0 ny__t1 vss__t19 sky130_fd_pr__nfet_01v8 L=0.15 W=0.84 AS=0.3948 AD=0.2184 PS=2.62 PD=1.36
* device instance $11 r0 *1 4.455,0.21 nfet
Xn11 sig_n1__t1 ro__t0 n6__t1 vss__t20 sky130_fd_pr__nfet_01v8 L=0.15 W=0.84 AS=0.2184 AD=0.3948 PS=1.36 PD=2.62
* device instance $12 r0 *1 1.42,3.74 pfet
Xn12 py_g__t0 vss__t1 vddr__t1 vddr__t2 sky130_fd_pr__pfet_01v8 L=2 W=0.42 AS=0.1764 AD=0.1764 PS=1.68 PD=1.68
* device instance $13 r0 *1 10.72,3.74 pfet
Xn13 py__t0 vss__t2 vddr__t13 vddr__t9 sky130_fd_pr__pfet_01v8 L=2 W=0.42 AS=0.1764 AD=0.1764 PS=1.68 PD=1.68
* device instance $14 r0 *1 18.895,3.74 pfet
Xn14 py__t02 vss__t3 vddr__t14 vddr__t10 sky130_fd_pr__pfet_01v8 L=2 W=0.42 AS=0.1764 AD=0.1764 PS=1.68 PD=1.68
* device instance $15 r0 *1 27.07,3.74 pfet
Xn15 py__t03 vss__t4 vddr__t15 vddr__t11 sky130_fd_pr__pfet_01v8 L=2 W=0.42 AS=0.1764 AD=0.1764 PS=1.68 PD=1.68
* device instance $16 r0 *1 35.245,3.74 pfet
Xn16 py__t04 vss__t5 vddr__t16 vddr__t12 sky130_fd_pr__pfet_01v8 L=2 W=0.42 AS=0.1764 AD=0.1764 PS=1.68 PD=1.68
* device instance $17 r0 *1 3.585,3.74 pfet
Xn17 sig_n1__t2 en__t1 py_g__t1 vddr__t3 sky130_fd_pr__pfet_01v8 L=0.15 W=0.84 AS=0.3948 AD=0.3948 PS=2.62 PD=2.62
* device instance $18 r0 *1 4.875,3.74 pfet
Xn18 py_g__t2 ro__t2 sig_n1__t3 vddr__t8 sky130_fd_pr__pfet_01v8 L=0.15 W=0.84 AS=0.3948 AD=0.3948 PS=2.62 PD=2.62
* device instance $19 r0 *1 12.885,3.74 pfet
Xn19 sig_n2__t2 sig_n1__t4 py__t1 vddr__t7 sky130_fd_pr__pfet_01v8 L=0.15 W=0.84 AS=0.3948 AD=0.3948 PS=2.62 PD=2.62
* device instance $20 r0 *1 21.06,3.74 pfet
Xn20 sig_n3__t2 sig_n2__t1 py__t12 vddr__t6 sky130_fd_pr__pfet_01v8 L=0.15 W=0.84 AS=0.3948 AD=0.3948 PS=2.62 PD=2.62
* device instance $21 r0 *1 29.235,3.74 pfet
Xn21 sig_n4__t2 sig_n3__t1 py__t13 vddr__t5 sky130_fd_pr__pfet_01v8 L=0.15 W=0.84 AS=0.3948 AD=0.3948 PS=2.62 PD=2.62
* device instance $22 r0 *1 37.41,3.74 pfet
Xn22 ro__t3 sig_n4__t1 py__t14 vddr__t4 sky130_fd_pr__pfet_01v8 L=0.15 W=0.84 AS=0.3948 AD=0.3948 PS=2.62 PD=2.62
* device instance _6_t0 r0 *1 0,0
R_6_t0 n6__t0 n6 12.8
* device instance _6_t1 r0 *1 0,0
R_6_t1 n6__t1 n6 12.8
* device instance _6 r0 *1 0,0
C_6 n6 vsubs 1.15618e-16
* device instance a_g_a_ro_s4_y_y_t0 r0 *1 0,0
Ra_g_a_ro_s4_y_y_t0 ro__t0 ro 199.905310752
* device instance a_g_a_ro_s4_y_y_t1 r0 *1 0,0
Ra_g_a_ro_s4_y_y_t1 ro__t1 ro 198.597996013
* device instance a_g_a_ro_s4_y_y_t2 r0 *1 0,0
Ra_g_a_ro_s4_y_y_t2 ro__t2 ro 194.914280155
* device instance a_g_a_ro_s4_y_y_t3 r0 *1 0,0
Ra_g_a_ro_s4_y_y_t3 ro__t3 ro 196.22131308
* device instance a_g_a_ro_s4_y_y r0 *1 0,0
Ca_g_a_ro_s4_y_y ro vsubs 4.73908e-15
* device instance a_g_y_mnab_y_mpa_y_mpb_y_n1_s1_a_y_t0 r0 *1 0,0
Ra_g_y_mnab_y_mpa_y_mpb_y_n1_s1_a_y_t0 sig_n1__t0 sig_n1 107.491339147
* device instance a_g_y_mnab_y_mpa_y_mpb_y_n1_s1_a_y_t1 r0 *1 0,0
Ra_g_y_mnab_y_mpa_y_mpb_y_n1_s1_a_y_t1 sig_n1__t1 sig_n1 74.101756002
* device instance a_g_y_mnab_y_mpa_y_mpb_y_n1_s1_a_y_t2 r0 *1 0,0
Ra_g_y_mnab_y_mpa_y_mpb_y_n1_s1_a_y_t2 sig_n1__t2 sig_n1 83.1989635875
* device instance a_g_y_mnab_y_mpa_y_mpb_y_n1_s1_a_y_t3 r0 *1 0,0
Ra_g_y_mnab_y_mpa_y_mpb_y_n1_s1_a_y_t3 sig_n1__t3 sig_n1 60.7011664601
* device instance a_g_y_mnab_y_mpa_y_mpb_y_n1_s1_a_y_t4 r0 *1 0,0
Ra_g_y_mnab_y_mpa_y_mpb_y_n1_s1_a_y_t4 sig_n1__t4 sig_n1 99.6782748034
* device instance a_g_y_mnab_y_mpa_y_mpb_y_n1_s1_a_y r0 *1 0,0
Ca_g_y_mnab_y_mpa_y_mpb_y_n1_s1_a_y sig_n1 vsubs 2.632209e-15
* device instance a_n2_s1_y_s2_a_y_t0 r0 *1 0,0
Ra_n2_s1_y_s2_a_y_t0 sig_n2__t0 sig_n2 184.787796322
* device instance a_n2_s1_y_s2_a_y_t1 r0 *1 0,0
Ra_n2_s1_y_s2_a_y_t1 sig_n2__t1 sig_n2 184.787796322
* device instance a_n2_s1_y_s2_a_y_t2 r0 *1 0,0
Ra_n2_s1_y_s2_a_y_t2 sig_n2__t2 sig_n2 192.568303678
* device instance a_n2_s1_y_s2_a_y_t3 r0 *1 0,0
Ra_n2_s1_y_s2_a_y_t3 sig_n2__t3 sig_n2 192.568303678
* device instance a_n2_s1_y_s2_a_y r0 *1 0,0
Ca_n2_s1_y_s2_a_y sig_n2 vsubs 2.529995e-15
* device instance a_n3_s2_y_s3_a_y_t0 r0 *1 0,0
Ra_n3_s2_y_s3_a_y_t0 sig_n3__t0 sig_n3 184.787796322
* device instance a_n3_s2_y_s3_a_y_t1 r0 *1 0,0
Ra_n3_s2_y_s3_a_y_t1 sig_n3__t1 sig_n3 184.787796322
* device instance a_n3_s2_y_s3_a_y_t2 r0 *1 0,0
Ra_n3_s2_y_s3_a_y_t2 sig_n3__t2 sig_n3 192.568303678
* device instance a_n3_s2_y_s3_a_y_t3 r0 *1 0,0
Ra_n3_s2_y_s3_a_y_t3 sig_n3__t3 sig_n3 192.568303678
* device instance a_n3_s2_y_s3_a_y r0 *1 0,0
Ca_n3_s2_y_s3_a_y sig_n3 vsubs 2.529995e-15
* device instance a_n4_s3_y_s4_a_y_t0 r0 *1 0,0
Ra_n4_s3_y_s4_a_y_t0 sig_n4__t0 sig_n4 184.787796322
* device instance a_n4_s3_y_s4_a_y_t1 r0 *1 0,0
Ra_n4_s3_y_s4_a_y_t1 sig_n4__t1 sig_n4 184.787796322
* device instance a_n4_s3_y_s4_a_y_t2 r0 *1 0,0
Ra_n4_s3_y_s4_a_y_t2 sig_n4__t2 sig_n4 192.568303678
* device instance a_n4_s3_y_s4_a_y_t3 r0 *1 0,0
Ra_n4_s3_y_s4_a_y_t3 sig_n4__t3 sig_n4 192.568303678
* device instance a_n4_s3_y_s4_a_y r0 *1 0,0
Ca_n4_s3_y_s4_a_y sig_n4 vsubs 2.529995e-15
* device instance en_g_en_t0 r0 *1 0,0
Ren_g_en_t0 en__t0 en 166.9848
* device instance en_g_en_t1 r0 *1 0,0
Ren_g_en_t1 en__t1 en 166.9848
* device instance en_g_en r0 *1 0,0
Cen_g_en en vsubs 5.93421e-16
* device instance g_vddr_m1_mnt_g_s1_vddr_m1_s2_vddr_m1_s3_vddr_m1_s4_vddr_m1_vddr_t0 r0 *1 0,0
Rg_vddr_m1_mnt_g_s1_vddr_m1_s2_vddr_m1_s3_vddr_m1_s4_vddr_m1_vddr_t0 vddr__t0 vddr 118.269225677
* device instance g_vddr_m1_mnt_g_s1_vddr_m1_s2_vddr_m1_s3_vddr_m1_s4_vddr_m1_vddr_t1 r0 *1 0,0
Rg_vddr_m1_mnt_g_s1_vddr_m1_s2_vddr_m1_s3_vddr_m1_s4_vddr_m1_vddr_t1 vddr__t1 vddr 116.975276743
* device instance g_vddr_m1_mnt_g_s1_vddr_m1_s2_vddr_m1_s3_vddr_m1_s4_vddr_m1_vddr_t2 r0 *1 0,0
Rg_vddr_m1_mnt_g_s1_vddr_m1_s2_vddr_m1_s3_vddr_m1_s4_vddr_m1_vddr_t2 vddr__t2 vddr 116.975276743
* device instance g_vddr_m1_mnt_g_s1_vddr_m1_s2_vddr_m1_s3_vddr_m1_s4_vddr_m1_vddr_t3 r0 *1 0,0
Rg_vddr_m1_mnt_g_s1_vddr_m1_s2_vddr_m1_s3_vddr_m1_s4_vddr_m1_vddr_t3 vddr__t3 vddr 102.210881433
* device instance g_vddr_m1_mnt_g_s1_vddr_m1_s2_vddr_m1_s3_vddr_m1_s4_vddr_m1_vddr_t4 r0 *1 0,0
Rg_vddr_m1_mnt_g_s1_vddr_m1_s2_vddr_m1_s3_vddr_m1_s4_vddr_m1_vddr_t4 vddr__t4 vddr 129.068896839
* device instance g_vddr_m1_mnt_g_s1_vddr_m1_s2_vddr_m1_s3_vddr_m1_s4_vddr_m1_vddr_t5 r0 *1 0,0
Rg_vddr_m1_mnt_g_s1_vddr_m1_s2_vddr_m1_s3_vddr_m1_s4_vddr_m1_vddr_t5 vddr__t5 vddr 73.3391059075
* device instance g_vddr_m1_mnt_g_s1_vddr_m1_s2_vddr_m1_s3_vddr_m1_s4_vddr_m1_vddr_t6 r0 *1 0,0
Rg_vddr_m1_mnt_g_s1_vddr_m1_s2_vddr_m1_s3_vddr_m1_s4_vddr_m1_vddr_t6 vddr__t6 vddr 18.2150363615
* device instance g_vddr_m1_mnt_g_s1_vddr_m1_s2_vddr_m1_s3_vddr_m1_s4_vddr_m1_vddr_t7 r0 *1 0,0
Rg_vddr_m1_mnt_g_s1_vddr_m1_s2_vddr_m1_s3_vddr_m1_s4_vddr_m1_vddr_t7 vddr__t7 vddr 38.9649767653
* device instance g_vddr_m1_mnt_g_s1_vddr_m1_s2_vddr_m1_s3_vddr_m1_s4_vddr_m1_vddr_t8 r0 *1 0,0
Rg_vddr_m1_mnt_g_s1_vddr_m1_s2_vddr_m1_s3_vddr_m1_s4_vddr_m1_vddr_t8 vddr__t8 vddr 93.4166858584
* device instance g_vddr_m1_mnt_g_s1_vddr_m1_s2_vddr_m1_s3_vddr_m1_s4_vddr_m1_vddr_t9 r0 *1 0,0
Rg_vddr_m1_mnt_g_s1_vddr_m1_s2_vddr_m1_s3_vddr_m1_s4_vddr_m1_vddr_t9 vddr__t9 vddr 53.632711459
* device instance g_vddr_m1_mnt_g_s1_vddr_m1_s2_vddr_m1_s3_vddr_m1_s4_vddr_m1_vddr_t10 r0 *1 0,0
Rg_vddr_m1_mnt_g_s1_vddr_m1_s2_vddr_m1_s3_vddr_m1_s4_vddr_m1_vddr_t10 vddr__t10 vddr 6.26137502177
* device instance g_vddr_m1_mnt_g_s1_vddr_m1_s2_vddr_m1_s3_vddr_m1_s4_vddr_m1_vddr_t11 r0 *1 0,0
Rg_vddr_m1_mnt_g_s1_vddr_m1_s2_vddr_m1_s3_vddr_m1_s4_vddr_m1_vddr_t11 vddr__t11 vddr 58.611096784
* device instance g_vddr_m1_mnt_g_s1_vddr_m1_s2_vddr_m1_s3_vddr_m1_s4_vddr_m1_vddr_t12 r0 *1 0,0
Rg_vddr_m1_mnt_g_s1_vddr_m1_s2_vddr_m1_s3_vddr_m1_s4_vddr_m1_vddr_t12 vddr__t12 vddr 114.300635543
* device instance g_vddr_m1_mnt_g_s1_vddr_m1_s2_vddr_m1_s3_vddr_m1_s4_vddr_m1_vddr_t13 r0 *1 0,0
Rg_vddr_m1_mnt_g_s1_vddr_m1_s2_vddr_m1_s3_vddr_m1_s4_vddr_m1_vddr_t13 vddr__t13 vddr 53.632711459
* device instance g_vddr_m1_mnt_g_s1_vddr_m1_s2_vddr_m1_s3_vddr_m1_s4_vddr_m1_vddr_t14 r0 *1 0,0
Rg_vddr_m1_mnt_g_s1_vddr_m1_s2_vddr_m1_s3_vddr_m1_s4_vddr_m1_vddr_t14 vddr__t14 vddr 6.26137502177
* device instance g_vddr_m1_mnt_g_s1_vddr_m1_s2_vddr_m1_s3_vddr_m1_s4_vddr_m1_vddr_t15 r0 *1 0,0
Rg_vddr_m1_mnt_g_s1_vddr_m1_s2_vddr_m1_s3_vddr_m1_s4_vddr_m1_vddr_t15 vddr__t15 vddr 58.611096784
* device instance g_vddr_m1_mnt_g_s1_vddr_m1_s2_vddr_m1_s3_vddr_m1_s4_vddr_m1_vddr_t16 r0 *1 0,0
Rg_vddr_m1_mnt_g_s1_vddr_m1_s2_vddr_m1_s3_vddr_m1_s4_vddr_m1_vddr_t16 vddr__t16 vddr 114.300635543
* device instance g_vddr_m1_mnt_g_s1_vddr_m1_s2_vddr_m1_s3_vddr_m1_s4_vddr_m1_vddr_t17 r0 *1 0,0
Rg_vddr_m1_mnt_g_s1_vddr_m1_s2_vddr_m1_s3_vddr_m1_s4_vddr_m1_vddr_t17 vddr__t17 vddr 115.624520145
* device instance g_vddr_m1_mnt_g_s1_vddr_m1_s2_vddr_m1_s3_vddr_m1_s4_vddr_m1_vddr_t18 r0 *1 0,0
Rg_vddr_m1_mnt_g_s1_vddr_m1_s2_vddr_m1_s3_vddr_m1_s4_vddr_m1_vddr_t18 vddr__t18 vddr 61.1527189857
* device instance g_vddr_m1_mnt_g_s1_vddr_m1_s2_vddr_m1_s3_vddr_m1_s4_vddr_m1_vddr_t19 r0 *1 0,0
Rg_vddr_m1_mnt_g_s1_vddr_m1_s2_vddr_m1_s3_vddr_m1_s4_vddr_m1_vddr_t19 vddr__t19 vddr 18.5364287362
* device instance g_vddr_m1_mnt_g_s1_vddr_m1_s2_vddr_m1_s3_vddr_m1_s4_vddr_m1_vddr_t20 r0 *1 0,0
Rg_vddr_m1_mnt_g_s1_vddr_m1_s2_vddr_m1_s3_vddr_m1_s4_vddr_m1_vddr_t20 vddr__t20 vddr 56.3991321881
* device instance g_vddr_m1_mnt_g_s1_vddr_m1_s2_vddr_m1_s3_vddr_m1_s4_vddr_m1_vddr r0 *1 0,0
Cg_vddr_m1_mnt_g_s1_vddr_m1_s2_vddr_m1_s3_vddr_m1_s4_vddr_m1_vddr vddr vsubs 1.2363377e-14
* device instance g_vss_m1_mph_g_s1_vss_m1_s2_vss_m1_s3_vss_m1_s4_vss_m1_vss_t0 r0 *1 0,0
Rg_vss_m1_mph_g_s1_vss_m1_s2_vss_m1_s3_vss_m1_s4_vss_m1_vss_t0 vss__t0 vss 118.483890525
* device instance g_vss_m1_mph_g_s1_vss_m1_s2_vss_m1_s3_vss_m1_s4_vss_m1_vss_t1 r0 *1 0,0
Rg_vss_m1_mph_g_s1_vss_m1_s2_vss_m1_s3_vss_m1_s4_vss_m1_vss_t1 vss__t1 vss 119.790339031
* device instance g_vss_m1_mph_g_s1_vss_m1_s2_vss_m1_s3_vss_m1_s4_vss_m1_vss_t2 r0 *1 0,0
Rg_vss_m1_mph_g_s1_vss_m1_s2_vss_m1_s3_vss_m1_s4_vss_m1_vss_t2 vss__t2 vss 57.215024145
* device instance g_vss_m1_mph_g_s1_vss_m1_s2_vss_m1_s3_vss_m1_s4_vss_m1_vss_t3 r0 *1 0,0
Rg_vss_m1_mph_g_s1_vss_m1_s2_vss_m1_s3_vss_m1_s4_vss_m1_vss_t3 vss__t3 vss 18.7205074433
* device instance g_vss_m1_mph_g_s1_vss_m1_s2_vss_m1_s3_vss_m1_s4_vss_m1_vss_t4 r0 *1 0,0
Rg_vss_m1_mph_g_s1_vss_m1_s2_vss_m1_s3_vss_m1_s4_vss_m1_vss_t4 vss__t4 vss 61.6599004245
* device instance g_vss_m1_mph_g_s1_vss_m1_s2_vss_m1_s3_vss_m1_s4_vss_m1_vss_t5 r0 *1 0,0
Rg_vss_m1_mph_g_s1_vss_m1_s2_vss_m1_s3_vss_m1_s4_vss_m1_vss_t5 vss__t5 vss 116.739096931
* device instance g_vss_m1_mph_g_s1_vss_m1_s2_vss_m1_s3_vss_m1_s4_vss_m1_vss_t6 r0 *1 0,0
Rg_vss_m1_mph_g_s1_vss_m1_s2_vss_m1_s3_vss_m1_s4_vss_m1_vss_t6 vss__t6 vss 115.398109781
* device instance g_vss_m1_mph_g_s1_vss_m1_s2_vss_m1_s3_vss_m1_s4_vss_m1_vss_t7 r0 *1 0,0
Rg_vss_m1_mph_g_s1_vss_m1_s2_vss_m1_s3_vss_m1_s4_vss_m1_vss_t7 vss__t7 vss 59.0817256794
* device instance g_vss_m1_mph_g_s1_vss_m1_s2_vss_m1_s3_vss_m1_s4_vss_m1_vss_t8 r0 *1 0,0
Rg_vss_m1_mph_g_s1_vss_m1_s2_vss_m1_s3_vss_m1_s4_vss_m1_vss_t8 vss__t8 vss 6.25814571825
* device instance g_vss_m1_mph_g_s1_vss_m1_s2_vss_m1_s3_vss_m1_s4_vss_m1_vss_t9 r0 *1 0,0
Rg_vss_m1_mph_g_s1_vss_m1_s2_vss_m1_s3_vss_m1_s4_vss_m1_vss_t9 vss__t9 vss 54.426702792
* device instance g_vss_m1_mph_g_s1_vss_m1_s2_vss_m1_s3_vss_m1_s4_vss_m1_vss_t10 r0 *1 0,0
Rg_vss_m1_mph_g_s1_vss_m1_s2_vss_m1_s3_vss_m1_s4_vss_m1_vss_t10 vss__t10 vss 118.483890525
* device instance g_vss_m1_mph_g_s1_vss_m1_s2_vss_m1_s3_vss_m1_s4_vss_m1_vss_t11 r0 *1 0,0
Rg_vss_m1_mph_g_s1_vss_m1_s2_vss_m1_s3_vss_m1_s4_vss_m1_vss_t11 vss__t11 vss 54.426702792
* device instance g_vss_m1_mph_g_s1_vss_m1_s2_vss_m1_s3_vss_m1_s4_vss_m1_vss_t12 r0 *1 0,0
Rg_vss_m1_mph_g_s1_vss_m1_s2_vss_m1_s3_vss_m1_s4_vss_m1_vss_t12 vss__t12 vss 6.25814571825
* device instance g_vss_m1_mph_g_s1_vss_m1_s2_vss_m1_s3_vss_m1_s4_vss_m1_vss_t13 r0 *1 0,0
Rg_vss_m1_mph_g_s1_vss_m1_s2_vss_m1_s3_vss_m1_s4_vss_m1_vss_t13 vss__t13 vss 59.0817256794
* device instance g_vss_m1_mph_g_s1_vss_m1_s2_vss_m1_s3_vss_m1_s4_vss_m1_vss_t14 r0 *1 0,0
Rg_vss_m1_mph_g_s1_vss_m1_s2_vss_m1_s3_vss_m1_s4_vss_m1_vss_t14 vss__t14 vss 115.398109781
* device instance g_vss_m1_mph_g_s1_vss_m1_s2_vss_m1_s3_vss_m1_s4_vss_m1_vss_t15 r0 *1 0,0
Rg_vss_m1_mph_g_s1_vss_m1_s2_vss_m1_s3_vss_m1_s4_vss_m1_vss_t15 vss__t15 vss 38.2269784356
* device instance g_vss_m1_mph_g_s1_vss_m1_s2_vss_m1_s3_vss_m1_s4_vss_m1_vss_t16 r0 *1 0,0
Rg_vss_m1_mph_g_s1_vss_m1_s2_vss_m1_s3_vss_m1_s4_vss_m1_vss_t16 vss__t16 vss 19.5536956746
* device instance g_vss_m1_mph_g_s1_vss_m1_s2_vss_m1_s3_vss_m1_s4_vss_m1_vss_t17 r0 *1 0,0
Rg_vss_m1_mph_g_s1_vss_m1_s2_vss_m1_s3_vss_m1_s4_vss_m1_vss_t17 vss__t17 vss 75.3523699638
* device instance g_vss_m1_mph_g_s1_vss_m1_s2_vss_m1_s3_vss_m1_s4_vss_m1_vss_t18 r0 *1 0,0
Rg_vss_m1_mph_g_s1_vss_m1_s2_vss_m1_s3_vss_m1_s4_vss_m1_vss_t18 vss__t18 vss 131.712565134
* device instance g_vss_m1_mph_g_s1_vss_m1_s2_vss_m1_s3_vss_m1_s4_vss_m1_vss_t19 r0 *1 0,0
Rg_vss_m1_mph_g_s1_vss_m1_s2_vss_m1_s3_vss_m1_s4_vss_m1_vss_t19 vss__t19 vss 102.174066353
* device instance g_vss_m1_mph_g_s1_vss_m1_s2_vss_m1_s3_vss_m1_s4_vss_m1_vss_t20 r0 *1 0,0
Rg_vss_m1_mph_g_s1_vss_m1_s2_vss_m1_s3_vss_m1_s4_vss_m1_vss_t20 vss__t20 vss 97.5549074724
* device instance g_vss_m1_mph_g_s1_vss_m1_s2_vss_m1_s3_vss_m1_s4_vss_m1_vss r0 *1 0,0
Cg_vss_m1_mph_g_s1_vss_m1_s2_vss_m1_s3_vss_m1_s4_vss_m1_vss vss vsubs 1.1753189e-14
* device instance mpa_py_mpb_py_mph_py_py_t0 r0 *1 0,0
Rmpa_py_mpb_py_mph_py_py_t0 py_g__t0 py_g 33.64835
* device instance mpa_py_mpb_py_mph_py_py_t1 r0 *1 0,0
Rmpa_py_mpb_py_mph_py_py_t1 py_g__t1 py_g 5.23884452847
* device instance mpa_py_mpb_py_mph_py_py_t2 r0 *1 0,0
Rmpa_py_mpb_py_mph_py_py_t2 py_g__t2 py_g 28.4095054715
* device instance mpa_py_mpb_py_mph_py_py r0 *1 0,0
Cmpa_py_mpb_py_mph_py_py py_g vsubs 7.94002e-16
* device instance ny_t0 r0 *1 0,0
Rny_t0 ny__t0 ny 44.45845
* device instance ny_t1 r0 *1 0,0
Rny_t1 ny__t1 ny 44.45845
* device instance ny r0 *1 0,0
Cny ny vsubs 2.11758e-16
* device instance ny_dup1_t0 r0 *1 0,0
Rny_dup1_t0 ny__t02 nyn1 41.7022
* device instance ny_dup1_t1 r0 *1 0,0
Rny_dup1_t1 ny__t12 nyn1 41.7022
* device instance ny_dup1 r0 *1 0,0
Cny_dup1 nyn1 vsubs 1.70111e-16
* device instance ny_dup2_t0 r0 *1 0,0
Rny_dup2_t0 ny__t03 nyn2 41.7022
* device instance ny_dup2_t1 r0 *1 0,0
Rny_dup2_t1 ny__t13 nyn2 41.7022
* device instance ny_dup2 r0 *1 0,0
Cny_dup2 nyn2 vsubs 1.70111e-16
* device instance ny_dup3_t0 r0 *1 0,0
Rny_dup3_t0 ny__t04 nyn3 41.7022
* device instance ny_dup3_t1 r0 *1 0,0
Rny_dup3_t1 ny__t14 nyn3 41.7022
* device instance ny_dup3 r0 *1 0,0
Cny_dup3 nyn3 vsubs 1.70111e-16
* device instance ny_dup4_t0 r0 *1 0,0
Rny_dup4_t0 ny__t05 nyn4 41.7022
* device instance ny_dup4_t1 r0 *1 0,0
Rny_dup4_t1 ny__t15 nyn4 41.7022
* device instance ny_dup4 r0 *1 0,0
Cny_dup4 nyn4 vsubs 1.70111e-16
* device instance py_t0 r0 *1 0,0
Rpy_t0 py__t0 py 37.6683
* device instance py_t1 r0 *1 0,0
Rpy_t1 py__t1 py 37.6683
* device instance py r0 *1 0,0
Cpy py vsubs 1.9321e-16
* device instance py_dup1_t0 r0 *1 0,0
Rpy_dup1_t0 py__t02 pyn1 37.6683
* device instance py_dup1_t1 r0 *1 0,0
Rpy_dup1_t1 py__t12 pyn1 37.6683
* device instance py_dup1 r0 *1 0,0
Cpy_dup1 pyn1 vsubs 1.9321e-16
* device instance py_dup2_t0 r0 *1 0,0
Rpy_dup2_t0 py__t03 pyn2 37.6683
* device instance py_dup2_t1 r0 *1 0,0
Rpy_dup2_t1 py__t13 pyn2 37.6683
* device instance py_dup2 r0 *1 0,0
Cpy_dup2 pyn2 vsubs 1.9321e-16
* device instance py_dup3_t0 r0 *1 0,0
Rpy_dup3_t0 py__t04 pyn3 37.6683
* device instance py_dup3_t1 r0 *1 0,0
Rpy_dup3_t1 py__t14 pyn3 37.6683
* device instance py_dup3 r0 *1 0,0
Cpy_dup3 pyn3 vsubs 1.9321e-16
* device instance cc_a_g_a_ro_s4_y_y_a_g_y_mnab_y_mpa_y_mpb_y_n1_s1_a_y r0 *1 0,0
Ccc_a_g_a_ro_s4_y_y_a_g_y_mnab_y_mpa_y_mpb_y_n1_s1_a_y ro sig_n1 1.5977e-17
* device instance cc_a_g_a_ro_s4_y_y_g_vddr_m1_mnt_g_s1_vddr_m1_s2_vddr_m1_s3_vddr_m1_s4_vddr_m1_vddr r0 *1 0,0
Ccc_a_g_a_ro_s4_y_y_g_vddr_m1_mnt_g_s1_vddr_m1_s2_vddr_m1_s3_vddr_m1_s4_vddr_m1_vddr ro vddr 1.5474e-17
* device instance cc_a_g_y_mnab_y_mpa_y_mpb_y_n1_s1_a_y_g_vss_m1_mph_g_s1_vss_m1_s2_vss_m1_s3_vss_m1_s4_vss_m1_vss r0 *1 0,0
Ccc_a_g_y_mnab_y_mpa_y_mpb_y_n1_s1_a_y_g_vss_m1_mph_g_s1_vss_m1_s2_vss_m1_s3_vss_m1_s4_vss_m1_vss sig_n1 vss 3.869e-18
* device instance cc_a_g_y_mnab_y_mpa_y_mpb_y_n1_s1_a_y_ny r0 *1 0,0
Ccc_a_g_y_mnab_y_mpa_y_mpb_y_n1_s1_a_y_ny sig_n1 nyn4 2.878e-18
* device instance cc_a_n2_s1_y_s2_a_y_g_vss_m1_mph_g_s1_vss_m1_s2_vss_m1_s3_vss_m1_s4_vss_m1_vss r0 *1 0,0
Ccc_a_n2_s1_y_s2_a_y_g_vss_m1_mph_g_s1_vss_m1_s2_vss_m1_s3_vss_m1_s4_vss_m1_vss sig_n2 vss 3.869e-18
* device instance cc_a_n2_s1_y_s2_a_y_ny r0 *1 0,0
Ccc_a_n2_s1_y_s2_a_y_ny sig_n2 nyn4 2.878e-18
* device instance cc_a_n3_s2_y_s3_a_y_g_vss_m1_mph_g_s1_vss_m1_s2_vss_m1_s3_vss_m1_s4_vss_m1_vss r0 *1 0,0
Ccc_a_n3_s2_y_s3_a_y_g_vss_m1_mph_g_s1_vss_m1_s2_vss_m1_s3_vss_m1_s4_vss_m1_vss sig_n3 vss 3.869e-18
* device instance cc_a_n3_s2_y_s3_a_y_ny r0 *1 0,0
Ccc_a_n3_s2_y_s3_a_y_ny sig_n3 nyn4 2.878e-18
* device instance cc_a_n4_s3_y_s4_a_y_g_vss_m1_mph_g_s1_vss_m1_s2_vss_m1_s3_vss_m1_s4_vss_m1_vss r0 *1 0,0
Ccc_a_n4_s3_y_s4_a_y_g_vss_m1_mph_g_s1_vss_m1_s2_vss_m1_s3_vss_m1_s4_vss_m1_vss sig_n4 vss 3.869e-18
* device instance cc_a_n4_s3_y_s4_a_y_ny r0 *1 0,0
Ccc_a_n4_s3_y_s4_a_y_ny sig_n4 nyn4 2.878e-18
* device instance cc_g_vddr_m1_mnt_g_s1_vddr_m1_s2_vddr_m1_s3_vddr_m1_s4_vddr_m1_vddr_py r0 *1 0,0
Ccc_g_vddr_m1_mnt_g_s1_vddr_m1_s2_vddr_m1_s3_vddr_m1_s4_vddr_m1_vddr_py vddr pyn3 1.2471e-17
* device instance vsubs_dctie r0 *1 0,0
Rvsubs_dctie vsubs 0 1e+12
.ends ro_ring5_assembled_pex_wstv0p42__core

* ro_ring5_assembled_pex_wstv0p42 -- design-port-order wrapper over ro_ring5_assembled_pex_wstv0p42__core.
* Promoted-internal layout pins kept local here: sig_n1, sig_n2, sig_n3, sig_n4, py_g, ny, nyn1, nyn2, nyn3, nyn4, py, pyn1, pyn2, pyn3
.subckt ro_ring5_assembled_pex_wstv0p42 en ro vddr vss
xpex ro sig_n1 sig_n2 sig_n3 sig_n4 en vddr vss py_g ny nyn1 nyn2 nyn3 nyn4 py pyn1 pyn2 pyn3 ro_ring5_assembled_pex_wstv0p42__core
.ends ro_ring5_assembled_pex_wstv0p42

*-----------------------------------------------------------------------
* ro_ring5_assembled_pex_wstv0p44 -- post-layout, from ../ro_ring5_wstv0p44/ro_ring5_wstv0p44.gds
* klt extract --parasitics: 22 devices, 19 nets
*-----------------------------------------------------------------------
.subckt ro_ring5_assembled_pex_wstv0p44__core ro sig_n1 sig_n2 sig_n3 sig_n4 en vddr vss py_g ny nyn1 nyn2 nyn3 nyn4 py pyn1 pyn2 pyn3
* device instance $1 r0 *1 13.085,0.21 nfet
Xn1 sig_n2__t0 sig_n1__t0 ny__t02 vss__t10 sky130_fd_pr__nfet_01v8 L=0.15 W=0.42 AS=0.1974 AD=0.1974 PS=1.78 PD=1.78
* device instance $2 r0 *1 21.26,0.21 nfet
Xn2 sig_n3__t0 sig_n2__t3 ny__t03 vss__t11 sky130_fd_pr__nfet_01v8 L=0.15 W=0.42 AS=0.1974 AD=0.1974 PS=1.78 PD=1.78
* device instance $3 r0 *1 29.435,0.21 nfet
Xn3 sig_n4__t0 sig_n3__t3 ny__t04 vss__t12 sky130_fd_pr__nfet_01v8 L=0.15 W=0.42 AS=0.1974 AD=0.1974 PS=1.78 PD=1.78
* device instance $4 r0 *1 37.61,0.21 nfet
Xn4 ro__t1 sig_n4__t3 ny__t05 vss__t13 sky130_fd_pr__nfet_01v8 L=0.15 W=0.42 AS=0.1974 AD=0.1974 PS=1.78 PD=1.78
* device instance $5 r0 *1 1.42,0.21 nfet
Xn5 ny__t0 vddr__t0 vss__t0 vss__t14 sky130_fd_pr__nfet_01v8 L=2 W=0.44 AS=0.1848 AD=0.1848 PS=1.72 PD=1.72
* device instance $6 r0 *1 10.72,0.21 nfet
Xn6 ny__t12 vddr__t20 vss__t9 vss__t15 sky130_fd_pr__nfet_01v8 L=2 W=0.44 AS=0.1848 AD=0.1848 PS=1.72 PD=1.72
* device instance $7 r0 *1 18.895,0.21 nfet
Xn7 ny__t13 vddr__t19 vss__t8 vss__t16 sky130_fd_pr__nfet_01v8 L=2 W=0.44 AS=0.1848 AD=0.1848 PS=1.72 PD=1.72
* device instance $8 r0 *1 27.07,0.21 nfet
Xn8 ny__t14 vddr__t18 vss__t7 vss__t17 sky130_fd_pr__nfet_01v8 L=2 W=0.44 AS=0.1848 AD=0.1848 PS=1.72 PD=1.72
* device instance $9 r0 *1 35.245,0.21 nfet
Xn9 ny__t15 vddr__t17 vss__t6 vss__t18 sky130_fd_pr__nfet_01v8 L=2 W=0.44 AS=0.1848 AD=0.1848 PS=1.72 PD=1.72
* device instance $10 r0 *1 3.785,0.21 nfet
Xn10 n5__t0 en__t0 ny__t1 vss__t19 sky130_fd_pr__nfet_01v8 L=0.15 W=0.84 AS=0.3948 AD=0.2184 PS=2.62 PD=1.36
* device instance $11 r0 *1 4.455,0.21 nfet
Xn11 sig_n1__t1 ro__t0 n5__t1 vss__t20 sky130_fd_pr__nfet_01v8 L=0.15 W=0.84 AS=0.2184 AD=0.3948 PS=1.36 PD=2.62
* device instance $12 r0 *1 1.42,3.74 pfet
Xn12 py_g__t0 vss__t1 vddr__t1 vddr__t2 sky130_fd_pr__pfet_01v8 L=2 W=0.44 AS=0.1848 AD=0.1848 PS=1.72 PD=1.72
* device instance $13 r0 *1 10.72,3.74 pfet
Xn13 py__t0 vss__t2 vddr__t13 vddr__t9 sky130_fd_pr__pfet_01v8 L=2 W=0.44 AS=0.1848 AD=0.1848 PS=1.72 PD=1.72
* device instance $14 r0 *1 18.895,3.74 pfet
Xn14 py__t02 vss__t3 vddr__t14 vddr__t10 sky130_fd_pr__pfet_01v8 L=2 W=0.44 AS=0.1848 AD=0.1848 PS=1.72 PD=1.72
* device instance $15 r0 *1 27.07,3.74 pfet
Xn15 py__t03 vss__t4 vddr__t15 vddr__t11 sky130_fd_pr__pfet_01v8 L=2 W=0.44 AS=0.1848 AD=0.1848 PS=1.72 PD=1.72
* device instance $16 r0 *1 35.245,3.74 pfet
Xn16 py__t04 vss__t5 vddr__t16 vddr__t12 sky130_fd_pr__pfet_01v8 L=2 W=0.44 AS=0.1848 AD=0.1848 PS=1.72 PD=1.72
* device instance $17 r0 *1 3.585,3.74 pfet
Xn17 sig_n1__t2 en__t1 py_g__t1 vddr__t3 sky130_fd_pr__pfet_01v8 L=0.15 W=0.84 AS=0.3948 AD=0.3948 PS=2.62 PD=2.62
* device instance $18 r0 *1 4.875,3.74 pfet
Xn18 py_g__t2 ro__t2 sig_n1__t3 vddr__t8 sky130_fd_pr__pfet_01v8 L=0.15 W=0.84 AS=0.3948 AD=0.3948 PS=2.62 PD=2.62
* device instance $19 r0 *1 12.885,3.74 pfet
Xn19 sig_n2__t2 sig_n1__t4 py__t1 vddr__t7 sky130_fd_pr__pfet_01v8 L=0.15 W=0.84 AS=0.3948 AD=0.3948 PS=2.62 PD=2.62
* device instance $20 r0 *1 21.06,3.74 pfet
Xn20 sig_n3__t2 sig_n2__t1 py__t12 vddr__t6 sky130_fd_pr__pfet_01v8 L=0.15 W=0.84 AS=0.3948 AD=0.3948 PS=2.62 PD=2.62
* device instance $21 r0 *1 29.235,3.74 pfet
Xn21 sig_n4__t2 sig_n3__t1 py__t13 vddr__t5 sky130_fd_pr__pfet_01v8 L=0.15 W=0.84 AS=0.3948 AD=0.3948 PS=2.62 PD=2.62
* device instance $22 r0 *1 37.41,3.74 pfet
Xn22 ro__t3 sig_n4__t1 py__t14 vddr__t4 sky130_fd_pr__pfet_01v8 L=0.15 W=0.84 AS=0.3948 AD=0.3948 PS=2.62 PD=2.62
* device instance _5_t0 r0 *1 0,0
R_5_t0 n5__t0 n5 12.8
* device instance _5_t1 r0 *1 0,0
R_5_t1 n5__t1 n5 12.8
* device instance _5 r0 *1 0,0
C_5 n5 vsubs 1.15618e-16
* device instance a_g_a_ro_s4_y_y_t0 r0 *1 0,0
Ra_g_a_ro_s4_y_y_t0 ro__t0 ro 199.905310752
* device instance a_g_a_ro_s4_y_y_t1 r0 *1 0,0
Ra_g_a_ro_s4_y_y_t1 ro__t1 ro 198.597996013
* device instance a_g_a_ro_s4_y_y_t2 r0 *1 0,0
Ra_g_a_ro_s4_y_y_t2 ro__t2 ro 194.914280155
* device instance a_g_a_ro_s4_y_y_t3 r0 *1 0,0
Ra_g_a_ro_s4_y_y_t3 ro__t3 ro 196.22131308
* device instance a_g_a_ro_s4_y_y r0 *1 0,0
Ca_g_a_ro_s4_y_y ro vsubs 4.73908e-15
* device instance a_g_y_mnab_y_mpa_y_mpb_y_n1_s1_a_y_t0 r0 *1 0,0
Ra_g_y_mnab_y_mpa_y_mpb_y_n1_s1_a_y_t0 sig_n1__t0 sig_n1 107.491339147
* device instance a_g_y_mnab_y_mpa_y_mpb_y_n1_s1_a_y_t1 r0 *1 0,0
Ra_g_y_mnab_y_mpa_y_mpb_y_n1_s1_a_y_t1 sig_n1__t1 sig_n1 74.101756002
* device instance a_g_y_mnab_y_mpa_y_mpb_y_n1_s1_a_y_t2 r0 *1 0,0
Ra_g_y_mnab_y_mpa_y_mpb_y_n1_s1_a_y_t2 sig_n1__t2 sig_n1 83.1989635875
* device instance a_g_y_mnab_y_mpa_y_mpb_y_n1_s1_a_y_t3 r0 *1 0,0
Ra_g_y_mnab_y_mpa_y_mpb_y_n1_s1_a_y_t3 sig_n1__t3 sig_n1 60.7011664601
* device instance a_g_y_mnab_y_mpa_y_mpb_y_n1_s1_a_y_t4 r0 *1 0,0
Ra_g_y_mnab_y_mpa_y_mpb_y_n1_s1_a_y_t4 sig_n1__t4 sig_n1 99.6782748034
* device instance a_g_y_mnab_y_mpa_y_mpb_y_n1_s1_a_y r0 *1 0,0
Ca_g_y_mnab_y_mpa_y_mpb_y_n1_s1_a_y sig_n1 vsubs 2.632209e-15
* device instance a_n2_s1_y_s2_a_y_t0 r0 *1 0,0
Ra_n2_s1_y_s2_a_y_t0 sig_n2__t0 sig_n2 184.787796322
* device instance a_n2_s1_y_s2_a_y_t1 r0 *1 0,0
Ra_n2_s1_y_s2_a_y_t1 sig_n2__t1 sig_n2 184.787796322
* device instance a_n2_s1_y_s2_a_y_t2 r0 *1 0,0
Ra_n2_s1_y_s2_a_y_t2 sig_n2__t2 sig_n2 192.568303678
* device instance a_n2_s1_y_s2_a_y_t3 r0 *1 0,0
Ra_n2_s1_y_s2_a_y_t3 sig_n2__t3 sig_n2 192.568303678
* device instance a_n2_s1_y_s2_a_y r0 *1 0,0
Ca_n2_s1_y_s2_a_y sig_n2 vsubs 2.529995e-15
* device instance a_n3_s2_y_s3_a_y_t0 r0 *1 0,0
Ra_n3_s2_y_s3_a_y_t0 sig_n3__t0 sig_n3 184.787796322
* device instance a_n3_s2_y_s3_a_y_t1 r0 *1 0,0
Ra_n3_s2_y_s3_a_y_t1 sig_n3__t1 sig_n3 184.787796322
* device instance a_n3_s2_y_s3_a_y_t2 r0 *1 0,0
Ra_n3_s2_y_s3_a_y_t2 sig_n3__t2 sig_n3 192.568303678
* device instance a_n3_s2_y_s3_a_y_t3 r0 *1 0,0
Ra_n3_s2_y_s3_a_y_t3 sig_n3__t3 sig_n3 192.568303678
* device instance a_n3_s2_y_s3_a_y r0 *1 0,0
Ca_n3_s2_y_s3_a_y sig_n3 vsubs 2.529995e-15
* device instance a_n4_s3_y_s4_a_y_t0 r0 *1 0,0
Ra_n4_s3_y_s4_a_y_t0 sig_n4__t0 sig_n4 184.787796322
* device instance a_n4_s3_y_s4_a_y_t1 r0 *1 0,0
Ra_n4_s3_y_s4_a_y_t1 sig_n4__t1 sig_n4 184.787796322
* device instance a_n4_s3_y_s4_a_y_t2 r0 *1 0,0
Ra_n4_s3_y_s4_a_y_t2 sig_n4__t2 sig_n4 192.568303678
* device instance a_n4_s3_y_s4_a_y_t3 r0 *1 0,0
Ra_n4_s3_y_s4_a_y_t3 sig_n4__t3 sig_n4 192.568303678
* device instance a_n4_s3_y_s4_a_y r0 *1 0,0
Ca_n4_s3_y_s4_a_y sig_n4 vsubs 2.529995e-15
* device instance en_g_en_t0 r0 *1 0,0
Ren_g_en_t0 en__t0 en 166.9848
* device instance en_g_en_t1 r0 *1 0,0
Ren_g_en_t1 en__t1 en 166.9848
* device instance en_g_en r0 *1 0,0
Cen_g_en en vsubs 5.93421e-16
* device instance g_vddr_m1_mnt_g_s1_vddr_m1_s2_vddr_m1_s3_vddr_m1_s4_vddr_m1_vddr_t0 r0 *1 0,0
Rg_vddr_m1_mnt_g_s1_vddr_m1_s2_vddr_m1_s3_vddr_m1_s4_vddr_m1_vddr_t0 vddr__t0 vddr 118.503071075
* device instance g_vddr_m1_mnt_g_s1_vddr_m1_s2_vddr_m1_s3_vddr_m1_s4_vddr_m1_vddr_t1 r0 *1 0,0
Rg_vddr_m1_mnt_g_s1_vddr_m1_s2_vddr_m1_s3_vddr_m1_s4_vddr_m1_vddr_t1 vddr__t1 vddr 117.206563707
* device instance g_vddr_m1_mnt_g_s1_vddr_m1_s2_vddr_m1_s3_vddr_m1_s4_vddr_m1_vddr_t2 r0 *1 0,0
Rg_vddr_m1_mnt_g_s1_vddr_m1_s2_vddr_m1_s3_vddr_m1_s4_vddr_m1_vddr_t2 vddr__t2 vddr 117.206563707
* device instance g_vddr_m1_mnt_g_s1_vddr_m1_s2_vddr_m1_s3_vddr_m1_s4_vddr_m1_vddr_t3 r0 *1 0,0
Rg_vddr_m1_mnt_g_s1_vddr_m1_s2_vddr_m1_s3_vddr_m1_s4_vddr_m1_vddr_t3 vddr__t3 vddr 102.412975799
* device instance g_vddr_m1_mnt_g_s1_vddr_m1_s2_vddr_m1_s3_vddr_m1_s4_vddr_m1_vddr_t4 r0 *1 0,0
Rg_vddr_m1_mnt_g_s1_vddr_m1_s2_vddr_m1_s3_vddr_m1_s4_vddr_m1_vddr_t4 vddr__t4 vddr 129.324095665
* device instance g_vddr_m1_mnt_g_s1_vddr_m1_s2_vddr_m1_s3_vddr_m1_s4_vddr_m1_vddr_t5 r0 *1 0,0
Rg_vddr_m1_mnt_g_s1_vddr_m1_s2_vddr_m1_s3_vddr_m1_s4_vddr_m1_vddr_t5 vddr__t5 vddr 73.4841141485
* device instance g_vddr_m1_mnt_g_s1_vddr_m1_s2_vddr_m1_s3_vddr_m1_s4_vddr_m1_vddr_t6 r0 *1 0,0
Rg_vddr_m1_mnt_g_s1_vddr_m1_s2_vddr_m1_s3_vddr_m1_s4_vddr_m1_vddr_t6 vddr__t6 vddr 18.2510516681
* device instance g_vddr_m1_mnt_g_s1_vddr_m1_s2_vddr_m1_s3_vddr_m1_s4_vddr_m1_vddr_t7 r0 *1 0,0
Rg_vddr_m1_mnt_g_s1_vddr_m1_s2_vddr_m1_s3_vddr_m1_s4_vddr_m1_vddr_t7 vddr__t7 vddr 39.0420194654
* device instance g_vddr_m1_mnt_g_s1_vddr_m1_s2_vddr_m1_s3_vddr_m1_s4_vddr_m1_vddr_t8 r0 *1 0,0
Rg_vddr_m1_mnt_g_s1_vddr_m1_s2_vddr_m1_s3_vddr_m1_s4_vddr_m1_vddr_t8 vddr__t8 vddr 93.6013920819
* device instance g_vddr_m1_mnt_g_s1_vddr_m1_s2_vddr_m1_s3_vddr_m1_s4_vddr_m1_vddr_t9 r0 *1 0,0
Rg_vddr_m1_mnt_g_s1_vddr_m1_s2_vddr_m1_s3_vddr_m1_s4_vddr_m1_vddr_t9 vddr__t9 vddr 53.7387556363
* device instance g_vddr_m1_mnt_g_s1_vddr_m1_s2_vddr_m1_s3_vddr_m1_s4_vddr_m1_vddr_t10 r0 *1 0,0
Rg_vddr_m1_mnt_g_s1_vddr_m1_s2_vddr_m1_s3_vddr_m1_s4_vddr_m1_vddr_t10 vddr__t10 vddr 6.27375519694
* device instance g_vddr_m1_mnt_g_s1_vddr_m1_s2_vddr_m1_s3_vddr_m1_s4_vddr_m1_vddr_t11 r0 *1 0,0
Rg_vddr_m1_mnt_g_s1_vddr_m1_s2_vddr_m1_s3_vddr_m1_s4_vddr_m1_vddr_t11 vddr__t11 vddr 58.7269843714
* device instance g_vddr_m1_mnt_g_s1_vddr_m1_s2_vddr_m1_s3_vddr_m1_s4_vddr_m1_vddr_t12 r0 *1 0,0
Rg_vddr_m1_mnt_g_s1_vddr_m1_s2_vddr_m1_s3_vddr_m1_s4_vddr_m1_vddr_t12 vddr__t12 vddr 114.526634128
* device instance g_vddr_m1_mnt_g_s1_vddr_m1_s2_vddr_m1_s3_vddr_m1_s4_vddr_m1_vddr_t13 r0 *1 0,0
Rg_vddr_m1_mnt_g_s1_vddr_m1_s2_vddr_m1_s3_vddr_m1_s4_vddr_m1_vddr_t13 vddr__t13 vddr 53.7387556363
* device instance g_vddr_m1_mnt_g_s1_vddr_m1_s2_vddr_m1_s3_vddr_m1_s4_vddr_m1_vddr_t14 r0 *1 0,0
Rg_vddr_m1_mnt_g_s1_vddr_m1_s2_vddr_m1_s3_vddr_m1_s4_vddr_m1_vddr_t14 vddr__t14 vddr 6.27375519694
* device instance g_vddr_m1_mnt_g_s1_vddr_m1_s2_vddr_m1_s3_vddr_m1_s4_vddr_m1_vddr_t15 r0 *1 0,0
Rg_vddr_m1_mnt_g_s1_vddr_m1_s2_vddr_m1_s3_vddr_m1_s4_vddr_m1_vddr_t15 vddr__t15 vddr 58.7269843714
* device instance g_vddr_m1_mnt_g_s1_vddr_m1_s2_vddr_m1_s3_vddr_m1_s4_vddr_m1_vddr_t16 r0 *1 0,0
Rg_vddr_m1_mnt_g_s1_vddr_m1_s2_vddr_m1_s3_vddr_m1_s4_vddr_m1_vddr_t16 vddr__t16 vddr 114.526634128
* device instance g_vddr_m1_mnt_g_s1_vddr_m1_s2_vddr_m1_s3_vddr_m1_s4_vddr_m1_vddr_t17 r0 *1 0,0
Rg_vddr_m1_mnt_g_s1_vddr_m1_s2_vddr_m1_s3_vddr_m1_s4_vddr_m1_vddr_t17 vddr__t17 vddr 115.853136353
* device instance g_vddr_m1_mnt_g_s1_vddr_m1_s2_vddr_m1_s3_vddr_m1_s4_vddr_m1_vddr_t18 r0 *1 0,0
Rg_vddr_m1_mnt_g_s1_vddr_m1_s2_vddr_m1_s3_vddr_m1_s4_vddr_m1_vddr_t18 vddr__t18 vddr 61.2736319434
* device instance g_vddr_m1_mnt_g_s1_vddr_m1_s2_vddr_m1_s3_vddr_m1_s4_vddr_m1_vddr_t19 r0 *1 0,0
Rg_vddr_m1_mnt_g_s1_vddr_m1_s2_vddr_m1_s3_vddr_m1_s4_vddr_m1_vddr_t19 vddr__t19 vddr 18.5730795093
* device instance g_vddr_m1_mnt_g_s1_vddr_m1_s2_vddr_m1_s3_vddr_m1_s4_vddr_m1_vddr_t20 r0 *1 0,0
Rg_vddr_m1_mnt_g_s1_vddr_m1_s2_vddr_m1_s3_vddr_m1_s4_vddr_m1_vddr_t20 vddr__t20 vddr 56.510646214
* device instance g_vddr_m1_mnt_g_s1_vddr_m1_s2_vddr_m1_s3_vddr_m1_s4_vddr_m1_vddr r0 *1 0,0
Cg_vddr_m1_mnt_g_s1_vddr_m1_s2_vddr_m1_s3_vddr_m1_s4_vddr_m1_vddr vddr vsubs 1.2368661e-14
* device instance g_vss_m1_mph_g_s1_vss_m1_s2_vss_m1_s3_vss_m1_s4_vss_m1_vss_t0 r0 *1 0,0
Rg_vss_m1_mph_g_s1_vss_m1_s2_vss_m1_s3_vss_m1_s4_vss_m1_vss_t0 vss__t0 vss 118.714643391
* device instance g_vss_m1_mph_g_s1_vss_m1_s2_vss_m1_s3_vss_m1_s4_vss_m1_vss_t1 r0 *1 0,0
Rg_vss_m1_mph_g_s1_vss_m1_s2_vss_m1_s3_vss_m1_s4_vss_m1_vss_t1 vss__t1 vss 120.023636265
* device instance g_vss_m1_mph_g_s1_vss_m1_s2_vss_m1_s3_vss_m1_s4_vss_m1_vss_t2 r0 *1 0,0
Rg_vss_m1_mph_g_s1_vss_m1_s2_vss_m1_s3_vss_m1_s4_vss_m1_vss_t2 vss__t2 vss 57.3264530551
* device instance g_vss_m1_mph_g_s1_vss_m1_s2_vss_m1_s3_vss_m1_s4_vss_m1_vss_t3 r0 *1 0,0
Rg_vss_m1_mph_g_s1_vss_m1_s2_vss_m1_s3_vss_m1_s4_vss_m1_vss_t3 vss__t3 vss 18.7569664989
* device instance g_vss_m1_mph_g_s1_vss_m1_s2_vss_m1_s3_vss_m1_s4_vss_m1_vss_t4 r0 *1 0,0
Rg_vss_m1_mph_g_s1_vss_m1_s2_vss_m1_s3_vss_m1_s4_vss_m1_vss_t4 vss__t4 vss 61.7799859371
* device instance g_vss_m1_mph_g_s1_vss_m1_s2_vss_m1_s3_vss_m1_s4_vss_m1_vss_t5 r0 *1 0,0
Rg_vss_m1_mph_g_s1_vss_m1_s2_vss_m1_s3_vss_m1_s4_vss_m1_vss_t5 vss__t5 vss 116.96645173
* device instance g_vss_m1_mph_g_s1_vss_m1_s2_vss_m1_s3_vss_m1_s4_vss_m1_vss_t6 r0 *1 0,0
Rg_vss_m1_mph_g_s1_vss_m1_s2_vss_m1_s3_vss_m1_s4_vss_m1_vss_t6 vss__t6 vss 115.622852946
* device instance g_vss_m1_mph_g_s1_vss_m1_s2_vss_m1_s3_vss_m1_s4_vss_m1_vss_t7 r0 *1 0,0
Rg_vss_m1_mph_g_s1_vss_m1_s2_vss_m1_s3_vss_m1_s4_vss_m1_vss_t7 vss__t7 vss 59.1967900773
* device instance g_vss_m1_mph_g_s1_vss_m1_s2_vss_m1_s3_vss_m1_s4_vss_m1_vss_t8 r0 *1 0,0
Rg_vss_m1_mph_g_s1_vss_m1_s2_vss_m1_s3_vss_m1_s4_vss_m1_vss_t8 vss__t8 vss 6.27033374696
* device instance g_vss_m1_mph_g_s1_vss_m1_s2_vss_m1_s3_vss_m1_s4_vss_m1_vss_t9 r0 *1 0,0
Rg_vss_m1_mph_g_s1_vss_m1_s2_vss_m1_s3_vss_m1_s4_vss_m1_vss_t9 vss__t9 vss 54.5327013171
* device instance g_vss_m1_mph_g_s1_vss_m1_s2_vss_m1_s3_vss_m1_s4_vss_m1_vss_t10 r0 *1 0,0
Rg_vss_m1_mph_g_s1_vss_m1_s2_vss_m1_s3_vss_m1_s4_vss_m1_vss_t10 vss__t10 vss 38.3014272471
* device instance g_vss_m1_mph_g_s1_vss_m1_s2_vss_m1_s3_vss_m1_s4_vss_m1_vss_t11 r0 *1 0,0
Rg_vss_m1_mph_g_s1_vss_m1_s2_vss_m1_s3_vss_m1_s4_vss_m1_vss_t11 vss__t11 vss 19.5917774028
* device instance g_vss_m1_mph_g_s1_vss_m1_s2_vss_m1_s3_vss_m1_s4_vss_m1_vss_t12 r0 *1 0,0
Rg_vss_m1_mph_g_s1_vss_m1_s2_vss_m1_s3_vss_m1_s4_vss_m1_vss_t12 vss__t12 vss 75.4991221951
* device instance g_vss_m1_mph_g_s1_vss_m1_s2_vss_m1_s3_vss_m1_s4_vss_m1_vss_t13 r0 *1 0,0
Rg_vss_m1_mph_g_s1_vss_m1_s2_vss_m1_s3_vss_m1_s4_vss_m1_vss_t13 vss__t13 vss 131.969081456
* device instance g_vss_m1_mph_g_s1_vss_m1_s2_vss_m1_s3_vss_m1_s4_vss_m1_vss_t14 r0 *1 0,0
Rg_vss_m1_mph_g_s1_vss_m1_s2_vss_m1_s3_vss_m1_s4_vss_m1_vss_t14 vss__t14 vss 118.714643391
* device instance g_vss_m1_mph_g_s1_vss_m1_s2_vss_m1_s3_vss_m1_s4_vss_m1_vss_t15 r0 *1 0,0
Rg_vss_m1_mph_g_s1_vss_m1_s2_vss_m1_s3_vss_m1_s4_vss_m1_vss_t15 vss__t15 vss 54.5327013171
* device instance g_vss_m1_mph_g_s1_vss_m1_s2_vss_m1_s3_vss_m1_s4_vss_m1_vss_t16 r0 *1 0,0
Rg_vss_m1_mph_g_s1_vss_m1_s2_vss_m1_s3_vss_m1_s4_vss_m1_vss_t16 vss__t16 vss 6.27033374696
* device instance g_vss_m1_mph_g_s1_vss_m1_s2_vss_m1_s3_vss_m1_s4_vss_m1_vss_t17 r0 *1 0,0
Rg_vss_m1_mph_g_s1_vss_m1_s2_vss_m1_s3_vss_m1_s4_vss_m1_vss_t17 vss__t17 vss 59.1967900773
* device instance g_vss_m1_mph_g_s1_vss_m1_s2_vss_m1_s3_vss_m1_s4_vss_m1_vss_t18 r0 *1 0,0
Rg_vss_m1_mph_g_s1_vss_m1_s2_vss_m1_s3_vss_m1_s4_vss_m1_vss_t18 vss__t18 vss 115.622852946
* device instance g_vss_m1_mph_g_s1_vss_m1_s2_vss_m1_s3_vss_m1_s4_vss_m1_vss_t19 r0 *1 0,0
Rg_vss_m1_mph_g_s1_vss_m1_s2_vss_m1_s3_vss_m1_s4_vss_m1_vss_t19 vss__t19 vss 102.373055081
* device instance g_vss_m1_mph_g_s1_vss_m1_s2_vss_m1_s3_vss_m1_s4_vss_m1_vss_t20 r0 *1 0,0
Rg_vss_m1_mph_g_s1_vss_m1_s2_vss_m1_s3_vss_m1_s4_vss_m1_vss_t20 vss__t20 vss 97.7449001741
* device instance g_vss_m1_mph_g_s1_vss_m1_s2_vss_m1_s3_vss_m1_s4_vss_m1_vss r0 *1 0,0
Cg_vss_m1_mph_g_s1_vss_m1_s2_vss_m1_s3_vss_m1_s4_vss_m1_vss vss vsubs 1.1758606e-14
* device instance mpa_py_mpb_py_mph_py_py_t0 r0 *1 0,0
Rmpa_py_mpb_py_mph_py_py_t0 py_g__t0 py_g 33.9531
* device instance mpa_py_mpb_py_mph_py_py_t1 r0 *1 0,0
Rmpa_py_mpb_py_mph_py_py_t1 py_g__t1 py_g 5.28629225979
* device instance mpa_py_mpb_py_mph_py_py_t2 r0 *1 0,0
Rmpa_py_mpb_py_mph_py_py_t2 py_g__t2 py_g 28.6668077402
* device instance mpa_py_mpb_py_mph_py_py r0 *1 0,0
Cmpa_py_mpb_py_mph_py_py py_g vsubs 7.95941e-16
* device instance ny_t0 r0 *1 0,0
Rny_t0 ny__t0 ny 44.6445
* device instance ny_t1 r0 *1 0,0
Rny_t1 ny__t1 ny 44.6445
* device instance ny r0 *1 0,0
Cny ny vsubs 2.13697e-16
* device instance ny_dup1_t0 r0 *1 0,0
Rny_dup1_t0 ny__t02 nyn1 41.76295
* device instance ny_dup1_t1 r0 *1 0,0
Rny_dup1_t1 ny__t12 nyn1 41.76295
* device instance ny_dup1 r0 *1 0,0
Cny_dup1 nyn1 vsubs 1.7205e-16
* device instance ny_dup2_t0 r0 *1 0,0
Rny_dup2_t0 ny__t03 nyn2 41.76295
* device instance ny_dup2_t1 r0 *1 0,0
Rny_dup2_t1 ny__t13 nyn2 41.76295
* device instance ny_dup2 r0 *1 0,0
Cny_dup2 nyn2 vsubs 1.7205e-16
* device instance ny_dup3_t0 r0 *1 0,0
Rny_dup3_t0 ny__t04 nyn3 41.76295
* device instance ny_dup3_t1 r0 *1 0,0
Rny_dup3_t1 ny__t14 nyn3 41.76295
* device instance ny_dup3 r0 *1 0,0
Cny_dup3 nyn3 vsubs 1.7205e-16
* device instance ny_dup4_t0 r0 *1 0,0
Rny_dup4_t0 ny__t05 nyn4 41.76295
* device instance ny_dup4_t1 r0 *1 0,0
Rny_dup4_t1 ny__t15 nyn4 41.76295
* device instance ny_dup4 r0 *1 0,0
Cny_dup4 nyn4 vsubs 1.7205e-16
* device instance py_t0 r0 *1 0,0
Rpy_t0 py__t0 py 37.875
* device instance py_t1 r0 *1 0,0
Rpy_t1 py__t1 py 37.875
* device instance py r0 *1 0,0
Cpy py vsubs 1.95101e-16
* device instance py_dup1_t0 r0 *1 0,0
Rpy_dup1_t0 py__t02 pyn1 37.875
* device instance py_dup1_t1 r0 *1 0,0
Rpy_dup1_t1 py__t12 pyn1 37.875
* device instance py_dup1 r0 *1 0,0
Cpy_dup1 pyn1 vsubs 1.95101e-16
* device instance py_dup2_t0 r0 *1 0,0
Rpy_dup2_t0 py__t03 pyn2 37.875
* device instance py_dup2_t1 r0 *1 0,0
Rpy_dup2_t1 py__t13 pyn2 37.875
* device instance py_dup2 r0 *1 0,0
Cpy_dup2 pyn2 vsubs 1.95101e-16
* device instance py_dup3_t0 r0 *1 0,0
Rpy_dup3_t0 py__t04 pyn3 37.875
* device instance py_dup3_t1 r0 *1 0,0
Rpy_dup3_t1 py__t14 pyn3 37.875
* device instance py_dup3 r0 *1 0,0
Cpy_dup3 pyn3 vsubs 1.95101e-16
* device instance cc_a_g_a_ro_s4_y_y_a_g_y_mnab_y_mpa_y_mpb_y_n1_s1_a_y r0 *1 0,0
Ccc_a_g_a_ro_s4_y_y_a_g_y_mnab_y_mpa_y_mpb_y_n1_s1_a_y ro sig_n1 1.5977e-17
* device instance cc_a_g_a_ro_s4_y_y_g_vddr_m1_mnt_g_s1_vddr_m1_s2_vddr_m1_s3_vddr_m1_s4_vddr_m1_vddr r0 *1 0,0
Ccc_a_g_a_ro_s4_y_y_g_vddr_m1_mnt_g_s1_vddr_m1_s2_vddr_m1_s3_vddr_m1_s4_vddr_m1_vddr ro vddr 1.5474e-17
* device instance cc_a_g_y_mnab_y_mpa_y_mpb_y_n1_s1_a_y_g_vss_m1_mph_g_s1_vss_m1_s2_vss_m1_s3_vss_m1_s4_vss_m1_vss r0 *1 0,0
Ccc_a_g_y_mnab_y_mpa_y_mpb_y_n1_s1_a_y_g_vss_m1_mph_g_s1_vss_m1_s2_vss_m1_s3_vss_m1_s4_vss_m1_vss sig_n1 vss 3.869e-18
* device instance cc_a_g_y_mnab_y_mpa_y_mpb_y_n1_s1_a_y_ny r0 *1 0,0
Ccc_a_g_y_mnab_y_mpa_y_mpb_y_n1_s1_a_y_ny sig_n1 nyn4 2.878e-18
* device instance cc_a_n2_s1_y_s2_a_y_g_vss_m1_mph_g_s1_vss_m1_s2_vss_m1_s3_vss_m1_s4_vss_m1_vss r0 *1 0,0
Ccc_a_n2_s1_y_s2_a_y_g_vss_m1_mph_g_s1_vss_m1_s2_vss_m1_s3_vss_m1_s4_vss_m1_vss sig_n2 vss 3.869e-18
* device instance cc_a_n2_s1_y_s2_a_y_ny r0 *1 0,0
Ccc_a_n2_s1_y_s2_a_y_ny sig_n2 nyn4 2.878e-18
* device instance cc_a_n3_s2_y_s3_a_y_g_vss_m1_mph_g_s1_vss_m1_s2_vss_m1_s3_vss_m1_s4_vss_m1_vss r0 *1 0,0
Ccc_a_n3_s2_y_s3_a_y_g_vss_m1_mph_g_s1_vss_m1_s2_vss_m1_s3_vss_m1_s4_vss_m1_vss sig_n3 vss 3.869e-18
* device instance cc_a_n3_s2_y_s3_a_y_ny r0 *1 0,0
Ccc_a_n3_s2_y_s3_a_y_ny sig_n3 nyn4 2.878e-18
* device instance cc_a_n4_s3_y_s4_a_y_g_vss_m1_mph_g_s1_vss_m1_s2_vss_m1_s3_vss_m1_s4_vss_m1_vss r0 *1 0,0
Ccc_a_n4_s3_y_s4_a_y_g_vss_m1_mph_g_s1_vss_m1_s2_vss_m1_s3_vss_m1_s4_vss_m1_vss sig_n4 vss 3.869e-18
* device instance cc_a_n4_s3_y_s4_a_y_ny r0 *1 0,0
Ccc_a_n4_s3_y_s4_a_y_ny sig_n4 nyn4 2.878e-18
* device instance cc_g_vddr_m1_mnt_g_s1_vddr_m1_s2_vddr_m1_s3_vddr_m1_s4_vddr_m1_vddr_py r0 *1 0,0
Ccc_g_vddr_m1_mnt_g_s1_vddr_m1_s2_vddr_m1_s3_vddr_m1_s4_vddr_m1_vddr_py vddr pyn3 1.3064e-17
* device instance vsubs_dctie r0 *1 0,0
Rvsubs_dctie vsubs 0 1e+12
.ends ro_ring5_assembled_pex_wstv0p44__core

* ro_ring5_assembled_pex_wstv0p44 -- design-port-order wrapper over ro_ring5_assembled_pex_wstv0p44__core.
* Promoted-internal layout pins kept local here: sig_n1, sig_n2, sig_n3, sig_n4, py_g, ny, nyn1, nyn2, nyn3, nyn4, py, pyn1, pyn2, pyn3
.subckt ro_ring5_assembled_pex_wstv0p44 en ro vddr vss
xpex ro sig_n1 sig_n2 sig_n3 sig_n4 en vddr vss py_g ny nyn1 nyn2 nyn3 nyn4 py pyn1 pyn2 pyn3 ro_ring5_assembled_pex_wstv0p44__core
.ends ro_ring5_assembled_pex_wstv0p44

*-----------------------------------------------------------------------
* ro_ring5_assembled_pex_wstv0p46 -- post-layout, from ../ro_ring5_wstv0p46/ro_ring5_wstv0p46.gds
* klt extract --parasitics: 22 devices, 19 nets
*-----------------------------------------------------------------------
.subckt ro_ring5_assembled_pex_wstv0p46__core ro sig_n1 sig_n2 sig_n3 sig_n4 en vddr vss py_g ny nyn1 nyn2 nyn3 nyn4 py pyn1 pyn2 pyn3
* device instance $1 r0 *1 13.085,0.21 nfet
Xn1 sig_n2__t0 sig_n1__t0 ny__t02 vss__t10 sky130_fd_pr__nfet_01v8 L=0.15 W=0.42 AS=0.1974 AD=0.1974 PS=1.78 PD=1.78
* device instance $2 r0 *1 21.26,0.21 nfet
Xn2 sig_n3__t0 sig_n2__t3 ny__t03 vss__t11 sky130_fd_pr__nfet_01v8 L=0.15 W=0.42 AS=0.1974 AD=0.1974 PS=1.78 PD=1.78
* device instance $3 r0 *1 29.435,0.21 nfet
Xn3 sig_n4__t0 sig_n3__t3 ny__t04 vss__t12 sky130_fd_pr__nfet_01v8 L=0.15 W=0.42 AS=0.1974 AD=0.1974 PS=1.78 PD=1.78
* device instance $4 r0 *1 37.61,0.21 nfet
Xn4 ro__t1 sig_n4__t3 ny__t05 vss__t13 sky130_fd_pr__nfet_01v8 L=0.15 W=0.42 AS=0.1974 AD=0.1974 PS=1.78 PD=1.78
* device instance $5 r0 *1 1.42,0.21 nfet
Xn5 ny__t0 vddr__t0 vss__t0 vss__t14 sky130_fd_pr__nfet_01v8 L=2 W=0.46 AS=0.1932 AD=0.1932 PS=1.76 PD=1.76
* device instance $6 r0 *1 10.72,0.21 nfet
Xn6 ny__t12 vddr__t20 vss__t9 vss__t15 sky130_fd_pr__nfet_01v8 L=2 W=0.46 AS=0.1932 AD=0.1932 PS=1.76 PD=1.76
* device instance $7 r0 *1 18.895,0.21 nfet
Xn7 ny__t13 vddr__t19 vss__t8 vss__t16 sky130_fd_pr__nfet_01v8 L=2 W=0.46 AS=0.1932 AD=0.1932 PS=1.76 PD=1.76
* device instance $8 r0 *1 27.07,0.21 nfet
Xn8 ny__t14 vddr__t18 vss__t7 vss__t17 sky130_fd_pr__nfet_01v8 L=2 W=0.46 AS=0.1932 AD=0.1932 PS=1.76 PD=1.76
* device instance $9 r0 *1 35.245,0.21 nfet
Xn9 ny__t15 vddr__t17 vss__t6 vss__t18 sky130_fd_pr__nfet_01v8 L=2 W=0.46 AS=0.1932 AD=0.1932 PS=1.76 PD=1.76
* device instance $10 r0 *1 3.785,0.21 nfet
Xn10 n5__t0 en__t0 ny__t1 vss__t19 sky130_fd_pr__nfet_01v8 L=0.15 W=0.84 AS=0.3948 AD=0.2184 PS=2.62 PD=1.36
* device instance $11 r0 *1 4.455,0.21 nfet
Xn11 sig_n1__t1 ro__t0 n5__t1 vss__t20 sky130_fd_pr__nfet_01v8 L=0.15 W=0.84 AS=0.2184 AD=0.3948 PS=1.36 PD=2.62
* device instance $12 r0 *1 1.42,3.74 pfet
Xn12 py_g__t0 vss__t1 vddr__t1 vddr__t2 sky130_fd_pr__pfet_01v8 L=2 W=0.46 AS=0.1932 AD=0.1932 PS=1.76 PD=1.76
* device instance $13 r0 *1 10.72,3.74 pfet
Xn13 py__t0 vss__t2 vddr__t13 vddr__t9 sky130_fd_pr__pfet_01v8 L=2 W=0.46 AS=0.1932 AD=0.1932 PS=1.76 PD=1.76
* device instance $14 r0 *1 18.895,3.74 pfet
Xn14 py__t02 vss__t3 vddr__t14 vddr__t10 sky130_fd_pr__pfet_01v8 L=2 W=0.46 AS=0.1932 AD=0.1932 PS=1.76 PD=1.76
* device instance $15 r0 *1 27.07,3.74 pfet
Xn15 py__t03 vss__t4 vddr__t15 vddr__t11 sky130_fd_pr__pfet_01v8 L=2 W=0.46 AS=0.1932 AD=0.1932 PS=1.76 PD=1.76
* device instance $16 r0 *1 35.245,3.74 pfet
Xn16 py__t04 vss__t5 vddr__t16 vddr__t12 sky130_fd_pr__pfet_01v8 L=2 W=0.46 AS=0.1932 AD=0.1932 PS=1.76 PD=1.76
* device instance $17 r0 *1 3.585,3.74 pfet
Xn17 sig_n1__t2 en__t1 py_g__t1 vddr__t3 sky130_fd_pr__pfet_01v8 L=0.15 W=0.84 AS=0.3948 AD=0.3948 PS=2.62 PD=2.62
* device instance $18 r0 *1 4.875,3.74 pfet
Xn18 py_g__t2 ro__t2 sig_n1__t3 vddr__t8 sky130_fd_pr__pfet_01v8 L=0.15 W=0.84 AS=0.3948 AD=0.3948 PS=2.62 PD=2.62
* device instance $19 r0 *1 12.885,3.74 pfet
Xn19 sig_n2__t2 sig_n1__t4 py__t1 vddr__t7 sky130_fd_pr__pfet_01v8 L=0.15 W=0.84 AS=0.3948 AD=0.3948 PS=2.62 PD=2.62
* device instance $20 r0 *1 21.06,3.74 pfet
Xn20 sig_n3__t2 sig_n2__t1 py__t12 vddr__t6 sky130_fd_pr__pfet_01v8 L=0.15 W=0.84 AS=0.3948 AD=0.3948 PS=2.62 PD=2.62
* device instance $21 r0 *1 29.235,3.74 pfet
Xn21 sig_n4__t2 sig_n3__t1 py__t13 vddr__t5 sky130_fd_pr__pfet_01v8 L=0.15 W=0.84 AS=0.3948 AD=0.3948 PS=2.62 PD=2.62
* device instance $22 r0 *1 37.41,3.74 pfet
Xn22 ro__t3 sig_n4__t1 py__t14 vddr__t4 sky130_fd_pr__pfet_01v8 L=0.15 W=0.84 AS=0.3948 AD=0.3948 PS=2.62 PD=2.62
* device instance _5_t0 r0 *1 0,0
R_5_t0 n5__t0 n5 12.8
* device instance _5_t1 r0 *1 0,0
R_5_t1 n5__t1 n5 12.8
* device instance _5 r0 *1 0,0
C_5 n5 vsubs 1.15618e-16
* device instance a_g_a_ro_s4_y_y_t0 r0 *1 0,0
Ra_g_a_ro_s4_y_y_t0 ro__t0 ro 199.905310752
* device instance a_g_a_ro_s4_y_y_t1 r0 *1 0,0
Ra_g_a_ro_s4_y_y_t1 ro__t1 ro 198.597996013
* device instance a_g_a_ro_s4_y_y_t2 r0 *1 0,0
Ra_g_a_ro_s4_y_y_t2 ro__t2 ro 194.914280155
* device instance a_g_a_ro_s4_y_y_t3 r0 *1 0,0
Ra_g_a_ro_s4_y_y_t3 ro__t3 ro 196.22131308
* device instance a_g_a_ro_s4_y_y r0 *1 0,0
Ca_g_a_ro_s4_y_y ro vsubs 4.73908e-15
* device instance a_g_y_mnab_y_mpa_y_mpb_y_n1_s1_a_y_t0 r0 *1 0,0
Ra_g_y_mnab_y_mpa_y_mpb_y_n1_s1_a_y_t0 sig_n1__t0 sig_n1 107.491339147
* device instance a_g_y_mnab_y_mpa_y_mpb_y_n1_s1_a_y_t1 r0 *1 0,0
Ra_g_y_mnab_y_mpa_y_mpb_y_n1_s1_a_y_t1 sig_n1__t1 sig_n1 74.101756002
* device instance a_g_y_mnab_y_mpa_y_mpb_y_n1_s1_a_y_t2 r0 *1 0,0
Ra_g_y_mnab_y_mpa_y_mpb_y_n1_s1_a_y_t2 sig_n1__t2 sig_n1 83.1989635875
* device instance a_g_y_mnab_y_mpa_y_mpb_y_n1_s1_a_y_t3 r0 *1 0,0
Ra_g_y_mnab_y_mpa_y_mpb_y_n1_s1_a_y_t3 sig_n1__t3 sig_n1 60.7011664601
* device instance a_g_y_mnab_y_mpa_y_mpb_y_n1_s1_a_y_t4 r0 *1 0,0
Ra_g_y_mnab_y_mpa_y_mpb_y_n1_s1_a_y_t4 sig_n1__t4 sig_n1 99.6782748034
* device instance a_g_y_mnab_y_mpa_y_mpb_y_n1_s1_a_y r0 *1 0,0
Ca_g_y_mnab_y_mpa_y_mpb_y_n1_s1_a_y sig_n1 vsubs 2.632209e-15
* device instance a_n2_s1_y_s2_a_y_t0 r0 *1 0,0
Ra_n2_s1_y_s2_a_y_t0 sig_n2__t0 sig_n2 184.787796322
* device instance a_n2_s1_y_s2_a_y_t1 r0 *1 0,0
Ra_n2_s1_y_s2_a_y_t1 sig_n2__t1 sig_n2 184.787796322
* device instance a_n2_s1_y_s2_a_y_t2 r0 *1 0,0
Ra_n2_s1_y_s2_a_y_t2 sig_n2__t2 sig_n2 192.568303678
* device instance a_n2_s1_y_s2_a_y_t3 r0 *1 0,0
Ra_n2_s1_y_s2_a_y_t3 sig_n2__t3 sig_n2 192.568303678
* device instance a_n2_s1_y_s2_a_y r0 *1 0,0
Ca_n2_s1_y_s2_a_y sig_n2 vsubs 2.529995e-15
* device instance a_n3_s2_y_s3_a_y_t0 r0 *1 0,0
Ra_n3_s2_y_s3_a_y_t0 sig_n3__t0 sig_n3 184.787796322
* device instance a_n3_s2_y_s3_a_y_t1 r0 *1 0,0
Ra_n3_s2_y_s3_a_y_t1 sig_n3__t1 sig_n3 184.787796322
* device instance a_n3_s2_y_s3_a_y_t2 r0 *1 0,0
Ra_n3_s2_y_s3_a_y_t2 sig_n3__t2 sig_n3 192.568303678
* device instance a_n3_s2_y_s3_a_y_t3 r0 *1 0,0
Ra_n3_s2_y_s3_a_y_t3 sig_n3__t3 sig_n3 192.568303678
* device instance a_n3_s2_y_s3_a_y r0 *1 0,0
Ca_n3_s2_y_s3_a_y sig_n3 vsubs 2.529995e-15
* device instance a_n4_s3_y_s4_a_y_t0 r0 *1 0,0
Ra_n4_s3_y_s4_a_y_t0 sig_n4__t0 sig_n4 184.787796322
* device instance a_n4_s3_y_s4_a_y_t1 r0 *1 0,0
Ra_n4_s3_y_s4_a_y_t1 sig_n4__t1 sig_n4 184.787796322
* device instance a_n4_s3_y_s4_a_y_t2 r0 *1 0,0
Ra_n4_s3_y_s4_a_y_t2 sig_n4__t2 sig_n4 192.568303678
* device instance a_n4_s3_y_s4_a_y_t3 r0 *1 0,0
Ra_n4_s3_y_s4_a_y_t3 sig_n4__t3 sig_n4 192.568303678
* device instance a_n4_s3_y_s4_a_y r0 *1 0,0
Ca_n4_s3_y_s4_a_y sig_n4 vsubs 2.529995e-15
* device instance en_g_en_t0 r0 *1 0,0
Ren_g_en_t0 en__t0 en 166.9848
* device instance en_g_en_t1 r0 *1 0,0
Ren_g_en_t1 en__t1 en 166.9848
* device instance en_g_en r0 *1 0,0
Cen_g_en en vsubs 5.93421e-16
* device instance g_vddr_m1_mnt_g_s1_vddr_m1_s2_vddr_m1_s3_vddr_m1_s4_vddr_m1_vddr_t0 r0 *1 0,0
Rg_vddr_m1_mnt_g_s1_vddr_m1_s2_vddr_m1_s3_vddr_m1_s4_vddr_m1_vddr_t0 vddr__t0 vddr 118.736924229
* device instance g_vddr_m1_mnt_g_s1_vddr_m1_s2_vddr_m1_s3_vddr_m1_s4_vddr_m1_vddr_t1 r0 *1 0,0
Rg_vddr_m1_mnt_g_s1_vddr_m1_s2_vddr_m1_s3_vddr_m1_s4_vddr_m1_vddr_t1 vddr__t1 vddr 117.437858342
* device instance g_vddr_m1_mnt_g_s1_vddr_m1_s2_vddr_m1_s3_vddr_m1_s4_vddr_m1_vddr_t2 r0 *1 0,0
Rg_vddr_m1_mnt_g_s1_vddr_m1_s2_vddr_m1_s3_vddr_m1_s4_vddr_m1_vddr_t2 vddr__t2 vddr 117.437858342
* device instance g_vddr_m1_mnt_g_s1_vddr_m1_s2_vddr_m1_s3_vddr_m1_s4_vddr_m1_vddr_t3 r0 *1 0,0
Rg_vddr_m1_mnt_g_s1_vddr_m1_s2_vddr_m1_s3_vddr_m1_s4_vddr_m1_vddr_t3 vddr__t3 vddr 102.615076869
* device instance g_vddr_m1_mnt_g_s1_vddr_m1_s2_vddr_m1_s3_vddr_m1_s4_vddr_m1_vddr_t4 r0 *1 0,0
Rg_vddr_m1_mnt_g_s1_vddr_m1_s2_vddr_m1_s3_vddr_m1_s4_vddr_m1_vddr_t4 vddr__t4 vddr 129.579302955
* device instance g_vddr_m1_mnt_g_s1_vddr_m1_s2_vddr_m1_s3_vddr_m1_s4_vddr_m1_vddr_t5 r0 *1 0,0
Rg_vddr_m1_mnt_g_s1_vddr_m1_s2_vddr_m1_s3_vddr_m1_s4_vddr_m1_vddr_t5 vddr__t5 vddr 73.6291271993
* device instance g_vddr_m1_mnt_g_s1_vddr_m1_s2_vddr_m1_s3_vddr_m1_s4_vddr_m1_vddr_t6 r0 *1 0,0
Rg_vddr_m1_mnt_g_s1_vddr_m1_s2_vddr_m1_s3_vddr_m1_s4_vddr_m1_vddr_t6 vddr__t6 vddr 18.2870681693
* device instance g_vddr_m1_mnt_g_s1_vddr_m1_s2_vddr_m1_s3_vddr_m1_s4_vddr_m1_vddr_t7 r0 *1 0,0
Rg_vddr_m1_mnt_g_s1_vddr_m1_s2_vddr_m1_s3_vddr_m1_s4_vddr_m1_vddr_t7 vddr__t7 vddr 39.119064721
* device instance g_vddr_m1_mnt_g_s1_vddr_m1_s2_vddr_m1_s3_vddr_m1_s4_vddr_m1_vddr_t8 r0 *1 0,0
Rg_vddr_m1_mnt_g_s1_vddr_m1_s2_vddr_m1_s3_vddr_m1_s4_vddr_m1_vddr_t8 vddr__t8 vddr 93.7861044322
* device instance g_vddr_m1_mnt_g_s1_vddr_m1_s2_vddr_m1_s3_vddr_m1_s4_vddr_m1_vddr_t9 r0 *1 0,0
Rg_vddr_m1_mnt_g_s1_vddr_m1_s2_vddr_m1_s3_vddr_m1_s4_vddr_m1_vddr_t9 vddr__t9 vddr 53.844803331
* device instance g_vddr_m1_mnt_g_s1_vddr_m1_s2_vddr_m1_s3_vddr_m1_s4_vddr_m1_vddr_t10 r0 *1 0,0
Rg_vddr_m1_mnt_g_s1_vddr_m1_s2_vddr_m1_s3_vddr_m1_s4_vddr_m1_vddr_t10 vddr__t10 vddr 6.28613578275
* device instance g_vddr_m1_mnt_g_s1_vddr_m1_s2_vddr_m1_s3_vddr_m1_s4_vddr_m1_vddr_t11 r0 *1 0,0
Rg_vddr_m1_mnt_g_s1_vddr_m1_s2_vddr_m1_s3_vddr_m1_s4_vddr_m1_vddr_t11 vddr__t11 vddr 58.8428758027
* device instance g_vddr_m1_mnt_g_s1_vddr_m1_s2_vddr_m1_s3_vddr_m1_s4_vddr_m1_vddr_t12 r0 *1 0,0
Rg_vddr_m1_mnt_g_s1_vddr_m1_s2_vddr_m1_s3_vddr_m1_s4_vddr_m1_vddr_t12 vddr__t12 vddr 114.752640208
* device instance g_vddr_m1_mnt_g_s1_vddr_m1_s2_vddr_m1_s3_vddr_m1_s4_vddr_m1_vddr_t13 r0 *1 0,0
Rg_vddr_m1_mnt_g_s1_vddr_m1_s2_vddr_m1_s3_vddr_m1_s4_vddr_m1_vddr_t13 vddr__t13 vddr 53.844803331
* device instance g_vddr_m1_mnt_g_s1_vddr_m1_s2_vddr_m1_s3_vddr_m1_s4_vddr_m1_vddr_t14 r0 *1 0,0
Rg_vddr_m1_mnt_g_s1_vddr_m1_s2_vddr_m1_s3_vddr_m1_s4_vddr_m1_vddr_t14 vddr__t14 vddr 6.28613578275
* device instance g_vddr_m1_mnt_g_s1_vddr_m1_s2_vddr_m1_s3_vddr_m1_s4_vddr_m1_vddr_t15 r0 *1 0,0
Rg_vddr_m1_mnt_g_s1_vddr_m1_s2_vddr_m1_s3_vddr_m1_s4_vddr_m1_vddr_t15 vddr__t15 vddr 58.8428758027
* device instance g_vddr_m1_mnt_g_s1_vddr_m1_s2_vddr_m1_s3_vddr_m1_s4_vddr_m1_vddr_t16 r0 *1 0,0
Rg_vddr_m1_mnt_g_s1_vddr_m1_s2_vddr_m1_s3_vddr_m1_s4_vddr_m1_vddr_t16 vddr__t16 vddr 114.752640208
* device instance g_vddr_m1_mnt_g_s1_vddr_m1_s2_vddr_m1_s3_vddr_m1_s4_vddr_m1_vddr_t17 r0 *1 0,0
Rg_vddr_m1_mnt_g_s1_vddr_m1_s2_vddr_m1_s3_vddr_m1_s4_vddr_m1_vddr_t17 vddr__t17 vddr 116.081760144
* device instance g_vddr_m1_mnt_g_s1_vddr_m1_s2_vddr_m1_s3_vddr_m1_s4_vddr_m1_vddr_t18 r0 *1 0,0
Rg_vddr_m1_mnt_g_s1_vddr_m1_s2_vddr_m1_s3_vddr_m1_s4_vddr_m1_vddr_t18 vddr__t18 vddr 61.3945489118
* device instance g_vddr_m1_mnt_g_s1_vddr_m1_s2_vddr_m1_s3_vddr_m1_s4_vddr_m1_vddr_t19 r0 *1 0,0
Rg_vddr_m1_mnt_g_s1_vddr_m1_s2_vddr_m1_s3_vddr_m1_s4_vddr_m1_vddr_t19 vddr__t19 vddr 18.609731498
* device instance g_vddr_m1_mnt_g_s1_vddr_m1_s2_vddr_m1_s3_vddr_m1_s4_vddr_m1_vddr_t20 r0 *1 0,0
Rg_vddr_m1_mnt_g_s1_vddr_m1_s2_vddr_m1_s3_vddr_m1_s4_vddr_m1_vddr_t20 vddr__t20 vddr 56.6221639387
* device instance g_vddr_m1_mnt_g_s1_vddr_m1_s2_vddr_m1_s3_vddr_m1_s4_vddr_m1_vddr r0 *1 0,0
Cg_vddr_m1_mnt_g_s1_vddr_m1_s2_vddr_m1_s3_vddr_m1_s4_vddr_m1_vddr vddr vsubs 1.2373945e-14
* device instance g_vss_m1_mph_g_s1_vss_m1_s2_vss_m1_s3_vss_m1_s4_vss_m1_vss_t0 r0 *1 0,0
Rg_vss_m1_mph_g_s1_vss_m1_s2_vss_m1_s3_vss_m1_s4_vss_m1_vss_t0 vss__t0 vss 118.945396257
* device instance g_vss_m1_mph_g_s1_vss_m1_s2_vss_m1_s3_vss_m1_s4_vss_m1_vss_t1 r0 *1 0,0
Rg_vss_m1_mph_g_s1_vss_m1_s2_vss_m1_s3_vss_m1_s4_vss_m1_vss_t1 vss__t1 vss 120.2569335
* device instance g_vss_m1_mph_g_s1_vss_m1_s2_vss_m1_s3_vss_m1_s4_vss_m1_vss_t2 r0 *1 0,0
Rg_vss_m1_mph_g_s1_vss_m1_s2_vss_m1_s3_vss_m1_s4_vss_m1_vss_t2 vss__t2 vss 57.4378819653
* device instance g_vss_m1_mph_g_s1_vss_m1_s2_vss_m1_s3_vss_m1_s4_vss_m1_vss_t3 r0 *1 0,0
Rg_vss_m1_mph_g_s1_vss_m1_s2_vss_m1_s3_vss_m1_s4_vss_m1_vss_t3 vss__t3 vss 18.7934255544
* device instance g_vss_m1_mph_g_s1_vss_m1_s2_vss_m1_s3_vss_m1_s4_vss_m1_vss_t4 r0 *1 0,0
Rg_vss_m1_mph_g_s1_vss_m1_s2_vss_m1_s3_vss_m1_s4_vss_m1_vss_t4 vss__t4 vss 61.9000714497
* device instance g_vss_m1_mph_g_s1_vss_m1_s2_vss_m1_s3_vss_m1_s4_vss_m1_vss_t5 r0 *1 0,0
Rg_vss_m1_mph_g_s1_vss_m1_s2_vss_m1_s3_vss_m1_s4_vss_m1_vss_t5 vss__t5 vss 117.19380653
* device instance g_vss_m1_mph_g_s1_vss_m1_s2_vss_m1_s3_vss_m1_s4_vss_m1_vss_t6 r0 *1 0,0
Rg_vss_m1_mph_g_s1_vss_m1_s2_vss_m1_s3_vss_m1_s4_vss_m1_vss_t6 vss__t6 vss 115.847596111
* device instance g_vss_m1_mph_g_s1_vss_m1_s2_vss_m1_s3_vss_m1_s4_vss_m1_vss_t7 r0 *1 0,0
Rg_vss_m1_mph_g_s1_vss_m1_s2_vss_m1_s3_vss_m1_s4_vss_m1_vss_t7 vss__t7 vss 59.3118544751
* device instance g_vss_m1_mph_g_s1_vss_m1_s2_vss_m1_s3_vss_m1_s4_vss_m1_vss_t8 r0 *1 0,0
Rg_vss_m1_mph_g_s1_vss_m1_s2_vss_m1_s3_vss_m1_s4_vss_m1_vss_t8 vss__t8 vss 6.28252177566
* device instance g_vss_m1_mph_g_s1_vss_m1_s2_vss_m1_s3_vss_m1_s4_vss_m1_vss_t9 r0 *1 0,0
Rg_vss_m1_mph_g_s1_vss_m1_s2_vss_m1_s3_vss_m1_s4_vss_m1_vss_t9 vss__t9 vss 54.6386998422
* device instance g_vss_m1_mph_g_s1_vss_m1_s2_vss_m1_s3_vss_m1_s4_vss_m1_vss_t10 r0 *1 0,0
Rg_vss_m1_mph_g_s1_vss_m1_s2_vss_m1_s3_vss_m1_s4_vss_m1_vss_t10 vss__t10 vss 38.3758760585
* device instance g_vss_m1_mph_g_s1_vss_m1_s2_vss_m1_s3_vss_m1_s4_vss_m1_vss_t11 r0 *1 0,0
Rg_vss_m1_mph_g_s1_vss_m1_s2_vss_m1_s3_vss_m1_s4_vss_m1_vss_t11 vss__t11 vss 19.629859131
* device instance g_vss_m1_mph_g_s1_vss_m1_s2_vss_m1_s3_vss_m1_s4_vss_m1_vss_t12 r0 *1 0,0
Rg_vss_m1_mph_g_s1_vss_m1_s2_vss_m1_s3_vss_m1_s4_vss_m1_vss_t12 vss__t12 vss 75.6458744265
* device instance g_vss_m1_mph_g_s1_vss_m1_s2_vss_m1_s3_vss_m1_s4_vss_m1_vss_t13 r0 *1 0,0
Rg_vss_m1_mph_g_s1_vss_m1_s2_vss_m1_s3_vss_m1_s4_vss_m1_vss_t13 vss__t13 vss 132.225597779
* device instance g_vss_m1_mph_g_s1_vss_m1_s2_vss_m1_s3_vss_m1_s4_vss_m1_vss_t14 r0 *1 0,0
Rg_vss_m1_mph_g_s1_vss_m1_s2_vss_m1_s3_vss_m1_s4_vss_m1_vss_t14 vss__t14 vss 118.945396257
* device instance g_vss_m1_mph_g_s1_vss_m1_s2_vss_m1_s3_vss_m1_s4_vss_m1_vss_t15 r0 *1 0,0
Rg_vss_m1_mph_g_s1_vss_m1_s2_vss_m1_s3_vss_m1_s4_vss_m1_vss_t15 vss__t15 vss 54.6386998422
* device instance g_vss_m1_mph_g_s1_vss_m1_s2_vss_m1_s3_vss_m1_s4_vss_m1_vss_t16 r0 *1 0,0
Rg_vss_m1_mph_g_s1_vss_m1_s2_vss_m1_s3_vss_m1_s4_vss_m1_vss_t16 vss__t16 vss 6.28252177566
* device instance g_vss_m1_mph_g_s1_vss_m1_s2_vss_m1_s3_vss_m1_s4_vss_m1_vss_t17 r0 *1 0,0
Rg_vss_m1_mph_g_s1_vss_m1_s2_vss_m1_s3_vss_m1_s4_vss_m1_vss_t17 vss__t17 vss 59.3118544751
* device instance g_vss_m1_mph_g_s1_vss_m1_s2_vss_m1_s3_vss_m1_s4_vss_m1_vss_t18 r0 *1 0,0
Rg_vss_m1_mph_g_s1_vss_m1_s2_vss_m1_s3_vss_m1_s4_vss_m1_vss_t18 vss__t18 vss 115.847596111
* device instance g_vss_m1_mph_g_s1_vss_m1_s2_vss_m1_s3_vss_m1_s4_vss_m1_vss_t19 r0 *1 0,0
Rg_vss_m1_mph_g_s1_vss_m1_s2_vss_m1_s3_vss_m1_s4_vss_m1_vss_t19 vss__t19 vss 102.572043808
* device instance g_vss_m1_mph_g_s1_vss_m1_s2_vss_m1_s3_vss_m1_s4_vss_m1_vss_t20 r0 *1 0,0
Rg_vss_m1_mph_g_s1_vss_m1_s2_vss_m1_s3_vss_m1_s4_vss_m1_vss_t20 vss__t20 vss 97.9348928759
* device instance g_vss_m1_mph_g_s1_vss_m1_s2_vss_m1_s3_vss_m1_s4_vss_m1_vss r0 *1 0,0
Cg_vss_m1_mph_g_s1_vss_m1_s2_vss_m1_s3_vss_m1_s4_vss_m1_vss vss vsubs 1.1764024e-14
* device instance mpa_py_mpb_py_mph_py_py_t0 r0 *1 0,0
Rmpa_py_mpb_py_mph_py_py_t0 py_g__t0 py_g 34.25785
* device instance mpa_py_mpb_py_mph_py_py_t1 r0 *1 0,0
Rmpa_py_mpb_py_mph_py_py_t1 py_g__t1 py_g 5.3337399911
* device instance mpa_py_mpb_py_mph_py_py_t2 r0 *1 0,0
Rmpa_py_mpb_py_mph_py_py_t2 py_g__t2 py_g 28.9241100089
* device instance mpa_py_mpb_py_mph_py_py r0 *1 0,0
Cmpa_py_mpb_py_mph_py_py py_g vsubs 7.9788e-16
* device instance ny_t0 r0 *1 0,0
Rny_t0 ny__t0 ny 44.8339
* device instance ny_t1 r0 *1 0,0
Rny_t1 ny__t1 ny 44.8339
* device instance ny r0 *1 0,0
Cny ny vsubs 2.15636e-16
* device instance ny_dup1_t0 r0 *1 0,0
Rny_dup1_t0 ny__t02 nyn1 41.8333
* device instance ny_dup1_t1 r0 *1 0,0
Rny_dup1_t1 ny__t12 nyn1 41.8333
* device instance ny_dup1 r0 *1 0,0
Cny_dup1 nyn1 vsubs 1.73989e-16
* device instance ny_dup2_t0 r0 *1 0,0
Rny_dup2_t0 ny__t03 nyn2 41.8333
* device instance ny_dup2_t1 r0 *1 0,0
Rny_dup2_t1 ny__t13 nyn2 41.8333
* device instance ny_dup2 r0 *1 0,0
Cny_dup2 nyn2 vsubs 1.73989e-16
* device instance ny_dup3_t0 r0 *1 0,0
Rny_dup3_t0 ny__t04 nyn3 41.8333
* device instance ny_dup3_t1 r0 *1 0,0
Rny_dup3_t1 ny__t14 nyn3 41.8333
* device instance ny_dup3 r0 *1 0,0
Cny_dup3 nyn3 vsubs 1.73989e-16
* device instance ny_dup4_t0 r0 *1 0,0
Rny_dup4_t0 ny__t05 nyn4 41.8333
* device instance ny_dup4_t1 r0 *1 0,0
Rny_dup4_t1 ny__t15 nyn4 41.8333
* device instance ny_dup4 r0 *1 0,0
Cny_dup4 nyn4 vsubs 1.73989e-16
* device instance py_t0 r0 *1 0,0
Rpy_t0 py__t0 py 38.0848
* device instance py_t1 r0 *1 0,0
Rpy_t1 py__t1 py 38.0848
* device instance py r0 *1 0,0
Cpy py vsubs 1.96992e-16
* device instance py_dup1_t0 r0 *1 0,0
Rpy_dup1_t0 py__t02 pyn1 38.0848
* device instance py_dup1_t1 r0 *1 0,0
Rpy_dup1_t1 py__t12 pyn1 38.0848
* device instance py_dup1 r0 *1 0,0
Cpy_dup1 pyn1 vsubs 1.96992e-16
* device instance py_dup2_t0 r0 *1 0,0
Rpy_dup2_t0 py__t03 pyn2 38.0848
* device instance py_dup2_t1 r0 *1 0,0
Rpy_dup2_t1 py__t13 pyn2 38.0848
* device instance py_dup2 r0 *1 0,0
Cpy_dup2 pyn2 vsubs 1.96992e-16
* device instance py_dup3_t0 r0 *1 0,0
Rpy_dup3_t0 py__t04 pyn3 38.0848
* device instance py_dup3_t1 r0 *1 0,0
Rpy_dup3_t1 py__t14 pyn3 38.0848
* device instance py_dup3 r0 *1 0,0
Cpy_dup3 pyn3 vsubs 1.96992e-16
* device instance cc_a_g_a_ro_s4_y_y_a_g_y_mnab_y_mpa_y_mpb_y_n1_s1_a_y r0 *1 0,0
Ccc_a_g_a_ro_s4_y_y_a_g_y_mnab_y_mpa_y_mpb_y_n1_s1_a_y ro sig_n1 1.5977e-17
* device instance cc_a_g_a_ro_s4_y_y_g_vddr_m1_mnt_g_s1_vddr_m1_s2_vddr_m1_s3_vddr_m1_s4_vddr_m1_vddr r0 *1 0,0
Ccc_a_g_a_ro_s4_y_y_g_vddr_m1_mnt_g_s1_vddr_m1_s2_vddr_m1_s3_vddr_m1_s4_vddr_m1_vddr ro vddr 1.5474e-17
* device instance cc_a_g_y_mnab_y_mpa_y_mpb_y_n1_s1_a_y_g_vss_m1_mph_g_s1_vss_m1_s2_vss_m1_s3_vss_m1_s4_vss_m1_vss r0 *1 0,0
Ccc_a_g_y_mnab_y_mpa_y_mpb_y_n1_s1_a_y_g_vss_m1_mph_g_s1_vss_m1_s2_vss_m1_s3_vss_m1_s4_vss_m1_vss sig_n1 vss 3.869e-18
* device instance cc_a_g_y_mnab_y_mpa_y_mpb_y_n1_s1_a_y_ny r0 *1 0,0
Ccc_a_g_y_mnab_y_mpa_y_mpb_y_n1_s1_a_y_ny sig_n1 nyn4 2.878e-18
* device instance cc_a_n2_s1_y_s2_a_y_g_vss_m1_mph_g_s1_vss_m1_s2_vss_m1_s3_vss_m1_s4_vss_m1_vss r0 *1 0,0
Ccc_a_n2_s1_y_s2_a_y_g_vss_m1_mph_g_s1_vss_m1_s2_vss_m1_s3_vss_m1_s4_vss_m1_vss sig_n2 vss 3.869e-18
* device instance cc_a_n2_s1_y_s2_a_y_ny r0 *1 0,0
Ccc_a_n2_s1_y_s2_a_y_ny sig_n2 nyn4 2.878e-18
* device instance cc_a_n3_s2_y_s3_a_y_g_vss_m1_mph_g_s1_vss_m1_s2_vss_m1_s3_vss_m1_s4_vss_m1_vss r0 *1 0,0
Ccc_a_n3_s2_y_s3_a_y_g_vss_m1_mph_g_s1_vss_m1_s2_vss_m1_s3_vss_m1_s4_vss_m1_vss sig_n3 vss 3.869e-18
* device instance cc_a_n3_s2_y_s3_a_y_ny r0 *1 0,0
Ccc_a_n3_s2_y_s3_a_y_ny sig_n3 nyn4 2.878e-18
* device instance cc_a_n4_s3_y_s4_a_y_g_vss_m1_mph_g_s1_vss_m1_s2_vss_m1_s3_vss_m1_s4_vss_m1_vss r0 *1 0,0
Ccc_a_n4_s3_y_s4_a_y_g_vss_m1_mph_g_s1_vss_m1_s2_vss_m1_s3_vss_m1_s4_vss_m1_vss sig_n4 vss 3.869e-18
* device instance cc_a_n4_s3_y_s4_a_y_ny r0 *1 0,0
Ccc_a_n4_s3_y_s4_a_y_ny sig_n4 nyn4 2.878e-18
* device instance cc_g_vddr_m1_mnt_g_s1_vddr_m1_s2_vddr_m1_s3_vddr_m1_s4_vddr_m1_vddr_py r0 *1 0,0
Ccc_g_vddr_m1_mnt_g_s1_vddr_m1_s2_vddr_m1_s3_vddr_m1_s4_vddr_m1_vddr_py vddr pyn3 1.3658e-17
* device instance vsubs_dctie r0 *1 0,0
Rvsubs_dctie vsubs 0 1e+12
.ends ro_ring5_assembled_pex_wstv0p46__core

* ro_ring5_assembled_pex_wstv0p46 -- design-port-order wrapper over ro_ring5_assembled_pex_wstv0p46__core.
* Promoted-internal layout pins kept local here: sig_n1, sig_n2, sig_n3, sig_n4, py_g, ny, nyn1, nyn2, nyn3, nyn4, py, pyn1, pyn2, pyn3
.subckt ro_ring5_assembled_pex_wstv0p46 en ro vddr vss
xpex ro sig_n1 sig_n2 sig_n3 sig_n4 en vddr vss py_g ny nyn1 nyn2 nyn3 nyn4 py pyn1 pyn2 pyn3 ro_ring5_assembled_pex_wstv0p46__core
.ends ro_ring5_assembled_pex_wstv0p46

*-----------------------------------------------------------------------
* ro_ring5_assembled_pex_wstv0p48 -- post-layout, from ../ro_ring5_wstv0p48/ro_ring5_wstv0p48.gds
* klt extract --parasitics: 22 devices, 19 nets
*-----------------------------------------------------------------------
.subckt ro_ring5_assembled_pex_wstv0p48__core ro sig_n1 sig_n2 sig_n3 sig_n4 en vddr vss py_g ny nyn1 nyn2 nyn3 nyn4 py pyn1 pyn2 pyn3
* device instance $1 r0 *1 13.085,0.21 nfet
Xn1 sig_n2__t0 sig_n1__t0 ny__t02 vss__t10 sky130_fd_pr__nfet_01v8 L=0.15 W=0.42 AS=0.1974 AD=0.1974 PS=1.78 PD=1.78
* device instance $2 r0 *1 21.26,0.21 nfet
Xn2 sig_n3__t0 sig_n2__t3 ny__t03 vss__t11 sky130_fd_pr__nfet_01v8 L=0.15 W=0.42 AS=0.1974 AD=0.1974 PS=1.78 PD=1.78
* device instance $3 r0 *1 29.435,0.21 nfet
Xn3 sig_n4__t0 sig_n3__t3 ny__t04 vss__t12 sky130_fd_pr__nfet_01v8 L=0.15 W=0.42 AS=0.1974 AD=0.1974 PS=1.78 PD=1.78
* device instance $4 r0 *1 37.61,0.21 nfet
Xn4 ro__t1 sig_n4__t3 ny__t05 vss__t13 sky130_fd_pr__nfet_01v8 L=0.15 W=0.42 AS=0.1974 AD=0.1974 PS=1.78 PD=1.78
* device instance $5 r0 *1 1.42,0.21 nfet
Xn5 ny__t0 vddr__t0 vss__t0 vss__t14 sky130_fd_pr__nfet_01v8 L=2 W=0.48 AS=0.2016 AD=0.2016 PS=1.8 PD=1.8
* device instance $6 r0 *1 10.72,0.21 nfet
Xn6 ny__t12 vddr__t20 vss__t9 vss__t15 sky130_fd_pr__nfet_01v8 L=2 W=0.48 AS=0.2016 AD=0.2016 PS=1.8 PD=1.8
* device instance $7 r0 *1 18.895,0.21 nfet
Xn7 ny__t13 vddr__t19 vss__t8 vss__t16 sky130_fd_pr__nfet_01v8 L=2 W=0.48 AS=0.2016 AD=0.2016 PS=1.8 PD=1.8
* device instance $8 r0 *1 27.07,0.21 nfet
Xn8 ny__t14 vddr__t18 vss__t7 vss__t17 sky130_fd_pr__nfet_01v8 L=2 W=0.48 AS=0.2016 AD=0.2016 PS=1.8 PD=1.8
* device instance $9 r0 *1 35.245,0.21 nfet
Xn9 ny__t15 vddr__t17 vss__t6 vss__t18 sky130_fd_pr__nfet_01v8 L=2 W=0.48 AS=0.2016 AD=0.2016 PS=1.8 PD=1.8
* device instance $10 r0 *1 3.785,0.21 nfet
Xn10 n5__t0 en__t0 ny__t1 vss__t19 sky130_fd_pr__nfet_01v8 L=0.15 W=0.84 AS=0.3948 AD=0.2184 PS=2.62 PD=1.36
* device instance $11 r0 *1 4.455,0.21 nfet
Xn11 sig_n1__t1 ro__t0 n5__t1 vss__t20 sky130_fd_pr__nfet_01v8 L=0.15 W=0.84 AS=0.2184 AD=0.3948 PS=1.36 PD=2.62
* device instance $12 r0 *1 1.42,3.74 pfet
Xn12 py_g__t0 vss__t1 vddr__t1 vddr__t2 sky130_fd_pr__pfet_01v8 L=2 W=0.48 AS=0.2016 AD=0.2016 PS=1.8 PD=1.8
* device instance $13 r0 *1 10.72,3.74 pfet
Xn13 py__t0 vss__t2 vddr__t13 vddr__t9 sky130_fd_pr__pfet_01v8 L=2 W=0.48 AS=0.2016 AD=0.2016 PS=1.8 PD=1.8
* device instance $14 r0 *1 18.895,3.74 pfet
Xn14 py__t02 vss__t3 vddr__t14 vddr__t10 sky130_fd_pr__pfet_01v8 L=2 W=0.48 AS=0.2016 AD=0.2016 PS=1.8 PD=1.8
* device instance $15 r0 *1 27.07,3.74 pfet
Xn15 py__t03 vss__t4 vddr__t15 vddr__t11 sky130_fd_pr__pfet_01v8 L=2 W=0.48 AS=0.2016 AD=0.2016 PS=1.8 PD=1.8
* device instance $16 r0 *1 35.245,3.74 pfet
Xn16 py__t04 vss__t5 vddr__t16 vddr__t12 sky130_fd_pr__pfet_01v8 L=2 W=0.48 AS=0.2016 AD=0.2016 PS=1.8 PD=1.8
* device instance $17 r0 *1 3.585,3.74 pfet
Xn17 sig_n1__t2 en__t1 py_g__t1 vddr__t3 sky130_fd_pr__pfet_01v8 L=0.15 W=0.84 AS=0.3948 AD=0.3948 PS=2.62 PD=2.62
* device instance $18 r0 *1 4.875,3.74 pfet
Xn18 py_g__t2 ro__t2 sig_n1__t3 vddr__t8 sky130_fd_pr__pfet_01v8 L=0.15 W=0.84 AS=0.3948 AD=0.3948 PS=2.62 PD=2.62
* device instance $19 r0 *1 12.885,3.74 pfet
Xn19 sig_n2__t2 sig_n1__t4 py__t1 vddr__t7 sky130_fd_pr__pfet_01v8 L=0.15 W=0.84 AS=0.3948 AD=0.3948 PS=2.62 PD=2.62
* device instance $20 r0 *1 21.06,3.74 pfet
Xn20 sig_n3__t2 sig_n2__t1 py__t12 vddr__t6 sky130_fd_pr__pfet_01v8 L=0.15 W=0.84 AS=0.3948 AD=0.3948 PS=2.62 PD=2.62
* device instance $21 r0 *1 29.235,3.74 pfet
Xn21 sig_n4__t2 sig_n3__t1 py__t13 vddr__t5 sky130_fd_pr__pfet_01v8 L=0.15 W=0.84 AS=0.3948 AD=0.3948 PS=2.62 PD=2.62
* device instance $22 r0 *1 37.41,3.74 pfet
Xn22 ro__t3 sig_n4__t1 py__t14 vddr__t4 sky130_fd_pr__pfet_01v8 L=0.15 W=0.84 AS=0.3948 AD=0.3948 PS=2.62 PD=2.62
* device instance _5_t0 r0 *1 0,0
R_5_t0 n5__t0 n5 12.8
* device instance _5_t1 r0 *1 0,0
R_5_t1 n5__t1 n5 12.8
* device instance _5 r0 *1 0,0
C_5 n5 vsubs 1.15618e-16
* device instance a_g_a_ro_s4_y_y_t0 r0 *1 0,0
Ra_g_a_ro_s4_y_y_t0 ro__t0 ro 199.905310752
* device instance a_g_a_ro_s4_y_y_t1 r0 *1 0,0
Ra_g_a_ro_s4_y_y_t1 ro__t1 ro 198.597996013
* device instance a_g_a_ro_s4_y_y_t2 r0 *1 0,0
Ra_g_a_ro_s4_y_y_t2 ro__t2 ro 194.914280155
* device instance a_g_a_ro_s4_y_y_t3 r0 *1 0,0
Ra_g_a_ro_s4_y_y_t3 ro__t3 ro 196.22131308
* device instance a_g_a_ro_s4_y_y r0 *1 0,0
Ca_g_a_ro_s4_y_y ro vsubs 4.73908e-15
* device instance a_g_y_mnab_y_mpa_y_mpb_y_n1_s1_a_y_t0 r0 *1 0,0
Ra_g_y_mnab_y_mpa_y_mpb_y_n1_s1_a_y_t0 sig_n1__t0 sig_n1 107.491339147
* device instance a_g_y_mnab_y_mpa_y_mpb_y_n1_s1_a_y_t1 r0 *1 0,0
Ra_g_y_mnab_y_mpa_y_mpb_y_n1_s1_a_y_t1 sig_n1__t1 sig_n1 74.101756002
* device instance a_g_y_mnab_y_mpa_y_mpb_y_n1_s1_a_y_t2 r0 *1 0,0
Ra_g_y_mnab_y_mpa_y_mpb_y_n1_s1_a_y_t2 sig_n1__t2 sig_n1 83.1989635875
* device instance a_g_y_mnab_y_mpa_y_mpb_y_n1_s1_a_y_t3 r0 *1 0,0
Ra_g_y_mnab_y_mpa_y_mpb_y_n1_s1_a_y_t3 sig_n1__t3 sig_n1 60.7011664601
* device instance a_g_y_mnab_y_mpa_y_mpb_y_n1_s1_a_y_t4 r0 *1 0,0
Ra_g_y_mnab_y_mpa_y_mpb_y_n1_s1_a_y_t4 sig_n1__t4 sig_n1 99.6782748034
* device instance a_g_y_mnab_y_mpa_y_mpb_y_n1_s1_a_y r0 *1 0,0
Ca_g_y_mnab_y_mpa_y_mpb_y_n1_s1_a_y sig_n1 vsubs 2.632209e-15
* device instance a_n2_s1_y_s2_a_y_t0 r0 *1 0,0
Ra_n2_s1_y_s2_a_y_t0 sig_n2__t0 sig_n2 184.787796322
* device instance a_n2_s1_y_s2_a_y_t1 r0 *1 0,0
Ra_n2_s1_y_s2_a_y_t1 sig_n2__t1 sig_n2 184.787796322
* device instance a_n2_s1_y_s2_a_y_t2 r0 *1 0,0
Ra_n2_s1_y_s2_a_y_t2 sig_n2__t2 sig_n2 192.568303678
* device instance a_n2_s1_y_s2_a_y_t3 r0 *1 0,0
Ra_n2_s1_y_s2_a_y_t3 sig_n2__t3 sig_n2 192.568303678
* device instance a_n2_s1_y_s2_a_y r0 *1 0,0
Ca_n2_s1_y_s2_a_y sig_n2 vsubs 2.529995e-15
* device instance a_n3_s2_y_s3_a_y_t0 r0 *1 0,0
Ra_n3_s2_y_s3_a_y_t0 sig_n3__t0 sig_n3 184.787796322
* device instance a_n3_s2_y_s3_a_y_t1 r0 *1 0,0
Ra_n3_s2_y_s3_a_y_t1 sig_n3__t1 sig_n3 184.787796322
* device instance a_n3_s2_y_s3_a_y_t2 r0 *1 0,0
Ra_n3_s2_y_s3_a_y_t2 sig_n3__t2 sig_n3 192.568303678
* device instance a_n3_s2_y_s3_a_y_t3 r0 *1 0,0
Ra_n3_s2_y_s3_a_y_t3 sig_n3__t3 sig_n3 192.568303678
* device instance a_n3_s2_y_s3_a_y r0 *1 0,0
Ca_n3_s2_y_s3_a_y sig_n3 vsubs 2.529995e-15
* device instance a_n4_s3_y_s4_a_y_t0 r0 *1 0,0
Ra_n4_s3_y_s4_a_y_t0 sig_n4__t0 sig_n4 184.787796322
* device instance a_n4_s3_y_s4_a_y_t1 r0 *1 0,0
Ra_n4_s3_y_s4_a_y_t1 sig_n4__t1 sig_n4 184.787796322
* device instance a_n4_s3_y_s4_a_y_t2 r0 *1 0,0
Ra_n4_s3_y_s4_a_y_t2 sig_n4__t2 sig_n4 192.568303678
* device instance a_n4_s3_y_s4_a_y_t3 r0 *1 0,0
Ra_n4_s3_y_s4_a_y_t3 sig_n4__t3 sig_n4 192.568303678
* device instance a_n4_s3_y_s4_a_y r0 *1 0,0
Ca_n4_s3_y_s4_a_y sig_n4 vsubs 2.529995e-15
* device instance en_g_en_t0 r0 *1 0,0
Ren_g_en_t0 en__t0 en 166.9848
* device instance en_g_en_t1 r0 *1 0,0
Ren_g_en_t1 en__t1 en 166.9848
* device instance en_g_en r0 *1 0,0
Cen_g_en en vsubs 5.93421e-16
* device instance g_vddr_m1_mnt_g_s1_vddr_m1_s2_vddr_m1_s3_vddr_m1_s4_vddr_m1_vddr_t0 r0 *1 0,0
Rg_vddr_m1_mnt_g_s1_vddr_m1_s2_vddr_m1_s3_vddr_m1_s4_vddr_m1_vddr_t0 vddr__t0 vddr 118.97076187
* device instance g_vddr_m1_mnt_g_s1_vddr_m1_s2_vddr_m1_s3_vddr_m1_s4_vddr_m1_vddr_t1 r0 *1 0,0
Rg_vddr_m1_mnt_g_s1_vddr_m1_s2_vddr_m1_s3_vddr_m1_s4_vddr_m1_vddr_t1 vddr__t1 vddr 117.669137634
* device instance g_vddr_m1_mnt_g_s1_vddr_m1_s2_vddr_m1_s3_vddr_m1_s4_vddr_m1_vddr_t2 r0 *1 0,0
Rg_vddr_m1_mnt_g_s1_vddr_m1_s2_vddr_m1_s3_vddr_m1_s4_vddr_m1_vddr_t2 vddr__t2 vddr 117.669137634
* device instance g_vddr_m1_mnt_g_s1_vddr_m1_s2_vddr_m1_s3_vddr_m1_s4_vddr_m1_vddr_t3 r0 *1 0,0
Rg_vddr_m1_mnt_g_s1_vddr_m1_s2_vddr_m1_s3_vddr_m1_s4_vddr_m1_vddr_t3 vddr__t3 vddr 102.817164532
* device instance g_vddr_m1_mnt_g_s1_vddr_m1_s2_vddr_m1_s3_vddr_m1_s4_vddr_m1_vddr_t4 r0 *1 0,0
Rg_vddr_m1_mnt_g_s1_vddr_m1_s2_vddr_m1_s3_vddr_m1_s4_vddr_m1_vddr_t4 vddr__t4 vddr 129.834493316
* device instance g_vddr_m1_mnt_g_s1_vddr_m1_s2_vddr_m1_s3_vddr_m1_s4_vddr_m1_vddr_t5 r0 *1 0,0
Rg_vddr_m1_mnt_g_s1_vddr_m1_s2_vddr_m1_s3_vddr_m1_s4_vddr_m1_vddr_t5 vddr__t5 vddr 73.7741306304
* device instance g_vddr_m1_mnt_g_s1_vddr_m1_s2_vddr_m1_s3_vddr_m1_s4_vddr_m1_vddr_t6 r0 *1 0,0
Rg_vddr_m1_mnt_g_s1_vddr_m1_s2_vddr_m1_s3_vddr_m1_s4_vddr_m1_vddr_t6 vddr__t6 vddr 18.3230822812
* device instance g_vddr_m1_mnt_g_s1_vddr_m1_s2_vddr_m1_s3_vddr_m1_s4_vddr_m1_vddr_t7 r0 *1 0,0
Rg_vddr_m1_mnt_g_s1_vddr_m1_s2_vddr_m1_s3_vddr_m1_s4_vddr_m1_vddr_t7 vddr__t7 vddr 39.1961048656
* device instance g_vddr_m1_mnt_g_s1_vddr_m1_s2_vddr_m1_s3_vddr_m1_s4_vddr_m1_vddr_t8 r0 *1 0,0
Rg_vddr_m1_mnt_g_s1_vddr_m1_s2_vddr_m1_s3_vddr_m1_s4_vddr_m1_vddr_t8 vddr__t8 vddr 93.9708045291
* device instance g_vddr_m1_mnt_g_s1_vddr_m1_s2_vddr_m1_s3_vddr_m1_s4_vddr_m1_vddr_t9 r0 *1 0,0
Rg_vddr_m1_mnt_g_s1_vddr_m1_s2_vddr_m1_s3_vddr_m1_s4_vddr_m1_vddr_t9 vddr__t9 vddr 53.9508439908
* device instance g_vddr_m1_mnt_g_s1_vddr_m1_s2_vddr_m1_s3_vddr_m1_s4_vddr_m1_vddr_t10 r0 *1 0,0
Rg_vddr_m1_mnt_g_s1_vddr_m1_s2_vddr_m1_s3_vddr_m1_s4_vddr_m1_vddr_t10 vddr__t10 vddr 6.29851554728
* device instance g_vddr_m1_mnt_g_s1_vddr_m1_s2_vddr_m1_s3_vddr_m1_s4_vddr_m1_vddr_t11 r0 *1 0,0
Rg_vddr_m1_mnt_g_s1_vddr_m1_s2_vddr_m1_s3_vddr_m1_s4_vddr_m1_vddr_t11 vddr__t11 vddr 58.9587595461
* device instance g_vddr_m1_mnt_g_s1_vddr_m1_s2_vddr_m1_s3_vddr_m1_s4_vddr_m1_vddr_t12 r0 *1 0,0
Rg_vddr_m1_mnt_g_s1_vddr_m1_s2_vddr_m1_s3_vddr_m1_s4_vddr_m1_vddr_t12 vddr__t12 vddr 114.978631296
* device instance g_vddr_m1_mnt_g_s1_vddr_m1_s2_vddr_m1_s3_vddr_m1_s4_vddr_m1_vddr_t13 r0 *1 0,0
Rg_vddr_m1_mnt_g_s1_vddr_m1_s2_vddr_m1_s3_vddr_m1_s4_vddr_m1_vddr_t13 vddr__t13 vddr 53.9508439908
* device instance g_vddr_m1_mnt_g_s1_vddr_m1_s2_vddr_m1_s3_vddr_m1_s4_vddr_m1_vddr_t14 r0 *1 0,0
Rg_vddr_m1_mnt_g_s1_vddr_m1_s2_vddr_m1_s3_vddr_m1_s4_vddr_m1_vddr_t14 vddr__t14 vddr 6.29851554728
* device instance g_vddr_m1_mnt_g_s1_vddr_m1_s2_vddr_m1_s3_vddr_m1_s4_vddr_m1_vddr_t15 r0 *1 0,0
Rg_vddr_m1_mnt_g_s1_vddr_m1_s2_vddr_m1_s3_vddr_m1_s4_vddr_m1_vddr_t15 vddr__t15 vddr 58.9587595461
* device instance g_vddr_m1_mnt_g_s1_vddr_m1_s2_vddr_m1_s3_vddr_m1_s4_vddr_m1_vddr_t16 r0 *1 0,0
Rg_vddr_m1_mnt_g_s1_vddr_m1_s2_vddr_m1_s3_vddr_m1_s4_vddr_m1_vddr_t16 vddr__t16 vddr 114.978631296
* device instance g_vddr_m1_mnt_g_s1_vddr_m1_s2_vddr_m1_s3_vddr_m1_s4_vddr_m1_vddr_t17 r0 *1 0,0
Rg_vddr_m1_mnt_g_s1_vddr_m1_s2_vddr_m1_s3_vddr_m1_s4_vddr_m1_vddr_t17 vddr__t17 vddr 116.310368768
* device instance g_vddr_m1_mnt_g_s1_vddr_m1_s2_vddr_m1_s3_vddr_m1_s4_vddr_m1_vddr_t18 r0 *1 0,0
Rg_vddr_m1_mnt_g_s1_vddr_m1_s2_vddr_m1_s3_vddr_m1_s4_vddr_m1_vddr_t18 vddr__t18 vddr 61.5154578588
* device instance g_vddr_m1_mnt_g_s1_vddr_m1_s2_vddr_m1_s3_vddr_m1_s4_vddr_m1_vddr_t19 r0 *1 0,0
Rg_vddr_m1_mnt_g_s1_vddr_m1_s2_vddr_m1_s3_vddr_m1_s4_vddr_m1_vddr_t19 vddr__t19 vddr 18.6463810553
* device instance g_vddr_m1_mnt_g_s1_vddr_m1_s2_vddr_m1_s3_vddr_m1_s4_vddr_m1_vddr_t20 r0 *1 0,0
Rg_vddr_m1_mnt_g_s1_vddr_m1_s2_vddr_m1_s3_vddr_m1_s4_vddr_m1_vddr_t20 vddr__t20 vddr 56.7336742656
* device instance g_vddr_m1_mnt_g_s1_vddr_m1_s2_vddr_m1_s3_vddr_m1_s4_vddr_m1_vddr r0 *1 0,0
Cg_vddr_m1_mnt_g_s1_vddr_m1_s2_vddr_m1_s3_vddr_m1_s4_vddr_m1_vddr vddr vsubs 1.2379228e-14
* device instance g_vss_m1_mph_g_s1_vss_m1_s2_vss_m1_s3_vss_m1_s4_vss_m1_vss_t0 r0 *1 0,0
Rg_vss_m1_mph_g_s1_vss_m1_s2_vss_m1_s3_vss_m1_s4_vss_m1_vss_t0 vss__t0 vss 119.176149123
* device instance g_vss_m1_mph_g_s1_vss_m1_s2_vss_m1_s3_vss_m1_s4_vss_m1_vss_t1 r0 *1 0,0
Rg_vss_m1_mph_g_s1_vss_m1_s2_vss_m1_s3_vss_m1_s4_vss_m1_vss_t1 vss__t1 vss 120.490230735
* device instance g_vss_m1_mph_g_s1_vss_m1_s2_vss_m1_s3_vss_m1_s4_vss_m1_vss_t2 r0 *1 0,0
Rg_vss_m1_mph_g_s1_vss_m1_s2_vss_m1_s3_vss_m1_s4_vss_m1_vss_t2 vss__t2 vss 57.5493108754
* device instance g_vss_m1_mph_g_s1_vss_m1_s2_vss_m1_s3_vss_m1_s4_vss_m1_vss_t3 r0 *1 0,0
Rg_vss_m1_mph_g_s1_vss_m1_s2_vss_m1_s3_vss_m1_s4_vss_m1_vss_t3 vss__t3 vss 18.8298846099
* device instance g_vss_m1_mph_g_s1_vss_m1_s2_vss_m1_s3_vss_m1_s4_vss_m1_vss_t4 r0 *1 0,0
Rg_vss_m1_mph_g_s1_vss_m1_s2_vss_m1_s3_vss_m1_s4_vss_m1_vss_t4 vss__t4 vss 62.0201569623
* device instance g_vss_m1_mph_g_s1_vss_m1_s2_vss_m1_s3_vss_m1_s4_vss_m1_vss_t5 r0 *1 0,0
Rg_vss_m1_mph_g_s1_vss_m1_s2_vss_m1_s3_vss_m1_s4_vss_m1_vss_t5 vss__t5 vss 117.421161329
* device instance g_vss_m1_mph_g_s1_vss_m1_s2_vss_m1_s3_vss_m1_s4_vss_m1_vss_t6 r0 *1 0,0
Rg_vss_m1_mph_g_s1_vss_m1_s2_vss_m1_s3_vss_m1_s4_vss_m1_vss_t6 vss__t6 vss 116.072339276
* device instance g_vss_m1_mph_g_s1_vss_m1_s2_vss_m1_s3_vss_m1_s4_vss_m1_vss_t7 r0 *1 0,0
Rg_vss_m1_mph_g_s1_vss_m1_s2_vss_m1_s3_vss_m1_s4_vss_m1_vss_t7 vss__t7 vss 59.4269188729
* device instance g_vss_m1_mph_g_s1_vss_m1_s2_vss_m1_s3_vss_m1_s4_vss_m1_vss_t8 r0 *1 0,0
Rg_vss_m1_mph_g_s1_vss_m1_s2_vss_m1_s3_vss_m1_s4_vss_m1_vss_t8 vss__t8 vss 6.29470980437
* device instance g_vss_m1_mph_g_s1_vss_m1_s2_vss_m1_s3_vss_m1_s4_vss_m1_vss_t9 r0 *1 0,0
Rg_vss_m1_mph_g_s1_vss_m1_s2_vss_m1_s3_vss_m1_s4_vss_m1_vss_t9 vss__t9 vss 54.7446983674
* device instance g_vss_m1_mph_g_s1_vss_m1_s2_vss_m1_s3_vss_m1_s4_vss_m1_vss_t10 r0 *1 0,0
Rg_vss_m1_mph_g_s1_vss_m1_s2_vss_m1_s3_vss_m1_s4_vss_m1_vss_t10 vss__t10 vss 38.45032487
* device instance g_vss_m1_mph_g_s1_vss_m1_s2_vss_m1_s3_vss_m1_s4_vss_m1_vss_t11 r0 *1 0,0
Rg_vss_m1_mph_g_s1_vss_m1_s2_vss_m1_s3_vss_m1_s4_vss_m1_vss_t11 vss__t11 vss 19.6679408591
* device instance g_vss_m1_mph_g_s1_vss_m1_s2_vss_m1_s3_vss_m1_s4_vss_m1_vss_t12 r0 *1 0,0
Rg_vss_m1_mph_g_s1_vss_m1_s2_vss_m1_s3_vss_m1_s4_vss_m1_vss_t12 vss__t12 vss 75.7926266578
* device instance g_vss_m1_mph_g_s1_vss_m1_s2_vss_m1_s3_vss_m1_s4_vss_m1_vss_t13 r0 *1 0,0
Rg_vss_m1_mph_g_s1_vss_m1_s2_vss_m1_s3_vss_m1_s4_vss_m1_vss_t13 vss__t13 vss 132.482114101
* device instance g_vss_m1_mph_g_s1_vss_m1_s2_vss_m1_s3_vss_m1_s4_vss_m1_vss_t14 r0 *1 0,0
Rg_vss_m1_mph_g_s1_vss_m1_s2_vss_m1_s3_vss_m1_s4_vss_m1_vss_t14 vss__t14 vss 119.176149123
* device instance g_vss_m1_mph_g_s1_vss_m1_s2_vss_m1_s3_vss_m1_s4_vss_m1_vss_t15 r0 *1 0,0
Rg_vss_m1_mph_g_s1_vss_m1_s2_vss_m1_s3_vss_m1_s4_vss_m1_vss_t15 vss__t15 vss 54.7446983674
* device instance g_vss_m1_mph_g_s1_vss_m1_s2_vss_m1_s3_vss_m1_s4_vss_m1_vss_t16 r0 *1 0,0
Rg_vss_m1_mph_g_s1_vss_m1_s2_vss_m1_s3_vss_m1_s4_vss_m1_vss_t16 vss__t16 vss 6.29470980437
* device instance g_vss_m1_mph_g_s1_vss_m1_s2_vss_m1_s3_vss_m1_s4_vss_m1_vss_t17 r0 *1 0,0
Rg_vss_m1_mph_g_s1_vss_m1_s2_vss_m1_s3_vss_m1_s4_vss_m1_vss_t17 vss__t17 vss 59.4269188729
* device instance g_vss_m1_mph_g_s1_vss_m1_s2_vss_m1_s3_vss_m1_s4_vss_m1_vss_t18 r0 *1 0,0
Rg_vss_m1_mph_g_s1_vss_m1_s2_vss_m1_s3_vss_m1_s4_vss_m1_vss_t18 vss__t18 vss 116.072339276
* device instance g_vss_m1_mph_g_s1_vss_m1_s2_vss_m1_s3_vss_m1_s4_vss_m1_vss_t19 r0 *1 0,0
Rg_vss_m1_mph_g_s1_vss_m1_s2_vss_m1_s3_vss_m1_s4_vss_m1_vss_t19 vss__t19 vss 102.771032536
* device instance g_vss_m1_mph_g_s1_vss_m1_s2_vss_m1_s3_vss_m1_s4_vss_m1_vss_t20 r0 *1 0,0
Rg_vss_m1_mph_g_s1_vss_m1_s2_vss_m1_s3_vss_m1_s4_vss_m1_vss_t20 vss__t20 vss 98.1248855776
* device instance g_vss_m1_mph_g_s1_vss_m1_s2_vss_m1_s3_vss_m1_s4_vss_m1_vss r0 *1 0,0
Cg_vss_m1_mph_g_s1_vss_m1_s2_vss_m1_s3_vss_m1_s4_vss_m1_vss vss vsubs 1.1769442e-14
* device instance mpa_py_mpb_py_mph_py_py_t0 r0 *1 0,0
Rmpa_py_mpb_py_mph_py_py_t0 py_g__t0 py_g 34.5626
* device instance mpa_py_mpb_py_mph_py_py_t1 r0 *1 0,0
Rmpa_py_mpb_py_mph_py_py_t1 py_g__t1 py_g 5.38118772242
* device instance mpa_py_mpb_py_mph_py_py_t2 r0 *1 0,0
Rmpa_py_mpb_py_mph_py_py_t2 py_g__t2 py_g 29.1814122776
* device instance mpa_py_mpb_py_mph_py_py r0 *1 0,0
Cmpa_py_mpb_py_mph_py_py py_g vsubs 7.99818e-16
* device instance ny_t0 r0 *1 0,0
Rny_t0 ny__t0 ny 45.02655
* device instance ny_t1 r0 *1 0,0
Rny_t1 ny__t1 ny 45.02655
* device instance ny r0 *1 0,0
Cny ny vsubs 2.17575e-16
* device instance ny_dup1_t0 r0 *1 0,0
Rny_dup1_t0 ny__t02 nyn1 41.9128
* device instance ny_dup1_t1 r0 *1 0,0
Rny_dup1_t1 ny__t12 nyn1 41.9128
* device instance ny_dup1 r0 *1 0,0
Cny_dup1 nyn1 vsubs 1.75928e-16
* device instance ny_dup2_t0 r0 *1 0,0
Rny_dup2_t0 ny__t03 nyn2 41.9128
* device instance ny_dup2_t1 r0 *1 0,0
Rny_dup2_t1 ny__t13 nyn2 41.9128
* device instance ny_dup2 r0 *1 0,0
Cny_dup2 nyn2 vsubs 1.75928e-16
* device instance ny_dup3_t0 r0 *1 0,0
Rny_dup3_t0 ny__t04 nyn3 41.9128
* device instance ny_dup3_t1 r0 *1 0,0
Rny_dup3_t1 ny__t14 nyn3 41.9128
* device instance ny_dup3 r0 *1 0,0
Cny_dup3 nyn3 vsubs 1.75928e-16
* device instance ny_dup4_t0 r0 *1 0,0
Rny_dup4_t0 ny__t05 nyn4 41.9128
* device instance ny_dup4_t1 r0 *1 0,0
Rny_dup4_t1 ny__t15 nyn4 41.9128
* device instance ny_dup4 r0 *1 0,0
Cny_dup4 nyn4 vsubs 1.75928e-16
* device instance py_t0 r0 *1 0,0
Rpy_t0 py__t0 py 38.29745
* device instance py_t1 r0 *1 0,0
Rpy_t1 py__t1 py 38.29745
* device instance py r0 *1 0,0
Cpy py vsubs 1.98882e-16
* device instance py_dup1_t0 r0 *1 0,0
Rpy_dup1_t0 py__t02 pyn1 38.29745
* device instance py_dup1_t1 r0 *1 0,0
Rpy_dup1_t1 py__t12 pyn1 38.29745
* device instance py_dup1 r0 *1 0,0
Cpy_dup1 pyn1 vsubs 1.98882e-16
* device instance py_dup2_t0 r0 *1 0,0
Rpy_dup2_t0 py__t03 pyn2 38.29745
* device instance py_dup2_t1 r0 *1 0,0
Rpy_dup2_t1 py__t13 pyn2 38.29745
* device instance py_dup2 r0 *1 0,0
Cpy_dup2 pyn2 vsubs 1.98882e-16
* device instance py_dup3_t0 r0 *1 0,0
Rpy_dup3_t0 py__t04 pyn3 38.29745
* device instance py_dup3_t1 r0 *1 0,0
Rpy_dup3_t1 py__t14 pyn3 38.29745
* device instance py_dup3 r0 *1 0,0
Cpy_dup3 pyn3 vsubs 1.98882e-16
* device instance cc_a_g_a_ro_s4_y_y_a_g_y_mnab_y_mpa_y_mpb_y_n1_s1_a_y r0 *1 0,0
Ccc_a_g_a_ro_s4_y_y_a_g_y_mnab_y_mpa_y_mpb_y_n1_s1_a_y ro sig_n1 1.5977e-17
* device instance cc_a_g_a_ro_s4_y_y_g_vddr_m1_mnt_g_s1_vddr_m1_s2_vddr_m1_s3_vddr_m1_s4_vddr_m1_vddr r0 *1 0,0
Ccc_a_g_a_ro_s4_y_y_g_vddr_m1_mnt_g_s1_vddr_m1_s2_vddr_m1_s3_vddr_m1_s4_vddr_m1_vddr ro vddr 1.5474e-17
* device instance cc_a_g_y_mnab_y_mpa_y_mpb_y_n1_s1_a_y_g_vss_m1_mph_g_s1_vss_m1_s2_vss_m1_s3_vss_m1_s4_vss_m1_vss r0 *1 0,0
Ccc_a_g_y_mnab_y_mpa_y_mpb_y_n1_s1_a_y_g_vss_m1_mph_g_s1_vss_m1_s2_vss_m1_s3_vss_m1_s4_vss_m1_vss sig_n1 vss 3.869e-18
* device instance cc_a_g_y_mnab_y_mpa_y_mpb_y_n1_s1_a_y_ny r0 *1 0,0
Ccc_a_g_y_mnab_y_mpa_y_mpb_y_n1_s1_a_y_ny sig_n1 nyn4 2.878e-18
* device instance cc_a_n2_s1_y_s2_a_y_g_vss_m1_mph_g_s1_vss_m1_s2_vss_m1_s3_vss_m1_s4_vss_m1_vss r0 *1 0,0
Ccc_a_n2_s1_y_s2_a_y_g_vss_m1_mph_g_s1_vss_m1_s2_vss_m1_s3_vss_m1_s4_vss_m1_vss sig_n2 vss 3.869e-18
* device instance cc_a_n2_s1_y_s2_a_y_ny r0 *1 0,0
Ccc_a_n2_s1_y_s2_a_y_ny sig_n2 nyn4 2.878e-18
* device instance cc_a_n3_s2_y_s3_a_y_g_vss_m1_mph_g_s1_vss_m1_s2_vss_m1_s3_vss_m1_s4_vss_m1_vss r0 *1 0,0
Ccc_a_n3_s2_y_s3_a_y_g_vss_m1_mph_g_s1_vss_m1_s2_vss_m1_s3_vss_m1_s4_vss_m1_vss sig_n3 vss 3.869e-18
* device instance cc_a_n3_s2_y_s3_a_y_ny r0 *1 0,0
Ccc_a_n3_s2_y_s3_a_y_ny sig_n3 nyn4 2.878e-18
* device instance cc_a_n4_s3_y_s4_a_y_g_vss_m1_mph_g_s1_vss_m1_s2_vss_m1_s3_vss_m1_s4_vss_m1_vss r0 *1 0,0
Ccc_a_n4_s3_y_s4_a_y_g_vss_m1_mph_g_s1_vss_m1_s2_vss_m1_s3_vss_m1_s4_vss_m1_vss sig_n4 vss 3.869e-18
* device instance cc_a_n4_s3_y_s4_a_y_ny r0 *1 0,0
Ccc_a_n4_s3_y_s4_a_y_ny sig_n4 nyn4 2.878e-18
* device instance cc_g_vddr_m1_mnt_g_s1_vddr_m1_s2_vddr_m1_s3_vddr_m1_s4_vddr_m1_vddr_py r0 *1 0,0
Ccc_g_vddr_m1_mnt_g_s1_vddr_m1_s2_vddr_m1_s3_vddr_m1_s4_vddr_m1_vddr_py vddr pyn3 1.4252e-17
* device instance vsubs_dctie r0 *1 0,0
Rvsubs_dctie vsubs 0 1e+12
.ends ro_ring5_assembled_pex_wstv0p48__core

* ro_ring5_assembled_pex_wstv0p48 -- design-port-order wrapper over ro_ring5_assembled_pex_wstv0p48__core.
* Promoted-internal layout pins kept local here: sig_n1, sig_n2, sig_n3, sig_n4, py_g, ny, nyn1, nyn2, nyn3, nyn4, py, pyn1, pyn2, pyn3
.subckt ro_ring5_assembled_pex_wstv0p48 en ro vddr vss
xpex ro sig_n1 sig_n2 sig_n3 sig_n4 en vddr vss py_g ny nyn1 nyn2 nyn3 nyn4 py pyn1 pyn2 pyn3 ro_ring5_assembled_pex_wstv0p48__core
.ends ro_ring5_assembled_pex_wstv0p48

*-----------------------------------------------------------------------
* ro_buf_pex -- post-layout, from ../ro_buf/ro_buf.gds
* klt extract --parasitics: 2 devices, 4 nets
*-----------------------------------------------------------------------
.subckt ro_buf_pex__core a vdd vss y
* device instance $1 r0 *1 0.545,0.21 nfet
Xn1 y__t0 a__t0 vss__t0 vss__t1 sky130_fd_pr__nfet_01v8 L=0.15 W=0.42 AS=0.1974 AD=0.1974 PS=1.78 PD=1.78
* device instance $2 r0 *1 0.545,3.53 pfet
Xn2 y__t1 a__t1 vdd__t0 vdd__t1 sky130_fd_pr__pfet_01v8 L=0.15 W=0.84 AS=0.3948 AD=0.3948 PS=2.62 PD=2.62
* device instance a_t0 r0 *1 0,0
Ra_t0 a__t0 a 159.62375
* device instance a_t1 r0 *1 0,0
Ra_t1 a__t1 a 159.62375
* device instance a r0 *1 0,0
Ca a vsubs 5.75883e-16
* device instance vdd_t0 r0 *1 0,0
Rvdd_t0 vdd__t0 vdd 98.9335
* device instance vdd_t1 r0 *1 0,0
Rvdd_t1 vdd__t1 vdd 98.9335
* device instance vdd r0 *1 0,0
Cvdd vdd vsubs 6.69937e-16
* device instance vss_t0 r0 *1 0,0
Rvss_t0 vss__t0 vss 95.08305
* device instance vss_t1 r0 *1 0,0
Rvss_t1 vss__t1 vss 95.08305
* device instance vss r0 *1 0,0
Cvss vss vsubs 6.37991e-16
* device instance y_t0 r0 *1 0,0
Ry_t0 y__t0 y 207.64565
* device instance y_t1 r0 *1 0,0
Ry_t1 y__t1 y 207.64565
* device instance y r0 *1 0,0
Cy y vsubs 6.09871e-16
* device instance vsubs_dctie r0 *1 0,0
Rvsubs_dctie vsubs 0 1e+12
.ends ro_buf_pex__core

* ro_buf_pex -- design-port-order wrapper over ro_buf_pex__core.
* Promoted-internal layout pins kept local here: (none)
.subckt ro_buf_pex a y vdd vss
xpex a vdd vss y ro_buf_pex__core
.ends ro_buf_pex
