* extracted by klt extract --deck sky130

* cell ro_array_core_signal_poc
* pin a,b,invb_a,mn12_g1,mp24_g0
* pin a,b,invb_a,mn12_g1,mp24_g0
* pin a,b,invb_a,mn12_g1,mp24_g0
* pin a,g_a,rn1,ro,s4_y,y
* pin a,g_a,rn2,ro,s4_y,y
* pin a,g_a,rn3,ro,s4_y,y
* pin a,g_a,rn4,ro,s4_y,y
* pin a,g_y,mnab_y,mpa_y,mpb_y,n1,s1_a,y
* pin a,g_y,mnab_y,mpa_y,mpb_y,n1,s1_a,y
* pin a,g_y,mnab_y,mpa_y,mpb_y,n1,s1_a,y
* pin a,g_y,mnab_y,mpa_y,mpb_y,n1,s1_a,y
* pin a,inva_a,mn12_g0,mp13_g0
* pin a,inva_a,mn12_g0,mp13_g0
* pin a,inva_a,mn12_g0,mp13_g0
* pin a,n2,s1_y,s2_a,y
* pin a,n2,s1_y,s2_a,y
* pin a,n2,s1_y,s2_a,y
* pin a,n2,s1_y,s2_a,y
* pin a,n3,s2_y,s3_a,y
* pin a,n3,s2_y,s3_a,y
* pin a,n3,s2_y,s3_a,y
* pin a,n3,s2_y,s3_a,y
* pin a,n4,s3_y,s4_a,y
* pin a,n4,s3_y,s4_a,y
* pin a,n4,s3_y,s4_a,y
* pin a,n4,s3_y,s4_a,y
* pin an,inva_y,mn34_g0,mp13_g1,y
* pin an,inva_y,mn34_g0,mp13_g1,y
* pin an,inva_y,mn34_g0,mp13_g1,y
* pin bn,invb_y,mn34_g1,mp24_g1,y
* pin bn,invb_y,mn34_g1,mp24_g1,y
* pin bn,invb_y,mn34_g1,mp24_g1,y
* pin en,en1,g_en
* pin en,en2,g_en
* pin en,en3,g_en
* pin en,en4,g_en
* pin g_vddr_m1,mnt_g,s1_vddr_m1,s2_vddr_m1,s3_vddr_m1,s4_vddr_m1,vddr,vddr1
* pin g_vddr_m1,mnt_g,s1_vddr_m1,s2_vddr_m1,s3_vddr_m1,s4_vddr_m1,vddr,vddr2
* pin g_vddr_m1,mnt_g,s1_vddr_m1,s2_vddr_m1,s3_vddr_m1,s4_vddr_m1,vddr,vddr3
* pin g_vddr_m1,mnt_g,s1_vddr_m1,s2_vddr_m1,s3_vddr_m1,s4_vddr_m1,vddr,vddr4
* pin g_vss_m1,mph_g,s1_vss_m1,s2_vss_m1,s3_vss_m1,s4_vss_m1,vss
* pin mid
* pin mid
* pin mid
* pin mpa_py,mpb_py,mph_py,py
* pin mpa_py,mpb_py,mph_py,py
* pin mpa_py,mpb_py,mph_py,py
* pin mpa_py,mpb_py,mph_py,py
* pin ny
* pin ny
* pin ny
* pin ny
* pin ny
* pin ny
* pin ny
* pin ny
* pin ny
* pin ny
* pin ny
* pin ny
* pin ny
* pin ny
* pin ny
* pin ny
* pin ny
* pin ny
* pin ny
* pin ny
* pin py
* pin py
* pin py
* pin py
* pin py
* pin py
* pin py
* pin py
* pin py
* pin py
* pin py
* pin py
* pin py
* pin py
* pin py
* pin py
* pin ro1,y
* pin ro2,y
* pin ro3,y
* pin ro4,y
* pin vdd
* pin vdd
* pin vdd
* pin vdd
* pin vdd
* pin vdd
* pin vdd
* pin y
* pin y
* pin y
.SUBCKT ro_array_core_signal_poc a|b|invb_a|mn12_g1|mp24_g0
+ a|b|invb_a|mn12_g1|mp24_g0$1 a|b|invb_a|mn12_g1|mp24_g0$2 a|g_a|rn1|ro|s4_y|y
+ a|g_a|rn2|ro|s4_y|y a|g_a|rn3|ro|s4_y|y a|g_a|rn4|ro|s4_y|y
+ a|g_y|mnab_y|mpa_y|mpb_y|n1|s1_a|y a|g_y|mnab_y|mpa_y|mpb_y|n1|s1_a|y$1
+ a|g_y|mnab_y|mpa_y|mpb_y|n1|s1_a|y$2 a|g_y|mnab_y|mpa_y|mpb_y|n1|s1_a|y$3
+ a|inva_a|mn12_g0|mp13_g0 a|inva_a|mn12_g0|mp13_g0$1
+ a|inva_a|mn12_g0|mp13_g0$2 a|n2|s1_y|s2_a|y a|n2|s1_y|s2_a|y$1
+ a|n2|s1_y|s2_a|y$2 a|n2|s1_y|s2_a|y$3 a|n3|s2_y|s3_a|y a|n3|s2_y|s3_a|y$1
+ a|n3|s2_y|s3_a|y$2 a|n3|s2_y|s3_a|y$3 a|n4|s3_y|s4_a|y a|n4|s3_y|s4_a|y$1
+ a|n4|s3_y|s4_a|y$2 a|n4|s3_y|s4_a|y$3 an|inva_y|mn34_g0|mp13_g1|y
+ an|inva_y|mn34_g0|mp13_g1|y$1 an|inva_y|mn34_g0|mp13_g1|y$2
+ bn|invb_y|mn34_g1|mp24_g1|y bn|invb_y|mn34_g1|mp24_g1|y$1
+ bn|invb_y|mn34_g1|mp24_g1|y$2 en|en1|g_en en|en2|g_en en|en3|g_en en|en4|g_en
+ g_vddr_m1|mnt_g|s1_vddr_m1|s2_vddr_m1|s3_vddr_m1|s4_vddr_m1|vddr|vddr1
+ g_vddr_m1|mnt_g|s1_vddr_m1|s2_vddr_m1|s3_vddr_m1|s4_vddr_m1|vddr|vddr2
+ g_vddr_m1|mnt_g|s1_vddr_m1|s2_vddr_m1|s3_vddr_m1|s4_vddr_m1|vddr|vddr3
+ g_vddr_m1|mnt_g|s1_vddr_m1|s2_vddr_m1|s3_vddr_m1|s4_vddr_m1|vddr|vddr4
+ g_vss_m1|mph_g|s1_vss_m1|s2_vss_m1|s3_vss_m1|s4_vss_m1|vss mid mid$1 mid$2
+ mpa_py|mpb_py|mph_py|py mpa_py|mpb_py|mph_py|py$1 mpa_py|mpb_py|mph_py|py$2
+ mpa_py|mpb_py|mph_py|py$3 ny ny$1 ny$2 ny$3 ny$4 ny$5 ny$6 ny$7 ny$8 ny$9
+ ny$10 ny$11 ny$12 ny$13 ny$14 ny$15 ny$16 ny$17 ny$18 ny$19 py py$1 py$2 py$3
+ py$4 py$5 py$6 py$7 py$8 py$9 py$10 py$11 py$12 py$13 py$14 py$15 ro1|y ro2|y
+ ro3|y ro4|y vdd vdd$1 vdd$2 vdd$3 vdd$4 vdd$5 vdd$6 y y$1 y$2
* device instance $1 r0 *1 5.975,0.21 nfet
M$1 \$8 en|en1|g_en ny
+ g_vss_m1|mph_g|s1_vss_m1|s2_vss_m1|s3_vss_m1|s4_vss_m1|vss nfet L=0.15U
+ W=0.84U AS=0.3948P AD=0.2184P PS=2.62U PD=1.36U
* device instance $2 r0 *1 6.645,0.21 nfet
M$2 a|g_y|mnab_y|mpa_y|mpb_y|n1|s1_a|y a|g_a|rn1|ro|s4_y|y \$8
+ g_vss_m1|mph_g|s1_vss_m1|s2_vss_m1|s3_vss_m1|s4_vss_m1|vss nfet L=0.15U
+ W=0.84U AS=0.2184P AD=0.3948P PS=1.36U PD=2.62U
* device instance $3 r0 *1 61.275,0.21 nfet
M$3 \$15 en|en2|g_en ny$5
+ g_vss_m1|mph_g|s1_vss_m1|s2_vss_m1|s3_vss_m1|s4_vss_m1|vss nfet L=0.15U
+ W=0.84U AS=0.3948P AD=0.2184P PS=2.62U PD=1.36U
* device instance $4 r0 *1 61.945,0.21 nfet
M$4 a|g_y|mnab_y|mpa_y|mpb_y|n1|s1_a|y$1 a|g_a|rn2|ro|s4_y|y \$15
+ g_vss_m1|mph_g|s1_vss_m1|s2_vss_m1|s3_vss_m1|s4_vss_m1|vss nfet L=0.15U
+ W=0.84U AS=0.2184P AD=0.3948P PS=1.36U PD=2.62U
* device instance $5 r0 *1 116.575,0.21 nfet
M$5 \$22 en|en3|g_en ny$10
+ g_vss_m1|mph_g|s1_vss_m1|s2_vss_m1|s3_vss_m1|s4_vss_m1|vss nfet L=0.15U
+ W=0.84U AS=0.3948P AD=0.2184P PS=2.62U PD=1.36U
* device instance $6 r0 *1 117.245,0.21 nfet
M$6 a|g_y|mnab_y|mpa_y|mpb_y|n1|s1_a|y$2 a|g_a|rn3|ro|s4_y|y \$22
+ g_vss_m1|mph_g|s1_vss_m1|s2_vss_m1|s3_vss_m1|s4_vss_m1|vss nfet L=0.15U
+ W=0.84U AS=0.2184P AD=0.3948P PS=1.36U PD=2.62U
* device instance $7 r0 *1 171.875,0.21 nfet
M$7 \$29 en|en4|g_en ny$15
+ g_vss_m1|mph_g|s1_vss_m1|s2_vss_m1|s3_vss_m1|s4_vss_m1|vss nfet L=0.15U
+ W=0.84U AS=0.3948P AD=0.2184P PS=2.62U PD=1.36U
* device instance $8 r0 *1 172.545,0.21 nfet
M$8 a|g_y|mnab_y|mpa_y|mpb_y|n1|s1_a|y$3 a|g_a|rn4|ro|s4_y|y \$29
+ g_vss_m1|mph_g|s1_vss_m1|s2_vss_m1|s3_vss_m1|s4_vss_m1|vss nfet L=0.15U
+ W=0.84U AS=0.2184P AD=0.3948P PS=1.36U PD=2.62U
* device instance $9 r0 *1 114.21,0.21 nfet
M$9 ny$10
+ g_vddr_m1|mnt_g|s1_vddr_m1|s2_vddr_m1|s3_vddr_m1|s4_vddr_m1|vddr|vddr3
+ g_vss_m1|mph_g|s1_vss_m1|s2_vss_m1|s3_vss_m1|s4_vss_m1|vss
+ g_vss_m1|mph_g|s1_vss_m1|s2_vss_m1|s3_vss_m1|s4_vss_m1|vss nfet L=2U W=0.46U
+ AS=0.1932P AD=0.1932P PS=1.76U PD=1.76U
* device instance $10 r0 *1 123.51,0.21 nfet
M$10 ny$11
+ g_vddr_m1|mnt_g|s1_vddr_m1|s2_vddr_m1|s3_vddr_m1|s4_vddr_m1|vddr|vddr3
+ g_vss_m1|mph_g|s1_vss_m1|s2_vss_m1|s3_vss_m1|s4_vss_m1|vss
+ g_vss_m1|mph_g|s1_vss_m1|s2_vss_m1|s3_vss_m1|s4_vss_m1|vss nfet L=2U W=0.46U
+ AS=0.1932P AD=0.1932P PS=1.76U PD=1.76U
* device instance $11 r0 *1 131.685,0.21 nfet
M$11 ny$12
+ g_vddr_m1|mnt_g|s1_vddr_m1|s2_vddr_m1|s3_vddr_m1|s4_vddr_m1|vddr|vddr3
+ g_vss_m1|mph_g|s1_vss_m1|s2_vss_m1|s3_vss_m1|s4_vss_m1|vss
+ g_vss_m1|mph_g|s1_vss_m1|s2_vss_m1|s3_vss_m1|s4_vss_m1|vss nfet L=2U W=0.46U
+ AS=0.1932P AD=0.1932P PS=1.76U PD=1.76U
* device instance $12 r0 *1 139.86,0.21 nfet
M$12 ny$13
+ g_vddr_m1|mnt_g|s1_vddr_m1|s2_vddr_m1|s3_vddr_m1|s4_vddr_m1|vddr|vddr3
+ g_vss_m1|mph_g|s1_vss_m1|s2_vss_m1|s3_vss_m1|s4_vss_m1|vss
+ g_vss_m1|mph_g|s1_vss_m1|s2_vss_m1|s3_vss_m1|s4_vss_m1|vss nfet L=2U W=0.46U
+ AS=0.1932P AD=0.1932P PS=1.76U PD=1.76U
* device instance $13 r0 *1 148.035,0.21 nfet
M$13 ny$14
+ g_vddr_m1|mnt_g|s1_vddr_m1|s2_vddr_m1|s3_vddr_m1|s4_vddr_m1|vddr|vddr3
+ g_vss_m1|mph_g|s1_vss_m1|s2_vss_m1|s3_vss_m1|s4_vss_m1|vss
+ g_vss_m1|mph_g|s1_vss_m1|s2_vss_m1|s3_vss_m1|s4_vss_m1|vss nfet L=2U W=0.46U
+ AS=0.1932P AD=0.1932P PS=1.76U PD=1.76U
* device instance $14 r0 *1 169.51,0.21 nfet
M$14 ny$15
+ g_vddr_m1|mnt_g|s1_vddr_m1|s2_vddr_m1|s3_vddr_m1|s4_vddr_m1|vddr|vddr4
+ g_vss_m1|mph_g|s1_vss_m1|s2_vss_m1|s3_vss_m1|s4_vss_m1|vss
+ g_vss_m1|mph_g|s1_vss_m1|s2_vss_m1|s3_vss_m1|s4_vss_m1|vss nfet L=2U W=0.48U
+ AS=0.2016P AD=0.2016P PS=1.8U PD=1.8U
* device instance $15 r0 *1 178.81,0.21 nfet
M$15 ny$16
+ g_vddr_m1|mnt_g|s1_vddr_m1|s2_vddr_m1|s3_vddr_m1|s4_vddr_m1|vddr|vddr4
+ g_vss_m1|mph_g|s1_vss_m1|s2_vss_m1|s3_vss_m1|s4_vss_m1|vss
+ g_vss_m1|mph_g|s1_vss_m1|s2_vss_m1|s3_vss_m1|s4_vss_m1|vss nfet L=2U W=0.48U
+ AS=0.2016P AD=0.2016P PS=1.8U PD=1.8U
* device instance $16 r0 *1 186.985,0.21 nfet
M$16 ny$17
+ g_vddr_m1|mnt_g|s1_vddr_m1|s2_vddr_m1|s3_vddr_m1|s4_vddr_m1|vddr|vddr4
+ g_vss_m1|mph_g|s1_vss_m1|s2_vss_m1|s3_vss_m1|s4_vss_m1|vss
+ g_vss_m1|mph_g|s1_vss_m1|s2_vss_m1|s3_vss_m1|s4_vss_m1|vss nfet L=2U W=0.48U
+ AS=0.2016P AD=0.2016P PS=1.8U PD=1.8U
* device instance $17 r0 *1 195.16,0.21 nfet
M$17 ny$18
+ g_vddr_m1|mnt_g|s1_vddr_m1|s2_vddr_m1|s3_vddr_m1|s4_vddr_m1|vddr|vddr4
+ g_vss_m1|mph_g|s1_vss_m1|s2_vss_m1|s3_vss_m1|s4_vss_m1|vss
+ g_vss_m1|mph_g|s1_vss_m1|s2_vss_m1|s3_vss_m1|s4_vss_m1|vss nfet L=2U W=0.48U
+ AS=0.2016P AD=0.2016P PS=1.8U PD=1.8U
* device instance $18 r0 *1 203.335,0.21 nfet
M$18 ny$19
+ g_vddr_m1|mnt_g|s1_vddr_m1|s2_vddr_m1|s3_vddr_m1|s4_vddr_m1|vddr|vddr4
+ g_vss_m1|mph_g|s1_vss_m1|s2_vss_m1|s3_vss_m1|s4_vss_m1|vss
+ g_vss_m1|mph_g|s1_vss_m1|s2_vss_m1|s3_vss_m1|s4_vss_m1|vss nfet L=2U W=0.48U
+ AS=0.2016P AD=0.2016P PS=1.8U PD=1.8U
* device instance $19 r0 *1 3.61,0.21 nfet
M$19 ny g_vddr_m1|mnt_g|s1_vddr_m1|s2_vddr_m1|s3_vddr_m1|s4_vddr_m1|vddr|vddr1
+ g_vss_m1|mph_g|s1_vss_m1|s2_vss_m1|s3_vss_m1|s4_vss_m1|vss
+ g_vss_m1|mph_g|s1_vss_m1|s2_vss_m1|s3_vss_m1|s4_vss_m1|vss nfet L=2U W=0.42U
+ AS=0.1764P AD=0.1764P PS=1.68U PD=1.68U
* device instance $20 r0 *1 12.91,0.21 nfet
M$20 ny$1
+ g_vddr_m1|mnt_g|s1_vddr_m1|s2_vddr_m1|s3_vddr_m1|s4_vddr_m1|vddr|vddr1
+ g_vss_m1|mph_g|s1_vss_m1|s2_vss_m1|s3_vss_m1|s4_vss_m1|vss
+ g_vss_m1|mph_g|s1_vss_m1|s2_vss_m1|s3_vss_m1|s4_vss_m1|vss nfet L=2U W=0.42U
+ AS=0.1764P AD=0.1764P PS=1.68U PD=1.68U
* device instance $21 r0 *1 15.275,0.21 nfet
M$21 a|n2|s1_y|s2_a|y a|g_y|mnab_y|mpa_y|mpb_y|n1|s1_a|y ny$1
+ g_vss_m1|mph_g|s1_vss_m1|s2_vss_m1|s3_vss_m1|s4_vss_m1|vss nfet L=0.15U
+ W=0.42U AS=0.1974P AD=0.1974P PS=1.78U PD=1.78U
* device instance $22 r0 *1 21.085,0.21 nfet
M$22 ny$2
+ g_vddr_m1|mnt_g|s1_vddr_m1|s2_vddr_m1|s3_vddr_m1|s4_vddr_m1|vddr|vddr1
+ g_vss_m1|mph_g|s1_vss_m1|s2_vss_m1|s3_vss_m1|s4_vss_m1|vss
+ g_vss_m1|mph_g|s1_vss_m1|s2_vss_m1|s3_vss_m1|s4_vss_m1|vss nfet L=2U W=0.42U
+ AS=0.1764P AD=0.1764P PS=1.68U PD=1.68U
* device instance $23 r0 *1 23.45,0.21 nfet
M$23 a|n3|s2_y|s3_a|y a|n2|s1_y|s2_a|y ny$2
+ g_vss_m1|mph_g|s1_vss_m1|s2_vss_m1|s3_vss_m1|s4_vss_m1|vss nfet L=0.15U
+ W=0.42U AS=0.1974P AD=0.1974P PS=1.78U PD=1.78U
* device instance $24 r0 *1 29.26,0.21 nfet
M$24 ny$3
+ g_vddr_m1|mnt_g|s1_vddr_m1|s2_vddr_m1|s3_vddr_m1|s4_vddr_m1|vddr|vddr1
+ g_vss_m1|mph_g|s1_vss_m1|s2_vss_m1|s3_vss_m1|s4_vss_m1|vss
+ g_vss_m1|mph_g|s1_vss_m1|s2_vss_m1|s3_vss_m1|s4_vss_m1|vss nfet L=2U W=0.42U
+ AS=0.1764P AD=0.1764P PS=1.68U PD=1.68U
* device instance $25 r0 *1 31.625,0.21 nfet
M$25 a|n4|s3_y|s4_a|y a|n3|s2_y|s3_a|y ny$3
+ g_vss_m1|mph_g|s1_vss_m1|s2_vss_m1|s3_vss_m1|s4_vss_m1|vss nfet L=0.15U
+ W=0.42U AS=0.1974P AD=0.1974P PS=1.78U PD=1.78U
* device instance $26 r0 *1 37.435,0.21 nfet
M$26 ny$4
+ g_vddr_m1|mnt_g|s1_vddr_m1|s2_vddr_m1|s3_vddr_m1|s4_vddr_m1|vddr|vddr1
+ g_vss_m1|mph_g|s1_vss_m1|s2_vss_m1|s3_vss_m1|s4_vss_m1|vss
+ g_vss_m1|mph_g|s1_vss_m1|s2_vss_m1|s3_vss_m1|s4_vss_m1|vss nfet L=2U W=0.42U
+ AS=0.1764P AD=0.1764P PS=1.68U PD=1.68U
* device instance $27 r0 *1 39.8,0.21 nfet
M$27 a|g_a|rn1|ro|s4_y|y a|n4|s3_y|s4_a|y ny$4
+ g_vss_m1|mph_g|s1_vss_m1|s2_vss_m1|s3_vss_m1|s4_vss_m1|vss nfet L=0.15U
+ W=0.42U AS=0.1974P AD=0.1974P PS=1.78U PD=1.78U
* device instance $28 r0 *1 48.86,0.21 nfet
M$28 ro1|y a|g_a|rn1|ro|s4_y|y
+ g_vss_m1|mph_g|s1_vss_m1|s2_vss_m1|s3_vss_m1|s4_vss_m1|vss
+ g_vss_m1|mph_g|s1_vss_m1|s2_vss_m1|s3_vss_m1|s4_vss_m1|vss nfet L=0.15U
+ W=0.42U AS=0.1974P AD=0.1974P PS=1.78U PD=1.78U
* device instance $29 r0 *1 58.91,0.21 nfet
M$29 ny$5
+ g_vddr_m1|mnt_g|s1_vddr_m1|s2_vddr_m1|s3_vddr_m1|s4_vddr_m1|vddr|vddr2
+ g_vss_m1|mph_g|s1_vss_m1|s2_vss_m1|s3_vss_m1|s4_vss_m1|vss
+ g_vss_m1|mph_g|s1_vss_m1|s2_vss_m1|s3_vss_m1|s4_vss_m1|vss nfet L=2U W=0.44U
+ AS=0.1848P AD=0.1848P PS=1.72U PD=1.72U
* device instance $30 r0 *1 68.21,0.21 nfet
M$30 ny$6
+ g_vddr_m1|mnt_g|s1_vddr_m1|s2_vddr_m1|s3_vddr_m1|s4_vddr_m1|vddr|vddr2
+ g_vss_m1|mph_g|s1_vss_m1|s2_vss_m1|s3_vss_m1|s4_vss_m1|vss
+ g_vss_m1|mph_g|s1_vss_m1|s2_vss_m1|s3_vss_m1|s4_vss_m1|vss nfet L=2U W=0.44U
+ AS=0.1848P AD=0.1848P PS=1.72U PD=1.72U
* device instance $31 r0 *1 70.575,0.21 nfet
M$31 a|n2|s1_y|s2_a|y$1 a|g_y|mnab_y|mpa_y|mpb_y|n1|s1_a|y$1 ny$6
+ g_vss_m1|mph_g|s1_vss_m1|s2_vss_m1|s3_vss_m1|s4_vss_m1|vss nfet L=0.15U
+ W=0.42U AS=0.1974P AD=0.1974P PS=1.78U PD=1.78U
* device instance $32 r0 *1 76.385,0.21 nfet
M$32 ny$7
+ g_vddr_m1|mnt_g|s1_vddr_m1|s2_vddr_m1|s3_vddr_m1|s4_vddr_m1|vddr|vddr2
+ g_vss_m1|mph_g|s1_vss_m1|s2_vss_m1|s3_vss_m1|s4_vss_m1|vss
+ g_vss_m1|mph_g|s1_vss_m1|s2_vss_m1|s3_vss_m1|s4_vss_m1|vss nfet L=2U W=0.44U
+ AS=0.1848P AD=0.1848P PS=1.72U PD=1.72U
* device instance $33 r0 *1 78.75,0.21 nfet
M$33 a|n3|s2_y|s3_a|y$1 a|n2|s1_y|s2_a|y$1 ny$7
+ g_vss_m1|mph_g|s1_vss_m1|s2_vss_m1|s3_vss_m1|s4_vss_m1|vss nfet L=0.15U
+ W=0.42U AS=0.1974P AD=0.1974P PS=1.78U PD=1.78U
* device instance $34 r0 *1 84.56,0.21 nfet
M$34 ny$8
+ g_vddr_m1|mnt_g|s1_vddr_m1|s2_vddr_m1|s3_vddr_m1|s4_vddr_m1|vddr|vddr2
+ g_vss_m1|mph_g|s1_vss_m1|s2_vss_m1|s3_vss_m1|s4_vss_m1|vss
+ g_vss_m1|mph_g|s1_vss_m1|s2_vss_m1|s3_vss_m1|s4_vss_m1|vss nfet L=2U W=0.44U
+ AS=0.1848P AD=0.1848P PS=1.72U PD=1.72U
* device instance $35 r0 *1 86.925,0.21 nfet
M$35 a|n4|s3_y|s4_a|y$1 a|n3|s2_y|s3_a|y$1 ny$8
+ g_vss_m1|mph_g|s1_vss_m1|s2_vss_m1|s3_vss_m1|s4_vss_m1|vss nfet L=0.15U
+ W=0.42U AS=0.1974P AD=0.1974P PS=1.78U PD=1.78U
* device instance $36 r0 *1 92.735,0.21 nfet
M$36 ny$9
+ g_vddr_m1|mnt_g|s1_vddr_m1|s2_vddr_m1|s3_vddr_m1|s4_vddr_m1|vddr|vddr2
+ g_vss_m1|mph_g|s1_vss_m1|s2_vss_m1|s3_vss_m1|s4_vss_m1|vss
+ g_vss_m1|mph_g|s1_vss_m1|s2_vss_m1|s3_vss_m1|s4_vss_m1|vss nfet L=2U W=0.44U
+ AS=0.1848P AD=0.1848P PS=1.72U PD=1.72U
* device instance $37 r0 *1 95.1,0.21 nfet
M$37 a|g_a|rn2|ro|s4_y|y a|n4|s3_y|s4_a|y$1 ny$9
+ g_vss_m1|mph_g|s1_vss_m1|s2_vss_m1|s3_vss_m1|s4_vss_m1|vss nfet L=0.15U
+ W=0.42U AS=0.1974P AD=0.1974P PS=1.78U PD=1.78U
* device instance $38 r0 *1 104.16,0.21 nfet
M$38 ro2|y a|g_a|rn2|ro|s4_y|y
+ g_vss_m1|mph_g|s1_vss_m1|s2_vss_m1|s3_vss_m1|s4_vss_m1|vss
+ g_vss_m1|mph_g|s1_vss_m1|s2_vss_m1|s3_vss_m1|s4_vss_m1|vss nfet L=0.15U
+ W=0.42U AS=0.1974P AD=0.1974P PS=1.78U PD=1.78U
* device instance $39 r0 *1 125.875,0.21 nfet
M$39 a|n2|s1_y|s2_a|y$2 a|g_y|mnab_y|mpa_y|mpb_y|n1|s1_a|y$2 ny$11
+ g_vss_m1|mph_g|s1_vss_m1|s2_vss_m1|s3_vss_m1|s4_vss_m1|vss nfet L=0.15U
+ W=0.42U AS=0.1974P AD=0.1974P PS=1.78U PD=1.78U
* device instance $40 r0 *1 134.05,0.21 nfet
M$40 a|n3|s2_y|s3_a|y$2 a|n2|s1_y|s2_a|y$2 ny$12
+ g_vss_m1|mph_g|s1_vss_m1|s2_vss_m1|s3_vss_m1|s4_vss_m1|vss nfet L=0.15U
+ W=0.42U AS=0.1974P AD=0.1974P PS=1.78U PD=1.78U
* device instance $41 r0 *1 142.225,0.21 nfet
M$41 a|n4|s3_y|s4_a|y$2 a|n3|s2_y|s3_a|y$2 ny$13
+ g_vss_m1|mph_g|s1_vss_m1|s2_vss_m1|s3_vss_m1|s4_vss_m1|vss nfet L=0.15U
+ W=0.42U AS=0.1974P AD=0.1974P PS=1.78U PD=1.78U
* device instance $42 r0 *1 150.4,0.21 nfet
M$42 a|g_a|rn3|ro|s4_y|y a|n4|s3_y|s4_a|y$2 ny$14
+ g_vss_m1|mph_g|s1_vss_m1|s2_vss_m1|s3_vss_m1|s4_vss_m1|vss nfet L=0.15U
+ W=0.42U AS=0.1974P AD=0.1974P PS=1.78U PD=1.78U
* device instance $43 r0 *1 159.46,0.21 nfet
M$43 ro3|y a|g_a|rn3|ro|s4_y|y
+ g_vss_m1|mph_g|s1_vss_m1|s2_vss_m1|s3_vss_m1|s4_vss_m1|vss
+ g_vss_m1|mph_g|s1_vss_m1|s2_vss_m1|s3_vss_m1|s4_vss_m1|vss nfet L=0.15U
+ W=0.42U AS=0.1974P AD=0.1974P PS=1.78U PD=1.78U
* device instance $44 r0 *1 181.175,0.21 nfet
M$44 a|n2|s1_y|s2_a|y$3 a|g_y|mnab_y|mpa_y|mpb_y|n1|s1_a|y$3 ny$16
+ g_vss_m1|mph_g|s1_vss_m1|s2_vss_m1|s3_vss_m1|s4_vss_m1|vss nfet L=0.15U
+ W=0.42U AS=0.1974P AD=0.1974P PS=1.78U PD=1.78U
* device instance $45 r0 *1 189.35,0.21 nfet
M$45 a|n3|s2_y|s3_a|y$3 a|n2|s1_y|s2_a|y$3 ny$17
+ g_vss_m1|mph_g|s1_vss_m1|s2_vss_m1|s3_vss_m1|s4_vss_m1|vss nfet L=0.15U
+ W=0.42U AS=0.1974P AD=0.1974P PS=1.78U PD=1.78U
* device instance $46 r0 *1 197.525,0.21 nfet
M$46 a|n4|s3_y|s4_a|y$3 a|n3|s2_y|s3_a|y$3 ny$18
+ g_vss_m1|mph_g|s1_vss_m1|s2_vss_m1|s3_vss_m1|s4_vss_m1|vss nfet L=0.15U
+ W=0.42U AS=0.1974P AD=0.1974P PS=1.78U PD=1.78U
* device instance $47 r0 *1 205.7,0.21 nfet
M$47 a|g_a|rn4|ro|s4_y|y a|n4|s3_y|s4_a|y$3 ny$19
+ g_vss_m1|mph_g|s1_vss_m1|s2_vss_m1|s3_vss_m1|s4_vss_m1|vss nfet L=0.15U
+ W=0.42U AS=0.1974P AD=0.1974P PS=1.78U PD=1.78U
* device instance $48 r0 *1 214.76,0.21 nfet
M$48 ro4|y a|g_a|rn4|ro|s4_y|y
+ g_vss_m1|mph_g|s1_vss_m1|s2_vss_m1|s3_vss_m1|s4_vss_m1|vss
+ g_vss_m1|mph_g|s1_vss_m1|s2_vss_m1|s3_vss_m1|s4_vss_m1|vss nfet L=0.15U
+ W=0.42U AS=0.1974P AD=0.1974P PS=1.78U PD=1.78U
* device instance $49 r0 *1 3.445,17.905 nfet
M$49 an|inva_y|mn34_g0|mp13_g1|y a|inva_a|mn12_g0|mp13_g0
+ g_vss_m1|mph_g|s1_vss_m1|s2_vss_m1|s3_vss_m1|s4_vss_m1|vss
+ g_vss_m1|mph_g|s1_vss_m1|s2_vss_m1|s3_vss_m1|s4_vss_m1|vss nfet L=0.15U
+ W=0.42U AS=0.1974P AD=0.1974P PS=1.78U PD=1.78U
* device instance $50 r0 *1 7.78,15.585 nfet
M$50 \$84 an|inva_y|mn34_g0|mp13_g1|y y
+ g_vss_m1|mph_g|s1_vss_m1|s2_vss_m1|s3_vss_m1|s4_vss_m1|vss nfet L=0.15U
+ W=0.84U AS=0.3948P AD=0.2184P PS=2.62U PD=1.36U
* device instance $51 r0 *1 8.45,15.585 nfet
M$51 g_vss_m1|mph_g|s1_vss_m1|s2_vss_m1|s3_vss_m1|s4_vss_m1|vss
+ bn|invb_y|mn34_g1|mp24_g1|y \$84
+ g_vss_m1|mph_g|s1_vss_m1|s2_vss_m1|s3_vss_m1|s4_vss_m1|vss nfet L=0.15U
+ W=0.84U AS=0.2184P AD=0.3948P PS=1.36U PD=2.62U
* device instance $52 r0 *1 14.78,15.585 nfet
M$52 \$86 a|inva_a|mn12_g0|mp13_g0 y
+ g_vss_m1|mph_g|s1_vss_m1|s2_vss_m1|s3_vss_m1|s4_vss_m1|vss nfet L=0.15U
+ W=0.84U AS=0.3948P AD=0.2184P PS=2.62U PD=1.36U
* device instance $53 r0 *1 15.45,15.585 nfet
M$53 g_vss_m1|mph_g|s1_vss_m1|s2_vss_m1|s3_vss_m1|s4_vss_m1|vss
+ a|b|invb_a|mn12_g1|mp24_g0 \$86
+ g_vss_m1|mph_g|s1_vss_m1|s2_vss_m1|s3_vss_m1|s4_vss_m1|vss nfet L=0.15U
+ W=0.84U AS=0.2184P AD=0.3948P PS=1.36U PD=2.62U
* device instance $54 r0 *1 21.62,17.905 nfet
M$54 bn|invb_y|mn34_g1|mp24_g1|y a|b|invb_a|mn12_g1|mp24_g0
+ g_vss_m1|mph_g|s1_vss_m1|s2_vss_m1|s3_vss_m1|s4_vss_m1|vss
+ g_vss_m1|mph_g|s1_vss_m1|s2_vss_m1|s3_vss_m1|s4_vss_m1|vss nfet L=0.15U
+ W=0.42U AS=0.1974P AD=0.1974P PS=1.78U PD=1.78U
* device instance $55 r0 *1 32.415,17.905 nfet
M$55 an|inva_y|mn34_g0|mp13_g1|y$1 a|inva_a|mn12_g0|mp13_g0$1
+ g_vss_m1|mph_g|s1_vss_m1|s2_vss_m1|s3_vss_m1|s4_vss_m1|vss
+ g_vss_m1|mph_g|s1_vss_m1|s2_vss_m1|s3_vss_m1|s4_vss_m1|vss nfet L=0.15U
+ W=0.42U AS=0.1974P AD=0.1974P PS=1.78U PD=1.78U
* device instance $56 r0 *1 36.75,15.585 nfet
M$56 \$90 an|inva_y|mn34_g0|mp13_g1|y$1 y$1
+ g_vss_m1|mph_g|s1_vss_m1|s2_vss_m1|s3_vss_m1|s4_vss_m1|vss nfet L=0.15U
+ W=0.84U AS=0.3948P AD=0.2184P PS=2.62U PD=1.36U
* device instance $57 r0 *1 37.42,15.585 nfet
M$57 g_vss_m1|mph_g|s1_vss_m1|s2_vss_m1|s3_vss_m1|s4_vss_m1|vss
+ bn|invb_y|mn34_g1|mp24_g1|y$1 \$90
+ g_vss_m1|mph_g|s1_vss_m1|s2_vss_m1|s3_vss_m1|s4_vss_m1|vss nfet L=0.15U
+ W=0.84U AS=0.2184P AD=0.3948P PS=1.36U PD=2.62U
* device instance $58 r0 *1 43.75,15.585 nfet
M$58 \$92 a|inva_a|mn12_g0|mp13_g0$1 y$1
+ g_vss_m1|mph_g|s1_vss_m1|s2_vss_m1|s3_vss_m1|s4_vss_m1|vss nfet L=0.15U
+ W=0.84U AS=0.3948P AD=0.2184P PS=2.62U PD=1.36U
* device instance $59 r0 *1 44.42,15.585 nfet
M$59 g_vss_m1|mph_g|s1_vss_m1|s2_vss_m1|s3_vss_m1|s4_vss_m1|vss
+ a|b|invb_a|mn12_g1|mp24_g0$1 \$92
+ g_vss_m1|mph_g|s1_vss_m1|s2_vss_m1|s3_vss_m1|s4_vss_m1|vss nfet L=0.15U
+ W=0.84U AS=0.2184P AD=0.3948P PS=1.36U PD=2.62U
* device instance $60 r0 *1 50.59,17.905 nfet
M$60 bn|invb_y|mn34_g1|mp24_g1|y$1 a|b|invb_a|mn12_g1|mp24_g0$1
+ g_vss_m1|mph_g|s1_vss_m1|s2_vss_m1|s3_vss_m1|s4_vss_m1|vss
+ g_vss_m1|mph_g|s1_vss_m1|s2_vss_m1|s3_vss_m1|s4_vss_m1|vss nfet L=0.15U
+ W=0.42U AS=0.1974P AD=0.1974P PS=1.78U PD=1.78U
* device instance $61 r0 *1 61.385,17.905 nfet
M$61 an|inva_y|mn34_g0|mp13_g1|y$2 a|inva_a|mn12_g0|mp13_g0$2
+ g_vss_m1|mph_g|s1_vss_m1|s2_vss_m1|s3_vss_m1|s4_vss_m1|vss
+ g_vss_m1|mph_g|s1_vss_m1|s2_vss_m1|s3_vss_m1|s4_vss_m1|vss nfet L=0.15U
+ W=0.42U AS=0.1974P AD=0.1974P PS=1.78U PD=1.78U
* device instance $62 r0 *1 65.72,15.585 nfet
M$62 \$96 an|inva_y|mn34_g0|mp13_g1|y$2 y$2
+ g_vss_m1|mph_g|s1_vss_m1|s2_vss_m1|s3_vss_m1|s4_vss_m1|vss nfet L=0.15U
+ W=0.84U AS=0.3948P AD=0.2184P PS=2.62U PD=1.36U
* device instance $63 r0 *1 66.39,15.585 nfet
M$63 g_vss_m1|mph_g|s1_vss_m1|s2_vss_m1|s3_vss_m1|s4_vss_m1|vss
+ bn|invb_y|mn34_g1|mp24_g1|y$2 \$96
+ g_vss_m1|mph_g|s1_vss_m1|s2_vss_m1|s3_vss_m1|s4_vss_m1|vss nfet L=0.15U
+ W=0.84U AS=0.2184P AD=0.3948P PS=1.36U PD=2.62U
* device instance $64 r0 *1 72.72,15.585 nfet
M$64 \$98 a|inva_a|mn12_g0|mp13_g0$2 y$2
+ g_vss_m1|mph_g|s1_vss_m1|s2_vss_m1|s3_vss_m1|s4_vss_m1|vss nfet L=0.15U
+ W=0.84U AS=0.3948P AD=0.2184P PS=2.62U PD=1.36U
* device instance $65 r0 *1 73.39,15.585 nfet
M$65 g_vss_m1|mph_g|s1_vss_m1|s2_vss_m1|s3_vss_m1|s4_vss_m1|vss
+ a|b|invb_a|mn12_g1|mp24_g0$2 \$98
+ g_vss_m1|mph_g|s1_vss_m1|s2_vss_m1|s3_vss_m1|s4_vss_m1|vss nfet L=0.15U
+ W=0.84U AS=0.2184P AD=0.3948P PS=1.36U PD=2.62U
* device instance $66 r0 *1 79.56,17.905 nfet
M$66 bn|invb_y|mn34_g1|mp24_g1|y$2 a|b|invb_a|mn12_g1|mp24_g0$2
+ g_vss_m1|mph_g|s1_vss_m1|s2_vss_m1|s3_vss_m1|s4_vss_m1|vss
+ g_vss_m1|mph_g|s1_vss_m1|s2_vss_m1|s3_vss_m1|s4_vss_m1|vss nfet L=0.15U
+ W=0.42U AS=0.1974P AD=0.1974P PS=1.78U PD=1.78U
* device instance $67 r0 *1 48.86,3.53 pfet
M$67 ro1|y a|g_a|rn1|ro|s4_y|y vdd vdd pfet L=0.15U W=0.84U AS=0.3948P
+ AD=0.3948P PS=2.62U PD=2.62U
* device instance $68 r0 *1 104.16,3.53 pfet
M$68 ro2|y a|g_a|rn2|ro|s4_y|y vdd$1 vdd$1 pfet L=0.15U W=0.84U AS=0.3948P
+ AD=0.3948P PS=2.62U PD=2.62U
* device instance $69 r0 *1 159.46,3.53 pfet
M$69 ro3|y a|g_a|rn3|ro|s4_y|y vdd$2 vdd$2 pfet L=0.15U W=0.84U AS=0.3948P
+ AD=0.3948P PS=2.62U PD=2.62U
* device instance $70 r0 *1 214.76,3.53 pfet
M$70 ro4|y a|g_a|rn4|ro|s4_y|y vdd$3 vdd$3 pfet L=0.15U W=0.84U AS=0.3948P
+ AD=0.3948P PS=2.62U PD=2.62U
* device instance $71 r0 *1 5.775,3.74 pfet
M$71 a|g_y|mnab_y|mpa_y|mpb_y|n1|s1_a|y en|en1|g_en mpa_py|mpb_py|mph_py|py
+ g_vddr_m1|mnt_g|s1_vddr_m1|s2_vddr_m1|s3_vddr_m1|s4_vddr_m1|vddr|vddr1 pfet
+ L=0.15U W=0.84U AS=0.3948P AD=0.3948P PS=2.62U PD=2.62U
* device instance $72 r0 *1 7.065,3.74 pfet
M$72 mpa_py|mpb_py|mph_py|py a|g_a|rn1|ro|s4_y|y
+ a|g_y|mnab_y|mpa_y|mpb_y|n1|s1_a|y
+ g_vddr_m1|mnt_g|s1_vddr_m1|s2_vddr_m1|s3_vddr_m1|s4_vddr_m1|vddr|vddr1 pfet
+ L=0.15U W=0.84U AS=0.3948P AD=0.3948P PS=2.62U PD=2.62U
* device instance $73 r0 *1 15.075,3.74 pfet
M$73 a|n2|s1_y|s2_a|y a|g_y|mnab_y|mpa_y|mpb_y|n1|s1_a|y py
+ g_vddr_m1|mnt_g|s1_vddr_m1|s2_vddr_m1|s3_vddr_m1|s4_vddr_m1|vddr|vddr1 pfet
+ L=0.15U W=0.84U AS=0.3948P AD=0.3948P PS=2.62U PD=2.62U
* device instance $74 r0 *1 23.25,3.74 pfet
M$74 a|n3|s2_y|s3_a|y a|n2|s1_y|s2_a|y py$1
+ g_vddr_m1|mnt_g|s1_vddr_m1|s2_vddr_m1|s3_vddr_m1|s4_vddr_m1|vddr|vddr1 pfet
+ L=0.15U W=0.84U AS=0.3948P AD=0.3948P PS=2.62U PD=2.62U
* device instance $75 r0 *1 31.425,3.74 pfet
M$75 a|n4|s3_y|s4_a|y a|n3|s2_y|s3_a|y py$2
+ g_vddr_m1|mnt_g|s1_vddr_m1|s2_vddr_m1|s3_vddr_m1|s4_vddr_m1|vddr|vddr1 pfet
+ L=0.15U W=0.84U AS=0.3948P AD=0.3948P PS=2.62U PD=2.62U
* device instance $76 r0 *1 39.6,3.74 pfet
M$76 a|g_a|rn1|ro|s4_y|y a|n4|s3_y|s4_a|y py$3
+ g_vddr_m1|mnt_g|s1_vddr_m1|s2_vddr_m1|s3_vddr_m1|s4_vddr_m1|vddr|vddr1 pfet
+ L=0.15U W=0.84U AS=0.3948P AD=0.3948P PS=2.62U PD=2.62U
* device instance $77 r0 *1 61.075,3.74 pfet
M$77 a|g_y|mnab_y|mpa_y|mpb_y|n1|s1_a|y$1 en|en2|g_en mpa_py|mpb_py|mph_py|py$1
+ g_vddr_m1|mnt_g|s1_vddr_m1|s2_vddr_m1|s3_vddr_m1|s4_vddr_m1|vddr|vddr2 pfet
+ L=0.15U W=0.84U AS=0.3948P AD=0.3948P PS=2.62U PD=2.62U
* device instance $78 r0 *1 62.365,3.74 pfet
M$78 mpa_py|mpb_py|mph_py|py$1 a|g_a|rn2|ro|s4_y|y
+ a|g_y|mnab_y|mpa_y|mpb_y|n1|s1_a|y$1
+ g_vddr_m1|mnt_g|s1_vddr_m1|s2_vddr_m1|s3_vddr_m1|s4_vddr_m1|vddr|vddr2 pfet
+ L=0.15U W=0.84U AS=0.3948P AD=0.3948P PS=2.62U PD=2.62U
* device instance $79 r0 *1 70.375,3.74 pfet
M$79 a|n2|s1_y|s2_a|y$1 a|g_y|mnab_y|mpa_y|mpb_y|n1|s1_a|y$1 py$4
+ g_vddr_m1|mnt_g|s1_vddr_m1|s2_vddr_m1|s3_vddr_m1|s4_vddr_m1|vddr|vddr2 pfet
+ L=0.15U W=0.84U AS=0.3948P AD=0.3948P PS=2.62U PD=2.62U
* device instance $80 r0 *1 78.55,3.74 pfet
M$80 a|n3|s2_y|s3_a|y$1 a|n2|s1_y|s2_a|y$1 py$5
+ g_vddr_m1|mnt_g|s1_vddr_m1|s2_vddr_m1|s3_vddr_m1|s4_vddr_m1|vddr|vddr2 pfet
+ L=0.15U W=0.84U AS=0.3948P AD=0.3948P PS=2.62U PD=2.62U
* device instance $81 r0 *1 86.725,3.74 pfet
M$81 a|n4|s3_y|s4_a|y$1 a|n3|s2_y|s3_a|y$1 py$6
+ g_vddr_m1|mnt_g|s1_vddr_m1|s2_vddr_m1|s3_vddr_m1|s4_vddr_m1|vddr|vddr2 pfet
+ L=0.15U W=0.84U AS=0.3948P AD=0.3948P PS=2.62U PD=2.62U
* device instance $82 r0 *1 94.9,3.74 pfet
M$82 a|g_a|rn2|ro|s4_y|y a|n4|s3_y|s4_a|y$1 py$7
+ g_vddr_m1|mnt_g|s1_vddr_m1|s2_vddr_m1|s3_vddr_m1|s4_vddr_m1|vddr|vddr2 pfet
+ L=0.15U W=0.84U AS=0.3948P AD=0.3948P PS=2.62U PD=2.62U
* device instance $83 r0 *1 116.375,3.74 pfet
M$83 a|g_y|mnab_y|mpa_y|mpb_y|n1|s1_a|y$2 en|en3|g_en mpa_py|mpb_py|mph_py|py$2
+ g_vddr_m1|mnt_g|s1_vddr_m1|s2_vddr_m1|s3_vddr_m1|s4_vddr_m1|vddr|vddr3 pfet
+ L=0.15U W=0.84U AS=0.3948P AD=0.3948P PS=2.62U PD=2.62U
* device instance $84 r0 *1 117.665,3.74 pfet
M$84 mpa_py|mpb_py|mph_py|py$2 a|g_a|rn3|ro|s4_y|y
+ a|g_y|mnab_y|mpa_y|mpb_y|n1|s1_a|y$2
+ g_vddr_m1|mnt_g|s1_vddr_m1|s2_vddr_m1|s3_vddr_m1|s4_vddr_m1|vddr|vddr3 pfet
+ L=0.15U W=0.84U AS=0.3948P AD=0.3948P PS=2.62U PD=2.62U
* device instance $85 r0 *1 125.675,3.74 pfet
M$85 a|n2|s1_y|s2_a|y$2 a|g_y|mnab_y|mpa_y|mpb_y|n1|s1_a|y$2 py$8
+ g_vddr_m1|mnt_g|s1_vddr_m1|s2_vddr_m1|s3_vddr_m1|s4_vddr_m1|vddr|vddr3 pfet
+ L=0.15U W=0.84U AS=0.3948P AD=0.3948P PS=2.62U PD=2.62U
* device instance $86 r0 *1 133.85,3.74 pfet
M$86 a|n3|s2_y|s3_a|y$2 a|n2|s1_y|s2_a|y$2 py$9
+ g_vddr_m1|mnt_g|s1_vddr_m1|s2_vddr_m1|s3_vddr_m1|s4_vddr_m1|vddr|vddr3 pfet
+ L=0.15U W=0.84U AS=0.3948P AD=0.3948P PS=2.62U PD=2.62U
* device instance $87 r0 *1 142.025,3.74 pfet
M$87 a|n4|s3_y|s4_a|y$2 a|n3|s2_y|s3_a|y$2 py$10
+ g_vddr_m1|mnt_g|s1_vddr_m1|s2_vddr_m1|s3_vddr_m1|s4_vddr_m1|vddr|vddr3 pfet
+ L=0.15U W=0.84U AS=0.3948P AD=0.3948P PS=2.62U PD=2.62U
* device instance $88 r0 *1 150.2,3.74 pfet
M$88 a|g_a|rn3|ro|s4_y|y a|n4|s3_y|s4_a|y$2 py$11
+ g_vddr_m1|mnt_g|s1_vddr_m1|s2_vddr_m1|s3_vddr_m1|s4_vddr_m1|vddr|vddr3 pfet
+ L=0.15U W=0.84U AS=0.3948P AD=0.3948P PS=2.62U PD=2.62U
* device instance $89 r0 *1 171.675,3.74 pfet
M$89 a|g_y|mnab_y|mpa_y|mpb_y|n1|s1_a|y$3 en|en4|g_en mpa_py|mpb_py|mph_py|py$3
+ g_vddr_m1|mnt_g|s1_vddr_m1|s2_vddr_m1|s3_vddr_m1|s4_vddr_m1|vddr|vddr4 pfet
+ L=0.15U W=0.84U AS=0.3948P AD=0.3948P PS=2.62U PD=2.62U
* device instance $90 r0 *1 172.965,3.74 pfet
M$90 mpa_py|mpb_py|mph_py|py$3 a|g_a|rn4|ro|s4_y|y
+ a|g_y|mnab_y|mpa_y|mpb_y|n1|s1_a|y$3
+ g_vddr_m1|mnt_g|s1_vddr_m1|s2_vddr_m1|s3_vddr_m1|s4_vddr_m1|vddr|vddr4 pfet
+ L=0.15U W=0.84U AS=0.3948P AD=0.3948P PS=2.62U PD=2.62U
* device instance $91 r0 *1 180.975,3.74 pfet
M$91 a|n2|s1_y|s2_a|y$3 a|g_y|mnab_y|mpa_y|mpb_y|n1|s1_a|y$3 py$12
+ g_vddr_m1|mnt_g|s1_vddr_m1|s2_vddr_m1|s3_vddr_m1|s4_vddr_m1|vddr|vddr4 pfet
+ L=0.15U W=0.84U AS=0.3948P AD=0.3948P PS=2.62U PD=2.62U
* device instance $92 r0 *1 189.15,3.74 pfet
M$92 a|n3|s2_y|s3_a|y$3 a|n2|s1_y|s2_a|y$3 py$13
+ g_vddr_m1|mnt_g|s1_vddr_m1|s2_vddr_m1|s3_vddr_m1|s4_vddr_m1|vddr|vddr4 pfet
+ L=0.15U W=0.84U AS=0.3948P AD=0.3948P PS=2.62U PD=2.62U
* device instance $93 r0 *1 197.325,3.74 pfet
M$93 a|n4|s3_y|s4_a|y$3 a|n3|s2_y|s3_a|y$3 py$14
+ g_vddr_m1|mnt_g|s1_vddr_m1|s2_vddr_m1|s3_vddr_m1|s4_vddr_m1|vddr|vddr4 pfet
+ L=0.15U W=0.84U AS=0.3948P AD=0.3948P PS=2.62U PD=2.62U
* device instance $94 r0 *1 205.5,3.74 pfet
M$94 a|g_a|rn4|ro|s4_y|y a|n4|s3_y|s4_a|y$3 py$15
+ g_vddr_m1|mnt_g|s1_vddr_m1|s2_vddr_m1|s3_vddr_m1|s4_vddr_m1|vddr|vddr4 pfet
+ L=0.15U W=0.84U AS=0.3948P AD=0.3948P PS=2.62U PD=2.62U
* device instance $95 r0 *1 3.61,3.74 pfet
M$95 mpa_py|mpb_py|mph_py|py
+ g_vss_m1|mph_g|s1_vss_m1|s2_vss_m1|s3_vss_m1|s4_vss_m1|vss
+ g_vddr_m1|mnt_g|s1_vddr_m1|s2_vddr_m1|s3_vddr_m1|s4_vddr_m1|vddr|vddr1
+ g_vddr_m1|mnt_g|s1_vddr_m1|s2_vddr_m1|s3_vddr_m1|s4_vddr_m1|vddr|vddr1 pfet
+ L=2U W=0.42U AS=0.1764P AD=0.1764P PS=1.68U PD=1.68U
* device instance $96 r0 *1 3.445,21.225 pfet
M$96 an|inva_y|mn34_g0|mp13_g1|y a|inva_a|mn12_g0|mp13_g0 vdd$4 vdd$4 pfet
+ L=0.15U W=0.84U AS=0.3948P AD=0.3948P PS=2.62U PD=2.62U
* device instance $97 r0 *1 7.43,25.585 pfet
M$97 mid a|inva_a|mn12_g0|mp13_g0 vdd$4 vdd$4 pfet L=0.15U W=1.68U AS=0.7896P
+ AD=0.4368P PS=4.3U PD=2.2U
* device instance $98 r0 *1 8.1,25.585 pfet
M$98 y an|inva_y|mn34_g0|mp13_g1|y mid vdd$4 pfet L=0.15U W=1.68U AS=0.4368P
+ AD=0.7896P PS=2.2U PD=4.3U
* device instance $99 r0 *1 12.91,3.74 pfet
M$99 py g_vss_m1|mph_g|s1_vss_m1|s2_vss_m1|s3_vss_m1|s4_vss_m1|vss
+ g_vddr_m1|mnt_g|s1_vddr_m1|s2_vddr_m1|s3_vddr_m1|s4_vddr_m1|vddr|vddr1
+ g_vddr_m1|mnt_g|s1_vddr_m1|s2_vddr_m1|s3_vddr_m1|s4_vddr_m1|vddr|vddr1 pfet
+ L=2U W=0.42U AS=0.1764P AD=0.1764P PS=1.68U PD=1.68U
* device instance $100 r0 *1 14.58,25.585 pfet
M$100 mid bn|invb_y|mn34_g1|mp24_g1|y y vdd$4 pfet L=0.15U W=1.68U AS=0.7896P
+ AD=0.4368P PS=4.3U PD=2.2U
* device instance $101 r0 *1 15.25,25.585 pfet
M$101 vdd$4 a|b|invb_a|mn12_g1|mp24_g0 mid vdd$4 pfet L=0.15U W=1.68U
+ AS=0.4368P AD=0.7896P PS=2.2U PD=4.3U
* device instance $102 r0 *1 21.085,3.74 pfet
M$102 py$1 g_vss_m1|mph_g|s1_vss_m1|s2_vss_m1|s3_vss_m1|s4_vss_m1|vss
+ g_vddr_m1|mnt_g|s1_vddr_m1|s2_vddr_m1|s3_vddr_m1|s4_vddr_m1|vddr|vddr1
+ g_vddr_m1|mnt_g|s1_vddr_m1|s2_vddr_m1|s3_vddr_m1|s4_vddr_m1|vddr|vddr1 pfet
+ L=2U W=0.42U AS=0.1764P AD=0.1764P PS=1.68U PD=1.68U
* device instance $103 r0 *1 21.62,21.225 pfet
M$103 bn|invb_y|mn34_g1|mp24_g1|y a|b|invb_a|mn12_g1|mp24_g0 vdd$4 vdd$4 pfet
+ L=0.15U W=0.84U AS=0.3948P AD=0.3948P PS=2.62U PD=2.62U
* device instance $104 r0 *1 29.26,3.74 pfet
M$104 py$2 g_vss_m1|mph_g|s1_vss_m1|s2_vss_m1|s3_vss_m1|s4_vss_m1|vss
+ g_vddr_m1|mnt_g|s1_vddr_m1|s2_vddr_m1|s3_vddr_m1|s4_vddr_m1|vddr|vddr1
+ g_vddr_m1|mnt_g|s1_vddr_m1|s2_vddr_m1|s3_vddr_m1|s4_vddr_m1|vddr|vddr1 pfet
+ L=2U W=0.42U AS=0.1764P AD=0.1764P PS=1.68U PD=1.68U
* device instance $105 r0 *1 32.415,21.225 pfet
M$105 an|inva_y|mn34_g0|mp13_g1|y$1 a|inva_a|mn12_g0|mp13_g0$1 vdd$5 vdd$5 pfet
+ L=0.15U W=0.84U AS=0.3948P AD=0.3948P PS=2.62U PD=2.62U
* device instance $106 r0 *1 36.4,25.585 pfet
M$106 mid$1 a|inva_a|mn12_g0|mp13_g0$1 vdd$5 vdd$5 pfet L=0.15U W=1.68U
+ AS=0.7896P AD=0.4368P PS=4.3U PD=2.2U
* device instance $107 r0 *1 37.07,25.585 pfet
M$107 y$1 an|inva_y|mn34_g0|mp13_g1|y$1 mid$1 vdd$5 pfet L=0.15U W=1.68U
+ AS=0.4368P AD=0.7896P PS=2.2U PD=4.3U
* device instance $108 r0 *1 37.435,3.74 pfet
M$108 py$3 g_vss_m1|mph_g|s1_vss_m1|s2_vss_m1|s3_vss_m1|s4_vss_m1|vss
+ g_vddr_m1|mnt_g|s1_vddr_m1|s2_vddr_m1|s3_vddr_m1|s4_vddr_m1|vddr|vddr1
+ g_vddr_m1|mnt_g|s1_vddr_m1|s2_vddr_m1|s3_vddr_m1|s4_vddr_m1|vddr|vddr1 pfet
+ L=2U W=0.42U AS=0.1764P AD=0.1764P PS=1.68U PD=1.68U
* device instance $109 r0 *1 43.55,25.585 pfet
M$109 mid$1 bn|invb_y|mn34_g1|mp24_g1|y$1 y$1 vdd$5 pfet L=0.15U W=1.68U
+ AS=0.7896P AD=0.4368P PS=4.3U PD=2.2U
* device instance $110 r0 *1 44.22,25.585 pfet
M$110 vdd$5 a|b|invb_a|mn12_g1|mp24_g0$1 mid$1 vdd$5 pfet L=0.15U W=1.68U
+ AS=0.4368P AD=0.7896P PS=2.2U PD=4.3U
* device instance $111 r0 *1 50.59,21.225 pfet
M$111 bn|invb_y|mn34_g1|mp24_g1|y$1 a|b|invb_a|mn12_g1|mp24_g0$1 vdd$5 vdd$5
+ pfet L=0.15U W=0.84U AS=0.3948P AD=0.3948P PS=2.62U PD=2.62U
* device instance $112 r0 *1 58.91,3.74 pfet
M$112 mpa_py|mpb_py|mph_py|py$1
+ g_vss_m1|mph_g|s1_vss_m1|s2_vss_m1|s3_vss_m1|s4_vss_m1|vss
+ g_vddr_m1|mnt_g|s1_vddr_m1|s2_vddr_m1|s3_vddr_m1|s4_vddr_m1|vddr|vddr2
+ g_vddr_m1|mnt_g|s1_vddr_m1|s2_vddr_m1|s3_vddr_m1|s4_vddr_m1|vddr|vddr2 pfet
+ L=2U W=0.44U AS=0.1848P AD=0.1848P PS=1.72U PD=1.72U
* device instance $113 r0 *1 61.385,21.225 pfet
M$113 an|inva_y|mn34_g0|mp13_g1|y$2 a|inva_a|mn12_g0|mp13_g0$2 vdd$6 vdd$6 pfet
+ L=0.15U W=0.84U AS=0.3948P AD=0.3948P PS=2.62U PD=2.62U
* device instance $114 r0 *1 65.37,25.585 pfet
M$114 mid$2 a|inva_a|mn12_g0|mp13_g0$2 vdd$6 vdd$6 pfet L=0.15U W=1.68U
+ AS=0.7896P AD=0.4368P PS=4.3U PD=2.2U
* device instance $115 r0 *1 66.04,25.585 pfet
M$115 y$2 an|inva_y|mn34_g0|mp13_g1|y$2 mid$2 vdd$6 pfet L=0.15U W=1.68U
+ AS=0.4368P AD=0.7896P PS=2.2U PD=4.3U
* device instance $116 r0 *1 68.21,3.74 pfet
M$116 py$4 g_vss_m1|mph_g|s1_vss_m1|s2_vss_m1|s3_vss_m1|s4_vss_m1|vss
+ g_vddr_m1|mnt_g|s1_vddr_m1|s2_vddr_m1|s3_vddr_m1|s4_vddr_m1|vddr|vddr2
+ g_vddr_m1|mnt_g|s1_vddr_m1|s2_vddr_m1|s3_vddr_m1|s4_vddr_m1|vddr|vddr2 pfet
+ L=2U W=0.44U AS=0.1848P AD=0.1848P PS=1.72U PD=1.72U
* device instance $117 r0 *1 72.52,25.585 pfet
M$117 mid$2 bn|invb_y|mn34_g1|mp24_g1|y$2 y$2 vdd$6 pfet L=0.15U W=1.68U
+ AS=0.7896P AD=0.4368P PS=4.3U PD=2.2U
* device instance $118 r0 *1 73.19,25.585 pfet
M$118 vdd$6 a|b|invb_a|mn12_g1|mp24_g0$2 mid$2 vdd$6 pfet L=0.15U W=1.68U
+ AS=0.4368P AD=0.7896P PS=2.2U PD=4.3U
* device instance $119 r0 *1 76.385,3.74 pfet
M$119 py$5 g_vss_m1|mph_g|s1_vss_m1|s2_vss_m1|s3_vss_m1|s4_vss_m1|vss
+ g_vddr_m1|mnt_g|s1_vddr_m1|s2_vddr_m1|s3_vddr_m1|s4_vddr_m1|vddr|vddr2
+ g_vddr_m1|mnt_g|s1_vddr_m1|s2_vddr_m1|s3_vddr_m1|s4_vddr_m1|vddr|vddr2 pfet
+ L=2U W=0.44U AS=0.1848P AD=0.1848P PS=1.72U PD=1.72U
* device instance $120 r0 *1 79.56,21.225 pfet
M$120 bn|invb_y|mn34_g1|mp24_g1|y$2 a|b|invb_a|mn12_g1|mp24_g0$2 vdd$6 vdd$6
+ pfet L=0.15U W=0.84U AS=0.3948P AD=0.3948P PS=2.62U PD=2.62U
* device instance $121 r0 *1 84.56,3.74 pfet
M$121 py$6 g_vss_m1|mph_g|s1_vss_m1|s2_vss_m1|s3_vss_m1|s4_vss_m1|vss
+ g_vddr_m1|mnt_g|s1_vddr_m1|s2_vddr_m1|s3_vddr_m1|s4_vddr_m1|vddr|vddr2
+ g_vddr_m1|mnt_g|s1_vddr_m1|s2_vddr_m1|s3_vddr_m1|s4_vddr_m1|vddr|vddr2 pfet
+ L=2U W=0.44U AS=0.1848P AD=0.1848P PS=1.72U PD=1.72U
* device instance $122 r0 *1 92.735,3.74 pfet
M$122 py$7 g_vss_m1|mph_g|s1_vss_m1|s2_vss_m1|s3_vss_m1|s4_vss_m1|vss
+ g_vddr_m1|mnt_g|s1_vddr_m1|s2_vddr_m1|s3_vddr_m1|s4_vddr_m1|vddr|vddr2
+ g_vddr_m1|mnt_g|s1_vddr_m1|s2_vddr_m1|s3_vddr_m1|s4_vddr_m1|vddr|vddr2 pfet
+ L=2U W=0.44U AS=0.1848P AD=0.1848P PS=1.72U PD=1.72U
* device instance $123 r0 *1 114.21,3.74 pfet
M$123 mpa_py|mpb_py|mph_py|py$2
+ g_vss_m1|mph_g|s1_vss_m1|s2_vss_m1|s3_vss_m1|s4_vss_m1|vss
+ g_vddr_m1|mnt_g|s1_vddr_m1|s2_vddr_m1|s3_vddr_m1|s4_vddr_m1|vddr|vddr3
+ g_vddr_m1|mnt_g|s1_vddr_m1|s2_vddr_m1|s3_vddr_m1|s4_vddr_m1|vddr|vddr3 pfet
+ L=2U W=0.46U AS=0.1932P AD=0.1932P PS=1.76U PD=1.76U
* device instance $124 r0 *1 123.51,3.74 pfet
M$124 py$8 g_vss_m1|mph_g|s1_vss_m1|s2_vss_m1|s3_vss_m1|s4_vss_m1|vss
+ g_vddr_m1|mnt_g|s1_vddr_m1|s2_vddr_m1|s3_vddr_m1|s4_vddr_m1|vddr|vddr3
+ g_vddr_m1|mnt_g|s1_vddr_m1|s2_vddr_m1|s3_vddr_m1|s4_vddr_m1|vddr|vddr3 pfet
+ L=2U W=0.46U AS=0.1932P AD=0.1932P PS=1.76U PD=1.76U
* device instance $125 r0 *1 131.685,3.74 pfet
M$125 py$9 g_vss_m1|mph_g|s1_vss_m1|s2_vss_m1|s3_vss_m1|s4_vss_m1|vss
+ g_vddr_m1|mnt_g|s1_vddr_m1|s2_vddr_m1|s3_vddr_m1|s4_vddr_m1|vddr|vddr3
+ g_vddr_m1|mnt_g|s1_vddr_m1|s2_vddr_m1|s3_vddr_m1|s4_vddr_m1|vddr|vddr3 pfet
+ L=2U W=0.46U AS=0.1932P AD=0.1932P PS=1.76U PD=1.76U
* device instance $126 r0 *1 139.86,3.74 pfet
M$126 py$10 g_vss_m1|mph_g|s1_vss_m1|s2_vss_m1|s3_vss_m1|s4_vss_m1|vss
+ g_vddr_m1|mnt_g|s1_vddr_m1|s2_vddr_m1|s3_vddr_m1|s4_vddr_m1|vddr|vddr3
+ g_vddr_m1|mnt_g|s1_vddr_m1|s2_vddr_m1|s3_vddr_m1|s4_vddr_m1|vddr|vddr3 pfet
+ L=2U W=0.46U AS=0.1932P AD=0.1932P PS=1.76U PD=1.76U
* device instance $127 r0 *1 148.035,3.74 pfet
M$127 py$11 g_vss_m1|mph_g|s1_vss_m1|s2_vss_m1|s3_vss_m1|s4_vss_m1|vss
+ g_vddr_m1|mnt_g|s1_vddr_m1|s2_vddr_m1|s3_vddr_m1|s4_vddr_m1|vddr|vddr3
+ g_vddr_m1|mnt_g|s1_vddr_m1|s2_vddr_m1|s3_vddr_m1|s4_vddr_m1|vddr|vddr3 pfet
+ L=2U W=0.46U AS=0.1932P AD=0.1932P PS=1.76U PD=1.76U
* device instance $128 r0 *1 169.51,3.74 pfet
M$128 mpa_py|mpb_py|mph_py|py$3
+ g_vss_m1|mph_g|s1_vss_m1|s2_vss_m1|s3_vss_m1|s4_vss_m1|vss
+ g_vddr_m1|mnt_g|s1_vddr_m1|s2_vddr_m1|s3_vddr_m1|s4_vddr_m1|vddr|vddr4
+ g_vddr_m1|mnt_g|s1_vddr_m1|s2_vddr_m1|s3_vddr_m1|s4_vddr_m1|vddr|vddr4 pfet
+ L=2U W=0.48U AS=0.2016P AD=0.2016P PS=1.8U PD=1.8U
* device instance $129 r0 *1 178.81,3.74 pfet
M$129 py$12 g_vss_m1|mph_g|s1_vss_m1|s2_vss_m1|s3_vss_m1|s4_vss_m1|vss
+ g_vddr_m1|mnt_g|s1_vddr_m1|s2_vddr_m1|s3_vddr_m1|s4_vddr_m1|vddr|vddr4
+ g_vddr_m1|mnt_g|s1_vddr_m1|s2_vddr_m1|s3_vddr_m1|s4_vddr_m1|vddr|vddr4 pfet
+ L=2U W=0.48U AS=0.2016P AD=0.2016P PS=1.8U PD=1.8U
* device instance $130 r0 *1 186.985,3.74 pfet
M$130 py$13 g_vss_m1|mph_g|s1_vss_m1|s2_vss_m1|s3_vss_m1|s4_vss_m1|vss
+ g_vddr_m1|mnt_g|s1_vddr_m1|s2_vddr_m1|s3_vddr_m1|s4_vddr_m1|vddr|vddr4
+ g_vddr_m1|mnt_g|s1_vddr_m1|s2_vddr_m1|s3_vddr_m1|s4_vddr_m1|vddr|vddr4 pfet
+ L=2U W=0.48U AS=0.2016P AD=0.2016P PS=1.8U PD=1.8U
* device instance $131 r0 *1 195.16,3.74 pfet
M$131 py$14 g_vss_m1|mph_g|s1_vss_m1|s2_vss_m1|s3_vss_m1|s4_vss_m1|vss
+ g_vddr_m1|mnt_g|s1_vddr_m1|s2_vddr_m1|s3_vddr_m1|s4_vddr_m1|vddr|vddr4
+ g_vddr_m1|mnt_g|s1_vddr_m1|s2_vddr_m1|s3_vddr_m1|s4_vddr_m1|vddr|vddr4 pfet
+ L=2U W=0.48U AS=0.2016P AD=0.2016P PS=1.8U PD=1.8U
* device instance $132 r0 *1 203.335,3.74 pfet
M$132 py$15 g_vss_m1|mph_g|s1_vss_m1|s2_vss_m1|s3_vss_m1|s4_vss_m1|vss
+ g_vddr_m1|mnt_g|s1_vddr_m1|s2_vddr_m1|s3_vddr_m1|s4_vddr_m1|vddr|vddr4
+ g_vddr_m1|mnt_g|s1_vddr_m1|s2_vddr_m1|s3_vddr_m1|s4_vddr_m1|vddr|vddr4 pfet
+ L=2U W=0.48U AS=0.2016P AD=0.2016P PS=1.8U PD=1.8U
.ENDS ro_array_core_signal_poc
