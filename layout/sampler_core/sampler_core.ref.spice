* Reference netlist for sampler_core LVS -- GENERATED by layout/bin/compose-cell.py
* Source: design/sampler_core.spice .subckt sampler_core plus dependency subckt(s) sampler_dff, ro_array_core, ro_buf, xor2 plus dependency variant(s) ro_ring5_r1, ro_ring5_r2, ro_ring5_r3, ro_ring5_r4
* Only unit spellings (and any substituted subckt parameter)
* differ from the source -- see compose-cell.py's docstring.
.subckt sampler_dff d clk rst_n q vdd vss
*.ipin d
*.ipin clk
*.ipin rst_n
*.opin q
*.iopin vdd
*.iopin vss
XMpc clkb clk vdd vdd sky130_fd_pr__pfet_01v8 L=0.15u W=0.84u nf=1 ad=0.2436 as=0.2436 pd=2.26 ps=2.26
+ nrd=0.345238095238095 nrs=0.345238095238095 sa=0 sb=0 sd=0 mult=1 m=1
XMnc clkb clk vss vss sky130_fd_pr__nfet_01v8 L=0.15u W=0.42u nf=1 ad=0.1218 as=0.1218 pd=1.42 ps=1.42
+ nrd=0.69047619047619 nrs=0.69047619047619 sa=0 sb=0 sd=0 mult=1 m=1
XMtdp d clk m vdd sky130_fd_pr__pfet_01v8 L=0.15u W=0.84u nf=1 ad=0.2436 as=0.2436 pd=2.26 ps=2.26 nrd=0.345238095238095
+ nrs=0.345238095238095 sa=0 sb=0 sd=0 mult=1 m=1
XMtdn d clkb m vss sky130_fd_pr__nfet_01v8 L=0.15u W=0.42u nf=1 ad=0.1218 as=0.1218 pd=1.42 ps=1.42 nrd=0.69047619047619
+ nrs=0.69047619047619 sa=0 sb=0 sd=0 mult=1 m=1
XMimpa mb m vdd vdd sky130_fd_pr__pfet_01v8 L=0.15u W=0.84u nf=1 ad=0.2436 as=0.2436 pd=2.26 ps=2.26 nrd=0.345238095238095
+ nrs=0.345238095238095 sa=0 sb=0 sd=0 mult=1 m=1
XMimpb mb rst_n vdd vdd sky130_fd_pr__pfet_01v8 L=0.15u W=0.84u nf=1 ad=0.2436 as=0.2436 pd=2.26 ps=2.26
+ nrd=0.345238095238095 nrs=0.345238095238095 sa=0 sb=0 sd=0 mult=1 m=1
XMimna mb m mmid vss sky130_fd_pr__nfet_01v8 L=0.15u W=0.84u nf=1 ad=0.2436 as=0.2436 pd=2.26 ps=2.26
+ nrd=0.345238095238095 nrs=0.345238095238095 sa=0 sb=0 sd=0 mult=1 m=1
XMimnb mmid rst_n vss vss sky130_fd_pr__nfet_01v8 L=0.15u W=0.84u nf=1 ad=0.2436 as=0.2436 pd=2.26 ps=2.26
+ nrd=0.345238095238095 nrs=0.345238095238095 sa=0 sb=0 sd=0 mult=1 m=1
XMim2p mc mb vdd vdd sky130_fd_pr__pfet_01v8 L=0.15u W=0.84u nf=1 ad=0.2436 as=0.2436 pd=2.26 ps=2.26
+ nrd=0.345238095238095 nrs=0.345238095238095 sa=0 sb=0 sd=0 mult=1 m=1
XMim2n mc mb vss vss sky130_fd_pr__nfet_01v8 L=0.15u W=0.42u nf=1 ad=0.1218 as=0.1218 pd=1.42 ps=1.42 nrd=0.69047619047619
+ nrs=0.69047619047619 sa=0 sb=0 sd=0 mult=1 m=1
XMfmp mc clkb m vdd sky130_fd_pr__pfet_01v8 L=0.15u W=0.84u nf=1 ad=0.2436 as=0.2436 pd=2.26 ps=2.26 nrd=0.345238095238095
+ nrs=0.345238095238095 sa=0 sb=0 sd=0 mult=1 m=1
XMfmn mc clk m vss sky130_fd_pr__nfet_01v8 L=0.15u W=0.42u nf=1 ad=0.1218 as=0.1218 pd=1.42 ps=1.42 nrd=0.69047619047619
+ nrs=0.69047619047619 sa=0 sb=0 sd=0 mult=1 m=1
XMtsp mb clkb s vdd sky130_fd_pr__pfet_01v8 L=0.15u W=0.84u nf=1 ad=0.2436 as=0.2436 pd=2.26 ps=2.26 nrd=0.345238095238095
+ nrs=0.345238095238095 sa=0 sb=0 sd=0 mult=1 m=1
XMtsn mb clk s vss sky130_fd_pr__nfet_01v8 L=0.15u W=0.42u nf=1 ad=0.1218 as=0.1218 pd=1.42 ps=1.42 nrd=0.69047619047619
+ nrs=0.69047619047619 sa=0 sb=0 sd=0 mult=1 m=1
XMisp q s vdd vdd sky130_fd_pr__pfet_01v8 L=0.15u W=0.84u nf=1 ad=0.2436 as=0.2436 pd=2.26 ps=2.26 nrd=0.345238095238095
+ nrs=0.345238095238095 sa=0 sb=0 sd=0 mult=1 m=1
XMisn q s vss vss sky130_fd_pr__nfet_01v8 L=0.15u W=0.42u nf=1 ad=0.1218 as=0.1218 pd=1.42 ps=1.42 nrd=0.69047619047619
+ nrs=0.69047619047619 sa=0 sb=0 sd=0 mult=1 m=1
XMis2pa qb q vdd vdd sky130_fd_pr__pfet_01v8 L=0.15u W=0.84u nf=1 ad=0.2436 as=0.2436 pd=2.26 ps=2.26
+ nrd=0.345238095238095 nrs=0.345238095238095 sa=0 sb=0 sd=0 mult=1 m=1
XMis2pb qb rst_n vdd vdd sky130_fd_pr__pfet_01v8 L=0.15u W=0.84u nf=1 ad=0.2436 as=0.2436 pd=2.26 ps=2.26
+ nrd=0.345238095238095 nrs=0.345238095238095 sa=0 sb=0 sd=0 mult=1 m=1
XMis2na qb q s2mid vss sky130_fd_pr__nfet_01v8 L=0.15u W=0.84u nf=1 ad=0.2436 as=0.2436 pd=2.26 ps=2.26
+ nrd=0.345238095238095 nrs=0.345238095238095 sa=0 sb=0 sd=0 mult=1 m=1
XMis2nb s2mid rst_n vss vss sky130_fd_pr__nfet_01v8 L=0.15u W=0.84u nf=1 ad=0.2436 as=0.2436 pd=2.26 ps=2.26
+ nrd=0.345238095238095 nrs=0.345238095238095 sa=0 sb=0 sd=0 mult=1 m=1
XMfsp qb clk s vdd sky130_fd_pr__pfet_01v8 L=0.15u W=0.84u nf=1 ad=0.2436 as=0.2436 pd=2.26 ps=2.26 nrd=0.345238095238095
+ nrs=0.345238095238095 sa=0 sb=0 sd=0 mult=1 m=1
XMfsn qb clkb s vss sky130_fd_pr__nfet_01v8 L=0.15u W=0.42u nf=1 ad=0.1218 as=0.1218 pd=1.42 ps=1.42 nrd=0.69047619047619
+ nrs=0.69047619047619 sa=0 sb=0 sd=0 mult=1 m=1
.ends

.subckt ro_array_core en1 en2 en3 en4 vddr1 vddr2 vddr3 vddr4 vdd vss xo ro1 ro2 ro3 ro4
*.ipin en1
*.ipin en2
*.ipin en3
*.ipin en4
*.iopin vddr1
*.iopin vddr2
*.iopin vddr3
*.iopin vddr4
*.iopin vdd
*.iopin vss
*.opin xo
*.opin ro1
*.opin ro2
*.opin ro3
*.opin ro4
xr1 en1 rn1 vddr1 vss ro_ring5 wstv=0.42 lstv=2 cld=0.5f
xr2 en2 rn2 vddr2 vss ro_ring5 wstv=0.44 lstv=2 cld=0.5f
xr3 en3 rn3 vddr3 vss ro_ring5 wstv=0.46 lstv=2 cld=0.5f
xr4 en4 rn4 vddr4 vss ro_ring5 wstv=0.48 lstv=2 cld=0.5f
xb1 rn1 ro1 vdd vss ro_buf
xb2 rn2 ro2 vdd vss ro_buf
xb3 rn3 ro3 vdd vss ro_buf
xb4 rn4 ro4 vdd vss ro_buf
xa1 ro1 ro2 t1 vdd vss xor2
xa2 ro3 ro4 t2 vdd vss xor2
xa3 t1 t2 xo vdd vss xor2
.ends

.subckt ro_buf a y vdd vss
*.ipin a
*.opin y
*.iopin vdd
*.iopin vss
XMp y a vdd vdd sky130_fd_pr__pfet_01v8 L=0.15u W=0.84u nf=1 ad=0.2436 as=0.2436 pd=2.26 ps=2.26 nrd=0.345238095238095
+ nrs=0.345238095238095 sa=0 sb=0 sd=0 mult=1 m=1
XMn y a vss vss sky130_fd_pr__nfet_01v8 L=0.15u W=0.42u nf=1 ad=0.1218 as=0.1218 pd=1.42 ps=1.42 nrd=0.69047619047619
+ nrs=0.69047619047619 sa=0 sb=0 sd=0 mult=1 m=1
.ends

.subckt xor2 a b y vdd vss
*.ipin a
*.ipin b
*.opin y
*.iopin vdd
*.iopin vss
XMpiA an a vdd vdd sky130_fd_pr__pfet_01v8 L=0.15u W=0.84u nf=1 ad=0.2436 as=0.2436 pd=2.26 ps=2.26 nrd=0.345238095238095
+ nrs=0.345238095238095 sa=0 sb=0 sd=0 mult=1 m=1
XMniA an a vss vss sky130_fd_pr__nfet_01v8 L=0.15u W=0.42u nf=1 ad=0.1218 as=0.1218 pd=1.42 ps=1.42 nrd=0.69047619047619
+ nrs=0.69047619047619 sa=0 sb=0 sd=0 mult=1 m=1
XMpiB bn b vdd vdd sky130_fd_pr__pfet_01v8 L=0.15u W=0.84u nf=1 ad=0.2436 as=0.2436 pd=2.26 ps=2.26 nrd=0.345238095238095
+ nrs=0.345238095238095 sa=0 sb=0 sd=0 mult=1 m=1
XMniB bn b vss vss sky130_fd_pr__nfet_01v8 L=0.15u W=0.42u nf=1 ad=0.1218 as=0.1218 pd=1.42 ps=1.42 nrd=0.69047619047619
+ nrs=0.69047619047619 sa=0 sb=0 sd=0 mult=1 m=1
XMp1 mid a vdd vdd sky130_fd_pr__pfet_01v8 L=0.15u W=1.68u nf=1 ad=0.4872 as=0.4872 pd=3.94 ps=3.94 nrd=0.172619047619048
+ nrs=0.172619047619048 sa=0 sb=0 sd=0 mult=1 m=1
XMp2 mid b vdd vdd sky130_fd_pr__pfet_01v8 L=0.15u W=1.68u nf=1 ad=0.4872 as=0.4872 pd=3.94 ps=3.94 nrd=0.172619047619048
+ nrs=0.172619047619048 sa=0 sb=0 sd=0 mult=1 m=1
XMp3 y an mid vdd sky130_fd_pr__pfet_01v8 L=0.15u W=1.68u nf=1 ad=0.4872 as=0.4872 pd=3.94 ps=3.94 nrd=0.172619047619048
+ nrs=0.172619047619048 sa=0 sb=0 sd=0 mult=1 m=1
XMp4 y bn mid vdd sky130_fd_pr__pfet_01v8 L=0.15u W=1.68u nf=1 ad=0.4872 as=0.4872 pd=3.94 ps=3.94 nrd=0.172619047619048
+ nrs=0.172619047619048 sa=0 sb=0 sd=0 mult=1 m=1
XMn1 y a s1 vss sky130_fd_pr__nfet_01v8 L=0.15u W=0.84u nf=1 ad=0.2436 as=0.2436 pd=2.26 ps=2.26 nrd=0.345238095238095
+ nrs=0.345238095238095 sa=0 sb=0 sd=0 mult=1 m=1
XMn2 s1 b vss vss sky130_fd_pr__nfet_01v8 L=0.15u W=0.84u nf=1 ad=0.2436 as=0.2436 pd=2.26 ps=2.26 nrd=0.345238095238095
+ nrs=0.345238095238095 sa=0 sb=0 sd=0 mult=1 m=1
XMn3 y an s2 vss sky130_fd_pr__nfet_01v8 L=0.15u W=0.84u nf=1 ad=0.2436 as=0.2436 pd=2.26 ps=2.26 nrd=0.345238095238095
+ nrs=0.345238095238095 sa=0 sb=0 sd=0 mult=1 m=1
XMn4 s2 bn vss vss sky130_fd_pr__nfet_01v8 L=0.15u W=0.84u nf=1 ad=0.2436 as=0.2436 pd=2.26 ps=2.26 nrd=0.345238095238095
+ nrs=0.345238095238095 sa=0 sb=0 sd=0 mult=1 m=1
.ends

.subckt ro_nand2_r1 a en y vddr vss
*.ipin a
*.ipin en
*.opin y
*.iopin vddr
*.iopin vss
XMph py vss vddr vddr sky130_fd_pr__pfet_01v8 L=2u W=0.42u nf=1 ad='int((1 + 1)/2) * wstv / 1 * 0.29'
+ as='int((1 + 2)/2) * wstv / 1 * 0.29' pd='2*int((1 + 1)/2) * (wstv / 1 + 0.29)'
+ ps='2*int((1 + 2)/2) * (wstv / 1 + 0.29)' nrd='0.29 / wstv ' nrs='0.29 / wstv ' sa=0 sb=0 sd=0 mult=1 m=1
XMpa y a py vddr sky130_fd_pr__pfet_01v8 L=0.15u W=0.84u nf=1 ad=0.2436 as=0.2436 pd=2.26 ps=2.26 nrd=0.345238095238095
+ nrs=0.345238095238095 sa=0 sb=0 sd=0 mult=1 m=1
XMpb y en py vddr sky130_fd_pr__pfet_01v8 L=0.15u W=0.84u nf=1 ad=0.2436 as=0.2436 pd=2.26 ps=2.26 nrd=0.345238095238095
+ nrs=0.345238095238095 sa=0 sb=0 sd=0 mult=1 m=1
XMna y a nm vss sky130_fd_pr__nfet_01v8 L=0.15u W=0.84u nf=1 ad=0.2436 as=0.2436 pd=2.26 ps=2.26 nrd=0.345238095238095
+ nrs=0.345238095238095 sa=0 sb=0 sd=0 mult=1 m=1
XMnb nm en ny vss sky130_fd_pr__nfet_01v8 L=0.15u W=0.84u nf=1 ad=0.2436 as=0.2436 pd=2.26 ps=2.26 nrd=0.345238095238095
+ nrs=0.345238095238095 sa=0 sb=0 sd=0 mult=1 m=1
XMnt ny vddr vss vss sky130_fd_pr__nfet_01v8 L=2u W=0.42u nf=1 ad='int((1 + 1)/2) * wstv / 1 * 0.29'
+ as='int((1 + 2)/2) * wstv / 1 * 0.29' pd='2*int((1 + 1)/2) * (wstv / 1 + 0.29)'
+ ps='2*int((1 + 2)/2) * (wstv / 1 + 0.29)' nrd='0.29 / wstv ' nrs='0.29 / wstv ' sa=0 sb=0 sd=0 mult=1 m=1
.ends

.subckt ro_stage_r1 a y vddr vss
*.ipin a
*.opin y
*.iopin vddr
*.iopin vss
XMph py vss vddr vddr sky130_fd_pr__pfet_01v8 L=2u W=0.42u nf=1 ad='int((1 + 1)/2) * wstv / 1 * 0.29'
+ as='int((1 + 2)/2) * wstv / 1 * 0.29' pd='2*int((1 + 1)/2) * (wstv / 1 + 0.29)'
+ ps='2*int((1 + 2)/2) * (wstv / 1 + 0.29)' nrd='0.29 / wstv ' nrs='0.29 / wstv ' sa=0 sb=0 sd=0 mult=1 m=1
XMp y a py vddr sky130_fd_pr__pfet_01v8 L=0.15u W=0.84u nf=1 ad=0.2436 as=0.2436 pd=2.26 ps=2.26 nrd=0.345238095238095
+ nrs=0.345238095238095 sa=0 sb=0 sd=0 mult=1 m=1
XMn y a ny vss sky130_fd_pr__nfet_01v8 L=0.15u W=0.42u nf=1 ad=0.1218 as=0.1218 pd=1.42 ps=1.42 nrd=0.69047619047619
+ nrs=0.69047619047619 sa=0 sb=0 sd=0 mult=1 m=1
XMnt ny vddr vss vss sky130_fd_pr__nfet_01v8 L=2u W=0.42u nf=1 ad='int((1 + 1)/2) * wstv / 1 * 0.29'
+ as='int((1 + 2)/2) * wstv / 1 * 0.29' pd='2*int((1 + 1)/2) * (wstv / 1 + 0.29)'
+ ps='2*int((1 + 2)/2) * (wstv / 1 + 0.29)' nrd='0.29 / wstv ' nrs='0.29 / wstv ' sa=0 sb=0 sd=0 mult=1 m=1
.ends

.subckt ro_ring5_r1 en ro vddr vss
*.ipin en
*.opin ro
*.iopin vddr
*.iopin vss
xg ro en n1 vddr vss ro_nand2_r1
x1 n1 n2 vddr vss ro_stage_r1
x2 n2 n3 vddr vss ro_stage_r1
x3 n3 n4 vddr vss ro_stage_r1
x4 n4 ro vddr vss ro_stage_r1
.ends

.subckt ro_nand2_r2 a en y vddr vss
*.ipin a
*.ipin en
*.opin y
*.iopin vddr
*.iopin vss
XMph py vss vddr vddr sky130_fd_pr__pfet_01v8 L=2u W=0.44u nf=1 ad='int((1 + 1)/2) * wstv / 1 * 0.29'
+ as='int((1 + 2)/2) * wstv / 1 * 0.29' pd='2*int((1 + 1)/2) * (wstv / 1 + 0.29)'
+ ps='2*int((1 + 2)/2) * (wstv / 1 + 0.29)' nrd='0.29 / wstv ' nrs='0.29 / wstv ' sa=0 sb=0 sd=0 mult=1 m=1
XMpa y a py vddr sky130_fd_pr__pfet_01v8 L=0.15u W=0.84u nf=1 ad=0.2436 as=0.2436 pd=2.26 ps=2.26 nrd=0.345238095238095
+ nrs=0.345238095238095 sa=0 sb=0 sd=0 mult=1 m=1
XMpb y en py vddr sky130_fd_pr__pfet_01v8 L=0.15u W=0.84u nf=1 ad=0.2436 as=0.2436 pd=2.26 ps=2.26 nrd=0.345238095238095
+ nrs=0.345238095238095 sa=0 sb=0 sd=0 mult=1 m=1
XMna y a nm vss sky130_fd_pr__nfet_01v8 L=0.15u W=0.84u nf=1 ad=0.2436 as=0.2436 pd=2.26 ps=2.26 nrd=0.345238095238095
+ nrs=0.345238095238095 sa=0 sb=0 sd=0 mult=1 m=1
XMnb nm en ny vss sky130_fd_pr__nfet_01v8 L=0.15u W=0.84u nf=1 ad=0.2436 as=0.2436 pd=2.26 ps=2.26 nrd=0.345238095238095
+ nrs=0.345238095238095 sa=0 sb=0 sd=0 mult=1 m=1
XMnt ny vddr vss vss sky130_fd_pr__nfet_01v8 L=2u W=0.44u nf=1 ad='int((1 + 1)/2) * wstv / 1 * 0.29'
+ as='int((1 + 2)/2) * wstv / 1 * 0.29' pd='2*int((1 + 1)/2) * (wstv / 1 + 0.29)'
+ ps='2*int((1 + 2)/2) * (wstv / 1 + 0.29)' nrd='0.29 / wstv ' nrs='0.29 / wstv ' sa=0 sb=0 sd=0 mult=1 m=1
.ends

.subckt ro_stage_r2 a y vddr vss
*.ipin a
*.opin y
*.iopin vddr
*.iopin vss
XMph py vss vddr vddr sky130_fd_pr__pfet_01v8 L=2u W=0.44u nf=1 ad='int((1 + 1)/2) * wstv / 1 * 0.29'
+ as='int((1 + 2)/2) * wstv / 1 * 0.29' pd='2*int((1 + 1)/2) * (wstv / 1 + 0.29)'
+ ps='2*int((1 + 2)/2) * (wstv / 1 + 0.29)' nrd='0.29 / wstv ' nrs='0.29 / wstv ' sa=0 sb=0 sd=0 mult=1 m=1
XMp y a py vddr sky130_fd_pr__pfet_01v8 L=0.15u W=0.84u nf=1 ad=0.2436 as=0.2436 pd=2.26 ps=2.26 nrd=0.345238095238095
+ nrs=0.345238095238095 sa=0 sb=0 sd=0 mult=1 m=1
XMn y a ny vss sky130_fd_pr__nfet_01v8 L=0.15u W=0.42u nf=1 ad=0.1218 as=0.1218 pd=1.42 ps=1.42 nrd=0.69047619047619
+ nrs=0.69047619047619 sa=0 sb=0 sd=0 mult=1 m=1
XMnt ny vddr vss vss sky130_fd_pr__nfet_01v8 L=2u W=0.44u nf=1 ad='int((1 + 1)/2) * wstv / 1 * 0.29'
+ as='int((1 + 2)/2) * wstv / 1 * 0.29' pd='2*int((1 + 1)/2) * (wstv / 1 + 0.29)'
+ ps='2*int((1 + 2)/2) * (wstv / 1 + 0.29)' nrd='0.29 / wstv ' nrs='0.29 / wstv ' sa=0 sb=0 sd=0 mult=1 m=1
.ends

.subckt ro_ring5_r2 en ro vddr vss
*.ipin en
*.opin ro
*.iopin vddr
*.iopin vss
xg ro en n1 vddr vss ro_nand2_r2
x1 n1 n2 vddr vss ro_stage_r2
x2 n2 n3 vddr vss ro_stage_r2
x3 n3 n4 vddr vss ro_stage_r2
x4 n4 ro vddr vss ro_stage_r2
.ends

.subckt ro_nand2_r3 a en y vddr vss
*.ipin a
*.ipin en
*.opin y
*.iopin vddr
*.iopin vss
XMph py vss vddr vddr sky130_fd_pr__pfet_01v8 L=2u W=0.46u nf=1 ad='int((1 + 1)/2) * wstv / 1 * 0.29'
+ as='int((1 + 2)/2) * wstv / 1 * 0.29' pd='2*int((1 + 1)/2) * (wstv / 1 + 0.29)'
+ ps='2*int((1 + 2)/2) * (wstv / 1 + 0.29)' nrd='0.29 / wstv ' nrs='0.29 / wstv ' sa=0 sb=0 sd=0 mult=1 m=1
XMpa y a py vddr sky130_fd_pr__pfet_01v8 L=0.15u W=0.84u nf=1 ad=0.2436 as=0.2436 pd=2.26 ps=2.26 nrd=0.345238095238095
+ nrs=0.345238095238095 sa=0 sb=0 sd=0 mult=1 m=1
XMpb y en py vddr sky130_fd_pr__pfet_01v8 L=0.15u W=0.84u nf=1 ad=0.2436 as=0.2436 pd=2.26 ps=2.26 nrd=0.345238095238095
+ nrs=0.345238095238095 sa=0 sb=0 sd=0 mult=1 m=1
XMna y a nm vss sky130_fd_pr__nfet_01v8 L=0.15u W=0.84u nf=1 ad=0.2436 as=0.2436 pd=2.26 ps=2.26 nrd=0.345238095238095
+ nrs=0.345238095238095 sa=0 sb=0 sd=0 mult=1 m=1
XMnb nm en ny vss sky130_fd_pr__nfet_01v8 L=0.15u W=0.84u nf=1 ad=0.2436 as=0.2436 pd=2.26 ps=2.26 nrd=0.345238095238095
+ nrs=0.345238095238095 sa=0 sb=0 sd=0 mult=1 m=1
XMnt ny vddr vss vss sky130_fd_pr__nfet_01v8 L=2u W=0.46u nf=1 ad='int((1 + 1)/2) * wstv / 1 * 0.29'
+ as='int((1 + 2)/2) * wstv / 1 * 0.29' pd='2*int((1 + 1)/2) * (wstv / 1 + 0.29)'
+ ps='2*int((1 + 2)/2) * (wstv / 1 + 0.29)' nrd='0.29 / wstv ' nrs='0.29 / wstv ' sa=0 sb=0 sd=0 mult=1 m=1
.ends

.subckt ro_stage_r3 a y vddr vss
*.ipin a
*.opin y
*.iopin vddr
*.iopin vss
XMph py vss vddr vddr sky130_fd_pr__pfet_01v8 L=2u W=0.46u nf=1 ad='int((1 + 1)/2) * wstv / 1 * 0.29'
+ as='int((1 + 2)/2) * wstv / 1 * 0.29' pd='2*int((1 + 1)/2) * (wstv / 1 + 0.29)'
+ ps='2*int((1 + 2)/2) * (wstv / 1 + 0.29)' nrd='0.29 / wstv ' nrs='0.29 / wstv ' sa=0 sb=0 sd=0 mult=1 m=1
XMp y a py vddr sky130_fd_pr__pfet_01v8 L=0.15u W=0.84u nf=1 ad=0.2436 as=0.2436 pd=2.26 ps=2.26 nrd=0.345238095238095
+ nrs=0.345238095238095 sa=0 sb=0 sd=0 mult=1 m=1
XMn y a ny vss sky130_fd_pr__nfet_01v8 L=0.15u W=0.42u nf=1 ad=0.1218 as=0.1218 pd=1.42 ps=1.42 nrd=0.69047619047619
+ nrs=0.69047619047619 sa=0 sb=0 sd=0 mult=1 m=1
XMnt ny vddr vss vss sky130_fd_pr__nfet_01v8 L=2u W=0.46u nf=1 ad='int((1 + 1)/2) * wstv / 1 * 0.29'
+ as='int((1 + 2)/2) * wstv / 1 * 0.29' pd='2*int((1 + 1)/2) * (wstv / 1 + 0.29)'
+ ps='2*int((1 + 2)/2) * (wstv / 1 + 0.29)' nrd='0.29 / wstv ' nrs='0.29 / wstv ' sa=0 sb=0 sd=0 mult=1 m=1
.ends

.subckt ro_ring5_r3 en ro vddr vss
*.ipin en
*.opin ro
*.iopin vddr
*.iopin vss
xg ro en n1 vddr vss ro_nand2_r3
x1 n1 n2 vddr vss ro_stage_r3
x2 n2 n3 vddr vss ro_stage_r3
x3 n3 n4 vddr vss ro_stage_r3
x4 n4 ro vddr vss ro_stage_r3
.ends

.subckt ro_nand2_r4 a en y vddr vss
*.ipin a
*.ipin en
*.opin y
*.iopin vddr
*.iopin vss
XMph py vss vddr vddr sky130_fd_pr__pfet_01v8 L=2u W=0.48u nf=1 ad='int((1 + 1)/2) * wstv / 1 * 0.29'
+ as='int((1 + 2)/2) * wstv / 1 * 0.29' pd='2*int((1 + 1)/2) * (wstv / 1 + 0.29)'
+ ps='2*int((1 + 2)/2) * (wstv / 1 + 0.29)' nrd='0.29 / wstv ' nrs='0.29 / wstv ' sa=0 sb=0 sd=0 mult=1 m=1
XMpa y a py vddr sky130_fd_pr__pfet_01v8 L=0.15u W=0.84u nf=1 ad=0.2436 as=0.2436 pd=2.26 ps=2.26 nrd=0.345238095238095
+ nrs=0.345238095238095 sa=0 sb=0 sd=0 mult=1 m=1
XMpb y en py vddr sky130_fd_pr__pfet_01v8 L=0.15u W=0.84u nf=1 ad=0.2436 as=0.2436 pd=2.26 ps=2.26 nrd=0.345238095238095
+ nrs=0.345238095238095 sa=0 sb=0 sd=0 mult=1 m=1
XMna y a nm vss sky130_fd_pr__nfet_01v8 L=0.15u W=0.84u nf=1 ad=0.2436 as=0.2436 pd=2.26 ps=2.26 nrd=0.345238095238095
+ nrs=0.345238095238095 sa=0 sb=0 sd=0 mult=1 m=1
XMnb nm en ny vss sky130_fd_pr__nfet_01v8 L=0.15u W=0.84u nf=1 ad=0.2436 as=0.2436 pd=2.26 ps=2.26 nrd=0.345238095238095
+ nrs=0.345238095238095 sa=0 sb=0 sd=0 mult=1 m=1
XMnt ny vddr vss vss sky130_fd_pr__nfet_01v8 L=2u W=0.48u nf=1 ad='int((1 + 1)/2) * wstv / 1 * 0.29'
+ as='int((1 + 2)/2) * wstv / 1 * 0.29' pd='2*int((1 + 1)/2) * (wstv / 1 + 0.29)'
+ ps='2*int((1 + 2)/2) * (wstv / 1 + 0.29)' nrd='0.29 / wstv ' nrs='0.29 / wstv ' sa=0 sb=0 sd=0 mult=1 m=1
.ends

.subckt ro_stage_r4 a y vddr vss
*.ipin a
*.opin y
*.iopin vddr
*.iopin vss
XMph py vss vddr vddr sky130_fd_pr__pfet_01v8 L=2u W=0.48u nf=1 ad='int((1 + 1)/2) * wstv / 1 * 0.29'
+ as='int((1 + 2)/2) * wstv / 1 * 0.29' pd='2*int((1 + 1)/2) * (wstv / 1 + 0.29)'
+ ps='2*int((1 + 2)/2) * (wstv / 1 + 0.29)' nrd='0.29 / wstv ' nrs='0.29 / wstv ' sa=0 sb=0 sd=0 mult=1 m=1
XMp y a py vddr sky130_fd_pr__pfet_01v8 L=0.15u W=0.84u nf=1 ad=0.2436 as=0.2436 pd=2.26 ps=2.26 nrd=0.345238095238095
+ nrs=0.345238095238095 sa=0 sb=0 sd=0 mult=1 m=1
XMn y a ny vss sky130_fd_pr__nfet_01v8 L=0.15u W=0.42u nf=1 ad=0.1218 as=0.1218 pd=1.42 ps=1.42 nrd=0.69047619047619
+ nrs=0.69047619047619 sa=0 sb=0 sd=0 mult=1 m=1
XMnt ny vddr vss vss sky130_fd_pr__nfet_01v8 L=2u W=0.48u nf=1 ad='int((1 + 1)/2) * wstv / 1 * 0.29'
+ as='int((1 + 2)/2) * wstv / 1 * 0.29' pd='2*int((1 + 1)/2) * (wstv / 1 + 0.29)'
+ ps='2*int((1 + 2)/2) * (wstv / 1 + 0.29)' nrd='0.29 / wstv ' nrs='0.29 / wstv ' sa=0 sb=0 sd=0 mult=1 m=1
.ends

.subckt ro_ring5_r4 en ro vddr vss
*.ipin en
*.opin ro
*.iopin vddr
*.iopin vss
xg ro en n1 vddr vss ro_nand2_r4
x1 n1 n2 vddr vss ro_stage_r4
x2 n2 n3 vddr vss ro_stage_r4
x3 n3 n4 vddr vss ro_stage_r4
x4 n4 ro vddr vss ro_stage_r4
.ends

.subckt sampler_core en1 en2 en3 en4 vddr1 vddr2 vddr3 vddr4 vdd vss clk rst_n raw_bit raw_valid ring_bit1 ring_bit2
+ ring_bit3 ring_bit4
*.ipin en1
*.ipin en2
*.ipin en3
*.ipin en4
*.iopin vddr1
*.iopin vddr2
*.iopin vddr3
*.iopin vddr4
*.iopin vdd
*.iopin vss
*.ipin clk
*.ipin rst_n
*.opin raw_bit
*.opin raw_valid
*.opin ring_bit1
*.opin ring_bit2
*.opin ring_bit3
*.opin ring_bit4
xdut en1 en2 en3 en4 vddr1 vddr2 vddr3 vddr4 vdd vss xo ro1 ro2 ro3 ro4 ro_array_core
xsb xo clk rst_n raw_bit vdd vss sampler_dff
xsv vdd clk rst_n raw_valid vdd vss sampler_dff
xsr1 ro1 clk rst_n ring_bit1 vdd vss sampler_dff
xsr2 ro2 clk rst_n ring_bit2 vdd vss sampler_dff
xsr3 ro3 clk rst_n ring_bit3 vdd vss sampler_dff
xsr4 ro4 clk rst_n ring_bit4 vdd vss sampler_dff
.ends
