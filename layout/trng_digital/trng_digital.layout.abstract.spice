* extracted by klt extract --deck sky130

* cell trng_digital
* pin VGND
* pin VPWR
* pin alarm
* pin bus_addr[0]
* pin bus_addr[1]
* pin bus_addr[2]
* pin bus_addr[3]
* pin bus_rdata_r[0]
* pin bus_rdata_r[10]
* pin bus_rdata_r[11]
* pin bus_rdata_r[12]
* pin bus_rdata_r[13]
* pin bus_rdata_r[14]
* pin bus_rdata_r[15]
* pin bus_rdata_r[16]
* pin bus_rdata_r[17]
* pin bus_rdata_r[18]
* pin bus_rdata_r[19]
* pin bus_rdata_r[1]
* pin bus_rdata_r[20]
* pin bus_rdata_r[21]
* pin bus_rdata_r[22]
* pin bus_rdata_r[23]
* pin bus_rdata_r[24]
* pin bus_rdata_r[25]
* pin bus_rdata_r[26]
* pin bus_rdata_r[27]
* pin bus_rdata_r[28]
* pin bus_rdata_r[29]
* pin bus_rdata_r[2]
* pin bus_rdata_r[30]
* pin bus_rdata_r[31]
* pin bus_rdata_r[3]
* pin bus_rdata_r[4]
* pin bus_rdata_r[5]
* pin bus_rdata_r[6]
* pin bus_rdata_r[7]
* pin bus_rdata_r[8]
* pin bus_rdata_r[9]
* pin bus_re
* pin bus_wdata[0]
* pin bus_wdata[1]
* pin bus_wdata[2]
* pin bus_we
* pin clk
* pin gated
* pin out_data[0]
* pin out_data[10]
* pin out_data[11]
* pin out_data[12]
* pin out_data[13]
* pin out_data[14]
* pin out_data[15]
* pin out_data[16]
* pin out_data[17]
* pin out_data[18]
* pin out_data[19]
* pin out_data[1]
* pin out_data[20]
* pin out_data[21]
* pin out_data[22]
* pin out_data[23]
* pin out_data[24]
* pin out_data[25]
* pin out_data[26]
* pin out_data[27]
* pin out_data[28]
* pin out_data[29]
* pin out_data[2]
* pin out_data[30]
* pin out_data[31]
* pin out_data[3]
* pin out_data[4]
* pin out_data[5]
* pin out_data[6]
* pin out_data[7]
* pin out_data[8]
* pin out_data[9]
* pin out_ready
* pin out_valid
* pin raw_bit
* pin raw_valid
* pin rst_n
* pin startup_done_r
* pin bus_wdata[10]
* pin bus_wdata[11]
* pin bus_wdata[12]
* pin bus_wdata[13]
* pin bus_wdata[14]
* pin bus_wdata[15]
* pin bus_wdata[16]
* pin bus_wdata[17]
* pin bus_wdata[18]
* pin bus_wdata[19]
* pin bus_wdata[20]
* pin bus_wdata[21]
* pin bus_wdata[22]
* pin bus_wdata[23]
* pin bus_wdata[24]
* pin bus_wdata[25]
* pin bus_wdata[26]
* pin bus_wdata[27]
* pin bus_wdata[28]
* pin bus_wdata[29]
* pin bus_wdata[30]
* pin bus_wdata[31]
* pin bus_wdata[3]
* pin bus_wdata[4]
* pin bus_wdata[5]
* pin bus_wdata[6]
* pin bus_wdata[7]
* pin bus_wdata[8]
* pin bus_wdata[9]
.SUBCKT trng_digital VGND VPWR alarm bus_addr[0] bus_addr[1] bus_addr[2]
+ bus_addr[3] bus_rdata_r[0] bus_rdata_r[10] bus_rdata_r[11] bus_rdata_r[12]
+ bus_rdata_r[13] bus_rdata_r[14] bus_rdata_r[15] bus_rdata_r[16]
+ bus_rdata_r[17] bus_rdata_r[18] bus_rdata_r[19] bus_rdata_r[1]
+ bus_rdata_r[20] bus_rdata_r[21] bus_rdata_r[22] bus_rdata_r[23]
+ bus_rdata_r[24] bus_rdata_r[25] bus_rdata_r[26] bus_rdata_r[27]
+ bus_rdata_r[28] bus_rdata_r[29] bus_rdata_r[2] bus_rdata_r[30]
+ bus_rdata_r[31] bus_rdata_r[3] bus_rdata_r[4] bus_rdata_r[5] bus_rdata_r[6]
+ bus_rdata_r[7] bus_rdata_r[8] bus_rdata_r[9] bus_re bus_wdata[0] bus_wdata[1]
+ bus_wdata[2] bus_we clk gated out_data[0] out_data[10] out_data[11]
+ out_data[12] out_data[13] out_data[14] out_data[15] out_data[16] out_data[17]
+ out_data[18] out_data[19] out_data[1] out_data[20] out_data[21] out_data[22]
+ out_data[23] out_data[24] out_data[25] out_data[26] out_data[27] out_data[28]
+ out_data[29] out_data[2] out_data[30] out_data[31] out_data[3] out_data[4]
+ out_data[5] out_data[6] out_data[7] out_data[8] out_data[9] out_ready
+ out_valid raw_bit raw_valid rst_n startup_done_r bus_wdata[10] bus_wdata[11]
+ bus_wdata[12] bus_wdata[13] bus_wdata[14] bus_wdata[15] bus_wdata[16]
+ bus_wdata[17] bus_wdata[18] bus_wdata[19] bus_wdata[20] bus_wdata[21]
+ bus_wdata[22] bus_wdata[23] bus_wdata[24] bus_wdata[25] bus_wdata[26]
+ bus_wdata[27] bus_wdata[28] bus_wdata[29] bus_wdata[30] bus_wdata[31]
+ bus_wdata[3] bus_wdata[4] bus_wdata[5] bus_wdata[6] bus_wdata[7] bus_wdata[8]
+ bus_wdata[9]
* cell instance sky130_fd_sc_hd__a211oi_1_0 r0 *1 0,0
Xsky130_fd_sc_hd__a211oi_1_0 \_0479_ \_0509_ \_0524_ \_0408_ VGND VPWR VPWR
+ \_0026_[3] sky130_fd_sc_hd__a211oi_1
* cell instance sky130_fd_sc_hd__a21o_1_0 r0 *1 0,0
Xsky130_fd_sc_hd__a21o_1_0 \_0774_ \_0778_ \_0782_ VGND VPWR VPWR \_0790_
+ sky130_fd_sc_hd__a21o_1
* cell instance sky130_fd_sc_hd__a21o_1_1 r0 *1 0,0
Xsky130_fd_sc_hd__a21o_1_1 cond_count[12] \_0207_ cond_count[13] VGND VPWR VPWR
+ \_0214_ sky130_fd_sc_hd__a21o_1
* cell instance sky130_fd_sc_hd__a21o_1_2 r0 *1 0,0
Xsky130_fd_sc_hd__a21o_1_2 apt_matches[9] \_0332_ apt_matches[10] VGND VPWR
+ VPWR \_0359_ sky130_fd_sc_hd__a21o_1
* cell instance sky130_fd_sc_hd__a21oi_1_0 r0 *1 0,0
Xsky130_fd_sc_hd__a21oi_1_0 raw_mem[1][8] \_0802_ \_0917_ VGND VPWR VPWR
+ \_0918_ sky130_fd_sc_hd__a21oi_1
* cell instance sky130_fd_sc_hd__a21oi_1_1 r0 *1 0,0
Xsky130_fd_sc_hd__a21oi_1_1 raw_mem[0][25] \_0797_ \_0838_ VGND VPWR VPWR
+ \_0839_ sky130_fd_sc_hd__a21oi_1
* cell instance sky130_fd_sc_hd__a21oi_1_2 r0 *1 0,0
Xsky130_fd_sc_hd__a21oi_1_2 raw_mem[2][25] net33 \_0979_ VGND VPWR VPWR \_0980_
+ sky130_fd_sc_hd__a21oi_1
* cell instance sky130_fd_sc_hd__a21oi_1_3 r0 *1 0,0
Xsky130_fd_sc_hd__a21oi_1_3 raw_mem[1][25] \_0802_ \_0840_ VGND VPWR VPWR
+ \_0841_ sky130_fd_sc_hd__a21oi_1
* cell instance sky130_fd_sc_hd__a21oi_1_4 r0 *1 0,0
Xsky130_fd_sc_hd__a21oi_1_4 raw_mem[0][19] \_0797_ \_0865_ VGND VPWR VPWR
+ \_0866_ sky130_fd_sc_hd__a21oi_1
* cell instance sky130_fd_sc_hd__a21oi_1_5 r0 *1 0,0
Xsky130_fd_sc_hd__a21oi_1_5 raw_mem[1][19] \_0802_ \_0867_ VGND VPWR VPWR
+ \_0868_ sky130_fd_sc_hd__a21oi_1
* cell instance sky130_fd_sc_hd__a21oi_1_6 r0 *1 0,0
Xsky130_fd_sc_hd__a21oi_1_6 raw_mem[0][8] \_0797_ \_0915_ VGND VPWR VPWR
+ \_0916_ sky130_fd_sc_hd__a21oi_1
* cell instance sky130_fd_sc_hd__a21oi_1_7 r0 *1 0,0
Xsky130_fd_sc_hd__a21oi_1_7 raw_mem[0][29] \_0797_ \_0817_ VGND VPWR VPWR
+ \_0818_ sky130_fd_sc_hd__a21oi_1
* cell instance sky130_fd_sc_hd__a21oi_1_8 r0 *1 0,0
Xsky130_fd_sc_hd__a21oi_1_8 raw_mem[0][24] \_0797_ \_0843_ VGND VPWR VPWR
+ \_0844_ sky130_fd_sc_hd__a21oi_1
* cell instance sky130_fd_sc_hd__a21oi_1_9 r0 *1 0,0
Xsky130_fd_sc_hd__a21oi_1_9 raw_mem[2][19] net33 \_0991_ VGND VPWR VPWR \_0992_
+ sky130_fd_sc_hd__a21oi_1
* cell instance sky130_fd_sc_hd__a21oi_1_10 r0 *1 0,0
Xsky130_fd_sc_hd__a21oi_1_10 raw_mem[0][31] \_0797_ \_1296_ VGND VPWR VPWR
+ \_1297_ sky130_fd_sc_hd__a21oi_1
* cell instance sky130_fd_sc_hd__a21oi_1_11 r0 *1 0,0
Xsky130_fd_sc_hd__a21oi_1_11 raw_mem[1][29] \_0802_ \_0820_ VGND VPWR VPWR
+ \_0821_ sky130_fd_sc_hd__a21oi_1
* cell instance sky130_fd_sc_hd__a21oi_1_12 r0 *1 0,0
Xsky130_fd_sc_hd__a21oi_1_12 bus_rdata_r[8] net36 \_1364_ VGND VPWR VPWR
+ \_1365_ sky130_fd_sc_hd__a21oi_1
* cell instance sky130_fd_sc_hd__a21oi_1_13 r0 *1 0,0
Xsky130_fd_sc_hd__a21oi_1_13 raw_mem[1][24] \_0802_ \_0846_ VGND VPWR VPWR
+ \_0847_ sky130_fd_sc_hd__a21oi_1
* cell instance sky130_fd_sc_hd__a21oi_1_14 r0 *1 0,0
Xsky130_fd_sc_hd__a21oi_1_14 raw_mem[2][29] net33 \_0969_ VGND VPWR VPWR
+ \_0970_ sky130_fd_sc_hd__a21oi_1
* cell instance sky130_fd_sc_hd__a21oi_1_15 r0 *1 0,0
Xsky130_fd_sc_hd__a21oi_1_15 net23 \_0897_ \_0900_ VGND VPWR VPWR \_0017_[12]
+ sky130_fd_sc_hd__a21oi_1
* cell instance sky130_fd_sc_hd__a21oi_1_16 r0 *1 0,0
Xsky130_fd_sc_hd__a21oi_1_16 cond_mem[0][8] net28 \_1146_ VGND VPWR VPWR
+ \_1147_ sky130_fd_sc_hd__a21oi_1
* cell instance sky130_fd_sc_hd__a21oi_1_17 r0 *1 0,0
Xsky130_fd_sc_hd__a21oi_1_17 raw_mem[1][12] \_0802_ \_0896_ VGND VPWR VPWR
+ \_0897_ sky130_fd_sc_hd__a21oi_1
* cell instance sky130_fd_sc_hd__a21oi_1_18 r0 *1 0,0
Xsky130_fd_sc_hd__a21oi_1_18 raw_mem[2][24] net33 \_0981_ VGND VPWR VPWR
+ \_0982_ sky130_fd_sc_hd__a21oi_1
* cell instance sky130_fd_sc_hd__a21oi_1_19 r0 *1 0,0
Xsky130_fd_sc_hd__a21oi_1_19 raw_mem[1][31] \_0802_ \_1298_ VGND VPWR VPWR
+ \_1299_ sky130_fd_sc_hd__a21oi_1
* cell instance sky130_fd_sc_hd__a21oi_1_20 r0 *1 0,0
Xsky130_fd_sc_hd__a21oi_1_20 cond_mem[0][12] net28 \_1130_ VGND VPWR VPWR
+ \_1131_ sky130_fd_sc_hd__a21oi_1
* cell instance sky130_fd_sc_hd__a21oi_1_21 r0 *1 0,0
Xsky130_fd_sc_hd__a21oi_1_21 cond_mem[2][8] net26 \_1215_ VGND VPWR VPWR
+ \_1216_ sky130_fd_sc_hd__a21oi_1
* cell instance sky130_fd_sc_hd__a21oi_1_22 r0 *1 0,0
Xsky130_fd_sc_hd__a21oi_1_22 cond_mem[2][12] net26 \_1207_ VGND VPWR VPWR
+ \_1208_ sky130_fd_sc_hd__a21oi_1
* cell instance sky130_fd_sc_hd__a21oi_1_23 r0 *1 0,0
Xsky130_fd_sc_hd__a21oi_1_23 net23 \_0933_ \_0936_ VGND VPWR VPWR \_0017_[5]
+ sky130_fd_sc_hd__a21oi_1
* cell instance sky130_fd_sc_hd__a21oi_1_24 r0 *1 0,0
Xsky130_fd_sc_hd__a21oi_1_24 cond_mem[2][26] net26 \_1187_ VGND VPWR VPWR
+ \_1188_ sky130_fd_sc_hd__a21oi_1
* cell instance sky130_fd_sc_hd__a21oi_1_25 r0 *1 0,0
Xsky130_fd_sc_hd__a21oi_1_25 cond_mem[0][26] net28 \_1091_ VGND VPWR VPWR
+ \_1092_ sky130_fd_sc_hd__a21oi_1
* cell instance sky130_fd_sc_hd__a21oi_1_26 r0 *1 0,0
Xsky130_fd_sc_hd__a21oi_1_26 net23 \_0928_ \_0931_ VGND VPWR VPWR \_0017_[6]
+ sky130_fd_sc_hd__a21oi_1
* cell instance sky130_fd_sc_hd__a21oi_1_27 r0 *1 0,0
Xsky130_fd_sc_hd__a21oi_1_27 raw_mem[0][26] \_0797_ \_0833_ VGND VPWR VPWR
+ \_0834_ sky130_fd_sc_hd__a21oi_1
* cell instance sky130_fd_sc_hd__a21oi_1_28 r0 *1 0,0
Xsky130_fd_sc_hd__a21oi_1_28 raw_mem[1][26] \_0802_ \_0836_ VGND VPWR VPWR
+ \_0837_ sky130_fd_sc_hd__a21oi_1
* cell instance sky130_fd_sc_hd__a21oi_1_29 r0 *1 0,0
Xsky130_fd_sc_hd__a21oi_1_29 raw_mem[1][5] \_0802_ \_0932_ VGND VPWR VPWR
+ \_0933_ sky130_fd_sc_hd__a21oi_1
* cell instance sky130_fd_sc_hd__a21oi_1_30 r0 *1 0,0
Xsky130_fd_sc_hd__a21oi_1_30 raw_mem[1][6] \_0802_ \_0927_ VGND VPWR VPWR
+ \_0928_ sky130_fd_sc_hd__a21oi_1
* cell instance sky130_fd_sc_hd__a21oi_1_31 r0 *1 0,0
Xsky130_fd_sc_hd__a21oi_1_31 raw_mem[2][26] net33 \_0977_ VGND VPWR VPWR
+ \_0978_ sky130_fd_sc_hd__a21oi_1
* cell instance sky130_fd_sc_hd__a21oi_1_32 r0 *1 0,0
Xsky130_fd_sc_hd__a21oi_1_32 bus_rdata_r[13] net36 \_1349_ VGND VPWR VPWR
+ \_1350_ sky130_fd_sc_hd__a21oi_1
* cell instance sky130_fd_sc_hd__a21oi_1_33 r0 *1 0,0
Xsky130_fd_sc_hd__a21oi_1_33 \_0756_ \_1336_ \_0730_ VGND VPWR VPWR \_1375_
+ sky130_fd_sc_hd__a21oi_1
* cell instance sky130_fd_sc_hd__a21oi_1_34 r0 *1 0,0
Xsky130_fd_sc_hd__a21oi_1_34 \_0810_ \_0940_ \_1375_ VGND VPWR VPWR \_1376_
+ sky130_fd_sc_hd__a21oi_1
* cell instance sky130_fd_sc_hd__a21oi_1_35 r0 *1 0,0
Xsky130_fd_sc_hd__a21oi_1_35 net23 \_0892_ \_0895_ VGND VPWR VPWR \_0017_[13]
+ sky130_fd_sc_hd__a21oi_1
* cell instance sky130_fd_sc_hd__a21oi_1_36 r0 *1 0,0
Xsky130_fd_sc_hd__a21oi_1_36 cond_mem[0][5] net28 \_1156_ VGND VPWR VPWR
+ \_1157_ sky130_fd_sc_hd__a21oi_1
* cell instance sky130_fd_sc_hd__a21oi_1_37 r0 *1 0,0
Xsky130_fd_sc_hd__a21oi_1_37 \_0761_ \_0930_ \_1368_ VGND VPWR VPWR \_1369_
+ sky130_fd_sc_hd__a21oi_1
* cell instance sky130_fd_sc_hd__a21oi_1_38 r0 *1 0,0
Xsky130_fd_sc_hd__a21oi_1_38 net23 \_0938_ \_0941_ VGND VPWR VPWR \_0017_[4]
+ sky130_fd_sc_hd__a21oi_1
* cell instance sky130_fd_sc_hd__a21oi_1_39 r0 *1 0,0
Xsky130_fd_sc_hd__a21oi_1_39 cond_mem[0][4] net28 \_1160_ VGND VPWR VPWR
+ \_1161_ sky130_fd_sc_hd__a21oi_1
* cell instance sky130_fd_sc_hd__a21oi_1_40 r0 *1 0,0
Xsky130_fd_sc_hd__a21oi_1_40 cond_mem[2][0] net26 \_1230_ VGND VPWR VPWR
+ \_1231_ sky130_fd_sc_hd__a21oi_1
* cell instance sky130_fd_sc_hd__a21oi_1_41 r0 *1 0,0
Xsky130_fd_sc_hd__a21oi_1_41 cond_mem[2][5] net26 \_1220_ VGND VPWR VPWR
+ \_1221_ sky130_fd_sc_hd__a21oi_1
* cell instance sky130_fd_sc_hd__a21oi_1_42 r0 *1 0,0
Xsky130_fd_sc_hd__a21oi_1_42 raw_mem[1][13] \_0802_ \_0891_ VGND VPWR VPWR
+ \_0892_ sky130_fd_sc_hd__a21oi_1
* cell instance sky130_fd_sc_hd__a21oi_1_43 r0 *1 0,0
Xsky130_fd_sc_hd__a21oi_1_43 \_0810_ \_0959_ \_1391_ VGND VPWR VPWR \_1392_
+ sky130_fd_sc_hd__a21oi_1
* cell instance sky130_fd_sc_hd__a21oi_1_44 r0 *1 0,0
Xsky130_fd_sc_hd__a21oi_1_44 cond_mem[0][0] net28 \_1175_ VGND VPWR VPWR
+ \_1176_ sky130_fd_sc_hd__a21oi_1
* cell instance sky130_fd_sc_hd__a21oi_1_45 r0 *1 0,0
Xsky130_fd_sc_hd__a21oi_1_45 raw_mem[1][4] \_0802_ \_0937_ VGND VPWR VPWR
+ \_0938_ sky130_fd_sc_hd__a21oi_1
* cell instance sky130_fd_sc_hd__a21oi_1_46 r0 *1 0,0
Xsky130_fd_sc_hd__a21oi_1_46 \_0290_ \_0014_[0] \_1367_ VGND VPWR VPWR \_1390_
+ sky130_fd_sc_hd__a21oi_1
* cell instance sky130_fd_sc_hd__a21oi_1_47 r0 *1 0,0
Xsky130_fd_sc_hd__a21oi_1_47 raw_mem[1][0] \_0802_ \_0960_ VGND VPWR VPWR
+ \_0961_ sky130_fd_sc_hd__a21oi_1
* cell instance sky130_fd_sc_hd__a21oi_1_48 r0 *1 0,0
Xsky130_fd_sc_hd__a21oi_1_48 net23 \_0949_ \_0952_ VGND VPWR VPWR \_0017_[2]
+ sky130_fd_sc_hd__a21oi_1
* cell instance sky130_fd_sc_hd__a21oi_1_49 r0 *1 0,0
Xsky130_fd_sc_hd__a21oi_1_49 \_0810_ \_0951_ \_1381_ VGND VPWR VPWR \_1382_
+ sky130_fd_sc_hd__a21oi_1
* cell instance sky130_fd_sc_hd__a21oi_1_50 r0 *1 0,0
Xsky130_fd_sc_hd__a21oi_1_50 raw_mem[1][16] \_0802_ \_0879_ VGND VPWR VPWR
+ \_0880_ sky130_fd_sc_hd__a21oi_1
* cell instance sky130_fd_sc_hd__a21oi_1_51 r0 *1 0,0
Xsky130_fd_sc_hd__a21oi_1_51 raw_mem[0][16] \_0797_ \_0877_ VGND VPWR VPWR
+ \_0878_ sky130_fd_sc_hd__a21oi_1
* cell instance sky130_fd_sc_hd__a21oi_1_52 r0 *1 0,0
Xsky130_fd_sc_hd__a21oi_1_52 raw_mem[2][16] net33 \_0997_ VGND VPWR VPWR
+ \_0998_ sky130_fd_sc_hd__a21oi_1
* cell instance sky130_fd_sc_hd__a21oi_1_53 r0 *1 0,0
Xsky130_fd_sc_hd__a21oi_1_53 raw_mem[1][2] \_0802_ \_0948_ VGND VPWR VPWR
+ \_0949_ sky130_fd_sc_hd__a21oi_1
* cell instance sky130_fd_sc_hd__a21oi_1_54 r0 *1 0,0
Xsky130_fd_sc_hd__a21oi_1_54 cond_mem[0][16] net28 \_1120_ VGND VPWR VPWR
+ \_1121_ sky130_fd_sc_hd__a21oi_1
* cell instance sky130_fd_sc_hd__a21oi_1_55 r0 *1 0,0
Xsky130_fd_sc_hd__a21oi_1_55 \_0749_ \_1343_ \_1354_ VGND VPWR VPWR \_1355_
+ sky130_fd_sc_hd__a21oi_1
* cell instance sky130_fd_sc_hd__a21oi_1_56 r0 *1 0,0
Xsky130_fd_sc_hd__a21oi_1_56 net23 \_0911_ \_0914_ VGND VPWR VPWR \_0017_[9]
+ sky130_fd_sc_hd__a21oi_1
* cell instance sky130_fd_sc_hd__a21oi_1_57 r0 *1 0,0
Xsky130_fd_sc_hd__a21oi_1_57 \_0761_ \_0913_ \_1360_ VGND VPWR VPWR \_1361_
+ sky130_fd_sc_hd__a21oi_1
* cell instance sky130_fd_sc_hd__a21oi_1_58 r0 *1 0,0
Xsky130_fd_sc_hd__a21oi_1_58 cond_mem[2][4] net26 \_1222_ VGND VPWR VPWR
+ \_1223_ sky130_fd_sc_hd__a21oi_1
* cell instance sky130_fd_sc_hd__a21oi_1_59 r0 *1 0,0
Xsky130_fd_sc_hd__a21oi_1_59 cond_mem[2][16] net26 \_1202_ VGND VPWR VPWR
+ \_1203_ sky130_fd_sc_hd__a21oi_1
* cell instance sky130_fd_sc_hd__a21oi_1_60 r0 *1 0,0
Xsky130_fd_sc_hd__a21oi_1_60 raw_mem[2][31] net33 \_1300_ VGND VPWR VPWR
+ \_1301_ sky130_fd_sc_hd__a21oi_1
* cell instance sky130_fd_sc_hd__a21oi_1_61 r0 *1 0,0
Xsky130_fd_sc_hd__a21oi_1_61 raw_mem[1][9] \_0802_ \_0910_ VGND VPWR VPWR
+ \_0911_ sky130_fd_sc_hd__a21oi_1
* cell instance sky130_fd_sc_hd__a21oi_1_62 r0 *1 0,0
Xsky130_fd_sc_hd__a21oi_1_62 raw_mem[2][7] net33 \_1021_ VGND VPWR VPWR \_1022_
+ sky130_fd_sc_hd__a21oi_1
* cell instance sky130_fd_sc_hd__a21oi_1_63 r0 *1 0,0
Xsky130_fd_sc_hd__a21oi_1_63 net23 \_1022_ \_1023_ VGND VPWR VPWR \_0018_[7]
+ sky130_fd_sc_hd__a21oi_1
* cell instance sky130_fd_sc_hd__a21oi_1_64 r0 *1 0,0
Xsky130_fd_sc_hd__a21oi_1_64 \_0290_ \_0014_[1] \_1386_ VGND VPWR VPWR \_1387_
+ sky130_fd_sc_hd__a21oi_1
* cell instance sky130_fd_sc_hd__a21oi_1_65 r0 *1 0,0
Xsky130_fd_sc_hd__a21oi_1_65 net23 \_1041_ \_1042_ VGND VPWR VPWR \_0018_[1]
+ sky130_fd_sc_hd__a21oi_1
* cell instance sky130_fd_sc_hd__a21oi_1_66 r0 *1 0,0
Xsky130_fd_sc_hd__a21oi_1_66 \_0764_ \_0767_ \_0769_ VGND VPWR VPWR \_0016_[1]
+ sky130_fd_sc_hd__a21oi_1
* cell instance sky130_fd_sc_hd__a21oi_1_67 r0 *1 0,0
Xsky130_fd_sc_hd__a21oi_1_67 raw_mem[2][1] net33 \_1040_ VGND VPWR VPWR \_1041_
+ sky130_fd_sc_hd__a21oi_1
* cell instance sky130_fd_sc_hd__a21oi_1_68 r0 *1 0,0
Xsky130_fd_sc_hd__a21oi_1_68 \_0955_ \_0956_ net23 VGND VPWR VPWR \_1042_
+ sky130_fd_sc_hd__a21oi_1
* cell instance sky130_fd_sc_hd__a21oi_1_69 r0 *1 0,0
Xsky130_fd_sc_hd__a21oi_1_69 \_0924_ \_0925_ net23 VGND VPWR VPWR \_1023_
+ sky130_fd_sc_hd__a21oi_1
* cell instance sky130_fd_sc_hd__a21oi_1_70 r0 *1 0,0
Xsky130_fd_sc_hd__a21oi_1_70 net42 \_0787_ \_0779_ VGND VPWR VPWR \_0791_
+ sky130_fd_sc_hd__a21oi_1
* cell instance sky130_fd_sc_hd__a21oi_1_71 r0 *1 0,0
Xsky130_fd_sc_hd__a21oi_1_71 net23 \_1035_ \_1036_ VGND VPWR VPWR \_0018_[3]
+ sky130_fd_sc_hd__a21oi_1
* cell instance sky130_fd_sc_hd__a21oi_1_72 r0 *1 0,0
Xsky130_fd_sc_hd__a21oi_1_72 \_0945_ \_0946_ net23 VGND VPWR VPWR \_1036_
+ sky130_fd_sc_hd__a21oi_1
* cell instance sky130_fd_sc_hd__a21oi_1_73 r0 *1 0,0
Xsky130_fd_sc_hd__a21oi_1_73 raw_mem[0][1] net31 \_0953_ VGND VPWR VPWR \_0954_
+ sky130_fd_sc_hd__a21oi_1
* cell instance sky130_fd_sc_hd__a21oi_1_74 r0 *1 0,0
Xsky130_fd_sc_hd__a21oi_1_74 raw_mem[0][3] net31 \_0943_ VGND VPWR VPWR \_0944_
+ sky130_fd_sc_hd__a21oi_1
* cell instance sky130_fd_sc_hd__a21oi_1_75 r0 *1 0,0
Xsky130_fd_sc_hd__a21oi_1_75 raw_sr[0] net40 \_0718_ VGND VPWR VPWR \_0719_
+ sky130_fd_sc_hd__a21oi_1
* cell instance sky130_fd_sc_hd__a21oi_1_76 r0 *1 0,0
Xsky130_fd_sc_hd__a21oi_1_76 raw_sr[16] net40 \_0685_ VGND VPWR VPWR \_0686_
+ sky130_fd_sc_hd__a21oi_1
* cell instance sky130_fd_sc_hd__a21oi_1_77 r0 *1 0,0
Xsky130_fd_sc_hd__a21oi_1_77 raw_mem[0][7] net31 \_0920_ VGND VPWR VPWR \_0921_
+ sky130_fd_sc_hd__a21oi_1
* cell instance sky130_fd_sc_hd__a21oi_1_78 r0 *1 0,0
Xsky130_fd_sc_hd__a21oi_1_78 raw_mem[2][3] net33 \_1034_ VGND VPWR VPWR \_1035_
+ sky130_fd_sc_hd__a21oi_1
* cell instance sky130_fd_sc_hd__a21oi_1_79 r0 *1 0,0
Xsky130_fd_sc_hd__a21oi_1_79 cond_mem[0][7] net28 \_1150_ VGND VPWR VPWR
+ \_1151_ sky130_fd_sc_hd__a21oi_1
* cell instance sky130_fd_sc_hd__a21oi_1_80 r0 *1 0,0
Xsky130_fd_sc_hd__a21oi_1_80 raw_sr[24] net40 \_0667_ VGND VPWR VPWR \_0668_
+ sky130_fd_sc_hd__a21oi_1
* cell instance sky130_fd_sc_hd__a21oi_1_81 r0 *1 0,0
Xsky130_fd_sc_hd__a21oi_1_81 cond_mem[2][7] net26 \_1217_ VGND VPWR VPWR
+ \_1218_ sky130_fd_sc_hd__a21oi_1
* cell instance sky130_fd_sc_hd__a21oi_1_82 r0 *1 0,0
Xsky130_fd_sc_hd__a21oi_1_82 raw_sr[25] net40 \_0665_ VGND VPWR VPWR \_0666_
+ sky130_fd_sc_hd__a21oi_1
* cell instance sky130_fd_sc_hd__a21oi_1_83 r0 *1 0,0
Xsky130_fd_sc_hd__a21oi_1_83 cond_mem[0][11] net28 \_1134_ VGND VPWR VPWR
+ \_1135_ sky130_fd_sc_hd__a21oi_1
* cell instance sky130_fd_sc_hd__a21oi_1_84 r0 *1 0,0
Xsky130_fd_sc_hd__a21oi_1_84 raw_sr[9] net40 \_0699_ VGND VPWR VPWR \_0700_
+ sky130_fd_sc_hd__a21oi_1
* cell instance sky130_fd_sc_hd__a21oi_1_85 r0 *1 0,0
Xsky130_fd_sc_hd__a21oi_1_85 raw_sr[24] \_0093_ \_0094_ VGND VPWR VPWR \_0095_
+ sky130_fd_sc_hd__a21oi_1
* cell instance sky130_fd_sc_hd__a21oi_1_86 r0 *1 0,0
Xsky130_fd_sc_hd__a21oi_1_86 raw_mem[0][10] net31 \_0906_ VGND VPWR VPWR
+ \_0907_ sky130_fd_sc_hd__a21oi_1
* cell instance sky130_fd_sc_hd__a21oi_1_87 r0 *1 0,0
Xsky130_fd_sc_hd__a21oi_1_87 cond_mem[0][10] net28 \_1140_ VGND VPWR VPWR
+ \_1141_ sky130_fd_sc_hd__a21oi_1
* cell instance sky130_fd_sc_hd__a21oi_1_88 r0 *1 0,0
Xsky130_fd_sc_hd__a21oi_1_88 cond_mem[2][11] net26 \_1210_ VGND VPWR VPWR
+ \_1211_ sky130_fd_sc_hd__a21oi_1
* cell instance sky130_fd_sc_hd__a21oi_1_89 r0 *1 0,0
Xsky130_fd_sc_hd__a21oi_1_89 raw_sr[8] net40 \_0701_ VGND VPWR VPWR \_0702_
+ sky130_fd_sc_hd__a21oi_1
* cell instance sky130_fd_sc_hd__a21oi_1_90 r0 *1 0,0
Xsky130_fd_sc_hd__a21oi_1_90 raw_count[4] \_0720_ net34 VGND VPWR VPWR \_0721_
+ sky130_fd_sc_hd__a21oi_1
* cell instance sky130_fd_sc_hd__a21oi_1_91 r0 *1 0,0
Xsky130_fd_sc_hd__a21oi_1_91 raw_mem[0][11] net31 \_0901_ VGND VPWR VPWR
+ \_0902_ sky130_fd_sc_hd__a21oi_1
* cell instance sky130_fd_sc_hd__a21oi_1_92 r0 *1 0,0
Xsky130_fd_sc_hd__a21oi_1_92 raw_mem[1][10] \_0802_ \_0908_ VGND VPWR VPWR
+ \_0909_ sky130_fd_sc_hd__a21oi_1
* cell instance sky130_fd_sc_hd__a21oi_1_93 r0 *1 0,0
Xsky130_fd_sc_hd__a21oi_1_93 \_0782_ net22 \_0781_ VGND VPWR VPWR \_0007_[2]
+ sky130_fd_sc_hd__a21oi_1
* cell instance sky130_fd_sc_hd__a21oi_1_94 r0 *1 0,0
Xsky130_fd_sc_hd__a21oi_1_94 raw_sr[29] net40 \_0656_ VGND VPWR VPWR \_0657_
+ sky130_fd_sc_hd__a21oi_1
* cell instance sky130_fd_sc_hd__a21oi_1_95 r0 *1 0,0
Xsky130_fd_sc_hd__a21oi_1_95 raw_sr[10] net40 \_0697_ VGND VPWR VPWR \_0698_
+ sky130_fd_sc_hd__a21oi_1
* cell instance sky130_fd_sc_hd__a21oi_1_96 r0 *1 0,0
Xsky130_fd_sc_hd__a21oi_1_96 cond_mem[0][2] net28 \_1166_ VGND VPWR VPWR
+ \_1167_ sky130_fd_sc_hd__a21oi_1
* cell instance sky130_fd_sc_hd__a21oi_1_97 r0 *1 0,0
Xsky130_fd_sc_hd__a21oi_1_97 raw_sr[26] net40 \_0663_ VGND VPWR VPWR \_0664_
+ sky130_fd_sc_hd__a21oi_1
* cell instance sky130_fd_sc_hd__a21oi_1_98 r0 *1 0,0
Xsky130_fd_sc_hd__a21oi_1_98 raw_mem[1][11] \_0802_ \_0903_ VGND VPWR VPWR
+ \_0904_ sky130_fd_sc_hd__a21oi_1
* cell instance sky130_fd_sc_hd__a21oi_1_99 r0 *1 0,0
Xsky130_fd_sc_hd__a21oi_1_99 raw_mem[2][10] net33 \_1013_ VGND VPWR VPWR
+ \_1014_ sky130_fd_sc_hd__a21oi_1
* cell instance sky130_fd_sc_hd__a21oi_1_100 r0 *1 0,0
Xsky130_fd_sc_hd__a21oi_1_100 cond_mem[2][10] net26 \_1212_ VGND VPWR VPWR
+ \_1213_ sky130_fd_sc_hd__a21oi_1
* cell instance sky130_fd_sc_hd__a21oi_1_101 r0 *1 0,0
Xsky130_fd_sc_hd__a21oi_1_101 raw_sr[12] net40 \_0693_ VGND VPWR VPWR \_0694_
+ sky130_fd_sc_hd__a21oi_1
* cell instance sky130_fd_sc_hd__a21oi_1_102 r0 *1 0,0
Xsky130_fd_sc_hd__a21oi_1_102 raw_sr[13] net40 \_0691_ VGND VPWR VPWR \_0692_
+ sky130_fd_sc_hd__a21oi_1
* cell instance sky130_fd_sc_hd__a21oi_1_103 r0 *1 0,0
Xsky130_fd_sc_hd__a21oi_1_103 raw_mem[2][11] net33 \_1011_ VGND VPWR VPWR
+ \_1012_ sky130_fd_sc_hd__a21oi_1
* cell instance sky130_fd_sc_hd__a21oi_1_104 r0 *1 0,0
Xsky130_fd_sc_hd__a21oi_1_104 raw_sr[2] net40 \_0714_ VGND VPWR VPWR \_0715_
+ sky130_fd_sc_hd__a21oi_1
* cell instance sky130_fd_sc_hd__a21oi_1_105 r0 *1 0,0
Xsky130_fd_sc_hd__a21oi_1_105 raw_sr[15] net40 \_0687_ VGND VPWR VPWR \_0688_
+ sky130_fd_sc_hd__a21oi_1
* cell instance sky130_fd_sc_hd__a21oi_1_106 r0 *1 0,0
Xsky130_fd_sc_hd__a21oi_1_106 raw_mem[0][27] net31 \_0829_ VGND VPWR VPWR
+ \_0830_ sky130_fd_sc_hd__a21oi_1
* cell instance sky130_fd_sc_hd__a21oi_1_107 r0 *1 0,0
Xsky130_fd_sc_hd__a21oi_1_107 raw_sr[19] net40 \_0678_ VGND VPWR VPWR \_0679_
+ sky130_fd_sc_hd__a21oi_1
* cell instance sky130_fd_sc_hd__a21oi_1_108 r0 *1 0,0
Xsky130_fd_sc_hd__a21oi_1_108 raw_mem[0][15] net31 \_0881_ VGND VPWR VPWR
+ \_0882_ sky130_fd_sc_hd__a21oi_1
* cell instance sky130_fd_sc_hd__a21oi_1_109 r0 *1 0,0
Xsky130_fd_sc_hd__a21oi_1_109 raw_mem[1][15] \_0802_ \_0883_ VGND VPWR VPWR
+ \_0884_ sky130_fd_sc_hd__a21oi_1
* cell instance sky130_fd_sc_hd__a21oi_1_110 r0 *1 0,0
Xsky130_fd_sc_hd__a21oi_1_110 raw_mem[2][15] net33 \_0999_ VGND VPWR VPWR
+ \_1000_ sky130_fd_sc_hd__a21oi_1
* cell instance sky130_fd_sc_hd__a21oi_1_111 r0 *1 0,0
Xsky130_fd_sc_hd__a21oi_1_111 raw_sr[19] \_0123_ \_0125_ VGND VPWR VPWR \_0126_
+ sky130_fd_sc_hd__a21oi_1
* cell instance sky130_fd_sc_hd__a21oi_1_112 r0 *1 0,0
Xsky130_fd_sc_hd__a21oi_1_112 raw_mem[0][18] net31 \_0869_ VGND VPWR VPWR
+ \_0870_ sky130_fd_sc_hd__a21oi_1
* cell instance sky130_fd_sc_hd__a21oi_1_113 r0 *1 0,0
Xsky130_fd_sc_hd__a21oi_1_113 raw_sr[3] net40 \_0712_ VGND VPWR VPWR \_0713_
+ sky130_fd_sc_hd__a21oi_1
* cell instance sky130_fd_sc_hd__a21oi_1_114 r0 *1 0,0
Xsky130_fd_sc_hd__a21oi_1_114 raw_sr[11] net40 \_0695_ VGND VPWR VPWR \_0696_
+ sky130_fd_sc_hd__a21oi_1
* cell instance sky130_fd_sc_hd__a21oi_1_115 r0 *1 0,0
Xsky130_fd_sc_hd__a21oi_1_115 raw_sr[5] net40 \_0708_ VGND VPWR VPWR \_0709_
+ sky130_fd_sc_hd__a21oi_1
* cell instance sky130_fd_sc_hd__a21oi_1_116 r0 *1 0,0
Xsky130_fd_sc_hd__a21oi_1_116 raw_sr[18] \_0128_ \_0130_ VGND VPWR VPWR \_0131_
+ sky130_fd_sc_hd__a21oi_1
* cell instance sky130_fd_sc_hd__a21oi_1_117 r0 *1 0,0
Xsky130_fd_sc_hd__a21oi_1_117 raw_sr[18] net40 \_0680_ VGND VPWR VPWR \_0681_
+ sky130_fd_sc_hd__a21oi_1
* cell instance sky130_fd_sc_hd__a21oi_1_118 r0 *1 0,0
Xsky130_fd_sc_hd__a21oi_1_118 raw_sr[3] \_0187_ \_0188_ VGND VPWR VPWR \_0189_
+ sky130_fd_sc_hd__a21oi_1
* cell instance sky130_fd_sc_hd__a21oi_1_119 r0 *1 0,0
Xsky130_fd_sc_hd__a21oi_1_119 raw_mem[1][27] \_0802_ \_0831_ VGND VPWR VPWR
+ \_0832_ sky130_fd_sc_hd__a21oi_1
* cell instance sky130_fd_sc_hd__a21oi_1_120 r0 *1 0,0
Xsky130_fd_sc_hd__a21oi_1_120 raw_sr[5] \_0179_ \_0180_ VGND VPWR VPWR \_0181_
+ sky130_fd_sc_hd__a21oi_1
* cell instance sky130_fd_sc_hd__a21oi_1_121 r0 *1 0,0
Xsky130_fd_sc_hd__a21oi_1_121 raw_count[0] \_0311_ raw_count[1] VGND VPWR VPWR
+ \_0726_ sky130_fd_sc_hd__a21oi_1
* cell instance sky130_fd_sc_hd__a21oi_1_122 r0 *1 0,0
Xsky130_fd_sc_hd__a21oi_1_122 raw_mem[2][27] net33 \_0973_ VGND VPWR VPWR
+ \_0974_ sky130_fd_sc_hd__a21oi_1
* cell instance sky130_fd_sc_hd__a21oi_1_123 r0 *1 0,0
Xsky130_fd_sc_hd__a21oi_1_123 \_0200_ net30 cond_level[0] VGND VPWR VPWR
+ \_0775_ sky130_fd_sc_hd__a21oi_1
* cell instance sky130_fd_sc_hd__a21oi_1_124 r0 *1 0,0
Xsky130_fd_sc_hd__a21oi_1_124 raw_mem[1][18] \_0802_ \_0871_ VGND VPWR VPWR
+ \_0872_ sky130_fd_sc_hd__a21oi_1
* cell instance sky130_fd_sc_hd__a21oi_1_125 r0 *1 0,0
Xsky130_fd_sc_hd__a21oi_1_125 raw_sr[27] net40 \_0661_ VGND VPWR VPWR \_0662_
+ sky130_fd_sc_hd__a21oi_1
* cell instance sky130_fd_sc_hd__a21oi_1_126 r0 *1 0,0
Xsky130_fd_sc_hd__a21oi_1_126 raw_mem[2][18] net33 \_0993_ VGND VPWR VPWR
+ \_0994_ sky130_fd_sc_hd__a21oi_1
* cell instance sky130_fd_sc_hd__a21oi_1_127 r0 *1 0,0
Xsky130_fd_sc_hd__a21oi_1_127 raw_sr[4] net40 \_0710_ VGND VPWR VPWR \_0711_
+ sky130_fd_sc_hd__a21oi_1
* cell instance sky130_fd_sc_hd__a21oi_1_128 r0 *1 0,0
Xsky130_fd_sc_hd__a21oi_1_128 raw_mem[0][17] net31 \_0873_ VGND VPWR VPWR
+ \_0874_ sky130_fd_sc_hd__a21oi_1
* cell instance sky130_fd_sc_hd__a21oi_1_129 r0 *1 0,0
Xsky130_fd_sc_hd__a21oi_1_129 raw_count[0] \_0311_ \_0727_ VGND VPWR VPWR
+ \_0015_[0] sky130_fd_sc_hd__a21oi_1
* cell instance sky130_fd_sc_hd__a21oi_1_130 r0 *1 0,0
Xsky130_fd_sc_hd__a21oi_1_130 raw_mem[0][14] net31 \_0885_ VGND VPWR VPWR
+ \_0886_ sky130_fd_sc_hd__a21oi_1
* cell instance sky130_fd_sc_hd__a21oi_1_131 r0 *1 0,0
Xsky130_fd_sc_hd__a21oi_1_131 cond_mem[0][23] net28 \_1101_ VGND VPWR VPWR
+ \_1102_ sky130_fd_sc_hd__a21oi_1
* cell instance sky130_fd_sc_hd__a21oi_1_132 r0 *1 0,0
Xsky130_fd_sc_hd__a21oi_1_132 cond_mem[0][1] net28 \_1170_ VGND VPWR VPWR
+ \_1171_ sky130_fd_sc_hd__a21oi_1
* cell instance sky130_fd_sc_hd__a21oi_1_133 r0 *1 0,0
Xsky130_fd_sc_hd__a21oi_1_133 raw_sr[1] net40 \_0716_ VGND VPWR VPWR \_0717_
+ sky130_fd_sc_hd__a21oi_1
* cell instance sky130_fd_sc_hd__a21oi_1_134 r0 *1 0,0
Xsky130_fd_sc_hd__a21oi_1_134 raw_mem[1][17] \_0802_ \_0875_ VGND VPWR VPWR
+ \_0876_ sky130_fd_sc_hd__a21oi_1
* cell instance sky130_fd_sc_hd__a21oi_1_135 r0 *1 0,0
Xsky130_fd_sc_hd__a21oi_1_135 cond_mem[0][22] net28 \_1105_ VGND VPWR VPWR
+ \_1106_ sky130_fd_sc_hd__a21oi_1
* cell instance sky130_fd_sc_hd__a21oi_1_136 r0 *1 0,0
Xsky130_fd_sc_hd__a21oi_1_136 raw_sr[7] \_0171_ \_0172_ VGND VPWR VPWR \_0173_
+ sky130_fd_sc_hd__a21oi_1
* cell instance sky130_fd_sc_hd__a21oi_1_137 r0 *1 0,0
Xsky130_fd_sc_hd__a21oi_1_137 cond_mem[2][2] net26 \_1225_ VGND VPWR VPWR
+ \_1226_ sky130_fd_sc_hd__a21oi_1
* cell instance sky130_fd_sc_hd__a21oi_1_138 r0 *1 0,0
Xsky130_fd_sc_hd__a21oi_1_138 raw_mem[0][28] net31 \_0824_ VGND VPWR VPWR
+ \_0825_ sky130_fd_sc_hd__a21oi_1
* cell instance sky130_fd_sc_hd__a21oi_1_139 r0 *1 0,0
Xsky130_fd_sc_hd__a21oi_1_139 raw_mem[2][17] net33 \_0995_ VGND VPWR VPWR
+ \_0996_ sky130_fd_sc_hd__a21oi_1
* cell instance sky130_fd_sc_hd__a21oi_1_140 r0 *1 0,0
Xsky130_fd_sc_hd__a21oi_1_140 raw_mem[1][14] \_0802_ \_0887_ VGND VPWR VPWR
+ \_0888_ sky130_fd_sc_hd__a21oi_1
* cell instance sky130_fd_sc_hd__a21oi_1_141 r0 *1 0,0
Xsky130_fd_sc_hd__a21oi_1_141 raw_sr[17] \_0133_ \_0135_ VGND VPWR VPWR \_0136_
+ sky130_fd_sc_hd__a21oi_1
* cell instance sky130_fd_sc_hd__a21oi_1_142 r0 *1 0,0
Xsky130_fd_sc_hd__a21oi_1_142 cond_mem[2][1] net26 \_1228_ VGND VPWR VPWR
+ \_1229_ sky130_fd_sc_hd__a21oi_1
* cell instance sky130_fd_sc_hd__a21oi_1_143 r0 *1 0,0
Xsky130_fd_sc_hd__a21oi_1_143 raw_sr[17] net40 \_0683_ VGND VPWR VPWR \_0684_
+ sky130_fd_sc_hd__a21oi_1
* cell instance sky130_fd_sc_hd__a21oi_1_144 r0 *1 0,0
Xsky130_fd_sc_hd__a21oi_1_144 raw_sr[14] net40 \_0689_ VGND VPWR VPWR \_0690_
+ sky130_fd_sc_hd__a21oi_1
* cell instance sky130_fd_sc_hd__a21oi_1_145 r0 *1 0,0
Xsky130_fd_sc_hd__a21oi_1_145 raw_mem[2][14] net33 \_1001_ VGND VPWR VPWR
+ \_1002_ sky130_fd_sc_hd__a21oi_1
* cell instance sky130_fd_sc_hd__a21oi_1_146 r0 *1 0,0
Xsky130_fd_sc_hd__a21oi_1_146 cond_mem[2][22] net26 \_1194_ VGND VPWR VPWR
+ \_1195_ sky130_fd_sc_hd__a21oi_1
* cell instance sky130_fd_sc_hd__a21oi_1_147 r0 *1 0,0
Xsky130_fd_sc_hd__a21oi_1_147 cond_mem[2][23] net26 \_1191_ VGND VPWR VPWR
+ \_1192_ sky130_fd_sc_hd__a21oi_1
* cell instance sky130_fd_sc_hd__a21oi_1_148 r0 *1 0,0
Xsky130_fd_sc_hd__a21oi_1_148 raw_mem[0][22] net31 \_0852_ VGND VPWR VPWR
+ \_0853_ sky130_fd_sc_hd__a21oi_1
* cell instance sky130_fd_sc_hd__a21oi_1_149 r0 *1 0,0
Xsky130_fd_sc_hd__a21oi_1_149 raw_sr[6] \_0175_ \_0176_ VGND VPWR VPWR \_0177_
+ sky130_fd_sc_hd__a21oi_1
* cell instance sky130_fd_sc_hd__a21oi_1_150 r0 *1 0,0
Xsky130_fd_sc_hd__a21oi_1_150 raw_sr[6] net40 \_0706_ VGND VPWR VPWR \_0707_
+ sky130_fd_sc_hd__a21oi_1
* cell instance sky130_fd_sc_hd__a21oi_1_151 r0 *1 0,0
Xsky130_fd_sc_hd__a21oi_1_151 raw_mem[0][30] net31 \_0800_ VGND VPWR VPWR
+ \_0801_ sky130_fd_sc_hd__a21oi_1
* cell instance sky130_fd_sc_hd__a21oi_1_152 r0 *1 0,0
Xsky130_fd_sc_hd__a21oi_1_152 raw_mem[0][23] net31 \_0848_ VGND VPWR VPWR
+ \_0849_ sky130_fd_sc_hd__a21oi_1
* cell instance sky130_fd_sc_hd__a21oi_1_153 r0 *1 0,0
Xsky130_fd_sc_hd__a21oi_1_153 raw_mem[0][21] net31 \_0857_ VGND VPWR VPWR
+ \_0858_ sky130_fd_sc_hd__a21oi_1
* cell instance sky130_fd_sc_hd__a21oi_1_154 r0 *1 0,0
Xsky130_fd_sc_hd__a21oi_1_154 raw_sr[28] \_0069_ \_0070_ VGND VPWR VPWR \_0071_
+ sky130_fd_sc_hd__a21oi_1
* cell instance sky130_fd_sc_hd__a21oi_1_155 r0 *1 0,0
Xsky130_fd_sc_hd__a21oi_1_155 raw_mem[0][20] net31 \_0861_ VGND VPWR VPWR
+ \_0862_ sky130_fd_sc_hd__a21oi_1
* cell instance sky130_fd_sc_hd__a21oi_1_156 r0 *1 0,0
Xsky130_fd_sc_hd__a21oi_1_156 raw_sr[21] \_0114_ \_0116_ VGND VPWR VPWR \_0117_
+ sky130_fd_sc_hd__a21oi_1
* cell instance sky130_fd_sc_hd__a21oi_1_157 r0 *1 0,0
Xsky130_fd_sc_hd__a21oi_1_157 raw_sr[23] \_0101_ \_0104_ VGND VPWR VPWR \_0105_
+ sky130_fd_sc_hd__a21oi_1
* cell instance sky130_fd_sc_hd__a21oi_1_158 r0 *1 0,0
Xsky130_fd_sc_hd__a21oi_1_158 raw_sr[22] \_0107_ \_0111_ VGND VPWR VPWR \_0112_
+ sky130_fd_sc_hd__a21oi_1
* cell instance sky130_fd_sc_hd__a21oi_1_159 r0 *1 0,0
Xsky130_fd_sc_hd__a21oi_1_159 raw_mem[1][28] \_0802_ \_0826_ VGND VPWR VPWR
+ \_0827_ sky130_fd_sc_hd__a21oi_1
* cell instance sky130_fd_sc_hd__a21oi_1_160 r0 *1 0,0
Xsky130_fd_sc_hd__a21oi_1_160 raw_sr[23] net40 \_0669_ VGND VPWR VPWR \_0670_
+ sky130_fd_sc_hd__a21oi_1
* cell instance sky130_fd_sc_hd__a21oi_1_161 r0 *1 0,0
Xsky130_fd_sc_hd__a21oi_1_161 raw_sr[21] net40 \_0674_ VGND VPWR VPWR \_0675_
+ sky130_fd_sc_hd__a21oi_1
* cell instance sky130_fd_sc_hd__a21oi_1_162 r0 *1 0,0
Xsky130_fd_sc_hd__a21oi_1_162 raw_mem[1][21] \_0802_ \_0859_ VGND VPWR VPWR
+ \_0860_ sky130_fd_sc_hd__a21oi_1
* cell instance sky130_fd_sc_hd__a21oi_1_163 r0 *1 0,0
Xsky130_fd_sc_hd__a21oi_1_163 raw_mem[1][20] \_0802_ \_0863_ VGND VPWR VPWR
+ \_0864_ sky130_fd_sc_hd__a21oi_1
* cell instance sky130_fd_sc_hd__a21oi_1_164 r0 *1 0,0
Xsky130_fd_sc_hd__a21oi_1_164 raw_sr[20] net40 \_0676_ VGND VPWR VPWR \_0677_
+ sky130_fd_sc_hd__a21oi_1
* cell instance sky130_fd_sc_hd__a21oi_1_165 r0 *1 0,0
Xsky130_fd_sc_hd__a21oi_1_165 raw_mem[2][21] net33 \_0987_ VGND VPWR VPWR
+ \_0988_ sky130_fd_sc_hd__a21oi_1
* cell instance sky130_fd_sc_hd__a21oi_1_166 r0 *1 0,0
Xsky130_fd_sc_hd__a21oi_1_166 cond_count[0] net35 cond_count[1] VGND VPWR VPWR
+ \_0648_ sky130_fd_sc_hd__a21oi_1
* cell instance sky130_fd_sc_hd__a21oi_1_167 r0 *1 0,0
Xsky130_fd_sc_hd__a21oi_1_167 cond_count[0] net35 \_0649_ VGND VPWR VPWR
+ \_0006_[0] sky130_fd_sc_hd__a21oi_1
* cell instance sky130_fd_sc_hd__a21oi_1_168 r0 *1 0,0
Xsky130_fd_sc_hd__a21oi_1_168 raw_mem[2][28] net33 \_0971_ VGND VPWR VPWR
+ \_0972_ sky130_fd_sc_hd__a21oi_1
* cell instance sky130_fd_sc_hd__a21oi_1_169 r0 *1 0,0
Xsky130_fd_sc_hd__a21oi_1_169 \_0200_ \_0213_ \_0618_ VGND VPWR VPWR \_0619_
+ sky130_fd_sc_hd__a21oi_1
* cell instance sky130_fd_sc_hd__a21oi_1_170 r0 *1 0,0
Xsky130_fd_sc_hd__a21oi_1_170 raw_sr[30] net40 \_0653_ VGND VPWR VPWR \_0654_
+ sky130_fd_sc_hd__a21oi_1
* cell instance sky130_fd_sc_hd__a21oi_1_171 r0 *1 0,0
Xsky130_fd_sc_hd__a21oi_1_171 raw_sr[28] net40 \_0659_ VGND VPWR VPWR \_0660_
+ sky130_fd_sc_hd__a21oi_1
* cell instance sky130_fd_sc_hd__a21oi_1_172 r0 *1 0,0
Xsky130_fd_sc_hd__a21oi_1_172 raw_mem[1][22] \_0802_ \_0854_ VGND VPWR VPWR
+ \_0855_ sky130_fd_sc_hd__a21oi_1
* cell instance sky130_fd_sc_hd__a21oi_1_173 r0 *1 0,0
Xsky130_fd_sc_hd__a21oi_1_173 raw_sr[22] net40 \_0672_ VGND VPWR VPWR \_0673_
+ sky130_fd_sc_hd__a21oi_1
* cell instance sky130_fd_sc_hd__a21oi_1_174 r0 *1 0,0
Xsky130_fd_sc_hd__a21oi_1_174 cond_count[2] \_0640_ \_0647_ VGND VPWR VPWR
+ \_0006_[2] sky130_fd_sc_hd__a21oi_1
* cell instance sky130_fd_sc_hd__a21oi_1_175 r0 *1 0,0
Xsky130_fd_sc_hd__a21oi_1_175 \_0206_ net35 cond_count[9] VGND VPWR VPWR
+ \_0633_ sky130_fd_sc_hd__a21oi_1
* cell instance sky130_fd_sc_hd__a21oi_1_176 r0 *1 0,0
Xsky130_fd_sc_hd__a21oi_1_176 raw_mem[2][22] net33 \_0985_ VGND VPWR VPWR
+ \_0986_ sky130_fd_sc_hd__a21oi_1
* cell instance sky130_fd_sc_hd__a21oi_1_177 r0 *1 0,0
Xsky130_fd_sc_hd__a21oi_1_177 \_0200_ \_0216_ cond_count[8] VGND VPWR VPWR
+ \_0635_ sky130_fd_sc_hd__a21oi_1
* cell instance sky130_fd_sc_hd__a21oi_1_178 r0 *1 0,0
Xsky130_fd_sc_hd__a21oi_1_178 \_0200_ \_0215_ \_0621_ VGND VPWR VPWR \_0622_
+ sky130_fd_sc_hd__a21oi_1
* cell instance sky130_fd_sc_hd__a21oi_1_179 r0 *1 0,0
Xsky130_fd_sc_hd__a21oi_1_179 cond_count[2] \_0640_ cond_count[3] VGND VPWR
+ VPWR \_0646_ sky130_fd_sc_hd__a21oi_1
* cell instance sky130_fd_sc_hd__a21oi_1_180 r0 *1 0,0
Xsky130_fd_sc_hd__a21oi_1_180 raw_mem[1][30] \_0802_ \_0807_ VGND VPWR VPWR
+ \_0808_ sky130_fd_sc_hd__a21oi_1
* cell instance sky130_fd_sc_hd__a21oi_1_181 r0 *1 0,0
Xsky130_fd_sc_hd__a21oi_1_181 \_0200_ \_0206_ \_0635_ VGND VPWR VPWR \_0636_
+ sky130_fd_sc_hd__a21oi_1
* cell instance sky130_fd_sc_hd__a21oi_1_182 r0 *1 0,0
Xsky130_fd_sc_hd__a21oi_1_182 raw_mem[1][23] \_0802_ \_0850_ VGND VPWR VPWR
+ \_0851_ sky130_fd_sc_hd__a21oi_1
* cell instance sky130_fd_sc_hd__a21oi_1_183 r0 *1 0,0
Xsky130_fd_sc_hd__a21oi_1_183 cond_count[13] net40 \_0622_ VGND VPWR VPWR
+ \_0623_ sky130_fd_sc_hd__a21oi_1
* cell instance sky130_fd_sc_hd__a21oi_1_184 r0 *1 0,0
Xsky130_fd_sc_hd__a21oi_1_184 raw_mem[2][20] net33 \_0989_ VGND VPWR VPWR
+ \_0990_ sky130_fd_sc_hd__a21oi_1
* cell instance sky130_fd_sc_hd__a21oi_1_185 r0 *1 0,0
Xsky130_fd_sc_hd__a21oi_1_185 raw_mem[2][30] net33 \_0966_ VGND VPWR VPWR
+ \_0967_ sky130_fd_sc_hd__a21oi_1
* cell instance sky130_fd_sc_hd__a21oi_1_186 r0 *1 0,0
Xsky130_fd_sc_hd__a21oi_1_186 raw_mem[2][23] net33 \_0983_ VGND VPWR VPWR
+ \_0984_ sky130_fd_sc_hd__a21oi_1
* cell instance sky130_fd_sc_hd__a21oi_1_187 r0 *1 0,0
Xsky130_fd_sc_hd__a21oi_1_187 cond_count[4] \_0641_ cond_count[5] VGND VPWR
+ VPWR \_0644_ sky130_fd_sc_hd__a21oi_1
* cell instance sky130_fd_sc_hd__a21oi_1_188 r0 *1 0,0
Xsky130_fd_sc_hd__a21oi_1_188 cond_count[4] \_0641_ \_0645_ VGND VPWR VPWR
+ \_0006_[4] sky130_fd_sc_hd__a21oi_1
* cell instance sky130_fd_sc_hd__a21oi_1_189 r0 *1 0,0
Xsky130_fd_sc_hd__a21oi_1_189 startup_count[5] \_0510_ startup_count[6] VGND
+ VPWR VPWR \_0519_ sky130_fd_sc_hd__a21oi_1
* cell instance sky130_fd_sc_hd__a21oi_1_190 r0 *1 0,0
Xsky130_fd_sc_hd__a21oi_1_190 startup_count[12] net40 \_0499_ VGND VPWR VPWR
+ \_0500_ sky130_fd_sc_hd__a21oi_1
* cell instance sky130_fd_sc_hd__a21oi_1_191 r0 *1 0,0
Xsky130_fd_sc_hd__a21oi_1_191 \_0479_ \_0509_ startup_count[4] VGND VPWR VPWR
+ \_0521_ sky130_fd_sc_hd__a21oi_1
* cell instance sky130_fd_sc_hd__a21oi_1_192 r0 *1 0,0
Xsky130_fd_sc_hd__a21oi_1_192 startup_done_r \_0490_ \_0498_ VGND VPWR VPWR
+ \_0499_ sky130_fd_sc_hd__a21oi_1
* cell instance sky130_fd_sc_hd__a21oi_1_193 r0 *1 0,0
Xsky130_fd_sc_hd__a21oi_1_193 apt_matches[15] net40 \_1280_ VGND VPWR VPWR
+ \_1281_ sky130_fd_sc_hd__a21oi_1
* cell instance sky130_fd_sc_hd__a21oi_1_194 r0 *1 0,0
Xsky130_fd_sc_hd__a21oi_1_194 apt_matches[14] net40 \_0440_ VGND VPWR VPWR
+ \_0441_ sky130_fd_sc_hd__a21oi_1
* cell instance sky130_fd_sc_hd__a21oi_1_195 r0 *1 0,0
Xsky130_fd_sc_hd__a21oi_1_195 apt_matches[12] net40 \_0445_ VGND VPWR VPWR
+ \_0446_ sky130_fd_sc_hd__a21oi_1
* cell instance sky130_fd_sc_hd__a21oi_1_196 r0 *1 0,0
Xsky130_fd_sc_hd__a21oi_1_196 startup_count[15] net40 \_1283_ VGND VPWR VPWR
+ \_1284_ sky130_fd_sc_hd__a21oi_1
* cell instance sky130_fd_sc_hd__a21oi_1_197 r0 *1 0,0
Xsky130_fd_sc_hd__a21oi_1_197 \_0404_ \_0405_ net38 VGND VPWR VPWR \_0003_[13]
+ sky130_fd_sc_hd__a21oi_1
* cell instance sky130_fd_sc_hd__a21oi_1_198 r0 *1 0,0
Xsky130_fd_sc_hd__a21oi_1_198 \_0737_ startup_done_r \_1282_ VGND VPWR VPWR
+ \_1283_ sky130_fd_sc_hd__a21oi_1
* cell instance sky130_fd_sc_hd__a21oi_1_199 r0 *1 0,0
Xsky130_fd_sc_hd__a21oi_1_199 apt_matches[12] \_0334_ apt_matches[13] VGND VPWR
+ VPWR \_0339_ sky130_fd_sc_hd__a21oi_1
* cell instance sky130_fd_sc_hd__a21oi_1_200 r0 *1 0,0
Xsky130_fd_sc_hd__a21oi_1_200 apt_index[14] net40 \_0402_ VGND VPWR VPWR
+ \_0403_ sky130_fd_sc_hd__a21oi_1
* cell instance sky130_fd_sc_hd__a21oi_1_201 r0 *1 0,0
Xsky130_fd_sc_hd__a21oi_1_201 apt_matches[9] net40 \_0451_ VGND VPWR VPWR
+ \_0452_ sky130_fd_sc_hd__a21oi_1
* cell instance sky130_fd_sc_hd__a21oi_1_202 r0 *1 0,0
Xsky130_fd_sc_hd__a21oi_1_202 apt_matches[9] \_0332_ \_0450_ VGND VPWR VPWR
+ \_0451_ sky130_fd_sc_hd__a21oi_1
* cell instance sky130_fd_sc_hd__a21oi_1_203 r0 *1 0,0
Xsky130_fd_sc_hd__a21oi_1_203 \_1272_ \_1273_ net38 VGND VPWR VPWR \_0025_
+ sky130_fd_sc_hd__a21oi_1
* cell instance sky130_fd_sc_hd__a21oi_1_204 r0 *1 0,0
Xsky130_fd_sc_hd__a21oi_1_204 apt_index[15] net40 \_1278_ VGND VPWR VPWR
+ \_1279_ sky130_fd_sc_hd__a21oi_1
* cell instance sky130_fd_sc_hd__a21oi_1_205 r0 *1 0,0
Xsky130_fd_sc_hd__a21oi_1_205 startup_count[1] \_0522_ startup_count[2] VGND
+ VPWR VPWR \_0525_ sky130_fd_sc_hd__a21oi_1
* cell instance sky130_fd_sc_hd__a21oi_1_206 r0 *1 0,0
Xsky130_fd_sc_hd__a21oi_1_206 \_0311_ net37 apt_ref VGND VPWR VPWR \_1275_
+ sky130_fd_sc_hd__a21oi_1
* cell instance sky130_fd_sc_hd__a21oi_1_207 r0 *1 0,0
Xsky130_fd_sc_hd__a21oi_1_207 apt_matches[0] net40 \_0474_ VGND VPWR VPWR
+ \_0475_ sky130_fd_sc_hd__a21oi_1
* cell instance sky130_fd_sc_hd__a21oi_1_208 r0 *1 0,0
Xsky130_fd_sc_hd__a21oi_1_208 \_0469_ \_0472_ net37 VGND VPWR VPWR \_0473_
+ sky130_fd_sc_hd__a21oi_1
* cell instance sky130_fd_sc_hd__a21oi_1_209 r0 *1 0,0
Xsky130_fd_sc_hd__a21oi_1_209 apt_index[10] net40 \_0418_ VGND VPWR VPWR
+ \_0419_ sky130_fd_sc_hd__a21oi_1
* cell instance sky130_fd_sc_hd__a21oi_1_210 r0 *1 0,0
Xsky130_fd_sc_hd__a21oi_1_210 apt_index[10] \_0410_ apt_index[11] VGND VPWR
+ VPWR \_0413_ sky130_fd_sc_hd__a21oi_1
* cell instance sky130_fd_sc_hd__a21oi_1_211 r0 *1 0,0
Xsky130_fd_sc_hd__a21oi_1_211 rct_count[1] rct_count[0] rct_count[2] VGND VPWR
+ VPWR \_0395_ sky130_fd_sc_hd__a21oi_1
* cell instance sky130_fd_sc_hd__a21oi_1_212 r0 *1 0,0
Xsky130_fd_sc_hd__a21oi_1_212 apt_index[0] \_0311_ \_0437_ VGND VPWR VPWR
+ \_0003_[0] sky130_fd_sc_hd__a21oi_1
* cell instance sky130_fd_sc_hd__a21oi_1_213 r0 *1 0,0
Xsky130_fd_sc_hd__a21oi_1_213 apt_matches[6] \_0330_ apt_matches[7] VGND VPWR
+ VPWR \_0344_ sky130_fd_sc_hd__a21oi_1
* cell instance sky130_fd_sc_hd__a21oi_1_214 r0 *1 0,0
Xsky130_fd_sc_hd__a21oi_1_214 rct_count[3] \_0304_ \_0309_ VGND VPWR VPWR
+ \_0323_ sky130_fd_sc_hd__a21oi_1
* cell instance sky130_fd_sc_hd__a21oi_1_215 r0 *1 0,0
Xsky130_fd_sc_hd__a21oi_1_215 rct_count[5] \_0305_ rct_count[6] VGND VPWR VPWR
+ \_0307_ sky130_fd_sc_hd__a21oi_1
* cell instance sky130_fd_sc_hd__a21oi_1_216 r0 *1 0,0
Xsky130_fd_sc_hd__a21oi_1_216 \_0393_ \_0394_ net38 VGND VPWR VPWR \_0024_[3]
+ sky130_fd_sc_hd__a21oi_1
* cell instance sky130_fd_sc_hd__a21oi_1_217 r0 *1 0,0
Xsky130_fd_sc_hd__a21oi_1_217 apt_matches[4] \_0346_ apt_matches[5] VGND VPWR
+ VPWR \_0459_ sky130_fd_sc_hd__a21oi_1
* cell instance sky130_fd_sc_hd__a21oi_1_218 r0 *1 0,0
Xsky130_fd_sc_hd__a21oi_1_218 rct_count[3] \_0304_ rct_count[4] VGND VPWR VPWR
+ \_0389_ sky130_fd_sc_hd__a21oi_1
* cell instance sky130_fd_sc_hd__a21oi_1_219 r0 *1 0,0
Xsky130_fd_sc_hd__a21oi_1_219 apt_index[7] \_0423_ apt_index[8] VGND VPWR VPWR
+ \_0426_ sky130_fd_sc_hd__a21oi_1
* cell instance sky130_fd_sc_hd__a21oi_1_220 r0 *1 0,0
Xsky130_fd_sc_hd__a21oi_1_220 apt_index[4] \_0421_ apt_index[5] VGND VPWR VPWR
+ \_0429_ sky130_fd_sc_hd__a21oi_1
* cell instance sky130_fd_sc_hd__a221o_1_0 r0 *1 0,0
Xsky130_fd_sc_hd__a221o_1_0 bus_rdata_r[16] \_1309_ \_1342_ net42 \_1345_ VGND
+ VPWR VPWR \_0043_ sky130_fd_sc_hd__a221o_1
* cell instance sky130_fd_sc_hd__a221oi_1_0 r0 *1 0,0
Xsky130_fd_sc_hd__a221oi_1_0 \_0761_ \_0899_ net36 bus_rdata_r[12] \_1351_ VGND
+ VPWR VPWR \_1352_ sky130_fd_sc_hd__a221oi_1
* cell instance sky130_fd_sc_hd__a221oi_1_1 r0 *1 0,0
Xsky130_fd_sc_hd__a221oi_1_1 raw_level[0] \_1401_ \_0746_ raw_level[2] \_0544_
+ VGND VPWR VPWR \_0753_ sky130_fd_sc_hd__a221oi_1
* cell instance sky130_fd_sc_hd__a222oi_1_0 r0 *1 0,0
Xsky130_fd_sc_hd__a222oi_1_0 \_0341_ \_0342_ \_0356_ \_0358_ \_0359_ \_0360_
+ VGND VPWR VPWR \_0361_ sky130_fd_sc_hd__a222oi_1
* cell instance sky130_fd_sc_hd__a22o_1_0 r0 *1 0,0
Xsky130_fd_sc_hd__a22o_1_0 bus_rdata_r[11] net36 \_1353_ net42 VGND VPWR VPWR
+ \_0048_ sky130_fd_sc_hd__a22o_1
* cell instance sky130_fd_sc_hd__a22o_1_1 r0 *1 0,0
Xsky130_fd_sc_hd__a22o_1_1 bus_rdata_r[26] net36 \_1326_ net42 VGND VPWR VPWR
+ \_0033_ sky130_fd_sc_hd__a22o_1
* cell instance sky130_fd_sc_hd__a22o_1_2 r0 *1 0,0
Xsky130_fd_sc_hd__a22o_1_2 bus_rdata_r[10] net36 \_1356_ net42 VGND VPWR VPWR
+ \_0049_ sky130_fd_sc_hd__a22o_1
* cell instance sky130_fd_sc_hd__a22o_1_3 r0 *1 0,0
Xsky130_fd_sc_hd__a22o_1_3 bus_rdata_r[0] net36 \_1393_ net42 VGND VPWR VPWR
+ \_0059_ sky130_fd_sc_hd__a22o_1
* cell instance sky130_fd_sc_hd__a22o_1_4 r0 *1 0,0
Xsky130_fd_sc_hd__a22o_1_4 bus_rdata_r[22] net36 \_1330_ net42 VGND VPWR VPWR
+ \_0037_ sky130_fd_sc_hd__a22o_1
* cell instance sky130_fd_sc_hd__a22o_1_5 r0 *1 0,0
Xsky130_fd_sc_hd__a22o_1_5 bus_rdata_r[30] net36 \_1319_ net42 VGND VPWR VPWR
+ \_0029_ sky130_fd_sc_hd__a22o_1
* cell instance sky130_fd_sc_hd__a22o_1_6 r0 *1 0,0
Xsky130_fd_sc_hd__a22o_1_6 bus_rdata_r[28] net36 \_1324_ net42 VGND VPWR VPWR
+ \_0031_ sky130_fd_sc_hd__a22o_1
* cell instance sky130_fd_sc_hd__a22o_1_7 r0 *1 0,0
Xsky130_fd_sc_hd__a22o_1_7 bus_rdata_r[20] net36 \_1332_ net42 VGND VPWR VPWR
+ \_0039_ sky130_fd_sc_hd__a22o_1
* cell instance sky130_fd_sc_hd__a22o_1_8 r0 *1 0,0
Xsky130_fd_sc_hd__a22o_1_8 bus_rdata_r[6] \_1309_ \_1367_ net42 VGND VPWR VPWR
+ \_1368_ sky130_fd_sc_hd__a22o_1
* cell instance sky130_fd_sc_hd__a22o_1_9 r0 *1 0,0
Xsky130_fd_sc_hd__a22o_1_9 \_0290_ \_0014_[2] \_1343_ raw_valid VGND VPWR VPWR
+ \_1381_ sky130_fd_sc_hd__a22o_1
* cell instance sky130_fd_sc_hd__a22o_1_10 r0 *1 0,0
Xsky130_fd_sc_hd__a22o_1_10 bus_rdata_r[9] net36 \_1359_ net42 VGND VPWR VPWR
+ \_1360_ sky130_fd_sc_hd__a22o_1
* cell instance sky130_fd_sc_hd__a22oi_1_0 r0 *1 0,0
Xsky130_fd_sc_hd__a22oi_1_0 bus_rdata_r[4] net36 \_1377_ net42 VGND VPWR VPWR
+ \_1378_ sky130_fd_sc_hd__a22oi_1
* cell instance sky130_fd_sc_hd__a22oi_1_1 r0 *1 0,0
Xsky130_fd_sc_hd__a22oi_1_1 bus_rdata_r[5] net36 \_1372_ net42 VGND VPWR VPWR
+ \_1373_ sky130_fd_sc_hd__a22oi_1
* cell instance sky130_fd_sc_hd__a22oi_1_2 r0 *1 0,0
Xsky130_fd_sc_hd__a22oi_1_2 bus_rdata_r[2] \_1309_ \_1383_ net42 VGND VPWR VPWR
+ \_1384_ sky130_fd_sc_hd__a22oi_1
* cell instance sky130_fd_sc_hd__a22oi_1_3 r0 *1 0,0
Xsky130_fd_sc_hd__a22oi_1_3 bus_rdata_r[1] net36 \_1388_ net42 VGND VPWR VPWR
+ \_1389_ sky130_fd_sc_hd__a22oi_1
* cell instance sky130_fd_sc_hd__a22oi_1_4 r0 *1 0,0
Xsky130_fd_sc_hd__a22oi_1_4 bus_rdata_r[3] \_1309_ \_1379_ net42 VGND VPWR VPWR
+ \_1380_ sky130_fd_sc_hd__a22oi_1
* cell instance sky130_fd_sc_hd__a22oi_1_5 r0 *1 0,0
Xsky130_fd_sc_hd__a22oi_1_5 \_0752_ \_0765_ \_0766_ \_0749_ VGND VPWR VPWR
+ \_0767_ sky130_fd_sc_hd__a22oi_1
* cell instance sky130_fd_sc_hd__a22oi_1_6 r0 *1 0,0
Xsky130_fd_sc_hd__a22oi_1_6 raw_sr[31] \_1400_ \_1418_ \_0143_ VGND VPWR VPWR
+ \_1292_ sky130_fd_sc_hd__a22oi_1
* cell instance sky130_fd_sc_hd__a22oi_1_7 r0 *1 0,0
Xsky130_fd_sc_hd__a22oi_1_7 raw_sr[25] \_0087_ \_0089_ \_1418_ VGND VPWR VPWR
+ \_0090_ sky130_fd_sc_hd__a22oi_1
* cell instance sky130_fd_sc_hd__a22oi_1_8 r0 *1 0,0
Xsky130_fd_sc_hd__a22oi_1_8 bus_rdata_r[14] \_1309_ \_1347_ net42 VGND VPWR
+ VPWR \_1348_ sky130_fd_sc_hd__a22oi_1
* cell instance sky130_fd_sc_hd__a22oi_1_9 r0 *1 0,0
Xsky130_fd_sc_hd__a22oi_1_9 \_0089_ \_0141_ \_0165_ raw_sr[9] VGND VPWR VPWR
+ \_0166_ sky130_fd_sc_hd__a22oi_1
* cell instance sky130_fd_sc_hd__a22oi_1_10 r0 *1 0,0
Xsky130_fd_sc_hd__a22oi_1_10 raw_sr[29] \_0061_ \_0063_ \_1418_ VGND VPWR VPWR
+ \_0064_ sky130_fd_sc_hd__a22oi_1
* cell instance sky130_fd_sc_hd__a22oi_1_11 r0 *1 0,0
Xsky130_fd_sc_hd__a22oi_1_11 \_0083_ \_0141_ \_0162_ raw_sr[10] VGND VPWR VPWR
+ \_0163_ sky130_fd_sc_hd__a22oi_1
* cell instance sky130_fd_sc_hd__a22oi_1_12 r0 *1 0,0
Xsky130_fd_sc_hd__a22oi_1_12 raw_sr[26] \_0081_ \_0083_ \_1418_ VGND VPWR VPWR
+ \_0084_ sky130_fd_sc_hd__a22oi_1
* cell instance sky130_fd_sc_hd__a22oi_1_13 r0 *1 0,0
Xsky130_fd_sc_hd__a22oi_1_13 \_0063_ \_0141_ \_0150_ raw_sr[13] VGND VPWR VPWR
+ \_0151_ sky130_fd_sc_hd__a22oi_1
* cell instance sky130_fd_sc_hd__a22oi_1_14 r0 *1 0,0
Xsky130_fd_sc_hd__a22oi_1_14 \_0141_ \_0143_ \_0144_ raw_sr[15] VGND VPWR VPWR
+ \_0145_ sky130_fd_sc_hd__a22oi_1
* cell instance sky130_fd_sc_hd__a22oi_1_15 r0 *1 0,0
Xsky130_fd_sc_hd__a22oi_1_15 \_0077_ \_0141_ \_0159_ raw_sr[11] VGND VPWR VPWR
+ \_0160_ sky130_fd_sc_hd__a22oi_1
* cell instance sky130_fd_sc_hd__a22oi_1_16 r0 *1 0,0
Xsky130_fd_sc_hd__a22oi_1_16 raw_sr[27] \_0076_ \_0077_ \_1418_ VGND VPWR VPWR
+ \_0078_ sky130_fd_sc_hd__a22oi_1
* cell instance sky130_fd_sc_hd__a22oi_1_17 r0 *1 0,0
Xsky130_fd_sc_hd__a22oi_1_17 \_1426_ \_0141_ \_0147_ raw_sr[14] VGND VPWR VPWR
+ \_0148_ sky130_fd_sc_hd__a22oi_1
* cell instance sky130_fd_sc_hd__a22oi_1_18 r0 *1 0,0
Xsky130_fd_sc_hd__a22oi_1_18 raw_sr[30] \_1419_ \_1426_ \_1418_ VGND VPWR VPWR
+ \_1428_ sky130_fd_sc_hd__a22oi_1
* cell instance sky130_fd_sc_hd__a22oi_1_19 r0 *1 0,0
Xsky130_fd_sc_hd__a22oi_1_19 cond_count[11] net40 \_0381_ \_0628_ VGND VPWR
+ VPWR \_0629_ sky130_fd_sc_hd__a22oi_1
* cell instance sky130_fd_sc_hd__a22oi_1_20 r0 *1 0,0
Xsky130_fd_sc_hd__a22oi_1_20 cond_count[14] net40 \_0381_ \_0619_ VGND VPWR
+ VPWR \_0620_ sky130_fd_sc_hd__a22oi_1
* cell instance sky130_fd_sc_hd__a22oi_1_21 r0 *1 0,0
Xsky130_fd_sc_hd__a22oi_1_21 cond_count[15] net40 \_0381_ \_1288_ VGND VPWR
+ VPWR \_1289_ sky130_fd_sc_hd__a22oi_1
* cell instance sky130_fd_sc_hd__a22oi_1_22 r0 *1 0,0
Xsky130_fd_sc_hd__a22oi_1_22 cond_count[12] net40 \_0381_ \_0625_ VGND VPWR
+ VPWR \_0626_ sky130_fd_sc_hd__a22oi_1
* cell instance sky130_fd_sc_hd__a22oi_1_23 r0 *1 0,0
Xsky130_fd_sc_hd__a22oi_1_23 startup_count[13] net40 \_0381_ \_0495_ VGND VPWR
+ VPWR \_0496_ sky130_fd_sc_hd__a22oi_1
* cell instance sky130_fd_sc_hd__a22oi_1_24 r0 *1 0,0
Xsky130_fd_sc_hd__a22oi_1_24 apt_matches[13] net40 \_0442_ \_0443_ VGND VPWR
+ VPWR \_0444_ sky130_fd_sc_hd__a22oi_1
* cell instance sky130_fd_sc_hd__a22oi_1_25 r0 *1 0,0
Xsky130_fd_sc_hd__a22oi_1_25 startup_count[8] net40 \_0381_ \_0516_ VGND VPWR
+ VPWR \_0517_ sky130_fd_sc_hd__a22oi_1
* cell instance sky130_fd_sc_hd__a22oi_1_26 r0 *1 0,0
Xsky130_fd_sc_hd__a22oi_1_26 startup_count[11] net40 \_0381_ \_0503_ VGND VPWR
+ VPWR \_0504_ sky130_fd_sc_hd__a22oi_1
* cell instance sky130_fd_sc_hd__a22oi_1_27 r0 *1 0,0
Xsky130_fd_sc_hd__a22oi_1_27 startup_count[14] net40 \_0381_ \_0488_ VGND VPWR
+ VPWR \_0489_ sky130_fd_sc_hd__a22oi_1
* cell instance sky130_fd_sc_hd__a22oi_1_28 r0 *1 0,0
Xsky130_fd_sc_hd__a22oi_1_28 apt_matches[1] net40 \_0443_ \_0470_ VGND VPWR
+ VPWR \_0471_ sky130_fd_sc_hd__a22oi_1
* cell instance sky130_fd_sc_hd__a22oi_1_29 r0 *1 0,0
Xsky130_fd_sc_hd__a22oi_1_29 rct_count[0] net40 \_0381_ \_0400_ VGND VPWR VPWR
+ \_0401_ sky130_fd_sc_hd__a22oi_1
* cell instance sky130_fd_sc_hd__a22oi_1_30 r0 *1 0,0
Xsky130_fd_sc_hd__a22oi_1_30 apt_matches[8] net40 \_0453_ \_0443_ VGND VPWR
+ VPWR \_0454_ sky130_fd_sc_hd__a22oi_1
* cell instance sky130_fd_sc_hd__a22oi_1_31 r0 *1 0,0
Xsky130_fd_sc_hd__a22oi_1_31 rct_count[2] net40 \_0381_ \_0396_ VGND VPWR VPWR
+ \_0397_ sky130_fd_sc_hd__a22oi_1
* cell instance sky130_fd_sc_hd__a22oi_1_32 r0 *1 0,0
Xsky130_fd_sc_hd__a22oi_1_32 apt_matches[7] net40 \_0455_ \_0443_ VGND VPWR
+ VPWR \_0456_ sky130_fd_sc_hd__a22oi_1
* cell instance sky130_fd_sc_hd__a22oi_1_33 r0 *1 0,0
Xsky130_fd_sc_hd__a22oi_1_33 rct_count[6] net40 \_0310_ \_0381_ VGND VPWR VPWR
+ \_0383_ sky130_fd_sc_hd__a22oi_1
* cell instance sky130_fd_sc_hd__a22oi_1_34 r0 *1 0,0
Xsky130_fd_sc_hd__a22oi_1_34 apt_matches[4] net40 \_0443_ \_0462_ VGND VPWR
+ VPWR \_0463_ sky130_fd_sc_hd__a22oi_1
* cell instance sky130_fd_sc_hd__a22oi_1_35 r0 *1 0,0
Xsky130_fd_sc_hd__a22oi_1_35 rct_count[5] net40 \_0381_ \_0386_ VGND VPWR VPWR
+ \_0387_ sky130_fd_sc_hd__a22oi_1
* cell instance sky130_fd_sc_hd__a22oi_1_36 r0 *1 0,0
Xsky130_fd_sc_hd__a22oi_1_36 apt_matches[3] net40 \_0464_ \_0443_ VGND VPWR
+ VPWR \_0465_ sky130_fd_sc_hd__a22oi_1
* cell instance sky130_fd_sc_hd__a22oi_1_37 r0 *1 0,0
Xsky130_fd_sc_hd__a22oi_1_37 rct_count[4] net40 \_0381_ \_0390_ VGND VPWR VPWR
+ \_0391_ sky130_fd_sc_hd__a22oi_1
* cell instance sky130_fd_sc_hd__a22oi_1_38 r0 *1 0,0
Xsky130_fd_sc_hd__a22oi_1_38 apt_matches[5] net40 \_0460_ \_0443_ VGND VPWR
+ VPWR \_0461_ sky130_fd_sc_hd__a22oi_1
* cell instance sky130_fd_sc_hd__a311o_1_0 r0 *1 0,0
Xsky130_fd_sc_hd__a311o_1_0 cond_level[0] \_0200_ net30 \_0744_ \_0775_ VGND
+ VPWR VPWR \_0776_ sky130_fd_sc_hd__a311o_1
* cell instance sky130_fd_sc_hd__a311oi_1_0 r0 *1 0,0
Xsky130_fd_sc_hd__a311oi_1_0 \_0336_ \_0338_ \_0362_ \_0379_ net40 VGND VPWR
+ VPWR \_0407_ sky130_fd_sc_hd__a311oi_1
* cell instance sky130_fd_sc_hd__a31o_2_0 r0 *1 0,0
Xsky130_fd_sc_hd__a31o_2_0 apt_matches[9] apt_matches[10] \_0332_
+ apt_matches[11] VGND VPWR VPWR \_0342_ sky130_fd_sc_hd__a31o_2
* cell instance sky130_fd_sc_hd__a31oi_1_0 r0 *1 0,0
Xsky130_fd_sc_hd__a31oi_1_0 raw_level[2] \_1401_ \_0746_ raw_ovf VGND VPWR VPWR
+ \_0747_ sky130_fd_sc_hd__a31oi_1
* cell instance sky130_fd_sc_hd__a31oi_1_1 r0 *1 0,0
Xsky130_fd_sc_hd__a31oi_1_1 \_0220_ net35 \_0744_ cond_ovf VGND VPWR VPWR
+ \_0745_ sky130_fd_sc_hd__a31oi_1
* cell instance sky130_fd_sc_hd__a31oi_1_2 r0 *1 0,0
Xsky130_fd_sc_hd__a31oi_1_2 cond_count[9] cond_count[10] \_0206_ cond_count[11]
+ VGND VPWR VPWR \_0208_ sky130_fd_sc_hd__a31oi_1
* cell instance sky130_fd_sc_hd__a31oi_1_3 r0 *1 0,0
Xsky130_fd_sc_hd__a31oi_1_3 \_0336_ \_0338_ \_0362_ \_0379_ VGND VPWR VPWR
+ \_0380_ sky130_fd_sc_hd__a31oi_1
* cell instance sky130_fd_sc_hd__a31oi_1_4 r0 *1 0,0
Xsky130_fd_sc_hd__a31oi_1_4 apt_matches[1] apt_matches[0] \_0328_
+ apt_matches[2] VGND VPWR VPWR \_0466_ sky130_fd_sc_hd__a31oi_1
* cell instance sky130_fd_sc_hd__a31oi_1_5 r0 *1 0,0
Xsky130_fd_sc_hd__a31oi_1_5 apt_matches[6] apt_matches[7] \_0330_
+ apt_matches[8] VGND VPWR VPWR \_0357_ sky130_fd_sc_hd__a31oi_1
* cell instance sky130_fd_sc_hd__a31oi_1_6 r0 *1 0,0
Xsky130_fd_sc_hd__a31oi_1_6 apt_index[1] apt_index[0] \_0311_ apt_index[2] VGND
+ VPWR VPWR \_0435_ sky130_fd_sc_hd__a31oi_1
* cell instance sky130_fd_sc_hd__a32o_1_0 r0 *1 0,0
Xsky130_fd_sc_hd__a32o_1_0 net42 \_0774_ \_1343_ \_0894_ \_0761_ VGND VPWR VPWR
+ \_1349_ sky130_fd_sc_hd__a32o_1
* cell instance sky130_fd_sc_hd__a32oi_1_0 r0 *1 0,0
Xsky130_fd_sc_hd__a32oi_1_0 \_0634_ \_0381_ \_0636_ net40 cond_count[8] VGND
+ VPWR VPWR \_0637_ sky130_fd_sc_hd__a32oi_1
* cell instance sky130_fd_sc_hd__a32oi_1_1 r0 *1 0,0
Xsky130_fd_sc_hd__a32oi_1_1 \_0381_ \_0505_ \_0507_ net40 startup_count[10]
+ VGND VPWR VPWR \_0508_ sky130_fd_sc_hd__a32oi_1
* cell instance sky130_fd_sc_hd__a32oi_1_2 r0 *1 0,0
Xsky130_fd_sc_hd__a32oi_1_2 \_0360_ \_0359_ \_0443_ net40 apt_matches[10] VGND
+ VPWR VPWR \_0448_ sky130_fd_sc_hd__a32oi_1
* cell instance sky130_fd_sc_hd__a32oi_1_3 r0 *1 0,0
Xsky130_fd_sc_hd__a32oi_1_3 \_0341_ \_0342_ \_0443_ net40 apt_matches[11] VGND
+ VPWR VPWR \_0447_ sky130_fd_sc_hd__a32oi_1
* cell instance sky130_fd_sc_hd__a32oi_1_4 r0 *1 0,0
Xsky130_fd_sc_hd__a32oi_1_4 \_0313_ \_0381_ \_0398_ net40 rct_count[1] VGND
+ VPWR VPWR \_0399_ sky130_fd_sc_hd__a32oi_1
* cell instance sky130_fd_sc_hd__a32oi_1_5 r0 *1 0,0
Xsky130_fd_sc_hd__a32oi_1_5 \_0313_ \_0317_ \_0321_ \_0310_ \_0325_ VGND VPWR
+ VPWR \_0326_ sky130_fd_sc_hd__a32oi_1
* cell instance sky130_fd_sc_hd__and2_1_0 r0 *1 0,0
Xsky130_fd_sc_hd__and2_1_0 \_0757_ \_0809_ VGND VPWR VPWR \_0810_
+ sky130_fd_sc_hd__and2_1
* cell instance sky130_fd_sc_hd__and2_1_1 r0 *1 0,0
Xsky130_fd_sc_hd__and2_1_1 ctrl[2] \_0291_ VGND VPWR VPWR \_0014_[2]
+ sky130_fd_sc_hd__and2_1
* cell instance sky130_fd_sc_hd__and2_1_2 r0 *1 0,0
Xsky130_fd_sc_hd__and2_1_2 ctrl[0] raw_valid VGND VPWR VPWR \_0311_
+ sky130_fd_sc_hd__and2_1
* cell instance sky130_fd_sc_hd__and2_1_3 r0 *1 0,0
Xsky130_fd_sc_hd__and2_1_3 \_0705_ \_0773_ VGND VPWR VPWR \_0774_
+ sky130_fd_sc_hd__and2_1
* cell instance sky130_fd_sc_hd__and2_1_4 r0 *1 0,0
Xsky130_fd_sc_hd__and2_1_4 raw_count[5] \_0721_ VGND VPWR VPWR \_0015_[5]
+ sky130_fd_sc_hd__and2_1
* cell instance sky130_fd_sc_hd__and2_1_5 r0 *1 0,0
Xsky130_fd_sc_hd__and2_1_5 startup_done_r \_0199_ VGND VPWR VPWR \_0200_
+ sky130_fd_sc_hd__and2_1
* cell instance sky130_fd_sc_hd__and2_1_6 r0 *1 0,0
Xsky130_fd_sc_hd__and2_1_6 \_0209_ \_0219_ VGND VPWR VPWR \_0220_
+ sky130_fd_sc_hd__and2_1
* cell instance sky130_fd_sc_hd__and2_1_7 r0 *1 0,0
Xsky130_fd_sc_hd__and2_1_7 raw_sr[7] net40 VGND VPWR VPWR \_0703_
+ sky130_fd_sc_hd__and2_1
* cell instance sky130_fd_sc_hd__and2_1_8 r0 *1 0,0
Xsky130_fd_sc_hd__and2_1_8 \_0478_ \_0483_ VGND VPWR VPWR \_0506_
+ sky130_fd_sc_hd__and2_1
* cell instance sky130_fd_sc_hd__and2_1_9 r0 *1 0,0
Xsky130_fd_sc_hd__and2_1_9 startup_count[0] \_0509_ VGND VPWR VPWR \_0522_
+ sky130_fd_sc_hd__and2_1
* cell instance sky130_fd_sc_hd__and2_1_10 r0 *1 0,0
Xsky130_fd_sc_hd__and2_1_10 rct_armed \_0308_ VGND VPWR VPWR \_0313_
+ sky130_fd_sc_hd__and2_1
* cell instance sky130_fd_sc_hd__and2_1_11 r0 *1 0,0
Xsky130_fd_sc_hd__and2_1_11 \_0311_ \_0372_ VGND VPWR VPWR \_0410_
+ sky130_fd_sc_hd__and2_1
* cell instance sky130_fd_sc_hd__and2_1_12 r0 *1 0,0
Xsky130_fd_sc_hd__and2_1_12 apt_matches[3] \_0329_ VGND VPWR VPWR \_0346_
+ sky130_fd_sc_hd__and2_1
* cell instance sky130_fd_sc_hd__and2_1_13 r0 *1 0,0
Xsky130_fd_sc_hd__and2_1_13 apt_index[6] \_0422_ VGND VPWR VPWR \_0423_
+ sky130_fd_sc_hd__and2_1
* cell instance sky130_fd_sc_hd__and3_1_0 r0 *1 0,0
Xsky130_fd_sc_hd__and3_1_0 cond_count[1] cond_count[0] net35 VGND VPWR VPWR
+ \_0640_ sky130_fd_sc_hd__and3_1
* cell instance sky130_fd_sc_hd__and3_1_1 r0 *1 0,0
Xsky130_fd_sc_hd__and3_1_1 cond_count[9] \_0206_ net35 VGND VPWR VPWR \_0631_
+ sky130_fd_sc_hd__and3_1
* cell instance sky130_fd_sc_hd__and3_1_2 r0 *1 0,0
Xsky130_fd_sc_hd__and3_1_2 cond_count[2] cond_count[3] \_0640_ VGND VPWR VPWR
+ \_0641_ sky130_fd_sc_hd__and3_1
* cell instance sky130_fd_sc_hd__and3_1_3 r0 *1 0,0
Xsky130_fd_sc_hd__and3_1_3 startup_count[6] startup_count[5] \_0510_ VGND VPWR
+ VPWR \_0511_ sky130_fd_sc_hd__and3_1
* cell instance sky130_fd_sc_hd__and3_1_4 r0 *1 0,0
Xsky130_fd_sc_hd__and3_1_4 startup_count[4] \_0479_ \_0509_ VGND VPWR VPWR
+ \_0510_ sky130_fd_sc_hd__and3_1
* cell instance sky130_fd_sc_hd__and3_1_5 r0 *1 0,0
Xsky130_fd_sc_hd__and3_1_5 apt_matches[12] apt_matches[13] \_0334_ VGND VPWR
+ VPWR \_0337_ sky130_fd_sc_hd__and3_1
* cell instance sky130_fd_sc_hd__and3_1_6 r0 *1 0,0
Xsky130_fd_sc_hd__and3_1_6 startup_count[2] startup_count[1] \_0522_ VGND VPWR
+ VPWR \_0523_ sky130_fd_sc_hd__and3_1
* cell instance sky130_fd_sc_hd__and3_1_7 r0 *1 0,0
Xsky130_fd_sc_hd__and3_1_7 rct_count[7] net40 \_0295_ VGND VPWR VPWR \_0024_[7]
+ sky130_fd_sc_hd__and3_1
* cell instance sky130_fd_sc_hd__and3_1_8 r0 *1 0,0
Xsky130_fd_sc_hd__and3_1_8 rct_count[15] net40 \_0295_ VGND VPWR VPWR
+ \_0024_[15] sky130_fd_sc_hd__and3_1
* cell instance sky130_fd_sc_hd__and3_1_9 r0 *1 0,0
Xsky130_fd_sc_hd__and3_1_9 rct_count[10] net40 \_0295_ VGND VPWR VPWR
+ \_0024_[10] sky130_fd_sc_hd__and3_1
* cell instance sky130_fd_sc_hd__and3_1_10 r0 *1 0,0
Xsky130_fd_sc_hd__and3_1_10 rct_count[11] net40 \_0295_ VGND VPWR VPWR
+ \_0024_[11] sky130_fd_sc_hd__and3_1
* cell instance sky130_fd_sc_hd__and3_1_11 r0 *1 0,0
Xsky130_fd_sc_hd__and3_1_11 rct_count[1] rct_count[0] rct_count[2] VGND VPWR
+ VPWR \_0304_ sky130_fd_sc_hd__and3_1
* cell instance sky130_fd_sc_hd__and3_1_12 r0 *1 0,0
Xsky130_fd_sc_hd__and3_1_12 apt_matches[6] apt_matches[7] \_0330_ VGND VPWR
+ VPWR \_0343_ sky130_fd_sc_hd__and3_1
* cell instance sky130_fd_sc_hd__and3_1_13 r0 *1 0,0
Xsky130_fd_sc_hd__and3_1_13 rct_count[9] net40 \_0295_ VGND VPWR VPWR
+ \_0024_[9] sky130_fd_sc_hd__and3_1
* cell instance sky130_fd_sc_hd__and3_1_14 r0 *1 0,0
Xsky130_fd_sc_hd__and3_1_14 rct_count[6] rct_count[5] \_0305_ VGND VPWR VPWR
+ \_0306_ sky130_fd_sc_hd__and3_1
* cell instance sky130_fd_sc_hd__and3_1_15 r0 *1 0,0
Xsky130_fd_sc_hd__and3_1_15 rct_count[3] rct_count[4] \_0304_ VGND VPWR VPWR
+ \_0305_ sky130_fd_sc_hd__and3_1
* cell instance sky130_fd_sc_hd__and3_1_16 r0 *1 0,0
Xsky130_fd_sc_hd__and3_1_16 rct_count[12] net40 \_0295_ VGND VPWR VPWR
+ \_0024_[12] sky130_fd_sc_hd__and3_1
* cell instance sky130_fd_sc_hd__and3_1_17 r0 *1 0,0
Xsky130_fd_sc_hd__and3_1_17 apt_index[8] apt_index[7] \_0423_ VGND VPWR VPWR
+ \_0424_ sky130_fd_sc_hd__and3_1
* cell instance sky130_fd_sc_hd__and3_1_18 r0 *1 0,0
Xsky130_fd_sc_hd__and3_1_18 rct_count[13] net40 \_0295_ VGND VPWR VPWR
+ \_0024_[13] sky130_fd_sc_hd__and3_1
* cell instance sky130_fd_sc_hd__and3_1_19 r0 *1 0,0
Xsky130_fd_sc_hd__and3_1_19 rct_count[14] net40 \_0295_ VGND VPWR VPWR
+ \_0024_[14] sky130_fd_sc_hd__and3_1
* cell instance sky130_fd_sc_hd__and3_1_20 r0 *1 0,0
Xsky130_fd_sc_hd__and3_1_20 rct_count[8] net40 \_0295_ VGND VPWR VPWR
+ \_0024_[8] sky130_fd_sc_hd__and3_1
* cell instance sky130_fd_sc_hd__and3_1_21 r0 *1 0,0
Xsky130_fd_sc_hd__and3_1_21 apt_index[5] apt_index[4] \_0421_ VGND VPWR VPWR
+ \_0422_ sky130_fd_sc_hd__and3_1
* cell instance sky130_fd_sc_hd__and3b_1_0 r0 *1 0,0
Xsky130_fd_sc_hd__and3b_1_0 raw_count[1] raw_count[0] raw_count[2] VGND VPWR
+ VPWR \_0060_ sky130_fd_sc_hd__and3b_1
* cell instance sky130_fd_sc_hd__and3b_1_1 r0 *1 0,0
Xsky130_fd_sc_hd__and3b_1_1 raw_count[0] raw_count[2] raw_count[1] VGND VPWR
+ VPWR \_1410_ sky130_fd_sc_hd__and3b_1
* cell instance sky130_fd_sc_hd__and3b_1_2 r0 *1 0,0
Xsky130_fd_sc_hd__and3b_1_2 \_0644_ \_0545_ \_0642_ VGND VPWR VPWR \_0006_[5]
+ sky130_fd_sc_hd__and3b_1
* cell instance sky130_fd_sc_hd__and4_1_0 r0 *1 0,0
Xsky130_fd_sc_hd__and4_1_0 net42 \_0779_ \_0783_ \_0787_ VGND VPWR VPWR \_0788_
+ sky130_fd_sc_hd__and4_1
* cell instance sky130_fd_sc_hd__and4_1_1 r0 *1 0,0
Xsky130_fd_sc_hd__and4_1_1 \_0211_ \_0213_ \_0215_ \_0218_ VGND VPWR VPWR
+ \_0219_ sky130_fd_sc_hd__and4_1
* cell instance sky130_fd_sc_hd__and4_1_2 r0 *1 0,0
Xsky130_fd_sc_hd__and4_1_2 cond_count[11] cond_count[9] cond_count[10] \_0206_
+ VGND VPWR VPWR \_0207_ sky130_fd_sc_hd__and4_1
* cell instance sky130_fd_sc_hd__and4_1_3 r0 *1 0,0
Xsky130_fd_sc_hd__and4_1_3 apt_matches[9] apt_matches[10] apt_matches[11]
+ \_0332_ VGND VPWR VPWR \_0334_ sky130_fd_sc_hd__and4_1
* cell instance sky130_fd_sc_hd__and4_1_4 r0 *1 0,0
Xsky130_fd_sc_hd__and4_1_4 startup_count[2] startup_count[1] startup_count[3]
+ startup_count[0] VGND VPWR VPWR \_0479_ sky130_fd_sc_hd__and4_1
* cell instance sky130_fd_sc_hd__and4_1_5 r0 *1 0,0
Xsky130_fd_sc_hd__and4_1_5 apt_matches[2] apt_matches[1] apt_matches[0] \_0328_
+ VGND VPWR VPWR \_0329_ sky130_fd_sc_hd__and4_1
* cell instance sky130_fd_sc_hd__and4_1_6 r0 *1 0,0
Xsky130_fd_sc_hd__and4_1_6 apt_matches[6] apt_matches[7] apt_matches[8] \_0330_
+ VGND VPWR VPWR \_0332_ sky130_fd_sc_hd__and4_1
* cell instance sky130_fd_sc_hd__and4_1_7 r0 *1 0,0
Xsky130_fd_sc_hd__and4_1_7 apt_matches[5] apt_matches[4] apt_matches[3] \_0329_
+ VGND VPWR VPWR \_0330_ sky130_fd_sc_hd__and4_1
* cell instance sky130_fd_sc_hd__and4b_1_0 r0 *1 0,0
Xsky130_fd_sc_hd__and4b_1_0 \_0532_ \_0215_ \_0213_ \_0211_ VGND VPWR VPWR
+ \_0533_ sky130_fd_sc_hd__and4b_1
* cell instance sky130_fd_sc_hd__buf_4_0 r0 *1 0,0
Xsky130_fd_sc_hd__buf_4_0 clknet_3_0__leaf_clk VGND VPWR VPWR
+ clknet_leaf_65_clk sky130_fd_sc_hd__buf_4
* cell instance sky130_fd_sc_hd__buf_4_1 r0 *1 0,0
Xsky130_fd_sc_hd__buf_4_1 \_0755_ VGND VPWR VPWR net42 sky130_fd_sc_hd__buf_4
* cell instance sky130_fd_sc_hd__buf_4_2 r0 *1 0,0
Xsky130_fd_sc_hd__buf_4_2 clknet_3_0__leaf_clk VGND VPWR VPWR
+ clknet_leaf_63_clk sky130_fd_sc_hd__buf_4
* cell instance sky130_fd_sc_hd__buf_4_3 r0 *1 0,0
Xsky130_fd_sc_hd__buf_4_3 clknet_3_1__leaf_clk VGND VPWR VPWR clknet_leaf_3_clk
+ sky130_fd_sc_hd__buf_4
* cell instance sky130_fd_sc_hd__buf_4_4 r0 *1 0,0
Xsky130_fd_sc_hd__buf_4_4 \_1421_ VGND VPWR VPWR net43 sky130_fd_sc_hd__buf_4
* cell instance sky130_fd_sc_hd__buf_4_5 r0 *1 0,0
Xsky130_fd_sc_hd__buf_4_5 clknet_3_5__leaf_clk VGND VPWR VPWR
+ clknet_leaf_18_clk sky130_fd_sc_hd__buf_4
* cell instance sky130_fd_sc_hd__buf_4_6 r0 *1 0,0
Xsky130_fd_sc_hd__buf_4_6 clknet_3_4__leaf_clk VGND VPWR VPWR
+ clknet_leaf_12_clk sky130_fd_sc_hd__buf_4
* cell instance sky130_fd_sc_hd__buf_4_7 r0 *1 0,0
Xsky130_fd_sc_hd__buf_4_7 clknet_3_0__leaf_clk VGND VPWR VPWR
+ clknet_leaf_64_clk sky130_fd_sc_hd__buf_4
* cell instance sky130_fd_sc_hd__buf_4_8 r0 *1 0,0
Xsky130_fd_sc_hd__buf_4_8 clknet_3_4__leaf_clk VGND VPWR VPWR
+ clknet_leaf_16_clk sky130_fd_sc_hd__buf_4
* cell instance sky130_fd_sc_hd__buf_4_9 r0 *1 0,0
Xsky130_fd_sc_hd__buf_4_9 clknet_3_4__leaf_clk VGND VPWR VPWR
+ clknet_leaf_13_clk sky130_fd_sc_hd__buf_4
* cell instance sky130_fd_sc_hd__buf_4_10 r0 *1 0,0
Xsky130_fd_sc_hd__buf_4_10 clknet_3_5__leaf_clk VGND VPWR VPWR
+ clknet_leaf_17_clk sky130_fd_sc_hd__buf_4
* cell instance sky130_fd_sc_hd__buf_4_11 r0 *1 0,0
Xsky130_fd_sc_hd__buf_4_11 clknet_3_1__leaf_clk VGND VPWR VPWR
+ clknet_leaf_2_clk sky130_fd_sc_hd__buf_4
* cell instance sky130_fd_sc_hd__buf_4_12 r0 *1 0,0
Xsky130_fd_sc_hd__buf_4_12 clknet_3_1__leaf_clk VGND VPWR VPWR
+ clknet_leaf_4_clk sky130_fd_sc_hd__buf_4
* cell instance sky130_fd_sc_hd__buf_4_13 r0 *1 0,0
Xsky130_fd_sc_hd__buf_4_13 clknet_3_0__leaf_clk VGND VPWR VPWR
+ clknet_leaf_62_clk sky130_fd_sc_hd__buf_4
* cell instance sky130_fd_sc_hd__buf_4_14 r0 *1 0,0
Xsky130_fd_sc_hd__buf_4_14 clknet_3_4__leaf_clk VGND VPWR VPWR
+ clknet_leaf_14_clk sky130_fd_sc_hd__buf_4
* cell instance sky130_fd_sc_hd__buf_4_15 r0 *1 0,0
Xsky130_fd_sc_hd__buf_4_15 clknet_3_0__leaf_clk VGND VPWR VPWR
+ clknet_leaf_0_clk sky130_fd_sc_hd__buf_4
* cell instance sky130_fd_sc_hd__buf_4_16 r0 *1 0,0
Xsky130_fd_sc_hd__buf_4_16 clknet_3_4__leaf_clk VGND VPWR VPWR
+ clknet_leaf_15_clk sky130_fd_sc_hd__buf_4
* cell instance sky130_fd_sc_hd__buf_4_17 r0 *1 0,0
Xsky130_fd_sc_hd__buf_4_17 clknet_3_4__leaf_clk VGND VPWR VPWR
+ clknet_leaf_11_clk sky130_fd_sc_hd__buf_4
* cell instance sky130_fd_sc_hd__buf_4_18 r0 *1 0,0
Xsky130_fd_sc_hd__buf_4_18 clknet_3_5__leaf_clk VGND VPWR VPWR
+ clknet_leaf_19_clk sky130_fd_sc_hd__buf_4
* cell instance sky130_fd_sc_hd__buf_4_19 r0 *1 0,0
Xsky130_fd_sc_hd__buf_4_19 clknet_3_1__leaf_clk VGND VPWR VPWR
+ clknet_leaf_1_clk sky130_fd_sc_hd__buf_4
* cell instance sky130_fd_sc_hd__buf_4_20 r0 *1 0,0
Xsky130_fd_sc_hd__buf_4_20 clknet_0_clk VGND VPWR VPWR clknet_3_1__leaf_clk
+ sky130_fd_sc_hd__buf_4
* cell instance sky130_fd_sc_hd__buf_4_21 r0 *1 0,0
Xsky130_fd_sc_hd__buf_4_21 clknet_0_clk VGND VPWR VPWR clknet_3_4__leaf_clk
+ sky130_fd_sc_hd__buf_4
* cell instance sky130_fd_sc_hd__buf_4_22 r0 *1 0,0
Xsky130_fd_sc_hd__buf_4_22 clknet_3_1__leaf_clk VGND VPWR VPWR
+ clknet_leaf_60_clk sky130_fd_sc_hd__buf_4
* cell instance sky130_fd_sc_hd__buf_4_23 r0 *1 0,0
Xsky130_fd_sc_hd__buf_4_23 \_1309_ VGND VPWR VPWR net36 sky130_fd_sc_hd__buf_4
* cell instance sky130_fd_sc_hd__buf_4_24 r0 *1 0,0
Xsky130_fd_sc_hd__buf_4_24 clknet_3_0__leaf_clk VGND VPWR VPWR
+ clknet_leaf_61_clk sky130_fd_sc_hd__buf_4
* cell instance sky130_fd_sc_hd__buf_4_25 r0 *1 0,0
Xsky130_fd_sc_hd__buf_4_25 clknet_3_4__leaf_clk VGND VPWR VPWR
+ clknet_leaf_10_clk sky130_fd_sc_hd__buf_4
* cell instance sky130_fd_sc_hd__buf_4_26 r0 *1 0,0
Xsky130_fd_sc_hd__buf_4_26 clknet_3_5__leaf_clk VGND VPWR VPWR
+ clknet_leaf_20_clk sky130_fd_sc_hd__buf_4
* cell instance sky130_fd_sc_hd__buf_4_27 r0 *1 0,0
Xsky130_fd_sc_hd__buf_4_27 clknet_0_clk VGND VPWR VPWR clknet_3_0__leaf_clk
+ sky130_fd_sc_hd__buf_4
* cell instance sky130_fd_sc_hd__buf_4_28 r0 *1 0,0
Xsky130_fd_sc_hd__buf_4_28 \_0232_ VGND VPWR VPWR net39 sky130_fd_sc_hd__buf_4
* cell instance sky130_fd_sc_hd__buf_4_29 r0 *1 0,0
Xsky130_fd_sc_hd__buf_4_29 \_0300_ VGND VPWR VPWR net38 sky130_fd_sc_hd__buf_4
* cell instance sky130_fd_sc_hd__buf_4_30 r0 *1 0,0
Xsky130_fd_sc_hd__buf_4_30 clknet_3_1__leaf_clk VGND VPWR VPWR
+ clknet_leaf_5_clk sky130_fd_sc_hd__buf_4
* cell instance sky130_fd_sc_hd__buf_4_31 r0 *1 0,0
Xsky130_fd_sc_hd__buf_4_31 clknet_0_clk VGND VPWR VPWR clknet_3_5__leaf_clk
+ sky130_fd_sc_hd__buf_4
* cell instance sky130_fd_sc_hd__buf_4_32 r0 *1 0,0
Xsky130_fd_sc_hd__buf_4_32 clknet_3_5__leaf_clk VGND VPWR VPWR \$7058
+ sky130_fd_sc_hd__buf_4
* cell instance sky130_fd_sc_hd__buf_4_33 r0 *1 0,0
Xsky130_fd_sc_hd__buf_4_33 clknet_3_0__leaf_clk VGND VPWR VPWR
+ clknet_leaf_59_clk sky130_fd_sc_hd__buf_4
* cell instance sky130_fd_sc_hd__buf_4_34 r0 *1 0,0
Xsky130_fd_sc_hd__buf_4_34 clknet_3_4__leaf_clk VGND VPWR VPWR
+ clknet_leaf_9_clk sky130_fd_sc_hd__buf_4
* cell instance sky130_fd_sc_hd__buf_4_35 r0 *1 0,0
Xsky130_fd_sc_hd__buf_4_35 clknet_3_5__leaf_clk VGND VPWR VPWR
+ clknet_leaf_21_clk sky130_fd_sc_hd__buf_4
* cell instance sky130_fd_sc_hd__buf_4_36 r0 *1 0,0
Xsky130_fd_sc_hd__buf_4_36 clknet_3_5__leaf_clk VGND VPWR VPWR
+ clknet_leaf_22_clk sky130_fd_sc_hd__buf_4
* cell instance sky130_fd_sc_hd__buf_4_37 r0 *1 0,0
Xsky130_fd_sc_hd__buf_4_37 clknet_3_4__leaf_clk VGND VPWR VPWR
+ clknet_leaf_8_clk sky130_fd_sc_hd__buf_4
* cell instance sky130_fd_sc_hd__buf_4_38 r0 *1 0,0
Xsky130_fd_sc_hd__buf_4_38 clknet_3_0__leaf_clk VGND VPWR VPWR
+ clknet_leaf_58_clk sky130_fd_sc_hd__buf_4
* cell instance sky130_fd_sc_hd__buf_4_39 r0 *1 0,0
Xsky130_fd_sc_hd__buf_4_39 \_0812_ VGND VPWR VPWR net24 sky130_fd_sc_hd__buf_4
* cell instance sky130_fd_sc_hd__buf_4_40 r0 *1 0,0
Xsky130_fd_sc_hd__buf_4_40 \_0797_ VGND VPWR VPWR net31 sky130_fd_sc_hd__buf_4
* cell instance sky130_fd_sc_hd__buf_4_41 r0 *1 0,0
Xsky130_fd_sc_hd__buf_4_41 clknet_3_1__leaf_clk VGND VPWR VPWR
+ clknet_leaf_55_clk sky130_fd_sc_hd__buf_4
* cell instance sky130_fd_sc_hd__buf_4_42 r0 *1 0,0
Xsky130_fd_sc_hd__buf_4_42 net22 VGND VPWR VPWR net21 sky130_fd_sc_hd__buf_4
* cell instance sky130_fd_sc_hd__buf_4_43 r0 *1 0,0
Xsky130_fd_sc_hd__buf_4_43 \_0544_ VGND VPWR VPWR net34 sky130_fd_sc_hd__buf_4
* cell instance sky130_fd_sc_hd__buf_4_44 r0 *1 0,0
Xsky130_fd_sc_hd__buf_4_44 \_1078_ VGND VPWR VPWR net22 sky130_fd_sc_hd__buf_4
* cell instance sky130_fd_sc_hd__buf_4_45 r0 *1 0,0
Xsky130_fd_sc_hd__buf_4_45 clknet_3_1__leaf_clk VGND VPWR VPWR
+ clknet_leaf_6_clk sky130_fd_sc_hd__buf_4
* cell instance sky130_fd_sc_hd__buf_4_46 r0 *1 0,0
Xsky130_fd_sc_hd__buf_4_46 net24 VGND VPWR VPWR net23 sky130_fd_sc_hd__buf_4
* cell instance sky130_fd_sc_hd__buf_4_47 r0 *1 0,0
Xsky130_fd_sc_hd__buf_4_47 clknet_3_4__leaf_clk VGND VPWR VPWR
+ clknet_leaf_26_clk sky130_fd_sc_hd__buf_4
* cell instance sky130_fd_sc_hd__buf_4_48 r0 *1 0,0
Xsky130_fd_sc_hd__buf_4_48 \_1395_ VGND VPWR VPWR net40 sky130_fd_sc_hd__buf_4
* cell instance sky130_fd_sc_hd__buf_4_49 r0 *1 0,0
Xsky130_fd_sc_hd__buf_4_49 ctrl[1] VGND VPWR VPWR net41 sky130_fd_sc_hd__buf_4
* cell instance sky130_fd_sc_hd__buf_4_50 r0 *1 0,0
Xsky130_fd_sc_hd__buf_4_50 \_1402_ VGND VPWR VPWR net32 sky130_fd_sc_hd__buf_4
* cell instance sky130_fd_sc_hd__buf_4_51 r0 *1 0,0
Xsky130_fd_sc_hd__buf_4_51 \_0963_ VGND VPWR VPWR net33 sky130_fd_sc_hd__buf_4
* cell instance sky130_fd_sc_hd__buf_4_52 r0 *1 0,0
Xsky130_fd_sc_hd__buf_4_52 clknet_3_5__leaf_clk VGND VPWR VPWR
+ clknet_leaf_25_clk sky130_fd_sc_hd__buf_4
* cell instance sky130_fd_sc_hd__buf_4_53 r0 *1 0,0
Xsky130_fd_sc_hd__buf_4_53 clknet_3_0__leaf_clk VGND VPWR VPWR
+ clknet_leaf_56_clk sky130_fd_sc_hd__buf_4
* cell instance sky130_fd_sc_hd__buf_4_54 r0 *1 0,0
Xsky130_fd_sc_hd__buf_4_54 clknet_3_5__leaf_clk VGND VPWR VPWR
+ clknet_leaf_23_clk sky130_fd_sc_hd__buf_4
* cell instance sky130_fd_sc_hd__buf_4_55 r0 *1 0,0
Xsky130_fd_sc_hd__buf_4_55 clknet_3_3__leaf_clk VGND VPWR VPWR
+ clknet_leaf_54_clk sky130_fd_sc_hd__buf_4
* cell instance sky130_fd_sc_hd__buf_4_56 r0 *1 0,0
Xsky130_fd_sc_hd__buf_4_56 clknet_3_0__leaf_clk VGND VPWR VPWR
+ clknet_leaf_57_clk sky130_fd_sc_hd__buf_4
* cell instance sky130_fd_sc_hd__buf_4_57 r0 *1 0,0
Xsky130_fd_sc_hd__buf_4_57 clknet_3_6__leaf_clk VGND VPWR VPWR
+ clknet_leaf_7_clk sky130_fd_sc_hd__buf_4
* cell instance sky130_fd_sc_hd__buf_4_58 r0 *1 0,0
Xsky130_fd_sc_hd__buf_4_58 clknet_3_5__leaf_clk VGND VPWR VPWR
+ clknet_leaf_24_clk sky130_fd_sc_hd__buf_4
* cell instance sky130_fd_sc_hd__buf_4_59 r0 *1 0,0
Xsky130_fd_sc_hd__buf_4_59 clknet_3_7__leaf_clk VGND VPWR VPWR
+ clknet_leaf_27_clk sky130_fd_sc_hd__buf_4
* cell instance sky130_fd_sc_hd__buf_4_60 r0 *1 0,0
Xsky130_fd_sc_hd__buf_4_60 clk VGND VPWR VPWR clknet_0_clk
+ sky130_fd_sc_hd__buf_4
* cell instance sky130_fd_sc_hd__buf_4_61 r0 *1 0,0
Xsky130_fd_sc_hd__buf_4_61 \_1071_ VGND VPWR VPWR net28 sky130_fd_sc_hd__buf_4
* cell instance sky130_fd_sc_hd__buf_4_62 r0 *1 0,0
Xsky130_fd_sc_hd__buf_4_62 clknet_3_6__leaf_clk VGND VPWR VPWR
+ clknet_leaf_28_clk sky130_fd_sc_hd__buf_4
* cell instance sky130_fd_sc_hd__buf_4_63 r0 *1 0,0
Xsky130_fd_sc_hd__buf_4_63 clknet_3_3__leaf_clk VGND VPWR VPWR
+ clknet_leaf_53_clk sky130_fd_sc_hd__buf_4
* cell instance sky130_fd_sc_hd__buf_4_64 r0 *1 0,0
Xsky130_fd_sc_hd__buf_4_64 \_0222_ VGND VPWR VPWR net29 sky130_fd_sc_hd__buf_4
* cell instance sky130_fd_sc_hd__buf_4_65 r0 *1 0,0
Xsky130_fd_sc_hd__buf_4_65 clknet_3_7__leaf_clk VGND VPWR VPWR
+ clknet_leaf_32_clk sky130_fd_sc_hd__buf_4
* cell instance sky130_fd_sc_hd__buf_4_66 r0 *1 0,0
Xsky130_fd_sc_hd__buf_4_66 \_1074_ VGND VPWR VPWR net27 sky130_fd_sc_hd__buf_4
* cell instance sky130_fd_sc_hd__buf_4_67 r0 *1 0,0
Xsky130_fd_sc_hd__buf_4_67 \_1178_ VGND VPWR VPWR net26 sky130_fd_sc_hd__buf_4
* cell instance sky130_fd_sc_hd__buf_4_68 r0 *1 0,0
Xsky130_fd_sc_hd__buf_4_68 clknet_3_2__leaf_clk VGND VPWR VPWR
+ clknet_leaf_52_clk sky130_fd_sc_hd__buf_4
* cell instance sky130_fd_sc_hd__buf_4_69 r0 *1 0,0
Xsky130_fd_sc_hd__buf_4_69 clknet_3_7__leaf_clk VGND VPWR VPWR
+ clknet_leaf_31_clk sky130_fd_sc_hd__buf_4
* cell instance sky130_fd_sc_hd__buf_4_70 r0 *1 0,0
Xsky130_fd_sc_hd__buf_4_70 clknet_3_3__leaf_clk VGND VPWR VPWR
+ clknet_leaf_41_clk sky130_fd_sc_hd__buf_4
* cell instance sky130_fd_sc_hd__buf_4_71 r0 *1 0,0
Xsky130_fd_sc_hd__buf_4_71 clknet_3_7__leaf_clk VGND VPWR VPWR
+ clknet_leaf_29_clk sky130_fd_sc_hd__buf_4
* cell instance sky130_fd_sc_hd__buf_4_72 r0 *1 0,0
Xsky130_fd_sc_hd__buf_4_72 clknet_3_2__leaf_clk VGND VPWR VPWR
+ clknet_leaf_49_clk sky130_fd_sc_hd__buf_4
* cell instance sky130_fd_sc_hd__buf_4_73 r0 *1 0,0
Xsky130_fd_sc_hd__buf_4_73 clknet_3_7__leaf_clk VGND VPWR VPWR
+ clknet_leaf_33_clk sky130_fd_sc_hd__buf_4
* cell instance sky130_fd_sc_hd__buf_4_74 r0 *1 0,0
Xsky130_fd_sc_hd__buf_4_74 clknet_3_2__leaf_clk VGND VPWR VPWR
+ clknet_leaf_50_clk sky130_fd_sc_hd__buf_4
* cell instance sky130_fd_sc_hd__buf_4_75 r0 *1 0,0
Xsky130_fd_sc_hd__buf_4_75 clknet_0_clk VGND VPWR VPWR clknet_3_7__leaf_clk
+ sky130_fd_sc_hd__buf_4
* cell instance sky130_fd_sc_hd__buf_4_76 r0 *1 0,0
Xsky130_fd_sc_hd__buf_4_76 \_0545_ VGND VPWR VPWR net25 sky130_fd_sc_hd__buf_4
* cell instance sky130_fd_sc_hd__buf_4_77 r0 *1 0,0
Xsky130_fd_sc_hd__buf_4_77 \_0221_ VGND VPWR VPWR net35 sky130_fd_sc_hd__buf_4
* cell instance sky130_fd_sc_hd__buf_4_78 r0 *1 0,0
Xsky130_fd_sc_hd__buf_4_78 clknet_3_6__leaf_clk VGND VPWR VPWR
+ clknet_leaf_40_clk sky130_fd_sc_hd__buf_4
* cell instance sky130_fd_sc_hd__buf_4_79 r0 *1 0,0
Xsky130_fd_sc_hd__buf_4_79 clknet_3_2__leaf_clk VGND VPWR VPWR
+ clknet_leaf_51_clk sky130_fd_sc_hd__buf_4
* cell instance sky130_fd_sc_hd__buf_4_80 r0 *1 0,0
Xsky130_fd_sc_hd__buf_4_80 clknet_3_7__leaf_clk VGND VPWR VPWR
+ clknet_leaf_30_clk sky130_fd_sc_hd__buf_4
* cell instance sky130_fd_sc_hd__buf_4_81 r0 *1 0,0
Xsky130_fd_sc_hd__buf_4_81 clknet_0_clk VGND VPWR VPWR clknet_3_2__leaf_clk
+ sky130_fd_sc_hd__buf_4
* cell instance sky130_fd_sc_hd__buf_4_82 r0 *1 0,0
Xsky130_fd_sc_hd__buf_4_82 clknet_3_3__leaf_clk VGND VPWR VPWR
+ clknet_leaf_42_clk sky130_fd_sc_hd__buf_4
* cell instance sky130_fd_sc_hd__buf_4_83 r0 *1 0,0
Xsky130_fd_sc_hd__buf_4_83 \_0533_ VGND VPWR VPWR net30 sky130_fd_sc_hd__buf_4
* cell instance sky130_fd_sc_hd__buf_4_84 r0 *1 0,0
Xsky130_fd_sc_hd__buf_4_84 clknet_0_clk VGND VPWR VPWR clknet_3_3__leaf_clk
+ sky130_fd_sc_hd__buf_4
* cell instance sky130_fd_sc_hd__buf_4_85 r0 *1 0,0
Xsky130_fd_sc_hd__buf_4_85 clknet_0_clk VGND VPWR VPWR clknet_3_6__leaf_clk
+ sky130_fd_sc_hd__buf_4
* cell instance sky130_fd_sc_hd__buf_4_86 r0 *1 0,0
Xsky130_fd_sc_hd__buf_4_86 clknet_3_3__leaf_clk VGND VPWR VPWR
+ clknet_leaf_43_clk sky130_fd_sc_hd__buf_4
* cell instance sky130_fd_sc_hd__buf_4_87 r0 *1 0,0
Xsky130_fd_sc_hd__buf_4_87 clknet_3_6__leaf_clk VGND VPWR VPWR
+ clknet_leaf_39_clk sky130_fd_sc_hd__buf_4
* cell instance sky130_fd_sc_hd__buf_4_88 r0 *1 0,0
Xsky130_fd_sc_hd__buf_4_88 clknet_3_2__leaf_clk VGND VPWR VPWR
+ clknet_leaf_48_clk sky130_fd_sc_hd__buf_4
* cell instance sky130_fd_sc_hd__buf_4_89 r0 *1 0,0
Xsky130_fd_sc_hd__buf_4_89 clknet_3_6__leaf_clk VGND VPWR VPWR
+ clknet_leaf_38_clk sky130_fd_sc_hd__buf_4
* cell instance sky130_fd_sc_hd__buf_4_90 r0 *1 0,0
Xsky130_fd_sc_hd__buf_4_90 clknet_3_3__leaf_clk VGND VPWR VPWR
+ clknet_leaf_44_clk sky130_fd_sc_hd__buf_4
* cell instance sky130_fd_sc_hd__buf_4_91 r0 *1 0,0
Xsky130_fd_sc_hd__buf_4_91 clknet_3_7__leaf_clk VGND VPWR VPWR
+ clknet_leaf_34_clk sky130_fd_sc_hd__buf_4
* cell instance sky130_fd_sc_hd__buf_4_92 r0 *1 0,0
Xsky130_fd_sc_hd__buf_4_92 clknet_3_2__leaf_clk VGND VPWR VPWR
+ clknet_leaf_47_clk sky130_fd_sc_hd__buf_4
* cell instance sky130_fd_sc_hd__buf_4_93 r0 *1 0,0
Xsky130_fd_sc_hd__buf_4_93 clknet_3_3__leaf_clk VGND VPWR VPWR
+ clknet_leaf_45_clk sky130_fd_sc_hd__buf_4
* cell instance sky130_fd_sc_hd__buf_4_94 r0 *1 0,0
Xsky130_fd_sc_hd__buf_4_94 clknet_3_7__leaf_clk VGND VPWR VPWR
+ clknet_leaf_35_clk sky130_fd_sc_hd__buf_4
* cell instance sky130_fd_sc_hd__buf_4_95 r0 *1 0,0
Xsky130_fd_sc_hd__buf_4_95 clknet_3_6__leaf_clk VGND VPWR VPWR
+ clknet_leaf_37_clk sky130_fd_sc_hd__buf_4
* cell instance sky130_fd_sc_hd__buf_4_96 r0 *1 0,0
Xsky130_fd_sc_hd__buf_4_96 \_0439_ VGND VPWR VPWR net37 sky130_fd_sc_hd__buf_4
* cell instance sky130_fd_sc_hd__buf_4_97 r0 *1 0,0
Xsky130_fd_sc_hd__buf_4_97 clknet_3_6__leaf_clk VGND VPWR VPWR
+ clknet_leaf_36_clk sky130_fd_sc_hd__buf_4
* cell instance sky130_fd_sc_hd__buf_4_98 r0 *1 0,0
Xsky130_fd_sc_hd__buf_4_98 clknet_3_3__leaf_clk VGND VPWR VPWR
+ clknet_leaf_46_clk sky130_fd_sc_hd__buf_4
* cell instance sky130_fd_sc_hd__bufinv_16_0 r0 *1 0,0
Xsky130_fd_sc_hd__bufinv_16_0 clknet_3_6__leaf_clk VGND VPWR VPWR \$4545
+ sky130_fd_sc_hd__bufinv_16
* cell instance sky130_fd_sc_hd__clkbuf_1_0 r0 *1 0,0
Xsky130_fd_sc_hd__clkbuf_1_0 raw_bit VGND VPWR VPWR \_1421_
+ sky130_fd_sc_hd__clkbuf_1
* cell instance sky130_fd_sc_hd__clkbuf_1_1 r0 *1 0,0
Xsky130_fd_sc_hd__clkbuf_1_1 bus_re VGND VPWR VPWR \_0755_
+ sky130_fd_sc_hd__clkbuf_1
* cell instance sky130_fd_sc_hd__clkinv_1_0 r0 *1 0,0
Xsky130_fd_sc_hd__clkinv_1_0 clknet_leaf_63_clk VGND VPWR VPWR \$431
+ sky130_fd_sc_hd__clkinv_1
* cell instance sky130_fd_sc_hd__clkinv_1_1 r0 *1 0,0
Xsky130_fd_sc_hd__clkinv_1_1 clknet_leaf_4_clk VGND VPWR VPWR \$3684
+ sky130_fd_sc_hd__clkinv_1
* cell instance sky130_fd_sc_hd__clkinv_1_2 r0 *1 0,0
Xsky130_fd_sc_hd__clkinv_1_2 clknet_leaf_14_clk VGND VPWR VPWR \$5549
+ sky130_fd_sc_hd__clkinv_1
* cell instance sky130_fd_sc_hd__clkinv_1_3 r0 *1 0,0
Xsky130_fd_sc_hd__clkinv_1_3 clknet_leaf_1_clk VGND VPWR VPWR \$2024
+ sky130_fd_sc_hd__clkinv_1
* cell instance sky130_fd_sc_hd__clkinv_1_4 r0 *1 0,0
Xsky130_fd_sc_hd__clkinv_1_4 clknet_leaf_8_clk VGND VPWR VPWR \$4511
+ sky130_fd_sc_hd__clkinv_1
* cell instance sky130_fd_sc_hd__clkinv_1_5 r0 *1 0,0
Xsky130_fd_sc_hd__clkinv_1_5 clknet_leaf_56_clk VGND VPWR VPWR \$1105
+ sky130_fd_sc_hd__clkinv_1
* cell instance sky130_fd_sc_hd__clkinv_1_6 r0 *1 0,0
Xsky130_fd_sc_hd__clkinv_1_6 clknet_leaf_28_clk VGND VPWR VPWR \$4663
+ sky130_fd_sc_hd__clkinv_1
* cell instance sky130_fd_sc_hd__clkinv_1_7 r0 *1 0,0
Xsky130_fd_sc_hd__clkinv_1_7 \_0200_ VGND VPWR VPWR gated
+ sky130_fd_sc_hd__clkinv_1
* cell instance sky130_fd_sc_hd__clkinv_1_8 r0 *1 0,0
Xsky130_fd_sc_hd__clkinv_1_8 clknet_leaf_38_clk VGND VPWR VPWR \$4331
+ sky130_fd_sc_hd__clkinv_1
* cell instance sky130_fd_sc_hd__clkinv_1_9 r0 *1 0,0
Xsky130_fd_sc_hd__clkinv_1_9 clknet_leaf_47_clk VGND VPWR VPWR \$2394
+ sky130_fd_sc_hd__clkinv_1
* cell instance sky130_fd_sc_hd__clkinv_2_0 r0 *1 0,0
Xsky130_fd_sc_hd__clkinv_2_0 clknet_leaf_49_clk VGND VPWR VPWR \$363
+ sky130_fd_sc_hd__clkinv_2
* cell instance sky130_fd_sc_hd__clkinv_2_1 r0 *1 0,0
Xsky130_fd_sc_hd__clkinv_2_1 clknet_leaf_48_clk VGND VPWR VPWR \$1361
+ sky130_fd_sc_hd__clkinv_2
* cell instance sky130_fd_sc_hd__clkinv_2_2 r0 *1 0,0
Xsky130_fd_sc_hd__clkinv_2_2 clknet_leaf_44_clk VGND VPWR VPWR \$2602
+ sky130_fd_sc_hd__clkinv_2
* cell instance sky130_fd_sc_hd__clkinv_4_0 r0 *1 0,0
Xsky130_fd_sc_hd__clkinv_4_0 clknet_leaf_65_clk VGND VPWR VPWR \$1477
+ sky130_fd_sc_hd__clkinv_4
* cell instance sky130_fd_sc_hd__clkinvlp_2_0 r0 *1 0,0
Xsky130_fd_sc_hd__clkinvlp_2_0 clknet_3_1__leaf_clk VGND VPWR VPWR \$2130
+ sky130_fd_sc_hd__clkinvlp_2
* cell instance sky130_fd_sc_hd__clkinvlp_2_1 r0 *1 0,0
Xsky130_fd_sc_hd__clkinvlp_2_1 clknet_3_7__leaf_clk VGND VPWR VPWR \$6468
+ sky130_fd_sc_hd__clkinvlp_2
* cell instance sky130_fd_sc_hd__clkinvlp_2_2 r0 *1 0,0
Xsky130_fd_sc_hd__clkinvlp_2_2 clknet_3_3__leaf_clk VGND VPWR VPWR \$3534
+ sky130_fd_sc_hd__clkinvlp_2
* cell instance sky130_fd_sc_hd__dfrtp_1_0 r0 *1 0,0
Xsky130_fd_sc_hd__dfrtp_1_0 clknet_leaf_2_clk \_0017_[19] raw_mem[0][19] rst_n
+ VGND VPWR VPWR sky130_fd_sc_hd__dfrtp_1
* cell instance sky130_fd_sc_hd__dfrtp_1_1 r0 *1 0,0
Xsky130_fd_sc_hd__dfrtp_1_1 clknet_leaf_16_clk \_0011_[31] cond_mem[3][31]
+ rst_n VGND VPWR VPWR sky130_fd_sc_hd__dfrtp_1
* cell instance sky130_fd_sc_hd__dfrtp_1_2 r0 *1 0,0
Xsky130_fd_sc_hd__dfrtp_1_2 clknet_leaf_17_clk \_0011_[25] cond_mem[3][25]
+ rst_n VGND VPWR VPWR sky130_fd_sc_hd__dfrtp_1
* cell instance sky130_fd_sc_hd__dfrtp_1_3 r0 *1 0,0
Xsky130_fd_sc_hd__dfrtp_1_3 clknet_leaf_18_clk \_0009_[19] cond_mem[1][19]
+ rst_n VGND VPWR VPWR sky130_fd_sc_hd__dfrtp_1
* cell instance sky130_fd_sc_hd__dfrtp_1_4 r0 *1 0,0
Xsky130_fd_sc_hd__dfrtp_1_4 clknet_leaf_63_clk \_0018_[8] raw_mem[1][8] rst_n
+ VGND VPWR VPWR sky130_fd_sc_hd__dfrtp_1
* cell instance sky130_fd_sc_hd__dfrtp_1_5 r0 *1 0,0
Xsky130_fd_sc_hd__dfrtp_1_5 clknet_leaf_63_clk \_0017_[8] raw_mem[0][8] rst_n
+ VGND VPWR VPWR sky130_fd_sc_hd__dfrtp_1
* cell instance sky130_fd_sc_hd__dfrtp_1_6 r0 *1 0,0
Xsky130_fd_sc_hd__dfrtp_1_6 clknet_leaf_64_clk \_0018_[25] raw_mem[1][25] rst_n
+ VGND VPWR VPWR sky130_fd_sc_hd__dfrtp_1
* cell instance sky130_fd_sc_hd__dfrtp_1_7 r0 *1 0,0
Xsky130_fd_sc_hd__dfrtp_1_7 clknet_leaf_64_clk \_0019_[25] raw_mem[2][25] rst_n
+ VGND VPWR VPWR sky130_fd_sc_hd__dfrtp_1
* cell instance sky130_fd_sc_hd__dfrtp_1_8 r0 *1 0,0
Xsky130_fd_sc_hd__dfrtp_1_8 clknet_leaf_64_clk \_0017_[25] raw_mem[0][25] rst_n
+ VGND VPWR VPWR sky130_fd_sc_hd__dfrtp_1
* cell instance sky130_fd_sc_hd__dfrtp_1_9 r0 *1 0,0
Xsky130_fd_sc_hd__dfrtp_1_9 clknet_leaf_65_clk \_0017_[24] raw_mem[0][24] rst_n
+ VGND VPWR VPWR sky130_fd_sc_hd__dfrtp_1
* cell instance sky130_fd_sc_hd__dfrtp_1_10 r0 *1 0,0
Xsky130_fd_sc_hd__dfrtp_1_10 clknet_leaf_65_clk \_0018_[19] raw_mem[1][19]
+ rst_n VGND VPWR VPWR sky130_fd_sc_hd__dfrtp_1
* cell instance sky130_fd_sc_hd__dfrtp_1_11 r0 *1 0,0
Xsky130_fd_sc_hd__dfrtp_1_11 clknet_leaf_3_clk \_0040_ bus_rdata_r[19] rst_n
+ VGND VPWR VPWR sky130_fd_sc_hd__dfrtp_1
* cell instance sky130_fd_sc_hd__dfrtp_1_12 r0 *1 0,0
Xsky130_fd_sc_hd__dfrtp_1_12 clknet_leaf_3_clk \_0048_ bus_rdata_r[11] rst_n
+ VGND VPWR VPWR sky130_fd_sc_hd__dfrtp_1
* cell instance sky130_fd_sc_hd__dfrtp_1_13 r0 *1 0,0
Xsky130_fd_sc_hd__dfrtp_1_13 clknet_leaf_3_clk \_0034_ bus_rdata_r[25] rst_n
+ VGND VPWR VPWR sky130_fd_sc_hd__dfrtp_1
* cell instance sky130_fd_sc_hd__dfrtp_1_14 r0 *1 0,0
Xsky130_fd_sc_hd__dfrtp_1_14 clknet_leaf_3_clk \_0017_[29] raw_mem[0][29] rst_n
+ VGND VPWR VPWR sky130_fd_sc_hd__dfrtp_1
* cell instance sky130_fd_sc_hd__dfrtp_1_15 r0 *1 0,0
Xsky130_fd_sc_hd__dfrtp_1_15 clknet_leaf_4_clk \_0033_ bus_rdata_r[26] rst_n
+ VGND VPWR VPWR sky130_fd_sc_hd__dfrtp_1
* cell instance sky130_fd_sc_hd__dfrtp_1_16 r0 *1 0,0
Xsky130_fd_sc_hd__dfrtp_1_16 clknet_leaf_12_clk \_0030_ bus_rdata_r[29] rst_n
+ VGND VPWR VPWR sky130_fd_sc_hd__dfrtp_1
* cell instance sky130_fd_sc_hd__dfrtp_1_17 r0 *1 0,0
Xsky130_fd_sc_hd__dfrtp_1_17 clknet_leaf_17_clk \_0008_[19] cond_mem[0][19]
+ rst_n VGND VPWR VPWR sky130_fd_sc_hd__dfrtp_1
* cell instance sky130_fd_sc_hd__dfrtp_1_18 r0 *1 0,0
Xsky130_fd_sc_hd__dfrtp_1_18 clknet_leaf_16_clk \_0009_[31] cond_mem[1][31]
+ rst_n VGND VPWR VPWR sky130_fd_sc_hd__dfrtp_1
* cell instance sky130_fd_sc_hd__dfrtp_1_19 r0 *1 0,0
Xsky130_fd_sc_hd__dfrtp_1_19 clknet_leaf_63_clk \_0019_[8] raw_mem[2][8] rst_n
+ VGND VPWR VPWR sky130_fd_sc_hd__dfrtp_1
* cell instance sky130_fd_sc_hd__dfrtp_1_20 r0 *1 0,0
Xsky130_fd_sc_hd__dfrtp_1_20 clknet_leaf_18_clk \_0011_[19] cond_mem[3][19]
+ rst_n VGND VPWR VPWR sky130_fd_sc_hd__dfrtp_1
* cell instance sky130_fd_sc_hd__dfrtp_1_21 r0 *1 0,0
Xsky130_fd_sc_hd__dfrtp_1_21 clknet_leaf_4_clk \_0049_ bus_rdata_r[10] rst_n
+ VGND VPWR VPWR sky130_fd_sc_hd__dfrtp_1
* cell instance sky130_fd_sc_hd__dfrtp_1_22 r0 *1 0,0
Xsky130_fd_sc_hd__dfrtp_1_22 clknet_leaf_12_clk \_0035_ bus_rdata_r[24] rst_n
+ VGND VPWR VPWR sky130_fd_sc_hd__dfrtp_1
* cell instance sky130_fd_sc_hd__dfrtp_1_23 r0 *1 0,0
Xsky130_fd_sc_hd__dfrtp_1_23 clknet_leaf_13_clk \_0009_[29] cond_mem[1][29]
+ rst_n VGND VPWR VPWR sky130_fd_sc_hd__dfrtp_1
* cell instance sky130_fd_sc_hd__dfrtp_1_24 r0 *1 0,0
Xsky130_fd_sc_hd__dfrtp_1_24 clknet_leaf_14_clk \_0008_[31] cond_mem[0][31]
+ rst_n VGND VPWR VPWR sky130_fd_sc_hd__dfrtp_1
* cell instance sky130_fd_sc_hd__dfrtp_1_25 r0 *1 0,0
Xsky130_fd_sc_hd__dfrtp_1_25 clknet_leaf_16_clk \_0008_[25] cond_mem[0][25]
+ rst_n VGND VPWR VPWR sky130_fd_sc_hd__dfrtp_1
* cell instance sky130_fd_sc_hd__dfrtp_1_26 r0 *1 0,0
Xsky130_fd_sc_hd__dfrtp_1_26 clknet_leaf_18_clk \_0010_[19] cond_mem[2][19]
+ rst_n VGND VPWR VPWR sky130_fd_sc_hd__dfrtp_1
* cell instance sky130_fd_sc_hd__dfrtp_1_27 r0 *1 0,0
Xsky130_fd_sc_hd__dfrtp_1_27 clknet_leaf_12_clk \_0059_ bus_rdata_r[0] rst_n
+ VGND VPWR VPWR sky130_fd_sc_hd__dfrtp_1
* cell instance sky130_fd_sc_hd__dfrtp_1_28 r0 *1 0,0
Xsky130_fd_sc_hd__dfrtp_1_28 clknet_leaf_16_clk \_0010_[31] cond_mem[2][31]
+ rst_n VGND VPWR VPWR sky130_fd_sc_hd__dfrtp_1
* cell instance sky130_fd_sc_hd__dfrtp_1_29 r0 *1 0,0
Xsky130_fd_sc_hd__dfrtp_1_29 clknet_leaf_17_clk \_0009_[25] cond_mem[1][25]
+ rst_n VGND VPWR VPWR sky130_fd_sc_hd__dfrtp_1
* cell instance sky130_fd_sc_hd__dfrtp_1_30 r0 *1 0,0
Xsky130_fd_sc_hd__dfrtp_1_30 clknet_leaf_17_clk \_0010_[25] cond_mem[2][25]
+ rst_n VGND VPWR VPWR sky130_fd_sc_hd__dfrtp_1
* cell instance sky130_fd_sc_hd__dfrtp_1_31 r0 *1 0,0
Xsky130_fd_sc_hd__dfrtp_1_31 clknet_leaf_12_clk \_0028_ bus_rdata_r[31] rst_n
+ VGND VPWR VPWR sky130_fd_sc_hd__dfrtp_1
* cell instance sky130_fd_sc_hd__dfrtp_1_32 r0 *1 0,0
Xsky130_fd_sc_hd__dfrtp_1_32 clknet_leaf_63_clk \_0020_[8] raw_mem[3][8] rst_n
+ VGND VPWR VPWR sky130_fd_sc_hd__dfrtp_1
* cell instance sky130_fd_sc_hd__dfrtp_1_33 r0 *1 0,0
Xsky130_fd_sc_hd__dfrtp_1_33 clknet_leaf_64_clk \_0019_[19] raw_mem[2][19]
+ rst_n VGND VPWR VPWR sky130_fd_sc_hd__dfrtp_1
* cell instance sky130_fd_sc_hd__dfrtp_1_34 r0 *1 0,0
Xsky130_fd_sc_hd__dfrtp_1_34 clknet_leaf_18_clk \_0008_[24] cond_mem[0][24]
+ rst_n VGND VPWR VPWR sky130_fd_sc_hd__dfrtp_1
* cell instance sky130_fd_sc_hd__dfrtp_1_35 r0 *1 0,0
Xsky130_fd_sc_hd__dfrtp_1_35 clknet_leaf_63_clk \_0020_[25] raw_mem[3][25]
+ rst_n VGND VPWR VPWR sky130_fd_sc_hd__dfrtp_1
* cell instance sky130_fd_sc_hd__dfrtp_1_36 r0 *1 0,0
Xsky130_fd_sc_hd__dfrtp_1_36 clknet_leaf_13_clk \_0008_[29] cond_mem[0][29]
+ rst_n VGND VPWR VPWR sky130_fd_sc_hd__dfrtp_1
* cell instance sky130_fd_sc_hd__dfrtp_1_37 r0 *1 0,0
Xsky130_fd_sc_hd__dfrtp_1_37 clknet_leaf_2_clk \_0017_[31] raw_mem[0][31] rst_n
+ VGND VPWR VPWR sky130_fd_sc_hd__dfrtp_1
* cell instance sky130_fd_sc_hd__dfrtp_1_38 r0 *1 0,0
Xsky130_fd_sc_hd__dfrtp_1_38 clknet_leaf_13_clk \_0010_[29] cond_mem[2][29]
+ rst_n VGND VPWR VPWR sky130_fd_sc_hd__dfrtp_1
* cell instance sky130_fd_sc_hd__dfrtp_1_39 r0 *1 0,0
Xsky130_fd_sc_hd__dfrtp_1_39 clknet_leaf_13_clk \_0011_[29] cond_mem[3][29]
+ rst_n VGND VPWR VPWR sky130_fd_sc_hd__dfrtp_1
* cell instance sky130_fd_sc_hd__dfrtp_1_40 r0 *1 0,0
Xsky130_fd_sc_hd__dfrtp_1_40 clknet_leaf_3_clk \_0018_[29] raw_mem[1][29] rst_n
+ VGND VPWR VPWR sky130_fd_sc_hd__dfrtp_1
* cell instance sky130_fd_sc_hd__dfrtp_1_41 r0 *1 0,0
Xsky130_fd_sc_hd__dfrtp_1_41 clknet_leaf_4_clk \_0051_ bus_rdata_r[8] rst_n
+ VGND VPWR VPWR sky130_fd_sc_hd__dfrtp_1
* cell instance sky130_fd_sc_hd__dfrtp_1_42 r0 *1 0,0
Xsky130_fd_sc_hd__dfrtp_1_42 clknet_leaf_2_clk \_0020_[29] raw_mem[3][29] rst_n
+ VGND VPWR VPWR sky130_fd_sc_hd__dfrtp_1
* cell instance sky130_fd_sc_hd__dfrtp_1_43 r0 *1 0,0
Xsky130_fd_sc_hd__dfrtp_1_43 clknet_leaf_64_clk \_0018_[24] raw_mem[1][24]
+ rst_n VGND VPWR VPWR sky130_fd_sc_hd__dfrtp_1
* cell instance sky130_fd_sc_hd__dfrtp_1_44 r0 *1 0,0
Xsky130_fd_sc_hd__dfrtp_1_44 clknet_leaf_3_clk \_0019_[29] raw_mem[2][29] rst_n
+ VGND VPWR VPWR sky130_fd_sc_hd__dfrtp_1
* cell instance sky130_fd_sc_hd__dfrtp_1_45 r0 *1 0,0
Xsky130_fd_sc_hd__dfrtp_1_45 clknet_leaf_18_clk \_0009_[24] cond_mem[1][24]
+ rst_n VGND VPWR VPWR sky130_fd_sc_hd__dfrtp_1
* cell instance sky130_fd_sc_hd__dfrtp_1_46 r0 *1 0,0
Xsky130_fd_sc_hd__dfrtp_1_46 clknet_leaf_62_clk \_0018_[12] raw_mem[1][12]
+ rst_n VGND VPWR VPWR sky130_fd_sc_hd__dfrtp_1
* cell instance sky130_fd_sc_hd__dfrtp_1_47 r0 *1 0,0
Xsky130_fd_sc_hd__dfrtp_1_47 clknet_leaf_17_clk \_0008_[12] cond_mem[0][12]
+ rst_n VGND VPWR VPWR sky130_fd_sc_hd__dfrtp_1
* cell instance sky130_fd_sc_hd__dfrtp_1_48 r0 *1 0,0
Xsky130_fd_sc_hd__dfrtp_1_48 clknet_leaf_64_clk \_0019_[24] raw_mem[2][24]
+ rst_n VGND VPWR VPWR sky130_fd_sc_hd__dfrtp_1
* cell instance sky130_fd_sc_hd__dfrtp_1_49 r0 *1 0,0
Xsky130_fd_sc_hd__dfrtp_1_49 clknet_leaf_62_clk \_0019_[12] raw_mem[2][12]
+ rst_n VGND VPWR VPWR sky130_fd_sc_hd__dfrtp_1
* cell instance sky130_fd_sc_hd__dfrtp_1_50 r0 *1 0,0
Xsky130_fd_sc_hd__dfrtp_1_50 clknet_leaf_16_clk \_0008_[8] cond_mem[0][8] rst_n
+ VGND VPWR VPWR sky130_fd_sc_hd__dfrtp_1
* cell instance sky130_fd_sc_hd__dfrtp_1_51 r0 *1 0,0
Xsky130_fd_sc_hd__dfrtp_1_51 clknet_leaf_62_clk \_0020_[12] raw_mem[3][12]
+ rst_n VGND VPWR VPWR sky130_fd_sc_hd__dfrtp_1
* cell instance sky130_fd_sc_hd__dfrtp_1_52 r0 *1 0,0
Xsky130_fd_sc_hd__dfrtp_1_52 clknet_leaf_0_clk \_0020_[19] raw_mem[3][19] rst_n
+ VGND VPWR VPWR sky130_fd_sc_hd__dfrtp_1
* cell instance sky130_fd_sc_hd__dfrtp_1_53 r0 *1 0,0
Xsky130_fd_sc_hd__dfrtp_1_53 clknet_leaf_2_clk \_0029_ bus_rdata_r[30] rst_n
+ VGND VPWR VPWR sky130_fd_sc_hd__dfrtp_1
* cell instance sky130_fd_sc_hd__dfrtp_1_54 r0 *1 0,0
Xsky130_fd_sc_hd__dfrtp_1_54 clknet_leaf_4_clk \_0037_ bus_rdata_r[22] rst_n
+ VGND VPWR VPWR sky130_fd_sc_hd__dfrtp_1
* cell instance sky130_fd_sc_hd__dfrtp_1_55 r0 *1 0,0
Xsky130_fd_sc_hd__dfrtp_1_55 clknet_leaf_12_clk \_0031_ bus_rdata_r[28] rst_n
+ VGND VPWR VPWR sky130_fd_sc_hd__dfrtp_1
* cell instance sky130_fd_sc_hd__dfrtp_1_56 r0 *1 0,0
Xsky130_fd_sc_hd__dfrtp_1_56 clknet_leaf_12_clk \_0032_ bus_rdata_r[27] rst_n
+ VGND VPWR VPWR sky130_fd_sc_hd__dfrtp_1
* cell instance sky130_fd_sc_hd__dfrtp_1_57 r0 *1 0,0
Xsky130_fd_sc_hd__dfrtp_1_57 clknet_leaf_0_clk \_0018_[31] raw_mem[1][31] rst_n
+ VGND VPWR VPWR sky130_fd_sc_hd__dfrtp_1
* cell instance sky130_fd_sc_hd__dfrtp_1_58 r0 *1 0,0
Xsky130_fd_sc_hd__dfrtp_1_58 clknet_leaf_12_clk \_0047_ bus_rdata_r[12] rst_n
+ VGND VPWR VPWR sky130_fd_sc_hd__dfrtp_1
* cell instance sky130_fd_sc_hd__dfrtp_1_59 r0 *1 0,0
Xsky130_fd_sc_hd__dfrtp_1_59 clknet_leaf_64_clk \_0017_[12] raw_mem[0][12]
+ rst_n VGND VPWR VPWR sky130_fd_sc_hd__dfrtp_1
* cell instance sky130_fd_sc_hd__dfrtp_1_60 r0 *1 0,0
Xsky130_fd_sc_hd__dfrtp_1_60 clknet_leaf_13_clk \_0008_[27] cond_mem[0][27]
+ rst_n VGND VPWR VPWR sky130_fd_sc_hd__dfrtp_1
* cell instance sky130_fd_sc_hd__dfrtp_1_61 r0 *1 0,0
Xsky130_fd_sc_hd__dfrtp_1_61 clknet_leaf_13_clk \_0009_[27] cond_mem[1][27]
+ rst_n VGND VPWR VPWR sky130_fd_sc_hd__dfrtp_1
* cell instance sky130_fd_sc_hd__dfrtp_1_62 r0 *1 0,0
Xsky130_fd_sc_hd__dfrtp_1_62 clknet_leaf_17_clk \_0009_[12] cond_mem[1][12]
+ rst_n VGND VPWR VPWR sky130_fd_sc_hd__dfrtp_1
* cell instance sky130_fd_sc_hd__dfrtp_1_63 r0 *1 0,0
Xsky130_fd_sc_hd__dfrtp_1_63 clknet_leaf_17_clk \_0010_[8] cond_mem[2][8] rst_n
+ VGND VPWR VPWR sky130_fd_sc_hd__dfrtp_1
* cell instance sky130_fd_sc_hd__dfrtp_1_64 r0 *1 0,0
Xsky130_fd_sc_hd__dfrtp_1_64 clknet_leaf_18_clk \_0010_[12] cond_mem[2][12]
+ rst_n VGND VPWR VPWR sky130_fd_sc_hd__dfrtp_1
* cell instance sky130_fd_sc_hd__dfrtp_1_65 r0 *1 0,0
Xsky130_fd_sc_hd__dfrtp_1_65 clknet_leaf_16_clk \_0009_[8] cond_mem[1][8] rst_n
+ VGND VPWR VPWR sky130_fd_sc_hd__dfrtp_1
* cell instance sky130_fd_sc_hd__dfrtp_1_66 r0 *1 0,0
Xsky130_fd_sc_hd__dfrtp_1_66 clknet_leaf_18_clk \_0010_[24] cond_mem[2][24]
+ rst_n VGND VPWR VPWR sky130_fd_sc_hd__dfrtp_1
* cell instance sky130_fd_sc_hd__dfrtp_1_67 r0 *1 0,0
Xsky130_fd_sc_hd__dfrtp_1_67 clknet_leaf_16_clk \_0011_[26] cond_mem[3][26]
+ rst_n VGND VPWR VPWR sky130_fd_sc_hd__dfrtp_1
* cell instance sky130_fd_sc_hd__dfrtp_1_68 r0 *1 0,0
Xsky130_fd_sc_hd__dfrtp_1_68 clknet_leaf_16_clk \_0011_[8] cond_mem[3][8] rst_n
+ VGND VPWR VPWR sky130_fd_sc_hd__dfrtp_1
* cell instance sky130_fd_sc_hd__dfrtp_1_69 r0 *1 0,0
Xsky130_fd_sc_hd__dfrtp_1_69 clknet_leaf_0_clk \_0020_[24] raw_mem[3][24] rst_n
+ VGND VPWR VPWR sky130_fd_sc_hd__dfrtp_1
* cell instance sky130_fd_sc_hd__dfrtp_1_70 r0 *1 0,0
Xsky130_fd_sc_hd__dfrtp_1_70 clknet_leaf_2_clk \_0017_[26] raw_mem[0][26] rst_n
+ VGND VPWR VPWR sky130_fd_sc_hd__dfrtp_1
* cell instance sky130_fd_sc_hd__dfrtp_1_71 r0 *1 0,0
Xsky130_fd_sc_hd__dfrtp_1_71 clknet_leaf_3_clk \_0039_ bus_rdata_r[20] rst_n
+ VGND VPWR VPWR sky130_fd_sc_hd__dfrtp_1
* cell instance sky130_fd_sc_hd__dfrtp_1_72 r0 *1 0,0
Xsky130_fd_sc_hd__dfrtp_1_72 clknet_leaf_12_clk \_0008_[26] cond_mem[0][26]
+ rst_n VGND VPWR VPWR sky130_fd_sc_hd__dfrtp_1
* cell instance sky130_fd_sc_hd__dfrtp_1_73 r0 *1 0,0
Xsky130_fd_sc_hd__dfrtp_1_73 clknet_leaf_14_clk \_0009_[26] cond_mem[1][26]
+ rst_n VGND VPWR VPWR sky130_fd_sc_hd__dfrtp_1
* cell instance sky130_fd_sc_hd__dfrtp_1_74 r0 *1 0,0
Xsky130_fd_sc_hd__dfrtp_1_74 clknet_leaf_14_clk \_0010_[26] cond_mem[2][26]
+ rst_n VGND VPWR VPWR sky130_fd_sc_hd__dfrtp_1
* cell instance sky130_fd_sc_hd__dfrtp_1_75 r0 *1 0,0
Xsky130_fd_sc_hd__dfrtp_1_75 clknet_leaf_17_clk \_0011_[12] cond_mem[3][12]
+ rst_n VGND VPWR VPWR sky130_fd_sc_hd__dfrtp_1
* cell instance sky130_fd_sc_hd__dfrtp_1_76 r0 *1 0,0
Xsky130_fd_sc_hd__dfrtp_1_76 clknet_leaf_4_clk \_0055_ bus_rdata_r[4] rst_n
+ VGND VPWR VPWR sky130_fd_sc_hd__dfrtp_1
* cell instance sky130_fd_sc_hd__dfrtp_1_77 r0 *1 0,0
Xsky130_fd_sc_hd__dfrtp_1_77 clknet_leaf_13_clk \_0010_[27] cond_mem[2][27]
+ rst_n VGND VPWR VPWR sky130_fd_sc_hd__dfrtp_1
* cell instance sky130_fd_sc_hd__dfrtp_1_78 r0 *1 0,0
Xsky130_fd_sc_hd__dfrtp_1_78 clknet_leaf_14_clk \_0011_[27] cond_mem[3][27]
+ rst_n VGND VPWR VPWR sky130_fd_sc_hd__dfrtp_1
* cell instance sky130_fd_sc_hd__dfrtp_1_79 r0 *1 0,0
Xsky130_fd_sc_hd__dfrtp_1_79 clknet_leaf_62_clk \_0019_[5] raw_mem[2][5] rst_n
+ VGND VPWR VPWR sky130_fd_sc_hd__dfrtp_1
* cell instance sky130_fd_sc_hd__dfrtp_1_80 r0 *1 0,0
Xsky130_fd_sc_hd__dfrtp_1_80 clknet_leaf_2_clk \_0018_[26] raw_mem[1][26] rst_n
+ VGND VPWR VPWR sky130_fd_sc_hd__dfrtp_1
* cell instance sky130_fd_sc_hd__dfrtp_1_81 r0 *1 0,0
Xsky130_fd_sc_hd__dfrtp_1_81 clknet_leaf_18_clk \_0011_[24] cond_mem[3][24]
+ rst_n VGND VPWR VPWR sky130_fd_sc_hd__dfrtp_1
* cell instance sky130_fd_sc_hd__dfrtp_1_82 r0 *1 0,0
Xsky130_fd_sc_hd__dfrtp_1_82 clknet_leaf_63_clk \_0017_[5] raw_mem[0][5] rst_n
+ VGND VPWR VPWR sky130_fd_sc_hd__dfrtp_1
* cell instance sky130_fd_sc_hd__dfrtp_1_83 r0 *1 0,0
Xsky130_fd_sc_hd__dfrtp_1_83 clknet_leaf_62_clk \_0020_[5] raw_mem[3][5] rst_n
+ VGND VPWR VPWR sky130_fd_sc_hd__dfrtp_1
* cell instance sky130_fd_sc_hd__dfrtp_1_84 r0 *1 0,0
Xsky130_fd_sc_hd__dfrtp_1_84 clknet_leaf_62_clk \_0018_[5] raw_mem[1][5] rst_n
+ VGND VPWR VPWR sky130_fd_sc_hd__dfrtp_1
* cell instance sky130_fd_sc_hd__dfrtp_1_85 r0 *1 0,0
Xsky130_fd_sc_hd__dfrtp_1_85 clknet_leaf_0_clk \_0018_[6] raw_mem[1][6] rst_n
+ VGND VPWR VPWR sky130_fd_sc_hd__dfrtp_1
* cell instance sky130_fd_sc_hd__dfrtp_1_86 r0 *1 0,0
Xsky130_fd_sc_hd__dfrtp_1_86 clknet_leaf_2_clk \_0019_[26] raw_mem[2][26] rst_n
+ VGND VPWR VPWR sky130_fd_sc_hd__dfrtp_1
* cell instance sky130_fd_sc_hd__dfrtp_1_87 r0 *1 0,0
Xsky130_fd_sc_hd__dfrtp_1_87 clknet_leaf_0_clk \_0019_[6] raw_mem[2][6] rst_n
+ VGND VPWR VPWR sky130_fd_sc_hd__dfrtp_1
* cell instance sky130_fd_sc_hd__dfrtp_1_88 r0 *1 0,0
Xsky130_fd_sc_hd__dfrtp_1_88 clknet_leaf_0_clk \_0017_[6] raw_mem[0][6] rst_n
+ VGND VPWR VPWR sky130_fd_sc_hd__dfrtp_1
* cell instance sky130_fd_sc_hd__dfrtp_1_89 r0 *1 0,0
Xsky130_fd_sc_hd__dfrtp_1_89 clknet_leaf_11_clk \_0046_ bus_rdata_r[13] rst_n
+ VGND VPWR VPWR sky130_fd_sc_hd__dfrtp_1
* cell instance sky130_fd_sc_hd__dfrtp_1_90 r0 *1 0,0
Xsky130_fd_sc_hd__dfrtp_1_90 clknet_leaf_15_clk \_0008_[5] cond_mem[0][5] rst_n
+ VGND VPWR VPWR sky130_fd_sc_hd__dfrtp_1
* cell instance sky130_fd_sc_hd__dfrtp_1_91 r0 *1 0,0
Xsky130_fd_sc_hd__dfrtp_1_91 clknet_leaf_0_clk \_0020_[6] raw_mem[3][6] rst_n
+ VGND VPWR VPWR sky130_fd_sc_hd__dfrtp_1
* cell instance sky130_fd_sc_hd__dfrtp_1_92 r0 *1 0,0
Xsky130_fd_sc_hd__dfrtp_1_92 clknet_leaf_11_clk \_0054_ bus_rdata_r[5] rst_n
+ VGND VPWR VPWR sky130_fd_sc_hd__dfrtp_1
* cell instance sky130_fd_sc_hd__dfrtp_1_93 r0 *1 0,0
Xsky130_fd_sc_hd__dfrtp_1_93 clknet_leaf_15_clk \_0008_[4] cond_mem[0][4] rst_n
+ VGND VPWR VPWR sky130_fd_sc_hd__dfrtp_1
* cell instance sky130_fd_sc_hd__dfrtp_1_94 r0 *1 0,0
Xsky130_fd_sc_hd__dfrtp_1_94 clknet_leaf_19_clk \_0009_[13] cond_mem[1][13]
+ rst_n VGND VPWR VPWR sky130_fd_sc_hd__dfrtp_1
* cell instance sky130_fd_sc_hd__dfrtp_1_95 r0 *1 0,0
Xsky130_fd_sc_hd__dfrtp_1_95 clknet_leaf_0_clk \_0017_[13] raw_mem[0][13] rst_n
+ VGND VPWR VPWR sky130_fd_sc_hd__dfrtp_1
* cell instance sky130_fd_sc_hd__dfrtp_1_96 r0 *1 0,0
Xsky130_fd_sc_hd__dfrtp_1_96 clknet_leaf_14_clk \_0011_[0] cond_mem[3][0] rst_n
+ VGND VPWR VPWR sky130_fd_sc_hd__dfrtp_1
* cell instance sky130_fd_sc_hd__dfrtp_1_97 r0 *1 0,0
Xsky130_fd_sc_hd__dfrtp_1_97 clknet_leaf_20_clk \_0009_[5] cond_mem[1][5] rst_n
+ VGND VPWR VPWR sky130_fd_sc_hd__dfrtp_1
* cell instance sky130_fd_sc_hd__dfrtp_1_98 r0 *1 0,0
Xsky130_fd_sc_hd__dfrtp_1_98 clknet_leaf_1_clk \_0053_ bus_rdata_r[6] rst_n
+ VGND VPWR VPWR sky130_fd_sc_hd__dfrtp_1
* cell instance sky130_fd_sc_hd__dfrtp_1_99 r0 *1 0,0
Xsky130_fd_sc_hd__dfrtp_1_99 clknet_leaf_19_clk \_0008_[13] cond_mem[0][13]
+ rst_n VGND VPWR VPWR sky130_fd_sc_hd__dfrtp_1
* cell instance sky130_fd_sc_hd__dfrtp_1_100 r0 *1 0,0
Xsky130_fd_sc_hd__dfrtp_1_100 clknet_leaf_60_clk \_0017_[4] raw_mem[0][4] rst_n
+ VGND VPWR VPWR sky130_fd_sc_hd__dfrtp_1
* cell instance sky130_fd_sc_hd__dfrtp_1_101 r0 *1 0,0
Xsky130_fd_sc_hd__dfrtp_1_101 clknet_leaf_15_clk \_0010_[0] cond_mem[2][0]
+ rst_n VGND VPWR VPWR sky130_fd_sc_hd__dfrtp_1
* cell instance sky130_fd_sc_hd__dfrtp_1_102 r0 *1 0,0
Xsky130_fd_sc_hd__dfrtp_1_102 clknet_leaf_62_clk \_0018_[13] raw_mem[1][13]
+ rst_n VGND VPWR VPWR sky130_fd_sc_hd__dfrtp_1
* cell instance sky130_fd_sc_hd__dfrtp_1_103 r0 *1 0,0
Xsky130_fd_sc_hd__dfrtp_1_103 clknet_leaf_1_clk \_0020_[26] raw_mem[3][26]
+ rst_n VGND VPWR VPWR sky130_fd_sc_hd__dfrtp_1
* cell instance sky130_fd_sc_hd__dfrtp_1_104 r0 *1 0,0
Xsky130_fd_sc_hd__dfrtp_1_104 clknet_leaf_11_clk \_0008_[6] cond_mem[0][6]
+ rst_n VGND VPWR VPWR sky130_fd_sc_hd__dfrtp_1
* cell instance sky130_fd_sc_hd__dfrtp_1_105 r0 *1 0,0
Xsky130_fd_sc_hd__dfrtp_1_105 clknet_leaf_10_clk \_0011_[6] cond_mem[3][6]
+ rst_n VGND VPWR VPWR sky130_fd_sc_hd__dfrtp_1
* cell instance sky130_fd_sc_hd__dfrtp_1_106 r0 *1 0,0
Xsky130_fd_sc_hd__dfrtp_1_106 clknet_leaf_61_clk \_0019_[13] raw_mem[2][13]
+ rst_n VGND VPWR VPWR sky130_fd_sc_hd__dfrtp_1
* cell instance sky130_fd_sc_hd__dfrtp_1_107 r0 *1 0,0
Xsky130_fd_sc_hd__dfrtp_1_107 clknet_leaf_4_clk \_0002_ al_startup rst_n VGND
+ VPWR VPWR sky130_fd_sc_hd__dfrtp_1
* cell instance sky130_fd_sc_hd__dfrtp_1_108 r0 *1 0,0
Xsky130_fd_sc_hd__dfrtp_1_108 clknet_leaf_15_clk \_0009_[4] cond_mem[1][4]
+ rst_n VGND VPWR VPWR sky130_fd_sc_hd__dfrtp_1
* cell instance sky130_fd_sc_hd__dfrtp_1_109 r0 *1 0,0
Xsky130_fd_sc_hd__dfrtp_1_109 clknet_leaf_19_clk \_0010_[5] cond_mem[2][5]
+ rst_n VGND VPWR VPWR sky130_fd_sc_hd__dfrtp_1
* cell instance sky130_fd_sc_hd__dfrtp_1_110 r0 *1 0,0
Xsky130_fd_sc_hd__dfrtp_1_110 clknet_leaf_61_clk \_0020_[13] raw_mem[3][13]
+ rst_n VGND VPWR VPWR sky130_fd_sc_hd__dfrtp_1
* cell instance sky130_fd_sc_hd__dfrtp_1_111 r0 *1 0,0
Xsky130_fd_sc_hd__dfrtp_1_111 clknet_leaf_1_clk \_0017_[0] raw_mem[0][0] rst_n
+ VGND VPWR VPWR sky130_fd_sc_hd__dfrtp_1
* cell instance sky130_fd_sc_hd__dfrtp_1_112 r0 *1 0,0
Xsky130_fd_sc_hd__dfrtp_1_112 clknet_leaf_11_clk \_0009_[6] cond_mem[1][6]
+ rst_n VGND VPWR VPWR sky130_fd_sc_hd__dfrtp_1
* cell instance sky130_fd_sc_hd__dfrtp_1_113 r0 *1 0,0
Xsky130_fd_sc_hd__dfrtp_1_113 clknet_leaf_10_clk \_0009_[0] cond_mem[1][0]
+ rst_n VGND VPWR VPWR sky130_fd_sc_hd__dfrtp_1
* cell instance sky130_fd_sc_hd__dfrtp_1_114 r0 *1 0,0
Xsky130_fd_sc_hd__dfrtp_1_114 clknet_leaf_19_clk \_0011_[13] cond_mem[3][13]
+ rst_n VGND VPWR VPWR sky130_fd_sc_hd__dfrtp_1
* cell instance sky130_fd_sc_hd__dfrtp_1_115 r0 *1 0,0
Xsky130_fd_sc_hd__dfrtp_1_115 clknet_leaf_14_clk \_0008_[0] cond_mem[0][0]
+ rst_n VGND VPWR VPWR sky130_fd_sc_hd__dfrtp_1
* cell instance sky130_fd_sc_hd__dfrtp_1_116 r0 *1 0,0
Xsky130_fd_sc_hd__dfrtp_1_116 clknet_leaf_20_clk \_0011_[5] cond_mem[3][5]
+ rst_n VGND VPWR VPWR sky130_fd_sc_hd__dfrtp_1
* cell instance sky130_fd_sc_hd__dfrtp_1_117 r0 *1 0,0
Xsky130_fd_sc_hd__dfrtp_1_117 clknet_leaf_5_clk \_0057_ bus_rdata_r[2] rst_n
+ VGND VPWR VPWR sky130_fd_sc_hd__dfrtp_1
* cell instance sky130_fd_sc_hd__dfrtp_1_118 r0 *1 0,0
Xsky130_fd_sc_hd__dfrtp_1_118 clknet_leaf_10_clk \_0010_[6] cond_mem[2][6]
+ rst_n VGND VPWR VPWR sky130_fd_sc_hd__dfrtp_1
* cell instance sky130_fd_sc_hd__dfrtp_1_119 r0 *1 0,0
Xsky130_fd_sc_hd__dfrtp_1_119 clknet_leaf_19_clk \_0010_[13] cond_mem[2][13]
+ rst_n VGND VPWR VPWR sky130_fd_sc_hd__dfrtp_1
* cell instance sky130_fd_sc_hd__dfrtp_1_120 r0 *1 0,0
Xsky130_fd_sc_hd__dfrtp_1_120 clknet_leaf_60_clk \_0019_[0] raw_mem[2][0] rst_n
+ VGND VPWR VPWR sky130_fd_sc_hd__dfrtp_1
* cell instance sky130_fd_sc_hd__dfrtp_1_121 r0 *1 0,0
Xsky130_fd_sc_hd__dfrtp_1_121 clknet_leaf_61_clk \_0018_[4] raw_mem[1][4] rst_n
+ VGND VPWR VPWR sky130_fd_sc_hd__dfrtp_1
* cell instance sky130_fd_sc_hd__dfrtp_1_122 r0 *1 0,0
Xsky130_fd_sc_hd__dfrtp_1_122 clknet_leaf_1_clk \_0018_[16] raw_mem[1][16]
+ rst_n VGND VPWR VPWR sky130_fd_sc_hd__dfrtp_1
* cell instance sky130_fd_sc_hd__dfrtp_1_123 r0 *1 0,0
Xsky130_fd_sc_hd__dfrtp_1_123 clknet_leaf_11_clk \_0001_ al_rct rst_n VGND VPWR
+ VPWR sky130_fd_sc_hd__dfrtp_1
* cell instance sky130_fd_sc_hd__dfrtp_1_124 r0 *1 0,0
Xsky130_fd_sc_hd__dfrtp_1_124 clknet_leaf_60_clk \_0020_[0] raw_mem[3][0] rst_n
+ VGND VPWR VPWR sky130_fd_sc_hd__dfrtp_1
* cell instance sky130_fd_sc_hd__dfrtp_1_125 r0 *1 0,0
Xsky130_fd_sc_hd__dfrtp_1_125 clknet_leaf_11_clk \_0058_ bus_rdata_r[1] rst_n
+ VGND VPWR VPWR sky130_fd_sc_hd__dfrtp_1
* cell instance sky130_fd_sc_hd__dfrtp_1_126 r0 *1 0,0
Xsky130_fd_sc_hd__dfrtp_1_126 clknet_leaf_11_clk \_0000_ al_apt rst_n VGND VPWR
+ VPWR sky130_fd_sc_hd__dfrtp_1
* cell instance sky130_fd_sc_hd__dfrtp_1_127 r0 *1 0,0
Xsky130_fd_sc_hd__dfrtp_1_127 clknet_leaf_1_clk \_0018_[0] raw_mem[1][0] rst_n
+ VGND VPWR VPWR sky130_fd_sc_hd__dfrtp_1
* cell instance sky130_fd_sc_hd__dfrtp_1_128 r0 *1 0,0
Xsky130_fd_sc_hd__dfrtp_1_128 clknet_leaf_60_clk \_0018_[2] raw_mem[1][2] rst_n
+ VGND VPWR VPWR sky130_fd_sc_hd__dfrtp_1
* cell instance sky130_fd_sc_hd__dfrtp_1_129 r0 *1 0,0
Xsky130_fd_sc_hd__dfrtp_1_129 clknet_leaf_1_clk \_0017_[16] raw_mem[0][16]
+ rst_n VGND VPWR VPWR sky130_fd_sc_hd__dfrtp_1
* cell instance sky130_fd_sc_hd__dfrtp_1_130 r0 *1 0,0
Xsky130_fd_sc_hd__dfrtp_1_130 clknet_leaf_61_clk \_0019_[4] raw_mem[2][4] rst_n
+ VGND VPWR VPWR sky130_fd_sc_hd__dfrtp_1
* cell instance sky130_fd_sc_hd__dfrtp_1_131 r0 *1 0,0
Xsky130_fd_sc_hd__dfrtp_1_131 clknet_leaf_5_clk \_0043_ bus_rdata_r[16] rst_n
+ VGND VPWR VPWR sky130_fd_sc_hd__dfrtp_1
* cell instance sky130_fd_sc_hd__dfrtp_1_132 r0 *1 0,0
Xsky130_fd_sc_hd__dfrtp_1_132 clknet_leaf_60_clk \_0017_[2] raw_mem[0][2] rst_n
+ VGND VPWR VPWR sky130_fd_sc_hd__dfrtp_1
* cell instance sky130_fd_sc_hd__dfrtp_1_133 r0 *1 0,0
Xsky130_fd_sc_hd__dfrtp_1_133 clknet_leaf_60_clk \_0019_[16] raw_mem[2][16]
+ rst_n VGND VPWR VPWR sky130_fd_sc_hd__dfrtp_1
* cell instance sky130_fd_sc_hd__dfrtp_1_134 r0 *1 0,0
Xsky130_fd_sc_hd__dfrtp_1_134 clknet_leaf_10_clk \_0009_[9] cond_mem[1][9]
+ rst_n VGND VPWR VPWR sky130_fd_sc_hd__dfrtp_1
* cell instance sky130_fd_sc_hd__dfrtp_1_135 r0 *1 0,0
Xsky130_fd_sc_hd__dfrtp_1_135 clknet_leaf_19_clk \_0008_[16] cond_mem[0][16]
+ rst_n VGND VPWR VPWR sky130_fd_sc_hd__dfrtp_1
* cell instance sky130_fd_sc_hd__dfrtp_1_136 r0 *1 0,0
Xsky130_fd_sc_hd__dfrtp_1_136 clknet_leaf_19_clk \_0009_[16] cond_mem[1][16]
+ rst_n VGND VPWR VPWR sky130_fd_sc_hd__dfrtp_1
* cell instance sky130_fd_sc_hd__dfrtp_1_137 r0 *1 0,0
Xsky130_fd_sc_hd__dfrtp_1_137 clknet_leaf_61_clk \_0020_[4] raw_mem[3][4] rst_n
+ VGND VPWR VPWR sky130_fd_sc_hd__dfrtp_1
* cell instance sky130_fd_sc_hd__dfrtp_1_138 r0 *1 0,0
Xsky130_fd_sc_hd__dfrtp_1_138 clknet_leaf_5_clk \_0056_ bus_rdata_r[3] rst_n
+ VGND VPWR VPWR sky130_fd_sc_hd__dfrtp_1
* cell instance sky130_fd_sc_hd__dfrtp_1_139 r0 *1 0,0
Xsky130_fd_sc_hd__dfrtp_1_139 clknet_leaf_60_clk \_0020_[16] raw_mem[3][16]
+ rst_n VGND VPWR VPWR sky130_fd_sc_hd__dfrtp_1
* cell instance sky130_fd_sc_hd__dfrtp_1_140 r0 *1 0,0
Xsky130_fd_sc_hd__dfrtp_1_140 clknet_leaf_19_clk \_0010_[16] cond_mem[2][16]
+ rst_n VGND VPWR VPWR sky130_fd_sc_hd__dfrtp_1
* cell instance sky130_fd_sc_hd__dfrtp_1_141 r0 *1 0,0
Xsky130_fd_sc_hd__dfrtp_1_141 clknet_leaf_61_clk \_0019_[2] raw_mem[2][2] rst_n
+ VGND VPWR VPWR sky130_fd_sc_hd__dfrtp_1
* cell instance sky130_fd_sc_hd__dfrtp_1_142 r0 *1 0,0
Xsky130_fd_sc_hd__dfrtp_1_142 clknet_leaf_10_clk \_0008_[9] cond_mem[0][9]
+ rst_n VGND VPWR VPWR sky130_fd_sc_hd__dfrtp_1
* cell instance sky130_fd_sc_hd__dfrtp_1_143 r0 *1 0,0
Xsky130_fd_sc_hd__dfrtp_1_143 clknet_leaf_10_clk \_0010_[9] cond_mem[2][9]
+ rst_n VGND VPWR VPWR sky130_fd_sc_hd__dfrtp_1
* cell instance sky130_fd_sc_hd__dfrtp_1_144 r0 *1 0,0
Xsky130_fd_sc_hd__dfrtp_1_144 clknet_leaf_10_clk \_0011_[9] cond_mem[3][9]
+ rst_n VGND VPWR VPWR sky130_fd_sc_hd__dfrtp_1
* cell instance sky130_fd_sc_hd__dfrtp_1_145 r0 *1 0,0
Xsky130_fd_sc_hd__dfrtp_1_145 clknet_leaf_5_clk \_0014_[2] ctrl[2] rst_n VGND
+ VPWR VPWR sky130_fd_sc_hd__dfrtp_1
* cell instance sky130_fd_sc_hd__dfrtp_1_146 r0 *1 0,0
Xsky130_fd_sc_hd__dfrtp_1_146 clknet_leaf_61_clk \_0020_[2] raw_mem[3][2] rst_n
+ VGND VPWR VPWR sky130_fd_sc_hd__dfrtp_1
* cell instance sky130_fd_sc_hd__dfrtp_1_147 r0 *1 0,0
Xsky130_fd_sc_hd__dfrtp_1_147 clknet_leaf_20_clk \_0010_[18] cond_mem[2][18]
+ rst_n VGND VPWR VPWR sky130_fd_sc_hd__dfrtp_1
* cell instance sky130_fd_sc_hd__dfrtp_1_148 r0 *1 0,0
Xsky130_fd_sc_hd__dfrtp_1_148 clknet_leaf_5_clk \_0020_[31] raw_mem[3][31]
+ rst_n VGND VPWR VPWR sky130_fd_sc_hd__dfrtp_1
* cell instance sky130_fd_sc_hd__dfrtp_1_149 r0 *1 0,0
Xsky130_fd_sc_hd__dfrtp_1_149 clknet_leaf_8_clk \_0050_ bus_rdata_r[9] rst_n
+ VGND VPWR VPWR sky130_fd_sc_hd__dfrtp_1
* cell instance sky130_fd_sc_hd__dfrtp_1_150 r0 *1 0,0
Xsky130_fd_sc_hd__dfrtp_1_150 clknet_leaf_20_clk \_0010_[4] cond_mem[2][4]
+ rst_n VGND VPWR VPWR sky130_fd_sc_hd__dfrtp_1
* cell instance sky130_fd_sc_hd__dfrtp_1_151 r0 *1 0,0
Xsky130_fd_sc_hd__dfrtp_1_151 clknet_leaf_22_clk \_0011_[16] cond_mem[3][16]
+ rst_n VGND VPWR VPWR sky130_fd_sc_hd__dfrtp_1
* cell instance sky130_fd_sc_hd__dfrtp_1_152 r0 *1 0,0
Xsky130_fd_sc_hd__dfrtp_1_152 clknet_leaf_59_clk \_0019_[9] raw_mem[2][9] rst_n
+ VGND VPWR VPWR sky130_fd_sc_hd__dfrtp_1
* cell instance sky130_fd_sc_hd__dfrtp_1_153 r0 *1 0,0
Xsky130_fd_sc_hd__dfrtp_1_153 clknet_leaf_59_clk \_0020_[9] raw_mem[3][9] rst_n
+ VGND VPWR VPWR sky130_fd_sc_hd__dfrtp_1
* cell instance sky130_fd_sc_hd__dfrtp_1_154 r0 *1 0,0
Xsky130_fd_sc_hd__dfrtp_1_154 clknet_leaf_6_clk \_0014_[0] ctrl[0] rst_n VGND
+ VPWR VPWR sky130_fd_sc_hd__dfrtp_1
* cell instance sky130_fd_sc_hd__dfrtp_1_155 r0 *1 0,0
Xsky130_fd_sc_hd__dfrtp_1_155 clknet_leaf_59_clk \_0019_[7] raw_mem[2][7] rst_n
+ VGND VPWR VPWR sky130_fd_sc_hd__dfrtp_1
* cell instance sky130_fd_sc_hd__dfrtp_1_156 r0 *1 0,0
Xsky130_fd_sc_hd__dfrtp_1_156 clknet_leaf_55_clk \_0019_[31] raw_mem[2][31]
+ rst_n VGND VPWR VPWR sky130_fd_sc_hd__dfrtp_1
* cell instance sky130_fd_sc_hd__dfrtp_1_157 r0 *1 0,0
Xsky130_fd_sc_hd__dfrtp_1_157 clknet_leaf_5_clk \_0021_ raw_ovf rst_n VGND VPWR
+ VPWR sky130_fd_sc_hd__dfrtp_1
* cell instance sky130_fd_sc_hd__dfrtp_1_158 r0 *1 0,0
Xsky130_fd_sc_hd__dfrtp_1_158 clknet_leaf_21_clk \_0009_[18] cond_mem[1][18]
+ rst_n VGND VPWR VPWR sky130_fd_sc_hd__dfrtp_1
* cell instance sky130_fd_sc_hd__dfrtp_1_159 r0 *1 0,0
Xsky130_fd_sc_hd__dfrtp_1_159 clknet_leaf_59_clk \_0018_[9] raw_mem[1][9] rst_n
+ VGND VPWR VPWR sky130_fd_sc_hd__dfrtp_1
* cell instance sky130_fd_sc_hd__dfrtp_1_160 r0 *1 0,0
Xsky130_fd_sc_hd__dfrtp_1_160 clknet_leaf_59_clk \_0017_[9] raw_mem[0][9] rst_n
+ VGND VPWR VPWR sky130_fd_sc_hd__dfrtp_1
* cell instance sky130_fd_sc_hd__dfrtp_1_161 r0 *1 0,0
Xsky130_fd_sc_hd__dfrtp_1_161 clknet_leaf_59_clk \_0020_[7] raw_mem[3][7] rst_n
+ VGND VPWR VPWR sky130_fd_sc_hd__dfrtp_1
* cell instance sky130_fd_sc_hd__dfrtp_1_162 r0 *1 0,0
Xsky130_fd_sc_hd__dfrtp_1_162 clknet_leaf_21_clk \_0011_[4] cond_mem[3][4]
+ rst_n VGND VPWR VPWR sky130_fd_sc_hd__dfrtp_1
* cell instance sky130_fd_sc_hd__dfrtp_1_163 r0 *1 0,0
Xsky130_fd_sc_hd__dfrtp_1_163 clknet_leaf_22_clk \_0011_[18] cond_mem[3][18]
+ rst_n VGND VPWR VPWR sky130_fd_sc_hd__dfrtp_1
* cell instance sky130_fd_sc_hd__dfrtp_1_164 r0 *1 0,0
Xsky130_fd_sc_hd__dfrtp_1_164 clknet_leaf_8_clk \_0041_ bus_rdata_r[18] rst_n
+ VGND VPWR VPWR sky130_fd_sc_hd__dfrtp_1
* cell instance sky130_fd_sc_hd__dfrtp_1_165 r0 *1 0,0
Xsky130_fd_sc_hd__dfrtp_1_165 clknet_leaf_21_clk \_0008_[18] cond_mem[0][18]
+ rst_n VGND VPWR VPWR sky130_fd_sc_hd__dfrtp_1
* cell instance sky130_fd_sc_hd__dfrtp_1_166 r0 *1 0,0
Xsky130_fd_sc_hd__dfrtp_1_166 clknet_leaf_58_clk \_0019_[1] raw_mem[2][1] rst_n
+ VGND VPWR VPWR sky130_fd_sc_hd__dfrtp_1
* cell instance sky130_fd_sc_hd__dfrtp_1_167 r0 *1 0,0
Xsky130_fd_sc_hd__dfrtp_1_167 clknet_leaf_5_clk \_0016_[0] raw_level[0] rst_n
+ VGND VPWR VPWR sky130_fd_sc_hd__dfrtp_1
* cell instance sky130_fd_sc_hd__dfrtp_1_168 r0 *1 0,0
Xsky130_fd_sc_hd__dfrtp_1_168 clknet_leaf_55_clk \_0018_[7] raw_mem[1][7] rst_n
+ VGND VPWR VPWR sky130_fd_sc_hd__dfrtp_1
* cell instance sky130_fd_sc_hd__dfrtp_1_169 r0 *1 0,0
Xsky130_fd_sc_hd__dfrtp_1_169 clknet_leaf_58_clk \_0018_[1] raw_mem[1][1] rst_n
+ VGND VPWR VPWR sky130_fd_sc_hd__dfrtp_1
* cell instance sky130_fd_sc_hd__dfrtp_1_170 r0 *1 0,0
Xsky130_fd_sc_hd__dfrtp_1_170 clknet_leaf_9_clk \_0010_[28] cond_mem[2][28]
+ rst_n VGND VPWR VPWR sky130_fd_sc_hd__dfrtp_1
* cell instance sky130_fd_sc_hd__dfrtp_1_171 r0 *1 0,0
Xsky130_fd_sc_hd__dfrtp_1_171 clknet_leaf_9_clk \_0011_[28] cond_mem[3][28]
+ rst_n VGND VPWR VPWR sky130_fd_sc_hd__dfrtp_1
* cell instance sky130_fd_sc_hd__dfrtp_1_172 r0 *1 0,0
Xsky130_fd_sc_hd__dfrtp_1_172 clknet_leaf_58_clk \_0020_[1] raw_mem[3][1] rst_n
+ VGND VPWR VPWR sky130_fd_sc_hd__dfrtp_1
* cell instance sky130_fd_sc_hd__dfrtp_1_173 r0 *1 0,0
Xsky130_fd_sc_hd__dfrtp_1_173 clknet_leaf_22_clk \_0011_[17] cond_mem[3][17]
+ rst_n VGND VPWR VPWR sky130_fd_sc_hd__dfrtp_1
* cell instance sky130_fd_sc_hd__dfrtp_1_174 r0 *1 0,0
Xsky130_fd_sc_hd__dfrtp_1_174 clknet_leaf_5_clk \_0016_[1] raw_level[1] rst_n
+ VGND VPWR VPWR sky130_fd_sc_hd__dfrtp_1
* cell instance sky130_fd_sc_hd__dfrtp_1_175 r0 *1 0,0
Xsky130_fd_sc_hd__dfrtp_1_175 clknet_leaf_9_clk \_0009_[28] cond_mem[1][28]
+ rst_n VGND VPWR VPWR sky130_fd_sc_hd__dfrtp_1
* cell instance sky130_fd_sc_hd__dfrtp_1_176 r0 *1 0,0
Xsky130_fd_sc_hd__dfrtp_1_176 clknet_leaf_6_clk \_0014_[1] ctrl[1] rst_n VGND
+ VPWR VPWR sky130_fd_sc_hd__dfrtp_1
* cell instance sky130_fd_sc_hd__dfrtp_1_177 r0 *1 0,0
Xsky130_fd_sc_hd__dfrtp_1_177 clknet_leaf_8_clk \_0008_[28] cond_mem[0][28]
+ rst_n VGND VPWR VPWR sky130_fd_sc_hd__dfrtp_1
* cell instance sky130_fd_sc_hd__dfrtp_1_178 r0 *1 0,0
Xsky130_fd_sc_hd__dfrtp_1_178 clknet_leaf_59_clk \_0017_[3] raw_mem[0][3] rst_n
+ VGND VPWR VPWR sky130_fd_sc_hd__dfrtp_1
* cell instance sky130_fd_sc_hd__dfrtp_1_179 r0 *1 0,0
Xsky130_fd_sc_hd__dfrtp_1_179 clknet_leaf_6_clk \_0016_[2] raw_level[2] rst_n
+ VGND VPWR VPWR sky130_fd_sc_hd__dfrtp_1
* cell instance sky130_fd_sc_hd__dfrtp_1_180 r0 *1 0,0
Xsky130_fd_sc_hd__dfrtp_1_180 clknet_leaf_58_clk \_0018_[3] raw_mem[1][3] rst_n
+ VGND VPWR VPWR sky130_fd_sc_hd__dfrtp_1
* cell instance sky130_fd_sc_hd__dfrtp_1_181 r0 *1 0,0
Xsky130_fd_sc_hd__dfrtp_1_181 clknet_leaf_26_clk \_0011_[30] cond_mem[3][30]
+ rst_n VGND VPWR VPWR sky130_fd_sc_hd__dfrtp_1
* cell instance sky130_fd_sc_hd__dfrtp_1_182 r0 *1 0,0
Xsky130_fd_sc_hd__dfrtp_1_182 clknet_leaf_26_clk \_0009_[30] cond_mem[1][30]
+ rst_n VGND VPWR VPWR sky130_fd_sc_hd__dfrtp_1
* cell instance sky130_fd_sc_hd__dfrtp_1_183 r0 *1 0,0
Xsky130_fd_sc_hd__dfrtp_1_183 clknet_leaf_26_clk \_0010_[30] cond_mem[2][30]
+ rst_n VGND VPWR VPWR sky130_fd_sc_hd__dfrtp_1
* cell instance sky130_fd_sc_hd__dfrtp_1_184 r0 *1 0,0
Xsky130_fd_sc_hd__dfrtp_1_184 clknet_leaf_55_clk \_0017_[7] raw_mem[0][7] rst_n
+ VGND VPWR VPWR sky130_fd_sc_hd__dfrtp_1
* cell instance sky130_fd_sc_hd__dfrtp_1_185 r0 *1 0,0
Xsky130_fd_sc_hd__dfrtp_1_185 clknet_leaf_59_clk \_0017_[1] raw_mem[0][1] rst_n
+ VGND VPWR VPWR sky130_fd_sc_hd__dfrtp_1
* cell instance sky130_fd_sc_hd__dfrtp_1_186 r0 *1 0,0
Xsky130_fd_sc_hd__dfrtp_1_186 clknet_leaf_55_clk \_0022_[16] raw_sr[16] rst_n
+ VGND VPWR VPWR sky130_fd_sc_hd__dfrtp_1
* cell instance sky130_fd_sc_hd__dfrtp_1_187 r0 *1 0,0
Xsky130_fd_sc_hd__dfrtp_1_187 clknet_leaf_25_clk \_0009_[11] cond_mem[1][11]
+ rst_n VGND VPWR VPWR sky130_fd_sc_hd__dfrtp_1
* cell instance sky130_fd_sc_hd__dfrtp_1_188 r0 *1 0,0
Xsky130_fd_sc_hd__dfrtp_1_188 clknet_leaf_55_clk \_0022_[0] raw_sr[0] rst_n
+ VGND VPWR VPWR sky130_fd_sc_hd__dfrtp_1
* cell instance sky130_fd_sc_hd__dfrtp_1_189 r0 *1 0,0
Xsky130_fd_sc_hd__dfrtp_1_189 clknet_leaf_6_clk \_0052_ bus_rdata_r[7] rst_n
+ VGND VPWR VPWR sky130_fd_sc_hd__dfrtp_1
* cell instance sky130_fd_sc_hd__dfrtp_1_190 r0 *1 0,0
Xsky130_fd_sc_hd__dfrtp_1_190 clknet_leaf_26_clk \_0008_[30] cond_mem[0][30]
+ rst_n VGND VPWR VPWR sky130_fd_sc_hd__dfrtp_1
* cell instance sky130_fd_sc_hd__dfrtp_1_191 r0 *1 0,0
Xsky130_fd_sc_hd__dfrtp_1_191 clknet_leaf_22_clk \_0010_[17] cond_mem[2][17]
+ rst_n VGND VPWR VPWR sky130_fd_sc_hd__dfrtp_1
* cell instance sky130_fd_sc_hd__dfrtp_1_192 r0 *1 0,0
Xsky130_fd_sc_hd__dfrtp_1_192 clknet_leaf_58_clk \_0019_[3] raw_mem[2][3] rst_n
+ VGND VPWR VPWR sky130_fd_sc_hd__dfrtp_1
* cell instance sky130_fd_sc_hd__dfrtp_1_193 r0 *1 0,0
Xsky130_fd_sc_hd__dfrtp_1_193 clknet_leaf_55_clk \_0022_[31] raw_sr[31] rst_n
+ VGND VPWR VPWR sky130_fd_sc_hd__dfrtp_1
* cell instance sky130_fd_sc_hd__dfrtp_1_194 r0 *1 0,0
Xsky130_fd_sc_hd__dfrtp_1_194 clknet_leaf_26_clk \_0011_[7] cond_mem[3][7]
+ rst_n VGND VPWR VPWR sky130_fd_sc_hd__dfrtp_1
* cell instance sky130_fd_sc_hd__dfrtp_1_195 r0 *1 0,0
Xsky130_fd_sc_hd__dfrtp_1_195 clknet_leaf_56_clk \_0022_[24] raw_sr[24] rst_n
+ VGND VPWR VPWR sky130_fd_sc_hd__dfrtp_1
* cell instance sky130_fd_sc_hd__dfrtp_1_196 r0 *1 0,0
Xsky130_fd_sc_hd__dfrtp_1_196 clknet_leaf_8_clk \_0008_[7] cond_mem[0][7] rst_n
+ VGND VPWR VPWR sky130_fd_sc_hd__dfrtp_1
* cell instance sky130_fd_sc_hd__dfrtp_1_197 r0 *1 0,0
Xsky130_fd_sc_hd__dfrtp_1_197 clknet_leaf_58_clk \_0020_[3] raw_mem[3][3] rst_n
+ VGND VPWR VPWR sky130_fd_sc_hd__dfrtp_1
* cell instance sky130_fd_sc_hd__dfrtp_1_198 r0 *1 0,0
Xsky130_fd_sc_hd__dfrtp_1_198 clknet_leaf_26_clk \_0010_[7] cond_mem[2][7]
+ rst_n VGND VPWR VPWR sky130_fd_sc_hd__dfrtp_1
* cell instance sky130_fd_sc_hd__dfrtp_1_199 r0 *1 0,0
Xsky130_fd_sc_hd__dfrtp_1_199 clknet_leaf_22_clk \_0009_[17] cond_mem[1][17]
+ rst_n VGND VPWR VPWR sky130_fd_sc_hd__dfrtp_1
* cell instance sky130_fd_sc_hd__dfrtp_1_200 r0 *1 0,0
Xsky130_fd_sc_hd__dfrtp_1_200 clknet_leaf_58_clk \_0022_[25] raw_sr[25] rst_n
+ VGND VPWR VPWR sky130_fd_sc_hd__dfrtp_1
* cell instance sky130_fd_sc_hd__dfrtp_1_201 r0 *1 0,0
Xsky130_fd_sc_hd__dfrtp_1_201 clknet_leaf_8_clk \_0009_[7] cond_mem[1][7] rst_n
+ VGND VPWR VPWR sky130_fd_sc_hd__dfrtp_1
* cell instance sky130_fd_sc_hd__dfrtp_1_202 r0 *1 0,0
Xsky130_fd_sc_hd__dfrtp_1_202 clknet_leaf_25_clk \_0008_[11] cond_mem[0][11]
+ rst_n VGND VPWR VPWR sky130_fd_sc_hd__dfrtp_1
* cell instance sky130_fd_sc_hd__dfrtp_1_203 r0 *1 0,0
Xsky130_fd_sc_hd__dfrtp_1_203 clknet_leaf_23_clk \_0008_[17] cond_mem[0][17]
+ rst_n VGND VPWR VPWR sky130_fd_sc_hd__dfrtp_1
* cell instance sky130_fd_sc_hd__dfrtp_1_204 r0 *1 0,0
Xsky130_fd_sc_hd__dfrtp_1_204 clknet_leaf_6_clk \_0042_ bus_rdata_r[17] rst_n
+ VGND VPWR VPWR sky130_fd_sc_hd__dfrtp_1
* cell instance sky130_fd_sc_hd__dfrtp_1_205 r0 *1 0,0
Xsky130_fd_sc_hd__dfrtp_1_205 clknet_leaf_6_clk \_0017_[10] raw_mem[0][10]
+ rst_n VGND VPWR VPWR sky130_fd_sc_hd__dfrtp_1
* cell instance sky130_fd_sc_hd__dfrtp_1_206 r0 *1 0,0
Xsky130_fd_sc_hd__dfrtp_1_206 clknet_leaf_24_clk \_0010_[11] cond_mem[2][11]
+ rst_n VGND VPWR VPWR sky130_fd_sc_hd__dfrtp_1
* cell instance sky130_fd_sc_hd__dfrtp_1_207 r0 *1 0,0
Xsky130_fd_sc_hd__dfrtp_1_207 clknet_leaf_57_clk \_0022_[8] raw_sr[8] rst_n
+ VGND VPWR VPWR sky130_fd_sc_hd__dfrtp_1
* cell instance sky130_fd_sc_hd__dfrtp_1_208 r0 *1 0,0
Xsky130_fd_sc_hd__dfrtp_1_208 clknet_leaf_57_clk \_0022_[9] raw_sr[9] rst_n
+ VGND VPWR VPWR sky130_fd_sc_hd__dfrtp_1
* cell instance sky130_fd_sc_hd__dfrtp_1_209 r0 *1 0,0
Xsky130_fd_sc_hd__dfrtp_1_209 clknet_leaf_56_clk \_0015_[4] raw_count[4] rst_n
+ VGND VPWR VPWR sky130_fd_sc_hd__dfrtp_1
* cell instance sky130_fd_sc_hd__dfrtp_1_210 r0 *1 0,0
Xsky130_fd_sc_hd__dfrtp_1_210 clknet_leaf_26_clk \_0008_[10] cond_mem[0][10]
+ rst_n VGND VPWR VPWR sky130_fd_sc_hd__dfrtp_1
* cell instance sky130_fd_sc_hd__dfrtp_1_211 r0 *1 0,0
Xsky130_fd_sc_hd__dfrtp_1_211 clknet_leaf_54_clk \_0017_[11] raw_mem[0][11]
+ rst_n VGND VPWR VPWR sky130_fd_sc_hd__dfrtp_1
* cell instance sky130_fd_sc_hd__dfrtp_1_212 r0 *1 0,0
Xsky130_fd_sc_hd__dfrtp_1_212 clknet_leaf_8_clk \_0045_ bus_rdata_r[14] rst_n
+ VGND VPWR VPWR sky130_fd_sc_hd__dfrtp_1
* cell instance sky130_fd_sc_hd__dfrtp_1_213 r0 *1 0,0
Xsky130_fd_sc_hd__dfrtp_1_213 clknet_leaf_7_clk \_0018_[10] raw_mem[1][10]
+ rst_n VGND VPWR VPWR sky130_fd_sc_hd__dfrtp_1
* cell instance sky130_fd_sc_hd__dfrtp_1_214 r0 *1 0,0
Xsky130_fd_sc_hd__dfrtp_1_214 clknet_leaf_54_clk \_0022_[10] raw_sr[10] rst_n
+ VGND VPWR VPWR sky130_fd_sc_hd__dfrtp_1
* cell instance sky130_fd_sc_hd__dfrtp_1_215 r0 *1 0,0
Xsky130_fd_sc_hd__dfrtp_1_215 clknet_leaf_54_clk \_0018_[11] raw_mem[1][11]
+ rst_n VGND VPWR VPWR sky130_fd_sc_hd__dfrtp_1
* cell instance sky130_fd_sc_hd__dfrtp_1_216 r0 *1 0,0
Xsky130_fd_sc_hd__dfrtp_1_216 clknet_leaf_56_clk \_0022_[29] raw_sr[29] rst_n
+ VGND VPWR VPWR sky130_fd_sc_hd__dfrtp_1
* cell instance sky130_fd_sc_hd__dfrtp_1_217 r0 *1 0,0
Xsky130_fd_sc_hd__dfrtp_1_217 clknet_leaf_25_clk \_0011_[11] cond_mem[3][11]
+ rst_n VGND VPWR VPWR sky130_fd_sc_hd__dfrtp_1
* cell instance sky130_fd_sc_hd__dfrtp_1_218 r0 *1 0,0
Xsky130_fd_sc_hd__dfrtp_1_218 clknet_leaf_56_clk \_0015_[5] raw_count[5] rst_n
+ VGND VPWR VPWR sky130_fd_sc_hd__dfrtp_1
* cell instance sky130_fd_sc_hd__dfrtp_1_219 r0 *1 0,0
Xsky130_fd_sc_hd__dfrtp_1_219 clknet_leaf_54_clk \_0022_[26] raw_sr[26] rst_n
+ VGND VPWR VPWR sky130_fd_sc_hd__dfrtp_1
* cell instance sky130_fd_sc_hd__dfrtp_1_220 r0 *1 0,0
Xsky130_fd_sc_hd__dfrtp_1_220 clknet_leaf_26_clk \_0008_[2] cond_mem[0][2]
+ rst_n VGND VPWR VPWR sky130_fd_sc_hd__dfrtp_1
* cell instance sky130_fd_sc_hd__dfrtp_1_221 r0 *1 0,0
Xsky130_fd_sc_hd__dfrtp_1_221 clknet_leaf_27_clk \_0009_[10] cond_mem[1][10]
+ rst_n VGND VPWR VPWR sky130_fd_sc_hd__dfrtp_1
* cell instance sky130_fd_sc_hd__dfrtp_1_222 r0 *1 0,0
Xsky130_fd_sc_hd__dfrtp_1_222 clknet_leaf_25_clk \_0011_[10] cond_mem[3][10]
+ rst_n VGND VPWR VPWR sky130_fd_sc_hd__dfrtp_1
* cell instance sky130_fd_sc_hd__dfrtp_1_223 r0 *1 0,0
Xsky130_fd_sc_hd__dfrtp_1_223 clknet_leaf_25_clk \_0010_[10] cond_mem[2][10]
+ rst_n VGND VPWR VPWR sky130_fd_sc_hd__dfrtp_1
* cell instance sky130_fd_sc_hd__dfrtp_1_224 r0 *1 0,0
Xsky130_fd_sc_hd__dfrtp_1_224 clknet_leaf_23_clk \_0009_[14] cond_mem[1][14]
+ rst_n VGND VPWR VPWR sky130_fd_sc_hd__dfrtp_1
* cell instance sky130_fd_sc_hd__dfrtp_1_225 r0 *1 0,0
Xsky130_fd_sc_hd__dfrtp_1_225 clknet_leaf_6_clk \_0019_[10] raw_mem[2][10]
+ rst_n VGND VPWR VPWR sky130_fd_sc_hd__dfrtp_1
* cell instance sky130_fd_sc_hd__dfrtp_1_226 r0 *1 0,0
Xsky130_fd_sc_hd__dfrtp_1_226 clknet_leaf_57_clk \_0022_[12] raw_sr[12] rst_n
+ VGND VPWR VPWR sky130_fd_sc_hd__dfrtp_1
* cell instance sky130_fd_sc_hd__dfrtp_1_227 r0 *1 0,0
Xsky130_fd_sc_hd__dfrtp_1_227 clknet_leaf_7_clk \_0038_ bus_rdata_r[21] rst_n
+ VGND VPWR VPWR sky130_fd_sc_hd__dfrtp_1
* cell instance sky130_fd_sc_hd__dfrtp_1_228 r0 *1 0,0
Xsky130_fd_sc_hd__dfrtp_1_228 clknet_leaf_24_clk \_0008_[14] cond_mem[0][14]
+ rst_n VGND VPWR VPWR sky130_fd_sc_hd__dfrtp_1
* cell instance sky130_fd_sc_hd__dfrtp_1_229 r0 *1 0,0
Xsky130_fd_sc_hd__dfrtp_1_229 clknet_leaf_57_clk \_0022_[13] raw_sr[13] rst_n
+ VGND VPWR VPWR sky130_fd_sc_hd__dfrtp_1
* cell instance sky130_fd_sc_hd__dfrtp_1_230 r0 *1 0,0
Xsky130_fd_sc_hd__dfrtp_1_230 clknet_leaf_55_clk \_0019_[11] raw_mem[2][11]
+ rst_n VGND VPWR VPWR sky130_fd_sc_hd__dfrtp_1
* cell instance sky130_fd_sc_hd__dfrtp_1_231 r0 *1 0,0
Xsky130_fd_sc_hd__dfrtp_1_231 clknet_leaf_7_clk \_0020_[10] raw_mem[3][10]
+ rst_n VGND VPWR VPWR sky130_fd_sc_hd__dfrtp_1
* cell instance sky130_fd_sc_hd__dfrtp_1_232 r0 *1 0,0
Xsky130_fd_sc_hd__dfrtp_1_232 clknet_leaf_28_clk \_0036_ bus_rdata_r[23] rst_n
+ VGND VPWR VPWR sky130_fd_sc_hd__dfrtp_1
* cell instance sky130_fd_sc_hd__dfrtp_1_233 r0 *1 0,0
Xsky130_fd_sc_hd__dfrtp_1_233 clknet_leaf_27_clk \_0008_[3] cond_mem[0][3]
+ rst_n VGND VPWR VPWR sky130_fd_sc_hd__dfrtp_1
* cell instance sky130_fd_sc_hd__dfrtp_1_234 r0 *1 0,0
Xsky130_fd_sc_hd__dfrtp_1_234 clknet_leaf_54_clk \_0017_[27] raw_mem[0][27]
+ rst_n VGND VPWR VPWR sky130_fd_sc_hd__dfrtp_1
* cell instance sky130_fd_sc_hd__dfrtp_1_235 r0 *1 0,0
Xsky130_fd_sc_hd__dfrtp_1_235 clknet_leaf_7_clk \_0044_ bus_rdata_r[15] rst_n
+ VGND VPWR VPWR sky130_fd_sc_hd__dfrtp_1
* cell instance sky130_fd_sc_hd__dfrtp_1_236 r0 *1 0,0
Xsky130_fd_sc_hd__dfrtp_1_236 clknet_leaf_7_clk \_0007_[2] cond_level[2] rst_n
+ VGND VPWR VPWR sky130_fd_sc_hd__dfrtp_1
* cell instance sky130_fd_sc_hd__dfrtp_1_237 r0 *1 0,0
Xsky130_fd_sc_hd__dfrtp_1_237 clknet_leaf_7_clk \_0007_[0] cond_level[0] rst_n
+ VGND VPWR VPWR sky130_fd_sc_hd__dfrtp_1
* cell instance sky130_fd_sc_hd__dfrtp_1_238 r0 *1 0,0
Xsky130_fd_sc_hd__dfrtp_1_238 clknet_leaf_23_clk \_0010_[14] cond_mem[2][14]
+ rst_n VGND VPWR VPWR sky130_fd_sc_hd__dfrtp_1
* cell instance sky130_fd_sc_hd__dfrtp_1_239 r0 *1 0,0
Xsky130_fd_sc_hd__dfrtp_1_239 clknet_leaf_7_clk \_0007_[1] cond_level[1] rst_n
+ VGND VPWR VPWR sky130_fd_sc_hd__dfrtp_1
* cell instance sky130_fd_sc_hd__dfrtp_1_240 r0 *1 0,0
Xsky130_fd_sc_hd__dfrtp_1_240 clknet_leaf_54_clk \_0020_[11] raw_mem[3][11]
+ rst_n VGND VPWR VPWR sky130_fd_sc_hd__dfrtp_1
* cell instance sky130_fd_sc_hd__dfrtp_1_241 r0 *1 0,0
Xsky130_fd_sc_hd__dfrtp_1_241 clknet_leaf_28_clk \_0012_ cond_ovf rst_n VGND
+ VPWR VPWR sky130_fd_sc_hd__dfrtp_1
* cell instance sky130_fd_sc_hd__dfrtp_1_242 r0 *1 0,0
Xsky130_fd_sc_hd__dfrtp_1_242 clknet_leaf_24_clk \_0009_[20] cond_mem[1][20]
+ rst_n VGND VPWR VPWR sky130_fd_sc_hd__dfrtp_1
* cell instance sky130_fd_sc_hd__dfrtp_1_243 r0 *1 0,0
Xsky130_fd_sc_hd__dfrtp_1_243 clknet_leaf_24_clk \_0011_[14] cond_mem[3][14]
+ rst_n VGND VPWR VPWR sky130_fd_sc_hd__dfrtp_1
* cell instance sky130_fd_sc_hd__dfrtp_1_244 r0 *1 0,0
Xsky130_fd_sc_hd__dfrtp_1_244 clknet_leaf_57_clk \_0022_[2] raw_sr[2] rst_n
+ VGND VPWR VPWR sky130_fd_sc_hd__dfrtp_1
* cell instance sky130_fd_sc_hd__dfrtp_1_245 r0 *1 0,0
Xsky130_fd_sc_hd__dfrtp_1_245 clknet_leaf_56_clk \_0022_[15] raw_sr[15] rst_n
+ VGND VPWR VPWR sky130_fd_sc_hd__dfrtp_1
* cell instance sky130_fd_sc_hd__dfrtp_1_246 r0 *1 0,0
Xsky130_fd_sc_hd__dfrtp_1_246 clknet_leaf_7_clk \_0017_[15] raw_mem[0][15]
+ rst_n VGND VPWR VPWR sky130_fd_sc_hd__dfrtp_1
* cell instance sky130_fd_sc_hd__dfrtp_1_247 r0 *1 0,0
Xsky130_fd_sc_hd__dfrtp_1_247 clknet_leaf_56_clk \_0022_[19] raw_sr[19] rst_n
+ VGND VPWR VPWR sky130_fd_sc_hd__dfrtp_1
* cell instance sky130_fd_sc_hd__dfrtp_1_248 r0 *1 0,0
Xsky130_fd_sc_hd__dfrtp_1_248 clknet_leaf_53_clk \_0018_[15] raw_mem[1][15]
+ rst_n VGND VPWR VPWR sky130_fd_sc_hd__dfrtp_1
* cell instance sky130_fd_sc_hd__dfrtp_1_249 r0 *1 0,0
Xsky130_fd_sc_hd__dfrtp_1_249 clknet_leaf_27_clk \_0009_[3] cond_mem[1][3]
+ rst_n VGND VPWR VPWR sky130_fd_sc_hd__dfrtp_1
* cell instance sky130_fd_sc_hd__dfrtp_1_250 r0 *1 0,0
Xsky130_fd_sc_hd__dfrtp_1_250 clknet_leaf_24_clk \_0010_[20] cond_mem[2][20]
+ rst_n VGND VPWR VPWR sky130_fd_sc_hd__dfrtp_1
* cell instance sky130_fd_sc_hd__dfrtp_1_251 r0 *1 0,0
Xsky130_fd_sc_hd__dfrtp_1_251 clknet_leaf_53_clk \_0019_[15] raw_mem[2][15]
+ rst_n VGND VPWR VPWR sky130_fd_sc_hd__dfrtp_1
* cell instance sky130_fd_sc_hd__dfrtp_1_252 r0 *1 0,0
Xsky130_fd_sc_hd__dfrtp_1_252 clknet_leaf_25_clk \_0008_[20] cond_mem[0][20]
+ rst_n VGND VPWR VPWR sky130_fd_sc_hd__dfrtp_1
* cell instance sky130_fd_sc_hd__dfrtp_1_253 r0 *1 0,0
Xsky130_fd_sc_hd__dfrtp_1_253 clknet_leaf_24_clk \_0011_[20] cond_mem[3][20]
+ rst_n VGND VPWR VPWR sky130_fd_sc_hd__dfrtp_1
* cell instance sky130_fd_sc_hd__dfrtp_1_254 r0 *1 0,0
Xsky130_fd_sc_hd__dfrtp_1_254 clknet_leaf_57_clk \_0022_[3] raw_sr[3] rst_n
+ VGND VPWR VPWR sky130_fd_sc_hd__dfrtp_1
* cell instance sky130_fd_sc_hd__dfrtp_1_255 r0 *1 0,0
Xsky130_fd_sc_hd__dfrtp_1_255 clknet_leaf_27_clk \_0011_[3] cond_mem[3][3]
+ rst_n VGND VPWR VPWR sky130_fd_sc_hd__dfrtp_1
* cell instance sky130_fd_sc_hd__dfrtp_1_256 r0 *1 0,0
Xsky130_fd_sc_hd__dfrtp_1_256 clknet_leaf_54_clk \_0022_[18] raw_sr[18] rst_n
+ VGND VPWR VPWR sky130_fd_sc_hd__dfrtp_1
* cell instance sky130_fd_sc_hd__dfrtp_1_257 r0 *1 0,0
Xsky130_fd_sc_hd__dfrtp_1_257 clknet_leaf_54_clk \_0022_[11] raw_sr[11] rst_n
+ VGND VPWR VPWR sky130_fd_sc_hd__dfrtp_1
* cell instance sky130_fd_sc_hd__dfrtp_1_258 r0 *1 0,0
Xsky130_fd_sc_hd__dfrtp_1_258 clknet_leaf_57_clk \_0022_[5] raw_sr[5] rst_n
+ VGND VPWR VPWR sky130_fd_sc_hd__dfrtp_1
* cell instance sky130_fd_sc_hd__dfrtp_1_259 r0 *1 0,0
Xsky130_fd_sc_hd__dfrtp_1_259 clknet_leaf_28_clk \_0017_[18] raw_mem[0][18]
+ rst_n VGND VPWR VPWR sky130_fd_sc_hd__dfrtp_1
* cell instance sky130_fd_sc_hd__dfrtp_1_260 r0 *1 0,0
Xsky130_fd_sc_hd__dfrtp_1_260 clknet_leaf_27_clk \_0010_[3] cond_mem[2][3]
+ rst_n VGND VPWR VPWR sky130_fd_sc_hd__dfrtp_1
* cell instance sky130_fd_sc_hd__dfrtp_1_261 r0 *1 0,0
Xsky130_fd_sc_hd__dfrtp_1_261 clknet_leaf_52_clk \_0018_[27] raw_mem[1][27]
+ rst_n VGND VPWR VPWR sky130_fd_sc_hd__dfrtp_1
* cell instance sky130_fd_sc_hd__dfrtp_1_262 r0 *1 0,0
Xsky130_fd_sc_hd__dfrtp_1_262 clknet_leaf_31_clk \_0009_[21] cond_mem[1][21]
+ rst_n VGND VPWR VPWR sky130_fd_sc_hd__dfrtp_1
* cell instance sky130_fd_sc_hd__dfrtp_1_263 r0 *1 0,0
Xsky130_fd_sc_hd__dfrtp_1_263 clknet_leaf_32_clk \_0011_[15] cond_mem[3][15]
+ rst_n VGND VPWR VPWR sky130_fd_sc_hd__dfrtp_1
* cell instance sky130_fd_sc_hd__dfrtp_1_264 r0 *1 0,0
Xsky130_fd_sc_hd__dfrtp_1_264 clknet_leaf_53_clk \_0020_[15] raw_mem[3][15]
+ rst_n VGND VPWR VPWR sky130_fd_sc_hd__dfrtp_1
* cell instance sky130_fd_sc_hd__dfrtp_1_265 r0 *1 0,0
Xsky130_fd_sc_hd__dfrtp_1_265 clknet_leaf_32_clk \_0008_[15] cond_mem[0][15]
+ rst_n VGND VPWR VPWR sky130_fd_sc_hd__dfrtp_1
* cell instance sky130_fd_sc_hd__dfrtp_1_266 r0 *1 0,0
Xsky130_fd_sc_hd__dfrtp_1_266 clknet_leaf_52_clk \_0019_[27] raw_mem[2][27]
+ rst_n VGND VPWR VPWR sky130_fd_sc_hd__dfrtp_1
* cell instance sky130_fd_sc_hd__dfrtp_1_267 r0 *1 0,0
Xsky130_fd_sc_hd__dfrtp_1_267 clknet_leaf_28_clk \_0018_[18] raw_mem[1][18]
+ rst_n VGND VPWR VPWR sky130_fd_sc_hd__dfrtp_1
* cell instance sky130_fd_sc_hd__dfrtp_1_268 r0 *1 0,0
Xsky130_fd_sc_hd__dfrtp_1_268 clknet_leaf_32_clk \_0009_[15] cond_mem[1][15]
+ rst_n VGND VPWR VPWR sky130_fd_sc_hd__dfrtp_1
* cell instance sky130_fd_sc_hd__dfrtp_1_269 r0 *1 0,0
Xsky130_fd_sc_hd__dfrtp_1_269 clknet_leaf_41_clk \_0019_[18] raw_mem[2][18]
+ rst_n VGND VPWR VPWR sky130_fd_sc_hd__dfrtp_1
* cell instance sky130_fd_sc_hd__dfrtp_1_270 r0 *1 0,0
Xsky130_fd_sc_hd__dfrtp_1_270 clknet_leaf_33_clk \_0010_[15] cond_mem[2][15]
+ rst_n VGND VPWR VPWR sky130_fd_sc_hd__dfrtp_1
* cell instance sky130_fd_sc_hd__dfrtp_1_271 r0 *1 0,0
Xsky130_fd_sc_hd__dfrtp_1_271 clknet_leaf_49_clk \_0022_[4] raw_sr[4] rst_n
+ VGND VPWR VPWR sky130_fd_sc_hd__dfrtp_1
* cell instance sky130_fd_sc_hd__dfrtp_1_272 r0 *1 0,0
Xsky130_fd_sc_hd__dfrtp_1_272 clknet_leaf_31_clk \_0011_[21] cond_mem[3][21]
+ rst_n VGND VPWR VPWR sky130_fd_sc_hd__dfrtp_1
* cell instance sky130_fd_sc_hd__dfrtp_1_273 r0 *1 0,0
Xsky130_fd_sc_hd__dfrtp_1_273 clknet_leaf_31_clk \_0010_[21] cond_mem[2][21]
+ rst_n VGND VPWR VPWR sky130_fd_sc_hd__dfrtp_1
* cell instance sky130_fd_sc_hd__dfrtp_1_274 r0 *1 0,0
Xsky130_fd_sc_hd__dfrtp_1_274 clknet_leaf_41_clk \_0020_[18] raw_mem[3][18]
+ rst_n VGND VPWR VPWR sky130_fd_sc_hd__dfrtp_1
* cell instance sky130_fd_sc_hd__dfrtp_1_275 r0 *1 0,0
Xsky130_fd_sc_hd__dfrtp_1_275 clknet_leaf_53_clk \_0020_[27] raw_mem[3][27]
+ rst_n VGND VPWR VPWR sky130_fd_sc_hd__dfrtp_1
* cell instance sky130_fd_sc_hd__dfrtp_1_276 r0 *1 0,0
Xsky130_fd_sc_hd__dfrtp_1_276 clknet_leaf_29_clk \_0008_[21] cond_mem[0][21]
+ rst_n VGND VPWR VPWR sky130_fd_sc_hd__dfrtp_1
* cell instance sky130_fd_sc_hd__dfrtp_1_277 r0 *1 0,0
Xsky130_fd_sc_hd__dfrtp_1_277 clknet_leaf_50_clk \_0015_[1] raw_count[1] rst_n
+ VGND VPWR VPWR sky130_fd_sc_hd__dfrtp_1
* cell instance sky130_fd_sc_hd__dfrtp_1_278 r0 *1 0,0
Xsky130_fd_sc_hd__dfrtp_1_278 clknet_leaf_52_clk \_0022_[27] raw_sr[27] rst_n
+ VGND VPWR VPWR sky130_fd_sc_hd__dfrtp_1
* cell instance sky130_fd_sc_hd__dfrtp_1_279 r0 *1 0,0
Xsky130_fd_sc_hd__dfrtp_1_279 clknet_leaf_53_clk \_0017_[17] raw_mem[0][17]
+ rst_n VGND VPWR VPWR sky130_fd_sc_hd__dfrtp_1
* cell instance sky130_fd_sc_hd__dfrtp_1_280 r0 *1 0,0
Xsky130_fd_sc_hd__dfrtp_1_280 clknet_leaf_29_clk \_0009_[2] cond_mem[1][2]
+ rst_n VGND VPWR VPWR sky130_fd_sc_hd__dfrtp_1
* cell instance sky130_fd_sc_hd__dfrtp_1_281 r0 *1 0,0
Xsky130_fd_sc_hd__dfrtp_1_281 clknet_leaf_50_clk \_0015_[2] raw_count[2] rst_n
+ VGND VPWR VPWR sky130_fd_sc_hd__dfrtp_1
* cell instance sky130_fd_sc_hd__dfrtp_1_282 r0 *1 0,0
Xsky130_fd_sc_hd__dfrtp_1_282 clknet_leaf_50_clk \_0015_[3] raw_count[3] rst_n
+ VGND VPWR VPWR sky130_fd_sc_hd__dfrtp_1
* cell instance sky130_fd_sc_hd__dfrtp_1_283 r0 *1 0,0
Xsky130_fd_sc_hd__dfrtp_1_283 clknet_leaf_32_clk \_0008_[23] cond_mem[0][23]
+ rst_n VGND VPWR VPWR sky130_fd_sc_hd__dfrtp_1
* cell instance sky130_fd_sc_hd__dfrtp_1_284 r0 *1 0,0
Xsky130_fd_sc_hd__dfrtp_1_284 clknet_leaf_53_clk \_0018_[17] raw_mem[1][17]
+ rst_n VGND VPWR VPWR sky130_fd_sc_hd__dfrtp_1
* cell instance sky130_fd_sc_hd__dfrtp_1_285 r0 *1 0,0
Xsky130_fd_sc_hd__dfrtp_1_285 clknet_leaf_41_clk \_0017_[14] raw_mem[0][14]
+ rst_n VGND VPWR VPWR sky130_fd_sc_hd__dfrtp_1
* cell instance sky130_fd_sc_hd__dfrtp_1_286 r0 *1 0,0
Xsky130_fd_sc_hd__dfrtp_1_286 clknet_leaf_40_clk \_0008_[1] cond_mem[0][1]
+ rst_n VGND VPWR VPWR sky130_fd_sc_hd__dfrtp_1
* cell instance sky130_fd_sc_hd__dfrtp_1_287 r0 *1 0,0
Xsky130_fd_sc_hd__dfrtp_1_287 clknet_leaf_52_clk \_0015_[0] raw_count[0] rst_n
+ VGND VPWR VPWR sky130_fd_sc_hd__dfrtp_1
* cell instance sky130_fd_sc_hd__dfrtp_1_288 r0 *1 0,0
Xsky130_fd_sc_hd__dfrtp_1_288 clknet_leaf_52_clk \_0022_[7] raw_sr[7] rst_n
+ VGND VPWR VPWR sky130_fd_sc_hd__dfrtp_1
* cell instance sky130_fd_sc_hd__dfrtp_1_289 r0 *1 0,0
Xsky130_fd_sc_hd__dfrtp_1_289 clknet_leaf_31_clk \_0009_[22] cond_mem[1][22]
+ rst_n VGND VPWR VPWR sky130_fd_sc_hd__dfrtp_1
* cell instance sky130_fd_sc_hd__dfrtp_1_290 r0 *1 0,0
Xsky130_fd_sc_hd__dfrtp_1_290 clknet_leaf_28_clk \_0009_[1] cond_mem[1][1]
+ rst_n VGND VPWR VPWR sky130_fd_sc_hd__dfrtp_1
* cell instance sky130_fd_sc_hd__dfrtp_1_291 r0 *1 0,0
Xsky130_fd_sc_hd__dfrtp_1_291 clknet_leaf_29_clk \_0008_[22] cond_mem[0][22]
+ rst_n VGND VPWR VPWR sky130_fd_sc_hd__dfrtp_1
* cell instance sky130_fd_sc_hd__dfrtp_1_292 r0 *1 0,0
Xsky130_fd_sc_hd__dfrtp_1_292 clknet_leaf_32_clk \_0009_[23] cond_mem[1][23]
+ rst_n VGND VPWR VPWR sky130_fd_sc_hd__dfrtp_1
* cell instance sky130_fd_sc_hd__dfrtp_1_293 r0 *1 0,0
Xsky130_fd_sc_hd__dfrtp_1_293 clknet_leaf_49_clk \_0022_[1] raw_sr[1] rst_n
+ VGND VPWR VPWR sky130_fd_sc_hd__dfrtp_1
* cell instance sky130_fd_sc_hd__dfrtp_1_294 r0 *1 0,0
Xsky130_fd_sc_hd__dfrtp_1_294 clknet_leaf_29_clk \_0010_[2] cond_mem[2][2]
+ rst_n VGND VPWR VPWR sky130_fd_sc_hd__dfrtp_1
* cell instance sky130_fd_sc_hd__dfrtp_1_295 r0 *1 0,0
Xsky130_fd_sc_hd__dfrtp_1_295 clknet_leaf_52_clk \_0017_[28] raw_mem[0][28]
+ rst_n VGND VPWR VPWR sky130_fd_sc_hd__dfrtp_1
* cell instance sky130_fd_sc_hd__dfrtp_1_296 r0 *1 0,0
Xsky130_fd_sc_hd__dfrtp_1_296 clknet_leaf_53_clk \_0019_[17] raw_mem[2][17]
+ rst_n VGND VPWR VPWR sky130_fd_sc_hd__dfrtp_1
* cell instance sky130_fd_sc_hd__dfrtp_1_297 r0 *1 0,0
Xsky130_fd_sc_hd__dfrtp_1_297 clknet_leaf_41_clk \_0018_[14] raw_mem[1][14]
+ rst_n VGND VPWR VPWR sky130_fd_sc_hd__dfrtp_1
* cell instance sky130_fd_sc_hd__dfrtp_1_298 r0 *1 0,0
Xsky130_fd_sc_hd__dfrtp_1_298 clknet_leaf_29_clk \_0010_[1] cond_mem[2][1]
+ rst_n VGND VPWR VPWR sky130_fd_sc_hd__dfrtp_1
* cell instance sky130_fd_sc_hd__dfrtp_1_299 r0 *1 0,0
Xsky130_fd_sc_hd__dfrtp_1_299 clknet_leaf_28_clk \_0011_[1] cond_mem[3][1]
+ rst_n VGND VPWR VPWR sky130_fd_sc_hd__dfrtp_1
* cell instance sky130_fd_sc_hd__dfrtp_1_300 r0 *1 0,0
Xsky130_fd_sc_hd__dfrtp_1_300 clknet_leaf_52_clk \_0020_[17] raw_mem[3][17]
+ rst_n VGND VPWR VPWR sky130_fd_sc_hd__dfrtp_1
* cell instance sky130_fd_sc_hd__dfrtp_1_301 r0 *1 0,0
Xsky130_fd_sc_hd__dfrtp_1_301 clknet_leaf_31_clk \_0010_[22] cond_mem[2][22]
+ rst_n VGND VPWR VPWR sky130_fd_sc_hd__dfrtp_1
* cell instance sky130_fd_sc_hd__dfrtp_1_302 r0 *1 0,0
Xsky130_fd_sc_hd__dfrtp_1_302 clknet_leaf_33_clk \_0010_[23] cond_mem[2][23]
+ rst_n VGND VPWR VPWR sky130_fd_sc_hd__dfrtp_1
* cell instance sky130_fd_sc_hd__dfrtp_1_303 r0 *1 0,0
Xsky130_fd_sc_hd__dfrtp_1_303 clknet_leaf_41_clk \_0017_[22] raw_mem[0][22]
+ rst_n VGND VPWR VPWR sky130_fd_sc_hd__dfrtp_1
* cell instance sky130_fd_sc_hd__dfrtp_1_304 r0 *1 0,0
Xsky130_fd_sc_hd__dfrtp_1_304 clknet_leaf_41_clk \_0019_[14] raw_mem[2][14]
+ rst_n VGND VPWR VPWR sky130_fd_sc_hd__dfrtp_1
* cell instance sky130_fd_sc_hd__dfrtp_1_305 r0 *1 0,0
Xsky130_fd_sc_hd__dfrtp_1_305 clknet_leaf_41_clk \_0020_[14] raw_mem[3][14]
+ rst_n VGND VPWR VPWR sky130_fd_sc_hd__dfrtp_1
* cell instance sky130_fd_sc_hd__dfrtp_1_306 r0 *1 0,0
Xsky130_fd_sc_hd__dfrtp_1_306 clknet_leaf_49_clk \_0022_[17] raw_sr[17] rst_n
+ VGND VPWR VPWR sky130_fd_sc_hd__dfrtp_1
* cell instance sky130_fd_sc_hd__dfrtp_1_307 r0 *1 0,0
Xsky130_fd_sc_hd__dfrtp_1_307 clknet_leaf_31_clk \_0011_[22] cond_mem[3][22]
+ rst_n VGND VPWR VPWR sky130_fd_sc_hd__dfrtp_1
* cell instance sky130_fd_sc_hd__dfrtp_1_308 r0 *1 0,0
Xsky130_fd_sc_hd__dfrtp_1_308 clknet_leaf_40_clk \_0017_[23] raw_mem[0][23]
+ rst_n VGND VPWR VPWR sky130_fd_sc_hd__dfrtp_1
* cell instance sky130_fd_sc_hd__dfrtp_1_309 r0 *1 0,0
Xsky130_fd_sc_hd__dfrtp_1_309 clknet_leaf_52_clk \_0017_[30] raw_mem[0][30]
+ rst_n VGND VPWR VPWR sky130_fd_sc_hd__dfrtp_1
* cell instance sky130_fd_sc_hd__dfrtp_1_310 r0 *1 0,0
Xsky130_fd_sc_hd__dfrtp_1_310 clknet_leaf_40_clk \_0017_[21] raw_mem[0][21]
+ rst_n VGND VPWR VPWR sky130_fd_sc_hd__dfrtp_1
* cell instance sky130_fd_sc_hd__dfrtp_1_311 r0 *1 0,0
Xsky130_fd_sc_hd__dfrtp_1_311 clknet_leaf_29_clk \_0011_[2] cond_mem[3][2]
+ rst_n VGND VPWR VPWR sky130_fd_sc_hd__dfrtp_1
* cell instance sky130_fd_sc_hd__dfrtp_1_312 r0 *1 0,0
Xsky130_fd_sc_hd__dfrtp_1_312 clknet_leaf_50_clk \_0022_[14] raw_sr[14] rst_n
+ VGND VPWR VPWR sky130_fd_sc_hd__dfrtp_1
* cell instance sky130_fd_sc_hd__dfrtp_1_313 r0 *1 0,0
Xsky130_fd_sc_hd__dfrtp_1_313 clknet_leaf_50_clk \_0022_[6] raw_sr[6] rst_n
+ VGND VPWR VPWR sky130_fd_sc_hd__dfrtp_1
* cell instance sky130_fd_sc_hd__dfrtp_1_314 r0 *1 0,0
Xsky130_fd_sc_hd__dfrtp_1_314 clknet_leaf_33_clk \_0011_[23] cond_mem[3][23]
+ rst_n VGND VPWR VPWR sky130_fd_sc_hd__dfrtp_1
* cell instance sky130_fd_sc_hd__dfrtp_1_315 r0 *1 0,0
Xsky130_fd_sc_hd__dfrtp_1_315 clknet_leaf_42_clk \_0017_[20] raw_mem[0][20]
+ rst_n VGND VPWR VPWR sky130_fd_sc_hd__dfrtp_1
* cell instance sky130_fd_sc_hd__dfrtp_1_316 r0 *1 0,0
Xsky130_fd_sc_hd__dfrtp_1_316 clknet_leaf_51_clk \_0018_[28] raw_mem[1][28]
+ rst_n VGND VPWR VPWR sky130_fd_sc_hd__dfrtp_1
* cell instance sky130_fd_sc_hd__dfrtp_1_317 r0 *1 0,0
Xsky130_fd_sc_hd__dfrtp_1_317 clknet_leaf_49_clk \_0022_[21] raw_sr[21] rst_n
+ VGND VPWR VPWR sky130_fd_sc_hd__dfrtp_1
* cell instance sky130_fd_sc_hd__dfrtp_1_318 r0 *1 0,0
Xsky130_fd_sc_hd__dfrtp_1_318 clknet_leaf_51_clk \_0022_[23] raw_sr[23] rst_n
+ VGND VPWR VPWR sky130_fd_sc_hd__dfrtp_1
* cell instance sky130_fd_sc_hd__dfrtp_1_319 r0 *1 0,0
Xsky130_fd_sc_hd__dfrtp_1_319 clknet_leaf_40_clk \_0018_[21] raw_mem[1][21]
+ rst_n VGND VPWR VPWR sky130_fd_sc_hd__dfrtp_1
* cell instance sky130_fd_sc_hd__dfrtp_1_320 r0 *1 0,0
Xsky130_fd_sc_hd__dfrtp_1_320 clknet_leaf_30_clk \_0006_[11] cond_count[11]
+ rst_n VGND VPWR VPWR sky130_fd_sc_hd__dfrtp_1
* cell instance sky130_fd_sc_hd__dfrtp_1_321 r0 *1 0,0
Xsky130_fd_sc_hd__dfrtp_1_321 clknet_leaf_51_clk \_0018_[20] raw_mem[1][20]
+ rst_n VGND VPWR VPWR sky130_fd_sc_hd__dfrtp_1
* cell instance sky130_fd_sc_hd__dfrtp_1_322 r0 *1 0,0
Xsky130_fd_sc_hd__dfrtp_1_322 clknet_leaf_42_clk \_0020_[21] raw_mem[3][21]
+ rst_n VGND VPWR VPWR sky130_fd_sc_hd__dfrtp_1
* cell instance sky130_fd_sc_hd__dfrtp_1_323 r0 *1 0,0
Xsky130_fd_sc_hd__dfrtp_1_323 clknet_leaf_39_clk \_0006_[14] cond_count[14]
+ rst_n VGND VPWR VPWR sky130_fd_sc_hd__dfrtp_1
* cell instance sky130_fd_sc_hd__dfrtp_1_324 r0 *1 0,0
Xsky130_fd_sc_hd__dfrtp_1_324 clknet_leaf_42_clk \_0019_[21] raw_mem[2][21]
+ rst_n VGND VPWR VPWR sky130_fd_sc_hd__dfrtp_1
* cell instance sky130_fd_sc_hd__dfrtp_1_325 r0 *1 0,0
Xsky130_fd_sc_hd__dfrtp_1_325 clknet_leaf_30_clk \_0006_[8] cond_count[8] rst_n
+ VGND VPWR VPWR sky130_fd_sc_hd__dfrtp_1
* cell instance sky130_fd_sc_hd__dfrtp_1_326 r0 *1 0,0
Xsky130_fd_sc_hd__dfrtp_1_326 clknet_leaf_30_clk \_0006_[6] cond_count[6] rst_n
+ VGND VPWR VPWR sky130_fd_sc_hd__dfrtp_1
* cell instance sky130_fd_sc_hd__dfrtp_1_327 r0 *1 0,0
Xsky130_fd_sc_hd__dfrtp_1_327 clknet_leaf_30_clk \_0006_[1] cond_count[1] rst_n
+ VGND VPWR VPWR sky130_fd_sc_hd__dfrtp_1
* cell instance sky130_fd_sc_hd__dfrtp_1_328 r0 *1 0,0
Xsky130_fd_sc_hd__dfrtp_1_328 clknet_leaf_49_clk \_0022_[20] raw_sr[20] rst_n
+ VGND VPWR VPWR sky130_fd_sc_hd__dfrtp_1
* cell instance sky130_fd_sc_hd__dfrtp_1_329 r0 *1 0,0
Xsky130_fd_sc_hd__dfrtp_1_329 clknet_leaf_42_clk \_0018_[22] raw_mem[1][22]
+ rst_n VGND VPWR VPWR sky130_fd_sc_hd__dfrtp_1
* cell instance sky130_fd_sc_hd__dfrtp_1_330 r0 *1 0,0
Xsky130_fd_sc_hd__dfrtp_1_330 clknet_leaf_51_clk \_0019_[28] raw_mem[2][28]
+ rst_n VGND VPWR VPWR sky130_fd_sc_hd__dfrtp_1
* cell instance sky130_fd_sc_hd__dfrtp_1_331 r0 *1 0,0
Xsky130_fd_sc_hd__dfrtp_1_331 clknet_leaf_33_clk \_0006_[0] cond_count[0] rst_n
+ VGND VPWR VPWR sky130_fd_sc_hd__dfrtp_1
* cell instance sky130_fd_sc_hd__dfrtp_1_332 r0 *1 0,0
Xsky130_fd_sc_hd__dfrtp_1_332 clknet_leaf_48_clk \_0022_[30] raw_sr[30] rst_n
+ VGND VPWR VPWR sky130_fd_sc_hd__dfrtp_1
* cell instance sky130_fd_sc_hd__dfrtp_1_333 r0 *1 0,0
Xsky130_fd_sc_hd__dfrtp_1_333 clknet_leaf_30_clk \_0006_[2] cond_count[2] rst_n
+ VGND VPWR VPWR sky130_fd_sc_hd__dfrtp_1
* cell instance sky130_fd_sc_hd__dfrtp_1_334 r0 *1 0,0
Xsky130_fd_sc_hd__dfrtp_1_334 clknet_leaf_42_clk \_0019_[22] raw_mem[2][22]
+ rst_n VGND VPWR VPWR sky130_fd_sc_hd__dfrtp_1
* cell instance sky130_fd_sc_hd__dfrtp_1_335 r0 *1 0,0
Xsky130_fd_sc_hd__dfrtp_1_335 clknet_leaf_50_clk \_0022_[28] raw_sr[28] rst_n
+ VGND VPWR VPWR sky130_fd_sc_hd__dfrtp_1
* cell instance sky130_fd_sc_hd__dfrtp_1_336 r0 *1 0,0
Xsky130_fd_sc_hd__dfrtp_1_336 clknet_leaf_50_clk \_0022_[22] raw_sr[22] rst_n
+ VGND VPWR VPWR sky130_fd_sc_hd__dfrtp_1
* cell instance sky130_fd_sc_hd__dfrtp_1_337 r0 *1 0,0
Xsky130_fd_sc_hd__dfrtp_1_337 clknet_leaf_51_clk \_0018_[30] raw_mem[1][30]
+ rst_n VGND VPWR VPWR sky130_fd_sc_hd__dfrtp_1
* cell instance sky130_fd_sc_hd__dfrtp_1_338 r0 *1 0,0
Xsky130_fd_sc_hd__dfrtp_1_338 clknet_leaf_43_clk \_0020_[28] raw_mem[3][28]
+ rst_n VGND VPWR VPWR sky130_fd_sc_hd__dfrtp_1
* cell instance sky130_fd_sc_hd__dfrtp_1_339 r0 *1 0,0
Xsky130_fd_sc_hd__dfrtp_1_339 clknet_leaf_30_clk \_0006_[9] cond_count[9] rst_n
+ VGND VPWR VPWR sky130_fd_sc_hd__dfrtp_1
* cell instance sky130_fd_sc_hd__dfrtp_1_340 r0 *1 0,0
Xsky130_fd_sc_hd__dfrtp_1_340 clknet_leaf_42_clk \_0018_[23] raw_mem[1][23]
+ rst_n VGND VPWR VPWR sky130_fd_sc_hd__dfrtp_1
* cell instance sky130_fd_sc_hd__dfrtp_1_341 r0 *1 0,0
Xsky130_fd_sc_hd__dfrtp_1_341 clknet_leaf_40_clk \_0006_[13] cond_count[13]
+ rst_n VGND VPWR VPWR sky130_fd_sc_hd__dfrtp_1
* cell instance sky130_fd_sc_hd__dfrtp_1_342 r0 *1 0,0
Xsky130_fd_sc_hd__dfrtp_1_342 clknet_leaf_51_clk \_0019_[30] raw_mem[2][30]
+ rst_n VGND VPWR VPWR sky130_fd_sc_hd__dfrtp_1
* cell instance sky130_fd_sc_hd__dfrtp_1_343 r0 *1 0,0
Xsky130_fd_sc_hd__dfrtp_1_343 clknet_leaf_43_clk \_0019_[20] raw_mem[2][20]
+ rst_n VGND VPWR VPWR sky130_fd_sc_hd__dfrtp_1
* cell instance sky130_fd_sc_hd__dfrtp_1_344 r0 *1 0,0
Xsky130_fd_sc_hd__dfrtp_1_344 clknet_leaf_39_clk \_0006_[10] cond_count[10]
+ rst_n VGND VPWR VPWR sky130_fd_sc_hd__dfrtp_1
* cell instance sky130_fd_sc_hd__dfrtp_1_345 r0 *1 0,0
Xsky130_fd_sc_hd__dfrtp_1_345 clknet_leaf_34_clk \_0006_[3] cond_count[3] rst_n
+ VGND VPWR VPWR sky130_fd_sc_hd__dfrtp_1
* cell instance sky130_fd_sc_hd__dfrtp_1_346 r0 *1 0,0
Xsky130_fd_sc_hd__dfrtp_1_346 clknet_leaf_51_clk \_0020_[30] raw_mem[3][30]
+ rst_n VGND VPWR VPWR sky130_fd_sc_hd__dfrtp_1
* cell instance sky130_fd_sc_hd__dfrtp_1_347 r0 *1 0,0
Xsky130_fd_sc_hd__dfrtp_1_347 clknet_leaf_43_clk \_0020_[20] raw_mem[3][20]
+ rst_n VGND VPWR VPWR sky130_fd_sc_hd__dfrtp_1
* cell instance sky130_fd_sc_hd__dfrtp_1_348 r0 *1 0,0
Xsky130_fd_sc_hd__dfrtp_1_348 clknet_leaf_43_clk \_0020_[22] raw_mem[3][22]
+ rst_n VGND VPWR VPWR sky130_fd_sc_hd__dfrtp_1
* cell instance sky130_fd_sc_hd__dfrtp_1_349 r0 *1 0,0
Xsky130_fd_sc_hd__dfrtp_1_349 clknet_leaf_30_clk \_0006_[7] cond_count[7] rst_n
+ VGND VPWR VPWR sky130_fd_sc_hd__dfrtp_1
* cell instance sky130_fd_sc_hd__dfrtp_1_350 r0 *1 0,0
Xsky130_fd_sc_hd__dfrtp_1_350 clknet_leaf_40_clk \_0019_[23] raw_mem[2][23]
+ rst_n VGND VPWR VPWR sky130_fd_sc_hd__dfrtp_1
* cell instance sky130_fd_sc_hd__dfrtp_1_351 r0 *1 0,0
Xsky130_fd_sc_hd__dfrtp_1_351 clknet_leaf_42_clk \_0020_[23] raw_mem[3][23]
+ rst_n VGND VPWR VPWR sky130_fd_sc_hd__dfrtp_1
* cell instance sky130_fd_sc_hd__dfrtp_1_352 r0 *1 0,0
Xsky130_fd_sc_hd__dfrtp_1_352 clknet_leaf_40_clk \_0006_[15] cond_count[15]
+ rst_n VGND VPWR VPWR sky130_fd_sc_hd__dfrtp_1
* cell instance sky130_fd_sc_hd__dfrtp_1_353 r0 *1 0,0
Xsky130_fd_sc_hd__dfrtp_1_353 clknet_leaf_39_clk \_0006_[12] cond_count[12]
+ rst_n VGND VPWR VPWR sky130_fd_sc_hd__dfrtp_1
* cell instance sky130_fd_sc_hd__dfrtp_1_354 r0 *1 0,0
Xsky130_fd_sc_hd__dfrtp_1_354 clknet_leaf_42_clk \_0026_[13] startup_count[13]
+ rst_n VGND VPWR VPWR sky130_fd_sc_hd__dfrtp_1
* cell instance sky130_fd_sc_hd__dfrtp_1_355 r0 *1 0,0
Xsky130_fd_sc_hd__dfrtp_1_355 clknet_leaf_34_clk \_0006_[4] cond_count[4] rst_n
+ VGND VPWR VPWR sky130_fd_sc_hd__dfrtp_1
* cell instance sky130_fd_sc_hd__dfrtp_1_356 r0 *1 0,0
Xsky130_fd_sc_hd__dfrtp_1_356 clknet_leaf_43_clk \_0026_[6] startup_count[6]
+ rst_n VGND VPWR VPWR sky130_fd_sc_hd__dfrtp_1
* cell instance sky130_fd_sc_hd__dfrtp_1_357 r0 *1 0,0
Xsky130_fd_sc_hd__dfrtp_1_357 clknet_leaf_43_clk \_0026_[7] startup_count[7]
+ rst_n VGND VPWR VPWR sky130_fd_sc_hd__dfrtp_1
* cell instance sky130_fd_sc_hd__dfrtp_1_358 r0 *1 0,0
Xsky130_fd_sc_hd__dfrtp_1_358 clknet_leaf_34_clk \_0006_[5] cond_count[5] rst_n
+ VGND VPWR VPWR sky130_fd_sc_hd__dfrtp_1
* cell instance sky130_fd_sc_hd__dfrtp_1_359 r0 *1 0,0
Xsky130_fd_sc_hd__dfrtp_1_359 clknet_leaf_44_clk \_0026_[12] startup_count[12]
+ rst_n VGND VPWR VPWR sky130_fd_sc_hd__dfrtp_1
* cell instance sky130_fd_sc_hd__dfrtp_1_360 r0 *1 0,0
Xsky130_fd_sc_hd__dfrtp_1_360 clknet_leaf_38_clk \_0027_ startup_done_r rst_n
+ VGND VPWR VPWR sky130_fd_sc_hd__dfrtp_1
* cell instance sky130_fd_sc_hd__dfrtp_1_361 r0 *1 0,0
Xsky130_fd_sc_hd__dfrtp_1_361 clknet_leaf_43_clk \_0026_[9] startup_count[9]
+ rst_n VGND VPWR VPWR sky130_fd_sc_hd__dfrtp_1
* cell instance sky130_fd_sc_hd__dfrtp_1_362 r0 *1 0,0
Xsky130_fd_sc_hd__dfrtp_1_362 clknet_leaf_44_clk \_0026_[10] startup_count[10]
+ rst_n VGND VPWR VPWR sky130_fd_sc_hd__dfrtp_1
* cell instance sky130_fd_sc_hd__dfrtp_1_363 r0 *1 0,0
Xsky130_fd_sc_hd__dfrtp_1_363 clknet_leaf_39_clk \_0004_[12] apt_matches[12]
+ rst_n VGND VPWR VPWR sky130_fd_sc_hd__dfrtp_1
* cell instance sky130_fd_sc_hd__dfrtp_1_364 r0 *1 0,0
Xsky130_fd_sc_hd__dfrtp_1_364 clknet_leaf_34_clk \_0004_[10] apt_matches[10]
+ rst_n VGND VPWR VPWR sky130_fd_sc_hd__dfrtp_1
* cell instance sky130_fd_sc_hd__dfrtp_1_365 r0 *1 0,0
Xsky130_fd_sc_hd__dfrtp_1_365 clknet_leaf_48_clk \_0026_[4] startup_count[4]
+ rst_n VGND VPWR VPWR sky130_fd_sc_hd__dfrtp_1
* cell instance sky130_fd_sc_hd__dfrtp_1_366 r0 *1 0,0
Xsky130_fd_sc_hd__dfrtp_1_366 clknet_leaf_39_clk \_0004_[13] apt_matches[13]
+ rst_n VGND VPWR VPWR sky130_fd_sc_hd__dfrtp_1
* cell instance sky130_fd_sc_hd__dfrtp_1_367 r0 *1 0,0
Xsky130_fd_sc_hd__dfrtp_1_367 clknet_leaf_39_clk \_0004_[14] apt_matches[14]
+ rst_n VGND VPWR VPWR sky130_fd_sc_hd__dfrtp_1
* cell instance sky130_fd_sc_hd__dfrtp_1_368 r0 *1 0,0
Xsky130_fd_sc_hd__dfrtp_1_368 clknet_leaf_48_clk \_0026_[5] startup_count[5]
+ rst_n VGND VPWR VPWR sky130_fd_sc_hd__dfrtp_1
* cell instance sky130_fd_sc_hd__dfrtp_1_369 r0 *1 0,0
Xsky130_fd_sc_hd__dfrtp_1_369 clknet_leaf_35_clk \_0004_[11] apt_matches[11]
+ rst_n VGND VPWR VPWR sky130_fd_sc_hd__dfrtp_1
* cell instance sky130_fd_sc_hd__dfrtp_1_370 r0 *1 0,0
Xsky130_fd_sc_hd__dfrtp_1_370 clknet_leaf_38_clk \_0026_[15] startup_count[15]
+ rst_n VGND VPWR VPWR sky130_fd_sc_hd__dfrtp_1
* cell instance sky130_fd_sc_hd__dfrtp_1_371 r0 *1 0,0
Xsky130_fd_sc_hd__dfrtp_1_371 clknet_leaf_38_clk \_0004_[15] apt_matches[15]
+ rst_n VGND VPWR VPWR sky130_fd_sc_hd__dfrtp_1
* cell instance sky130_fd_sc_hd__dfrtp_1_372 r0 *1 0,0
Xsky130_fd_sc_hd__dfrtp_1_372 clknet_leaf_38_clk \_0003_[13] apt_index[13]
+ rst_n VGND VPWR VPWR sky130_fd_sc_hd__dfrtp_1
* cell instance sky130_fd_sc_hd__dfrtp_1_373 r0 *1 0,0
Xsky130_fd_sc_hd__dfrtp_1_373 clknet_leaf_38_clk \_0003_[14] apt_index[14]
+ rst_n VGND VPWR VPWR sky130_fd_sc_hd__dfrtp_1
* cell instance sky130_fd_sc_hd__dfrtp_1_374 r0 *1 0,0
Xsky130_fd_sc_hd__dfrtp_1_374 clknet_leaf_44_clk \_0026_[11] startup_count[11]
+ rst_n VGND VPWR VPWR sky130_fd_sc_hd__dfrtp_1
* cell instance sky130_fd_sc_hd__dfrtp_1_375 r0 *1 0,0
Xsky130_fd_sc_hd__dfrtp_1_375 clknet_leaf_34_clk \_0004_[9] apt_matches[9]
+ rst_n VGND VPWR VPWR sky130_fd_sc_hd__dfrtp_1
* cell instance sky130_fd_sc_hd__dfrtp_1_376 r0 *1 0,0
Xsky130_fd_sc_hd__dfrtp_1_376 clknet_leaf_38_clk \_0026_[14] startup_count[14]
+ rst_n VGND VPWR VPWR sky130_fd_sc_hd__dfrtp_1
* cell instance sky130_fd_sc_hd__dfrtp_1_377 r0 *1 0,0
Xsky130_fd_sc_hd__dfrtp_1_377 clknet_leaf_44_clk \_0026_[8] startup_count[8]
+ rst_n VGND VPWR VPWR sky130_fd_sc_hd__dfrtp_1
* cell instance sky130_fd_sc_hd__dfrtp_1_378 r0 *1 0,0
Xsky130_fd_sc_hd__dfrtp_1_378 clknet_leaf_48_clk \_0026_[1] startup_count[1]
+ rst_n VGND VPWR VPWR sky130_fd_sc_hd__dfrtp_1
* cell instance sky130_fd_sc_hd__dfrtp_1_379 r0 *1 0,0
Xsky130_fd_sc_hd__dfrtp_1_379 clknet_leaf_47_clk \_0026_[0] startup_count[0]
+ rst_n VGND VPWR VPWR sky130_fd_sc_hd__dfrtp_1
* cell instance sky130_fd_sc_hd__dfrtp_1_380 r0 *1 0,0
Xsky130_fd_sc_hd__dfrtp_1_380 clknet_leaf_44_clk \_0025_ rct_ref rst_n VGND
+ VPWR VPWR sky130_fd_sc_hd__dfrtp_1
* cell instance sky130_fd_sc_hd__dfrtp_1_381 r0 *1 0,0
Xsky130_fd_sc_hd__dfrtp_1_381 clknet_leaf_48_clk \_0026_[2] startup_count[2]
+ rst_n VGND VPWR VPWR sky130_fd_sc_hd__dfrtp_1
* cell instance sky130_fd_sc_hd__dfrtp_1_382 r0 *1 0,0
Xsky130_fd_sc_hd__dfrtp_1_382 clknet_leaf_39_clk \_0005_ apt_ref rst_n VGND
+ VPWR VPWR sky130_fd_sc_hd__dfrtp_1
* cell instance sky130_fd_sc_hd__dfrtp_1_383 r0 *1 0,0
Xsky130_fd_sc_hd__dfrtp_1_383 clknet_leaf_47_clk \_0026_[3] startup_count[3]
+ rst_n VGND VPWR VPWR sky130_fd_sc_hd__dfrtp_1
* cell instance sky130_fd_sc_hd__dfrtp_1_384 r0 *1 0,0
Xsky130_fd_sc_hd__dfrtp_1_384 clknet_leaf_35_clk \_0004_[1] apt_matches[1]
+ rst_n VGND VPWR VPWR sky130_fd_sc_hd__dfrtp_1
* cell instance sky130_fd_sc_hd__dfrtp_1_385 r0 *1 0,0
Xsky130_fd_sc_hd__dfrtp_1_385 clknet_leaf_37_clk \_0003_[15] apt_index[15]
+ rst_n VGND VPWR VPWR sky130_fd_sc_hd__dfrtp_1
* cell instance sky130_fd_sc_hd__dfrtp_1_386 r0 *1 0,0
Xsky130_fd_sc_hd__dfrtp_1_386 clknet_leaf_47_clk \_0024_[0] rct_count[0] rst_n
+ VGND VPWR VPWR sky130_fd_sc_hd__dfrtp_1
* cell instance sky130_fd_sc_hd__dfrtp_1_387 r0 *1 0,0
Xsky130_fd_sc_hd__dfrtp_1_387 clknet_leaf_45_clk \_0024_[7] rct_count[7] rst_n
+ VGND VPWR VPWR sky130_fd_sc_hd__dfrtp_1
* cell instance sky130_fd_sc_hd__dfrtp_1_388 r0 *1 0,0
Xsky130_fd_sc_hd__dfrtp_1_388 clknet_leaf_35_clk \_0004_[2] apt_matches[2]
+ rst_n VGND VPWR VPWR sky130_fd_sc_hd__dfrtp_1
* cell instance sky130_fd_sc_hd__dfrtp_1_389 r0 *1 0,0
Xsky130_fd_sc_hd__dfrtp_1_389 clknet_leaf_47_clk \_0024_[1] rct_count[1] rst_n
+ VGND VPWR VPWR sky130_fd_sc_hd__dfrtp_1
* cell instance sky130_fd_sc_hd__dfrtp_1_390 r0 *1 0,0
Xsky130_fd_sc_hd__dfrtp_1_390 clknet_leaf_45_clk \_0023_ rct_armed rst_n VGND
+ VPWR VPWR sky130_fd_sc_hd__dfrtp_1
* cell instance sky130_fd_sc_hd__dfrtp_1_391 r0 *1 0,0
Xsky130_fd_sc_hd__dfrtp_1_391 clknet_leaf_45_clk \_0024_[15] rct_count[15]
+ rst_n VGND VPWR VPWR sky130_fd_sc_hd__dfrtp_1
* cell instance sky130_fd_sc_hd__dfrtp_1_392 r0 *1 0,0
Xsky130_fd_sc_hd__dfrtp_1_392 clknet_leaf_37_clk \_0003_[11] apt_index[11]
+ rst_n VGND VPWR VPWR sky130_fd_sc_hd__dfrtp_1
* cell instance sky130_fd_sc_hd__dfrtp_1_393 r0 *1 0,0
Xsky130_fd_sc_hd__dfrtp_1_393 clknet_leaf_37_clk \_0004_[0] apt_matches[0]
+ rst_n VGND VPWR VPWR sky130_fd_sc_hd__dfrtp_1
* cell instance sky130_fd_sc_hd__dfrtp_1_394 r0 *1 0,0
Xsky130_fd_sc_hd__dfrtp_1_394 clknet_leaf_45_clk \_0003_[12] apt_index[12]
+ rst_n VGND VPWR VPWR sky130_fd_sc_hd__dfrtp_1
* cell instance sky130_fd_sc_hd__dfrtp_1_395 r0 *1 0,0
Xsky130_fd_sc_hd__dfrtp_1_395 clknet_leaf_37_clk \_0003_[10] apt_index[10]
+ rst_n VGND VPWR VPWR sky130_fd_sc_hd__dfrtp_1
* cell instance sky130_fd_sc_hd__dfrtp_1_396 r0 *1 0,0
Xsky130_fd_sc_hd__dfrtp_1_396 clknet_leaf_34_clk \_0004_[8] apt_matches[8]
+ rst_n VGND VPWR VPWR sky130_fd_sc_hd__dfrtp_1
* cell instance sky130_fd_sc_hd__dfrtp_1_397 r0 *1 0,0
Xsky130_fd_sc_hd__dfrtp_1_397 clknet_leaf_35_clk \_0004_[6] apt_matches[6]
+ rst_n VGND VPWR VPWR sky130_fd_sc_hd__dfrtp_1
* cell instance sky130_fd_sc_hd__dfrtp_1_398 r0 *1 0,0
Xsky130_fd_sc_hd__dfrtp_1_398 clknet_leaf_45_clk \_0024_[10] rct_count[10]
+ rst_n VGND VPWR VPWR sky130_fd_sc_hd__dfrtp_1
* cell instance sky130_fd_sc_hd__dfrtp_1_399 r0 *1 0,0
Xsky130_fd_sc_hd__dfrtp_1_399 clknet_leaf_47_clk \_0024_[2] rct_count[2] rst_n
+ VGND VPWR VPWR sky130_fd_sc_hd__dfrtp_1
* cell instance sky130_fd_sc_hd__dfrtp_1_400 r0 *1 0,0
Xsky130_fd_sc_hd__dfrtp_1_400 clknet_leaf_45_clk \_0024_[11] rct_count[11]
+ rst_n VGND VPWR VPWR sky130_fd_sc_hd__dfrtp_1
* cell instance sky130_fd_sc_hd__dfrtp_1_401 r0 *1 0,0
Xsky130_fd_sc_hd__dfrtp_1_401 clknet_leaf_36_clk \_0003_[0] apt_index[0] rst_n
+ VGND VPWR VPWR sky130_fd_sc_hd__dfrtp_1
* cell instance sky130_fd_sc_hd__dfrtp_1_402 r0 *1 0,0
Xsky130_fd_sc_hd__dfrtp_1_402 clknet_leaf_46_clk \_0024_[6] rct_count[6] rst_n
+ VGND VPWR VPWR sky130_fd_sc_hd__dfrtp_1
* cell instance sky130_fd_sc_hd__dfrtp_1_403 r0 *1 0,0
Xsky130_fd_sc_hd__dfrtp_1_403 clknet_leaf_37_clk \_0024_[9] rct_count[9] rst_n
+ VGND VPWR VPWR sky130_fd_sc_hd__dfrtp_1
* cell instance sky130_fd_sc_hd__dfrtp_1_404 r0 *1 0,0
Xsky130_fd_sc_hd__dfrtp_1_404 clknet_leaf_45_clk \_0003_[9] apt_index[9] rst_n
+ VGND VPWR VPWR sky130_fd_sc_hd__dfrtp_1
* cell instance sky130_fd_sc_hd__dfrtp_1_405 r0 *1 0,0
Xsky130_fd_sc_hd__dfrtp_1_405 clknet_leaf_36_clk \_0003_[2] apt_index[2] rst_n
+ VGND VPWR VPWR sky130_fd_sc_hd__dfrtp_1
* cell instance sky130_fd_sc_hd__dfrtp_1_406 r0 *1 0,0
Xsky130_fd_sc_hd__dfrtp_1_406 clknet_leaf_34_clk \_0004_[7] apt_matches[7]
+ rst_n VGND VPWR VPWR sky130_fd_sc_hd__dfrtp_1
* cell instance sky130_fd_sc_hd__dfrtp_1_407 r0 *1 0,0
Xsky130_fd_sc_hd__dfrtp_1_407 clknet_leaf_36_clk \_0004_[4] apt_matches[4]
+ rst_n VGND VPWR VPWR sky130_fd_sc_hd__dfrtp_1
* cell instance sky130_fd_sc_hd__dfrtp_1_408 r0 *1 0,0
Xsky130_fd_sc_hd__dfrtp_1_408 clknet_leaf_47_clk \_0024_[3] rct_count[3] rst_n
+ VGND VPWR VPWR sky130_fd_sc_hd__dfrtp_1
* cell instance sky130_fd_sc_hd__dfrtp_1_409 r0 *1 0,0
Xsky130_fd_sc_hd__dfrtp_1_409 clknet_leaf_37_clk \_0003_[8] apt_index[8] rst_n
+ VGND VPWR VPWR sky130_fd_sc_hd__dfrtp_1
* cell instance sky130_fd_sc_hd__dfrtp_1_410 r0 *1 0,0
Xsky130_fd_sc_hd__dfrtp_1_410 clknet_leaf_46_clk \_0024_[4] rct_count[4] rst_n
+ VGND VPWR VPWR sky130_fd_sc_hd__dfrtp_1
* cell instance sky130_fd_sc_hd__dfrtp_1_411 r0 *1 0,0
Xsky130_fd_sc_hd__dfrtp_1_411 clknet_leaf_46_clk \_0024_[5] rct_count[5] rst_n
+ VGND VPWR VPWR sky130_fd_sc_hd__dfrtp_1
* cell instance sky130_fd_sc_hd__dfrtp_1_412 r0 *1 0,0
Xsky130_fd_sc_hd__dfrtp_1_412 clknet_leaf_46_clk \_0024_[12] rct_count[12]
+ rst_n VGND VPWR VPWR sky130_fd_sc_hd__dfrtp_1
* cell instance sky130_fd_sc_hd__dfrtp_1_413 r0 *1 0,0
Xsky130_fd_sc_hd__dfrtp_1_413 clknet_leaf_35_clk \_0004_[3] apt_matches[3]
+ rst_n VGND VPWR VPWR sky130_fd_sc_hd__dfrtp_1
* cell instance sky130_fd_sc_hd__dfrtp_1_414 r0 *1 0,0
Xsky130_fd_sc_hd__dfrtp_1_414 clknet_leaf_35_clk \_0004_[5] apt_matches[5]
+ rst_n VGND VPWR VPWR sky130_fd_sc_hd__dfrtp_1
* cell instance sky130_fd_sc_hd__dfrtp_1_415 r0 *1 0,0
Xsky130_fd_sc_hd__dfrtp_1_415 clknet_leaf_46_clk \_0024_[14] rct_count[14]
+ rst_n VGND VPWR VPWR sky130_fd_sc_hd__dfrtp_1
* cell instance sky130_fd_sc_hd__dfrtp_1_416 r0 *1 0,0
Xsky130_fd_sc_hd__dfrtp_1_416 clknet_leaf_36_clk \_0003_[1] apt_index[1] rst_n
+ VGND VPWR VPWR sky130_fd_sc_hd__dfrtp_1
* cell instance sky130_fd_sc_hd__dfrtp_1_417 r0 *1 0,0
Xsky130_fd_sc_hd__dfrtp_1_417 clknet_leaf_46_clk \_0024_[13] rct_count[13]
+ rst_n VGND VPWR VPWR sky130_fd_sc_hd__dfrtp_1
* cell instance sky130_fd_sc_hd__dfrtp_1_418 r0 *1 0,0
Xsky130_fd_sc_hd__dfrtp_1_418 clknet_leaf_46_clk \_0024_[8] rct_count[8] rst_n
+ VGND VPWR VPWR sky130_fd_sc_hd__dfrtp_1
* cell instance sky130_fd_sc_hd__dfrtp_1_419 r0 *1 0,0
Xsky130_fd_sc_hd__dfrtp_1_419 clknet_leaf_36_clk \_0003_[3] apt_index[3] rst_n
+ VGND VPWR VPWR sky130_fd_sc_hd__dfrtp_1
* cell instance sky130_fd_sc_hd__dfrtp_1_420 r0 *1 0,0
Xsky130_fd_sc_hd__dfrtp_1_420 clknet_leaf_37_clk \_0003_[7] apt_index[7] rst_n
+ VGND VPWR VPWR sky130_fd_sc_hd__dfrtp_1
* cell instance sky130_fd_sc_hd__dfrtp_1_421 r0 *1 0,0
Xsky130_fd_sc_hd__dfrtp_1_421 clknet_leaf_37_clk \_0003_[6] apt_index[6] rst_n
+ VGND VPWR VPWR sky130_fd_sc_hd__dfrtp_1
* cell instance sky130_fd_sc_hd__dfrtp_1_422 r0 *1 0,0
Xsky130_fd_sc_hd__dfrtp_1_422 clknet_leaf_36_clk \_0003_[5] apt_index[5] rst_n
+ VGND VPWR VPWR sky130_fd_sc_hd__dfrtp_1
* cell instance sky130_fd_sc_hd__dfrtp_1_423 r0 *1 0,0
Xsky130_fd_sc_hd__dfrtp_1_423 clknet_leaf_36_clk \_0003_[4] apt_index[4] rst_n
+ VGND VPWR VPWR sky130_fd_sc_hd__dfrtp_1
* cell instance sky130_fd_sc_hd__dfstp_1_0 r0 *1 0,0
Xsky130_fd_sc_hd__dfstp_1_0 clknet_leaf_15_clk \_0013_[30] crc_state[30] rst_n
+ VGND VPWR VPWR sky130_fd_sc_hd__dfstp_1
* cell instance sky130_fd_sc_hd__dfstp_1_1 r0 *1 0,0
Xsky130_fd_sc_hd__dfstp_1_1 clknet_leaf_15_clk \_0013_[25] crc_state[25] rst_n
+ VGND VPWR VPWR sky130_fd_sc_hd__dfstp_1
* cell instance sky130_fd_sc_hd__dfstp_1_2 r0 *1 0,0
Xsky130_fd_sc_hd__dfstp_1_2 clknet_leaf_20_clk \_0013_[5] crc_state[5] rst_n
+ VGND VPWR VPWR sky130_fd_sc_hd__dfstp_1
* cell instance sky130_fd_sc_hd__dfstp_1_3 r0 *1 0,0
Xsky130_fd_sc_hd__dfstp_1_3 clknet_leaf_20_clk \_0013_[4] crc_state[4] rst_n
+ VGND VPWR VPWR sky130_fd_sc_hd__dfstp_1
* cell instance sky130_fd_sc_hd__dfstp_1_4 r0 *1 0,0
Xsky130_fd_sc_hd__dfstp_1_4 clknet_leaf_10_clk \_0013_[26] crc_state[26] rst_n
+ VGND VPWR VPWR sky130_fd_sc_hd__dfstp_1
* cell instance sky130_fd_sc_hd__dfstp_1_5 r0 *1 0,0
Xsky130_fd_sc_hd__dfstp_1_5 clknet_leaf_15_clk \_0013_[31] crc_state[31] rst_n
+ VGND VPWR VPWR sky130_fd_sc_hd__dfstp_1
* cell instance sky130_fd_sc_hd__dfstp_1_6 r0 *1 0,0
Xsky130_fd_sc_hd__dfstp_1_6 clknet_leaf_20_clk \_0013_[24] crc_state[24] rst_n
+ VGND VPWR VPWR sky130_fd_sc_hd__dfstp_1
* cell instance sky130_fd_sc_hd__dfstp_1_7 r0 *1 0,0
Xsky130_fd_sc_hd__dfstp_1_7 clknet_leaf_9_clk \_0013_[6] crc_state[6] rst_n
+ VGND VPWR VPWR sky130_fd_sc_hd__dfstp_1
* cell instance sky130_fd_sc_hd__dfstp_1_8 r0 *1 0,0
Xsky130_fd_sc_hd__dfstp_1_8 clknet_leaf_21_clk \_0013_[7] crc_state[7] rst_n
+ VGND VPWR VPWR sky130_fd_sc_hd__dfstp_1
* cell instance sky130_fd_sc_hd__dfstp_1_9 r0 *1 0,0
Xsky130_fd_sc_hd__dfstp_1_9 clknet_leaf_9_clk \_0013_[29] crc_state[29] rst_n
+ VGND VPWR VPWR sky130_fd_sc_hd__dfstp_1
* cell instance sky130_fd_sc_hd__dfstp_1_10 r0 *1 0,0
Xsky130_fd_sc_hd__dfstp_1_10 clknet_leaf_9_clk \_0013_[28] crc_state[28] rst_n
+ VGND VPWR VPWR sky130_fd_sc_hd__dfstp_1
* cell instance sky130_fd_sc_hd__dfstp_1_11 r0 *1 0,0
Xsky130_fd_sc_hd__dfstp_1_11 clknet_leaf_22_clk \_0013_[16] crc_state[16] rst_n
+ VGND VPWR VPWR sky130_fd_sc_hd__dfstp_1
* cell instance sky130_fd_sc_hd__dfstp_1_12 r0 *1 0,0
Xsky130_fd_sc_hd__dfstp_1_12 clknet_leaf_9_clk \_0013_[27] crc_state[27] rst_n
+ VGND VPWR VPWR sky130_fd_sc_hd__dfstp_1
* cell instance sky130_fd_sc_hd__dfstp_1_13 r0 *1 0,0
Xsky130_fd_sc_hd__dfstp_1_13 clknet_leaf_21_clk \_0013_[8] crc_state[8] rst_n
+ VGND VPWR VPWR sky130_fd_sc_hd__dfstp_1
* cell instance sky130_fd_sc_hd__dfstp_1_14 r0 *1 0,0
Xsky130_fd_sc_hd__dfstp_1_14 clknet_leaf_21_clk \_0013_[17] crc_state[17] rst_n
+ VGND VPWR VPWR sky130_fd_sc_hd__dfstp_1
* cell instance sky130_fd_sc_hd__dfstp_1_15 r0 *1 0,0
Xsky130_fd_sc_hd__dfstp_1_15 clknet_leaf_21_clk \_0013_[11] crc_state[11] rst_n
+ VGND VPWR VPWR sky130_fd_sc_hd__dfstp_1
* cell instance sky130_fd_sc_hd__dfstp_1_16 r0 *1 0,0
Xsky130_fd_sc_hd__dfstp_1_16 clknet_leaf_25_clk \_0013_[9] crc_state[9] rst_n
+ VGND VPWR VPWR sky130_fd_sc_hd__dfstp_1
* cell instance sky130_fd_sc_hd__dfstp_1_17 r0 *1 0,0
Xsky130_fd_sc_hd__dfstp_1_17 clknet_leaf_22_clk \_0013_[12] crc_state[12] rst_n
+ VGND VPWR VPWR sky130_fd_sc_hd__dfstp_1
* cell instance sky130_fd_sc_hd__dfstp_1_18 r0 *1 0,0
Xsky130_fd_sc_hd__dfstp_1_18 clknet_leaf_23_clk \_0013_[18] crc_state[18] rst_n
+ VGND VPWR VPWR sky130_fd_sc_hd__dfstp_1
* cell instance sky130_fd_sc_hd__dfstp_1_19 r0 *1 0,0
Xsky130_fd_sc_hd__dfstp_1_19 clknet_leaf_24_clk \_0013_[10] crc_state[10] rst_n
+ VGND VPWR VPWR sky130_fd_sc_hd__dfstp_1
* cell instance sky130_fd_sc_hd__dfstp_1_20 r0 *1 0,0
Xsky130_fd_sc_hd__dfstp_1_20 clknet_leaf_23_clk \_0013_[13] crc_state[13] rst_n
+ VGND VPWR VPWR sky130_fd_sc_hd__dfstp_1
* cell instance sky130_fd_sc_hd__dfstp_1_21 r0 *1 0,0
Xsky130_fd_sc_hd__dfstp_1_21 clknet_leaf_24_clk \_0013_[19] crc_state[19] rst_n
+ VGND VPWR VPWR sky130_fd_sc_hd__dfstp_1
* cell instance sky130_fd_sc_hd__dfstp_1_22 r0 *1 0,0
Xsky130_fd_sc_hd__dfstp_1_22 clknet_leaf_27_clk \_0013_[3] crc_state[3] rst_n
+ VGND VPWR VPWR sky130_fd_sc_hd__dfstp_1
* cell instance sky130_fd_sc_hd__dfstp_1_23 r0 *1 0,0
Xsky130_fd_sc_hd__dfstp_1_23 clknet_leaf_27_clk \_0013_[2] crc_state[2] rst_n
+ VGND VPWR VPWR sky130_fd_sc_hd__dfstp_1
* cell instance sky130_fd_sc_hd__dfstp_1_24 r0 *1 0,0
Xsky130_fd_sc_hd__dfstp_1_24 clknet_leaf_23_clk \_0013_[15] crc_state[15] rst_n
+ VGND VPWR VPWR sky130_fd_sc_hd__dfstp_1
* cell instance sky130_fd_sc_hd__dfstp_1_25 r0 *1 0,0
Xsky130_fd_sc_hd__dfstp_1_25 clknet_leaf_23_clk \_0013_[14] crc_state[14] rst_n
+ VGND VPWR VPWR sky130_fd_sc_hd__dfstp_1
* cell instance sky130_fd_sc_hd__dfstp_1_26 r0 *1 0,0
Xsky130_fd_sc_hd__dfstp_1_26 clknet_leaf_32_clk \_0013_[20] crc_state[20] rst_n
+ VGND VPWR VPWR sky130_fd_sc_hd__dfstp_1
* cell instance sky130_fd_sc_hd__dfstp_1_27 r0 *1 0,0
Xsky130_fd_sc_hd__dfstp_1_27 clknet_leaf_32_clk \_0013_[21] crc_state[21] rst_n
+ VGND VPWR VPWR sky130_fd_sc_hd__dfstp_1
* cell instance sky130_fd_sc_hd__dfstp_1_28 r0 *1 0,0
Xsky130_fd_sc_hd__dfstp_1_28 clknet_leaf_33_clk \_0013_[23] crc_state[23] rst_n
+ VGND VPWR VPWR sky130_fd_sc_hd__dfstp_1
* cell instance sky130_fd_sc_hd__dfstp_1_29 r0 *1 0,0
Xsky130_fd_sc_hd__dfstp_1_29 clknet_leaf_29_clk \_0013_[1] crc_state[1] rst_n
+ VGND VPWR VPWR sky130_fd_sc_hd__dfstp_1
* cell instance sky130_fd_sc_hd__dfstp_1_30 r0 *1 0,0
Xsky130_fd_sc_hd__dfstp_1_30 clknet_leaf_31_clk \_0013_[0] crc_state[0] rst_n
+ VGND VPWR VPWR sky130_fd_sc_hd__dfstp_1
* cell instance sky130_fd_sc_hd__dfstp_1_31 r0 *1 0,0
Xsky130_fd_sc_hd__dfstp_1_31 clknet_leaf_33_clk \_0013_[22] crc_state[22] rst_n
+ VGND VPWR VPWR sky130_fd_sc_hd__dfstp_1
* cell instance sky130_fd_sc_hd__diode_2_0 r0 *1 0,0
Xsky130_fd_sc_hd__diode_2_0 clk VGND VPWR VPWR sky130_fd_sc_hd__diode_2
* cell instance sky130_fd_sc_hd__fill_1_0 r0 *1 0,0
Xsky130_fd_sc_hd__fill_1_0 VGND VPWR VPWR sky130_fd_sc_hd__fill_1
* cell instance sky130_fd_sc_hd__fill_1_1 r0 *1 0,0
Xsky130_fd_sc_hd__fill_1_1 VGND VPWR VPWR sky130_fd_sc_hd__fill_1
* cell instance sky130_fd_sc_hd__fill_1_2 r0 *1 0,0
Xsky130_fd_sc_hd__fill_1_2 VGND VPWR VPWR sky130_fd_sc_hd__fill_1
* cell instance sky130_fd_sc_hd__fill_1_3 r0 *1 0,0
Xsky130_fd_sc_hd__fill_1_3 VGND VPWR VPWR sky130_fd_sc_hd__fill_1
* cell instance sky130_fd_sc_hd__fill_1_4 r0 *1 0,0
Xsky130_fd_sc_hd__fill_1_4 VGND VPWR VPWR sky130_fd_sc_hd__fill_1
* cell instance sky130_fd_sc_hd__fill_1_5 r0 *1 0,0
Xsky130_fd_sc_hd__fill_1_5 VGND VPWR VPWR sky130_fd_sc_hd__fill_1
* cell instance sky130_fd_sc_hd__fill_1_6 r0 *1 0,0
Xsky130_fd_sc_hd__fill_1_6 VGND VPWR VPWR sky130_fd_sc_hd__fill_1
* cell instance sky130_fd_sc_hd__fill_1_7 r0 *1 0,0
Xsky130_fd_sc_hd__fill_1_7 VGND VPWR VPWR sky130_fd_sc_hd__fill_1
* cell instance sky130_fd_sc_hd__fill_1_8 r0 *1 0,0
Xsky130_fd_sc_hd__fill_1_8 VGND VPWR VPWR sky130_fd_sc_hd__fill_1
* cell instance sky130_fd_sc_hd__fill_1_9 r0 *1 0,0
Xsky130_fd_sc_hd__fill_1_9 VGND VPWR VPWR sky130_fd_sc_hd__fill_1
* cell instance sky130_fd_sc_hd__fill_1_10 r0 *1 0,0
Xsky130_fd_sc_hd__fill_1_10 VGND VPWR VPWR sky130_fd_sc_hd__fill_1
* cell instance sky130_fd_sc_hd__fill_1_11 r0 *1 0,0
Xsky130_fd_sc_hd__fill_1_11 VGND VPWR VPWR sky130_fd_sc_hd__fill_1
* cell instance sky130_fd_sc_hd__fill_1_12 r0 *1 0,0
Xsky130_fd_sc_hd__fill_1_12 VGND VPWR VPWR sky130_fd_sc_hd__fill_1
* cell instance sky130_fd_sc_hd__fill_1_13 r0 *1 0,0
Xsky130_fd_sc_hd__fill_1_13 VGND VPWR VPWR sky130_fd_sc_hd__fill_1
* cell instance sky130_fd_sc_hd__fill_1_14 r0 *1 0,0
Xsky130_fd_sc_hd__fill_1_14 VGND VPWR VPWR sky130_fd_sc_hd__fill_1
* cell instance sky130_fd_sc_hd__fill_1_15 r0 *1 0,0
Xsky130_fd_sc_hd__fill_1_15 VGND VPWR VPWR sky130_fd_sc_hd__fill_1
* cell instance sky130_fd_sc_hd__fill_1_16 r0 *1 0,0
Xsky130_fd_sc_hd__fill_1_16 VGND VPWR VPWR sky130_fd_sc_hd__fill_1
* cell instance sky130_fd_sc_hd__fill_1_17 r0 *1 0,0
Xsky130_fd_sc_hd__fill_1_17 VGND VPWR VPWR sky130_fd_sc_hd__fill_1
* cell instance sky130_fd_sc_hd__fill_1_18 r0 *1 0,0
Xsky130_fd_sc_hd__fill_1_18 VGND VPWR VPWR sky130_fd_sc_hd__fill_1
* cell instance sky130_fd_sc_hd__fill_1_19 r0 *1 0,0
Xsky130_fd_sc_hd__fill_1_19 VGND VPWR VPWR sky130_fd_sc_hd__fill_1
* cell instance sky130_fd_sc_hd__fill_1_20 r0 *1 0,0
Xsky130_fd_sc_hd__fill_1_20 VGND VPWR VPWR sky130_fd_sc_hd__fill_1
* cell instance sky130_fd_sc_hd__fill_1_21 r0 *1 0,0
Xsky130_fd_sc_hd__fill_1_21 VGND VPWR VPWR sky130_fd_sc_hd__fill_1
* cell instance sky130_fd_sc_hd__fill_1_22 r0 *1 0,0
Xsky130_fd_sc_hd__fill_1_22 VGND VPWR VPWR sky130_fd_sc_hd__fill_1
* cell instance sky130_fd_sc_hd__fill_1_23 r0 *1 0,0
Xsky130_fd_sc_hd__fill_1_23 VGND VPWR VPWR sky130_fd_sc_hd__fill_1
* cell instance sky130_fd_sc_hd__fill_1_24 r0 *1 0,0
Xsky130_fd_sc_hd__fill_1_24 VGND VPWR VPWR sky130_fd_sc_hd__fill_1
* cell instance sky130_fd_sc_hd__fill_1_25 r0 *1 0,0
Xsky130_fd_sc_hd__fill_1_25 VGND VPWR VPWR sky130_fd_sc_hd__fill_1
* cell instance sky130_fd_sc_hd__fill_1_26 r0 *1 0,0
Xsky130_fd_sc_hd__fill_1_26 VGND VPWR VPWR sky130_fd_sc_hd__fill_1
* cell instance sky130_fd_sc_hd__fill_1_27 r0 *1 0,0
Xsky130_fd_sc_hd__fill_1_27 VGND VPWR VPWR sky130_fd_sc_hd__fill_1
* cell instance sky130_fd_sc_hd__fill_1_28 r0 *1 0,0
Xsky130_fd_sc_hd__fill_1_28 VGND VPWR VPWR sky130_fd_sc_hd__fill_1
* cell instance sky130_fd_sc_hd__fill_1_29 r0 *1 0,0
Xsky130_fd_sc_hd__fill_1_29 VGND VPWR VPWR sky130_fd_sc_hd__fill_1
* cell instance sky130_fd_sc_hd__fill_1_30 r0 *1 0,0
Xsky130_fd_sc_hd__fill_1_30 VGND VPWR VPWR sky130_fd_sc_hd__fill_1
* cell instance sky130_fd_sc_hd__fill_1_31 r0 *1 0,0
Xsky130_fd_sc_hd__fill_1_31 VGND VPWR VPWR sky130_fd_sc_hd__fill_1
* cell instance sky130_fd_sc_hd__fill_1_32 r0 *1 0,0
Xsky130_fd_sc_hd__fill_1_32 VGND VPWR VPWR sky130_fd_sc_hd__fill_1
* cell instance sky130_fd_sc_hd__fill_1_33 r0 *1 0,0
Xsky130_fd_sc_hd__fill_1_33 VGND VPWR VPWR sky130_fd_sc_hd__fill_1
* cell instance sky130_fd_sc_hd__fill_1_34 r0 *1 0,0
Xsky130_fd_sc_hd__fill_1_34 VGND VPWR VPWR sky130_fd_sc_hd__fill_1
* cell instance sky130_fd_sc_hd__fill_1_35 r0 *1 0,0
Xsky130_fd_sc_hd__fill_1_35 VGND VPWR VPWR sky130_fd_sc_hd__fill_1
* cell instance sky130_fd_sc_hd__fill_1_36 r0 *1 0,0
Xsky130_fd_sc_hd__fill_1_36 VGND VPWR VPWR sky130_fd_sc_hd__fill_1
* cell instance sky130_fd_sc_hd__fill_1_37 r0 *1 0,0
Xsky130_fd_sc_hd__fill_1_37 VGND VPWR VPWR sky130_fd_sc_hd__fill_1
* cell instance sky130_fd_sc_hd__fill_1_38 r0 *1 0,0
Xsky130_fd_sc_hd__fill_1_38 VGND VPWR VPWR sky130_fd_sc_hd__fill_1
* cell instance sky130_fd_sc_hd__fill_1_39 r0 *1 0,0
Xsky130_fd_sc_hd__fill_1_39 VGND VPWR VPWR sky130_fd_sc_hd__fill_1
* cell instance sky130_fd_sc_hd__fill_1_40 r0 *1 0,0
Xsky130_fd_sc_hd__fill_1_40 VGND VPWR VPWR sky130_fd_sc_hd__fill_1
* cell instance sky130_fd_sc_hd__fill_1_41 r0 *1 0,0
Xsky130_fd_sc_hd__fill_1_41 VGND VPWR VPWR sky130_fd_sc_hd__fill_1
* cell instance sky130_fd_sc_hd__fill_1_42 r0 *1 0,0
Xsky130_fd_sc_hd__fill_1_42 VGND VPWR VPWR sky130_fd_sc_hd__fill_1
* cell instance sky130_fd_sc_hd__fill_1_43 r0 *1 0,0
Xsky130_fd_sc_hd__fill_1_43 VGND VPWR VPWR sky130_fd_sc_hd__fill_1
* cell instance sky130_fd_sc_hd__fill_1_44 r0 *1 0,0
Xsky130_fd_sc_hd__fill_1_44 VGND VPWR VPWR sky130_fd_sc_hd__fill_1
* cell instance sky130_fd_sc_hd__fill_1_45 r0 *1 0,0
Xsky130_fd_sc_hd__fill_1_45 VGND VPWR VPWR sky130_fd_sc_hd__fill_1
* cell instance sky130_fd_sc_hd__fill_1_46 r0 *1 0,0
Xsky130_fd_sc_hd__fill_1_46 VGND VPWR VPWR sky130_fd_sc_hd__fill_1
* cell instance sky130_fd_sc_hd__fill_1_47 r0 *1 0,0
Xsky130_fd_sc_hd__fill_1_47 VGND VPWR VPWR sky130_fd_sc_hd__fill_1
* cell instance sky130_fd_sc_hd__fill_1_48 r0 *1 0,0
Xsky130_fd_sc_hd__fill_1_48 VGND VPWR VPWR sky130_fd_sc_hd__fill_1
* cell instance sky130_fd_sc_hd__fill_1_49 r0 *1 0,0
Xsky130_fd_sc_hd__fill_1_49 VGND VPWR VPWR sky130_fd_sc_hd__fill_1
* cell instance sky130_fd_sc_hd__fill_1_50 r0 *1 0,0
Xsky130_fd_sc_hd__fill_1_50 VGND VPWR VPWR sky130_fd_sc_hd__fill_1
* cell instance sky130_fd_sc_hd__fill_1_51 r0 *1 0,0
Xsky130_fd_sc_hd__fill_1_51 VGND VPWR VPWR sky130_fd_sc_hd__fill_1
* cell instance sky130_fd_sc_hd__fill_1_52 r0 *1 0,0
Xsky130_fd_sc_hd__fill_1_52 VGND VPWR VPWR sky130_fd_sc_hd__fill_1
* cell instance sky130_fd_sc_hd__fill_1_53 r0 *1 0,0
Xsky130_fd_sc_hd__fill_1_53 VGND VPWR VPWR sky130_fd_sc_hd__fill_1
* cell instance sky130_fd_sc_hd__fill_1_54 r0 *1 0,0
Xsky130_fd_sc_hd__fill_1_54 VGND VPWR VPWR sky130_fd_sc_hd__fill_1
* cell instance sky130_fd_sc_hd__fill_1_55 r0 *1 0,0
Xsky130_fd_sc_hd__fill_1_55 VGND VPWR VPWR sky130_fd_sc_hd__fill_1
* cell instance sky130_fd_sc_hd__fill_1_56 r0 *1 0,0
Xsky130_fd_sc_hd__fill_1_56 VGND VPWR VPWR sky130_fd_sc_hd__fill_1
* cell instance sky130_fd_sc_hd__fill_1_57 r0 *1 0,0
Xsky130_fd_sc_hd__fill_1_57 VGND VPWR VPWR sky130_fd_sc_hd__fill_1
* cell instance sky130_fd_sc_hd__fill_1_58 r0 *1 0,0
Xsky130_fd_sc_hd__fill_1_58 VGND VPWR VPWR sky130_fd_sc_hd__fill_1
* cell instance sky130_fd_sc_hd__fill_1_59 r0 *1 0,0
Xsky130_fd_sc_hd__fill_1_59 VGND VPWR VPWR sky130_fd_sc_hd__fill_1
* cell instance sky130_fd_sc_hd__fill_1_60 r0 *1 0,0
Xsky130_fd_sc_hd__fill_1_60 VGND VPWR VPWR sky130_fd_sc_hd__fill_1
* cell instance sky130_fd_sc_hd__fill_1_61 r0 *1 0,0
Xsky130_fd_sc_hd__fill_1_61 VGND VPWR VPWR sky130_fd_sc_hd__fill_1
* cell instance sky130_fd_sc_hd__fill_1_62 r0 *1 0,0
Xsky130_fd_sc_hd__fill_1_62 VGND VPWR VPWR sky130_fd_sc_hd__fill_1
* cell instance sky130_fd_sc_hd__fill_1_63 r0 *1 0,0
Xsky130_fd_sc_hd__fill_1_63 VGND VPWR VPWR sky130_fd_sc_hd__fill_1
* cell instance sky130_fd_sc_hd__fill_1_64 r0 *1 0,0
Xsky130_fd_sc_hd__fill_1_64 VGND VPWR VPWR sky130_fd_sc_hd__fill_1
* cell instance sky130_fd_sc_hd__fill_1_65 r0 *1 0,0
Xsky130_fd_sc_hd__fill_1_65 VGND VPWR VPWR sky130_fd_sc_hd__fill_1
* cell instance sky130_fd_sc_hd__fill_1_66 r0 *1 0,0
Xsky130_fd_sc_hd__fill_1_66 VGND VPWR VPWR sky130_fd_sc_hd__fill_1
* cell instance sky130_fd_sc_hd__fill_1_67 r0 *1 0,0
Xsky130_fd_sc_hd__fill_1_67 VGND VPWR VPWR sky130_fd_sc_hd__fill_1
* cell instance sky130_fd_sc_hd__fill_1_68 r0 *1 0,0
Xsky130_fd_sc_hd__fill_1_68 VGND VPWR VPWR sky130_fd_sc_hd__fill_1
* cell instance sky130_fd_sc_hd__fill_1_69 r0 *1 0,0
Xsky130_fd_sc_hd__fill_1_69 VGND VPWR VPWR sky130_fd_sc_hd__fill_1
* cell instance sky130_fd_sc_hd__fill_1_70 r0 *1 0,0
Xsky130_fd_sc_hd__fill_1_70 VGND VPWR VPWR sky130_fd_sc_hd__fill_1
* cell instance sky130_fd_sc_hd__fill_1_71 r0 *1 0,0
Xsky130_fd_sc_hd__fill_1_71 VGND VPWR VPWR sky130_fd_sc_hd__fill_1
* cell instance sky130_fd_sc_hd__fill_1_72 r0 *1 0,0
Xsky130_fd_sc_hd__fill_1_72 VGND VPWR VPWR sky130_fd_sc_hd__fill_1
* cell instance sky130_fd_sc_hd__fill_1_73 r0 *1 0,0
Xsky130_fd_sc_hd__fill_1_73 VGND VPWR VPWR sky130_fd_sc_hd__fill_1
* cell instance sky130_fd_sc_hd__fill_1_74 r0 *1 0,0
Xsky130_fd_sc_hd__fill_1_74 VGND VPWR VPWR sky130_fd_sc_hd__fill_1
* cell instance sky130_fd_sc_hd__fill_1_75 r0 *1 0,0
Xsky130_fd_sc_hd__fill_1_75 VGND VPWR VPWR sky130_fd_sc_hd__fill_1
* cell instance sky130_fd_sc_hd__fill_1_76 r0 *1 0,0
Xsky130_fd_sc_hd__fill_1_76 VGND VPWR VPWR sky130_fd_sc_hd__fill_1
* cell instance sky130_fd_sc_hd__fill_1_77 r0 *1 0,0
Xsky130_fd_sc_hd__fill_1_77 VGND VPWR VPWR sky130_fd_sc_hd__fill_1
* cell instance sky130_fd_sc_hd__fill_1_78 r0 *1 0,0
Xsky130_fd_sc_hd__fill_1_78 VGND VPWR VPWR sky130_fd_sc_hd__fill_1
* cell instance sky130_fd_sc_hd__fill_1_79 r0 *1 0,0
Xsky130_fd_sc_hd__fill_1_79 VGND VPWR VPWR sky130_fd_sc_hd__fill_1
* cell instance sky130_fd_sc_hd__fill_1_80 r0 *1 0,0
Xsky130_fd_sc_hd__fill_1_80 VGND VPWR VPWR sky130_fd_sc_hd__fill_1
* cell instance sky130_fd_sc_hd__fill_1_81 r0 *1 0,0
Xsky130_fd_sc_hd__fill_1_81 VGND VPWR VPWR sky130_fd_sc_hd__fill_1
* cell instance sky130_fd_sc_hd__fill_1_82 r0 *1 0,0
Xsky130_fd_sc_hd__fill_1_82 VGND VPWR VPWR sky130_fd_sc_hd__fill_1
* cell instance sky130_fd_sc_hd__fill_1_83 r0 *1 0,0
Xsky130_fd_sc_hd__fill_1_83 VGND VPWR VPWR sky130_fd_sc_hd__fill_1
* cell instance sky130_fd_sc_hd__fill_1_84 r0 *1 0,0
Xsky130_fd_sc_hd__fill_1_84 VGND VPWR VPWR sky130_fd_sc_hd__fill_1
* cell instance sky130_fd_sc_hd__fill_1_85 r0 *1 0,0
Xsky130_fd_sc_hd__fill_1_85 VGND VPWR VPWR sky130_fd_sc_hd__fill_1
* cell instance sky130_fd_sc_hd__fill_1_86 r0 *1 0,0
Xsky130_fd_sc_hd__fill_1_86 VGND VPWR VPWR sky130_fd_sc_hd__fill_1
* cell instance sky130_fd_sc_hd__fill_1_87 r0 *1 0,0
Xsky130_fd_sc_hd__fill_1_87 VGND VPWR VPWR sky130_fd_sc_hd__fill_1
* cell instance sky130_fd_sc_hd__fill_1_88 r0 *1 0,0
Xsky130_fd_sc_hd__fill_1_88 VGND VPWR VPWR sky130_fd_sc_hd__fill_1
* cell instance sky130_fd_sc_hd__fill_1_89 r0 *1 0,0
Xsky130_fd_sc_hd__fill_1_89 VGND VPWR VPWR sky130_fd_sc_hd__fill_1
* cell instance sky130_fd_sc_hd__fill_1_90 r0 *1 0,0
Xsky130_fd_sc_hd__fill_1_90 VGND VPWR VPWR sky130_fd_sc_hd__fill_1
* cell instance sky130_fd_sc_hd__fill_1_91 r0 *1 0,0
Xsky130_fd_sc_hd__fill_1_91 VGND VPWR VPWR sky130_fd_sc_hd__fill_1
* cell instance sky130_fd_sc_hd__fill_1_92 r0 *1 0,0
Xsky130_fd_sc_hd__fill_1_92 VGND VPWR VPWR sky130_fd_sc_hd__fill_1
* cell instance sky130_fd_sc_hd__fill_1_93 r0 *1 0,0
Xsky130_fd_sc_hd__fill_1_93 VGND VPWR VPWR sky130_fd_sc_hd__fill_1
* cell instance sky130_fd_sc_hd__fill_1_94 r0 *1 0,0
Xsky130_fd_sc_hd__fill_1_94 VGND VPWR VPWR sky130_fd_sc_hd__fill_1
* cell instance sky130_fd_sc_hd__fill_1_95 r0 *1 0,0
Xsky130_fd_sc_hd__fill_1_95 VGND VPWR VPWR sky130_fd_sc_hd__fill_1
* cell instance sky130_fd_sc_hd__fill_1_96 r0 *1 0,0
Xsky130_fd_sc_hd__fill_1_96 VGND VPWR VPWR sky130_fd_sc_hd__fill_1
* cell instance sky130_fd_sc_hd__fill_1_97 r0 *1 0,0
Xsky130_fd_sc_hd__fill_1_97 VGND VPWR VPWR sky130_fd_sc_hd__fill_1
* cell instance sky130_fd_sc_hd__fill_1_98 r0 *1 0,0
Xsky130_fd_sc_hd__fill_1_98 VGND VPWR VPWR sky130_fd_sc_hd__fill_1
* cell instance sky130_fd_sc_hd__fill_1_99 r0 *1 0,0
Xsky130_fd_sc_hd__fill_1_99 VGND VPWR VPWR sky130_fd_sc_hd__fill_1
* cell instance sky130_fd_sc_hd__fill_1_100 r0 *1 0,0
Xsky130_fd_sc_hd__fill_1_100 VGND VPWR VPWR sky130_fd_sc_hd__fill_1
* cell instance sky130_fd_sc_hd__fill_1_101 r0 *1 0,0
Xsky130_fd_sc_hd__fill_1_101 VGND VPWR VPWR sky130_fd_sc_hd__fill_1
* cell instance sky130_fd_sc_hd__fill_1_102 r0 *1 0,0
Xsky130_fd_sc_hd__fill_1_102 VGND VPWR VPWR sky130_fd_sc_hd__fill_1
* cell instance sky130_fd_sc_hd__fill_1_103 r0 *1 0,0
Xsky130_fd_sc_hd__fill_1_103 VGND VPWR VPWR sky130_fd_sc_hd__fill_1
* cell instance sky130_fd_sc_hd__fill_1_104 r0 *1 0,0
Xsky130_fd_sc_hd__fill_1_104 VGND VPWR VPWR sky130_fd_sc_hd__fill_1
* cell instance sky130_fd_sc_hd__fill_1_105 r0 *1 0,0
Xsky130_fd_sc_hd__fill_1_105 VGND VPWR VPWR sky130_fd_sc_hd__fill_1
* cell instance sky130_fd_sc_hd__fill_1_106 r0 *1 0,0
Xsky130_fd_sc_hd__fill_1_106 VGND VPWR VPWR sky130_fd_sc_hd__fill_1
* cell instance sky130_fd_sc_hd__fill_1_107 r0 *1 0,0
Xsky130_fd_sc_hd__fill_1_107 VGND VPWR VPWR sky130_fd_sc_hd__fill_1
* cell instance sky130_fd_sc_hd__fill_1_108 r0 *1 0,0
Xsky130_fd_sc_hd__fill_1_108 VGND VPWR VPWR sky130_fd_sc_hd__fill_1
* cell instance sky130_fd_sc_hd__fill_1_109 r0 *1 0,0
Xsky130_fd_sc_hd__fill_1_109 VGND VPWR VPWR sky130_fd_sc_hd__fill_1
* cell instance sky130_fd_sc_hd__fill_1_110 r0 *1 0,0
Xsky130_fd_sc_hd__fill_1_110 VGND VPWR VPWR sky130_fd_sc_hd__fill_1
* cell instance sky130_fd_sc_hd__fill_1_111 r0 *1 0,0
Xsky130_fd_sc_hd__fill_1_111 VGND VPWR VPWR sky130_fd_sc_hd__fill_1
* cell instance sky130_fd_sc_hd__fill_1_112 r0 *1 0,0
Xsky130_fd_sc_hd__fill_1_112 VGND VPWR VPWR sky130_fd_sc_hd__fill_1
* cell instance sky130_fd_sc_hd__fill_1_113 r0 *1 0,0
Xsky130_fd_sc_hd__fill_1_113 VGND VPWR VPWR sky130_fd_sc_hd__fill_1
* cell instance sky130_fd_sc_hd__fill_1_114 r0 *1 0,0
Xsky130_fd_sc_hd__fill_1_114 VGND VPWR VPWR sky130_fd_sc_hd__fill_1
* cell instance sky130_fd_sc_hd__fill_1_115 r0 *1 0,0
Xsky130_fd_sc_hd__fill_1_115 VGND VPWR VPWR sky130_fd_sc_hd__fill_1
* cell instance sky130_fd_sc_hd__fill_1_116 r0 *1 0,0
Xsky130_fd_sc_hd__fill_1_116 VGND VPWR VPWR sky130_fd_sc_hd__fill_1
* cell instance sky130_fd_sc_hd__fill_1_117 r0 *1 0,0
Xsky130_fd_sc_hd__fill_1_117 VGND VPWR VPWR sky130_fd_sc_hd__fill_1
* cell instance sky130_fd_sc_hd__fill_1_118 r0 *1 0,0
Xsky130_fd_sc_hd__fill_1_118 VGND VPWR VPWR sky130_fd_sc_hd__fill_1
* cell instance sky130_fd_sc_hd__fill_1_119 r0 *1 0,0
Xsky130_fd_sc_hd__fill_1_119 VGND VPWR VPWR sky130_fd_sc_hd__fill_1
* cell instance sky130_fd_sc_hd__fill_1_120 r0 *1 0,0
Xsky130_fd_sc_hd__fill_1_120 VGND VPWR VPWR sky130_fd_sc_hd__fill_1
* cell instance sky130_fd_sc_hd__fill_1_121 r0 *1 0,0
Xsky130_fd_sc_hd__fill_1_121 VGND VPWR VPWR sky130_fd_sc_hd__fill_1
* cell instance sky130_fd_sc_hd__fill_1_122 r0 *1 0,0
Xsky130_fd_sc_hd__fill_1_122 VGND VPWR VPWR sky130_fd_sc_hd__fill_1
* cell instance sky130_fd_sc_hd__fill_1_123 r0 *1 0,0
Xsky130_fd_sc_hd__fill_1_123 VGND VPWR VPWR sky130_fd_sc_hd__fill_1
* cell instance sky130_fd_sc_hd__fill_1_124 r0 *1 0,0
Xsky130_fd_sc_hd__fill_1_124 VGND VPWR VPWR sky130_fd_sc_hd__fill_1
* cell instance sky130_fd_sc_hd__fill_1_125 r0 *1 0,0
Xsky130_fd_sc_hd__fill_1_125 VGND VPWR VPWR sky130_fd_sc_hd__fill_1
* cell instance sky130_fd_sc_hd__fill_1_126 r0 *1 0,0
Xsky130_fd_sc_hd__fill_1_126 VGND VPWR VPWR sky130_fd_sc_hd__fill_1
* cell instance sky130_fd_sc_hd__fill_1_127 r0 *1 0,0
Xsky130_fd_sc_hd__fill_1_127 VGND VPWR VPWR sky130_fd_sc_hd__fill_1
* cell instance sky130_fd_sc_hd__fill_1_128 r0 *1 0,0
Xsky130_fd_sc_hd__fill_1_128 VGND VPWR VPWR sky130_fd_sc_hd__fill_1
* cell instance sky130_fd_sc_hd__fill_1_129 r0 *1 0,0
Xsky130_fd_sc_hd__fill_1_129 VGND VPWR VPWR sky130_fd_sc_hd__fill_1
* cell instance sky130_fd_sc_hd__fill_1_130 r0 *1 0,0
Xsky130_fd_sc_hd__fill_1_130 VGND VPWR VPWR sky130_fd_sc_hd__fill_1
* cell instance sky130_fd_sc_hd__fill_1_131 r0 *1 0,0
Xsky130_fd_sc_hd__fill_1_131 VGND VPWR VPWR sky130_fd_sc_hd__fill_1
* cell instance sky130_fd_sc_hd__fill_1_132 r0 *1 0,0
Xsky130_fd_sc_hd__fill_1_132 VGND VPWR VPWR sky130_fd_sc_hd__fill_1
* cell instance sky130_fd_sc_hd__fill_1_133 r0 *1 0,0
Xsky130_fd_sc_hd__fill_1_133 VGND VPWR VPWR sky130_fd_sc_hd__fill_1
* cell instance sky130_fd_sc_hd__fill_1_134 r0 *1 0,0
Xsky130_fd_sc_hd__fill_1_134 VGND VPWR VPWR sky130_fd_sc_hd__fill_1
* cell instance sky130_fd_sc_hd__fill_1_135 r0 *1 0,0
Xsky130_fd_sc_hd__fill_1_135 VGND VPWR VPWR sky130_fd_sc_hd__fill_1
* cell instance sky130_fd_sc_hd__fill_1_136 r0 *1 0,0
Xsky130_fd_sc_hd__fill_1_136 VGND VPWR VPWR sky130_fd_sc_hd__fill_1
* cell instance sky130_fd_sc_hd__fill_1_137 r0 *1 0,0
Xsky130_fd_sc_hd__fill_1_137 VGND VPWR VPWR sky130_fd_sc_hd__fill_1
* cell instance sky130_fd_sc_hd__fill_1_138 r0 *1 0,0
Xsky130_fd_sc_hd__fill_1_138 VGND VPWR VPWR sky130_fd_sc_hd__fill_1
* cell instance sky130_fd_sc_hd__fill_1_139 r0 *1 0,0
Xsky130_fd_sc_hd__fill_1_139 VGND VPWR VPWR sky130_fd_sc_hd__fill_1
* cell instance sky130_fd_sc_hd__fill_1_140 r0 *1 0,0
Xsky130_fd_sc_hd__fill_1_140 VGND VPWR VPWR sky130_fd_sc_hd__fill_1
* cell instance sky130_fd_sc_hd__fill_1_141 r0 *1 0,0
Xsky130_fd_sc_hd__fill_1_141 VGND VPWR VPWR sky130_fd_sc_hd__fill_1
* cell instance sky130_fd_sc_hd__fill_1_142 r0 *1 0,0
Xsky130_fd_sc_hd__fill_1_142 VGND VPWR VPWR sky130_fd_sc_hd__fill_1
* cell instance sky130_fd_sc_hd__fill_1_143 r0 *1 0,0
Xsky130_fd_sc_hd__fill_1_143 VGND VPWR VPWR sky130_fd_sc_hd__fill_1
* cell instance sky130_fd_sc_hd__fill_1_144 r0 *1 0,0
Xsky130_fd_sc_hd__fill_1_144 VGND VPWR VPWR sky130_fd_sc_hd__fill_1
* cell instance sky130_fd_sc_hd__fill_1_145 r0 *1 0,0
Xsky130_fd_sc_hd__fill_1_145 VGND VPWR VPWR sky130_fd_sc_hd__fill_1
* cell instance sky130_fd_sc_hd__fill_1_146 r0 *1 0,0
Xsky130_fd_sc_hd__fill_1_146 VGND VPWR VPWR sky130_fd_sc_hd__fill_1
* cell instance sky130_fd_sc_hd__fill_1_147 r0 *1 0,0
Xsky130_fd_sc_hd__fill_1_147 VGND VPWR VPWR sky130_fd_sc_hd__fill_1
* cell instance sky130_fd_sc_hd__fill_1_148 r0 *1 0,0
Xsky130_fd_sc_hd__fill_1_148 VGND VPWR VPWR sky130_fd_sc_hd__fill_1
* cell instance sky130_fd_sc_hd__fill_1_149 r0 *1 0,0
Xsky130_fd_sc_hd__fill_1_149 VGND VPWR VPWR sky130_fd_sc_hd__fill_1
* cell instance sky130_fd_sc_hd__fill_1_150 r0 *1 0,0
Xsky130_fd_sc_hd__fill_1_150 VGND VPWR VPWR sky130_fd_sc_hd__fill_1
* cell instance sky130_fd_sc_hd__fill_1_151 r0 *1 0,0
Xsky130_fd_sc_hd__fill_1_151 VGND VPWR VPWR sky130_fd_sc_hd__fill_1
* cell instance sky130_fd_sc_hd__fill_1_152 r0 *1 0,0
Xsky130_fd_sc_hd__fill_1_152 VGND VPWR VPWR sky130_fd_sc_hd__fill_1
* cell instance sky130_fd_sc_hd__fill_1_153 r0 *1 0,0
Xsky130_fd_sc_hd__fill_1_153 VGND VPWR VPWR sky130_fd_sc_hd__fill_1
* cell instance sky130_fd_sc_hd__fill_1_154 r0 *1 0,0
Xsky130_fd_sc_hd__fill_1_154 VGND VPWR VPWR sky130_fd_sc_hd__fill_1
* cell instance sky130_fd_sc_hd__fill_1_155 r0 *1 0,0
Xsky130_fd_sc_hd__fill_1_155 VGND VPWR VPWR sky130_fd_sc_hd__fill_1
* cell instance sky130_fd_sc_hd__fill_1_156 r0 *1 0,0
Xsky130_fd_sc_hd__fill_1_156 VGND VPWR VPWR sky130_fd_sc_hd__fill_1
* cell instance sky130_fd_sc_hd__fill_1_157 r0 *1 0,0
Xsky130_fd_sc_hd__fill_1_157 VGND VPWR VPWR sky130_fd_sc_hd__fill_1
* cell instance sky130_fd_sc_hd__fill_1_158 r0 *1 0,0
Xsky130_fd_sc_hd__fill_1_158 VGND VPWR VPWR sky130_fd_sc_hd__fill_1
* cell instance sky130_fd_sc_hd__fill_1_159 r0 *1 0,0
Xsky130_fd_sc_hd__fill_1_159 VGND VPWR VPWR sky130_fd_sc_hd__fill_1
* cell instance sky130_fd_sc_hd__fill_1_160 r0 *1 0,0
Xsky130_fd_sc_hd__fill_1_160 VGND VPWR VPWR sky130_fd_sc_hd__fill_1
* cell instance sky130_fd_sc_hd__fill_1_161 r0 *1 0,0
Xsky130_fd_sc_hd__fill_1_161 VGND VPWR VPWR sky130_fd_sc_hd__fill_1
* cell instance sky130_fd_sc_hd__fill_1_162 r0 *1 0,0
Xsky130_fd_sc_hd__fill_1_162 VGND VPWR VPWR sky130_fd_sc_hd__fill_1
* cell instance sky130_fd_sc_hd__fill_1_163 r0 *1 0,0
Xsky130_fd_sc_hd__fill_1_163 VGND VPWR VPWR sky130_fd_sc_hd__fill_1
* cell instance sky130_fd_sc_hd__fill_1_164 r0 *1 0,0
Xsky130_fd_sc_hd__fill_1_164 VGND VPWR VPWR sky130_fd_sc_hd__fill_1
* cell instance sky130_fd_sc_hd__fill_1_165 r0 *1 0,0
Xsky130_fd_sc_hd__fill_1_165 VGND VPWR VPWR sky130_fd_sc_hd__fill_1
* cell instance sky130_fd_sc_hd__fill_1_166 r0 *1 0,0
Xsky130_fd_sc_hd__fill_1_166 VGND VPWR VPWR sky130_fd_sc_hd__fill_1
* cell instance sky130_fd_sc_hd__fill_1_167 r0 *1 0,0
Xsky130_fd_sc_hd__fill_1_167 VGND VPWR VPWR sky130_fd_sc_hd__fill_1
* cell instance sky130_fd_sc_hd__fill_1_168 r0 *1 0,0
Xsky130_fd_sc_hd__fill_1_168 VGND VPWR VPWR sky130_fd_sc_hd__fill_1
* cell instance sky130_fd_sc_hd__fill_1_169 r0 *1 0,0
Xsky130_fd_sc_hd__fill_1_169 VGND VPWR VPWR sky130_fd_sc_hd__fill_1
* cell instance sky130_fd_sc_hd__fill_1_170 r0 *1 0,0
Xsky130_fd_sc_hd__fill_1_170 VGND VPWR VPWR sky130_fd_sc_hd__fill_1
* cell instance sky130_fd_sc_hd__fill_1_171 r0 *1 0,0
Xsky130_fd_sc_hd__fill_1_171 VGND VPWR VPWR sky130_fd_sc_hd__fill_1
* cell instance sky130_fd_sc_hd__fill_1_172 r0 *1 0,0
Xsky130_fd_sc_hd__fill_1_172 VGND VPWR VPWR sky130_fd_sc_hd__fill_1
* cell instance sky130_fd_sc_hd__fill_1_173 r0 *1 0,0
Xsky130_fd_sc_hd__fill_1_173 VGND VPWR VPWR sky130_fd_sc_hd__fill_1
* cell instance sky130_fd_sc_hd__fill_1_174 r0 *1 0,0
Xsky130_fd_sc_hd__fill_1_174 VGND VPWR VPWR sky130_fd_sc_hd__fill_1
* cell instance sky130_fd_sc_hd__fill_1_175 r0 *1 0,0
Xsky130_fd_sc_hd__fill_1_175 VGND VPWR VPWR sky130_fd_sc_hd__fill_1
* cell instance sky130_fd_sc_hd__fill_1_176 r0 *1 0,0
Xsky130_fd_sc_hd__fill_1_176 VGND VPWR VPWR sky130_fd_sc_hd__fill_1
* cell instance sky130_fd_sc_hd__fill_1_177 r0 *1 0,0
Xsky130_fd_sc_hd__fill_1_177 VGND VPWR VPWR sky130_fd_sc_hd__fill_1
* cell instance sky130_fd_sc_hd__fill_1_178 r0 *1 0,0
Xsky130_fd_sc_hd__fill_1_178 VGND VPWR VPWR sky130_fd_sc_hd__fill_1
* cell instance sky130_fd_sc_hd__fill_1_179 r0 *1 0,0
Xsky130_fd_sc_hd__fill_1_179 VGND VPWR VPWR sky130_fd_sc_hd__fill_1
* cell instance sky130_fd_sc_hd__fill_1_180 r0 *1 0,0
Xsky130_fd_sc_hd__fill_1_180 VGND VPWR VPWR sky130_fd_sc_hd__fill_1
* cell instance sky130_fd_sc_hd__fill_1_181 r0 *1 0,0
Xsky130_fd_sc_hd__fill_1_181 VGND VPWR VPWR sky130_fd_sc_hd__fill_1
* cell instance sky130_fd_sc_hd__fill_1_182 r0 *1 0,0
Xsky130_fd_sc_hd__fill_1_182 VGND VPWR VPWR sky130_fd_sc_hd__fill_1
* cell instance sky130_fd_sc_hd__fill_1_183 r0 *1 0,0
Xsky130_fd_sc_hd__fill_1_183 VGND VPWR VPWR sky130_fd_sc_hd__fill_1
* cell instance sky130_fd_sc_hd__fill_1_184 r0 *1 0,0
Xsky130_fd_sc_hd__fill_1_184 VGND VPWR VPWR sky130_fd_sc_hd__fill_1
* cell instance sky130_fd_sc_hd__fill_1_185 r0 *1 0,0
Xsky130_fd_sc_hd__fill_1_185 VGND VPWR VPWR sky130_fd_sc_hd__fill_1
* cell instance sky130_fd_sc_hd__fill_1_186 r0 *1 0,0
Xsky130_fd_sc_hd__fill_1_186 VGND VPWR VPWR sky130_fd_sc_hd__fill_1
* cell instance sky130_fd_sc_hd__fill_1_187 r0 *1 0,0
Xsky130_fd_sc_hd__fill_1_187 VGND VPWR VPWR sky130_fd_sc_hd__fill_1
* cell instance sky130_fd_sc_hd__fill_1_188 r0 *1 0,0
Xsky130_fd_sc_hd__fill_1_188 VGND VPWR VPWR sky130_fd_sc_hd__fill_1
* cell instance sky130_fd_sc_hd__fill_1_189 r0 *1 0,0
Xsky130_fd_sc_hd__fill_1_189 VGND VPWR VPWR sky130_fd_sc_hd__fill_1
* cell instance sky130_fd_sc_hd__fill_1_190 r0 *1 0,0
Xsky130_fd_sc_hd__fill_1_190 VGND VPWR VPWR sky130_fd_sc_hd__fill_1
* cell instance sky130_fd_sc_hd__fill_1_191 r0 *1 0,0
Xsky130_fd_sc_hd__fill_1_191 VGND VPWR VPWR sky130_fd_sc_hd__fill_1
* cell instance sky130_fd_sc_hd__fill_1_192 r0 *1 0,0
Xsky130_fd_sc_hd__fill_1_192 VGND VPWR VPWR sky130_fd_sc_hd__fill_1
* cell instance sky130_fd_sc_hd__fill_1_193 r0 *1 0,0
Xsky130_fd_sc_hd__fill_1_193 VGND VPWR VPWR sky130_fd_sc_hd__fill_1
* cell instance sky130_fd_sc_hd__fill_1_194 r0 *1 0,0
Xsky130_fd_sc_hd__fill_1_194 VGND VPWR VPWR sky130_fd_sc_hd__fill_1
* cell instance sky130_fd_sc_hd__fill_1_195 r0 *1 0,0
Xsky130_fd_sc_hd__fill_1_195 VGND VPWR VPWR sky130_fd_sc_hd__fill_1
* cell instance sky130_fd_sc_hd__fill_1_196 r0 *1 0,0
Xsky130_fd_sc_hd__fill_1_196 VGND VPWR VPWR sky130_fd_sc_hd__fill_1
* cell instance sky130_fd_sc_hd__fill_1_197 r0 *1 0,0
Xsky130_fd_sc_hd__fill_1_197 VGND VPWR VPWR sky130_fd_sc_hd__fill_1
* cell instance sky130_fd_sc_hd__fill_1_198 r0 *1 0,0
Xsky130_fd_sc_hd__fill_1_198 VGND VPWR VPWR sky130_fd_sc_hd__fill_1
* cell instance sky130_fd_sc_hd__fill_1_199 r0 *1 0,0
Xsky130_fd_sc_hd__fill_1_199 VGND VPWR VPWR sky130_fd_sc_hd__fill_1
* cell instance sky130_fd_sc_hd__fill_1_200 r0 *1 0,0
Xsky130_fd_sc_hd__fill_1_200 VGND VPWR VPWR sky130_fd_sc_hd__fill_1
* cell instance sky130_fd_sc_hd__fill_1_201 r0 *1 0,0
Xsky130_fd_sc_hd__fill_1_201 VGND VPWR VPWR sky130_fd_sc_hd__fill_1
* cell instance sky130_fd_sc_hd__fill_1_202 r0 *1 0,0
Xsky130_fd_sc_hd__fill_1_202 VGND VPWR VPWR sky130_fd_sc_hd__fill_1
* cell instance sky130_fd_sc_hd__fill_1_203 r0 *1 0,0
Xsky130_fd_sc_hd__fill_1_203 VGND VPWR VPWR sky130_fd_sc_hd__fill_1
* cell instance sky130_fd_sc_hd__fill_1_204 r0 *1 0,0
Xsky130_fd_sc_hd__fill_1_204 VGND VPWR VPWR sky130_fd_sc_hd__fill_1
* cell instance sky130_fd_sc_hd__fill_1_205 r0 *1 0,0
Xsky130_fd_sc_hd__fill_1_205 VGND VPWR VPWR sky130_fd_sc_hd__fill_1
* cell instance sky130_fd_sc_hd__fill_1_206 r0 *1 0,0
Xsky130_fd_sc_hd__fill_1_206 VGND VPWR VPWR sky130_fd_sc_hd__fill_1
* cell instance sky130_fd_sc_hd__fill_1_207 r0 *1 0,0
Xsky130_fd_sc_hd__fill_1_207 VGND VPWR VPWR sky130_fd_sc_hd__fill_1
* cell instance sky130_fd_sc_hd__fill_1_208 r0 *1 0,0
Xsky130_fd_sc_hd__fill_1_208 VGND VPWR VPWR sky130_fd_sc_hd__fill_1
* cell instance sky130_fd_sc_hd__fill_1_209 r0 *1 0,0
Xsky130_fd_sc_hd__fill_1_209 VGND VPWR VPWR sky130_fd_sc_hd__fill_1
* cell instance sky130_fd_sc_hd__fill_1_210 r0 *1 0,0
Xsky130_fd_sc_hd__fill_1_210 VGND VPWR VPWR sky130_fd_sc_hd__fill_1
* cell instance sky130_fd_sc_hd__fill_1_211 r0 *1 0,0
Xsky130_fd_sc_hd__fill_1_211 VGND VPWR VPWR sky130_fd_sc_hd__fill_1
* cell instance sky130_fd_sc_hd__fill_1_212 r0 *1 0,0
Xsky130_fd_sc_hd__fill_1_212 VGND VPWR VPWR sky130_fd_sc_hd__fill_1
* cell instance sky130_fd_sc_hd__fill_1_213 r0 *1 0,0
Xsky130_fd_sc_hd__fill_1_213 VGND VPWR VPWR sky130_fd_sc_hd__fill_1
* cell instance sky130_fd_sc_hd__fill_1_214 r0 *1 0,0
Xsky130_fd_sc_hd__fill_1_214 VGND VPWR VPWR sky130_fd_sc_hd__fill_1
* cell instance sky130_fd_sc_hd__fill_1_215 r0 *1 0,0
Xsky130_fd_sc_hd__fill_1_215 VGND VPWR VPWR sky130_fd_sc_hd__fill_1
* cell instance sky130_fd_sc_hd__fill_1_216 r0 *1 0,0
Xsky130_fd_sc_hd__fill_1_216 VGND VPWR VPWR sky130_fd_sc_hd__fill_1
* cell instance sky130_fd_sc_hd__fill_1_217 r0 *1 0,0
Xsky130_fd_sc_hd__fill_1_217 VGND VPWR VPWR sky130_fd_sc_hd__fill_1
* cell instance sky130_fd_sc_hd__fill_1_218 r0 *1 0,0
Xsky130_fd_sc_hd__fill_1_218 VGND VPWR VPWR sky130_fd_sc_hd__fill_1
* cell instance sky130_fd_sc_hd__fill_1_219 r0 *1 0,0
Xsky130_fd_sc_hd__fill_1_219 VGND VPWR VPWR sky130_fd_sc_hd__fill_1
* cell instance sky130_fd_sc_hd__fill_1_220 r0 *1 0,0
Xsky130_fd_sc_hd__fill_1_220 VGND VPWR VPWR sky130_fd_sc_hd__fill_1
* cell instance sky130_fd_sc_hd__fill_1_221 r0 *1 0,0
Xsky130_fd_sc_hd__fill_1_221 VGND VPWR VPWR sky130_fd_sc_hd__fill_1
* cell instance sky130_fd_sc_hd__fill_1_222 r0 *1 0,0
Xsky130_fd_sc_hd__fill_1_222 VGND VPWR VPWR sky130_fd_sc_hd__fill_1
* cell instance sky130_fd_sc_hd__fill_1_223 r0 *1 0,0
Xsky130_fd_sc_hd__fill_1_223 VGND VPWR VPWR sky130_fd_sc_hd__fill_1
* cell instance sky130_fd_sc_hd__fill_1_224 r0 *1 0,0
Xsky130_fd_sc_hd__fill_1_224 VGND VPWR VPWR sky130_fd_sc_hd__fill_1
* cell instance sky130_fd_sc_hd__fill_1_225 r0 *1 0,0
Xsky130_fd_sc_hd__fill_1_225 VGND VPWR VPWR sky130_fd_sc_hd__fill_1
* cell instance sky130_fd_sc_hd__fill_1_226 r0 *1 0,0
Xsky130_fd_sc_hd__fill_1_226 VGND VPWR VPWR sky130_fd_sc_hd__fill_1
* cell instance sky130_fd_sc_hd__fill_1_227 r0 *1 0,0
Xsky130_fd_sc_hd__fill_1_227 VGND VPWR VPWR sky130_fd_sc_hd__fill_1
* cell instance sky130_fd_sc_hd__fill_1_228 r0 *1 0,0
Xsky130_fd_sc_hd__fill_1_228 VGND VPWR VPWR sky130_fd_sc_hd__fill_1
* cell instance sky130_fd_sc_hd__fill_1_229 r0 *1 0,0
Xsky130_fd_sc_hd__fill_1_229 VGND VPWR VPWR sky130_fd_sc_hd__fill_1
* cell instance sky130_fd_sc_hd__fill_1_230 r0 *1 0,0
Xsky130_fd_sc_hd__fill_1_230 VGND VPWR VPWR sky130_fd_sc_hd__fill_1
* cell instance sky130_fd_sc_hd__fill_1_231 r0 *1 0,0
Xsky130_fd_sc_hd__fill_1_231 VGND VPWR VPWR sky130_fd_sc_hd__fill_1
* cell instance sky130_fd_sc_hd__fill_1_232 r0 *1 0,0
Xsky130_fd_sc_hd__fill_1_232 VGND VPWR VPWR sky130_fd_sc_hd__fill_1
* cell instance sky130_fd_sc_hd__fill_1_233 r0 *1 0,0
Xsky130_fd_sc_hd__fill_1_233 VGND VPWR VPWR sky130_fd_sc_hd__fill_1
* cell instance sky130_fd_sc_hd__fill_1_234 r0 *1 0,0
Xsky130_fd_sc_hd__fill_1_234 VGND VPWR VPWR sky130_fd_sc_hd__fill_1
* cell instance sky130_fd_sc_hd__fill_1_235 r0 *1 0,0
Xsky130_fd_sc_hd__fill_1_235 VGND VPWR VPWR sky130_fd_sc_hd__fill_1
* cell instance sky130_fd_sc_hd__fill_1_236 r0 *1 0,0
Xsky130_fd_sc_hd__fill_1_236 VGND VPWR VPWR sky130_fd_sc_hd__fill_1
* cell instance sky130_fd_sc_hd__fill_1_237 r0 *1 0,0
Xsky130_fd_sc_hd__fill_1_237 VGND VPWR VPWR sky130_fd_sc_hd__fill_1
* cell instance sky130_fd_sc_hd__fill_1_238 r0 *1 0,0
Xsky130_fd_sc_hd__fill_1_238 VGND VPWR VPWR sky130_fd_sc_hd__fill_1
* cell instance sky130_fd_sc_hd__fill_1_239 r0 *1 0,0
Xsky130_fd_sc_hd__fill_1_239 VGND VPWR VPWR sky130_fd_sc_hd__fill_1
* cell instance sky130_fd_sc_hd__fill_1_240 r0 *1 0,0
Xsky130_fd_sc_hd__fill_1_240 VGND VPWR VPWR sky130_fd_sc_hd__fill_1
* cell instance sky130_fd_sc_hd__fill_1_241 r0 *1 0,0
Xsky130_fd_sc_hd__fill_1_241 VGND VPWR VPWR sky130_fd_sc_hd__fill_1
* cell instance sky130_fd_sc_hd__fill_1_242 r0 *1 0,0
Xsky130_fd_sc_hd__fill_1_242 VGND VPWR VPWR sky130_fd_sc_hd__fill_1
* cell instance sky130_fd_sc_hd__fill_1_243 r0 *1 0,0
Xsky130_fd_sc_hd__fill_1_243 VGND VPWR VPWR sky130_fd_sc_hd__fill_1
* cell instance sky130_fd_sc_hd__fill_1_244 r0 *1 0,0
Xsky130_fd_sc_hd__fill_1_244 VGND VPWR VPWR sky130_fd_sc_hd__fill_1
* cell instance sky130_fd_sc_hd__fill_1_245 r0 *1 0,0
Xsky130_fd_sc_hd__fill_1_245 VGND VPWR VPWR sky130_fd_sc_hd__fill_1
* cell instance sky130_fd_sc_hd__fill_1_246 r0 *1 0,0
Xsky130_fd_sc_hd__fill_1_246 VGND VPWR VPWR sky130_fd_sc_hd__fill_1
* cell instance sky130_fd_sc_hd__fill_1_247 r0 *1 0,0
Xsky130_fd_sc_hd__fill_1_247 VGND VPWR VPWR sky130_fd_sc_hd__fill_1
* cell instance sky130_fd_sc_hd__fill_1_248 r0 *1 0,0
Xsky130_fd_sc_hd__fill_1_248 VGND VPWR VPWR sky130_fd_sc_hd__fill_1
* cell instance sky130_fd_sc_hd__fill_1_249 r0 *1 0,0
Xsky130_fd_sc_hd__fill_1_249 VGND VPWR VPWR sky130_fd_sc_hd__fill_1
* cell instance sky130_fd_sc_hd__fill_1_250 r0 *1 0,0
Xsky130_fd_sc_hd__fill_1_250 VGND VPWR VPWR sky130_fd_sc_hd__fill_1
* cell instance sky130_fd_sc_hd__fill_1_251 r0 *1 0,0
Xsky130_fd_sc_hd__fill_1_251 VGND VPWR VPWR sky130_fd_sc_hd__fill_1
* cell instance sky130_fd_sc_hd__fill_1_252 r0 *1 0,0
Xsky130_fd_sc_hd__fill_1_252 VGND VPWR VPWR sky130_fd_sc_hd__fill_1
* cell instance sky130_fd_sc_hd__fill_1_253 r0 *1 0,0
Xsky130_fd_sc_hd__fill_1_253 VGND VPWR VPWR sky130_fd_sc_hd__fill_1
* cell instance sky130_fd_sc_hd__fill_1_254 r0 *1 0,0
Xsky130_fd_sc_hd__fill_1_254 VGND VPWR VPWR sky130_fd_sc_hd__fill_1
* cell instance sky130_fd_sc_hd__fill_1_255 r0 *1 0,0
Xsky130_fd_sc_hd__fill_1_255 VGND VPWR VPWR sky130_fd_sc_hd__fill_1
* cell instance sky130_fd_sc_hd__fill_1_256 r0 *1 0,0
Xsky130_fd_sc_hd__fill_1_256 VGND VPWR VPWR sky130_fd_sc_hd__fill_1
* cell instance sky130_fd_sc_hd__fill_1_257 r0 *1 0,0
Xsky130_fd_sc_hd__fill_1_257 VGND VPWR VPWR sky130_fd_sc_hd__fill_1
* cell instance sky130_fd_sc_hd__fill_1_258 r0 *1 0,0
Xsky130_fd_sc_hd__fill_1_258 VGND VPWR VPWR sky130_fd_sc_hd__fill_1
* cell instance sky130_fd_sc_hd__fill_1_259 r0 *1 0,0
Xsky130_fd_sc_hd__fill_1_259 VGND VPWR VPWR sky130_fd_sc_hd__fill_1
* cell instance sky130_fd_sc_hd__fill_1_260 r0 *1 0,0
Xsky130_fd_sc_hd__fill_1_260 VGND VPWR VPWR sky130_fd_sc_hd__fill_1
* cell instance sky130_fd_sc_hd__fill_1_261 r0 *1 0,0
Xsky130_fd_sc_hd__fill_1_261 VGND VPWR VPWR sky130_fd_sc_hd__fill_1
* cell instance sky130_fd_sc_hd__fill_1_262 r0 *1 0,0
Xsky130_fd_sc_hd__fill_1_262 VGND VPWR VPWR sky130_fd_sc_hd__fill_1
* cell instance sky130_fd_sc_hd__fill_1_263 r0 *1 0,0
Xsky130_fd_sc_hd__fill_1_263 VGND VPWR VPWR sky130_fd_sc_hd__fill_1
* cell instance sky130_fd_sc_hd__fill_1_264 r0 *1 0,0
Xsky130_fd_sc_hd__fill_1_264 VGND VPWR VPWR sky130_fd_sc_hd__fill_1
* cell instance sky130_fd_sc_hd__fill_1_265 r0 *1 0,0
Xsky130_fd_sc_hd__fill_1_265 VGND VPWR VPWR sky130_fd_sc_hd__fill_1
* cell instance sky130_fd_sc_hd__fill_1_266 r0 *1 0,0
Xsky130_fd_sc_hd__fill_1_266 VGND VPWR VPWR sky130_fd_sc_hd__fill_1
* cell instance sky130_fd_sc_hd__fill_1_267 r0 *1 0,0
Xsky130_fd_sc_hd__fill_1_267 VGND VPWR VPWR sky130_fd_sc_hd__fill_1
* cell instance sky130_fd_sc_hd__fill_1_268 r0 *1 0,0
Xsky130_fd_sc_hd__fill_1_268 VGND VPWR VPWR sky130_fd_sc_hd__fill_1
* cell instance sky130_fd_sc_hd__fill_1_269 r0 *1 0,0
Xsky130_fd_sc_hd__fill_1_269 VGND VPWR VPWR sky130_fd_sc_hd__fill_1
* cell instance sky130_fd_sc_hd__fill_1_270 r0 *1 0,0
Xsky130_fd_sc_hd__fill_1_270 VGND VPWR VPWR sky130_fd_sc_hd__fill_1
* cell instance sky130_fd_sc_hd__fill_1_271 r0 *1 0,0
Xsky130_fd_sc_hd__fill_1_271 VGND VPWR VPWR sky130_fd_sc_hd__fill_1
* cell instance sky130_fd_sc_hd__fill_1_272 r0 *1 0,0
Xsky130_fd_sc_hd__fill_1_272 VGND VPWR VPWR sky130_fd_sc_hd__fill_1
* cell instance sky130_fd_sc_hd__fill_1_273 r0 *1 0,0
Xsky130_fd_sc_hd__fill_1_273 VGND VPWR VPWR sky130_fd_sc_hd__fill_1
* cell instance sky130_fd_sc_hd__fill_1_274 r0 *1 0,0
Xsky130_fd_sc_hd__fill_1_274 VGND VPWR VPWR sky130_fd_sc_hd__fill_1
* cell instance sky130_fd_sc_hd__fill_1_275 r0 *1 0,0
Xsky130_fd_sc_hd__fill_1_275 VGND VPWR VPWR sky130_fd_sc_hd__fill_1
* cell instance sky130_fd_sc_hd__fill_1_276 r0 *1 0,0
Xsky130_fd_sc_hd__fill_1_276 VGND VPWR VPWR sky130_fd_sc_hd__fill_1
* cell instance sky130_fd_sc_hd__fill_1_277 r0 *1 0,0
Xsky130_fd_sc_hd__fill_1_277 VGND VPWR VPWR sky130_fd_sc_hd__fill_1
* cell instance sky130_fd_sc_hd__fill_1_278 r0 *1 0,0
Xsky130_fd_sc_hd__fill_1_278 VGND VPWR VPWR sky130_fd_sc_hd__fill_1
* cell instance sky130_fd_sc_hd__fill_1_279 r0 *1 0,0
Xsky130_fd_sc_hd__fill_1_279 VGND VPWR VPWR sky130_fd_sc_hd__fill_1
* cell instance sky130_fd_sc_hd__fill_1_280 r0 *1 0,0
Xsky130_fd_sc_hd__fill_1_280 VGND VPWR VPWR sky130_fd_sc_hd__fill_1
* cell instance sky130_fd_sc_hd__fill_1_281 r0 *1 0,0
Xsky130_fd_sc_hd__fill_1_281 VGND VPWR VPWR sky130_fd_sc_hd__fill_1
* cell instance sky130_fd_sc_hd__fill_1_282 r0 *1 0,0
Xsky130_fd_sc_hd__fill_1_282 VGND VPWR VPWR sky130_fd_sc_hd__fill_1
* cell instance sky130_fd_sc_hd__fill_1_283 r0 *1 0,0
Xsky130_fd_sc_hd__fill_1_283 VGND VPWR VPWR sky130_fd_sc_hd__fill_1
* cell instance sky130_fd_sc_hd__fill_1_284 r0 *1 0,0
Xsky130_fd_sc_hd__fill_1_284 VGND VPWR VPWR sky130_fd_sc_hd__fill_1
* cell instance sky130_fd_sc_hd__fill_1_285 r0 *1 0,0
Xsky130_fd_sc_hd__fill_1_285 VGND VPWR VPWR sky130_fd_sc_hd__fill_1
* cell instance sky130_fd_sc_hd__fill_1_286 r0 *1 0,0
Xsky130_fd_sc_hd__fill_1_286 VGND VPWR VPWR sky130_fd_sc_hd__fill_1
* cell instance sky130_fd_sc_hd__fill_1_287 r0 *1 0,0
Xsky130_fd_sc_hd__fill_1_287 VGND VPWR VPWR sky130_fd_sc_hd__fill_1
* cell instance sky130_fd_sc_hd__fill_1_288 r0 *1 0,0
Xsky130_fd_sc_hd__fill_1_288 VGND VPWR VPWR sky130_fd_sc_hd__fill_1
* cell instance sky130_fd_sc_hd__fill_1_289 r0 *1 0,0
Xsky130_fd_sc_hd__fill_1_289 VGND VPWR VPWR sky130_fd_sc_hd__fill_1
* cell instance sky130_fd_sc_hd__fill_1_290 r0 *1 0,0
Xsky130_fd_sc_hd__fill_1_290 VGND VPWR VPWR sky130_fd_sc_hd__fill_1
* cell instance sky130_fd_sc_hd__fill_1_291 r0 *1 0,0
Xsky130_fd_sc_hd__fill_1_291 VGND VPWR VPWR sky130_fd_sc_hd__fill_1
* cell instance sky130_fd_sc_hd__fill_1_292 r0 *1 0,0
Xsky130_fd_sc_hd__fill_1_292 VGND VPWR VPWR sky130_fd_sc_hd__fill_1
* cell instance sky130_fd_sc_hd__fill_1_293 r0 *1 0,0
Xsky130_fd_sc_hd__fill_1_293 VGND VPWR VPWR sky130_fd_sc_hd__fill_1
* cell instance sky130_fd_sc_hd__fill_1_294 r0 *1 0,0
Xsky130_fd_sc_hd__fill_1_294 VGND VPWR VPWR sky130_fd_sc_hd__fill_1
* cell instance sky130_fd_sc_hd__fill_1_295 r0 *1 0,0
Xsky130_fd_sc_hd__fill_1_295 VGND VPWR VPWR sky130_fd_sc_hd__fill_1
* cell instance sky130_fd_sc_hd__fill_1_296 r0 *1 0,0
Xsky130_fd_sc_hd__fill_1_296 VGND VPWR VPWR sky130_fd_sc_hd__fill_1
* cell instance sky130_fd_sc_hd__fill_1_297 r0 *1 0,0
Xsky130_fd_sc_hd__fill_1_297 VGND VPWR VPWR sky130_fd_sc_hd__fill_1
* cell instance sky130_fd_sc_hd__fill_1_298 r0 *1 0,0
Xsky130_fd_sc_hd__fill_1_298 VGND VPWR VPWR sky130_fd_sc_hd__fill_1
* cell instance sky130_fd_sc_hd__fill_1_299 r0 *1 0,0
Xsky130_fd_sc_hd__fill_1_299 VGND VPWR VPWR sky130_fd_sc_hd__fill_1
* cell instance sky130_fd_sc_hd__fill_1_300 r0 *1 0,0
Xsky130_fd_sc_hd__fill_1_300 VGND VPWR VPWR sky130_fd_sc_hd__fill_1
* cell instance sky130_fd_sc_hd__fill_1_301 r0 *1 0,0
Xsky130_fd_sc_hd__fill_1_301 VGND VPWR VPWR sky130_fd_sc_hd__fill_1
* cell instance sky130_fd_sc_hd__fill_1_302 r0 *1 0,0
Xsky130_fd_sc_hd__fill_1_302 VGND VPWR VPWR sky130_fd_sc_hd__fill_1
* cell instance sky130_fd_sc_hd__fill_1_303 r0 *1 0,0
Xsky130_fd_sc_hd__fill_1_303 VGND VPWR VPWR sky130_fd_sc_hd__fill_1
* cell instance sky130_fd_sc_hd__fill_1_304 r0 *1 0,0
Xsky130_fd_sc_hd__fill_1_304 VGND VPWR VPWR sky130_fd_sc_hd__fill_1
* cell instance sky130_fd_sc_hd__fill_1_305 r0 *1 0,0
Xsky130_fd_sc_hd__fill_1_305 VGND VPWR VPWR sky130_fd_sc_hd__fill_1
* cell instance sky130_fd_sc_hd__fill_1_306 r0 *1 0,0
Xsky130_fd_sc_hd__fill_1_306 VGND VPWR VPWR sky130_fd_sc_hd__fill_1
* cell instance sky130_fd_sc_hd__fill_1_307 r0 *1 0,0
Xsky130_fd_sc_hd__fill_1_307 VGND VPWR VPWR sky130_fd_sc_hd__fill_1
* cell instance sky130_fd_sc_hd__fill_1_308 r0 *1 0,0
Xsky130_fd_sc_hd__fill_1_308 VGND VPWR VPWR sky130_fd_sc_hd__fill_1
* cell instance sky130_fd_sc_hd__fill_1_309 r0 *1 0,0
Xsky130_fd_sc_hd__fill_1_309 VGND VPWR VPWR sky130_fd_sc_hd__fill_1
* cell instance sky130_fd_sc_hd__fill_1_310 r0 *1 0,0
Xsky130_fd_sc_hd__fill_1_310 VGND VPWR VPWR sky130_fd_sc_hd__fill_1
* cell instance sky130_fd_sc_hd__fill_1_311 r0 *1 0,0
Xsky130_fd_sc_hd__fill_1_311 VGND VPWR VPWR sky130_fd_sc_hd__fill_1
* cell instance sky130_fd_sc_hd__fill_1_312 r0 *1 0,0
Xsky130_fd_sc_hd__fill_1_312 VGND VPWR VPWR sky130_fd_sc_hd__fill_1
* cell instance sky130_fd_sc_hd__fill_1_313 r0 *1 0,0
Xsky130_fd_sc_hd__fill_1_313 VGND VPWR VPWR sky130_fd_sc_hd__fill_1
* cell instance sky130_fd_sc_hd__fill_1_314 r0 *1 0,0
Xsky130_fd_sc_hd__fill_1_314 VGND VPWR VPWR sky130_fd_sc_hd__fill_1
* cell instance sky130_fd_sc_hd__fill_1_315 r0 *1 0,0
Xsky130_fd_sc_hd__fill_1_315 VGND VPWR VPWR sky130_fd_sc_hd__fill_1
* cell instance sky130_fd_sc_hd__fill_1_316 r0 *1 0,0
Xsky130_fd_sc_hd__fill_1_316 VGND VPWR VPWR sky130_fd_sc_hd__fill_1
* cell instance sky130_fd_sc_hd__fill_1_317 r0 *1 0,0
Xsky130_fd_sc_hd__fill_1_317 VGND VPWR VPWR sky130_fd_sc_hd__fill_1
* cell instance sky130_fd_sc_hd__fill_1_318 r0 *1 0,0
Xsky130_fd_sc_hd__fill_1_318 VGND VPWR VPWR sky130_fd_sc_hd__fill_1
* cell instance sky130_fd_sc_hd__fill_1_319 r0 *1 0,0
Xsky130_fd_sc_hd__fill_1_319 VGND VPWR VPWR sky130_fd_sc_hd__fill_1
* cell instance sky130_fd_sc_hd__fill_1_320 r0 *1 0,0
Xsky130_fd_sc_hd__fill_1_320 VGND VPWR VPWR sky130_fd_sc_hd__fill_1
* cell instance sky130_fd_sc_hd__fill_1_321 r0 *1 0,0
Xsky130_fd_sc_hd__fill_1_321 VGND VPWR VPWR sky130_fd_sc_hd__fill_1
* cell instance sky130_fd_sc_hd__fill_1_322 r0 *1 0,0
Xsky130_fd_sc_hd__fill_1_322 VGND VPWR VPWR sky130_fd_sc_hd__fill_1
* cell instance sky130_fd_sc_hd__fill_1_323 r0 *1 0,0
Xsky130_fd_sc_hd__fill_1_323 VGND VPWR VPWR sky130_fd_sc_hd__fill_1
* cell instance sky130_fd_sc_hd__fill_1_324 r0 *1 0,0
Xsky130_fd_sc_hd__fill_1_324 VGND VPWR VPWR sky130_fd_sc_hd__fill_1
* cell instance sky130_fd_sc_hd__fill_1_325 r0 *1 0,0
Xsky130_fd_sc_hd__fill_1_325 VGND VPWR VPWR sky130_fd_sc_hd__fill_1
* cell instance sky130_fd_sc_hd__fill_1_326 r0 *1 0,0
Xsky130_fd_sc_hd__fill_1_326 VGND VPWR VPWR sky130_fd_sc_hd__fill_1
* cell instance sky130_fd_sc_hd__fill_1_327 r0 *1 0,0
Xsky130_fd_sc_hd__fill_1_327 VGND VPWR VPWR sky130_fd_sc_hd__fill_1
* cell instance sky130_fd_sc_hd__fill_1_328 r0 *1 0,0
Xsky130_fd_sc_hd__fill_1_328 VGND VPWR VPWR sky130_fd_sc_hd__fill_1
* cell instance sky130_fd_sc_hd__fill_1_329 r0 *1 0,0
Xsky130_fd_sc_hd__fill_1_329 VGND VPWR VPWR sky130_fd_sc_hd__fill_1
* cell instance sky130_fd_sc_hd__fill_1_330 r0 *1 0,0
Xsky130_fd_sc_hd__fill_1_330 VGND VPWR VPWR sky130_fd_sc_hd__fill_1
* cell instance sky130_fd_sc_hd__fill_1_331 r0 *1 0,0
Xsky130_fd_sc_hd__fill_1_331 VGND VPWR VPWR sky130_fd_sc_hd__fill_1
* cell instance sky130_fd_sc_hd__fill_1_332 r0 *1 0,0
Xsky130_fd_sc_hd__fill_1_332 VGND VPWR VPWR sky130_fd_sc_hd__fill_1
* cell instance sky130_fd_sc_hd__fill_1_333 r0 *1 0,0
Xsky130_fd_sc_hd__fill_1_333 VGND VPWR VPWR sky130_fd_sc_hd__fill_1
* cell instance sky130_fd_sc_hd__fill_1_334 r0 *1 0,0
Xsky130_fd_sc_hd__fill_1_334 VGND VPWR VPWR sky130_fd_sc_hd__fill_1
* cell instance sky130_fd_sc_hd__fill_1_335 r0 *1 0,0
Xsky130_fd_sc_hd__fill_1_335 VGND VPWR VPWR sky130_fd_sc_hd__fill_1
* cell instance sky130_fd_sc_hd__fill_1_336 r0 *1 0,0
Xsky130_fd_sc_hd__fill_1_336 VGND VPWR VPWR sky130_fd_sc_hd__fill_1
* cell instance sky130_fd_sc_hd__fill_1_337 r0 *1 0,0
Xsky130_fd_sc_hd__fill_1_337 VGND VPWR VPWR sky130_fd_sc_hd__fill_1
* cell instance sky130_fd_sc_hd__fill_1_338 r0 *1 0,0
Xsky130_fd_sc_hd__fill_1_338 VGND VPWR VPWR sky130_fd_sc_hd__fill_1
* cell instance sky130_fd_sc_hd__fill_1_339 r0 *1 0,0
Xsky130_fd_sc_hd__fill_1_339 VGND VPWR VPWR sky130_fd_sc_hd__fill_1
* cell instance sky130_fd_sc_hd__fill_1_340 r0 *1 0,0
Xsky130_fd_sc_hd__fill_1_340 VGND VPWR VPWR sky130_fd_sc_hd__fill_1
* cell instance sky130_fd_sc_hd__fill_1_341 r0 *1 0,0
Xsky130_fd_sc_hd__fill_1_341 VGND VPWR VPWR sky130_fd_sc_hd__fill_1
* cell instance sky130_fd_sc_hd__fill_1_342 r0 *1 0,0
Xsky130_fd_sc_hd__fill_1_342 VGND VPWR VPWR sky130_fd_sc_hd__fill_1
* cell instance sky130_fd_sc_hd__fill_1_343 r0 *1 0,0
Xsky130_fd_sc_hd__fill_1_343 VGND VPWR VPWR sky130_fd_sc_hd__fill_1
* cell instance sky130_fd_sc_hd__fill_1_344 r0 *1 0,0
Xsky130_fd_sc_hd__fill_1_344 VGND VPWR VPWR sky130_fd_sc_hd__fill_1
* cell instance sky130_fd_sc_hd__fill_1_345 r0 *1 0,0
Xsky130_fd_sc_hd__fill_1_345 VGND VPWR VPWR sky130_fd_sc_hd__fill_1
* cell instance sky130_fd_sc_hd__fill_1_346 r0 *1 0,0
Xsky130_fd_sc_hd__fill_1_346 VGND VPWR VPWR sky130_fd_sc_hd__fill_1
* cell instance sky130_fd_sc_hd__fill_1_347 r0 *1 0,0
Xsky130_fd_sc_hd__fill_1_347 VGND VPWR VPWR sky130_fd_sc_hd__fill_1
* cell instance sky130_fd_sc_hd__fill_1_348 r0 *1 0,0
Xsky130_fd_sc_hd__fill_1_348 VGND VPWR VPWR sky130_fd_sc_hd__fill_1
* cell instance sky130_fd_sc_hd__fill_1_349 r0 *1 0,0
Xsky130_fd_sc_hd__fill_1_349 VGND VPWR VPWR sky130_fd_sc_hd__fill_1
* cell instance sky130_fd_sc_hd__fill_1_350 r0 *1 0,0
Xsky130_fd_sc_hd__fill_1_350 VGND VPWR VPWR sky130_fd_sc_hd__fill_1
* cell instance sky130_fd_sc_hd__fill_1_351 r0 *1 0,0
Xsky130_fd_sc_hd__fill_1_351 VGND VPWR VPWR sky130_fd_sc_hd__fill_1
* cell instance sky130_fd_sc_hd__fill_1_352 r0 *1 0,0
Xsky130_fd_sc_hd__fill_1_352 VGND VPWR VPWR sky130_fd_sc_hd__fill_1
* cell instance sky130_fd_sc_hd__fill_1_353 r0 *1 0,0
Xsky130_fd_sc_hd__fill_1_353 VGND VPWR VPWR sky130_fd_sc_hd__fill_1
* cell instance sky130_fd_sc_hd__fill_1_354 r0 *1 0,0
Xsky130_fd_sc_hd__fill_1_354 VGND VPWR VPWR sky130_fd_sc_hd__fill_1
* cell instance sky130_fd_sc_hd__fill_1_355 r0 *1 0,0
Xsky130_fd_sc_hd__fill_1_355 VGND VPWR VPWR sky130_fd_sc_hd__fill_1
* cell instance sky130_fd_sc_hd__fill_1_356 r0 *1 0,0
Xsky130_fd_sc_hd__fill_1_356 VGND VPWR VPWR sky130_fd_sc_hd__fill_1
* cell instance sky130_fd_sc_hd__fill_1_357 r0 *1 0,0
Xsky130_fd_sc_hd__fill_1_357 VGND VPWR VPWR sky130_fd_sc_hd__fill_1
* cell instance sky130_fd_sc_hd__fill_1_358 r0 *1 0,0
Xsky130_fd_sc_hd__fill_1_358 VGND VPWR VPWR sky130_fd_sc_hd__fill_1
* cell instance sky130_fd_sc_hd__fill_1_359 r0 *1 0,0
Xsky130_fd_sc_hd__fill_1_359 VGND VPWR VPWR sky130_fd_sc_hd__fill_1
* cell instance sky130_fd_sc_hd__fill_1_360 r0 *1 0,0
Xsky130_fd_sc_hd__fill_1_360 VGND VPWR VPWR sky130_fd_sc_hd__fill_1
* cell instance sky130_fd_sc_hd__fill_1_361 r0 *1 0,0
Xsky130_fd_sc_hd__fill_1_361 VGND VPWR VPWR sky130_fd_sc_hd__fill_1
* cell instance sky130_fd_sc_hd__fill_1_362 r0 *1 0,0
Xsky130_fd_sc_hd__fill_1_362 VGND VPWR VPWR sky130_fd_sc_hd__fill_1
* cell instance sky130_fd_sc_hd__fill_1_363 r0 *1 0,0
Xsky130_fd_sc_hd__fill_1_363 VGND VPWR VPWR sky130_fd_sc_hd__fill_1
* cell instance sky130_fd_sc_hd__fill_1_364 r0 *1 0,0
Xsky130_fd_sc_hd__fill_1_364 VGND VPWR VPWR sky130_fd_sc_hd__fill_1
* cell instance sky130_fd_sc_hd__fill_1_365 r0 *1 0,0
Xsky130_fd_sc_hd__fill_1_365 VGND VPWR VPWR sky130_fd_sc_hd__fill_1
* cell instance sky130_fd_sc_hd__fill_1_366 r0 *1 0,0
Xsky130_fd_sc_hd__fill_1_366 VGND VPWR VPWR sky130_fd_sc_hd__fill_1
* cell instance sky130_fd_sc_hd__fill_1_367 r0 *1 0,0
Xsky130_fd_sc_hd__fill_1_367 VGND VPWR VPWR sky130_fd_sc_hd__fill_1
* cell instance sky130_fd_sc_hd__fill_1_368 r0 *1 0,0
Xsky130_fd_sc_hd__fill_1_368 VGND VPWR VPWR sky130_fd_sc_hd__fill_1
* cell instance sky130_fd_sc_hd__fill_1_369 r0 *1 0,0
Xsky130_fd_sc_hd__fill_1_369 VGND VPWR VPWR sky130_fd_sc_hd__fill_1
* cell instance sky130_fd_sc_hd__fill_1_370 r0 *1 0,0
Xsky130_fd_sc_hd__fill_1_370 VGND VPWR VPWR sky130_fd_sc_hd__fill_1
* cell instance sky130_fd_sc_hd__fill_1_371 r0 *1 0,0
Xsky130_fd_sc_hd__fill_1_371 VGND VPWR VPWR sky130_fd_sc_hd__fill_1
* cell instance sky130_fd_sc_hd__fill_1_372 r0 *1 0,0
Xsky130_fd_sc_hd__fill_1_372 VGND VPWR VPWR sky130_fd_sc_hd__fill_1
* cell instance sky130_fd_sc_hd__fill_1_373 r0 *1 0,0
Xsky130_fd_sc_hd__fill_1_373 VGND VPWR VPWR sky130_fd_sc_hd__fill_1
* cell instance sky130_fd_sc_hd__fill_1_374 r0 *1 0,0
Xsky130_fd_sc_hd__fill_1_374 VGND VPWR VPWR sky130_fd_sc_hd__fill_1
* cell instance sky130_fd_sc_hd__fill_1_375 r0 *1 0,0
Xsky130_fd_sc_hd__fill_1_375 VGND VPWR VPWR sky130_fd_sc_hd__fill_1
* cell instance sky130_fd_sc_hd__fill_1_376 r0 *1 0,0
Xsky130_fd_sc_hd__fill_1_376 VGND VPWR VPWR sky130_fd_sc_hd__fill_1
* cell instance sky130_fd_sc_hd__fill_1_377 r0 *1 0,0
Xsky130_fd_sc_hd__fill_1_377 VGND VPWR VPWR sky130_fd_sc_hd__fill_1
* cell instance sky130_fd_sc_hd__fill_1_378 r0 *1 0,0
Xsky130_fd_sc_hd__fill_1_378 VGND VPWR VPWR sky130_fd_sc_hd__fill_1
* cell instance sky130_fd_sc_hd__fill_1_379 r0 *1 0,0
Xsky130_fd_sc_hd__fill_1_379 VGND VPWR VPWR sky130_fd_sc_hd__fill_1
* cell instance sky130_fd_sc_hd__fill_1_380 r0 *1 0,0
Xsky130_fd_sc_hd__fill_1_380 VGND VPWR VPWR sky130_fd_sc_hd__fill_1
* cell instance sky130_fd_sc_hd__fill_1_381 r0 *1 0,0
Xsky130_fd_sc_hd__fill_1_381 VGND VPWR VPWR sky130_fd_sc_hd__fill_1
* cell instance sky130_fd_sc_hd__fill_1_382 r0 *1 0,0
Xsky130_fd_sc_hd__fill_1_382 VGND VPWR VPWR sky130_fd_sc_hd__fill_1
* cell instance sky130_fd_sc_hd__fill_1_383 r0 *1 0,0
Xsky130_fd_sc_hd__fill_1_383 VGND VPWR VPWR sky130_fd_sc_hd__fill_1
* cell instance sky130_fd_sc_hd__fill_1_384 r0 *1 0,0
Xsky130_fd_sc_hd__fill_1_384 VGND VPWR VPWR sky130_fd_sc_hd__fill_1
* cell instance sky130_fd_sc_hd__fill_1_385 r0 *1 0,0
Xsky130_fd_sc_hd__fill_1_385 VGND VPWR VPWR sky130_fd_sc_hd__fill_1
* cell instance sky130_fd_sc_hd__fill_1_386 r0 *1 0,0
Xsky130_fd_sc_hd__fill_1_386 VGND VPWR VPWR sky130_fd_sc_hd__fill_1
* cell instance sky130_fd_sc_hd__fill_1_387 r0 *1 0,0
Xsky130_fd_sc_hd__fill_1_387 VGND VPWR VPWR sky130_fd_sc_hd__fill_1
* cell instance sky130_fd_sc_hd__fill_1_388 r0 *1 0,0
Xsky130_fd_sc_hd__fill_1_388 VGND VPWR VPWR sky130_fd_sc_hd__fill_1
* cell instance sky130_fd_sc_hd__fill_1_389 r0 *1 0,0
Xsky130_fd_sc_hd__fill_1_389 VGND VPWR VPWR sky130_fd_sc_hd__fill_1
* cell instance sky130_fd_sc_hd__fill_1_390 r0 *1 0,0
Xsky130_fd_sc_hd__fill_1_390 VGND VPWR VPWR sky130_fd_sc_hd__fill_1
* cell instance sky130_fd_sc_hd__fill_1_391 r0 *1 0,0
Xsky130_fd_sc_hd__fill_1_391 VGND VPWR VPWR sky130_fd_sc_hd__fill_1
* cell instance sky130_fd_sc_hd__fill_1_392 r0 *1 0,0
Xsky130_fd_sc_hd__fill_1_392 VGND VPWR VPWR sky130_fd_sc_hd__fill_1
* cell instance sky130_fd_sc_hd__fill_1_393 r0 *1 0,0
Xsky130_fd_sc_hd__fill_1_393 VGND VPWR VPWR sky130_fd_sc_hd__fill_1
* cell instance sky130_fd_sc_hd__fill_1_394 r0 *1 0,0
Xsky130_fd_sc_hd__fill_1_394 VGND VPWR VPWR sky130_fd_sc_hd__fill_1
* cell instance sky130_fd_sc_hd__fill_1_395 r0 *1 0,0
Xsky130_fd_sc_hd__fill_1_395 VGND VPWR VPWR sky130_fd_sc_hd__fill_1
* cell instance sky130_fd_sc_hd__fill_1_396 r0 *1 0,0
Xsky130_fd_sc_hd__fill_1_396 VGND VPWR VPWR sky130_fd_sc_hd__fill_1
* cell instance sky130_fd_sc_hd__fill_1_397 r0 *1 0,0
Xsky130_fd_sc_hd__fill_1_397 VGND VPWR VPWR sky130_fd_sc_hd__fill_1
* cell instance sky130_fd_sc_hd__fill_1_398 r0 *1 0,0
Xsky130_fd_sc_hd__fill_1_398 VGND VPWR VPWR sky130_fd_sc_hd__fill_1
* cell instance sky130_fd_sc_hd__fill_1_399 r0 *1 0,0
Xsky130_fd_sc_hd__fill_1_399 VGND VPWR VPWR sky130_fd_sc_hd__fill_1
* cell instance sky130_fd_sc_hd__fill_1_400 r0 *1 0,0
Xsky130_fd_sc_hd__fill_1_400 VGND VPWR VPWR sky130_fd_sc_hd__fill_1
* cell instance sky130_fd_sc_hd__fill_1_401 r0 *1 0,0
Xsky130_fd_sc_hd__fill_1_401 VGND VPWR VPWR sky130_fd_sc_hd__fill_1
* cell instance sky130_fd_sc_hd__fill_1_402 r0 *1 0,0
Xsky130_fd_sc_hd__fill_1_402 VGND VPWR VPWR sky130_fd_sc_hd__fill_1
* cell instance sky130_fd_sc_hd__fill_1_403 r0 *1 0,0
Xsky130_fd_sc_hd__fill_1_403 VGND VPWR VPWR sky130_fd_sc_hd__fill_1
* cell instance sky130_fd_sc_hd__fill_1_404 r0 *1 0,0
Xsky130_fd_sc_hd__fill_1_404 VGND VPWR VPWR sky130_fd_sc_hd__fill_1
* cell instance sky130_fd_sc_hd__fill_1_405 r0 *1 0,0
Xsky130_fd_sc_hd__fill_1_405 VGND VPWR VPWR sky130_fd_sc_hd__fill_1
* cell instance sky130_fd_sc_hd__fill_1_406 r0 *1 0,0
Xsky130_fd_sc_hd__fill_1_406 VGND VPWR VPWR sky130_fd_sc_hd__fill_1
* cell instance sky130_fd_sc_hd__fill_1_407 r0 *1 0,0
Xsky130_fd_sc_hd__fill_1_407 VGND VPWR VPWR sky130_fd_sc_hd__fill_1
* cell instance sky130_fd_sc_hd__fill_1_408 r0 *1 0,0
Xsky130_fd_sc_hd__fill_1_408 VGND VPWR VPWR sky130_fd_sc_hd__fill_1
* cell instance sky130_fd_sc_hd__fill_1_409 r0 *1 0,0
Xsky130_fd_sc_hd__fill_1_409 VGND VPWR VPWR sky130_fd_sc_hd__fill_1
* cell instance sky130_fd_sc_hd__fill_1_410 r0 *1 0,0
Xsky130_fd_sc_hd__fill_1_410 VGND VPWR VPWR sky130_fd_sc_hd__fill_1
* cell instance sky130_fd_sc_hd__fill_1_411 r0 *1 0,0
Xsky130_fd_sc_hd__fill_1_411 VGND VPWR VPWR sky130_fd_sc_hd__fill_1
* cell instance sky130_fd_sc_hd__fill_1_412 r0 *1 0,0
Xsky130_fd_sc_hd__fill_1_412 VGND VPWR VPWR sky130_fd_sc_hd__fill_1
* cell instance sky130_fd_sc_hd__fill_1_413 r0 *1 0,0
Xsky130_fd_sc_hd__fill_1_413 VGND VPWR VPWR sky130_fd_sc_hd__fill_1
* cell instance sky130_fd_sc_hd__fill_1_414 r0 *1 0,0
Xsky130_fd_sc_hd__fill_1_414 VGND VPWR VPWR sky130_fd_sc_hd__fill_1
* cell instance sky130_fd_sc_hd__fill_1_415 r0 *1 0,0
Xsky130_fd_sc_hd__fill_1_415 VGND VPWR VPWR sky130_fd_sc_hd__fill_1
* cell instance sky130_fd_sc_hd__fill_1_416 r0 *1 0,0
Xsky130_fd_sc_hd__fill_1_416 VGND VPWR VPWR sky130_fd_sc_hd__fill_1
* cell instance sky130_fd_sc_hd__fill_1_417 r0 *1 0,0
Xsky130_fd_sc_hd__fill_1_417 VGND VPWR VPWR sky130_fd_sc_hd__fill_1
* cell instance sky130_fd_sc_hd__fill_1_418 r0 *1 0,0
Xsky130_fd_sc_hd__fill_1_418 VGND VPWR VPWR sky130_fd_sc_hd__fill_1
* cell instance sky130_fd_sc_hd__fill_1_419 r0 *1 0,0
Xsky130_fd_sc_hd__fill_1_419 VGND VPWR VPWR sky130_fd_sc_hd__fill_1
* cell instance sky130_fd_sc_hd__fill_1_420 r0 *1 0,0
Xsky130_fd_sc_hd__fill_1_420 VGND VPWR VPWR sky130_fd_sc_hd__fill_1
* cell instance sky130_fd_sc_hd__fill_1_421 r0 *1 0,0
Xsky130_fd_sc_hd__fill_1_421 VGND VPWR VPWR sky130_fd_sc_hd__fill_1
* cell instance sky130_fd_sc_hd__fill_1_422 r0 *1 0,0
Xsky130_fd_sc_hd__fill_1_422 VGND VPWR VPWR sky130_fd_sc_hd__fill_1
* cell instance sky130_fd_sc_hd__fill_1_423 r0 *1 0,0
Xsky130_fd_sc_hd__fill_1_423 VGND VPWR VPWR sky130_fd_sc_hd__fill_1
* cell instance sky130_fd_sc_hd__fill_1_424 r0 *1 0,0
Xsky130_fd_sc_hd__fill_1_424 VGND VPWR VPWR sky130_fd_sc_hd__fill_1
* cell instance sky130_fd_sc_hd__fill_1_425 r0 *1 0,0
Xsky130_fd_sc_hd__fill_1_425 VGND VPWR VPWR sky130_fd_sc_hd__fill_1
* cell instance sky130_fd_sc_hd__fill_1_426 r0 *1 0,0
Xsky130_fd_sc_hd__fill_1_426 VGND VPWR VPWR sky130_fd_sc_hd__fill_1
* cell instance sky130_fd_sc_hd__fill_1_427 r0 *1 0,0
Xsky130_fd_sc_hd__fill_1_427 VGND VPWR VPWR sky130_fd_sc_hd__fill_1
* cell instance sky130_fd_sc_hd__fill_1_428 r0 *1 0,0
Xsky130_fd_sc_hd__fill_1_428 VGND VPWR VPWR sky130_fd_sc_hd__fill_1
* cell instance sky130_fd_sc_hd__fill_1_429 r0 *1 0,0
Xsky130_fd_sc_hd__fill_1_429 VGND VPWR VPWR sky130_fd_sc_hd__fill_1
* cell instance sky130_fd_sc_hd__fill_1_430 r0 *1 0,0
Xsky130_fd_sc_hd__fill_1_430 VGND VPWR VPWR sky130_fd_sc_hd__fill_1
* cell instance sky130_fd_sc_hd__fill_1_431 r0 *1 0,0
Xsky130_fd_sc_hd__fill_1_431 VGND VPWR VPWR sky130_fd_sc_hd__fill_1
* cell instance sky130_fd_sc_hd__fill_1_432 r0 *1 0,0
Xsky130_fd_sc_hd__fill_1_432 VGND VPWR VPWR sky130_fd_sc_hd__fill_1
* cell instance sky130_fd_sc_hd__fill_1_433 r0 *1 0,0
Xsky130_fd_sc_hd__fill_1_433 VGND VPWR VPWR sky130_fd_sc_hd__fill_1
* cell instance sky130_fd_sc_hd__fill_1_434 r0 *1 0,0
Xsky130_fd_sc_hd__fill_1_434 VGND VPWR VPWR sky130_fd_sc_hd__fill_1
* cell instance sky130_fd_sc_hd__fill_1_435 r0 *1 0,0
Xsky130_fd_sc_hd__fill_1_435 VGND VPWR VPWR sky130_fd_sc_hd__fill_1
* cell instance sky130_fd_sc_hd__fill_1_436 r0 *1 0,0
Xsky130_fd_sc_hd__fill_1_436 VGND VPWR VPWR sky130_fd_sc_hd__fill_1
* cell instance sky130_fd_sc_hd__fill_1_437 r0 *1 0,0
Xsky130_fd_sc_hd__fill_1_437 VGND VPWR VPWR sky130_fd_sc_hd__fill_1
* cell instance sky130_fd_sc_hd__fill_1_438 r0 *1 0,0
Xsky130_fd_sc_hd__fill_1_438 VGND VPWR VPWR sky130_fd_sc_hd__fill_1
* cell instance sky130_fd_sc_hd__fill_1_439 r0 *1 0,0
Xsky130_fd_sc_hd__fill_1_439 VGND VPWR VPWR sky130_fd_sc_hd__fill_1
* cell instance sky130_fd_sc_hd__fill_1_440 r0 *1 0,0
Xsky130_fd_sc_hd__fill_1_440 VGND VPWR VPWR sky130_fd_sc_hd__fill_1
* cell instance sky130_fd_sc_hd__fill_1_441 r0 *1 0,0
Xsky130_fd_sc_hd__fill_1_441 VGND VPWR VPWR sky130_fd_sc_hd__fill_1
* cell instance sky130_fd_sc_hd__fill_1_442 r0 *1 0,0
Xsky130_fd_sc_hd__fill_1_442 VGND VPWR VPWR sky130_fd_sc_hd__fill_1
* cell instance sky130_fd_sc_hd__fill_1_443 r0 *1 0,0
Xsky130_fd_sc_hd__fill_1_443 VGND VPWR VPWR sky130_fd_sc_hd__fill_1
* cell instance sky130_fd_sc_hd__fill_1_444 r0 *1 0,0
Xsky130_fd_sc_hd__fill_1_444 VGND VPWR VPWR sky130_fd_sc_hd__fill_1
* cell instance sky130_fd_sc_hd__fill_1_445 r0 *1 0,0
Xsky130_fd_sc_hd__fill_1_445 VGND VPWR VPWR sky130_fd_sc_hd__fill_1
* cell instance sky130_fd_sc_hd__fill_1_446 r0 *1 0,0
Xsky130_fd_sc_hd__fill_1_446 VGND VPWR VPWR sky130_fd_sc_hd__fill_1
* cell instance sky130_fd_sc_hd__fill_1_447 r0 *1 0,0
Xsky130_fd_sc_hd__fill_1_447 VGND VPWR VPWR sky130_fd_sc_hd__fill_1
* cell instance sky130_fd_sc_hd__fill_1_448 r0 *1 0,0
Xsky130_fd_sc_hd__fill_1_448 VGND VPWR VPWR sky130_fd_sc_hd__fill_1
* cell instance sky130_fd_sc_hd__fill_1_449 r0 *1 0,0
Xsky130_fd_sc_hd__fill_1_449 VGND VPWR VPWR sky130_fd_sc_hd__fill_1
* cell instance sky130_fd_sc_hd__fill_1_450 r0 *1 0,0
Xsky130_fd_sc_hd__fill_1_450 VGND VPWR VPWR sky130_fd_sc_hd__fill_1
* cell instance sky130_fd_sc_hd__fill_1_451 r0 *1 0,0
Xsky130_fd_sc_hd__fill_1_451 VGND VPWR VPWR sky130_fd_sc_hd__fill_1
* cell instance sky130_fd_sc_hd__fill_1_452 r0 *1 0,0
Xsky130_fd_sc_hd__fill_1_452 VGND VPWR VPWR sky130_fd_sc_hd__fill_1
* cell instance sky130_fd_sc_hd__fill_1_453 r0 *1 0,0
Xsky130_fd_sc_hd__fill_1_453 VGND VPWR VPWR sky130_fd_sc_hd__fill_1
* cell instance sky130_fd_sc_hd__fill_1_454 r0 *1 0,0
Xsky130_fd_sc_hd__fill_1_454 VGND VPWR VPWR sky130_fd_sc_hd__fill_1
* cell instance sky130_fd_sc_hd__fill_1_455 r0 *1 0,0
Xsky130_fd_sc_hd__fill_1_455 VGND VPWR VPWR sky130_fd_sc_hd__fill_1
* cell instance sky130_fd_sc_hd__fill_1_456 r0 *1 0,0
Xsky130_fd_sc_hd__fill_1_456 VGND VPWR VPWR sky130_fd_sc_hd__fill_1
* cell instance sky130_fd_sc_hd__fill_1_457 r0 *1 0,0
Xsky130_fd_sc_hd__fill_1_457 VGND VPWR VPWR sky130_fd_sc_hd__fill_1
* cell instance sky130_fd_sc_hd__fill_1_458 r0 *1 0,0
Xsky130_fd_sc_hd__fill_1_458 VGND VPWR VPWR sky130_fd_sc_hd__fill_1
* cell instance sky130_fd_sc_hd__fill_1_459 r0 *1 0,0
Xsky130_fd_sc_hd__fill_1_459 VGND VPWR VPWR sky130_fd_sc_hd__fill_1
* cell instance sky130_fd_sc_hd__fill_1_460 r0 *1 0,0
Xsky130_fd_sc_hd__fill_1_460 VGND VPWR VPWR sky130_fd_sc_hd__fill_1
* cell instance sky130_fd_sc_hd__fill_1_461 r0 *1 0,0
Xsky130_fd_sc_hd__fill_1_461 VGND VPWR VPWR sky130_fd_sc_hd__fill_1
* cell instance sky130_fd_sc_hd__fill_1_462 r0 *1 0,0
Xsky130_fd_sc_hd__fill_1_462 VGND VPWR VPWR sky130_fd_sc_hd__fill_1
* cell instance sky130_fd_sc_hd__fill_1_463 r0 *1 0,0
Xsky130_fd_sc_hd__fill_1_463 VGND VPWR VPWR sky130_fd_sc_hd__fill_1
* cell instance sky130_fd_sc_hd__fill_1_464 r0 *1 0,0
Xsky130_fd_sc_hd__fill_1_464 VGND VPWR VPWR sky130_fd_sc_hd__fill_1
* cell instance sky130_fd_sc_hd__fill_1_465 r0 *1 0,0
Xsky130_fd_sc_hd__fill_1_465 VGND VPWR VPWR sky130_fd_sc_hd__fill_1
* cell instance sky130_fd_sc_hd__fill_1_466 r0 *1 0,0
Xsky130_fd_sc_hd__fill_1_466 VGND VPWR VPWR sky130_fd_sc_hd__fill_1
* cell instance sky130_fd_sc_hd__fill_1_467 r0 *1 0,0
Xsky130_fd_sc_hd__fill_1_467 VGND VPWR VPWR sky130_fd_sc_hd__fill_1
* cell instance sky130_fd_sc_hd__fill_1_468 r0 *1 0,0
Xsky130_fd_sc_hd__fill_1_468 VGND VPWR VPWR sky130_fd_sc_hd__fill_1
* cell instance sky130_fd_sc_hd__fill_1_469 r0 *1 0,0
Xsky130_fd_sc_hd__fill_1_469 VGND VPWR VPWR sky130_fd_sc_hd__fill_1
* cell instance sky130_fd_sc_hd__fill_1_470 r0 *1 0,0
Xsky130_fd_sc_hd__fill_1_470 VGND VPWR VPWR sky130_fd_sc_hd__fill_1
* cell instance sky130_fd_sc_hd__fill_1_471 r0 *1 0,0
Xsky130_fd_sc_hd__fill_1_471 VGND VPWR VPWR sky130_fd_sc_hd__fill_1
* cell instance sky130_fd_sc_hd__fill_1_472 r0 *1 0,0
Xsky130_fd_sc_hd__fill_1_472 VGND VPWR VPWR sky130_fd_sc_hd__fill_1
* cell instance sky130_fd_sc_hd__fill_1_473 r0 *1 0,0
Xsky130_fd_sc_hd__fill_1_473 VGND VPWR VPWR sky130_fd_sc_hd__fill_1
* cell instance sky130_fd_sc_hd__fill_1_474 r0 *1 0,0
Xsky130_fd_sc_hd__fill_1_474 VGND VPWR VPWR sky130_fd_sc_hd__fill_1
* cell instance sky130_fd_sc_hd__fill_1_475 r0 *1 0,0
Xsky130_fd_sc_hd__fill_1_475 VGND VPWR VPWR sky130_fd_sc_hd__fill_1
* cell instance sky130_fd_sc_hd__fill_1_476 r0 *1 0,0
Xsky130_fd_sc_hd__fill_1_476 VGND VPWR VPWR sky130_fd_sc_hd__fill_1
* cell instance sky130_fd_sc_hd__fill_1_477 r0 *1 0,0
Xsky130_fd_sc_hd__fill_1_477 VGND VPWR VPWR sky130_fd_sc_hd__fill_1
* cell instance sky130_fd_sc_hd__fill_1_478 r0 *1 0,0
Xsky130_fd_sc_hd__fill_1_478 VGND VPWR VPWR sky130_fd_sc_hd__fill_1
* cell instance sky130_fd_sc_hd__fill_1_479 r0 *1 0,0
Xsky130_fd_sc_hd__fill_1_479 VGND VPWR VPWR sky130_fd_sc_hd__fill_1
* cell instance sky130_fd_sc_hd__fill_1_480 r0 *1 0,0
Xsky130_fd_sc_hd__fill_1_480 VGND VPWR VPWR sky130_fd_sc_hd__fill_1
* cell instance sky130_fd_sc_hd__fill_1_481 r0 *1 0,0
Xsky130_fd_sc_hd__fill_1_481 VGND VPWR VPWR sky130_fd_sc_hd__fill_1
* cell instance sky130_fd_sc_hd__fill_1_482 r0 *1 0,0
Xsky130_fd_sc_hd__fill_1_482 VGND VPWR VPWR sky130_fd_sc_hd__fill_1
* cell instance sky130_fd_sc_hd__fill_1_483 r0 *1 0,0
Xsky130_fd_sc_hd__fill_1_483 VGND VPWR VPWR sky130_fd_sc_hd__fill_1
* cell instance sky130_fd_sc_hd__fill_1_484 r0 *1 0,0
Xsky130_fd_sc_hd__fill_1_484 VGND VPWR VPWR sky130_fd_sc_hd__fill_1
* cell instance sky130_fd_sc_hd__fill_1_485 r0 *1 0,0
Xsky130_fd_sc_hd__fill_1_485 VGND VPWR VPWR sky130_fd_sc_hd__fill_1
* cell instance sky130_fd_sc_hd__fill_1_486 r0 *1 0,0
Xsky130_fd_sc_hd__fill_1_486 VGND VPWR VPWR sky130_fd_sc_hd__fill_1
* cell instance sky130_fd_sc_hd__fill_1_487 r0 *1 0,0
Xsky130_fd_sc_hd__fill_1_487 VGND VPWR VPWR sky130_fd_sc_hd__fill_1
* cell instance sky130_fd_sc_hd__fill_1_488 r0 *1 0,0
Xsky130_fd_sc_hd__fill_1_488 VGND VPWR VPWR sky130_fd_sc_hd__fill_1
* cell instance sky130_fd_sc_hd__fill_1_489 r0 *1 0,0
Xsky130_fd_sc_hd__fill_1_489 VGND VPWR VPWR sky130_fd_sc_hd__fill_1
* cell instance sky130_fd_sc_hd__fill_1_490 r0 *1 0,0
Xsky130_fd_sc_hd__fill_1_490 VGND VPWR VPWR sky130_fd_sc_hd__fill_1
* cell instance sky130_fd_sc_hd__fill_1_491 r0 *1 0,0
Xsky130_fd_sc_hd__fill_1_491 VGND VPWR VPWR sky130_fd_sc_hd__fill_1
* cell instance sky130_fd_sc_hd__fill_1_492 r0 *1 0,0
Xsky130_fd_sc_hd__fill_1_492 VGND VPWR VPWR sky130_fd_sc_hd__fill_1
* cell instance sky130_fd_sc_hd__fill_1_493 r0 *1 0,0
Xsky130_fd_sc_hd__fill_1_493 VGND VPWR VPWR sky130_fd_sc_hd__fill_1
* cell instance sky130_fd_sc_hd__fill_1_494 r0 *1 0,0
Xsky130_fd_sc_hd__fill_1_494 VGND VPWR VPWR sky130_fd_sc_hd__fill_1
* cell instance sky130_fd_sc_hd__fill_1_495 r0 *1 0,0
Xsky130_fd_sc_hd__fill_1_495 VGND VPWR VPWR sky130_fd_sc_hd__fill_1
* cell instance sky130_fd_sc_hd__fill_1_496 r0 *1 0,0
Xsky130_fd_sc_hd__fill_1_496 VGND VPWR VPWR sky130_fd_sc_hd__fill_1
* cell instance sky130_fd_sc_hd__fill_1_497 r0 *1 0,0
Xsky130_fd_sc_hd__fill_1_497 VGND VPWR VPWR sky130_fd_sc_hd__fill_1
* cell instance sky130_fd_sc_hd__fill_1_498 r0 *1 0,0
Xsky130_fd_sc_hd__fill_1_498 VGND VPWR VPWR sky130_fd_sc_hd__fill_1
* cell instance sky130_fd_sc_hd__fill_1_499 r0 *1 0,0
Xsky130_fd_sc_hd__fill_1_499 VGND VPWR VPWR sky130_fd_sc_hd__fill_1
* cell instance sky130_fd_sc_hd__fill_1_500 r0 *1 0,0
Xsky130_fd_sc_hd__fill_1_500 VGND VPWR VPWR sky130_fd_sc_hd__fill_1
* cell instance sky130_fd_sc_hd__fill_1_501 r0 *1 0,0
Xsky130_fd_sc_hd__fill_1_501 VGND VPWR VPWR sky130_fd_sc_hd__fill_1
* cell instance sky130_fd_sc_hd__fill_1_502 r0 *1 0,0
Xsky130_fd_sc_hd__fill_1_502 VGND VPWR VPWR sky130_fd_sc_hd__fill_1
* cell instance sky130_fd_sc_hd__fill_1_503 r0 *1 0,0
Xsky130_fd_sc_hd__fill_1_503 VGND VPWR VPWR sky130_fd_sc_hd__fill_1
* cell instance sky130_fd_sc_hd__fill_1_504 r0 *1 0,0
Xsky130_fd_sc_hd__fill_1_504 VGND VPWR VPWR sky130_fd_sc_hd__fill_1
* cell instance sky130_fd_sc_hd__fill_1_505 r0 *1 0,0
Xsky130_fd_sc_hd__fill_1_505 VGND VPWR VPWR sky130_fd_sc_hd__fill_1
* cell instance sky130_fd_sc_hd__fill_1_506 r0 *1 0,0
Xsky130_fd_sc_hd__fill_1_506 VGND VPWR VPWR sky130_fd_sc_hd__fill_1
* cell instance sky130_fd_sc_hd__fill_1_507 r0 *1 0,0
Xsky130_fd_sc_hd__fill_1_507 VGND VPWR VPWR sky130_fd_sc_hd__fill_1
* cell instance sky130_fd_sc_hd__fill_1_508 r0 *1 0,0
Xsky130_fd_sc_hd__fill_1_508 VGND VPWR VPWR sky130_fd_sc_hd__fill_1
* cell instance sky130_fd_sc_hd__fill_1_509 r0 *1 0,0
Xsky130_fd_sc_hd__fill_1_509 VGND VPWR VPWR sky130_fd_sc_hd__fill_1
* cell instance sky130_fd_sc_hd__fill_1_510 r0 *1 0,0
Xsky130_fd_sc_hd__fill_1_510 VGND VPWR VPWR sky130_fd_sc_hd__fill_1
* cell instance sky130_fd_sc_hd__fill_1_511 r0 *1 0,0
Xsky130_fd_sc_hd__fill_1_511 VGND VPWR VPWR sky130_fd_sc_hd__fill_1
* cell instance sky130_fd_sc_hd__fill_1_512 r0 *1 0,0
Xsky130_fd_sc_hd__fill_1_512 VGND VPWR VPWR sky130_fd_sc_hd__fill_1
* cell instance sky130_fd_sc_hd__fill_1_513 r0 *1 0,0
Xsky130_fd_sc_hd__fill_1_513 VGND VPWR VPWR sky130_fd_sc_hd__fill_1
* cell instance sky130_fd_sc_hd__fill_1_514 r0 *1 0,0
Xsky130_fd_sc_hd__fill_1_514 VGND VPWR VPWR sky130_fd_sc_hd__fill_1
* cell instance sky130_fd_sc_hd__fill_1_515 r0 *1 0,0
Xsky130_fd_sc_hd__fill_1_515 VGND VPWR VPWR sky130_fd_sc_hd__fill_1
* cell instance sky130_fd_sc_hd__fill_1_516 r0 *1 0,0
Xsky130_fd_sc_hd__fill_1_516 VGND VPWR VPWR sky130_fd_sc_hd__fill_1
* cell instance sky130_fd_sc_hd__fill_1_517 r0 *1 0,0
Xsky130_fd_sc_hd__fill_1_517 VGND VPWR VPWR sky130_fd_sc_hd__fill_1
* cell instance sky130_fd_sc_hd__fill_1_518 r0 *1 0,0
Xsky130_fd_sc_hd__fill_1_518 VGND VPWR VPWR sky130_fd_sc_hd__fill_1
* cell instance sky130_fd_sc_hd__fill_1_519 r0 *1 0,0
Xsky130_fd_sc_hd__fill_1_519 VGND VPWR VPWR sky130_fd_sc_hd__fill_1
* cell instance sky130_fd_sc_hd__fill_1_520 r0 *1 0,0
Xsky130_fd_sc_hd__fill_1_520 VGND VPWR VPWR sky130_fd_sc_hd__fill_1
* cell instance sky130_fd_sc_hd__fill_1_521 r0 *1 0,0
Xsky130_fd_sc_hd__fill_1_521 VGND VPWR VPWR sky130_fd_sc_hd__fill_1
* cell instance sky130_fd_sc_hd__fill_1_522 r0 *1 0,0
Xsky130_fd_sc_hd__fill_1_522 VGND VPWR VPWR sky130_fd_sc_hd__fill_1
* cell instance sky130_fd_sc_hd__fill_1_523 r0 *1 0,0
Xsky130_fd_sc_hd__fill_1_523 VGND VPWR VPWR sky130_fd_sc_hd__fill_1
* cell instance sky130_fd_sc_hd__fill_1_524 r0 *1 0,0
Xsky130_fd_sc_hd__fill_1_524 VGND VPWR VPWR sky130_fd_sc_hd__fill_1
* cell instance sky130_fd_sc_hd__fill_1_525 r0 *1 0,0
Xsky130_fd_sc_hd__fill_1_525 VGND VPWR VPWR sky130_fd_sc_hd__fill_1
* cell instance sky130_fd_sc_hd__fill_1_526 r0 *1 0,0
Xsky130_fd_sc_hd__fill_1_526 VGND VPWR VPWR sky130_fd_sc_hd__fill_1
* cell instance sky130_fd_sc_hd__fill_1_527 r0 *1 0,0
Xsky130_fd_sc_hd__fill_1_527 VGND VPWR VPWR sky130_fd_sc_hd__fill_1
* cell instance sky130_fd_sc_hd__fill_1_528 r0 *1 0,0
Xsky130_fd_sc_hd__fill_1_528 VGND VPWR VPWR sky130_fd_sc_hd__fill_1
* cell instance sky130_fd_sc_hd__fill_1_529 r0 *1 0,0
Xsky130_fd_sc_hd__fill_1_529 VGND VPWR VPWR sky130_fd_sc_hd__fill_1
* cell instance sky130_fd_sc_hd__fill_1_530 r0 *1 0,0
Xsky130_fd_sc_hd__fill_1_530 VGND VPWR VPWR sky130_fd_sc_hd__fill_1
* cell instance sky130_fd_sc_hd__fill_1_531 r0 *1 0,0
Xsky130_fd_sc_hd__fill_1_531 VGND VPWR VPWR sky130_fd_sc_hd__fill_1
* cell instance sky130_fd_sc_hd__fill_1_532 r0 *1 0,0
Xsky130_fd_sc_hd__fill_1_532 VGND VPWR VPWR sky130_fd_sc_hd__fill_1
* cell instance sky130_fd_sc_hd__fill_1_533 r0 *1 0,0
Xsky130_fd_sc_hd__fill_1_533 VGND VPWR VPWR sky130_fd_sc_hd__fill_1
* cell instance sky130_fd_sc_hd__fill_1_534 r0 *1 0,0
Xsky130_fd_sc_hd__fill_1_534 VGND VPWR VPWR sky130_fd_sc_hd__fill_1
* cell instance sky130_fd_sc_hd__fill_1_535 r0 *1 0,0
Xsky130_fd_sc_hd__fill_1_535 VGND VPWR VPWR sky130_fd_sc_hd__fill_1
* cell instance sky130_fd_sc_hd__fill_1_536 r0 *1 0,0
Xsky130_fd_sc_hd__fill_1_536 VGND VPWR VPWR sky130_fd_sc_hd__fill_1
* cell instance sky130_fd_sc_hd__fill_1_537 r0 *1 0,0
Xsky130_fd_sc_hd__fill_1_537 VGND VPWR VPWR sky130_fd_sc_hd__fill_1
* cell instance sky130_fd_sc_hd__fill_1_538 r0 *1 0,0
Xsky130_fd_sc_hd__fill_1_538 VGND VPWR VPWR sky130_fd_sc_hd__fill_1
* cell instance sky130_fd_sc_hd__fill_1_539 r0 *1 0,0
Xsky130_fd_sc_hd__fill_1_539 VGND VPWR VPWR sky130_fd_sc_hd__fill_1
* cell instance sky130_fd_sc_hd__fill_1_540 r0 *1 0,0
Xsky130_fd_sc_hd__fill_1_540 VGND VPWR VPWR sky130_fd_sc_hd__fill_1
* cell instance sky130_fd_sc_hd__fill_1_541 r0 *1 0,0
Xsky130_fd_sc_hd__fill_1_541 VGND VPWR VPWR sky130_fd_sc_hd__fill_1
* cell instance sky130_fd_sc_hd__fill_1_542 r0 *1 0,0
Xsky130_fd_sc_hd__fill_1_542 VGND VPWR VPWR sky130_fd_sc_hd__fill_1
* cell instance sky130_fd_sc_hd__fill_1_543 r0 *1 0,0
Xsky130_fd_sc_hd__fill_1_543 VGND VPWR VPWR sky130_fd_sc_hd__fill_1
* cell instance sky130_fd_sc_hd__fill_1_544 r0 *1 0,0
Xsky130_fd_sc_hd__fill_1_544 VGND VPWR VPWR sky130_fd_sc_hd__fill_1
* cell instance sky130_fd_sc_hd__fill_1_545 r0 *1 0,0
Xsky130_fd_sc_hd__fill_1_545 VGND VPWR VPWR sky130_fd_sc_hd__fill_1
* cell instance sky130_fd_sc_hd__fill_1_546 r0 *1 0,0
Xsky130_fd_sc_hd__fill_1_546 VGND VPWR VPWR sky130_fd_sc_hd__fill_1
* cell instance sky130_fd_sc_hd__fill_1_547 r0 *1 0,0
Xsky130_fd_sc_hd__fill_1_547 VGND VPWR VPWR sky130_fd_sc_hd__fill_1
* cell instance sky130_fd_sc_hd__fill_1_548 r0 *1 0,0
Xsky130_fd_sc_hd__fill_1_548 VGND VPWR VPWR sky130_fd_sc_hd__fill_1
* cell instance sky130_fd_sc_hd__fill_1_549 r0 *1 0,0
Xsky130_fd_sc_hd__fill_1_549 VGND VPWR VPWR sky130_fd_sc_hd__fill_1
* cell instance sky130_fd_sc_hd__fill_1_550 r0 *1 0,0
Xsky130_fd_sc_hd__fill_1_550 VGND VPWR VPWR sky130_fd_sc_hd__fill_1
* cell instance sky130_fd_sc_hd__fill_1_551 r0 *1 0,0
Xsky130_fd_sc_hd__fill_1_551 VGND VPWR VPWR sky130_fd_sc_hd__fill_1
* cell instance sky130_fd_sc_hd__fill_1_552 r0 *1 0,0
Xsky130_fd_sc_hd__fill_1_552 VGND VPWR VPWR sky130_fd_sc_hd__fill_1
* cell instance sky130_fd_sc_hd__fill_1_553 r0 *1 0,0
Xsky130_fd_sc_hd__fill_1_553 VGND VPWR VPWR sky130_fd_sc_hd__fill_1
* cell instance sky130_fd_sc_hd__fill_1_554 r0 *1 0,0
Xsky130_fd_sc_hd__fill_1_554 VGND VPWR VPWR sky130_fd_sc_hd__fill_1
* cell instance sky130_fd_sc_hd__fill_1_555 r0 *1 0,0
Xsky130_fd_sc_hd__fill_1_555 VGND VPWR VPWR sky130_fd_sc_hd__fill_1
* cell instance sky130_fd_sc_hd__fill_1_556 r0 *1 0,0
Xsky130_fd_sc_hd__fill_1_556 VGND VPWR VPWR sky130_fd_sc_hd__fill_1
* cell instance sky130_fd_sc_hd__fill_1_557 r0 *1 0,0
Xsky130_fd_sc_hd__fill_1_557 VGND VPWR VPWR sky130_fd_sc_hd__fill_1
* cell instance sky130_fd_sc_hd__fill_1_558 r0 *1 0,0
Xsky130_fd_sc_hd__fill_1_558 VGND VPWR VPWR sky130_fd_sc_hd__fill_1
* cell instance sky130_fd_sc_hd__fill_1_559 r0 *1 0,0
Xsky130_fd_sc_hd__fill_1_559 VGND VPWR VPWR sky130_fd_sc_hd__fill_1
* cell instance sky130_fd_sc_hd__fill_1_560 r0 *1 0,0
Xsky130_fd_sc_hd__fill_1_560 VGND VPWR VPWR sky130_fd_sc_hd__fill_1
* cell instance sky130_fd_sc_hd__fill_1_561 r0 *1 0,0
Xsky130_fd_sc_hd__fill_1_561 VGND VPWR VPWR sky130_fd_sc_hd__fill_1
* cell instance sky130_fd_sc_hd__fill_1_562 r0 *1 0,0
Xsky130_fd_sc_hd__fill_1_562 VGND VPWR VPWR sky130_fd_sc_hd__fill_1
* cell instance sky130_fd_sc_hd__fill_1_563 r0 *1 0,0
Xsky130_fd_sc_hd__fill_1_563 VGND VPWR VPWR sky130_fd_sc_hd__fill_1
* cell instance sky130_fd_sc_hd__fill_1_564 r0 *1 0,0
Xsky130_fd_sc_hd__fill_1_564 VGND VPWR VPWR sky130_fd_sc_hd__fill_1
* cell instance sky130_fd_sc_hd__fill_1_565 r0 *1 0,0
Xsky130_fd_sc_hd__fill_1_565 VGND VPWR VPWR sky130_fd_sc_hd__fill_1
* cell instance sky130_fd_sc_hd__fill_1_566 r0 *1 0,0
Xsky130_fd_sc_hd__fill_1_566 VGND VPWR VPWR sky130_fd_sc_hd__fill_1
* cell instance sky130_fd_sc_hd__fill_1_567 r0 *1 0,0
Xsky130_fd_sc_hd__fill_1_567 VGND VPWR VPWR sky130_fd_sc_hd__fill_1
* cell instance sky130_fd_sc_hd__fill_1_568 r0 *1 0,0
Xsky130_fd_sc_hd__fill_1_568 VGND VPWR VPWR sky130_fd_sc_hd__fill_1
* cell instance sky130_fd_sc_hd__fill_1_569 r0 *1 0,0
Xsky130_fd_sc_hd__fill_1_569 VGND VPWR VPWR sky130_fd_sc_hd__fill_1
* cell instance sky130_fd_sc_hd__fill_1_570 r0 *1 0,0
Xsky130_fd_sc_hd__fill_1_570 VGND VPWR VPWR sky130_fd_sc_hd__fill_1
* cell instance sky130_fd_sc_hd__fill_1_571 r0 *1 0,0
Xsky130_fd_sc_hd__fill_1_571 VGND VPWR VPWR sky130_fd_sc_hd__fill_1
* cell instance sky130_fd_sc_hd__fill_1_572 r0 *1 0,0
Xsky130_fd_sc_hd__fill_1_572 VGND VPWR VPWR sky130_fd_sc_hd__fill_1
* cell instance sky130_fd_sc_hd__fill_1_573 r0 *1 0,0
Xsky130_fd_sc_hd__fill_1_573 VGND VPWR VPWR sky130_fd_sc_hd__fill_1
* cell instance sky130_fd_sc_hd__fill_1_574 r0 *1 0,0
Xsky130_fd_sc_hd__fill_1_574 VGND VPWR VPWR sky130_fd_sc_hd__fill_1
* cell instance sky130_fd_sc_hd__fill_1_575 r0 *1 0,0
Xsky130_fd_sc_hd__fill_1_575 VGND VPWR VPWR sky130_fd_sc_hd__fill_1
* cell instance sky130_fd_sc_hd__fill_1_576 r0 *1 0,0
Xsky130_fd_sc_hd__fill_1_576 VGND VPWR VPWR sky130_fd_sc_hd__fill_1
* cell instance sky130_fd_sc_hd__fill_1_577 r0 *1 0,0
Xsky130_fd_sc_hd__fill_1_577 VGND VPWR VPWR sky130_fd_sc_hd__fill_1
* cell instance sky130_fd_sc_hd__fill_1_578 r0 *1 0,0
Xsky130_fd_sc_hd__fill_1_578 VGND VPWR VPWR sky130_fd_sc_hd__fill_1
* cell instance sky130_fd_sc_hd__fill_1_579 r0 *1 0,0
Xsky130_fd_sc_hd__fill_1_579 VGND VPWR VPWR sky130_fd_sc_hd__fill_1
* cell instance sky130_fd_sc_hd__fill_1_580 r0 *1 0,0
Xsky130_fd_sc_hd__fill_1_580 VGND VPWR VPWR sky130_fd_sc_hd__fill_1
* cell instance sky130_fd_sc_hd__fill_1_581 r0 *1 0,0
Xsky130_fd_sc_hd__fill_1_581 VGND VPWR VPWR sky130_fd_sc_hd__fill_1
* cell instance sky130_fd_sc_hd__fill_1_582 r0 *1 0,0
Xsky130_fd_sc_hd__fill_1_582 VGND VPWR VPWR sky130_fd_sc_hd__fill_1
* cell instance sky130_fd_sc_hd__fill_1_583 r0 *1 0,0
Xsky130_fd_sc_hd__fill_1_583 VGND VPWR VPWR sky130_fd_sc_hd__fill_1
* cell instance sky130_fd_sc_hd__fill_1_584 r0 *1 0,0
Xsky130_fd_sc_hd__fill_1_584 VGND VPWR VPWR sky130_fd_sc_hd__fill_1
* cell instance sky130_fd_sc_hd__fill_1_585 r0 *1 0,0
Xsky130_fd_sc_hd__fill_1_585 VGND VPWR VPWR sky130_fd_sc_hd__fill_1
* cell instance sky130_fd_sc_hd__fill_1_586 r0 *1 0,0
Xsky130_fd_sc_hd__fill_1_586 VGND VPWR VPWR sky130_fd_sc_hd__fill_1
* cell instance sky130_fd_sc_hd__fill_1_587 r0 *1 0,0
Xsky130_fd_sc_hd__fill_1_587 VGND VPWR VPWR sky130_fd_sc_hd__fill_1
* cell instance sky130_fd_sc_hd__fill_1_588 r0 *1 0,0
Xsky130_fd_sc_hd__fill_1_588 VGND VPWR VPWR sky130_fd_sc_hd__fill_1
* cell instance sky130_fd_sc_hd__fill_1_589 r0 *1 0,0
Xsky130_fd_sc_hd__fill_1_589 VGND VPWR VPWR sky130_fd_sc_hd__fill_1
* cell instance sky130_fd_sc_hd__fill_1_590 r0 *1 0,0
Xsky130_fd_sc_hd__fill_1_590 VGND VPWR VPWR sky130_fd_sc_hd__fill_1
* cell instance sky130_fd_sc_hd__fill_1_591 r0 *1 0,0
Xsky130_fd_sc_hd__fill_1_591 VGND VPWR VPWR sky130_fd_sc_hd__fill_1
* cell instance sky130_fd_sc_hd__fill_1_592 r0 *1 0,0
Xsky130_fd_sc_hd__fill_1_592 VGND VPWR VPWR sky130_fd_sc_hd__fill_1
* cell instance sky130_fd_sc_hd__fill_1_593 r0 *1 0,0
Xsky130_fd_sc_hd__fill_1_593 VGND VPWR VPWR sky130_fd_sc_hd__fill_1
* cell instance sky130_fd_sc_hd__fill_1_594 r0 *1 0,0
Xsky130_fd_sc_hd__fill_1_594 VGND VPWR VPWR sky130_fd_sc_hd__fill_1
* cell instance sky130_fd_sc_hd__fill_1_595 r0 *1 0,0
Xsky130_fd_sc_hd__fill_1_595 VGND VPWR VPWR sky130_fd_sc_hd__fill_1
* cell instance sky130_fd_sc_hd__fill_1_596 r0 *1 0,0
Xsky130_fd_sc_hd__fill_1_596 VGND VPWR VPWR sky130_fd_sc_hd__fill_1
* cell instance sky130_fd_sc_hd__fill_1_597 r0 *1 0,0
Xsky130_fd_sc_hd__fill_1_597 VGND VPWR VPWR sky130_fd_sc_hd__fill_1
* cell instance sky130_fd_sc_hd__fill_1_598 r0 *1 0,0
Xsky130_fd_sc_hd__fill_1_598 VGND VPWR VPWR sky130_fd_sc_hd__fill_1
* cell instance sky130_fd_sc_hd__fill_1_599 r0 *1 0,0
Xsky130_fd_sc_hd__fill_1_599 VGND VPWR VPWR sky130_fd_sc_hd__fill_1
* cell instance sky130_fd_sc_hd__fill_1_600 r0 *1 0,0
Xsky130_fd_sc_hd__fill_1_600 VGND VPWR VPWR sky130_fd_sc_hd__fill_1
* cell instance sky130_fd_sc_hd__fill_1_601 r0 *1 0,0
Xsky130_fd_sc_hd__fill_1_601 VGND VPWR VPWR sky130_fd_sc_hd__fill_1
* cell instance sky130_fd_sc_hd__fill_1_602 r0 *1 0,0
Xsky130_fd_sc_hd__fill_1_602 VGND VPWR VPWR sky130_fd_sc_hd__fill_1
* cell instance sky130_fd_sc_hd__fill_1_603 r0 *1 0,0
Xsky130_fd_sc_hd__fill_1_603 VGND VPWR VPWR sky130_fd_sc_hd__fill_1
* cell instance sky130_fd_sc_hd__fill_1_604 r0 *1 0,0
Xsky130_fd_sc_hd__fill_1_604 VGND VPWR VPWR sky130_fd_sc_hd__fill_1
* cell instance sky130_fd_sc_hd__fill_1_605 r0 *1 0,0
Xsky130_fd_sc_hd__fill_1_605 VGND VPWR VPWR sky130_fd_sc_hd__fill_1
* cell instance sky130_fd_sc_hd__fill_1_606 r0 *1 0,0
Xsky130_fd_sc_hd__fill_1_606 VGND VPWR VPWR sky130_fd_sc_hd__fill_1
* cell instance sky130_fd_sc_hd__fill_1_607 r0 *1 0,0
Xsky130_fd_sc_hd__fill_1_607 VGND VPWR VPWR sky130_fd_sc_hd__fill_1
* cell instance sky130_fd_sc_hd__fill_1_608 r0 *1 0,0
Xsky130_fd_sc_hd__fill_1_608 VGND VPWR VPWR sky130_fd_sc_hd__fill_1
* cell instance sky130_fd_sc_hd__fill_1_609 r0 *1 0,0
Xsky130_fd_sc_hd__fill_1_609 VGND VPWR VPWR sky130_fd_sc_hd__fill_1
* cell instance sky130_fd_sc_hd__fill_1_610 r0 *1 0,0
Xsky130_fd_sc_hd__fill_1_610 VGND VPWR VPWR sky130_fd_sc_hd__fill_1
* cell instance sky130_fd_sc_hd__fill_1_611 r0 *1 0,0
Xsky130_fd_sc_hd__fill_1_611 VGND VPWR VPWR sky130_fd_sc_hd__fill_1
* cell instance sky130_fd_sc_hd__fill_1_612 r0 *1 0,0
Xsky130_fd_sc_hd__fill_1_612 VGND VPWR VPWR sky130_fd_sc_hd__fill_1
* cell instance sky130_fd_sc_hd__fill_1_613 r0 *1 0,0
Xsky130_fd_sc_hd__fill_1_613 VGND VPWR VPWR sky130_fd_sc_hd__fill_1
* cell instance sky130_fd_sc_hd__fill_1_614 r0 *1 0,0
Xsky130_fd_sc_hd__fill_1_614 VGND VPWR VPWR sky130_fd_sc_hd__fill_1
* cell instance sky130_fd_sc_hd__fill_1_615 r0 *1 0,0
Xsky130_fd_sc_hd__fill_1_615 VGND VPWR VPWR sky130_fd_sc_hd__fill_1
* cell instance sky130_fd_sc_hd__fill_1_616 r0 *1 0,0
Xsky130_fd_sc_hd__fill_1_616 VGND VPWR VPWR sky130_fd_sc_hd__fill_1
* cell instance sky130_fd_sc_hd__fill_1_617 r0 *1 0,0
Xsky130_fd_sc_hd__fill_1_617 VGND VPWR VPWR sky130_fd_sc_hd__fill_1
* cell instance sky130_fd_sc_hd__fill_1_618 r0 *1 0,0
Xsky130_fd_sc_hd__fill_1_618 VGND VPWR VPWR sky130_fd_sc_hd__fill_1
* cell instance sky130_fd_sc_hd__fill_1_619 r0 *1 0,0
Xsky130_fd_sc_hd__fill_1_619 VGND VPWR VPWR sky130_fd_sc_hd__fill_1
* cell instance sky130_fd_sc_hd__fill_1_620 r0 *1 0,0
Xsky130_fd_sc_hd__fill_1_620 VGND VPWR VPWR sky130_fd_sc_hd__fill_1
* cell instance sky130_fd_sc_hd__fill_1_621 r0 *1 0,0
Xsky130_fd_sc_hd__fill_1_621 VGND VPWR VPWR sky130_fd_sc_hd__fill_1
* cell instance sky130_fd_sc_hd__fill_1_622 r0 *1 0,0
Xsky130_fd_sc_hd__fill_1_622 VGND VPWR VPWR sky130_fd_sc_hd__fill_1
* cell instance sky130_fd_sc_hd__fill_1_623 r0 *1 0,0
Xsky130_fd_sc_hd__fill_1_623 VGND VPWR VPWR sky130_fd_sc_hd__fill_1
* cell instance sky130_fd_sc_hd__fill_1_624 r0 *1 0,0
Xsky130_fd_sc_hd__fill_1_624 VGND VPWR VPWR sky130_fd_sc_hd__fill_1
* cell instance sky130_fd_sc_hd__fill_1_625 r0 *1 0,0
Xsky130_fd_sc_hd__fill_1_625 VGND VPWR VPWR sky130_fd_sc_hd__fill_1
* cell instance sky130_fd_sc_hd__fill_1_626 r0 *1 0,0
Xsky130_fd_sc_hd__fill_1_626 VGND VPWR VPWR sky130_fd_sc_hd__fill_1
* cell instance sky130_fd_sc_hd__fill_1_627 r0 *1 0,0
Xsky130_fd_sc_hd__fill_1_627 VGND VPWR VPWR sky130_fd_sc_hd__fill_1
* cell instance sky130_fd_sc_hd__fill_1_628 r0 *1 0,0
Xsky130_fd_sc_hd__fill_1_628 VGND VPWR VPWR sky130_fd_sc_hd__fill_1
* cell instance sky130_fd_sc_hd__fill_1_629 r0 *1 0,0
Xsky130_fd_sc_hd__fill_1_629 VGND VPWR VPWR sky130_fd_sc_hd__fill_1
* cell instance sky130_fd_sc_hd__fill_1_630 r0 *1 0,0
Xsky130_fd_sc_hd__fill_1_630 VGND VPWR VPWR sky130_fd_sc_hd__fill_1
* cell instance sky130_fd_sc_hd__fill_1_631 r0 *1 0,0
Xsky130_fd_sc_hd__fill_1_631 VGND VPWR VPWR sky130_fd_sc_hd__fill_1
* cell instance sky130_fd_sc_hd__fill_1_632 r0 *1 0,0
Xsky130_fd_sc_hd__fill_1_632 VGND VPWR VPWR sky130_fd_sc_hd__fill_1
* cell instance sky130_fd_sc_hd__fill_1_633 r0 *1 0,0
Xsky130_fd_sc_hd__fill_1_633 VGND VPWR VPWR sky130_fd_sc_hd__fill_1
* cell instance sky130_fd_sc_hd__fill_1_634 r0 *1 0,0
Xsky130_fd_sc_hd__fill_1_634 VGND VPWR VPWR sky130_fd_sc_hd__fill_1
* cell instance sky130_fd_sc_hd__fill_1_635 r0 *1 0,0
Xsky130_fd_sc_hd__fill_1_635 VGND VPWR VPWR sky130_fd_sc_hd__fill_1
* cell instance sky130_fd_sc_hd__fill_1_636 r0 *1 0,0
Xsky130_fd_sc_hd__fill_1_636 VGND VPWR VPWR sky130_fd_sc_hd__fill_1
* cell instance sky130_fd_sc_hd__fill_1_637 r0 *1 0,0
Xsky130_fd_sc_hd__fill_1_637 VGND VPWR VPWR sky130_fd_sc_hd__fill_1
* cell instance sky130_fd_sc_hd__fill_1_638 r0 *1 0,0
Xsky130_fd_sc_hd__fill_1_638 VGND VPWR VPWR sky130_fd_sc_hd__fill_1
* cell instance sky130_fd_sc_hd__fill_1_639 r0 *1 0,0
Xsky130_fd_sc_hd__fill_1_639 VGND VPWR VPWR sky130_fd_sc_hd__fill_1
* cell instance sky130_fd_sc_hd__fill_1_640 r0 *1 0,0
Xsky130_fd_sc_hd__fill_1_640 VGND VPWR VPWR sky130_fd_sc_hd__fill_1
* cell instance sky130_fd_sc_hd__fill_1_641 r0 *1 0,0
Xsky130_fd_sc_hd__fill_1_641 VGND VPWR VPWR sky130_fd_sc_hd__fill_1
* cell instance sky130_fd_sc_hd__fill_1_642 r0 *1 0,0
Xsky130_fd_sc_hd__fill_1_642 VGND VPWR VPWR sky130_fd_sc_hd__fill_1
* cell instance sky130_fd_sc_hd__fill_1_643 r0 *1 0,0
Xsky130_fd_sc_hd__fill_1_643 VGND VPWR VPWR sky130_fd_sc_hd__fill_1
* cell instance sky130_fd_sc_hd__fill_1_644 r0 *1 0,0
Xsky130_fd_sc_hd__fill_1_644 VGND VPWR VPWR sky130_fd_sc_hd__fill_1
* cell instance sky130_fd_sc_hd__fill_1_645 r0 *1 0,0
Xsky130_fd_sc_hd__fill_1_645 VGND VPWR VPWR sky130_fd_sc_hd__fill_1
* cell instance sky130_fd_sc_hd__fill_1_646 r0 *1 0,0
Xsky130_fd_sc_hd__fill_1_646 VGND VPWR VPWR sky130_fd_sc_hd__fill_1
* cell instance sky130_fd_sc_hd__fill_1_647 r0 *1 0,0
Xsky130_fd_sc_hd__fill_1_647 VGND VPWR VPWR sky130_fd_sc_hd__fill_1
* cell instance sky130_fd_sc_hd__fill_1_648 r0 *1 0,0
Xsky130_fd_sc_hd__fill_1_648 VGND VPWR VPWR sky130_fd_sc_hd__fill_1
* cell instance sky130_fd_sc_hd__fill_1_649 r0 *1 0,0
Xsky130_fd_sc_hd__fill_1_649 VGND VPWR VPWR sky130_fd_sc_hd__fill_1
* cell instance sky130_fd_sc_hd__fill_1_650 r0 *1 0,0
Xsky130_fd_sc_hd__fill_1_650 VGND VPWR VPWR sky130_fd_sc_hd__fill_1
* cell instance sky130_fd_sc_hd__fill_1_651 r0 *1 0,0
Xsky130_fd_sc_hd__fill_1_651 VGND VPWR VPWR sky130_fd_sc_hd__fill_1
* cell instance sky130_fd_sc_hd__fill_1_652 r0 *1 0,0
Xsky130_fd_sc_hd__fill_1_652 VGND VPWR VPWR sky130_fd_sc_hd__fill_1
* cell instance sky130_fd_sc_hd__fill_1_653 r0 *1 0,0
Xsky130_fd_sc_hd__fill_1_653 VGND VPWR VPWR sky130_fd_sc_hd__fill_1
* cell instance sky130_fd_sc_hd__fill_1_654 r0 *1 0,0
Xsky130_fd_sc_hd__fill_1_654 VGND VPWR VPWR sky130_fd_sc_hd__fill_1
* cell instance sky130_fd_sc_hd__fill_1_655 r0 *1 0,0
Xsky130_fd_sc_hd__fill_1_655 VGND VPWR VPWR sky130_fd_sc_hd__fill_1
* cell instance sky130_fd_sc_hd__fill_1_656 r0 *1 0,0
Xsky130_fd_sc_hd__fill_1_656 VGND VPWR VPWR sky130_fd_sc_hd__fill_1
* cell instance sky130_fd_sc_hd__fill_1_657 r0 *1 0,0
Xsky130_fd_sc_hd__fill_1_657 VGND VPWR VPWR sky130_fd_sc_hd__fill_1
* cell instance sky130_fd_sc_hd__fill_1_658 r0 *1 0,0
Xsky130_fd_sc_hd__fill_1_658 VGND VPWR VPWR sky130_fd_sc_hd__fill_1
* cell instance sky130_fd_sc_hd__fill_1_659 r0 *1 0,0
Xsky130_fd_sc_hd__fill_1_659 VGND VPWR VPWR sky130_fd_sc_hd__fill_1
* cell instance sky130_fd_sc_hd__fill_1_660 r0 *1 0,0
Xsky130_fd_sc_hd__fill_1_660 VGND VPWR VPWR sky130_fd_sc_hd__fill_1
* cell instance sky130_fd_sc_hd__fill_1_661 r0 *1 0,0
Xsky130_fd_sc_hd__fill_1_661 VGND VPWR VPWR sky130_fd_sc_hd__fill_1
* cell instance sky130_fd_sc_hd__fill_1_662 r0 *1 0,0
Xsky130_fd_sc_hd__fill_1_662 VGND VPWR VPWR sky130_fd_sc_hd__fill_1
* cell instance sky130_fd_sc_hd__fill_1_663 r0 *1 0,0
Xsky130_fd_sc_hd__fill_1_663 VGND VPWR VPWR sky130_fd_sc_hd__fill_1
* cell instance sky130_fd_sc_hd__fill_1_664 r0 *1 0,0
Xsky130_fd_sc_hd__fill_1_664 VGND VPWR VPWR sky130_fd_sc_hd__fill_1
* cell instance sky130_fd_sc_hd__fill_1_665 r0 *1 0,0
Xsky130_fd_sc_hd__fill_1_665 VGND VPWR VPWR sky130_fd_sc_hd__fill_1
* cell instance sky130_fd_sc_hd__fill_1_666 r0 *1 0,0
Xsky130_fd_sc_hd__fill_1_666 VGND VPWR VPWR sky130_fd_sc_hd__fill_1
* cell instance sky130_fd_sc_hd__fill_1_667 r0 *1 0,0
Xsky130_fd_sc_hd__fill_1_667 VGND VPWR VPWR sky130_fd_sc_hd__fill_1
* cell instance sky130_fd_sc_hd__fill_1_668 r0 *1 0,0
Xsky130_fd_sc_hd__fill_1_668 VGND VPWR VPWR sky130_fd_sc_hd__fill_1
* cell instance sky130_fd_sc_hd__fill_1_669 r0 *1 0,0
Xsky130_fd_sc_hd__fill_1_669 VGND VPWR VPWR sky130_fd_sc_hd__fill_1
* cell instance sky130_fd_sc_hd__fill_1_670 r0 *1 0,0
Xsky130_fd_sc_hd__fill_1_670 VGND VPWR VPWR sky130_fd_sc_hd__fill_1
* cell instance sky130_fd_sc_hd__fill_1_671 r0 *1 0,0
Xsky130_fd_sc_hd__fill_1_671 VGND VPWR VPWR sky130_fd_sc_hd__fill_1
* cell instance sky130_fd_sc_hd__fill_1_672 r0 *1 0,0
Xsky130_fd_sc_hd__fill_1_672 VGND VPWR VPWR sky130_fd_sc_hd__fill_1
* cell instance sky130_fd_sc_hd__fill_1_673 r0 *1 0,0
Xsky130_fd_sc_hd__fill_1_673 VGND VPWR VPWR sky130_fd_sc_hd__fill_1
* cell instance sky130_fd_sc_hd__fill_1_674 r0 *1 0,0
Xsky130_fd_sc_hd__fill_1_674 VGND VPWR VPWR sky130_fd_sc_hd__fill_1
* cell instance sky130_fd_sc_hd__fill_1_675 r0 *1 0,0
Xsky130_fd_sc_hd__fill_1_675 VGND VPWR VPWR sky130_fd_sc_hd__fill_1
* cell instance sky130_fd_sc_hd__fill_1_676 r0 *1 0,0
Xsky130_fd_sc_hd__fill_1_676 VGND VPWR VPWR sky130_fd_sc_hd__fill_1
* cell instance sky130_fd_sc_hd__fill_1_677 r0 *1 0,0
Xsky130_fd_sc_hd__fill_1_677 VGND VPWR VPWR sky130_fd_sc_hd__fill_1
* cell instance sky130_fd_sc_hd__fill_1_678 r0 *1 0,0
Xsky130_fd_sc_hd__fill_1_678 VGND VPWR VPWR sky130_fd_sc_hd__fill_1
* cell instance sky130_fd_sc_hd__fill_1_679 r0 *1 0,0
Xsky130_fd_sc_hd__fill_1_679 VGND VPWR VPWR sky130_fd_sc_hd__fill_1
* cell instance sky130_fd_sc_hd__fill_1_680 r0 *1 0,0
Xsky130_fd_sc_hd__fill_1_680 VGND VPWR VPWR sky130_fd_sc_hd__fill_1
* cell instance sky130_fd_sc_hd__fill_1_681 r0 *1 0,0
Xsky130_fd_sc_hd__fill_1_681 VGND VPWR VPWR sky130_fd_sc_hd__fill_1
* cell instance sky130_fd_sc_hd__fill_1_682 r0 *1 0,0
Xsky130_fd_sc_hd__fill_1_682 VGND VPWR VPWR sky130_fd_sc_hd__fill_1
* cell instance sky130_fd_sc_hd__fill_1_683 r0 *1 0,0
Xsky130_fd_sc_hd__fill_1_683 VGND VPWR VPWR sky130_fd_sc_hd__fill_1
* cell instance sky130_fd_sc_hd__fill_1_684 r0 *1 0,0
Xsky130_fd_sc_hd__fill_1_684 VGND VPWR VPWR sky130_fd_sc_hd__fill_1
* cell instance sky130_fd_sc_hd__fill_1_685 r0 *1 0,0
Xsky130_fd_sc_hd__fill_1_685 VGND VPWR VPWR sky130_fd_sc_hd__fill_1
* cell instance sky130_fd_sc_hd__fill_1_686 r0 *1 0,0
Xsky130_fd_sc_hd__fill_1_686 VGND VPWR VPWR sky130_fd_sc_hd__fill_1
* cell instance sky130_fd_sc_hd__fill_1_687 r0 *1 0,0
Xsky130_fd_sc_hd__fill_1_687 VGND VPWR VPWR sky130_fd_sc_hd__fill_1
* cell instance sky130_fd_sc_hd__fill_1_688 r0 *1 0,0
Xsky130_fd_sc_hd__fill_1_688 VGND VPWR VPWR sky130_fd_sc_hd__fill_1
* cell instance sky130_fd_sc_hd__fill_1_689 r0 *1 0,0
Xsky130_fd_sc_hd__fill_1_689 VGND VPWR VPWR sky130_fd_sc_hd__fill_1
* cell instance sky130_fd_sc_hd__fill_1_690 r0 *1 0,0
Xsky130_fd_sc_hd__fill_1_690 VGND VPWR VPWR sky130_fd_sc_hd__fill_1
* cell instance sky130_fd_sc_hd__fill_1_691 r0 *1 0,0
Xsky130_fd_sc_hd__fill_1_691 VGND VPWR VPWR sky130_fd_sc_hd__fill_1
* cell instance sky130_fd_sc_hd__fill_1_692 r0 *1 0,0
Xsky130_fd_sc_hd__fill_1_692 VGND VPWR VPWR sky130_fd_sc_hd__fill_1
* cell instance sky130_fd_sc_hd__fill_1_693 r0 *1 0,0
Xsky130_fd_sc_hd__fill_1_693 VGND VPWR VPWR sky130_fd_sc_hd__fill_1
* cell instance sky130_fd_sc_hd__fill_1_694 r0 *1 0,0
Xsky130_fd_sc_hd__fill_1_694 VGND VPWR VPWR sky130_fd_sc_hd__fill_1
* cell instance sky130_fd_sc_hd__fill_1_695 r0 *1 0,0
Xsky130_fd_sc_hd__fill_1_695 VGND VPWR VPWR sky130_fd_sc_hd__fill_1
* cell instance sky130_fd_sc_hd__fill_1_696 r0 *1 0,0
Xsky130_fd_sc_hd__fill_1_696 VGND VPWR VPWR sky130_fd_sc_hd__fill_1
* cell instance sky130_fd_sc_hd__fill_1_697 r0 *1 0,0
Xsky130_fd_sc_hd__fill_1_697 VGND VPWR VPWR sky130_fd_sc_hd__fill_1
* cell instance sky130_fd_sc_hd__fill_1_698 r0 *1 0,0
Xsky130_fd_sc_hd__fill_1_698 VGND VPWR VPWR sky130_fd_sc_hd__fill_1
* cell instance sky130_fd_sc_hd__fill_1_699 r0 *1 0,0
Xsky130_fd_sc_hd__fill_1_699 VGND VPWR VPWR sky130_fd_sc_hd__fill_1
* cell instance sky130_fd_sc_hd__fill_1_700 r0 *1 0,0
Xsky130_fd_sc_hd__fill_1_700 VGND VPWR VPWR sky130_fd_sc_hd__fill_1
* cell instance sky130_fd_sc_hd__fill_1_701 r0 *1 0,0
Xsky130_fd_sc_hd__fill_1_701 VGND VPWR VPWR sky130_fd_sc_hd__fill_1
* cell instance sky130_fd_sc_hd__fill_1_702 r0 *1 0,0
Xsky130_fd_sc_hd__fill_1_702 VGND VPWR VPWR sky130_fd_sc_hd__fill_1
* cell instance sky130_fd_sc_hd__fill_1_703 r0 *1 0,0
Xsky130_fd_sc_hd__fill_1_703 VGND VPWR VPWR sky130_fd_sc_hd__fill_1
* cell instance sky130_fd_sc_hd__fill_1_704 r0 *1 0,0
Xsky130_fd_sc_hd__fill_1_704 VGND VPWR VPWR sky130_fd_sc_hd__fill_1
* cell instance sky130_fd_sc_hd__fill_1_705 r0 *1 0,0
Xsky130_fd_sc_hd__fill_1_705 VGND VPWR VPWR sky130_fd_sc_hd__fill_1
* cell instance sky130_fd_sc_hd__fill_1_706 r0 *1 0,0
Xsky130_fd_sc_hd__fill_1_706 VGND VPWR VPWR sky130_fd_sc_hd__fill_1
* cell instance sky130_fd_sc_hd__fill_1_707 r0 *1 0,0
Xsky130_fd_sc_hd__fill_1_707 VGND VPWR VPWR sky130_fd_sc_hd__fill_1
* cell instance sky130_fd_sc_hd__fill_1_708 r0 *1 0,0
Xsky130_fd_sc_hd__fill_1_708 VGND VPWR VPWR sky130_fd_sc_hd__fill_1
* cell instance sky130_fd_sc_hd__fill_1_709 r0 *1 0,0
Xsky130_fd_sc_hd__fill_1_709 VGND VPWR VPWR sky130_fd_sc_hd__fill_1
* cell instance sky130_fd_sc_hd__fill_1_710 r0 *1 0,0
Xsky130_fd_sc_hd__fill_1_710 VGND VPWR VPWR sky130_fd_sc_hd__fill_1
* cell instance sky130_fd_sc_hd__fill_1_711 r0 *1 0,0
Xsky130_fd_sc_hd__fill_1_711 VGND VPWR VPWR sky130_fd_sc_hd__fill_1
* cell instance sky130_fd_sc_hd__fill_1_712 r0 *1 0,0
Xsky130_fd_sc_hd__fill_1_712 VGND VPWR VPWR sky130_fd_sc_hd__fill_1
* cell instance sky130_fd_sc_hd__fill_1_713 r0 *1 0,0
Xsky130_fd_sc_hd__fill_1_713 VGND VPWR VPWR sky130_fd_sc_hd__fill_1
* cell instance sky130_fd_sc_hd__fill_1_714 r0 *1 0,0
Xsky130_fd_sc_hd__fill_1_714 VGND VPWR VPWR sky130_fd_sc_hd__fill_1
* cell instance sky130_fd_sc_hd__fill_1_715 r0 *1 0,0
Xsky130_fd_sc_hd__fill_1_715 VGND VPWR VPWR sky130_fd_sc_hd__fill_1
* cell instance sky130_fd_sc_hd__fill_1_716 r0 *1 0,0
Xsky130_fd_sc_hd__fill_1_716 VGND VPWR VPWR sky130_fd_sc_hd__fill_1
* cell instance sky130_fd_sc_hd__fill_1_717 r0 *1 0,0
Xsky130_fd_sc_hd__fill_1_717 VGND VPWR VPWR sky130_fd_sc_hd__fill_1
* cell instance sky130_fd_sc_hd__fill_1_718 r0 *1 0,0
Xsky130_fd_sc_hd__fill_1_718 VGND VPWR VPWR sky130_fd_sc_hd__fill_1
* cell instance sky130_fd_sc_hd__fill_1_719 r0 *1 0,0
Xsky130_fd_sc_hd__fill_1_719 VGND VPWR VPWR sky130_fd_sc_hd__fill_1
* cell instance sky130_fd_sc_hd__fill_1_720 r0 *1 0,0
Xsky130_fd_sc_hd__fill_1_720 VGND VPWR VPWR sky130_fd_sc_hd__fill_1
* cell instance sky130_fd_sc_hd__fill_1_721 r0 *1 0,0
Xsky130_fd_sc_hd__fill_1_721 VGND VPWR VPWR sky130_fd_sc_hd__fill_1
* cell instance sky130_fd_sc_hd__fill_1_722 r0 *1 0,0
Xsky130_fd_sc_hd__fill_1_722 VGND VPWR VPWR sky130_fd_sc_hd__fill_1
* cell instance sky130_fd_sc_hd__fill_1_723 r0 *1 0,0
Xsky130_fd_sc_hd__fill_1_723 VGND VPWR VPWR sky130_fd_sc_hd__fill_1
* cell instance sky130_fd_sc_hd__fill_1_724 r0 *1 0,0
Xsky130_fd_sc_hd__fill_1_724 VGND VPWR VPWR sky130_fd_sc_hd__fill_1
* cell instance sky130_fd_sc_hd__fill_1_725 r0 *1 0,0
Xsky130_fd_sc_hd__fill_1_725 VGND VPWR VPWR sky130_fd_sc_hd__fill_1
* cell instance sky130_fd_sc_hd__fill_1_726 r0 *1 0,0
Xsky130_fd_sc_hd__fill_1_726 VGND VPWR VPWR sky130_fd_sc_hd__fill_1
* cell instance sky130_fd_sc_hd__fill_1_727 r0 *1 0,0
Xsky130_fd_sc_hd__fill_1_727 VGND VPWR VPWR sky130_fd_sc_hd__fill_1
* cell instance sky130_fd_sc_hd__fill_1_728 r0 *1 0,0
Xsky130_fd_sc_hd__fill_1_728 VGND VPWR VPWR sky130_fd_sc_hd__fill_1
* cell instance sky130_fd_sc_hd__fill_1_729 r0 *1 0,0
Xsky130_fd_sc_hd__fill_1_729 VGND VPWR VPWR sky130_fd_sc_hd__fill_1
* cell instance sky130_fd_sc_hd__fill_1_730 r0 *1 0,0
Xsky130_fd_sc_hd__fill_1_730 VGND VPWR VPWR sky130_fd_sc_hd__fill_1
* cell instance sky130_fd_sc_hd__fill_1_731 r0 *1 0,0
Xsky130_fd_sc_hd__fill_1_731 VGND VPWR VPWR sky130_fd_sc_hd__fill_1
* cell instance sky130_fd_sc_hd__fill_1_732 r0 *1 0,0
Xsky130_fd_sc_hd__fill_1_732 VGND VPWR VPWR sky130_fd_sc_hd__fill_1
* cell instance sky130_fd_sc_hd__fill_1_733 r0 *1 0,0
Xsky130_fd_sc_hd__fill_1_733 VGND VPWR VPWR sky130_fd_sc_hd__fill_1
* cell instance sky130_fd_sc_hd__fill_1_734 r0 *1 0,0
Xsky130_fd_sc_hd__fill_1_734 VGND VPWR VPWR sky130_fd_sc_hd__fill_1
* cell instance sky130_fd_sc_hd__fill_1_735 r0 *1 0,0
Xsky130_fd_sc_hd__fill_1_735 VGND VPWR VPWR sky130_fd_sc_hd__fill_1
* cell instance sky130_fd_sc_hd__fill_1_736 r0 *1 0,0
Xsky130_fd_sc_hd__fill_1_736 VGND VPWR VPWR sky130_fd_sc_hd__fill_1
* cell instance sky130_fd_sc_hd__fill_1_737 r0 *1 0,0
Xsky130_fd_sc_hd__fill_1_737 VGND VPWR VPWR sky130_fd_sc_hd__fill_1
* cell instance sky130_fd_sc_hd__fill_1_738 r0 *1 0,0
Xsky130_fd_sc_hd__fill_1_738 VGND VPWR VPWR sky130_fd_sc_hd__fill_1
* cell instance sky130_fd_sc_hd__fill_1_739 r0 *1 0,0
Xsky130_fd_sc_hd__fill_1_739 VGND VPWR VPWR sky130_fd_sc_hd__fill_1
* cell instance sky130_fd_sc_hd__fill_1_740 r0 *1 0,0
Xsky130_fd_sc_hd__fill_1_740 VGND VPWR VPWR sky130_fd_sc_hd__fill_1
* cell instance sky130_fd_sc_hd__fill_1_741 r0 *1 0,0
Xsky130_fd_sc_hd__fill_1_741 VGND VPWR VPWR sky130_fd_sc_hd__fill_1
* cell instance sky130_fd_sc_hd__fill_1_742 r0 *1 0,0
Xsky130_fd_sc_hd__fill_1_742 VGND VPWR VPWR sky130_fd_sc_hd__fill_1
* cell instance sky130_fd_sc_hd__fill_1_743 r0 *1 0,0
Xsky130_fd_sc_hd__fill_1_743 VGND VPWR VPWR sky130_fd_sc_hd__fill_1
* cell instance sky130_fd_sc_hd__fill_1_744 r0 *1 0,0
Xsky130_fd_sc_hd__fill_1_744 VGND VPWR VPWR sky130_fd_sc_hd__fill_1
* cell instance sky130_fd_sc_hd__fill_1_745 r0 *1 0,0
Xsky130_fd_sc_hd__fill_1_745 VGND VPWR VPWR sky130_fd_sc_hd__fill_1
* cell instance sky130_fd_sc_hd__fill_1_746 r0 *1 0,0
Xsky130_fd_sc_hd__fill_1_746 VGND VPWR VPWR sky130_fd_sc_hd__fill_1
* cell instance sky130_fd_sc_hd__fill_1_747 r0 *1 0,0
Xsky130_fd_sc_hd__fill_1_747 VGND VPWR VPWR sky130_fd_sc_hd__fill_1
* cell instance sky130_fd_sc_hd__fill_1_748 r0 *1 0,0
Xsky130_fd_sc_hd__fill_1_748 VGND VPWR VPWR sky130_fd_sc_hd__fill_1
* cell instance sky130_fd_sc_hd__fill_1_749 r0 *1 0,0
Xsky130_fd_sc_hd__fill_1_749 VGND VPWR VPWR sky130_fd_sc_hd__fill_1
* cell instance sky130_fd_sc_hd__fill_1_750 r0 *1 0,0
Xsky130_fd_sc_hd__fill_1_750 VGND VPWR VPWR sky130_fd_sc_hd__fill_1
* cell instance sky130_fd_sc_hd__fill_1_751 r0 *1 0,0
Xsky130_fd_sc_hd__fill_1_751 VGND VPWR VPWR sky130_fd_sc_hd__fill_1
* cell instance sky130_fd_sc_hd__fill_1_752 r0 *1 0,0
Xsky130_fd_sc_hd__fill_1_752 VGND VPWR VPWR sky130_fd_sc_hd__fill_1
* cell instance sky130_fd_sc_hd__fill_1_753 r0 *1 0,0
Xsky130_fd_sc_hd__fill_1_753 VGND VPWR VPWR sky130_fd_sc_hd__fill_1
* cell instance sky130_fd_sc_hd__fill_1_754 r0 *1 0,0
Xsky130_fd_sc_hd__fill_1_754 VGND VPWR VPWR sky130_fd_sc_hd__fill_1
* cell instance sky130_fd_sc_hd__fill_1_755 r0 *1 0,0
Xsky130_fd_sc_hd__fill_1_755 VGND VPWR VPWR sky130_fd_sc_hd__fill_1
* cell instance sky130_fd_sc_hd__fill_1_756 r0 *1 0,0
Xsky130_fd_sc_hd__fill_1_756 VGND VPWR VPWR sky130_fd_sc_hd__fill_1
* cell instance sky130_fd_sc_hd__fill_1_757 r0 *1 0,0
Xsky130_fd_sc_hd__fill_1_757 VGND VPWR VPWR sky130_fd_sc_hd__fill_1
* cell instance sky130_fd_sc_hd__fill_1_758 r0 *1 0,0
Xsky130_fd_sc_hd__fill_1_758 VGND VPWR VPWR sky130_fd_sc_hd__fill_1
* cell instance sky130_fd_sc_hd__fill_1_759 r0 *1 0,0
Xsky130_fd_sc_hd__fill_1_759 VGND VPWR VPWR sky130_fd_sc_hd__fill_1
* cell instance sky130_fd_sc_hd__fill_1_760 r0 *1 0,0
Xsky130_fd_sc_hd__fill_1_760 VGND VPWR VPWR sky130_fd_sc_hd__fill_1
* cell instance sky130_fd_sc_hd__fill_1_761 r0 *1 0,0
Xsky130_fd_sc_hd__fill_1_761 VGND VPWR VPWR sky130_fd_sc_hd__fill_1
* cell instance sky130_fd_sc_hd__fill_1_762 r0 *1 0,0
Xsky130_fd_sc_hd__fill_1_762 VGND VPWR VPWR sky130_fd_sc_hd__fill_1
* cell instance sky130_fd_sc_hd__fill_1_763 r0 *1 0,0
Xsky130_fd_sc_hd__fill_1_763 VGND VPWR VPWR sky130_fd_sc_hd__fill_1
* cell instance sky130_fd_sc_hd__fill_1_764 r0 *1 0,0
Xsky130_fd_sc_hd__fill_1_764 VGND VPWR VPWR sky130_fd_sc_hd__fill_1
* cell instance sky130_fd_sc_hd__fill_1_765 r0 *1 0,0
Xsky130_fd_sc_hd__fill_1_765 VGND VPWR VPWR sky130_fd_sc_hd__fill_1
* cell instance sky130_fd_sc_hd__fill_1_766 r0 *1 0,0
Xsky130_fd_sc_hd__fill_1_766 VGND VPWR VPWR sky130_fd_sc_hd__fill_1
* cell instance sky130_fd_sc_hd__fill_1_767 r0 *1 0,0
Xsky130_fd_sc_hd__fill_1_767 VGND VPWR VPWR sky130_fd_sc_hd__fill_1
* cell instance sky130_fd_sc_hd__fill_1_768 r0 *1 0,0
Xsky130_fd_sc_hd__fill_1_768 VGND VPWR VPWR sky130_fd_sc_hd__fill_1
* cell instance sky130_fd_sc_hd__fill_1_769 r0 *1 0,0
Xsky130_fd_sc_hd__fill_1_769 VGND VPWR VPWR sky130_fd_sc_hd__fill_1
* cell instance sky130_fd_sc_hd__fill_1_770 r0 *1 0,0
Xsky130_fd_sc_hd__fill_1_770 VGND VPWR VPWR sky130_fd_sc_hd__fill_1
* cell instance sky130_fd_sc_hd__fill_1_771 r0 *1 0,0
Xsky130_fd_sc_hd__fill_1_771 VGND VPWR VPWR sky130_fd_sc_hd__fill_1
* cell instance sky130_fd_sc_hd__fill_1_772 r0 *1 0,0
Xsky130_fd_sc_hd__fill_1_772 VGND VPWR VPWR sky130_fd_sc_hd__fill_1
* cell instance sky130_fd_sc_hd__fill_1_773 r0 *1 0,0
Xsky130_fd_sc_hd__fill_1_773 VGND VPWR VPWR sky130_fd_sc_hd__fill_1
* cell instance sky130_fd_sc_hd__fill_1_774 r0 *1 0,0
Xsky130_fd_sc_hd__fill_1_774 VGND VPWR VPWR sky130_fd_sc_hd__fill_1
* cell instance sky130_fd_sc_hd__fill_1_775 r0 *1 0,0
Xsky130_fd_sc_hd__fill_1_775 VGND VPWR VPWR sky130_fd_sc_hd__fill_1
* cell instance sky130_fd_sc_hd__fill_1_776 r0 *1 0,0
Xsky130_fd_sc_hd__fill_1_776 VGND VPWR VPWR sky130_fd_sc_hd__fill_1
* cell instance sky130_fd_sc_hd__fill_1_777 r0 *1 0,0
Xsky130_fd_sc_hd__fill_1_777 VGND VPWR VPWR sky130_fd_sc_hd__fill_1
* cell instance sky130_fd_sc_hd__fill_1_778 r0 *1 0,0
Xsky130_fd_sc_hd__fill_1_778 VGND VPWR VPWR sky130_fd_sc_hd__fill_1
* cell instance sky130_fd_sc_hd__fill_1_779 r0 *1 0,0
Xsky130_fd_sc_hd__fill_1_779 VGND VPWR VPWR sky130_fd_sc_hd__fill_1
* cell instance sky130_fd_sc_hd__fill_1_780 r0 *1 0,0
Xsky130_fd_sc_hd__fill_1_780 VGND VPWR VPWR sky130_fd_sc_hd__fill_1
* cell instance sky130_fd_sc_hd__fill_1_781 r0 *1 0,0
Xsky130_fd_sc_hd__fill_1_781 VGND VPWR VPWR sky130_fd_sc_hd__fill_1
* cell instance sky130_fd_sc_hd__fill_1_782 r0 *1 0,0
Xsky130_fd_sc_hd__fill_1_782 VGND VPWR VPWR sky130_fd_sc_hd__fill_1
* cell instance sky130_fd_sc_hd__fill_1_783 r0 *1 0,0
Xsky130_fd_sc_hd__fill_1_783 VGND VPWR VPWR sky130_fd_sc_hd__fill_1
* cell instance sky130_fd_sc_hd__fill_1_784 r0 *1 0,0
Xsky130_fd_sc_hd__fill_1_784 VGND VPWR VPWR sky130_fd_sc_hd__fill_1
* cell instance sky130_fd_sc_hd__fill_1_785 r0 *1 0,0
Xsky130_fd_sc_hd__fill_1_785 VGND VPWR VPWR sky130_fd_sc_hd__fill_1
* cell instance sky130_fd_sc_hd__fill_1_786 r0 *1 0,0
Xsky130_fd_sc_hd__fill_1_786 VGND VPWR VPWR sky130_fd_sc_hd__fill_1
* cell instance sky130_fd_sc_hd__fill_1_787 r0 *1 0,0
Xsky130_fd_sc_hd__fill_1_787 VGND VPWR VPWR sky130_fd_sc_hd__fill_1
* cell instance sky130_fd_sc_hd__fill_1_788 r0 *1 0,0
Xsky130_fd_sc_hd__fill_1_788 VGND VPWR VPWR sky130_fd_sc_hd__fill_1
* cell instance sky130_fd_sc_hd__fill_1_789 r0 *1 0,0
Xsky130_fd_sc_hd__fill_1_789 VGND VPWR VPWR sky130_fd_sc_hd__fill_1
* cell instance sky130_fd_sc_hd__fill_1_790 r0 *1 0,0
Xsky130_fd_sc_hd__fill_1_790 VGND VPWR VPWR sky130_fd_sc_hd__fill_1
* cell instance sky130_fd_sc_hd__fill_1_791 r0 *1 0,0
Xsky130_fd_sc_hd__fill_1_791 VGND VPWR VPWR sky130_fd_sc_hd__fill_1
* cell instance sky130_fd_sc_hd__fill_1_792 r0 *1 0,0
Xsky130_fd_sc_hd__fill_1_792 VGND VPWR VPWR sky130_fd_sc_hd__fill_1
* cell instance sky130_fd_sc_hd__fill_1_793 r0 *1 0,0
Xsky130_fd_sc_hd__fill_1_793 VGND VPWR VPWR sky130_fd_sc_hd__fill_1
* cell instance sky130_fd_sc_hd__fill_1_794 r0 *1 0,0
Xsky130_fd_sc_hd__fill_1_794 VGND VPWR VPWR sky130_fd_sc_hd__fill_1
* cell instance sky130_fd_sc_hd__fill_1_795 r0 *1 0,0
Xsky130_fd_sc_hd__fill_1_795 VGND VPWR VPWR sky130_fd_sc_hd__fill_1
* cell instance sky130_fd_sc_hd__fill_1_796 r0 *1 0,0
Xsky130_fd_sc_hd__fill_1_796 VGND VPWR VPWR sky130_fd_sc_hd__fill_1
* cell instance sky130_fd_sc_hd__fill_1_797 r0 *1 0,0
Xsky130_fd_sc_hd__fill_1_797 VGND VPWR VPWR sky130_fd_sc_hd__fill_1
* cell instance sky130_fd_sc_hd__fill_1_798 r0 *1 0,0
Xsky130_fd_sc_hd__fill_1_798 VGND VPWR VPWR sky130_fd_sc_hd__fill_1
* cell instance sky130_fd_sc_hd__fill_1_799 r0 *1 0,0
Xsky130_fd_sc_hd__fill_1_799 VGND VPWR VPWR sky130_fd_sc_hd__fill_1
* cell instance sky130_fd_sc_hd__fill_1_800 r0 *1 0,0
Xsky130_fd_sc_hd__fill_1_800 VGND VPWR VPWR sky130_fd_sc_hd__fill_1
* cell instance sky130_fd_sc_hd__fill_1_801 r0 *1 0,0
Xsky130_fd_sc_hd__fill_1_801 VGND VPWR VPWR sky130_fd_sc_hd__fill_1
* cell instance sky130_fd_sc_hd__fill_1_802 r0 *1 0,0
Xsky130_fd_sc_hd__fill_1_802 VGND VPWR VPWR sky130_fd_sc_hd__fill_1
* cell instance sky130_fd_sc_hd__fill_1_803 r0 *1 0,0
Xsky130_fd_sc_hd__fill_1_803 VGND VPWR VPWR sky130_fd_sc_hd__fill_1
* cell instance sky130_fd_sc_hd__fill_1_804 r0 *1 0,0
Xsky130_fd_sc_hd__fill_1_804 VGND VPWR VPWR sky130_fd_sc_hd__fill_1
* cell instance sky130_fd_sc_hd__fill_1_805 r0 *1 0,0
Xsky130_fd_sc_hd__fill_1_805 VGND VPWR VPWR sky130_fd_sc_hd__fill_1
* cell instance sky130_fd_sc_hd__fill_1_806 r0 *1 0,0
Xsky130_fd_sc_hd__fill_1_806 VGND VPWR VPWR sky130_fd_sc_hd__fill_1
* cell instance sky130_fd_sc_hd__fill_1_807 r0 *1 0,0
Xsky130_fd_sc_hd__fill_1_807 VGND VPWR VPWR sky130_fd_sc_hd__fill_1
* cell instance sky130_fd_sc_hd__fill_1_808 r0 *1 0,0
Xsky130_fd_sc_hd__fill_1_808 VGND VPWR VPWR sky130_fd_sc_hd__fill_1
* cell instance sky130_fd_sc_hd__fill_1_809 r0 *1 0,0
Xsky130_fd_sc_hd__fill_1_809 VGND VPWR VPWR sky130_fd_sc_hd__fill_1
* cell instance sky130_fd_sc_hd__fill_1_810 r0 *1 0,0
Xsky130_fd_sc_hd__fill_1_810 VGND VPWR VPWR sky130_fd_sc_hd__fill_1
* cell instance sky130_fd_sc_hd__fill_1_811 r0 *1 0,0
Xsky130_fd_sc_hd__fill_1_811 VGND VPWR VPWR sky130_fd_sc_hd__fill_1
* cell instance sky130_fd_sc_hd__fill_1_812 r0 *1 0,0
Xsky130_fd_sc_hd__fill_1_812 VGND VPWR VPWR sky130_fd_sc_hd__fill_1
* cell instance sky130_fd_sc_hd__fill_1_813 r0 *1 0,0
Xsky130_fd_sc_hd__fill_1_813 VGND VPWR VPWR sky130_fd_sc_hd__fill_1
* cell instance sky130_fd_sc_hd__fill_1_814 r0 *1 0,0
Xsky130_fd_sc_hd__fill_1_814 VGND VPWR VPWR sky130_fd_sc_hd__fill_1
* cell instance sky130_fd_sc_hd__fill_1_815 r0 *1 0,0
Xsky130_fd_sc_hd__fill_1_815 VGND VPWR VPWR sky130_fd_sc_hd__fill_1
* cell instance sky130_fd_sc_hd__fill_1_816 r0 *1 0,0
Xsky130_fd_sc_hd__fill_1_816 VGND VPWR VPWR sky130_fd_sc_hd__fill_1
* cell instance sky130_fd_sc_hd__fill_1_817 r0 *1 0,0
Xsky130_fd_sc_hd__fill_1_817 VGND VPWR VPWR sky130_fd_sc_hd__fill_1
* cell instance sky130_fd_sc_hd__fill_1_818 r0 *1 0,0
Xsky130_fd_sc_hd__fill_1_818 VGND VPWR VPWR sky130_fd_sc_hd__fill_1
* cell instance sky130_fd_sc_hd__fill_1_819 r0 *1 0,0
Xsky130_fd_sc_hd__fill_1_819 VGND VPWR VPWR sky130_fd_sc_hd__fill_1
* cell instance sky130_fd_sc_hd__fill_1_820 r0 *1 0,0
Xsky130_fd_sc_hd__fill_1_820 VGND VPWR VPWR sky130_fd_sc_hd__fill_1
* cell instance sky130_fd_sc_hd__fill_1_821 r0 *1 0,0
Xsky130_fd_sc_hd__fill_1_821 VGND VPWR VPWR sky130_fd_sc_hd__fill_1
* cell instance sky130_fd_sc_hd__fill_1_822 r0 *1 0,0
Xsky130_fd_sc_hd__fill_1_822 VGND VPWR VPWR sky130_fd_sc_hd__fill_1
* cell instance sky130_fd_sc_hd__fill_1_823 r0 *1 0,0
Xsky130_fd_sc_hd__fill_1_823 VGND VPWR VPWR sky130_fd_sc_hd__fill_1
* cell instance sky130_fd_sc_hd__fill_1_824 r0 *1 0,0
Xsky130_fd_sc_hd__fill_1_824 VGND VPWR VPWR sky130_fd_sc_hd__fill_1
* cell instance sky130_fd_sc_hd__fill_1_825 r0 *1 0,0
Xsky130_fd_sc_hd__fill_1_825 VGND VPWR VPWR sky130_fd_sc_hd__fill_1
* cell instance sky130_fd_sc_hd__fill_1_826 r0 *1 0,0
Xsky130_fd_sc_hd__fill_1_826 VGND VPWR VPWR sky130_fd_sc_hd__fill_1
* cell instance sky130_fd_sc_hd__fill_1_827 r0 *1 0,0
Xsky130_fd_sc_hd__fill_1_827 VGND VPWR VPWR sky130_fd_sc_hd__fill_1
* cell instance sky130_fd_sc_hd__fill_1_828 r0 *1 0,0
Xsky130_fd_sc_hd__fill_1_828 VGND VPWR VPWR sky130_fd_sc_hd__fill_1
* cell instance sky130_fd_sc_hd__fill_1_829 r0 *1 0,0
Xsky130_fd_sc_hd__fill_1_829 VGND VPWR VPWR sky130_fd_sc_hd__fill_1
* cell instance sky130_fd_sc_hd__fill_1_830 r0 *1 0,0
Xsky130_fd_sc_hd__fill_1_830 VGND VPWR VPWR sky130_fd_sc_hd__fill_1
* cell instance sky130_fd_sc_hd__fill_1_831 r0 *1 0,0
Xsky130_fd_sc_hd__fill_1_831 VGND VPWR VPWR sky130_fd_sc_hd__fill_1
* cell instance sky130_fd_sc_hd__fill_1_832 r0 *1 0,0
Xsky130_fd_sc_hd__fill_1_832 VGND VPWR VPWR sky130_fd_sc_hd__fill_1
* cell instance sky130_fd_sc_hd__fill_1_833 r0 *1 0,0
Xsky130_fd_sc_hd__fill_1_833 VGND VPWR VPWR sky130_fd_sc_hd__fill_1
* cell instance sky130_fd_sc_hd__fill_1_834 r0 *1 0,0
Xsky130_fd_sc_hd__fill_1_834 VGND VPWR VPWR sky130_fd_sc_hd__fill_1
* cell instance sky130_fd_sc_hd__fill_1_835 r0 *1 0,0
Xsky130_fd_sc_hd__fill_1_835 VGND VPWR VPWR sky130_fd_sc_hd__fill_1
* cell instance sky130_fd_sc_hd__fill_1_836 r0 *1 0,0
Xsky130_fd_sc_hd__fill_1_836 VGND VPWR VPWR sky130_fd_sc_hd__fill_1
* cell instance sky130_fd_sc_hd__fill_1_837 r0 *1 0,0
Xsky130_fd_sc_hd__fill_1_837 VGND VPWR VPWR sky130_fd_sc_hd__fill_1
* cell instance sky130_fd_sc_hd__fill_1_838 r0 *1 0,0
Xsky130_fd_sc_hd__fill_1_838 VGND VPWR VPWR sky130_fd_sc_hd__fill_1
* cell instance sky130_fd_sc_hd__fill_1_839 r0 *1 0,0
Xsky130_fd_sc_hd__fill_1_839 VGND VPWR VPWR sky130_fd_sc_hd__fill_1
* cell instance sky130_fd_sc_hd__fill_1_840 r0 *1 0,0
Xsky130_fd_sc_hd__fill_1_840 VGND VPWR VPWR sky130_fd_sc_hd__fill_1
* cell instance sky130_fd_sc_hd__fill_1_841 r0 *1 0,0
Xsky130_fd_sc_hd__fill_1_841 VGND VPWR VPWR sky130_fd_sc_hd__fill_1
* cell instance sky130_fd_sc_hd__fill_1_842 r0 *1 0,0
Xsky130_fd_sc_hd__fill_1_842 VGND VPWR VPWR sky130_fd_sc_hd__fill_1
* cell instance sky130_fd_sc_hd__fill_1_843 r0 *1 0,0
Xsky130_fd_sc_hd__fill_1_843 VGND VPWR VPWR sky130_fd_sc_hd__fill_1
* cell instance sky130_fd_sc_hd__fill_1_844 r0 *1 0,0
Xsky130_fd_sc_hd__fill_1_844 VGND VPWR VPWR sky130_fd_sc_hd__fill_1
* cell instance sky130_fd_sc_hd__fill_1_845 r0 *1 0,0
Xsky130_fd_sc_hd__fill_1_845 VGND VPWR VPWR sky130_fd_sc_hd__fill_1
* cell instance sky130_fd_sc_hd__fill_1_846 r0 *1 0,0
Xsky130_fd_sc_hd__fill_1_846 VGND VPWR VPWR sky130_fd_sc_hd__fill_1
* cell instance sky130_fd_sc_hd__fill_1_847 r0 *1 0,0
Xsky130_fd_sc_hd__fill_1_847 VGND VPWR VPWR sky130_fd_sc_hd__fill_1
* cell instance sky130_fd_sc_hd__fill_1_848 r0 *1 0,0
Xsky130_fd_sc_hd__fill_1_848 VGND VPWR VPWR sky130_fd_sc_hd__fill_1
* cell instance sky130_fd_sc_hd__fill_1_849 r0 *1 0,0
Xsky130_fd_sc_hd__fill_1_849 VGND VPWR VPWR sky130_fd_sc_hd__fill_1
* cell instance sky130_fd_sc_hd__fill_1_850 r0 *1 0,0
Xsky130_fd_sc_hd__fill_1_850 VGND VPWR VPWR sky130_fd_sc_hd__fill_1
* cell instance sky130_fd_sc_hd__fill_1_851 r0 *1 0,0
Xsky130_fd_sc_hd__fill_1_851 VGND VPWR VPWR sky130_fd_sc_hd__fill_1
* cell instance sky130_fd_sc_hd__fill_1_852 r0 *1 0,0
Xsky130_fd_sc_hd__fill_1_852 VGND VPWR VPWR sky130_fd_sc_hd__fill_1
* cell instance sky130_fd_sc_hd__fill_1_853 r0 *1 0,0
Xsky130_fd_sc_hd__fill_1_853 VGND VPWR VPWR sky130_fd_sc_hd__fill_1
* cell instance sky130_fd_sc_hd__fill_1_854 r0 *1 0,0
Xsky130_fd_sc_hd__fill_1_854 VGND VPWR VPWR sky130_fd_sc_hd__fill_1
* cell instance sky130_fd_sc_hd__fill_1_855 r0 *1 0,0
Xsky130_fd_sc_hd__fill_1_855 VGND VPWR VPWR sky130_fd_sc_hd__fill_1
* cell instance sky130_fd_sc_hd__fill_1_856 r0 *1 0,0
Xsky130_fd_sc_hd__fill_1_856 VGND VPWR VPWR sky130_fd_sc_hd__fill_1
* cell instance sky130_fd_sc_hd__fill_1_857 r0 *1 0,0
Xsky130_fd_sc_hd__fill_1_857 VGND VPWR VPWR sky130_fd_sc_hd__fill_1
* cell instance sky130_fd_sc_hd__fill_1_858 r0 *1 0,0
Xsky130_fd_sc_hd__fill_1_858 VGND VPWR VPWR sky130_fd_sc_hd__fill_1
* cell instance sky130_fd_sc_hd__fill_1_859 r0 *1 0,0
Xsky130_fd_sc_hd__fill_1_859 VGND VPWR VPWR sky130_fd_sc_hd__fill_1
* cell instance sky130_fd_sc_hd__fill_1_860 r0 *1 0,0
Xsky130_fd_sc_hd__fill_1_860 VGND VPWR VPWR sky130_fd_sc_hd__fill_1
* cell instance sky130_fd_sc_hd__fill_1_861 r0 *1 0,0
Xsky130_fd_sc_hd__fill_1_861 VGND VPWR VPWR sky130_fd_sc_hd__fill_1
* cell instance sky130_fd_sc_hd__fill_1_862 r0 *1 0,0
Xsky130_fd_sc_hd__fill_1_862 VGND VPWR VPWR sky130_fd_sc_hd__fill_1
* cell instance sky130_fd_sc_hd__fill_1_863 r0 *1 0,0
Xsky130_fd_sc_hd__fill_1_863 VGND VPWR VPWR sky130_fd_sc_hd__fill_1
* cell instance sky130_fd_sc_hd__fill_1_864 r0 *1 0,0
Xsky130_fd_sc_hd__fill_1_864 VGND VPWR VPWR sky130_fd_sc_hd__fill_1
* cell instance sky130_fd_sc_hd__fill_1_865 r0 *1 0,0
Xsky130_fd_sc_hd__fill_1_865 VGND VPWR VPWR sky130_fd_sc_hd__fill_1
* cell instance sky130_fd_sc_hd__fill_1_866 r0 *1 0,0
Xsky130_fd_sc_hd__fill_1_866 VGND VPWR VPWR sky130_fd_sc_hd__fill_1
* cell instance sky130_fd_sc_hd__fill_1_867 r0 *1 0,0
Xsky130_fd_sc_hd__fill_1_867 VGND VPWR VPWR sky130_fd_sc_hd__fill_1
* cell instance sky130_fd_sc_hd__fill_1_868 r0 *1 0,0
Xsky130_fd_sc_hd__fill_1_868 VGND VPWR VPWR sky130_fd_sc_hd__fill_1
* cell instance sky130_fd_sc_hd__fill_1_869 r0 *1 0,0
Xsky130_fd_sc_hd__fill_1_869 VGND VPWR VPWR sky130_fd_sc_hd__fill_1
* cell instance sky130_fd_sc_hd__fill_1_870 r0 *1 0,0
Xsky130_fd_sc_hd__fill_1_870 VGND VPWR VPWR sky130_fd_sc_hd__fill_1
* cell instance sky130_fd_sc_hd__fill_1_871 r0 *1 0,0
Xsky130_fd_sc_hd__fill_1_871 VGND VPWR VPWR sky130_fd_sc_hd__fill_1
* cell instance sky130_fd_sc_hd__fill_1_872 r0 *1 0,0
Xsky130_fd_sc_hd__fill_1_872 VGND VPWR VPWR sky130_fd_sc_hd__fill_1
* cell instance sky130_fd_sc_hd__fill_1_873 r0 *1 0,0
Xsky130_fd_sc_hd__fill_1_873 VGND VPWR VPWR sky130_fd_sc_hd__fill_1
* cell instance sky130_fd_sc_hd__fill_1_874 r0 *1 0,0
Xsky130_fd_sc_hd__fill_1_874 VGND VPWR VPWR sky130_fd_sc_hd__fill_1
* cell instance sky130_fd_sc_hd__fill_1_875 r0 *1 0,0
Xsky130_fd_sc_hd__fill_1_875 VGND VPWR VPWR sky130_fd_sc_hd__fill_1
* cell instance sky130_fd_sc_hd__fill_1_876 r0 *1 0,0
Xsky130_fd_sc_hd__fill_1_876 VGND VPWR VPWR sky130_fd_sc_hd__fill_1
* cell instance sky130_fd_sc_hd__fill_1_877 r0 *1 0,0
Xsky130_fd_sc_hd__fill_1_877 VGND VPWR VPWR sky130_fd_sc_hd__fill_1
* cell instance sky130_fd_sc_hd__fill_1_878 r0 *1 0,0
Xsky130_fd_sc_hd__fill_1_878 VGND VPWR VPWR sky130_fd_sc_hd__fill_1
* cell instance sky130_fd_sc_hd__fill_1_879 r0 *1 0,0
Xsky130_fd_sc_hd__fill_1_879 VGND VPWR VPWR sky130_fd_sc_hd__fill_1
* cell instance sky130_fd_sc_hd__fill_1_880 r0 *1 0,0
Xsky130_fd_sc_hd__fill_1_880 VGND VPWR VPWR sky130_fd_sc_hd__fill_1
* cell instance sky130_fd_sc_hd__fill_1_881 r0 *1 0,0
Xsky130_fd_sc_hd__fill_1_881 VGND VPWR VPWR sky130_fd_sc_hd__fill_1
* cell instance sky130_fd_sc_hd__fill_1_882 r0 *1 0,0
Xsky130_fd_sc_hd__fill_1_882 VGND VPWR VPWR sky130_fd_sc_hd__fill_1
* cell instance sky130_fd_sc_hd__fill_1_883 r0 *1 0,0
Xsky130_fd_sc_hd__fill_1_883 VGND VPWR VPWR sky130_fd_sc_hd__fill_1
* cell instance sky130_fd_sc_hd__fill_1_884 r0 *1 0,0
Xsky130_fd_sc_hd__fill_1_884 VGND VPWR VPWR sky130_fd_sc_hd__fill_1
* cell instance sky130_fd_sc_hd__fill_1_885 r0 *1 0,0
Xsky130_fd_sc_hd__fill_1_885 VGND VPWR VPWR sky130_fd_sc_hd__fill_1
* cell instance sky130_fd_sc_hd__fill_1_886 r0 *1 0,0
Xsky130_fd_sc_hd__fill_1_886 VGND VPWR VPWR sky130_fd_sc_hd__fill_1
* cell instance sky130_fd_sc_hd__fill_1_887 r0 *1 0,0
Xsky130_fd_sc_hd__fill_1_887 VGND VPWR VPWR sky130_fd_sc_hd__fill_1
* cell instance sky130_fd_sc_hd__fill_1_888 r0 *1 0,0
Xsky130_fd_sc_hd__fill_1_888 VGND VPWR VPWR sky130_fd_sc_hd__fill_1
* cell instance sky130_fd_sc_hd__fill_1_889 r0 *1 0,0
Xsky130_fd_sc_hd__fill_1_889 VGND VPWR VPWR sky130_fd_sc_hd__fill_1
* cell instance sky130_fd_sc_hd__fill_1_890 r0 *1 0,0
Xsky130_fd_sc_hd__fill_1_890 VGND VPWR VPWR sky130_fd_sc_hd__fill_1
* cell instance sky130_fd_sc_hd__fill_1_891 r0 *1 0,0
Xsky130_fd_sc_hd__fill_1_891 VGND VPWR VPWR sky130_fd_sc_hd__fill_1
* cell instance sky130_fd_sc_hd__fill_1_892 r0 *1 0,0
Xsky130_fd_sc_hd__fill_1_892 VGND VPWR VPWR sky130_fd_sc_hd__fill_1
* cell instance sky130_fd_sc_hd__fill_1_893 r0 *1 0,0
Xsky130_fd_sc_hd__fill_1_893 VGND VPWR VPWR sky130_fd_sc_hd__fill_1
* cell instance sky130_fd_sc_hd__fill_1_894 r0 *1 0,0
Xsky130_fd_sc_hd__fill_1_894 VGND VPWR VPWR sky130_fd_sc_hd__fill_1
* cell instance sky130_fd_sc_hd__fill_1_895 r0 *1 0,0
Xsky130_fd_sc_hd__fill_1_895 VGND VPWR VPWR sky130_fd_sc_hd__fill_1
* cell instance sky130_fd_sc_hd__fill_1_896 r0 *1 0,0
Xsky130_fd_sc_hd__fill_1_896 VGND VPWR VPWR sky130_fd_sc_hd__fill_1
* cell instance sky130_fd_sc_hd__fill_1_897 r0 *1 0,0
Xsky130_fd_sc_hd__fill_1_897 VGND VPWR VPWR sky130_fd_sc_hd__fill_1
* cell instance sky130_fd_sc_hd__fill_1_898 r0 *1 0,0
Xsky130_fd_sc_hd__fill_1_898 VGND VPWR VPWR sky130_fd_sc_hd__fill_1
* cell instance sky130_fd_sc_hd__fill_1_899 r0 *1 0,0
Xsky130_fd_sc_hd__fill_1_899 VGND VPWR VPWR sky130_fd_sc_hd__fill_1
* cell instance sky130_fd_sc_hd__fill_1_900 r0 *1 0,0
Xsky130_fd_sc_hd__fill_1_900 VGND VPWR VPWR sky130_fd_sc_hd__fill_1
* cell instance sky130_fd_sc_hd__fill_1_901 r0 *1 0,0
Xsky130_fd_sc_hd__fill_1_901 VGND VPWR VPWR sky130_fd_sc_hd__fill_1
* cell instance sky130_fd_sc_hd__fill_1_902 r0 *1 0,0
Xsky130_fd_sc_hd__fill_1_902 VGND VPWR VPWR sky130_fd_sc_hd__fill_1
* cell instance sky130_fd_sc_hd__fill_1_903 r0 *1 0,0
Xsky130_fd_sc_hd__fill_1_903 VGND VPWR VPWR sky130_fd_sc_hd__fill_1
* cell instance sky130_fd_sc_hd__fill_1_904 r0 *1 0,0
Xsky130_fd_sc_hd__fill_1_904 VGND VPWR VPWR sky130_fd_sc_hd__fill_1
* cell instance sky130_fd_sc_hd__fill_1_905 r0 *1 0,0
Xsky130_fd_sc_hd__fill_1_905 VGND VPWR VPWR sky130_fd_sc_hd__fill_1
* cell instance sky130_fd_sc_hd__fill_1_906 r0 *1 0,0
Xsky130_fd_sc_hd__fill_1_906 VGND VPWR VPWR sky130_fd_sc_hd__fill_1
* cell instance sky130_fd_sc_hd__fill_1_907 r0 *1 0,0
Xsky130_fd_sc_hd__fill_1_907 VGND VPWR VPWR sky130_fd_sc_hd__fill_1
* cell instance sky130_fd_sc_hd__fill_1_908 r0 *1 0,0
Xsky130_fd_sc_hd__fill_1_908 VGND VPWR VPWR sky130_fd_sc_hd__fill_1
* cell instance sky130_fd_sc_hd__fill_1_909 r0 *1 0,0
Xsky130_fd_sc_hd__fill_1_909 VGND VPWR VPWR sky130_fd_sc_hd__fill_1
* cell instance sky130_fd_sc_hd__fill_1_910 r0 *1 0,0
Xsky130_fd_sc_hd__fill_1_910 VGND VPWR VPWR sky130_fd_sc_hd__fill_1
* cell instance sky130_fd_sc_hd__fill_1_911 r0 *1 0,0
Xsky130_fd_sc_hd__fill_1_911 VGND VPWR VPWR sky130_fd_sc_hd__fill_1
* cell instance sky130_fd_sc_hd__fill_1_912 r0 *1 0,0
Xsky130_fd_sc_hd__fill_1_912 VGND VPWR VPWR sky130_fd_sc_hd__fill_1
* cell instance sky130_fd_sc_hd__fill_1_913 r0 *1 0,0
Xsky130_fd_sc_hd__fill_1_913 VGND VPWR VPWR sky130_fd_sc_hd__fill_1
* cell instance sky130_fd_sc_hd__fill_1_914 r0 *1 0,0
Xsky130_fd_sc_hd__fill_1_914 VGND VPWR VPWR sky130_fd_sc_hd__fill_1
* cell instance sky130_fd_sc_hd__fill_1_915 r0 *1 0,0
Xsky130_fd_sc_hd__fill_1_915 VGND VPWR VPWR sky130_fd_sc_hd__fill_1
* cell instance sky130_fd_sc_hd__fill_1_916 r0 *1 0,0
Xsky130_fd_sc_hd__fill_1_916 VGND VPWR VPWR sky130_fd_sc_hd__fill_1
* cell instance sky130_fd_sc_hd__fill_1_917 r0 *1 0,0
Xsky130_fd_sc_hd__fill_1_917 VGND VPWR VPWR sky130_fd_sc_hd__fill_1
* cell instance sky130_fd_sc_hd__fill_1_918 r0 *1 0,0
Xsky130_fd_sc_hd__fill_1_918 VGND VPWR VPWR sky130_fd_sc_hd__fill_1
* cell instance sky130_fd_sc_hd__fill_1_919 r0 *1 0,0
Xsky130_fd_sc_hd__fill_1_919 VGND VPWR VPWR sky130_fd_sc_hd__fill_1
* cell instance sky130_fd_sc_hd__fill_1_920 r0 *1 0,0
Xsky130_fd_sc_hd__fill_1_920 VGND VPWR VPWR sky130_fd_sc_hd__fill_1
* cell instance sky130_fd_sc_hd__fill_1_921 r0 *1 0,0
Xsky130_fd_sc_hd__fill_1_921 VGND VPWR VPWR sky130_fd_sc_hd__fill_1
* cell instance sky130_fd_sc_hd__fill_1_922 r0 *1 0,0
Xsky130_fd_sc_hd__fill_1_922 VGND VPWR VPWR sky130_fd_sc_hd__fill_1
* cell instance sky130_fd_sc_hd__fill_1_923 r0 *1 0,0
Xsky130_fd_sc_hd__fill_1_923 VGND VPWR VPWR sky130_fd_sc_hd__fill_1
* cell instance sky130_fd_sc_hd__fill_1_924 r0 *1 0,0
Xsky130_fd_sc_hd__fill_1_924 VGND VPWR VPWR sky130_fd_sc_hd__fill_1
* cell instance sky130_fd_sc_hd__fill_1_925 r0 *1 0,0
Xsky130_fd_sc_hd__fill_1_925 VGND VPWR VPWR sky130_fd_sc_hd__fill_1
* cell instance sky130_fd_sc_hd__fill_1_926 r0 *1 0,0
Xsky130_fd_sc_hd__fill_1_926 VGND VPWR VPWR sky130_fd_sc_hd__fill_1
* cell instance sky130_fd_sc_hd__fill_1_927 r0 *1 0,0
Xsky130_fd_sc_hd__fill_1_927 VGND VPWR VPWR sky130_fd_sc_hd__fill_1
* cell instance sky130_fd_sc_hd__fill_1_928 r0 *1 0,0
Xsky130_fd_sc_hd__fill_1_928 VGND VPWR VPWR sky130_fd_sc_hd__fill_1
* cell instance sky130_fd_sc_hd__fill_1_929 r0 *1 0,0
Xsky130_fd_sc_hd__fill_1_929 VGND VPWR VPWR sky130_fd_sc_hd__fill_1
* cell instance sky130_fd_sc_hd__fill_1_930 r0 *1 0,0
Xsky130_fd_sc_hd__fill_1_930 VGND VPWR VPWR sky130_fd_sc_hd__fill_1
* cell instance sky130_fd_sc_hd__fill_1_931 r0 *1 0,0
Xsky130_fd_sc_hd__fill_1_931 VGND VPWR VPWR sky130_fd_sc_hd__fill_1
* cell instance sky130_fd_sc_hd__fill_1_932 r0 *1 0,0
Xsky130_fd_sc_hd__fill_1_932 VGND VPWR VPWR sky130_fd_sc_hd__fill_1
* cell instance sky130_fd_sc_hd__fill_1_933 r0 *1 0,0
Xsky130_fd_sc_hd__fill_1_933 VGND VPWR VPWR sky130_fd_sc_hd__fill_1
* cell instance sky130_fd_sc_hd__fill_1_934 r0 *1 0,0
Xsky130_fd_sc_hd__fill_1_934 VGND VPWR VPWR sky130_fd_sc_hd__fill_1
* cell instance sky130_fd_sc_hd__fill_1_935 r0 *1 0,0
Xsky130_fd_sc_hd__fill_1_935 VGND VPWR VPWR sky130_fd_sc_hd__fill_1
* cell instance sky130_fd_sc_hd__fill_1_936 r0 *1 0,0
Xsky130_fd_sc_hd__fill_1_936 VGND VPWR VPWR sky130_fd_sc_hd__fill_1
* cell instance sky130_fd_sc_hd__fill_1_937 r0 *1 0,0
Xsky130_fd_sc_hd__fill_1_937 VGND VPWR VPWR sky130_fd_sc_hd__fill_1
* cell instance sky130_fd_sc_hd__fill_1_938 r0 *1 0,0
Xsky130_fd_sc_hd__fill_1_938 VGND VPWR VPWR sky130_fd_sc_hd__fill_1
* cell instance sky130_fd_sc_hd__fill_1_939 r0 *1 0,0
Xsky130_fd_sc_hd__fill_1_939 VGND VPWR VPWR sky130_fd_sc_hd__fill_1
* cell instance sky130_fd_sc_hd__fill_1_940 r0 *1 0,0
Xsky130_fd_sc_hd__fill_1_940 VGND VPWR VPWR sky130_fd_sc_hd__fill_1
* cell instance sky130_fd_sc_hd__fill_1_941 r0 *1 0,0
Xsky130_fd_sc_hd__fill_1_941 VGND VPWR VPWR sky130_fd_sc_hd__fill_1
* cell instance sky130_fd_sc_hd__fill_1_942 r0 *1 0,0
Xsky130_fd_sc_hd__fill_1_942 VGND VPWR VPWR sky130_fd_sc_hd__fill_1
* cell instance sky130_fd_sc_hd__fill_1_943 r0 *1 0,0
Xsky130_fd_sc_hd__fill_1_943 VGND VPWR VPWR sky130_fd_sc_hd__fill_1
* cell instance sky130_fd_sc_hd__fill_1_944 r0 *1 0,0
Xsky130_fd_sc_hd__fill_1_944 VGND VPWR VPWR sky130_fd_sc_hd__fill_1
* cell instance sky130_fd_sc_hd__fill_1_945 r0 *1 0,0
Xsky130_fd_sc_hd__fill_1_945 VGND VPWR VPWR sky130_fd_sc_hd__fill_1
* cell instance sky130_fd_sc_hd__fill_1_946 r0 *1 0,0
Xsky130_fd_sc_hd__fill_1_946 VGND VPWR VPWR sky130_fd_sc_hd__fill_1
* cell instance sky130_fd_sc_hd__fill_1_947 r0 *1 0,0
Xsky130_fd_sc_hd__fill_1_947 VGND VPWR VPWR sky130_fd_sc_hd__fill_1
* cell instance sky130_fd_sc_hd__fill_1_948 r0 *1 0,0
Xsky130_fd_sc_hd__fill_1_948 VGND VPWR VPWR sky130_fd_sc_hd__fill_1
* cell instance sky130_fd_sc_hd__fill_1_949 r0 *1 0,0
Xsky130_fd_sc_hd__fill_1_949 VGND VPWR VPWR sky130_fd_sc_hd__fill_1
* cell instance sky130_fd_sc_hd__fill_1_950 r0 *1 0,0
Xsky130_fd_sc_hd__fill_1_950 VGND VPWR VPWR sky130_fd_sc_hd__fill_1
* cell instance sky130_fd_sc_hd__fill_1_951 r0 *1 0,0
Xsky130_fd_sc_hd__fill_1_951 VGND VPWR VPWR sky130_fd_sc_hd__fill_1
* cell instance sky130_fd_sc_hd__fill_1_952 r0 *1 0,0
Xsky130_fd_sc_hd__fill_1_952 VGND VPWR VPWR sky130_fd_sc_hd__fill_1
* cell instance sky130_fd_sc_hd__fill_1_953 r0 *1 0,0
Xsky130_fd_sc_hd__fill_1_953 VGND VPWR VPWR sky130_fd_sc_hd__fill_1
* cell instance sky130_fd_sc_hd__fill_1_954 r0 *1 0,0
Xsky130_fd_sc_hd__fill_1_954 VGND VPWR VPWR sky130_fd_sc_hd__fill_1
* cell instance sky130_fd_sc_hd__fill_1_955 r0 *1 0,0
Xsky130_fd_sc_hd__fill_1_955 VGND VPWR VPWR sky130_fd_sc_hd__fill_1
* cell instance sky130_fd_sc_hd__fill_1_956 r0 *1 0,0
Xsky130_fd_sc_hd__fill_1_956 VGND VPWR VPWR sky130_fd_sc_hd__fill_1
* cell instance sky130_fd_sc_hd__fill_1_957 r0 *1 0,0
Xsky130_fd_sc_hd__fill_1_957 VGND VPWR VPWR sky130_fd_sc_hd__fill_1
* cell instance sky130_fd_sc_hd__fill_1_958 r0 *1 0,0
Xsky130_fd_sc_hd__fill_1_958 VGND VPWR VPWR sky130_fd_sc_hd__fill_1
* cell instance sky130_fd_sc_hd__fill_1_959 r0 *1 0,0
Xsky130_fd_sc_hd__fill_1_959 VGND VPWR VPWR sky130_fd_sc_hd__fill_1
* cell instance sky130_fd_sc_hd__fill_1_960 r0 *1 0,0
Xsky130_fd_sc_hd__fill_1_960 VGND VPWR VPWR sky130_fd_sc_hd__fill_1
* cell instance sky130_fd_sc_hd__fill_1_961 r0 *1 0,0
Xsky130_fd_sc_hd__fill_1_961 VGND VPWR VPWR sky130_fd_sc_hd__fill_1
* cell instance sky130_fd_sc_hd__fill_1_962 r0 *1 0,0
Xsky130_fd_sc_hd__fill_1_962 VGND VPWR VPWR sky130_fd_sc_hd__fill_1
* cell instance sky130_fd_sc_hd__fill_1_963 r0 *1 0,0
Xsky130_fd_sc_hd__fill_1_963 VGND VPWR VPWR sky130_fd_sc_hd__fill_1
* cell instance sky130_fd_sc_hd__fill_1_964 r0 *1 0,0
Xsky130_fd_sc_hd__fill_1_964 VGND VPWR VPWR sky130_fd_sc_hd__fill_1
* cell instance sky130_fd_sc_hd__fill_1_965 r0 *1 0,0
Xsky130_fd_sc_hd__fill_1_965 VGND VPWR VPWR sky130_fd_sc_hd__fill_1
* cell instance sky130_fd_sc_hd__fill_1_966 r0 *1 0,0
Xsky130_fd_sc_hd__fill_1_966 VGND VPWR VPWR sky130_fd_sc_hd__fill_1
* cell instance sky130_fd_sc_hd__fill_1_967 r0 *1 0,0
Xsky130_fd_sc_hd__fill_1_967 VGND VPWR VPWR sky130_fd_sc_hd__fill_1
* cell instance sky130_fd_sc_hd__fill_1_968 r0 *1 0,0
Xsky130_fd_sc_hd__fill_1_968 VGND VPWR VPWR sky130_fd_sc_hd__fill_1
* cell instance sky130_fd_sc_hd__fill_1_969 r0 *1 0,0
Xsky130_fd_sc_hd__fill_1_969 VGND VPWR VPWR sky130_fd_sc_hd__fill_1
* cell instance sky130_fd_sc_hd__fill_1_970 r0 *1 0,0
Xsky130_fd_sc_hd__fill_1_970 VGND VPWR VPWR sky130_fd_sc_hd__fill_1
* cell instance sky130_fd_sc_hd__fill_1_971 r0 *1 0,0
Xsky130_fd_sc_hd__fill_1_971 VGND VPWR VPWR sky130_fd_sc_hd__fill_1
* cell instance sky130_fd_sc_hd__fill_1_972 r0 *1 0,0
Xsky130_fd_sc_hd__fill_1_972 VGND VPWR VPWR sky130_fd_sc_hd__fill_1
* cell instance sky130_fd_sc_hd__fill_1_973 r0 *1 0,0
Xsky130_fd_sc_hd__fill_1_973 VGND VPWR VPWR sky130_fd_sc_hd__fill_1
* cell instance sky130_fd_sc_hd__fill_1_974 r0 *1 0,0
Xsky130_fd_sc_hd__fill_1_974 VGND VPWR VPWR sky130_fd_sc_hd__fill_1
* cell instance sky130_fd_sc_hd__fill_1_975 r0 *1 0,0
Xsky130_fd_sc_hd__fill_1_975 VGND VPWR VPWR sky130_fd_sc_hd__fill_1
* cell instance sky130_fd_sc_hd__fill_1_976 r0 *1 0,0
Xsky130_fd_sc_hd__fill_1_976 VGND VPWR VPWR sky130_fd_sc_hd__fill_1
* cell instance sky130_fd_sc_hd__fill_1_977 r0 *1 0,0
Xsky130_fd_sc_hd__fill_1_977 VGND VPWR VPWR sky130_fd_sc_hd__fill_1
* cell instance sky130_fd_sc_hd__fill_1_978 r0 *1 0,0
Xsky130_fd_sc_hd__fill_1_978 VGND VPWR VPWR sky130_fd_sc_hd__fill_1
* cell instance sky130_fd_sc_hd__fill_1_979 r0 *1 0,0
Xsky130_fd_sc_hd__fill_1_979 VGND VPWR VPWR sky130_fd_sc_hd__fill_1
* cell instance sky130_fd_sc_hd__fill_1_980 r0 *1 0,0
Xsky130_fd_sc_hd__fill_1_980 VGND VPWR VPWR sky130_fd_sc_hd__fill_1
* cell instance sky130_fd_sc_hd__fill_1_981 r0 *1 0,0
Xsky130_fd_sc_hd__fill_1_981 VGND VPWR VPWR sky130_fd_sc_hd__fill_1
* cell instance sky130_fd_sc_hd__fill_1_982 r0 *1 0,0
Xsky130_fd_sc_hd__fill_1_982 VGND VPWR VPWR sky130_fd_sc_hd__fill_1
* cell instance sky130_fd_sc_hd__fill_1_983 r0 *1 0,0
Xsky130_fd_sc_hd__fill_1_983 VGND VPWR VPWR sky130_fd_sc_hd__fill_1
* cell instance sky130_fd_sc_hd__fill_1_984 r0 *1 0,0
Xsky130_fd_sc_hd__fill_1_984 VGND VPWR VPWR sky130_fd_sc_hd__fill_1
* cell instance sky130_fd_sc_hd__fill_1_985 r0 *1 0,0
Xsky130_fd_sc_hd__fill_1_985 VGND VPWR VPWR sky130_fd_sc_hd__fill_1
* cell instance sky130_fd_sc_hd__fill_1_986 r0 *1 0,0
Xsky130_fd_sc_hd__fill_1_986 VGND VPWR VPWR sky130_fd_sc_hd__fill_1
* cell instance sky130_fd_sc_hd__fill_1_987 r0 *1 0,0
Xsky130_fd_sc_hd__fill_1_987 VGND VPWR VPWR sky130_fd_sc_hd__fill_1
* cell instance sky130_fd_sc_hd__fill_1_988 r0 *1 0,0
Xsky130_fd_sc_hd__fill_1_988 VGND VPWR VPWR sky130_fd_sc_hd__fill_1
* cell instance sky130_fd_sc_hd__fill_1_989 r0 *1 0,0
Xsky130_fd_sc_hd__fill_1_989 VGND VPWR VPWR sky130_fd_sc_hd__fill_1
* cell instance sky130_fd_sc_hd__fill_1_990 r0 *1 0,0
Xsky130_fd_sc_hd__fill_1_990 VGND VPWR VPWR sky130_fd_sc_hd__fill_1
* cell instance sky130_fd_sc_hd__fill_1_991 r0 *1 0,0
Xsky130_fd_sc_hd__fill_1_991 VGND VPWR VPWR sky130_fd_sc_hd__fill_1
* cell instance sky130_fd_sc_hd__fill_1_992 r0 *1 0,0
Xsky130_fd_sc_hd__fill_1_992 VGND VPWR VPWR sky130_fd_sc_hd__fill_1
* cell instance sky130_fd_sc_hd__fill_1_993 r0 *1 0,0
Xsky130_fd_sc_hd__fill_1_993 VGND VPWR VPWR sky130_fd_sc_hd__fill_1
* cell instance sky130_fd_sc_hd__fill_1_994 r0 *1 0,0
Xsky130_fd_sc_hd__fill_1_994 VGND VPWR VPWR sky130_fd_sc_hd__fill_1
* cell instance sky130_fd_sc_hd__fill_1_995 r0 *1 0,0
Xsky130_fd_sc_hd__fill_1_995 VGND VPWR VPWR sky130_fd_sc_hd__fill_1
* cell instance sky130_fd_sc_hd__fill_1_996 r0 *1 0,0
Xsky130_fd_sc_hd__fill_1_996 VGND VPWR VPWR sky130_fd_sc_hd__fill_1
* cell instance sky130_fd_sc_hd__fill_1_997 r0 *1 0,0
Xsky130_fd_sc_hd__fill_1_997 VGND VPWR VPWR sky130_fd_sc_hd__fill_1
* cell instance sky130_fd_sc_hd__fill_1_998 r0 *1 0,0
Xsky130_fd_sc_hd__fill_1_998 VGND VPWR VPWR sky130_fd_sc_hd__fill_1
* cell instance sky130_fd_sc_hd__fill_1_999 r0 *1 0,0
Xsky130_fd_sc_hd__fill_1_999 VGND VPWR VPWR sky130_fd_sc_hd__fill_1
* cell instance sky130_fd_sc_hd__fill_1_1000 r0 *1 0,0
Xsky130_fd_sc_hd__fill_1_1000 VGND VPWR VPWR sky130_fd_sc_hd__fill_1
* cell instance sky130_fd_sc_hd__fill_1_1001 r0 *1 0,0
Xsky130_fd_sc_hd__fill_1_1001 VGND VPWR VPWR sky130_fd_sc_hd__fill_1
* cell instance sky130_fd_sc_hd__fill_1_1002 r0 *1 0,0
Xsky130_fd_sc_hd__fill_1_1002 VGND VPWR VPWR sky130_fd_sc_hd__fill_1
* cell instance sky130_fd_sc_hd__fill_1_1003 r0 *1 0,0
Xsky130_fd_sc_hd__fill_1_1003 VGND VPWR VPWR sky130_fd_sc_hd__fill_1
* cell instance sky130_fd_sc_hd__fill_1_1004 r0 *1 0,0
Xsky130_fd_sc_hd__fill_1_1004 VGND VPWR VPWR sky130_fd_sc_hd__fill_1
* cell instance sky130_fd_sc_hd__fill_1_1005 r0 *1 0,0
Xsky130_fd_sc_hd__fill_1_1005 VGND VPWR VPWR sky130_fd_sc_hd__fill_1
* cell instance sky130_fd_sc_hd__fill_1_1006 r0 *1 0,0
Xsky130_fd_sc_hd__fill_1_1006 VGND VPWR VPWR sky130_fd_sc_hd__fill_1
* cell instance sky130_fd_sc_hd__fill_1_1007 r0 *1 0,0
Xsky130_fd_sc_hd__fill_1_1007 VGND VPWR VPWR sky130_fd_sc_hd__fill_1
* cell instance sky130_fd_sc_hd__fill_1_1008 r0 *1 0,0
Xsky130_fd_sc_hd__fill_1_1008 VGND VPWR VPWR sky130_fd_sc_hd__fill_1
* cell instance sky130_fd_sc_hd__fill_1_1009 r0 *1 0,0
Xsky130_fd_sc_hd__fill_1_1009 VGND VPWR VPWR sky130_fd_sc_hd__fill_1
* cell instance sky130_fd_sc_hd__fill_1_1010 r0 *1 0,0
Xsky130_fd_sc_hd__fill_1_1010 VGND VPWR VPWR sky130_fd_sc_hd__fill_1
* cell instance sky130_fd_sc_hd__fill_1_1011 r0 *1 0,0
Xsky130_fd_sc_hd__fill_1_1011 VGND VPWR VPWR sky130_fd_sc_hd__fill_1
* cell instance sky130_fd_sc_hd__fill_1_1012 r0 *1 0,0
Xsky130_fd_sc_hd__fill_1_1012 VGND VPWR VPWR sky130_fd_sc_hd__fill_1
* cell instance sky130_fd_sc_hd__fill_1_1013 r0 *1 0,0
Xsky130_fd_sc_hd__fill_1_1013 VGND VPWR VPWR sky130_fd_sc_hd__fill_1
* cell instance sky130_fd_sc_hd__fill_1_1014 r0 *1 0,0
Xsky130_fd_sc_hd__fill_1_1014 VGND VPWR VPWR sky130_fd_sc_hd__fill_1
* cell instance sky130_fd_sc_hd__fill_1_1015 r0 *1 0,0
Xsky130_fd_sc_hd__fill_1_1015 VGND VPWR VPWR sky130_fd_sc_hd__fill_1
* cell instance sky130_fd_sc_hd__fill_1_1016 r0 *1 0,0
Xsky130_fd_sc_hd__fill_1_1016 VGND VPWR VPWR sky130_fd_sc_hd__fill_1
* cell instance sky130_fd_sc_hd__fill_1_1017 r0 *1 0,0
Xsky130_fd_sc_hd__fill_1_1017 VGND VPWR VPWR sky130_fd_sc_hd__fill_1
* cell instance sky130_fd_sc_hd__fill_1_1018 r0 *1 0,0
Xsky130_fd_sc_hd__fill_1_1018 VGND VPWR VPWR sky130_fd_sc_hd__fill_1
* cell instance sky130_fd_sc_hd__fill_1_1019 r0 *1 0,0
Xsky130_fd_sc_hd__fill_1_1019 VGND VPWR VPWR sky130_fd_sc_hd__fill_1
* cell instance sky130_fd_sc_hd__fill_1_1020 r0 *1 0,0
Xsky130_fd_sc_hd__fill_1_1020 VGND VPWR VPWR sky130_fd_sc_hd__fill_1
* cell instance sky130_fd_sc_hd__fill_1_1021 r0 *1 0,0
Xsky130_fd_sc_hd__fill_1_1021 VGND VPWR VPWR sky130_fd_sc_hd__fill_1
* cell instance sky130_fd_sc_hd__fill_1_1022 r0 *1 0,0
Xsky130_fd_sc_hd__fill_1_1022 VGND VPWR VPWR sky130_fd_sc_hd__fill_1
* cell instance sky130_fd_sc_hd__fill_1_1023 r0 *1 0,0
Xsky130_fd_sc_hd__fill_1_1023 VGND VPWR VPWR sky130_fd_sc_hd__fill_1
* cell instance sky130_fd_sc_hd__fill_1_1024 r0 *1 0,0
Xsky130_fd_sc_hd__fill_1_1024 VGND VPWR VPWR sky130_fd_sc_hd__fill_1
* cell instance sky130_fd_sc_hd__fill_1_1025 r0 *1 0,0
Xsky130_fd_sc_hd__fill_1_1025 VGND VPWR VPWR sky130_fd_sc_hd__fill_1
* cell instance sky130_fd_sc_hd__fill_1_1026 r0 *1 0,0
Xsky130_fd_sc_hd__fill_1_1026 VGND VPWR VPWR sky130_fd_sc_hd__fill_1
* cell instance sky130_fd_sc_hd__fill_1_1027 r0 *1 0,0
Xsky130_fd_sc_hd__fill_1_1027 VGND VPWR VPWR sky130_fd_sc_hd__fill_1
* cell instance sky130_fd_sc_hd__fill_1_1028 r0 *1 0,0
Xsky130_fd_sc_hd__fill_1_1028 VGND VPWR VPWR sky130_fd_sc_hd__fill_1
* cell instance sky130_fd_sc_hd__fill_1_1029 r0 *1 0,0
Xsky130_fd_sc_hd__fill_1_1029 VGND VPWR VPWR sky130_fd_sc_hd__fill_1
* cell instance sky130_fd_sc_hd__fill_1_1030 r0 *1 0,0
Xsky130_fd_sc_hd__fill_1_1030 VGND VPWR VPWR sky130_fd_sc_hd__fill_1
* cell instance sky130_fd_sc_hd__fill_1_1031 r0 *1 0,0
Xsky130_fd_sc_hd__fill_1_1031 VGND VPWR VPWR sky130_fd_sc_hd__fill_1
* cell instance sky130_fd_sc_hd__fill_1_1032 r0 *1 0,0
Xsky130_fd_sc_hd__fill_1_1032 VGND VPWR VPWR sky130_fd_sc_hd__fill_1
* cell instance sky130_fd_sc_hd__fill_1_1033 r0 *1 0,0
Xsky130_fd_sc_hd__fill_1_1033 VGND VPWR VPWR sky130_fd_sc_hd__fill_1
* cell instance sky130_fd_sc_hd__fill_1_1034 r0 *1 0,0
Xsky130_fd_sc_hd__fill_1_1034 VGND VPWR VPWR sky130_fd_sc_hd__fill_1
* cell instance sky130_fd_sc_hd__fill_1_1035 r0 *1 0,0
Xsky130_fd_sc_hd__fill_1_1035 VGND VPWR VPWR sky130_fd_sc_hd__fill_1
* cell instance sky130_fd_sc_hd__fill_1_1036 r0 *1 0,0
Xsky130_fd_sc_hd__fill_1_1036 VGND VPWR VPWR sky130_fd_sc_hd__fill_1
* cell instance sky130_fd_sc_hd__fill_1_1037 r0 *1 0,0
Xsky130_fd_sc_hd__fill_1_1037 VGND VPWR VPWR sky130_fd_sc_hd__fill_1
* cell instance sky130_fd_sc_hd__fill_1_1038 r0 *1 0,0
Xsky130_fd_sc_hd__fill_1_1038 VGND VPWR VPWR sky130_fd_sc_hd__fill_1
* cell instance sky130_fd_sc_hd__fill_1_1039 r0 *1 0,0
Xsky130_fd_sc_hd__fill_1_1039 VGND VPWR VPWR sky130_fd_sc_hd__fill_1
* cell instance sky130_fd_sc_hd__fill_1_1040 r0 *1 0,0
Xsky130_fd_sc_hd__fill_1_1040 VGND VPWR VPWR sky130_fd_sc_hd__fill_1
* cell instance sky130_fd_sc_hd__fill_1_1041 r0 *1 0,0
Xsky130_fd_sc_hd__fill_1_1041 VGND VPWR VPWR sky130_fd_sc_hd__fill_1
* cell instance sky130_fd_sc_hd__fill_1_1042 r0 *1 0,0
Xsky130_fd_sc_hd__fill_1_1042 VGND VPWR VPWR sky130_fd_sc_hd__fill_1
* cell instance sky130_fd_sc_hd__fill_1_1043 r0 *1 0,0
Xsky130_fd_sc_hd__fill_1_1043 VGND VPWR VPWR sky130_fd_sc_hd__fill_1
* cell instance sky130_fd_sc_hd__fill_1_1044 r0 *1 0,0
Xsky130_fd_sc_hd__fill_1_1044 VGND VPWR VPWR sky130_fd_sc_hd__fill_1
* cell instance sky130_fd_sc_hd__fill_1_1045 r0 *1 0,0
Xsky130_fd_sc_hd__fill_1_1045 VGND VPWR VPWR sky130_fd_sc_hd__fill_1
* cell instance sky130_fd_sc_hd__fill_1_1046 r0 *1 0,0
Xsky130_fd_sc_hd__fill_1_1046 VGND VPWR VPWR sky130_fd_sc_hd__fill_1
* cell instance sky130_fd_sc_hd__fill_1_1047 r0 *1 0,0
Xsky130_fd_sc_hd__fill_1_1047 VGND VPWR VPWR sky130_fd_sc_hd__fill_1
* cell instance sky130_fd_sc_hd__fill_1_1048 r0 *1 0,0
Xsky130_fd_sc_hd__fill_1_1048 VGND VPWR VPWR sky130_fd_sc_hd__fill_1
* cell instance sky130_fd_sc_hd__fill_1_1049 r0 *1 0,0
Xsky130_fd_sc_hd__fill_1_1049 VGND VPWR VPWR sky130_fd_sc_hd__fill_1
* cell instance sky130_fd_sc_hd__fill_1_1050 r0 *1 0,0
Xsky130_fd_sc_hd__fill_1_1050 VGND VPWR VPWR sky130_fd_sc_hd__fill_1
* cell instance sky130_fd_sc_hd__fill_1_1051 r0 *1 0,0
Xsky130_fd_sc_hd__fill_1_1051 VGND VPWR VPWR sky130_fd_sc_hd__fill_1
* cell instance sky130_fd_sc_hd__fill_1_1052 r0 *1 0,0
Xsky130_fd_sc_hd__fill_1_1052 VGND VPWR VPWR sky130_fd_sc_hd__fill_1
* cell instance sky130_fd_sc_hd__fill_1_1053 r0 *1 0,0
Xsky130_fd_sc_hd__fill_1_1053 VGND VPWR VPWR sky130_fd_sc_hd__fill_1
* cell instance sky130_fd_sc_hd__fill_1_1054 r0 *1 0,0
Xsky130_fd_sc_hd__fill_1_1054 VGND VPWR VPWR sky130_fd_sc_hd__fill_1
* cell instance sky130_fd_sc_hd__fill_1_1055 r0 *1 0,0
Xsky130_fd_sc_hd__fill_1_1055 VGND VPWR VPWR sky130_fd_sc_hd__fill_1
* cell instance sky130_fd_sc_hd__fill_1_1056 r0 *1 0,0
Xsky130_fd_sc_hd__fill_1_1056 VGND VPWR VPWR sky130_fd_sc_hd__fill_1
* cell instance sky130_fd_sc_hd__fill_1_1057 r0 *1 0,0
Xsky130_fd_sc_hd__fill_1_1057 VGND VPWR VPWR sky130_fd_sc_hd__fill_1
* cell instance sky130_fd_sc_hd__fill_1_1058 r0 *1 0,0
Xsky130_fd_sc_hd__fill_1_1058 VGND VPWR VPWR sky130_fd_sc_hd__fill_1
* cell instance sky130_fd_sc_hd__fill_1_1059 r0 *1 0,0
Xsky130_fd_sc_hd__fill_1_1059 VGND VPWR VPWR sky130_fd_sc_hd__fill_1
* cell instance sky130_fd_sc_hd__fill_1_1060 r0 *1 0,0
Xsky130_fd_sc_hd__fill_1_1060 VGND VPWR VPWR sky130_fd_sc_hd__fill_1
* cell instance sky130_fd_sc_hd__fill_1_1061 r0 *1 0,0
Xsky130_fd_sc_hd__fill_1_1061 VGND VPWR VPWR sky130_fd_sc_hd__fill_1
* cell instance sky130_fd_sc_hd__fill_1_1062 r0 *1 0,0
Xsky130_fd_sc_hd__fill_1_1062 VGND VPWR VPWR sky130_fd_sc_hd__fill_1
* cell instance sky130_fd_sc_hd__fill_1_1063 r0 *1 0,0
Xsky130_fd_sc_hd__fill_1_1063 VGND VPWR VPWR sky130_fd_sc_hd__fill_1
* cell instance sky130_fd_sc_hd__fill_1_1064 r0 *1 0,0
Xsky130_fd_sc_hd__fill_1_1064 VGND VPWR VPWR sky130_fd_sc_hd__fill_1
* cell instance sky130_fd_sc_hd__fill_1_1065 r0 *1 0,0
Xsky130_fd_sc_hd__fill_1_1065 VGND VPWR VPWR sky130_fd_sc_hd__fill_1
* cell instance sky130_fd_sc_hd__fill_1_1066 r0 *1 0,0
Xsky130_fd_sc_hd__fill_1_1066 VGND VPWR VPWR sky130_fd_sc_hd__fill_1
* cell instance sky130_fd_sc_hd__fill_1_1067 r0 *1 0,0
Xsky130_fd_sc_hd__fill_1_1067 VGND VPWR VPWR sky130_fd_sc_hd__fill_1
* cell instance sky130_fd_sc_hd__fill_1_1068 r0 *1 0,0
Xsky130_fd_sc_hd__fill_1_1068 VGND VPWR VPWR sky130_fd_sc_hd__fill_1
* cell instance sky130_fd_sc_hd__fill_1_1069 r0 *1 0,0
Xsky130_fd_sc_hd__fill_1_1069 VGND VPWR VPWR sky130_fd_sc_hd__fill_1
* cell instance sky130_fd_sc_hd__fill_1_1070 r0 *1 0,0
Xsky130_fd_sc_hd__fill_1_1070 VGND VPWR VPWR sky130_fd_sc_hd__fill_1
* cell instance sky130_fd_sc_hd__fill_1_1071 r0 *1 0,0
Xsky130_fd_sc_hd__fill_1_1071 VGND VPWR VPWR sky130_fd_sc_hd__fill_1
* cell instance sky130_fd_sc_hd__fill_1_1072 r0 *1 0,0
Xsky130_fd_sc_hd__fill_1_1072 VGND VPWR VPWR sky130_fd_sc_hd__fill_1
* cell instance sky130_fd_sc_hd__fill_1_1073 r0 *1 0,0
Xsky130_fd_sc_hd__fill_1_1073 VGND VPWR VPWR sky130_fd_sc_hd__fill_1
* cell instance sky130_fd_sc_hd__fill_1_1074 r0 *1 0,0
Xsky130_fd_sc_hd__fill_1_1074 VGND VPWR VPWR sky130_fd_sc_hd__fill_1
* cell instance sky130_fd_sc_hd__fill_1_1075 r0 *1 0,0
Xsky130_fd_sc_hd__fill_1_1075 VGND VPWR VPWR sky130_fd_sc_hd__fill_1
* cell instance sky130_fd_sc_hd__fill_1_1076 r0 *1 0,0
Xsky130_fd_sc_hd__fill_1_1076 VGND VPWR VPWR sky130_fd_sc_hd__fill_1
* cell instance sky130_fd_sc_hd__fill_1_1077 r0 *1 0,0
Xsky130_fd_sc_hd__fill_1_1077 VGND VPWR VPWR sky130_fd_sc_hd__fill_1
* cell instance sky130_fd_sc_hd__fill_1_1078 r0 *1 0,0
Xsky130_fd_sc_hd__fill_1_1078 VGND VPWR VPWR sky130_fd_sc_hd__fill_1
* cell instance sky130_fd_sc_hd__fill_1_1079 r0 *1 0,0
Xsky130_fd_sc_hd__fill_1_1079 VGND VPWR VPWR sky130_fd_sc_hd__fill_1
* cell instance sky130_fd_sc_hd__fill_1_1080 r0 *1 0,0
Xsky130_fd_sc_hd__fill_1_1080 VGND VPWR VPWR sky130_fd_sc_hd__fill_1
* cell instance sky130_fd_sc_hd__fill_1_1081 r0 *1 0,0
Xsky130_fd_sc_hd__fill_1_1081 VGND VPWR VPWR sky130_fd_sc_hd__fill_1
* cell instance sky130_fd_sc_hd__fill_1_1082 r0 *1 0,0
Xsky130_fd_sc_hd__fill_1_1082 VGND VPWR VPWR sky130_fd_sc_hd__fill_1
* cell instance sky130_fd_sc_hd__fill_1_1083 r0 *1 0,0
Xsky130_fd_sc_hd__fill_1_1083 VGND VPWR VPWR sky130_fd_sc_hd__fill_1
* cell instance sky130_fd_sc_hd__fill_1_1084 r0 *1 0,0
Xsky130_fd_sc_hd__fill_1_1084 VGND VPWR VPWR sky130_fd_sc_hd__fill_1
* cell instance sky130_fd_sc_hd__fill_1_1085 r0 *1 0,0
Xsky130_fd_sc_hd__fill_1_1085 VGND VPWR VPWR sky130_fd_sc_hd__fill_1
* cell instance sky130_fd_sc_hd__fill_1_1086 r0 *1 0,0
Xsky130_fd_sc_hd__fill_1_1086 VGND VPWR VPWR sky130_fd_sc_hd__fill_1
* cell instance sky130_fd_sc_hd__fill_1_1087 r0 *1 0,0
Xsky130_fd_sc_hd__fill_1_1087 VGND VPWR VPWR sky130_fd_sc_hd__fill_1
* cell instance sky130_fd_sc_hd__fill_1_1088 r0 *1 0,0
Xsky130_fd_sc_hd__fill_1_1088 VGND VPWR VPWR sky130_fd_sc_hd__fill_1
* cell instance sky130_fd_sc_hd__fill_1_1089 r0 *1 0,0
Xsky130_fd_sc_hd__fill_1_1089 VGND VPWR VPWR sky130_fd_sc_hd__fill_1
* cell instance sky130_fd_sc_hd__fill_1_1090 r0 *1 0,0
Xsky130_fd_sc_hd__fill_1_1090 VGND VPWR VPWR sky130_fd_sc_hd__fill_1
* cell instance sky130_fd_sc_hd__fill_1_1091 r0 *1 0,0
Xsky130_fd_sc_hd__fill_1_1091 VGND VPWR VPWR sky130_fd_sc_hd__fill_1
* cell instance sky130_fd_sc_hd__fill_1_1092 r0 *1 0,0
Xsky130_fd_sc_hd__fill_1_1092 VGND VPWR VPWR sky130_fd_sc_hd__fill_1
* cell instance sky130_fd_sc_hd__fill_1_1093 r0 *1 0,0
Xsky130_fd_sc_hd__fill_1_1093 VGND VPWR VPWR sky130_fd_sc_hd__fill_1
* cell instance sky130_fd_sc_hd__fill_1_1094 r0 *1 0,0
Xsky130_fd_sc_hd__fill_1_1094 VGND VPWR VPWR sky130_fd_sc_hd__fill_1
* cell instance sky130_fd_sc_hd__fill_1_1095 r0 *1 0,0
Xsky130_fd_sc_hd__fill_1_1095 VGND VPWR VPWR sky130_fd_sc_hd__fill_1
* cell instance sky130_fd_sc_hd__fill_1_1096 r0 *1 0,0
Xsky130_fd_sc_hd__fill_1_1096 VGND VPWR VPWR sky130_fd_sc_hd__fill_1
* cell instance sky130_fd_sc_hd__fill_1_1097 r0 *1 0,0
Xsky130_fd_sc_hd__fill_1_1097 VGND VPWR VPWR sky130_fd_sc_hd__fill_1
* cell instance sky130_fd_sc_hd__fill_1_1098 r0 *1 0,0
Xsky130_fd_sc_hd__fill_1_1098 VGND VPWR VPWR sky130_fd_sc_hd__fill_1
* cell instance sky130_fd_sc_hd__fill_1_1099 r0 *1 0,0
Xsky130_fd_sc_hd__fill_1_1099 VGND VPWR VPWR sky130_fd_sc_hd__fill_1
* cell instance sky130_fd_sc_hd__fill_1_1100 r0 *1 0,0
Xsky130_fd_sc_hd__fill_1_1100 VGND VPWR VPWR sky130_fd_sc_hd__fill_1
* cell instance sky130_fd_sc_hd__fill_1_1101 r0 *1 0,0
Xsky130_fd_sc_hd__fill_1_1101 VGND VPWR VPWR sky130_fd_sc_hd__fill_1
* cell instance sky130_fd_sc_hd__fill_1_1102 r0 *1 0,0
Xsky130_fd_sc_hd__fill_1_1102 VGND VPWR VPWR sky130_fd_sc_hd__fill_1
* cell instance sky130_fd_sc_hd__fill_1_1103 r0 *1 0,0
Xsky130_fd_sc_hd__fill_1_1103 VGND VPWR VPWR sky130_fd_sc_hd__fill_1
* cell instance sky130_fd_sc_hd__fill_1_1104 r0 *1 0,0
Xsky130_fd_sc_hd__fill_1_1104 VGND VPWR VPWR sky130_fd_sc_hd__fill_1
* cell instance sky130_fd_sc_hd__fill_1_1105 r0 *1 0,0
Xsky130_fd_sc_hd__fill_1_1105 VGND VPWR VPWR sky130_fd_sc_hd__fill_1
* cell instance sky130_fd_sc_hd__fill_1_1106 r0 *1 0,0
Xsky130_fd_sc_hd__fill_1_1106 VGND VPWR VPWR sky130_fd_sc_hd__fill_1
* cell instance sky130_fd_sc_hd__fill_1_1107 r0 *1 0,0
Xsky130_fd_sc_hd__fill_1_1107 VGND VPWR VPWR sky130_fd_sc_hd__fill_1
* cell instance sky130_fd_sc_hd__fill_1_1108 r0 *1 0,0
Xsky130_fd_sc_hd__fill_1_1108 VGND VPWR VPWR sky130_fd_sc_hd__fill_1
* cell instance sky130_fd_sc_hd__fill_1_1109 r0 *1 0,0
Xsky130_fd_sc_hd__fill_1_1109 VGND VPWR VPWR sky130_fd_sc_hd__fill_1
* cell instance sky130_fd_sc_hd__fill_1_1110 r0 *1 0,0
Xsky130_fd_sc_hd__fill_1_1110 VGND VPWR VPWR sky130_fd_sc_hd__fill_1
* cell instance sky130_fd_sc_hd__fill_1_1111 r0 *1 0,0
Xsky130_fd_sc_hd__fill_1_1111 VGND VPWR VPWR sky130_fd_sc_hd__fill_1
* cell instance sky130_fd_sc_hd__fill_1_1112 r0 *1 0,0
Xsky130_fd_sc_hd__fill_1_1112 VGND VPWR VPWR sky130_fd_sc_hd__fill_1
* cell instance sky130_fd_sc_hd__fill_1_1113 r0 *1 0,0
Xsky130_fd_sc_hd__fill_1_1113 VGND VPWR VPWR sky130_fd_sc_hd__fill_1
* cell instance sky130_fd_sc_hd__fill_1_1114 r0 *1 0,0
Xsky130_fd_sc_hd__fill_1_1114 VGND VPWR VPWR sky130_fd_sc_hd__fill_1
* cell instance sky130_fd_sc_hd__fill_1_1115 r0 *1 0,0
Xsky130_fd_sc_hd__fill_1_1115 VGND VPWR VPWR sky130_fd_sc_hd__fill_1
* cell instance sky130_fd_sc_hd__fill_1_1116 r0 *1 0,0
Xsky130_fd_sc_hd__fill_1_1116 VGND VPWR VPWR sky130_fd_sc_hd__fill_1
* cell instance sky130_fd_sc_hd__fill_1_1117 r0 *1 0,0
Xsky130_fd_sc_hd__fill_1_1117 VGND VPWR VPWR sky130_fd_sc_hd__fill_1
* cell instance sky130_fd_sc_hd__fill_1_1118 r0 *1 0,0
Xsky130_fd_sc_hd__fill_1_1118 VGND VPWR VPWR sky130_fd_sc_hd__fill_1
* cell instance sky130_fd_sc_hd__fill_1_1119 r0 *1 0,0
Xsky130_fd_sc_hd__fill_1_1119 VGND VPWR VPWR sky130_fd_sc_hd__fill_1
* cell instance sky130_fd_sc_hd__fill_1_1120 r0 *1 0,0
Xsky130_fd_sc_hd__fill_1_1120 VGND VPWR VPWR sky130_fd_sc_hd__fill_1
* cell instance sky130_fd_sc_hd__fill_1_1121 r0 *1 0,0
Xsky130_fd_sc_hd__fill_1_1121 VGND VPWR VPWR sky130_fd_sc_hd__fill_1
* cell instance sky130_fd_sc_hd__fill_1_1122 r0 *1 0,0
Xsky130_fd_sc_hd__fill_1_1122 VGND VPWR VPWR sky130_fd_sc_hd__fill_1
* cell instance sky130_fd_sc_hd__fill_1_1123 r0 *1 0,0
Xsky130_fd_sc_hd__fill_1_1123 VGND VPWR VPWR sky130_fd_sc_hd__fill_1
* cell instance sky130_fd_sc_hd__fill_1_1124 r0 *1 0,0
Xsky130_fd_sc_hd__fill_1_1124 VGND VPWR VPWR sky130_fd_sc_hd__fill_1
* cell instance sky130_fd_sc_hd__fill_1_1125 r0 *1 0,0
Xsky130_fd_sc_hd__fill_1_1125 VGND VPWR VPWR sky130_fd_sc_hd__fill_1
* cell instance sky130_fd_sc_hd__fill_1_1126 r0 *1 0,0
Xsky130_fd_sc_hd__fill_1_1126 VGND VPWR VPWR sky130_fd_sc_hd__fill_1
* cell instance sky130_fd_sc_hd__fill_1_1127 r0 *1 0,0
Xsky130_fd_sc_hd__fill_1_1127 VGND VPWR VPWR sky130_fd_sc_hd__fill_1
* cell instance sky130_fd_sc_hd__fill_1_1128 r0 *1 0,0
Xsky130_fd_sc_hd__fill_1_1128 VGND VPWR VPWR sky130_fd_sc_hd__fill_1
* cell instance sky130_fd_sc_hd__fill_1_1129 r0 *1 0,0
Xsky130_fd_sc_hd__fill_1_1129 VGND VPWR VPWR sky130_fd_sc_hd__fill_1
* cell instance sky130_fd_sc_hd__fill_1_1130 r0 *1 0,0
Xsky130_fd_sc_hd__fill_1_1130 VGND VPWR VPWR sky130_fd_sc_hd__fill_1
* cell instance sky130_fd_sc_hd__fill_1_1131 r0 *1 0,0
Xsky130_fd_sc_hd__fill_1_1131 VGND VPWR VPWR sky130_fd_sc_hd__fill_1
* cell instance sky130_fd_sc_hd__fill_1_1132 r0 *1 0,0
Xsky130_fd_sc_hd__fill_1_1132 VGND VPWR VPWR sky130_fd_sc_hd__fill_1
* cell instance sky130_fd_sc_hd__fill_1_1133 r0 *1 0,0
Xsky130_fd_sc_hd__fill_1_1133 VGND VPWR VPWR sky130_fd_sc_hd__fill_1
* cell instance sky130_fd_sc_hd__fill_1_1134 r0 *1 0,0
Xsky130_fd_sc_hd__fill_1_1134 VGND VPWR VPWR sky130_fd_sc_hd__fill_1
* cell instance sky130_fd_sc_hd__fill_1_1135 r0 *1 0,0
Xsky130_fd_sc_hd__fill_1_1135 VGND VPWR VPWR sky130_fd_sc_hd__fill_1
* cell instance sky130_fd_sc_hd__fill_1_1136 r0 *1 0,0
Xsky130_fd_sc_hd__fill_1_1136 VGND VPWR VPWR sky130_fd_sc_hd__fill_1
* cell instance sky130_fd_sc_hd__fill_1_1137 r0 *1 0,0
Xsky130_fd_sc_hd__fill_1_1137 VGND VPWR VPWR sky130_fd_sc_hd__fill_1
* cell instance sky130_fd_sc_hd__fill_1_1138 r0 *1 0,0
Xsky130_fd_sc_hd__fill_1_1138 VGND VPWR VPWR sky130_fd_sc_hd__fill_1
* cell instance sky130_fd_sc_hd__fill_1_1139 r0 *1 0,0
Xsky130_fd_sc_hd__fill_1_1139 VGND VPWR VPWR sky130_fd_sc_hd__fill_1
* cell instance sky130_fd_sc_hd__fill_1_1140 r0 *1 0,0
Xsky130_fd_sc_hd__fill_1_1140 VGND VPWR VPWR sky130_fd_sc_hd__fill_1
* cell instance sky130_fd_sc_hd__fill_1_1141 r0 *1 0,0
Xsky130_fd_sc_hd__fill_1_1141 VGND VPWR VPWR sky130_fd_sc_hd__fill_1
* cell instance sky130_fd_sc_hd__fill_1_1142 r0 *1 0,0
Xsky130_fd_sc_hd__fill_1_1142 VGND VPWR VPWR sky130_fd_sc_hd__fill_1
* cell instance sky130_fd_sc_hd__fill_1_1143 r0 *1 0,0
Xsky130_fd_sc_hd__fill_1_1143 VGND VPWR VPWR sky130_fd_sc_hd__fill_1
* cell instance sky130_fd_sc_hd__fill_1_1144 r0 *1 0,0
Xsky130_fd_sc_hd__fill_1_1144 VGND VPWR VPWR sky130_fd_sc_hd__fill_1
* cell instance sky130_fd_sc_hd__fill_1_1145 r0 *1 0,0
Xsky130_fd_sc_hd__fill_1_1145 VGND VPWR VPWR sky130_fd_sc_hd__fill_1
* cell instance sky130_fd_sc_hd__fill_1_1146 r0 *1 0,0
Xsky130_fd_sc_hd__fill_1_1146 VGND VPWR VPWR sky130_fd_sc_hd__fill_1
* cell instance sky130_fd_sc_hd__fill_1_1147 r0 *1 0,0
Xsky130_fd_sc_hd__fill_1_1147 VGND VPWR VPWR sky130_fd_sc_hd__fill_1
* cell instance sky130_fd_sc_hd__fill_1_1148 r0 *1 0,0
Xsky130_fd_sc_hd__fill_1_1148 VGND VPWR VPWR sky130_fd_sc_hd__fill_1
* cell instance sky130_fd_sc_hd__fill_1_1149 r0 *1 0,0
Xsky130_fd_sc_hd__fill_1_1149 VGND VPWR VPWR sky130_fd_sc_hd__fill_1
* cell instance sky130_fd_sc_hd__fill_1_1150 r0 *1 0,0
Xsky130_fd_sc_hd__fill_1_1150 VGND VPWR VPWR sky130_fd_sc_hd__fill_1
* cell instance sky130_fd_sc_hd__fill_1_1151 r0 *1 0,0
Xsky130_fd_sc_hd__fill_1_1151 VGND VPWR VPWR sky130_fd_sc_hd__fill_1
* cell instance sky130_fd_sc_hd__fill_1_1152 r0 *1 0,0
Xsky130_fd_sc_hd__fill_1_1152 VGND VPWR VPWR sky130_fd_sc_hd__fill_1
* cell instance sky130_fd_sc_hd__fill_1_1153 r0 *1 0,0
Xsky130_fd_sc_hd__fill_1_1153 VGND VPWR VPWR sky130_fd_sc_hd__fill_1
* cell instance sky130_fd_sc_hd__fill_1_1154 r0 *1 0,0
Xsky130_fd_sc_hd__fill_1_1154 VGND VPWR VPWR sky130_fd_sc_hd__fill_1
* cell instance sky130_fd_sc_hd__fill_1_1155 r0 *1 0,0
Xsky130_fd_sc_hd__fill_1_1155 VGND VPWR VPWR sky130_fd_sc_hd__fill_1
* cell instance sky130_fd_sc_hd__fill_1_1156 r0 *1 0,0
Xsky130_fd_sc_hd__fill_1_1156 VGND VPWR VPWR sky130_fd_sc_hd__fill_1
* cell instance sky130_fd_sc_hd__fill_1_1157 r0 *1 0,0
Xsky130_fd_sc_hd__fill_1_1157 VGND VPWR VPWR sky130_fd_sc_hd__fill_1
* cell instance sky130_fd_sc_hd__fill_1_1158 r0 *1 0,0
Xsky130_fd_sc_hd__fill_1_1158 VGND VPWR VPWR sky130_fd_sc_hd__fill_1
* cell instance sky130_fd_sc_hd__fill_1_1159 r0 *1 0,0
Xsky130_fd_sc_hd__fill_1_1159 VGND VPWR VPWR sky130_fd_sc_hd__fill_1
* cell instance sky130_fd_sc_hd__fill_1_1160 r0 *1 0,0
Xsky130_fd_sc_hd__fill_1_1160 VGND VPWR VPWR sky130_fd_sc_hd__fill_1
* cell instance sky130_fd_sc_hd__fill_1_1161 r0 *1 0,0
Xsky130_fd_sc_hd__fill_1_1161 VGND VPWR VPWR sky130_fd_sc_hd__fill_1
* cell instance sky130_fd_sc_hd__fill_1_1162 r0 *1 0,0
Xsky130_fd_sc_hd__fill_1_1162 VGND VPWR VPWR sky130_fd_sc_hd__fill_1
* cell instance sky130_fd_sc_hd__fill_1_1163 r0 *1 0,0
Xsky130_fd_sc_hd__fill_1_1163 VGND VPWR VPWR sky130_fd_sc_hd__fill_1
* cell instance sky130_fd_sc_hd__fill_1_1164 r0 *1 0,0
Xsky130_fd_sc_hd__fill_1_1164 VGND VPWR VPWR sky130_fd_sc_hd__fill_1
* cell instance sky130_fd_sc_hd__fill_1_1165 r0 *1 0,0
Xsky130_fd_sc_hd__fill_1_1165 VGND VPWR VPWR sky130_fd_sc_hd__fill_1
* cell instance sky130_fd_sc_hd__fill_1_1166 r0 *1 0,0
Xsky130_fd_sc_hd__fill_1_1166 VGND VPWR VPWR sky130_fd_sc_hd__fill_1
* cell instance sky130_fd_sc_hd__fill_1_1167 r0 *1 0,0
Xsky130_fd_sc_hd__fill_1_1167 VGND VPWR VPWR sky130_fd_sc_hd__fill_1
* cell instance sky130_fd_sc_hd__fill_1_1168 r0 *1 0,0
Xsky130_fd_sc_hd__fill_1_1168 VGND VPWR VPWR sky130_fd_sc_hd__fill_1
* cell instance sky130_fd_sc_hd__fill_1_1169 r0 *1 0,0
Xsky130_fd_sc_hd__fill_1_1169 VGND VPWR VPWR sky130_fd_sc_hd__fill_1
* cell instance sky130_fd_sc_hd__fill_1_1170 r0 *1 0,0
Xsky130_fd_sc_hd__fill_1_1170 VGND VPWR VPWR sky130_fd_sc_hd__fill_1
* cell instance sky130_fd_sc_hd__fill_1_1171 r0 *1 0,0
Xsky130_fd_sc_hd__fill_1_1171 VGND VPWR VPWR sky130_fd_sc_hd__fill_1
* cell instance sky130_fd_sc_hd__fill_1_1172 r0 *1 0,0
Xsky130_fd_sc_hd__fill_1_1172 VGND VPWR VPWR sky130_fd_sc_hd__fill_1
* cell instance sky130_fd_sc_hd__fill_1_1173 r0 *1 0,0
Xsky130_fd_sc_hd__fill_1_1173 VGND VPWR VPWR sky130_fd_sc_hd__fill_1
* cell instance sky130_fd_sc_hd__fill_1_1174 r0 *1 0,0
Xsky130_fd_sc_hd__fill_1_1174 VGND VPWR VPWR sky130_fd_sc_hd__fill_1
* cell instance sky130_fd_sc_hd__fill_1_1175 r0 *1 0,0
Xsky130_fd_sc_hd__fill_1_1175 VGND VPWR VPWR sky130_fd_sc_hd__fill_1
* cell instance sky130_fd_sc_hd__fill_1_1176 r0 *1 0,0
Xsky130_fd_sc_hd__fill_1_1176 VGND VPWR VPWR sky130_fd_sc_hd__fill_1
* cell instance sky130_fd_sc_hd__fill_1_1177 r0 *1 0,0
Xsky130_fd_sc_hd__fill_1_1177 VGND VPWR VPWR sky130_fd_sc_hd__fill_1
* cell instance sky130_fd_sc_hd__fill_1_1178 r0 *1 0,0
Xsky130_fd_sc_hd__fill_1_1178 VGND VPWR VPWR sky130_fd_sc_hd__fill_1
* cell instance sky130_fd_sc_hd__fill_1_1179 r0 *1 0,0
Xsky130_fd_sc_hd__fill_1_1179 VGND VPWR VPWR sky130_fd_sc_hd__fill_1
* cell instance sky130_fd_sc_hd__fill_1_1180 r0 *1 0,0
Xsky130_fd_sc_hd__fill_1_1180 VGND VPWR VPWR sky130_fd_sc_hd__fill_1
* cell instance sky130_fd_sc_hd__fill_1_1181 r0 *1 0,0
Xsky130_fd_sc_hd__fill_1_1181 VGND VPWR VPWR sky130_fd_sc_hd__fill_1
* cell instance sky130_fd_sc_hd__fill_1_1182 r0 *1 0,0
Xsky130_fd_sc_hd__fill_1_1182 VGND VPWR VPWR sky130_fd_sc_hd__fill_1
* cell instance sky130_fd_sc_hd__fill_1_1183 r0 *1 0,0
Xsky130_fd_sc_hd__fill_1_1183 VGND VPWR VPWR sky130_fd_sc_hd__fill_1
* cell instance sky130_fd_sc_hd__fill_1_1184 r0 *1 0,0
Xsky130_fd_sc_hd__fill_1_1184 VGND VPWR VPWR sky130_fd_sc_hd__fill_1
* cell instance sky130_fd_sc_hd__fill_1_1185 r0 *1 0,0
Xsky130_fd_sc_hd__fill_1_1185 VGND VPWR VPWR sky130_fd_sc_hd__fill_1
* cell instance sky130_fd_sc_hd__fill_1_1186 r0 *1 0,0
Xsky130_fd_sc_hd__fill_1_1186 VGND VPWR VPWR sky130_fd_sc_hd__fill_1
* cell instance sky130_fd_sc_hd__fill_1_1187 r0 *1 0,0
Xsky130_fd_sc_hd__fill_1_1187 VGND VPWR VPWR sky130_fd_sc_hd__fill_1
* cell instance sky130_fd_sc_hd__fill_1_1188 r0 *1 0,0
Xsky130_fd_sc_hd__fill_1_1188 VGND VPWR VPWR sky130_fd_sc_hd__fill_1
* cell instance sky130_fd_sc_hd__fill_1_1189 r0 *1 0,0
Xsky130_fd_sc_hd__fill_1_1189 VGND VPWR VPWR sky130_fd_sc_hd__fill_1
* cell instance sky130_fd_sc_hd__fill_1_1190 r0 *1 0,0
Xsky130_fd_sc_hd__fill_1_1190 VGND VPWR VPWR sky130_fd_sc_hd__fill_1
* cell instance sky130_fd_sc_hd__fill_1_1191 r0 *1 0,0
Xsky130_fd_sc_hd__fill_1_1191 VGND VPWR VPWR sky130_fd_sc_hd__fill_1
* cell instance sky130_fd_sc_hd__fill_1_1192 r0 *1 0,0
Xsky130_fd_sc_hd__fill_1_1192 VGND VPWR VPWR sky130_fd_sc_hd__fill_1
* cell instance sky130_fd_sc_hd__fill_1_1193 r0 *1 0,0
Xsky130_fd_sc_hd__fill_1_1193 VGND VPWR VPWR sky130_fd_sc_hd__fill_1
* cell instance sky130_fd_sc_hd__fill_1_1194 r0 *1 0,0
Xsky130_fd_sc_hd__fill_1_1194 VGND VPWR VPWR sky130_fd_sc_hd__fill_1
* cell instance sky130_fd_sc_hd__fill_1_1195 r0 *1 0,0
Xsky130_fd_sc_hd__fill_1_1195 VGND VPWR VPWR sky130_fd_sc_hd__fill_1
* cell instance sky130_fd_sc_hd__fill_1_1196 r0 *1 0,0
Xsky130_fd_sc_hd__fill_1_1196 VGND VPWR VPWR sky130_fd_sc_hd__fill_1
* cell instance sky130_fd_sc_hd__fill_1_1197 r0 *1 0,0
Xsky130_fd_sc_hd__fill_1_1197 VGND VPWR VPWR sky130_fd_sc_hd__fill_1
* cell instance sky130_fd_sc_hd__fill_1_1198 r0 *1 0,0
Xsky130_fd_sc_hd__fill_1_1198 VGND VPWR VPWR sky130_fd_sc_hd__fill_1
* cell instance sky130_fd_sc_hd__fill_1_1199 r0 *1 0,0
Xsky130_fd_sc_hd__fill_1_1199 VGND VPWR VPWR sky130_fd_sc_hd__fill_1
* cell instance sky130_fd_sc_hd__fill_1_1200 r0 *1 0,0
Xsky130_fd_sc_hd__fill_1_1200 VGND VPWR VPWR sky130_fd_sc_hd__fill_1
* cell instance sky130_fd_sc_hd__fill_1_1201 r0 *1 0,0
Xsky130_fd_sc_hd__fill_1_1201 VGND VPWR VPWR sky130_fd_sc_hd__fill_1
* cell instance sky130_fd_sc_hd__fill_1_1202 r0 *1 0,0
Xsky130_fd_sc_hd__fill_1_1202 VGND VPWR VPWR sky130_fd_sc_hd__fill_1
* cell instance sky130_fd_sc_hd__fill_1_1203 r0 *1 0,0
Xsky130_fd_sc_hd__fill_1_1203 VGND VPWR VPWR sky130_fd_sc_hd__fill_1
* cell instance sky130_fd_sc_hd__fill_1_1204 r0 *1 0,0
Xsky130_fd_sc_hd__fill_1_1204 VGND VPWR VPWR sky130_fd_sc_hd__fill_1
* cell instance sky130_fd_sc_hd__fill_1_1205 r0 *1 0,0
Xsky130_fd_sc_hd__fill_1_1205 VGND VPWR VPWR sky130_fd_sc_hd__fill_1
* cell instance sky130_fd_sc_hd__fill_1_1206 r0 *1 0,0
Xsky130_fd_sc_hd__fill_1_1206 VGND VPWR VPWR sky130_fd_sc_hd__fill_1
* cell instance sky130_fd_sc_hd__fill_1_1207 r0 *1 0,0
Xsky130_fd_sc_hd__fill_1_1207 VGND VPWR VPWR sky130_fd_sc_hd__fill_1
* cell instance sky130_fd_sc_hd__fill_1_1208 r0 *1 0,0
Xsky130_fd_sc_hd__fill_1_1208 VGND VPWR VPWR sky130_fd_sc_hd__fill_1
* cell instance sky130_fd_sc_hd__fill_1_1209 r0 *1 0,0
Xsky130_fd_sc_hd__fill_1_1209 VGND VPWR VPWR sky130_fd_sc_hd__fill_1
* cell instance sky130_fd_sc_hd__fill_1_1210 r0 *1 0,0
Xsky130_fd_sc_hd__fill_1_1210 VGND VPWR VPWR sky130_fd_sc_hd__fill_1
* cell instance sky130_fd_sc_hd__fill_1_1211 r0 *1 0,0
Xsky130_fd_sc_hd__fill_1_1211 VGND VPWR VPWR sky130_fd_sc_hd__fill_1
* cell instance sky130_fd_sc_hd__fill_1_1212 r0 *1 0,0
Xsky130_fd_sc_hd__fill_1_1212 VGND VPWR VPWR sky130_fd_sc_hd__fill_1
* cell instance sky130_fd_sc_hd__fill_1_1213 r0 *1 0,0
Xsky130_fd_sc_hd__fill_1_1213 VGND VPWR VPWR sky130_fd_sc_hd__fill_1
* cell instance sky130_fd_sc_hd__fill_1_1214 r0 *1 0,0
Xsky130_fd_sc_hd__fill_1_1214 VGND VPWR VPWR sky130_fd_sc_hd__fill_1
* cell instance sky130_fd_sc_hd__fill_1_1215 r0 *1 0,0
Xsky130_fd_sc_hd__fill_1_1215 VGND VPWR VPWR sky130_fd_sc_hd__fill_1
* cell instance sky130_fd_sc_hd__fill_1_1216 r0 *1 0,0
Xsky130_fd_sc_hd__fill_1_1216 VGND VPWR VPWR sky130_fd_sc_hd__fill_1
* cell instance sky130_fd_sc_hd__fill_1_1217 r0 *1 0,0
Xsky130_fd_sc_hd__fill_1_1217 VGND VPWR VPWR sky130_fd_sc_hd__fill_1
* cell instance sky130_fd_sc_hd__fill_1_1218 r0 *1 0,0
Xsky130_fd_sc_hd__fill_1_1218 VGND VPWR VPWR sky130_fd_sc_hd__fill_1
* cell instance sky130_fd_sc_hd__fill_1_1219 r0 *1 0,0
Xsky130_fd_sc_hd__fill_1_1219 VGND VPWR VPWR sky130_fd_sc_hd__fill_1
* cell instance sky130_fd_sc_hd__fill_1_1220 r0 *1 0,0
Xsky130_fd_sc_hd__fill_1_1220 VGND VPWR VPWR sky130_fd_sc_hd__fill_1
* cell instance sky130_fd_sc_hd__fill_1_1221 r0 *1 0,0
Xsky130_fd_sc_hd__fill_1_1221 VGND VPWR VPWR sky130_fd_sc_hd__fill_1
* cell instance sky130_fd_sc_hd__fill_1_1222 r0 *1 0,0
Xsky130_fd_sc_hd__fill_1_1222 VGND VPWR VPWR sky130_fd_sc_hd__fill_1
* cell instance sky130_fd_sc_hd__fill_1_1223 r0 *1 0,0
Xsky130_fd_sc_hd__fill_1_1223 VGND VPWR VPWR sky130_fd_sc_hd__fill_1
* cell instance sky130_fd_sc_hd__fill_1_1224 r0 *1 0,0
Xsky130_fd_sc_hd__fill_1_1224 VGND VPWR VPWR sky130_fd_sc_hd__fill_1
* cell instance sky130_fd_sc_hd__fill_1_1225 r0 *1 0,0
Xsky130_fd_sc_hd__fill_1_1225 VGND VPWR VPWR sky130_fd_sc_hd__fill_1
* cell instance sky130_fd_sc_hd__fill_1_1226 r0 *1 0,0
Xsky130_fd_sc_hd__fill_1_1226 VGND VPWR VPWR sky130_fd_sc_hd__fill_1
* cell instance sky130_fd_sc_hd__fill_1_1227 r0 *1 0,0
Xsky130_fd_sc_hd__fill_1_1227 VGND VPWR VPWR sky130_fd_sc_hd__fill_1
* cell instance sky130_fd_sc_hd__fill_1_1228 r0 *1 0,0
Xsky130_fd_sc_hd__fill_1_1228 VGND VPWR VPWR sky130_fd_sc_hd__fill_1
* cell instance sky130_fd_sc_hd__fill_1_1229 r0 *1 0,0
Xsky130_fd_sc_hd__fill_1_1229 VGND VPWR VPWR sky130_fd_sc_hd__fill_1
* cell instance sky130_fd_sc_hd__fill_1_1230 r0 *1 0,0
Xsky130_fd_sc_hd__fill_1_1230 VGND VPWR VPWR sky130_fd_sc_hd__fill_1
* cell instance sky130_fd_sc_hd__fill_1_1231 r0 *1 0,0
Xsky130_fd_sc_hd__fill_1_1231 VGND VPWR VPWR sky130_fd_sc_hd__fill_1
* cell instance sky130_fd_sc_hd__fill_1_1232 r0 *1 0,0
Xsky130_fd_sc_hd__fill_1_1232 VGND VPWR VPWR sky130_fd_sc_hd__fill_1
* cell instance sky130_fd_sc_hd__fill_1_1233 r0 *1 0,0
Xsky130_fd_sc_hd__fill_1_1233 VGND VPWR VPWR sky130_fd_sc_hd__fill_1
* cell instance sky130_fd_sc_hd__fill_1_1234 r0 *1 0,0
Xsky130_fd_sc_hd__fill_1_1234 VGND VPWR VPWR sky130_fd_sc_hd__fill_1
* cell instance sky130_fd_sc_hd__fill_1_1235 r0 *1 0,0
Xsky130_fd_sc_hd__fill_1_1235 VGND VPWR VPWR sky130_fd_sc_hd__fill_1
* cell instance sky130_fd_sc_hd__fill_1_1236 r0 *1 0,0
Xsky130_fd_sc_hd__fill_1_1236 VGND VPWR VPWR sky130_fd_sc_hd__fill_1
* cell instance sky130_fd_sc_hd__fill_1_1237 r0 *1 0,0
Xsky130_fd_sc_hd__fill_1_1237 VGND VPWR VPWR sky130_fd_sc_hd__fill_1
* cell instance sky130_fd_sc_hd__fill_1_1238 r0 *1 0,0
Xsky130_fd_sc_hd__fill_1_1238 VGND VPWR VPWR sky130_fd_sc_hd__fill_1
* cell instance sky130_fd_sc_hd__fill_1_1239 r0 *1 0,0
Xsky130_fd_sc_hd__fill_1_1239 VGND VPWR VPWR sky130_fd_sc_hd__fill_1
* cell instance sky130_fd_sc_hd__fill_1_1240 r0 *1 0,0
Xsky130_fd_sc_hd__fill_1_1240 VGND VPWR VPWR sky130_fd_sc_hd__fill_1
* cell instance sky130_fd_sc_hd__fill_1_1241 r0 *1 0,0
Xsky130_fd_sc_hd__fill_1_1241 VGND VPWR VPWR sky130_fd_sc_hd__fill_1
* cell instance sky130_fd_sc_hd__fill_1_1242 r0 *1 0,0
Xsky130_fd_sc_hd__fill_1_1242 VGND VPWR VPWR sky130_fd_sc_hd__fill_1
* cell instance sky130_fd_sc_hd__fill_1_1243 r0 *1 0,0
Xsky130_fd_sc_hd__fill_1_1243 VGND VPWR VPWR sky130_fd_sc_hd__fill_1
* cell instance sky130_fd_sc_hd__fill_1_1244 r0 *1 0,0
Xsky130_fd_sc_hd__fill_1_1244 VGND VPWR VPWR sky130_fd_sc_hd__fill_1
* cell instance sky130_fd_sc_hd__fill_1_1245 r0 *1 0,0
Xsky130_fd_sc_hd__fill_1_1245 VGND VPWR VPWR sky130_fd_sc_hd__fill_1
* cell instance sky130_fd_sc_hd__fill_1_1246 r0 *1 0,0
Xsky130_fd_sc_hd__fill_1_1246 VGND VPWR VPWR sky130_fd_sc_hd__fill_1
* cell instance sky130_fd_sc_hd__fill_1_1247 r0 *1 0,0
Xsky130_fd_sc_hd__fill_1_1247 VGND VPWR VPWR sky130_fd_sc_hd__fill_1
* cell instance sky130_fd_sc_hd__fill_1_1248 r0 *1 0,0
Xsky130_fd_sc_hd__fill_1_1248 VGND VPWR VPWR sky130_fd_sc_hd__fill_1
* cell instance sky130_fd_sc_hd__fill_1_1249 r0 *1 0,0
Xsky130_fd_sc_hd__fill_1_1249 VGND VPWR VPWR sky130_fd_sc_hd__fill_1
* cell instance sky130_fd_sc_hd__fill_1_1250 r0 *1 0,0
Xsky130_fd_sc_hd__fill_1_1250 VGND VPWR VPWR sky130_fd_sc_hd__fill_1
* cell instance sky130_fd_sc_hd__fill_1_1251 r0 *1 0,0
Xsky130_fd_sc_hd__fill_1_1251 VGND VPWR VPWR sky130_fd_sc_hd__fill_1
* cell instance sky130_fd_sc_hd__fill_1_1252 r0 *1 0,0
Xsky130_fd_sc_hd__fill_1_1252 VGND VPWR VPWR sky130_fd_sc_hd__fill_1
* cell instance sky130_fd_sc_hd__fill_1_1253 r0 *1 0,0
Xsky130_fd_sc_hd__fill_1_1253 VGND VPWR VPWR sky130_fd_sc_hd__fill_1
* cell instance sky130_fd_sc_hd__fill_1_1254 r0 *1 0,0
Xsky130_fd_sc_hd__fill_1_1254 VGND VPWR VPWR sky130_fd_sc_hd__fill_1
* cell instance sky130_fd_sc_hd__fill_1_1255 r0 *1 0,0
Xsky130_fd_sc_hd__fill_1_1255 VGND VPWR VPWR sky130_fd_sc_hd__fill_1
* cell instance sky130_fd_sc_hd__fill_1_1256 r0 *1 0,0
Xsky130_fd_sc_hd__fill_1_1256 VGND VPWR VPWR sky130_fd_sc_hd__fill_1
* cell instance sky130_fd_sc_hd__fill_1_1257 r0 *1 0,0
Xsky130_fd_sc_hd__fill_1_1257 VGND VPWR VPWR sky130_fd_sc_hd__fill_1
* cell instance sky130_fd_sc_hd__fill_1_1258 r0 *1 0,0
Xsky130_fd_sc_hd__fill_1_1258 VGND VPWR VPWR sky130_fd_sc_hd__fill_1
* cell instance sky130_fd_sc_hd__fill_1_1259 r0 *1 0,0
Xsky130_fd_sc_hd__fill_1_1259 VGND VPWR VPWR sky130_fd_sc_hd__fill_1
* cell instance sky130_fd_sc_hd__fill_1_1260 r0 *1 0,0
Xsky130_fd_sc_hd__fill_1_1260 VGND VPWR VPWR sky130_fd_sc_hd__fill_1
* cell instance sky130_fd_sc_hd__fill_1_1261 r0 *1 0,0
Xsky130_fd_sc_hd__fill_1_1261 VGND VPWR VPWR sky130_fd_sc_hd__fill_1
* cell instance sky130_fd_sc_hd__fill_1_1262 r0 *1 0,0
Xsky130_fd_sc_hd__fill_1_1262 VGND VPWR VPWR sky130_fd_sc_hd__fill_1
* cell instance sky130_fd_sc_hd__fill_1_1263 r0 *1 0,0
Xsky130_fd_sc_hd__fill_1_1263 VGND VPWR VPWR sky130_fd_sc_hd__fill_1
* cell instance sky130_fd_sc_hd__fill_1_1264 r0 *1 0,0
Xsky130_fd_sc_hd__fill_1_1264 VGND VPWR VPWR sky130_fd_sc_hd__fill_1
* cell instance sky130_fd_sc_hd__fill_1_1265 r0 *1 0,0
Xsky130_fd_sc_hd__fill_1_1265 VGND VPWR VPWR sky130_fd_sc_hd__fill_1
* cell instance sky130_fd_sc_hd__fill_1_1266 r0 *1 0,0
Xsky130_fd_sc_hd__fill_1_1266 VGND VPWR VPWR sky130_fd_sc_hd__fill_1
* cell instance sky130_fd_sc_hd__fill_1_1267 r0 *1 0,0
Xsky130_fd_sc_hd__fill_1_1267 VGND VPWR VPWR sky130_fd_sc_hd__fill_1
* cell instance sky130_fd_sc_hd__fill_1_1268 r0 *1 0,0
Xsky130_fd_sc_hd__fill_1_1268 VGND VPWR VPWR sky130_fd_sc_hd__fill_1
* cell instance sky130_fd_sc_hd__fill_1_1269 r0 *1 0,0
Xsky130_fd_sc_hd__fill_1_1269 VGND VPWR VPWR sky130_fd_sc_hd__fill_1
* cell instance sky130_fd_sc_hd__fill_1_1270 r0 *1 0,0
Xsky130_fd_sc_hd__fill_1_1270 VGND VPWR VPWR sky130_fd_sc_hd__fill_1
* cell instance sky130_fd_sc_hd__fill_1_1271 r0 *1 0,0
Xsky130_fd_sc_hd__fill_1_1271 VGND VPWR VPWR sky130_fd_sc_hd__fill_1
* cell instance sky130_fd_sc_hd__fill_1_1272 r0 *1 0,0
Xsky130_fd_sc_hd__fill_1_1272 VGND VPWR VPWR sky130_fd_sc_hd__fill_1
* cell instance sky130_fd_sc_hd__fill_1_1273 r0 *1 0,0
Xsky130_fd_sc_hd__fill_1_1273 VGND VPWR VPWR sky130_fd_sc_hd__fill_1
* cell instance sky130_fd_sc_hd__fill_1_1274 r0 *1 0,0
Xsky130_fd_sc_hd__fill_1_1274 VGND VPWR VPWR sky130_fd_sc_hd__fill_1
* cell instance sky130_fd_sc_hd__fill_1_1275 r0 *1 0,0
Xsky130_fd_sc_hd__fill_1_1275 VGND VPWR VPWR sky130_fd_sc_hd__fill_1
* cell instance sky130_fd_sc_hd__fill_1_1276 r0 *1 0,0
Xsky130_fd_sc_hd__fill_1_1276 VGND VPWR VPWR sky130_fd_sc_hd__fill_1
* cell instance sky130_fd_sc_hd__fill_1_1277 r0 *1 0,0
Xsky130_fd_sc_hd__fill_1_1277 VGND VPWR VPWR sky130_fd_sc_hd__fill_1
* cell instance sky130_fd_sc_hd__fill_1_1278 r0 *1 0,0
Xsky130_fd_sc_hd__fill_1_1278 VGND VPWR VPWR sky130_fd_sc_hd__fill_1
* cell instance sky130_fd_sc_hd__fill_1_1279 r0 *1 0,0
Xsky130_fd_sc_hd__fill_1_1279 VGND VPWR VPWR sky130_fd_sc_hd__fill_1
* cell instance sky130_fd_sc_hd__fill_1_1280 r0 *1 0,0
Xsky130_fd_sc_hd__fill_1_1280 VGND VPWR VPWR sky130_fd_sc_hd__fill_1
* cell instance sky130_fd_sc_hd__fill_1_1281 r0 *1 0,0
Xsky130_fd_sc_hd__fill_1_1281 VGND VPWR VPWR sky130_fd_sc_hd__fill_1
* cell instance sky130_fd_sc_hd__fill_1_1282 r0 *1 0,0
Xsky130_fd_sc_hd__fill_1_1282 VGND VPWR VPWR sky130_fd_sc_hd__fill_1
* cell instance sky130_fd_sc_hd__fill_1_1283 r0 *1 0,0
Xsky130_fd_sc_hd__fill_1_1283 VGND VPWR VPWR sky130_fd_sc_hd__fill_1
* cell instance sky130_fd_sc_hd__fill_1_1284 r0 *1 0,0
Xsky130_fd_sc_hd__fill_1_1284 VGND VPWR VPWR sky130_fd_sc_hd__fill_1
* cell instance sky130_fd_sc_hd__fill_1_1285 r0 *1 0,0
Xsky130_fd_sc_hd__fill_1_1285 VGND VPWR VPWR sky130_fd_sc_hd__fill_1
* cell instance sky130_fd_sc_hd__fill_1_1286 r0 *1 0,0
Xsky130_fd_sc_hd__fill_1_1286 VGND VPWR VPWR sky130_fd_sc_hd__fill_1
* cell instance sky130_fd_sc_hd__fill_1_1287 r0 *1 0,0
Xsky130_fd_sc_hd__fill_1_1287 VGND VPWR VPWR sky130_fd_sc_hd__fill_1
* cell instance sky130_fd_sc_hd__fill_1_1288 r0 *1 0,0
Xsky130_fd_sc_hd__fill_1_1288 VGND VPWR VPWR sky130_fd_sc_hd__fill_1
* cell instance sky130_fd_sc_hd__fill_1_1289 r0 *1 0,0
Xsky130_fd_sc_hd__fill_1_1289 VGND VPWR VPWR sky130_fd_sc_hd__fill_1
* cell instance sky130_fd_sc_hd__fill_1_1290 r0 *1 0,0
Xsky130_fd_sc_hd__fill_1_1290 VGND VPWR VPWR sky130_fd_sc_hd__fill_1
* cell instance sky130_fd_sc_hd__fill_1_1291 r0 *1 0,0
Xsky130_fd_sc_hd__fill_1_1291 VGND VPWR VPWR sky130_fd_sc_hd__fill_1
* cell instance sky130_fd_sc_hd__fill_1_1292 r0 *1 0,0
Xsky130_fd_sc_hd__fill_1_1292 VGND VPWR VPWR sky130_fd_sc_hd__fill_1
* cell instance sky130_fd_sc_hd__fill_1_1293 r0 *1 0,0
Xsky130_fd_sc_hd__fill_1_1293 VGND VPWR VPWR sky130_fd_sc_hd__fill_1
* cell instance sky130_fd_sc_hd__fill_1_1294 r0 *1 0,0
Xsky130_fd_sc_hd__fill_1_1294 VGND VPWR VPWR sky130_fd_sc_hd__fill_1
* cell instance sky130_fd_sc_hd__fill_1_1295 r0 *1 0,0
Xsky130_fd_sc_hd__fill_1_1295 VGND VPWR VPWR sky130_fd_sc_hd__fill_1
* cell instance sky130_fd_sc_hd__fill_1_1296 r0 *1 0,0
Xsky130_fd_sc_hd__fill_1_1296 VGND VPWR VPWR sky130_fd_sc_hd__fill_1
* cell instance sky130_fd_sc_hd__fill_1_1297 r0 *1 0,0
Xsky130_fd_sc_hd__fill_1_1297 VGND VPWR VPWR sky130_fd_sc_hd__fill_1
* cell instance sky130_fd_sc_hd__fill_1_1298 r0 *1 0,0
Xsky130_fd_sc_hd__fill_1_1298 VGND VPWR VPWR sky130_fd_sc_hd__fill_1
* cell instance sky130_fd_sc_hd__fill_1_1299 r0 *1 0,0
Xsky130_fd_sc_hd__fill_1_1299 VGND VPWR VPWR sky130_fd_sc_hd__fill_1
* cell instance sky130_fd_sc_hd__fill_1_1300 r0 *1 0,0
Xsky130_fd_sc_hd__fill_1_1300 VGND VPWR VPWR sky130_fd_sc_hd__fill_1
* cell instance sky130_fd_sc_hd__fill_1_1301 r0 *1 0,0
Xsky130_fd_sc_hd__fill_1_1301 VGND VPWR VPWR sky130_fd_sc_hd__fill_1
* cell instance sky130_fd_sc_hd__fill_1_1302 r0 *1 0,0
Xsky130_fd_sc_hd__fill_1_1302 VGND VPWR VPWR sky130_fd_sc_hd__fill_1
* cell instance sky130_fd_sc_hd__fill_1_1303 r0 *1 0,0
Xsky130_fd_sc_hd__fill_1_1303 VGND VPWR VPWR sky130_fd_sc_hd__fill_1
* cell instance sky130_fd_sc_hd__fill_1_1304 r0 *1 0,0
Xsky130_fd_sc_hd__fill_1_1304 VGND VPWR VPWR sky130_fd_sc_hd__fill_1
* cell instance sky130_fd_sc_hd__fill_1_1305 r0 *1 0,0
Xsky130_fd_sc_hd__fill_1_1305 VGND VPWR VPWR sky130_fd_sc_hd__fill_1
* cell instance sky130_fd_sc_hd__fill_1_1306 r0 *1 0,0
Xsky130_fd_sc_hd__fill_1_1306 VGND VPWR VPWR sky130_fd_sc_hd__fill_1
* cell instance sky130_fd_sc_hd__fill_1_1307 r0 *1 0,0
Xsky130_fd_sc_hd__fill_1_1307 VGND VPWR VPWR sky130_fd_sc_hd__fill_1
* cell instance sky130_fd_sc_hd__fill_1_1308 r0 *1 0,0
Xsky130_fd_sc_hd__fill_1_1308 VGND VPWR VPWR sky130_fd_sc_hd__fill_1
* cell instance sky130_fd_sc_hd__fill_1_1309 r0 *1 0,0
Xsky130_fd_sc_hd__fill_1_1309 VGND VPWR VPWR sky130_fd_sc_hd__fill_1
* cell instance sky130_fd_sc_hd__fill_1_1310 r0 *1 0,0
Xsky130_fd_sc_hd__fill_1_1310 VGND VPWR VPWR sky130_fd_sc_hd__fill_1
* cell instance sky130_fd_sc_hd__fill_1_1311 r0 *1 0,0
Xsky130_fd_sc_hd__fill_1_1311 VGND VPWR VPWR sky130_fd_sc_hd__fill_1
* cell instance sky130_fd_sc_hd__fill_1_1312 r0 *1 0,0
Xsky130_fd_sc_hd__fill_1_1312 VGND VPWR VPWR sky130_fd_sc_hd__fill_1
* cell instance sky130_fd_sc_hd__fill_1_1313 r0 *1 0,0
Xsky130_fd_sc_hd__fill_1_1313 VGND VPWR VPWR sky130_fd_sc_hd__fill_1
* cell instance sky130_fd_sc_hd__fill_1_1314 r0 *1 0,0
Xsky130_fd_sc_hd__fill_1_1314 VGND VPWR VPWR sky130_fd_sc_hd__fill_1
* cell instance sky130_fd_sc_hd__fill_1_1315 r0 *1 0,0
Xsky130_fd_sc_hd__fill_1_1315 VGND VPWR VPWR sky130_fd_sc_hd__fill_1
* cell instance sky130_fd_sc_hd__fill_1_1316 r0 *1 0,0
Xsky130_fd_sc_hd__fill_1_1316 VGND VPWR VPWR sky130_fd_sc_hd__fill_1
* cell instance sky130_fd_sc_hd__fill_1_1317 r0 *1 0,0
Xsky130_fd_sc_hd__fill_1_1317 VGND VPWR VPWR sky130_fd_sc_hd__fill_1
* cell instance sky130_fd_sc_hd__fill_1_1318 r0 *1 0,0
Xsky130_fd_sc_hd__fill_1_1318 VGND VPWR VPWR sky130_fd_sc_hd__fill_1
* cell instance sky130_fd_sc_hd__fill_1_1319 r0 *1 0,0
Xsky130_fd_sc_hd__fill_1_1319 VGND VPWR VPWR sky130_fd_sc_hd__fill_1
* cell instance sky130_fd_sc_hd__fill_1_1320 r0 *1 0,0
Xsky130_fd_sc_hd__fill_1_1320 VGND VPWR VPWR sky130_fd_sc_hd__fill_1
* cell instance sky130_fd_sc_hd__fill_1_1321 r0 *1 0,0
Xsky130_fd_sc_hd__fill_1_1321 VGND VPWR VPWR sky130_fd_sc_hd__fill_1
* cell instance sky130_fd_sc_hd__fill_1_1322 r0 *1 0,0
Xsky130_fd_sc_hd__fill_1_1322 VGND VPWR VPWR sky130_fd_sc_hd__fill_1
* cell instance sky130_fd_sc_hd__fill_1_1323 r0 *1 0,0
Xsky130_fd_sc_hd__fill_1_1323 VGND VPWR VPWR sky130_fd_sc_hd__fill_1
* cell instance sky130_fd_sc_hd__fill_1_1324 r0 *1 0,0
Xsky130_fd_sc_hd__fill_1_1324 VGND VPWR VPWR sky130_fd_sc_hd__fill_1
* cell instance sky130_fd_sc_hd__fill_1_1325 r0 *1 0,0
Xsky130_fd_sc_hd__fill_1_1325 VGND VPWR VPWR sky130_fd_sc_hd__fill_1
* cell instance sky130_fd_sc_hd__fill_1_1326 r0 *1 0,0
Xsky130_fd_sc_hd__fill_1_1326 VGND VPWR VPWR sky130_fd_sc_hd__fill_1
* cell instance sky130_fd_sc_hd__fill_1_1327 r0 *1 0,0
Xsky130_fd_sc_hd__fill_1_1327 VGND VPWR VPWR sky130_fd_sc_hd__fill_1
* cell instance sky130_fd_sc_hd__fill_1_1328 r0 *1 0,0
Xsky130_fd_sc_hd__fill_1_1328 VGND VPWR VPWR sky130_fd_sc_hd__fill_1
* cell instance sky130_fd_sc_hd__fill_2_0 r0 *1 0,0
Xsky130_fd_sc_hd__fill_2_0 VGND VPWR VPWR sky130_fd_sc_hd__fill_2
* cell instance sky130_fd_sc_hd__fill_2_1 r0 *1 0,0
Xsky130_fd_sc_hd__fill_2_1 VGND VPWR VPWR sky130_fd_sc_hd__fill_2
* cell instance sky130_fd_sc_hd__fill_2_2 r0 *1 0,0
Xsky130_fd_sc_hd__fill_2_2 VGND VPWR VPWR sky130_fd_sc_hd__fill_2
* cell instance sky130_fd_sc_hd__fill_2_3 r0 *1 0,0
Xsky130_fd_sc_hd__fill_2_3 VGND VPWR VPWR sky130_fd_sc_hd__fill_2
* cell instance sky130_fd_sc_hd__fill_2_4 r0 *1 0,0
Xsky130_fd_sc_hd__fill_2_4 VGND VPWR VPWR sky130_fd_sc_hd__fill_2
* cell instance sky130_fd_sc_hd__fill_2_5 r0 *1 0,0
Xsky130_fd_sc_hd__fill_2_5 VGND VPWR VPWR sky130_fd_sc_hd__fill_2
* cell instance sky130_fd_sc_hd__fill_2_6 r0 *1 0,0
Xsky130_fd_sc_hd__fill_2_6 VGND VPWR VPWR sky130_fd_sc_hd__fill_2
* cell instance sky130_fd_sc_hd__fill_2_7 r0 *1 0,0
Xsky130_fd_sc_hd__fill_2_7 VGND VPWR VPWR sky130_fd_sc_hd__fill_2
* cell instance sky130_fd_sc_hd__fill_2_8 r0 *1 0,0
Xsky130_fd_sc_hd__fill_2_8 VGND VPWR VPWR sky130_fd_sc_hd__fill_2
* cell instance sky130_fd_sc_hd__fill_2_9 r0 *1 0,0
Xsky130_fd_sc_hd__fill_2_9 VGND VPWR VPWR sky130_fd_sc_hd__fill_2
* cell instance sky130_fd_sc_hd__fill_2_10 r0 *1 0,0
Xsky130_fd_sc_hd__fill_2_10 VGND VPWR VPWR sky130_fd_sc_hd__fill_2
* cell instance sky130_fd_sc_hd__fill_2_11 r0 *1 0,0
Xsky130_fd_sc_hd__fill_2_11 VGND VPWR VPWR sky130_fd_sc_hd__fill_2
* cell instance sky130_fd_sc_hd__fill_2_12 r0 *1 0,0
Xsky130_fd_sc_hd__fill_2_12 VGND VPWR VPWR sky130_fd_sc_hd__fill_2
* cell instance sky130_fd_sc_hd__fill_2_13 r0 *1 0,0
Xsky130_fd_sc_hd__fill_2_13 VGND VPWR VPWR sky130_fd_sc_hd__fill_2
* cell instance sky130_fd_sc_hd__fill_2_14 r0 *1 0,0
Xsky130_fd_sc_hd__fill_2_14 VGND VPWR VPWR sky130_fd_sc_hd__fill_2
* cell instance sky130_fd_sc_hd__fill_2_15 r0 *1 0,0
Xsky130_fd_sc_hd__fill_2_15 VGND VPWR VPWR sky130_fd_sc_hd__fill_2
* cell instance sky130_fd_sc_hd__fill_2_16 r0 *1 0,0
Xsky130_fd_sc_hd__fill_2_16 VGND VPWR VPWR sky130_fd_sc_hd__fill_2
* cell instance sky130_fd_sc_hd__fill_2_17 r0 *1 0,0
Xsky130_fd_sc_hd__fill_2_17 VGND VPWR VPWR sky130_fd_sc_hd__fill_2
* cell instance sky130_fd_sc_hd__fill_2_18 r0 *1 0,0
Xsky130_fd_sc_hd__fill_2_18 VGND VPWR VPWR sky130_fd_sc_hd__fill_2
* cell instance sky130_fd_sc_hd__fill_2_19 r0 *1 0,0
Xsky130_fd_sc_hd__fill_2_19 VGND VPWR VPWR sky130_fd_sc_hd__fill_2
* cell instance sky130_fd_sc_hd__fill_2_20 r0 *1 0,0
Xsky130_fd_sc_hd__fill_2_20 VGND VPWR VPWR sky130_fd_sc_hd__fill_2
* cell instance sky130_fd_sc_hd__fill_2_21 r0 *1 0,0
Xsky130_fd_sc_hd__fill_2_21 VGND VPWR VPWR sky130_fd_sc_hd__fill_2
* cell instance sky130_fd_sc_hd__fill_2_22 r0 *1 0,0
Xsky130_fd_sc_hd__fill_2_22 VGND VPWR VPWR sky130_fd_sc_hd__fill_2
* cell instance sky130_fd_sc_hd__fill_2_23 r0 *1 0,0
Xsky130_fd_sc_hd__fill_2_23 VGND VPWR VPWR sky130_fd_sc_hd__fill_2
* cell instance sky130_fd_sc_hd__fill_2_24 r0 *1 0,0
Xsky130_fd_sc_hd__fill_2_24 VGND VPWR VPWR sky130_fd_sc_hd__fill_2
* cell instance sky130_fd_sc_hd__fill_2_25 r0 *1 0,0
Xsky130_fd_sc_hd__fill_2_25 VGND VPWR VPWR sky130_fd_sc_hd__fill_2
* cell instance sky130_fd_sc_hd__fill_2_26 r0 *1 0,0
Xsky130_fd_sc_hd__fill_2_26 VGND VPWR VPWR sky130_fd_sc_hd__fill_2
* cell instance sky130_fd_sc_hd__fill_2_27 r0 *1 0,0
Xsky130_fd_sc_hd__fill_2_27 VGND VPWR VPWR sky130_fd_sc_hd__fill_2
* cell instance sky130_fd_sc_hd__fill_2_28 r0 *1 0,0
Xsky130_fd_sc_hd__fill_2_28 VGND VPWR VPWR sky130_fd_sc_hd__fill_2
* cell instance sky130_fd_sc_hd__fill_2_29 r0 *1 0,0
Xsky130_fd_sc_hd__fill_2_29 VGND VPWR VPWR sky130_fd_sc_hd__fill_2
* cell instance sky130_fd_sc_hd__fill_2_30 r0 *1 0,0
Xsky130_fd_sc_hd__fill_2_30 VGND VPWR VPWR sky130_fd_sc_hd__fill_2
* cell instance sky130_fd_sc_hd__fill_2_31 r0 *1 0,0
Xsky130_fd_sc_hd__fill_2_31 VGND VPWR VPWR sky130_fd_sc_hd__fill_2
* cell instance sky130_fd_sc_hd__fill_2_32 r0 *1 0,0
Xsky130_fd_sc_hd__fill_2_32 VGND VPWR VPWR sky130_fd_sc_hd__fill_2
* cell instance sky130_fd_sc_hd__fill_2_33 r0 *1 0,0
Xsky130_fd_sc_hd__fill_2_33 VGND VPWR VPWR sky130_fd_sc_hd__fill_2
* cell instance sky130_fd_sc_hd__fill_2_34 r0 *1 0,0
Xsky130_fd_sc_hd__fill_2_34 VGND VPWR VPWR sky130_fd_sc_hd__fill_2
* cell instance sky130_fd_sc_hd__fill_2_35 r0 *1 0,0
Xsky130_fd_sc_hd__fill_2_35 VGND VPWR VPWR sky130_fd_sc_hd__fill_2
* cell instance sky130_fd_sc_hd__fill_2_36 r0 *1 0,0
Xsky130_fd_sc_hd__fill_2_36 VGND VPWR VPWR sky130_fd_sc_hd__fill_2
* cell instance sky130_fd_sc_hd__fill_2_37 r0 *1 0,0
Xsky130_fd_sc_hd__fill_2_37 VGND VPWR VPWR sky130_fd_sc_hd__fill_2
* cell instance sky130_fd_sc_hd__fill_2_38 r0 *1 0,0
Xsky130_fd_sc_hd__fill_2_38 VGND VPWR VPWR sky130_fd_sc_hd__fill_2
* cell instance sky130_fd_sc_hd__fill_2_39 r0 *1 0,0
Xsky130_fd_sc_hd__fill_2_39 VGND VPWR VPWR sky130_fd_sc_hd__fill_2
* cell instance sky130_fd_sc_hd__fill_2_40 r0 *1 0,0
Xsky130_fd_sc_hd__fill_2_40 VGND VPWR VPWR sky130_fd_sc_hd__fill_2
* cell instance sky130_fd_sc_hd__fill_2_41 r0 *1 0,0
Xsky130_fd_sc_hd__fill_2_41 VGND VPWR VPWR sky130_fd_sc_hd__fill_2
* cell instance sky130_fd_sc_hd__fill_2_42 r0 *1 0,0
Xsky130_fd_sc_hd__fill_2_42 VGND VPWR VPWR sky130_fd_sc_hd__fill_2
* cell instance sky130_fd_sc_hd__fill_2_43 r0 *1 0,0
Xsky130_fd_sc_hd__fill_2_43 VGND VPWR VPWR sky130_fd_sc_hd__fill_2
* cell instance sky130_fd_sc_hd__fill_2_44 r0 *1 0,0
Xsky130_fd_sc_hd__fill_2_44 VGND VPWR VPWR sky130_fd_sc_hd__fill_2
* cell instance sky130_fd_sc_hd__fill_2_45 r0 *1 0,0
Xsky130_fd_sc_hd__fill_2_45 VGND VPWR VPWR sky130_fd_sc_hd__fill_2
* cell instance sky130_fd_sc_hd__fill_2_46 r0 *1 0,0
Xsky130_fd_sc_hd__fill_2_46 VGND VPWR VPWR sky130_fd_sc_hd__fill_2
* cell instance sky130_fd_sc_hd__fill_2_47 r0 *1 0,0
Xsky130_fd_sc_hd__fill_2_47 VGND VPWR VPWR sky130_fd_sc_hd__fill_2
* cell instance sky130_fd_sc_hd__fill_2_48 r0 *1 0,0
Xsky130_fd_sc_hd__fill_2_48 VGND VPWR VPWR sky130_fd_sc_hd__fill_2
* cell instance sky130_fd_sc_hd__fill_2_49 r0 *1 0,0
Xsky130_fd_sc_hd__fill_2_49 VGND VPWR VPWR sky130_fd_sc_hd__fill_2
* cell instance sky130_fd_sc_hd__fill_2_50 r0 *1 0,0
Xsky130_fd_sc_hd__fill_2_50 VGND VPWR VPWR sky130_fd_sc_hd__fill_2
* cell instance sky130_fd_sc_hd__fill_2_51 r0 *1 0,0
Xsky130_fd_sc_hd__fill_2_51 VGND VPWR VPWR sky130_fd_sc_hd__fill_2
* cell instance sky130_fd_sc_hd__fill_2_52 r0 *1 0,0
Xsky130_fd_sc_hd__fill_2_52 VGND VPWR VPWR sky130_fd_sc_hd__fill_2
* cell instance sky130_fd_sc_hd__fill_2_53 r0 *1 0,0
Xsky130_fd_sc_hd__fill_2_53 VGND VPWR VPWR sky130_fd_sc_hd__fill_2
* cell instance sky130_fd_sc_hd__fill_2_54 r0 *1 0,0
Xsky130_fd_sc_hd__fill_2_54 VGND VPWR VPWR sky130_fd_sc_hd__fill_2
* cell instance sky130_fd_sc_hd__fill_2_55 r0 *1 0,0
Xsky130_fd_sc_hd__fill_2_55 VGND VPWR VPWR sky130_fd_sc_hd__fill_2
* cell instance sky130_fd_sc_hd__fill_2_56 r0 *1 0,0
Xsky130_fd_sc_hd__fill_2_56 VGND VPWR VPWR sky130_fd_sc_hd__fill_2
* cell instance sky130_fd_sc_hd__fill_2_57 r0 *1 0,0
Xsky130_fd_sc_hd__fill_2_57 VGND VPWR VPWR sky130_fd_sc_hd__fill_2
* cell instance sky130_fd_sc_hd__fill_2_58 r0 *1 0,0
Xsky130_fd_sc_hd__fill_2_58 VGND VPWR VPWR sky130_fd_sc_hd__fill_2
* cell instance sky130_fd_sc_hd__fill_2_59 r0 *1 0,0
Xsky130_fd_sc_hd__fill_2_59 VGND VPWR VPWR sky130_fd_sc_hd__fill_2
* cell instance sky130_fd_sc_hd__fill_2_60 r0 *1 0,0
Xsky130_fd_sc_hd__fill_2_60 VGND VPWR VPWR sky130_fd_sc_hd__fill_2
* cell instance sky130_fd_sc_hd__fill_2_61 r0 *1 0,0
Xsky130_fd_sc_hd__fill_2_61 VGND VPWR VPWR sky130_fd_sc_hd__fill_2
* cell instance sky130_fd_sc_hd__fill_2_62 r0 *1 0,0
Xsky130_fd_sc_hd__fill_2_62 VGND VPWR VPWR sky130_fd_sc_hd__fill_2
* cell instance sky130_fd_sc_hd__fill_2_63 r0 *1 0,0
Xsky130_fd_sc_hd__fill_2_63 VGND VPWR VPWR sky130_fd_sc_hd__fill_2
* cell instance sky130_fd_sc_hd__fill_2_64 r0 *1 0,0
Xsky130_fd_sc_hd__fill_2_64 VGND VPWR VPWR sky130_fd_sc_hd__fill_2
* cell instance sky130_fd_sc_hd__fill_2_65 r0 *1 0,0
Xsky130_fd_sc_hd__fill_2_65 VGND VPWR VPWR sky130_fd_sc_hd__fill_2
* cell instance sky130_fd_sc_hd__fill_2_66 r0 *1 0,0
Xsky130_fd_sc_hd__fill_2_66 VGND VPWR VPWR sky130_fd_sc_hd__fill_2
* cell instance sky130_fd_sc_hd__fill_2_67 r0 *1 0,0
Xsky130_fd_sc_hd__fill_2_67 VGND VPWR VPWR sky130_fd_sc_hd__fill_2
* cell instance sky130_fd_sc_hd__fill_2_68 r0 *1 0,0
Xsky130_fd_sc_hd__fill_2_68 VGND VPWR VPWR sky130_fd_sc_hd__fill_2
* cell instance sky130_fd_sc_hd__fill_2_69 r0 *1 0,0
Xsky130_fd_sc_hd__fill_2_69 VGND VPWR VPWR sky130_fd_sc_hd__fill_2
* cell instance sky130_fd_sc_hd__fill_2_70 r0 *1 0,0
Xsky130_fd_sc_hd__fill_2_70 VGND VPWR VPWR sky130_fd_sc_hd__fill_2
* cell instance sky130_fd_sc_hd__fill_2_71 r0 *1 0,0
Xsky130_fd_sc_hd__fill_2_71 VGND VPWR VPWR sky130_fd_sc_hd__fill_2
* cell instance sky130_fd_sc_hd__fill_2_72 r0 *1 0,0
Xsky130_fd_sc_hd__fill_2_72 VGND VPWR VPWR sky130_fd_sc_hd__fill_2
* cell instance sky130_fd_sc_hd__fill_2_73 r0 *1 0,0
Xsky130_fd_sc_hd__fill_2_73 VGND VPWR VPWR sky130_fd_sc_hd__fill_2
* cell instance sky130_fd_sc_hd__fill_2_74 r0 *1 0,0
Xsky130_fd_sc_hd__fill_2_74 VGND VPWR VPWR sky130_fd_sc_hd__fill_2
* cell instance sky130_fd_sc_hd__fill_2_75 r0 *1 0,0
Xsky130_fd_sc_hd__fill_2_75 VGND VPWR VPWR sky130_fd_sc_hd__fill_2
* cell instance sky130_fd_sc_hd__fill_2_76 r0 *1 0,0
Xsky130_fd_sc_hd__fill_2_76 VGND VPWR VPWR sky130_fd_sc_hd__fill_2
* cell instance sky130_fd_sc_hd__fill_2_77 r0 *1 0,0
Xsky130_fd_sc_hd__fill_2_77 VGND VPWR VPWR sky130_fd_sc_hd__fill_2
* cell instance sky130_fd_sc_hd__fill_2_78 r0 *1 0,0
Xsky130_fd_sc_hd__fill_2_78 VGND VPWR VPWR sky130_fd_sc_hd__fill_2
* cell instance sky130_fd_sc_hd__fill_2_79 r0 *1 0,0
Xsky130_fd_sc_hd__fill_2_79 VGND VPWR VPWR sky130_fd_sc_hd__fill_2
* cell instance sky130_fd_sc_hd__fill_2_80 r0 *1 0,0
Xsky130_fd_sc_hd__fill_2_80 VGND VPWR VPWR sky130_fd_sc_hd__fill_2
* cell instance sky130_fd_sc_hd__fill_2_81 r0 *1 0,0
Xsky130_fd_sc_hd__fill_2_81 VGND VPWR VPWR sky130_fd_sc_hd__fill_2
* cell instance sky130_fd_sc_hd__fill_2_82 r0 *1 0,0
Xsky130_fd_sc_hd__fill_2_82 VGND VPWR VPWR sky130_fd_sc_hd__fill_2
* cell instance sky130_fd_sc_hd__fill_2_83 r0 *1 0,0
Xsky130_fd_sc_hd__fill_2_83 VGND VPWR VPWR sky130_fd_sc_hd__fill_2
* cell instance sky130_fd_sc_hd__fill_2_84 r0 *1 0,0
Xsky130_fd_sc_hd__fill_2_84 VGND VPWR VPWR sky130_fd_sc_hd__fill_2
* cell instance sky130_fd_sc_hd__fill_2_85 r0 *1 0,0
Xsky130_fd_sc_hd__fill_2_85 VGND VPWR VPWR sky130_fd_sc_hd__fill_2
* cell instance sky130_fd_sc_hd__fill_2_86 r0 *1 0,0
Xsky130_fd_sc_hd__fill_2_86 VGND VPWR VPWR sky130_fd_sc_hd__fill_2
* cell instance sky130_fd_sc_hd__fill_2_87 r0 *1 0,0
Xsky130_fd_sc_hd__fill_2_87 VGND VPWR VPWR sky130_fd_sc_hd__fill_2
* cell instance sky130_fd_sc_hd__fill_2_88 r0 *1 0,0
Xsky130_fd_sc_hd__fill_2_88 VGND VPWR VPWR sky130_fd_sc_hd__fill_2
* cell instance sky130_fd_sc_hd__fill_2_89 r0 *1 0,0
Xsky130_fd_sc_hd__fill_2_89 VGND VPWR VPWR sky130_fd_sc_hd__fill_2
* cell instance sky130_fd_sc_hd__fill_2_90 r0 *1 0,0
Xsky130_fd_sc_hd__fill_2_90 VGND VPWR VPWR sky130_fd_sc_hd__fill_2
* cell instance sky130_fd_sc_hd__fill_2_91 r0 *1 0,0
Xsky130_fd_sc_hd__fill_2_91 VGND VPWR VPWR sky130_fd_sc_hd__fill_2
* cell instance sky130_fd_sc_hd__fill_2_92 r0 *1 0,0
Xsky130_fd_sc_hd__fill_2_92 VGND VPWR VPWR sky130_fd_sc_hd__fill_2
* cell instance sky130_fd_sc_hd__fill_2_93 r0 *1 0,0
Xsky130_fd_sc_hd__fill_2_93 VGND VPWR VPWR sky130_fd_sc_hd__fill_2
* cell instance sky130_fd_sc_hd__fill_2_94 r0 *1 0,0
Xsky130_fd_sc_hd__fill_2_94 VGND VPWR VPWR sky130_fd_sc_hd__fill_2
* cell instance sky130_fd_sc_hd__fill_2_95 r0 *1 0,0
Xsky130_fd_sc_hd__fill_2_95 VGND VPWR VPWR sky130_fd_sc_hd__fill_2
* cell instance sky130_fd_sc_hd__fill_2_96 r0 *1 0,0
Xsky130_fd_sc_hd__fill_2_96 VGND VPWR VPWR sky130_fd_sc_hd__fill_2
* cell instance sky130_fd_sc_hd__fill_2_97 r0 *1 0,0
Xsky130_fd_sc_hd__fill_2_97 VGND VPWR VPWR sky130_fd_sc_hd__fill_2
* cell instance sky130_fd_sc_hd__fill_2_98 r0 *1 0,0
Xsky130_fd_sc_hd__fill_2_98 VGND VPWR VPWR sky130_fd_sc_hd__fill_2
* cell instance sky130_fd_sc_hd__fill_2_99 r0 *1 0,0
Xsky130_fd_sc_hd__fill_2_99 VGND VPWR VPWR sky130_fd_sc_hd__fill_2
* cell instance sky130_fd_sc_hd__fill_2_100 r0 *1 0,0
Xsky130_fd_sc_hd__fill_2_100 VGND VPWR VPWR sky130_fd_sc_hd__fill_2
* cell instance sky130_fd_sc_hd__fill_2_101 r0 *1 0,0
Xsky130_fd_sc_hd__fill_2_101 VGND VPWR VPWR sky130_fd_sc_hd__fill_2
* cell instance sky130_fd_sc_hd__fill_2_102 r0 *1 0,0
Xsky130_fd_sc_hd__fill_2_102 VGND VPWR VPWR sky130_fd_sc_hd__fill_2
* cell instance sky130_fd_sc_hd__fill_2_103 r0 *1 0,0
Xsky130_fd_sc_hd__fill_2_103 VGND VPWR VPWR sky130_fd_sc_hd__fill_2
* cell instance sky130_fd_sc_hd__fill_2_104 r0 *1 0,0
Xsky130_fd_sc_hd__fill_2_104 VGND VPWR VPWR sky130_fd_sc_hd__fill_2
* cell instance sky130_fd_sc_hd__fill_2_105 r0 *1 0,0
Xsky130_fd_sc_hd__fill_2_105 VGND VPWR VPWR sky130_fd_sc_hd__fill_2
* cell instance sky130_fd_sc_hd__fill_2_106 r0 *1 0,0
Xsky130_fd_sc_hd__fill_2_106 VGND VPWR VPWR sky130_fd_sc_hd__fill_2
* cell instance sky130_fd_sc_hd__fill_2_107 r0 *1 0,0
Xsky130_fd_sc_hd__fill_2_107 VGND VPWR VPWR sky130_fd_sc_hd__fill_2
* cell instance sky130_fd_sc_hd__fill_2_108 r0 *1 0,0
Xsky130_fd_sc_hd__fill_2_108 VGND VPWR VPWR sky130_fd_sc_hd__fill_2
* cell instance sky130_fd_sc_hd__fill_2_109 r0 *1 0,0
Xsky130_fd_sc_hd__fill_2_109 VGND VPWR VPWR sky130_fd_sc_hd__fill_2
* cell instance sky130_fd_sc_hd__fill_2_110 r0 *1 0,0
Xsky130_fd_sc_hd__fill_2_110 VGND VPWR VPWR sky130_fd_sc_hd__fill_2
* cell instance sky130_fd_sc_hd__fill_2_111 r0 *1 0,0
Xsky130_fd_sc_hd__fill_2_111 VGND VPWR VPWR sky130_fd_sc_hd__fill_2
* cell instance sky130_fd_sc_hd__fill_2_112 r0 *1 0,0
Xsky130_fd_sc_hd__fill_2_112 VGND VPWR VPWR sky130_fd_sc_hd__fill_2
* cell instance sky130_fd_sc_hd__fill_2_113 r0 *1 0,0
Xsky130_fd_sc_hd__fill_2_113 VGND VPWR VPWR sky130_fd_sc_hd__fill_2
* cell instance sky130_fd_sc_hd__fill_2_114 r0 *1 0,0
Xsky130_fd_sc_hd__fill_2_114 VGND VPWR VPWR sky130_fd_sc_hd__fill_2
* cell instance sky130_fd_sc_hd__fill_2_115 r0 *1 0,0
Xsky130_fd_sc_hd__fill_2_115 VGND VPWR VPWR sky130_fd_sc_hd__fill_2
* cell instance sky130_fd_sc_hd__fill_2_116 r0 *1 0,0
Xsky130_fd_sc_hd__fill_2_116 VGND VPWR VPWR sky130_fd_sc_hd__fill_2
* cell instance sky130_fd_sc_hd__fill_2_117 r0 *1 0,0
Xsky130_fd_sc_hd__fill_2_117 VGND VPWR VPWR sky130_fd_sc_hd__fill_2
* cell instance sky130_fd_sc_hd__fill_2_118 r0 *1 0,0
Xsky130_fd_sc_hd__fill_2_118 VGND VPWR VPWR sky130_fd_sc_hd__fill_2
* cell instance sky130_fd_sc_hd__fill_2_119 r0 *1 0,0
Xsky130_fd_sc_hd__fill_2_119 VGND VPWR VPWR sky130_fd_sc_hd__fill_2
* cell instance sky130_fd_sc_hd__fill_2_120 r0 *1 0,0
Xsky130_fd_sc_hd__fill_2_120 VGND VPWR VPWR sky130_fd_sc_hd__fill_2
* cell instance sky130_fd_sc_hd__fill_2_121 r0 *1 0,0
Xsky130_fd_sc_hd__fill_2_121 VGND VPWR VPWR sky130_fd_sc_hd__fill_2
* cell instance sky130_fd_sc_hd__fill_2_122 r0 *1 0,0
Xsky130_fd_sc_hd__fill_2_122 VGND VPWR VPWR sky130_fd_sc_hd__fill_2
* cell instance sky130_fd_sc_hd__fill_2_123 r0 *1 0,0
Xsky130_fd_sc_hd__fill_2_123 VGND VPWR VPWR sky130_fd_sc_hd__fill_2
* cell instance sky130_fd_sc_hd__fill_2_124 r0 *1 0,0
Xsky130_fd_sc_hd__fill_2_124 VGND VPWR VPWR sky130_fd_sc_hd__fill_2
* cell instance sky130_fd_sc_hd__fill_2_125 r0 *1 0,0
Xsky130_fd_sc_hd__fill_2_125 VGND VPWR VPWR sky130_fd_sc_hd__fill_2
* cell instance sky130_fd_sc_hd__fill_2_126 r0 *1 0,0
Xsky130_fd_sc_hd__fill_2_126 VGND VPWR VPWR sky130_fd_sc_hd__fill_2
* cell instance sky130_fd_sc_hd__fill_2_127 r0 *1 0,0
Xsky130_fd_sc_hd__fill_2_127 VGND VPWR VPWR sky130_fd_sc_hd__fill_2
* cell instance sky130_fd_sc_hd__fill_2_128 r0 *1 0,0
Xsky130_fd_sc_hd__fill_2_128 VGND VPWR VPWR sky130_fd_sc_hd__fill_2
* cell instance sky130_fd_sc_hd__fill_2_129 r0 *1 0,0
Xsky130_fd_sc_hd__fill_2_129 VGND VPWR VPWR sky130_fd_sc_hd__fill_2
* cell instance sky130_fd_sc_hd__fill_2_130 r0 *1 0,0
Xsky130_fd_sc_hd__fill_2_130 VGND VPWR VPWR sky130_fd_sc_hd__fill_2
* cell instance sky130_fd_sc_hd__fill_2_131 r0 *1 0,0
Xsky130_fd_sc_hd__fill_2_131 VGND VPWR VPWR sky130_fd_sc_hd__fill_2
* cell instance sky130_fd_sc_hd__fill_2_132 r0 *1 0,0
Xsky130_fd_sc_hd__fill_2_132 VGND VPWR VPWR sky130_fd_sc_hd__fill_2
* cell instance sky130_fd_sc_hd__fill_2_133 r0 *1 0,0
Xsky130_fd_sc_hd__fill_2_133 VGND VPWR VPWR sky130_fd_sc_hd__fill_2
* cell instance sky130_fd_sc_hd__fill_2_134 r0 *1 0,0
Xsky130_fd_sc_hd__fill_2_134 VGND VPWR VPWR sky130_fd_sc_hd__fill_2
* cell instance sky130_fd_sc_hd__fill_2_135 r0 *1 0,0
Xsky130_fd_sc_hd__fill_2_135 VGND VPWR VPWR sky130_fd_sc_hd__fill_2
* cell instance sky130_fd_sc_hd__fill_2_136 r0 *1 0,0
Xsky130_fd_sc_hd__fill_2_136 VGND VPWR VPWR sky130_fd_sc_hd__fill_2
* cell instance sky130_fd_sc_hd__fill_2_137 r0 *1 0,0
Xsky130_fd_sc_hd__fill_2_137 VGND VPWR VPWR sky130_fd_sc_hd__fill_2
* cell instance sky130_fd_sc_hd__fill_2_138 r0 *1 0,0
Xsky130_fd_sc_hd__fill_2_138 VGND VPWR VPWR sky130_fd_sc_hd__fill_2
* cell instance sky130_fd_sc_hd__fill_2_139 r0 *1 0,0
Xsky130_fd_sc_hd__fill_2_139 VGND VPWR VPWR sky130_fd_sc_hd__fill_2
* cell instance sky130_fd_sc_hd__fill_2_140 r0 *1 0,0
Xsky130_fd_sc_hd__fill_2_140 VGND VPWR VPWR sky130_fd_sc_hd__fill_2
* cell instance sky130_fd_sc_hd__fill_2_141 r0 *1 0,0
Xsky130_fd_sc_hd__fill_2_141 VGND VPWR VPWR sky130_fd_sc_hd__fill_2
* cell instance sky130_fd_sc_hd__fill_2_142 r0 *1 0,0
Xsky130_fd_sc_hd__fill_2_142 VGND VPWR VPWR sky130_fd_sc_hd__fill_2
* cell instance sky130_fd_sc_hd__fill_2_143 r0 *1 0,0
Xsky130_fd_sc_hd__fill_2_143 VGND VPWR VPWR sky130_fd_sc_hd__fill_2
* cell instance sky130_fd_sc_hd__fill_2_144 r0 *1 0,0
Xsky130_fd_sc_hd__fill_2_144 VGND VPWR VPWR sky130_fd_sc_hd__fill_2
* cell instance sky130_fd_sc_hd__fill_2_145 r0 *1 0,0
Xsky130_fd_sc_hd__fill_2_145 VGND VPWR VPWR sky130_fd_sc_hd__fill_2
* cell instance sky130_fd_sc_hd__fill_2_146 r0 *1 0,0
Xsky130_fd_sc_hd__fill_2_146 VGND VPWR VPWR sky130_fd_sc_hd__fill_2
* cell instance sky130_fd_sc_hd__fill_2_147 r0 *1 0,0
Xsky130_fd_sc_hd__fill_2_147 VGND VPWR VPWR sky130_fd_sc_hd__fill_2
* cell instance sky130_fd_sc_hd__fill_2_148 r0 *1 0,0
Xsky130_fd_sc_hd__fill_2_148 VGND VPWR VPWR sky130_fd_sc_hd__fill_2
* cell instance sky130_fd_sc_hd__fill_2_149 r0 *1 0,0
Xsky130_fd_sc_hd__fill_2_149 VGND VPWR VPWR sky130_fd_sc_hd__fill_2
* cell instance sky130_fd_sc_hd__fill_2_150 r0 *1 0,0
Xsky130_fd_sc_hd__fill_2_150 VGND VPWR VPWR sky130_fd_sc_hd__fill_2
* cell instance sky130_fd_sc_hd__fill_2_151 r0 *1 0,0
Xsky130_fd_sc_hd__fill_2_151 VGND VPWR VPWR sky130_fd_sc_hd__fill_2
* cell instance sky130_fd_sc_hd__fill_2_152 r0 *1 0,0
Xsky130_fd_sc_hd__fill_2_152 VGND VPWR VPWR sky130_fd_sc_hd__fill_2
* cell instance sky130_fd_sc_hd__fill_2_153 r0 *1 0,0
Xsky130_fd_sc_hd__fill_2_153 VGND VPWR VPWR sky130_fd_sc_hd__fill_2
* cell instance sky130_fd_sc_hd__fill_2_154 r0 *1 0,0
Xsky130_fd_sc_hd__fill_2_154 VGND VPWR VPWR sky130_fd_sc_hd__fill_2
* cell instance sky130_fd_sc_hd__fill_2_155 r0 *1 0,0
Xsky130_fd_sc_hd__fill_2_155 VGND VPWR VPWR sky130_fd_sc_hd__fill_2
* cell instance sky130_fd_sc_hd__fill_2_156 r0 *1 0,0
Xsky130_fd_sc_hd__fill_2_156 VGND VPWR VPWR sky130_fd_sc_hd__fill_2
* cell instance sky130_fd_sc_hd__fill_2_157 r0 *1 0,0
Xsky130_fd_sc_hd__fill_2_157 VGND VPWR VPWR sky130_fd_sc_hd__fill_2
* cell instance sky130_fd_sc_hd__fill_2_158 r0 *1 0,0
Xsky130_fd_sc_hd__fill_2_158 VGND VPWR VPWR sky130_fd_sc_hd__fill_2
* cell instance sky130_fd_sc_hd__fill_2_159 r0 *1 0,0
Xsky130_fd_sc_hd__fill_2_159 VGND VPWR VPWR sky130_fd_sc_hd__fill_2
* cell instance sky130_fd_sc_hd__fill_2_160 r0 *1 0,0
Xsky130_fd_sc_hd__fill_2_160 VGND VPWR VPWR sky130_fd_sc_hd__fill_2
* cell instance sky130_fd_sc_hd__fill_2_161 r0 *1 0,0
Xsky130_fd_sc_hd__fill_2_161 VGND VPWR VPWR sky130_fd_sc_hd__fill_2
* cell instance sky130_fd_sc_hd__fill_2_162 r0 *1 0,0
Xsky130_fd_sc_hd__fill_2_162 VGND VPWR VPWR sky130_fd_sc_hd__fill_2
* cell instance sky130_fd_sc_hd__fill_2_163 r0 *1 0,0
Xsky130_fd_sc_hd__fill_2_163 VGND VPWR VPWR sky130_fd_sc_hd__fill_2
* cell instance sky130_fd_sc_hd__fill_2_164 r0 *1 0,0
Xsky130_fd_sc_hd__fill_2_164 VGND VPWR VPWR sky130_fd_sc_hd__fill_2
* cell instance sky130_fd_sc_hd__fill_2_165 r0 *1 0,0
Xsky130_fd_sc_hd__fill_2_165 VGND VPWR VPWR sky130_fd_sc_hd__fill_2
* cell instance sky130_fd_sc_hd__fill_2_166 r0 *1 0,0
Xsky130_fd_sc_hd__fill_2_166 VGND VPWR VPWR sky130_fd_sc_hd__fill_2
* cell instance sky130_fd_sc_hd__fill_2_167 r0 *1 0,0
Xsky130_fd_sc_hd__fill_2_167 VGND VPWR VPWR sky130_fd_sc_hd__fill_2
* cell instance sky130_fd_sc_hd__fill_2_168 r0 *1 0,0
Xsky130_fd_sc_hd__fill_2_168 VGND VPWR VPWR sky130_fd_sc_hd__fill_2
* cell instance sky130_fd_sc_hd__fill_2_169 r0 *1 0,0
Xsky130_fd_sc_hd__fill_2_169 VGND VPWR VPWR sky130_fd_sc_hd__fill_2
* cell instance sky130_fd_sc_hd__fill_2_170 r0 *1 0,0
Xsky130_fd_sc_hd__fill_2_170 VGND VPWR VPWR sky130_fd_sc_hd__fill_2
* cell instance sky130_fd_sc_hd__fill_2_171 r0 *1 0,0
Xsky130_fd_sc_hd__fill_2_171 VGND VPWR VPWR sky130_fd_sc_hd__fill_2
* cell instance sky130_fd_sc_hd__fill_2_172 r0 *1 0,0
Xsky130_fd_sc_hd__fill_2_172 VGND VPWR VPWR sky130_fd_sc_hd__fill_2
* cell instance sky130_fd_sc_hd__fill_2_173 r0 *1 0,0
Xsky130_fd_sc_hd__fill_2_173 VGND VPWR VPWR sky130_fd_sc_hd__fill_2
* cell instance sky130_fd_sc_hd__fill_2_174 r0 *1 0,0
Xsky130_fd_sc_hd__fill_2_174 VGND VPWR VPWR sky130_fd_sc_hd__fill_2
* cell instance sky130_fd_sc_hd__fill_2_175 r0 *1 0,0
Xsky130_fd_sc_hd__fill_2_175 VGND VPWR VPWR sky130_fd_sc_hd__fill_2
* cell instance sky130_fd_sc_hd__fill_2_176 r0 *1 0,0
Xsky130_fd_sc_hd__fill_2_176 VGND VPWR VPWR sky130_fd_sc_hd__fill_2
* cell instance sky130_fd_sc_hd__fill_2_177 r0 *1 0,0
Xsky130_fd_sc_hd__fill_2_177 VGND VPWR VPWR sky130_fd_sc_hd__fill_2
* cell instance sky130_fd_sc_hd__fill_2_178 r0 *1 0,0
Xsky130_fd_sc_hd__fill_2_178 VGND VPWR VPWR sky130_fd_sc_hd__fill_2
* cell instance sky130_fd_sc_hd__fill_2_179 r0 *1 0,0
Xsky130_fd_sc_hd__fill_2_179 VGND VPWR VPWR sky130_fd_sc_hd__fill_2
* cell instance sky130_fd_sc_hd__fill_2_180 r0 *1 0,0
Xsky130_fd_sc_hd__fill_2_180 VGND VPWR VPWR sky130_fd_sc_hd__fill_2
* cell instance sky130_fd_sc_hd__fill_2_181 r0 *1 0,0
Xsky130_fd_sc_hd__fill_2_181 VGND VPWR VPWR sky130_fd_sc_hd__fill_2
* cell instance sky130_fd_sc_hd__fill_2_182 r0 *1 0,0
Xsky130_fd_sc_hd__fill_2_182 VGND VPWR VPWR sky130_fd_sc_hd__fill_2
* cell instance sky130_fd_sc_hd__fill_2_183 r0 *1 0,0
Xsky130_fd_sc_hd__fill_2_183 VGND VPWR VPWR sky130_fd_sc_hd__fill_2
* cell instance sky130_fd_sc_hd__fill_2_184 r0 *1 0,0
Xsky130_fd_sc_hd__fill_2_184 VGND VPWR VPWR sky130_fd_sc_hd__fill_2
* cell instance sky130_fd_sc_hd__fill_2_185 r0 *1 0,0
Xsky130_fd_sc_hd__fill_2_185 VGND VPWR VPWR sky130_fd_sc_hd__fill_2
* cell instance sky130_fd_sc_hd__fill_2_186 r0 *1 0,0
Xsky130_fd_sc_hd__fill_2_186 VGND VPWR VPWR sky130_fd_sc_hd__fill_2
* cell instance sky130_fd_sc_hd__fill_2_187 r0 *1 0,0
Xsky130_fd_sc_hd__fill_2_187 VGND VPWR VPWR sky130_fd_sc_hd__fill_2
* cell instance sky130_fd_sc_hd__fill_2_188 r0 *1 0,0
Xsky130_fd_sc_hd__fill_2_188 VGND VPWR VPWR sky130_fd_sc_hd__fill_2
* cell instance sky130_fd_sc_hd__fill_2_189 r0 *1 0,0
Xsky130_fd_sc_hd__fill_2_189 VGND VPWR VPWR sky130_fd_sc_hd__fill_2
* cell instance sky130_fd_sc_hd__fill_2_190 r0 *1 0,0
Xsky130_fd_sc_hd__fill_2_190 VGND VPWR VPWR sky130_fd_sc_hd__fill_2
* cell instance sky130_fd_sc_hd__fill_2_191 r0 *1 0,0
Xsky130_fd_sc_hd__fill_2_191 VGND VPWR VPWR sky130_fd_sc_hd__fill_2
* cell instance sky130_fd_sc_hd__fill_2_192 r0 *1 0,0
Xsky130_fd_sc_hd__fill_2_192 VGND VPWR VPWR sky130_fd_sc_hd__fill_2
* cell instance sky130_fd_sc_hd__fill_2_193 r0 *1 0,0
Xsky130_fd_sc_hd__fill_2_193 VGND VPWR VPWR sky130_fd_sc_hd__fill_2
* cell instance sky130_fd_sc_hd__fill_2_194 r0 *1 0,0
Xsky130_fd_sc_hd__fill_2_194 VGND VPWR VPWR sky130_fd_sc_hd__fill_2
* cell instance sky130_fd_sc_hd__fill_2_195 r0 *1 0,0
Xsky130_fd_sc_hd__fill_2_195 VGND VPWR VPWR sky130_fd_sc_hd__fill_2
* cell instance sky130_fd_sc_hd__fill_2_196 r0 *1 0,0
Xsky130_fd_sc_hd__fill_2_196 VGND VPWR VPWR sky130_fd_sc_hd__fill_2
* cell instance sky130_fd_sc_hd__fill_2_197 r0 *1 0,0
Xsky130_fd_sc_hd__fill_2_197 VGND VPWR VPWR sky130_fd_sc_hd__fill_2
* cell instance sky130_fd_sc_hd__fill_2_198 r0 *1 0,0
Xsky130_fd_sc_hd__fill_2_198 VGND VPWR VPWR sky130_fd_sc_hd__fill_2
* cell instance sky130_fd_sc_hd__fill_2_199 r0 *1 0,0
Xsky130_fd_sc_hd__fill_2_199 VGND VPWR VPWR sky130_fd_sc_hd__fill_2
* cell instance sky130_fd_sc_hd__fill_2_200 r0 *1 0,0
Xsky130_fd_sc_hd__fill_2_200 VGND VPWR VPWR sky130_fd_sc_hd__fill_2
* cell instance sky130_fd_sc_hd__fill_2_201 r0 *1 0,0
Xsky130_fd_sc_hd__fill_2_201 VGND VPWR VPWR sky130_fd_sc_hd__fill_2
* cell instance sky130_fd_sc_hd__fill_2_202 r0 *1 0,0
Xsky130_fd_sc_hd__fill_2_202 VGND VPWR VPWR sky130_fd_sc_hd__fill_2
* cell instance sky130_fd_sc_hd__fill_2_203 r0 *1 0,0
Xsky130_fd_sc_hd__fill_2_203 VGND VPWR VPWR sky130_fd_sc_hd__fill_2
* cell instance sky130_fd_sc_hd__fill_2_204 r0 *1 0,0
Xsky130_fd_sc_hd__fill_2_204 VGND VPWR VPWR sky130_fd_sc_hd__fill_2
* cell instance sky130_fd_sc_hd__fill_2_205 r0 *1 0,0
Xsky130_fd_sc_hd__fill_2_205 VGND VPWR VPWR sky130_fd_sc_hd__fill_2
* cell instance sky130_fd_sc_hd__fill_2_206 r0 *1 0,0
Xsky130_fd_sc_hd__fill_2_206 VGND VPWR VPWR sky130_fd_sc_hd__fill_2
* cell instance sky130_fd_sc_hd__fill_2_207 r0 *1 0,0
Xsky130_fd_sc_hd__fill_2_207 VGND VPWR VPWR sky130_fd_sc_hd__fill_2
* cell instance sky130_fd_sc_hd__fill_2_208 r0 *1 0,0
Xsky130_fd_sc_hd__fill_2_208 VGND VPWR VPWR sky130_fd_sc_hd__fill_2
* cell instance sky130_fd_sc_hd__fill_2_209 r0 *1 0,0
Xsky130_fd_sc_hd__fill_2_209 VGND VPWR VPWR sky130_fd_sc_hd__fill_2
* cell instance sky130_fd_sc_hd__fill_2_210 r0 *1 0,0
Xsky130_fd_sc_hd__fill_2_210 VGND VPWR VPWR sky130_fd_sc_hd__fill_2
* cell instance sky130_fd_sc_hd__fill_2_211 r0 *1 0,0
Xsky130_fd_sc_hd__fill_2_211 VGND VPWR VPWR sky130_fd_sc_hd__fill_2
* cell instance sky130_fd_sc_hd__fill_2_212 r0 *1 0,0
Xsky130_fd_sc_hd__fill_2_212 VGND VPWR VPWR sky130_fd_sc_hd__fill_2
* cell instance sky130_fd_sc_hd__fill_2_213 r0 *1 0,0
Xsky130_fd_sc_hd__fill_2_213 VGND VPWR VPWR sky130_fd_sc_hd__fill_2
* cell instance sky130_fd_sc_hd__fill_2_214 r0 *1 0,0
Xsky130_fd_sc_hd__fill_2_214 VGND VPWR VPWR sky130_fd_sc_hd__fill_2
* cell instance sky130_fd_sc_hd__fill_2_215 r0 *1 0,0
Xsky130_fd_sc_hd__fill_2_215 VGND VPWR VPWR sky130_fd_sc_hd__fill_2
* cell instance sky130_fd_sc_hd__fill_2_216 r0 *1 0,0
Xsky130_fd_sc_hd__fill_2_216 VGND VPWR VPWR sky130_fd_sc_hd__fill_2
* cell instance sky130_fd_sc_hd__fill_2_217 r0 *1 0,0
Xsky130_fd_sc_hd__fill_2_217 VGND VPWR VPWR sky130_fd_sc_hd__fill_2
* cell instance sky130_fd_sc_hd__fill_2_218 r0 *1 0,0
Xsky130_fd_sc_hd__fill_2_218 VGND VPWR VPWR sky130_fd_sc_hd__fill_2
* cell instance sky130_fd_sc_hd__fill_2_219 r0 *1 0,0
Xsky130_fd_sc_hd__fill_2_219 VGND VPWR VPWR sky130_fd_sc_hd__fill_2
* cell instance sky130_fd_sc_hd__fill_2_220 r0 *1 0,0
Xsky130_fd_sc_hd__fill_2_220 VGND VPWR VPWR sky130_fd_sc_hd__fill_2
* cell instance sky130_fd_sc_hd__fill_2_221 r0 *1 0,0
Xsky130_fd_sc_hd__fill_2_221 VGND VPWR VPWR sky130_fd_sc_hd__fill_2
* cell instance sky130_fd_sc_hd__fill_2_222 r0 *1 0,0
Xsky130_fd_sc_hd__fill_2_222 VGND VPWR VPWR sky130_fd_sc_hd__fill_2
* cell instance sky130_fd_sc_hd__fill_2_223 r0 *1 0,0
Xsky130_fd_sc_hd__fill_2_223 VGND VPWR VPWR sky130_fd_sc_hd__fill_2
* cell instance sky130_fd_sc_hd__fill_2_224 r0 *1 0,0
Xsky130_fd_sc_hd__fill_2_224 VGND VPWR VPWR sky130_fd_sc_hd__fill_2
* cell instance sky130_fd_sc_hd__fill_2_225 r0 *1 0,0
Xsky130_fd_sc_hd__fill_2_225 VGND VPWR VPWR sky130_fd_sc_hd__fill_2
* cell instance sky130_fd_sc_hd__fill_2_226 r0 *1 0,0
Xsky130_fd_sc_hd__fill_2_226 VGND VPWR VPWR sky130_fd_sc_hd__fill_2
* cell instance sky130_fd_sc_hd__fill_2_227 r0 *1 0,0
Xsky130_fd_sc_hd__fill_2_227 VGND VPWR VPWR sky130_fd_sc_hd__fill_2
* cell instance sky130_fd_sc_hd__fill_2_228 r0 *1 0,0
Xsky130_fd_sc_hd__fill_2_228 VGND VPWR VPWR sky130_fd_sc_hd__fill_2
* cell instance sky130_fd_sc_hd__fill_2_229 r0 *1 0,0
Xsky130_fd_sc_hd__fill_2_229 VGND VPWR VPWR sky130_fd_sc_hd__fill_2
* cell instance sky130_fd_sc_hd__fill_2_230 r0 *1 0,0
Xsky130_fd_sc_hd__fill_2_230 VGND VPWR VPWR sky130_fd_sc_hd__fill_2
* cell instance sky130_fd_sc_hd__fill_2_231 r0 *1 0,0
Xsky130_fd_sc_hd__fill_2_231 VGND VPWR VPWR sky130_fd_sc_hd__fill_2
* cell instance sky130_fd_sc_hd__fill_2_232 r0 *1 0,0
Xsky130_fd_sc_hd__fill_2_232 VGND VPWR VPWR sky130_fd_sc_hd__fill_2
* cell instance sky130_fd_sc_hd__fill_2_233 r0 *1 0,0
Xsky130_fd_sc_hd__fill_2_233 VGND VPWR VPWR sky130_fd_sc_hd__fill_2
* cell instance sky130_fd_sc_hd__fill_2_234 r0 *1 0,0
Xsky130_fd_sc_hd__fill_2_234 VGND VPWR VPWR sky130_fd_sc_hd__fill_2
* cell instance sky130_fd_sc_hd__fill_2_235 r0 *1 0,0
Xsky130_fd_sc_hd__fill_2_235 VGND VPWR VPWR sky130_fd_sc_hd__fill_2
* cell instance sky130_fd_sc_hd__fill_2_236 r0 *1 0,0
Xsky130_fd_sc_hd__fill_2_236 VGND VPWR VPWR sky130_fd_sc_hd__fill_2
* cell instance sky130_fd_sc_hd__fill_2_237 r0 *1 0,0
Xsky130_fd_sc_hd__fill_2_237 VGND VPWR VPWR sky130_fd_sc_hd__fill_2
* cell instance sky130_fd_sc_hd__fill_2_238 r0 *1 0,0
Xsky130_fd_sc_hd__fill_2_238 VGND VPWR VPWR sky130_fd_sc_hd__fill_2
* cell instance sky130_fd_sc_hd__fill_2_239 r0 *1 0,0
Xsky130_fd_sc_hd__fill_2_239 VGND VPWR VPWR sky130_fd_sc_hd__fill_2
* cell instance sky130_fd_sc_hd__fill_2_240 r0 *1 0,0
Xsky130_fd_sc_hd__fill_2_240 VGND VPWR VPWR sky130_fd_sc_hd__fill_2
* cell instance sky130_fd_sc_hd__fill_2_241 r0 *1 0,0
Xsky130_fd_sc_hd__fill_2_241 VGND VPWR VPWR sky130_fd_sc_hd__fill_2
* cell instance sky130_fd_sc_hd__fill_2_242 r0 *1 0,0
Xsky130_fd_sc_hd__fill_2_242 VGND VPWR VPWR sky130_fd_sc_hd__fill_2
* cell instance sky130_fd_sc_hd__fill_2_243 r0 *1 0,0
Xsky130_fd_sc_hd__fill_2_243 VGND VPWR VPWR sky130_fd_sc_hd__fill_2
* cell instance sky130_fd_sc_hd__fill_2_244 r0 *1 0,0
Xsky130_fd_sc_hd__fill_2_244 VGND VPWR VPWR sky130_fd_sc_hd__fill_2
* cell instance sky130_fd_sc_hd__fill_2_245 r0 *1 0,0
Xsky130_fd_sc_hd__fill_2_245 VGND VPWR VPWR sky130_fd_sc_hd__fill_2
* cell instance sky130_fd_sc_hd__fill_2_246 r0 *1 0,0
Xsky130_fd_sc_hd__fill_2_246 VGND VPWR VPWR sky130_fd_sc_hd__fill_2
* cell instance sky130_fd_sc_hd__fill_2_247 r0 *1 0,0
Xsky130_fd_sc_hd__fill_2_247 VGND VPWR VPWR sky130_fd_sc_hd__fill_2
* cell instance sky130_fd_sc_hd__fill_2_248 r0 *1 0,0
Xsky130_fd_sc_hd__fill_2_248 VGND VPWR VPWR sky130_fd_sc_hd__fill_2
* cell instance sky130_fd_sc_hd__fill_2_249 r0 *1 0,0
Xsky130_fd_sc_hd__fill_2_249 VGND VPWR VPWR sky130_fd_sc_hd__fill_2
* cell instance sky130_fd_sc_hd__fill_2_250 r0 *1 0,0
Xsky130_fd_sc_hd__fill_2_250 VGND VPWR VPWR sky130_fd_sc_hd__fill_2
* cell instance sky130_fd_sc_hd__fill_2_251 r0 *1 0,0
Xsky130_fd_sc_hd__fill_2_251 VGND VPWR VPWR sky130_fd_sc_hd__fill_2
* cell instance sky130_fd_sc_hd__fill_2_252 r0 *1 0,0
Xsky130_fd_sc_hd__fill_2_252 VGND VPWR VPWR sky130_fd_sc_hd__fill_2
* cell instance sky130_fd_sc_hd__fill_2_253 r0 *1 0,0
Xsky130_fd_sc_hd__fill_2_253 VGND VPWR VPWR sky130_fd_sc_hd__fill_2
* cell instance sky130_fd_sc_hd__fill_2_254 r0 *1 0,0
Xsky130_fd_sc_hd__fill_2_254 VGND VPWR VPWR sky130_fd_sc_hd__fill_2
* cell instance sky130_fd_sc_hd__fill_2_255 r0 *1 0,0
Xsky130_fd_sc_hd__fill_2_255 VGND VPWR VPWR sky130_fd_sc_hd__fill_2
* cell instance sky130_fd_sc_hd__fill_2_256 r0 *1 0,0
Xsky130_fd_sc_hd__fill_2_256 VGND VPWR VPWR sky130_fd_sc_hd__fill_2
* cell instance sky130_fd_sc_hd__fill_2_257 r0 *1 0,0
Xsky130_fd_sc_hd__fill_2_257 VGND VPWR VPWR sky130_fd_sc_hd__fill_2
* cell instance sky130_fd_sc_hd__fill_2_258 r0 *1 0,0
Xsky130_fd_sc_hd__fill_2_258 VGND VPWR VPWR sky130_fd_sc_hd__fill_2
* cell instance sky130_fd_sc_hd__fill_2_259 r0 *1 0,0
Xsky130_fd_sc_hd__fill_2_259 VGND VPWR VPWR sky130_fd_sc_hd__fill_2
* cell instance sky130_fd_sc_hd__fill_2_260 r0 *1 0,0
Xsky130_fd_sc_hd__fill_2_260 VGND VPWR VPWR sky130_fd_sc_hd__fill_2
* cell instance sky130_fd_sc_hd__fill_2_261 r0 *1 0,0
Xsky130_fd_sc_hd__fill_2_261 VGND VPWR VPWR sky130_fd_sc_hd__fill_2
* cell instance sky130_fd_sc_hd__fill_2_262 r0 *1 0,0
Xsky130_fd_sc_hd__fill_2_262 VGND VPWR VPWR sky130_fd_sc_hd__fill_2
* cell instance sky130_fd_sc_hd__fill_2_263 r0 *1 0,0
Xsky130_fd_sc_hd__fill_2_263 VGND VPWR VPWR sky130_fd_sc_hd__fill_2
* cell instance sky130_fd_sc_hd__fill_2_264 r0 *1 0,0
Xsky130_fd_sc_hd__fill_2_264 VGND VPWR VPWR sky130_fd_sc_hd__fill_2
* cell instance sky130_fd_sc_hd__fill_2_265 r0 *1 0,0
Xsky130_fd_sc_hd__fill_2_265 VGND VPWR VPWR sky130_fd_sc_hd__fill_2
* cell instance sky130_fd_sc_hd__fill_2_266 r0 *1 0,0
Xsky130_fd_sc_hd__fill_2_266 VGND VPWR VPWR sky130_fd_sc_hd__fill_2
* cell instance sky130_fd_sc_hd__fill_2_267 r0 *1 0,0
Xsky130_fd_sc_hd__fill_2_267 VGND VPWR VPWR sky130_fd_sc_hd__fill_2
* cell instance sky130_fd_sc_hd__fill_2_268 r0 *1 0,0
Xsky130_fd_sc_hd__fill_2_268 VGND VPWR VPWR sky130_fd_sc_hd__fill_2
* cell instance sky130_fd_sc_hd__fill_2_269 r0 *1 0,0
Xsky130_fd_sc_hd__fill_2_269 VGND VPWR VPWR sky130_fd_sc_hd__fill_2
* cell instance sky130_fd_sc_hd__fill_2_270 r0 *1 0,0
Xsky130_fd_sc_hd__fill_2_270 VGND VPWR VPWR sky130_fd_sc_hd__fill_2
* cell instance sky130_fd_sc_hd__fill_2_271 r0 *1 0,0
Xsky130_fd_sc_hd__fill_2_271 VGND VPWR VPWR sky130_fd_sc_hd__fill_2
* cell instance sky130_fd_sc_hd__fill_2_272 r0 *1 0,0
Xsky130_fd_sc_hd__fill_2_272 VGND VPWR VPWR sky130_fd_sc_hd__fill_2
* cell instance sky130_fd_sc_hd__fill_2_273 r0 *1 0,0
Xsky130_fd_sc_hd__fill_2_273 VGND VPWR VPWR sky130_fd_sc_hd__fill_2
* cell instance sky130_fd_sc_hd__fill_2_274 r0 *1 0,0
Xsky130_fd_sc_hd__fill_2_274 VGND VPWR VPWR sky130_fd_sc_hd__fill_2
* cell instance sky130_fd_sc_hd__fill_2_275 r0 *1 0,0
Xsky130_fd_sc_hd__fill_2_275 VGND VPWR VPWR sky130_fd_sc_hd__fill_2
* cell instance sky130_fd_sc_hd__fill_2_276 r0 *1 0,0
Xsky130_fd_sc_hd__fill_2_276 VGND VPWR VPWR sky130_fd_sc_hd__fill_2
* cell instance sky130_fd_sc_hd__fill_2_277 r0 *1 0,0
Xsky130_fd_sc_hd__fill_2_277 VGND VPWR VPWR sky130_fd_sc_hd__fill_2
* cell instance sky130_fd_sc_hd__fill_2_278 r0 *1 0,0
Xsky130_fd_sc_hd__fill_2_278 VGND VPWR VPWR sky130_fd_sc_hd__fill_2
* cell instance sky130_fd_sc_hd__fill_2_279 r0 *1 0,0
Xsky130_fd_sc_hd__fill_2_279 VGND VPWR VPWR sky130_fd_sc_hd__fill_2
* cell instance sky130_fd_sc_hd__fill_2_280 r0 *1 0,0
Xsky130_fd_sc_hd__fill_2_280 VGND VPWR VPWR sky130_fd_sc_hd__fill_2
* cell instance sky130_fd_sc_hd__fill_2_281 r0 *1 0,0
Xsky130_fd_sc_hd__fill_2_281 VGND VPWR VPWR sky130_fd_sc_hd__fill_2
* cell instance sky130_fd_sc_hd__fill_2_282 r0 *1 0,0
Xsky130_fd_sc_hd__fill_2_282 VGND VPWR VPWR sky130_fd_sc_hd__fill_2
* cell instance sky130_fd_sc_hd__fill_2_283 r0 *1 0,0
Xsky130_fd_sc_hd__fill_2_283 VGND VPWR VPWR sky130_fd_sc_hd__fill_2
* cell instance sky130_fd_sc_hd__fill_2_284 r0 *1 0,0
Xsky130_fd_sc_hd__fill_2_284 VGND VPWR VPWR sky130_fd_sc_hd__fill_2
* cell instance sky130_fd_sc_hd__fill_2_285 r0 *1 0,0
Xsky130_fd_sc_hd__fill_2_285 VGND VPWR VPWR sky130_fd_sc_hd__fill_2
* cell instance sky130_fd_sc_hd__fill_2_286 r0 *1 0,0
Xsky130_fd_sc_hd__fill_2_286 VGND VPWR VPWR sky130_fd_sc_hd__fill_2
* cell instance sky130_fd_sc_hd__fill_2_287 r0 *1 0,0
Xsky130_fd_sc_hd__fill_2_287 VGND VPWR VPWR sky130_fd_sc_hd__fill_2
* cell instance sky130_fd_sc_hd__fill_2_288 r0 *1 0,0
Xsky130_fd_sc_hd__fill_2_288 VGND VPWR VPWR sky130_fd_sc_hd__fill_2
* cell instance sky130_fd_sc_hd__fill_2_289 r0 *1 0,0
Xsky130_fd_sc_hd__fill_2_289 VGND VPWR VPWR sky130_fd_sc_hd__fill_2
* cell instance sky130_fd_sc_hd__fill_2_290 r0 *1 0,0
Xsky130_fd_sc_hd__fill_2_290 VGND VPWR VPWR sky130_fd_sc_hd__fill_2
* cell instance sky130_fd_sc_hd__fill_2_291 r0 *1 0,0
Xsky130_fd_sc_hd__fill_2_291 VGND VPWR VPWR sky130_fd_sc_hd__fill_2
* cell instance sky130_fd_sc_hd__fill_2_292 r0 *1 0,0
Xsky130_fd_sc_hd__fill_2_292 VGND VPWR VPWR sky130_fd_sc_hd__fill_2
* cell instance sky130_fd_sc_hd__fill_2_293 r0 *1 0,0
Xsky130_fd_sc_hd__fill_2_293 VGND VPWR VPWR sky130_fd_sc_hd__fill_2
* cell instance sky130_fd_sc_hd__fill_2_294 r0 *1 0,0
Xsky130_fd_sc_hd__fill_2_294 VGND VPWR VPWR sky130_fd_sc_hd__fill_2
* cell instance sky130_fd_sc_hd__fill_2_295 r0 *1 0,0
Xsky130_fd_sc_hd__fill_2_295 VGND VPWR VPWR sky130_fd_sc_hd__fill_2
* cell instance sky130_fd_sc_hd__fill_2_296 r0 *1 0,0
Xsky130_fd_sc_hd__fill_2_296 VGND VPWR VPWR sky130_fd_sc_hd__fill_2
* cell instance sky130_fd_sc_hd__fill_2_297 r0 *1 0,0
Xsky130_fd_sc_hd__fill_2_297 VGND VPWR VPWR sky130_fd_sc_hd__fill_2
* cell instance sky130_fd_sc_hd__fill_2_298 r0 *1 0,0
Xsky130_fd_sc_hd__fill_2_298 VGND VPWR VPWR sky130_fd_sc_hd__fill_2
* cell instance sky130_fd_sc_hd__fill_2_299 r0 *1 0,0
Xsky130_fd_sc_hd__fill_2_299 VGND VPWR VPWR sky130_fd_sc_hd__fill_2
* cell instance sky130_fd_sc_hd__fill_2_300 r0 *1 0,0
Xsky130_fd_sc_hd__fill_2_300 VGND VPWR VPWR sky130_fd_sc_hd__fill_2
* cell instance sky130_fd_sc_hd__fill_2_301 r0 *1 0,0
Xsky130_fd_sc_hd__fill_2_301 VGND VPWR VPWR sky130_fd_sc_hd__fill_2
* cell instance sky130_fd_sc_hd__fill_2_302 r0 *1 0,0
Xsky130_fd_sc_hd__fill_2_302 VGND VPWR VPWR sky130_fd_sc_hd__fill_2
* cell instance sky130_fd_sc_hd__fill_2_303 r0 *1 0,0
Xsky130_fd_sc_hd__fill_2_303 VGND VPWR VPWR sky130_fd_sc_hd__fill_2
* cell instance sky130_fd_sc_hd__fill_2_304 r0 *1 0,0
Xsky130_fd_sc_hd__fill_2_304 VGND VPWR VPWR sky130_fd_sc_hd__fill_2
* cell instance sky130_fd_sc_hd__fill_2_305 r0 *1 0,0
Xsky130_fd_sc_hd__fill_2_305 VGND VPWR VPWR sky130_fd_sc_hd__fill_2
* cell instance sky130_fd_sc_hd__fill_2_306 r0 *1 0,0
Xsky130_fd_sc_hd__fill_2_306 VGND VPWR VPWR sky130_fd_sc_hd__fill_2
* cell instance sky130_fd_sc_hd__fill_2_307 r0 *1 0,0
Xsky130_fd_sc_hd__fill_2_307 VGND VPWR VPWR sky130_fd_sc_hd__fill_2
* cell instance sky130_fd_sc_hd__fill_2_308 r0 *1 0,0
Xsky130_fd_sc_hd__fill_2_308 VGND VPWR VPWR sky130_fd_sc_hd__fill_2
* cell instance sky130_fd_sc_hd__fill_2_309 r0 *1 0,0
Xsky130_fd_sc_hd__fill_2_309 VGND VPWR VPWR sky130_fd_sc_hd__fill_2
* cell instance sky130_fd_sc_hd__fill_2_310 r0 *1 0,0
Xsky130_fd_sc_hd__fill_2_310 VGND VPWR VPWR sky130_fd_sc_hd__fill_2
* cell instance sky130_fd_sc_hd__fill_2_311 r0 *1 0,0
Xsky130_fd_sc_hd__fill_2_311 VGND VPWR VPWR sky130_fd_sc_hd__fill_2
* cell instance sky130_fd_sc_hd__fill_2_312 r0 *1 0,0
Xsky130_fd_sc_hd__fill_2_312 VGND VPWR VPWR sky130_fd_sc_hd__fill_2
* cell instance sky130_fd_sc_hd__fill_2_313 r0 *1 0,0
Xsky130_fd_sc_hd__fill_2_313 VGND VPWR VPWR sky130_fd_sc_hd__fill_2
* cell instance sky130_fd_sc_hd__fill_2_314 r0 *1 0,0
Xsky130_fd_sc_hd__fill_2_314 VGND VPWR VPWR sky130_fd_sc_hd__fill_2
* cell instance sky130_fd_sc_hd__fill_2_315 r0 *1 0,0
Xsky130_fd_sc_hd__fill_2_315 VGND VPWR VPWR sky130_fd_sc_hd__fill_2
* cell instance sky130_fd_sc_hd__fill_2_316 r0 *1 0,0
Xsky130_fd_sc_hd__fill_2_316 VGND VPWR VPWR sky130_fd_sc_hd__fill_2
* cell instance sky130_fd_sc_hd__fill_2_317 r0 *1 0,0
Xsky130_fd_sc_hd__fill_2_317 VGND VPWR VPWR sky130_fd_sc_hd__fill_2
* cell instance sky130_fd_sc_hd__fill_2_318 r0 *1 0,0
Xsky130_fd_sc_hd__fill_2_318 VGND VPWR VPWR sky130_fd_sc_hd__fill_2
* cell instance sky130_fd_sc_hd__fill_2_319 r0 *1 0,0
Xsky130_fd_sc_hd__fill_2_319 VGND VPWR VPWR sky130_fd_sc_hd__fill_2
* cell instance sky130_fd_sc_hd__fill_2_320 r0 *1 0,0
Xsky130_fd_sc_hd__fill_2_320 VGND VPWR VPWR sky130_fd_sc_hd__fill_2
* cell instance sky130_fd_sc_hd__fill_2_321 r0 *1 0,0
Xsky130_fd_sc_hd__fill_2_321 VGND VPWR VPWR sky130_fd_sc_hd__fill_2
* cell instance sky130_fd_sc_hd__fill_2_322 r0 *1 0,0
Xsky130_fd_sc_hd__fill_2_322 VGND VPWR VPWR sky130_fd_sc_hd__fill_2
* cell instance sky130_fd_sc_hd__fill_2_323 r0 *1 0,0
Xsky130_fd_sc_hd__fill_2_323 VGND VPWR VPWR sky130_fd_sc_hd__fill_2
* cell instance sky130_fd_sc_hd__fill_2_324 r0 *1 0,0
Xsky130_fd_sc_hd__fill_2_324 VGND VPWR VPWR sky130_fd_sc_hd__fill_2
* cell instance sky130_fd_sc_hd__fill_2_325 r0 *1 0,0
Xsky130_fd_sc_hd__fill_2_325 VGND VPWR VPWR sky130_fd_sc_hd__fill_2
* cell instance sky130_fd_sc_hd__fill_2_326 r0 *1 0,0
Xsky130_fd_sc_hd__fill_2_326 VGND VPWR VPWR sky130_fd_sc_hd__fill_2
* cell instance sky130_fd_sc_hd__fill_2_327 r0 *1 0,0
Xsky130_fd_sc_hd__fill_2_327 VGND VPWR VPWR sky130_fd_sc_hd__fill_2
* cell instance sky130_fd_sc_hd__fill_2_328 r0 *1 0,0
Xsky130_fd_sc_hd__fill_2_328 VGND VPWR VPWR sky130_fd_sc_hd__fill_2
* cell instance sky130_fd_sc_hd__fill_2_329 r0 *1 0,0
Xsky130_fd_sc_hd__fill_2_329 VGND VPWR VPWR sky130_fd_sc_hd__fill_2
* cell instance sky130_fd_sc_hd__fill_2_330 r0 *1 0,0
Xsky130_fd_sc_hd__fill_2_330 VGND VPWR VPWR sky130_fd_sc_hd__fill_2
* cell instance sky130_fd_sc_hd__fill_2_331 r0 *1 0,0
Xsky130_fd_sc_hd__fill_2_331 VGND VPWR VPWR sky130_fd_sc_hd__fill_2
* cell instance sky130_fd_sc_hd__fill_2_332 r0 *1 0,0
Xsky130_fd_sc_hd__fill_2_332 VGND VPWR VPWR sky130_fd_sc_hd__fill_2
* cell instance sky130_fd_sc_hd__fill_2_333 r0 *1 0,0
Xsky130_fd_sc_hd__fill_2_333 VGND VPWR VPWR sky130_fd_sc_hd__fill_2
* cell instance sky130_fd_sc_hd__fill_2_334 r0 *1 0,0
Xsky130_fd_sc_hd__fill_2_334 VGND VPWR VPWR sky130_fd_sc_hd__fill_2
* cell instance sky130_fd_sc_hd__fill_2_335 r0 *1 0,0
Xsky130_fd_sc_hd__fill_2_335 VGND VPWR VPWR sky130_fd_sc_hd__fill_2
* cell instance sky130_fd_sc_hd__fill_2_336 r0 *1 0,0
Xsky130_fd_sc_hd__fill_2_336 VGND VPWR VPWR sky130_fd_sc_hd__fill_2
* cell instance sky130_fd_sc_hd__fill_2_337 r0 *1 0,0
Xsky130_fd_sc_hd__fill_2_337 VGND VPWR VPWR sky130_fd_sc_hd__fill_2
* cell instance sky130_fd_sc_hd__fill_2_338 r0 *1 0,0
Xsky130_fd_sc_hd__fill_2_338 VGND VPWR VPWR sky130_fd_sc_hd__fill_2
* cell instance sky130_fd_sc_hd__fill_2_339 r0 *1 0,0
Xsky130_fd_sc_hd__fill_2_339 VGND VPWR VPWR sky130_fd_sc_hd__fill_2
* cell instance sky130_fd_sc_hd__fill_2_340 r0 *1 0,0
Xsky130_fd_sc_hd__fill_2_340 VGND VPWR VPWR sky130_fd_sc_hd__fill_2
* cell instance sky130_fd_sc_hd__fill_2_341 r0 *1 0,0
Xsky130_fd_sc_hd__fill_2_341 VGND VPWR VPWR sky130_fd_sc_hd__fill_2
* cell instance sky130_fd_sc_hd__fill_2_342 r0 *1 0,0
Xsky130_fd_sc_hd__fill_2_342 VGND VPWR VPWR sky130_fd_sc_hd__fill_2
* cell instance sky130_fd_sc_hd__fill_2_343 r0 *1 0,0
Xsky130_fd_sc_hd__fill_2_343 VGND VPWR VPWR sky130_fd_sc_hd__fill_2
* cell instance sky130_fd_sc_hd__fill_2_344 r0 *1 0,0
Xsky130_fd_sc_hd__fill_2_344 VGND VPWR VPWR sky130_fd_sc_hd__fill_2
* cell instance sky130_fd_sc_hd__fill_2_345 r0 *1 0,0
Xsky130_fd_sc_hd__fill_2_345 VGND VPWR VPWR sky130_fd_sc_hd__fill_2
* cell instance sky130_fd_sc_hd__fill_2_346 r0 *1 0,0
Xsky130_fd_sc_hd__fill_2_346 VGND VPWR VPWR sky130_fd_sc_hd__fill_2
* cell instance sky130_fd_sc_hd__fill_2_347 r0 *1 0,0
Xsky130_fd_sc_hd__fill_2_347 VGND VPWR VPWR sky130_fd_sc_hd__fill_2
* cell instance sky130_fd_sc_hd__fill_2_348 r0 *1 0,0
Xsky130_fd_sc_hd__fill_2_348 VGND VPWR VPWR sky130_fd_sc_hd__fill_2
* cell instance sky130_fd_sc_hd__fill_2_349 r0 *1 0,0
Xsky130_fd_sc_hd__fill_2_349 VGND VPWR VPWR sky130_fd_sc_hd__fill_2
* cell instance sky130_fd_sc_hd__fill_2_350 r0 *1 0,0
Xsky130_fd_sc_hd__fill_2_350 VGND VPWR VPWR sky130_fd_sc_hd__fill_2
* cell instance sky130_fd_sc_hd__fill_2_351 r0 *1 0,0
Xsky130_fd_sc_hd__fill_2_351 VGND VPWR VPWR sky130_fd_sc_hd__fill_2
* cell instance sky130_fd_sc_hd__fill_2_352 r0 *1 0,0
Xsky130_fd_sc_hd__fill_2_352 VGND VPWR VPWR sky130_fd_sc_hd__fill_2
* cell instance sky130_fd_sc_hd__fill_2_353 r0 *1 0,0
Xsky130_fd_sc_hd__fill_2_353 VGND VPWR VPWR sky130_fd_sc_hd__fill_2
* cell instance sky130_fd_sc_hd__fill_2_354 r0 *1 0,0
Xsky130_fd_sc_hd__fill_2_354 VGND VPWR VPWR sky130_fd_sc_hd__fill_2
* cell instance sky130_fd_sc_hd__fill_2_355 r0 *1 0,0
Xsky130_fd_sc_hd__fill_2_355 VGND VPWR VPWR sky130_fd_sc_hd__fill_2
* cell instance sky130_fd_sc_hd__fill_2_356 r0 *1 0,0
Xsky130_fd_sc_hd__fill_2_356 VGND VPWR VPWR sky130_fd_sc_hd__fill_2
* cell instance sky130_fd_sc_hd__fill_2_357 r0 *1 0,0
Xsky130_fd_sc_hd__fill_2_357 VGND VPWR VPWR sky130_fd_sc_hd__fill_2
* cell instance sky130_fd_sc_hd__fill_2_358 r0 *1 0,0
Xsky130_fd_sc_hd__fill_2_358 VGND VPWR VPWR sky130_fd_sc_hd__fill_2
* cell instance sky130_fd_sc_hd__fill_2_359 r0 *1 0,0
Xsky130_fd_sc_hd__fill_2_359 VGND VPWR VPWR sky130_fd_sc_hd__fill_2
* cell instance sky130_fd_sc_hd__fill_2_360 r0 *1 0,0
Xsky130_fd_sc_hd__fill_2_360 VGND VPWR VPWR sky130_fd_sc_hd__fill_2
* cell instance sky130_fd_sc_hd__fill_2_361 r0 *1 0,0
Xsky130_fd_sc_hd__fill_2_361 VGND VPWR VPWR sky130_fd_sc_hd__fill_2
* cell instance sky130_fd_sc_hd__fill_2_362 r0 *1 0,0
Xsky130_fd_sc_hd__fill_2_362 VGND VPWR VPWR sky130_fd_sc_hd__fill_2
* cell instance sky130_fd_sc_hd__fill_2_363 r0 *1 0,0
Xsky130_fd_sc_hd__fill_2_363 VGND VPWR VPWR sky130_fd_sc_hd__fill_2
* cell instance sky130_fd_sc_hd__fill_2_364 r0 *1 0,0
Xsky130_fd_sc_hd__fill_2_364 VGND VPWR VPWR sky130_fd_sc_hd__fill_2
* cell instance sky130_fd_sc_hd__fill_2_365 r0 *1 0,0
Xsky130_fd_sc_hd__fill_2_365 VGND VPWR VPWR sky130_fd_sc_hd__fill_2
* cell instance sky130_fd_sc_hd__fill_2_366 r0 *1 0,0
Xsky130_fd_sc_hd__fill_2_366 VGND VPWR VPWR sky130_fd_sc_hd__fill_2
* cell instance sky130_fd_sc_hd__fill_2_367 r0 *1 0,0
Xsky130_fd_sc_hd__fill_2_367 VGND VPWR VPWR sky130_fd_sc_hd__fill_2
* cell instance sky130_fd_sc_hd__fill_2_368 r0 *1 0,0
Xsky130_fd_sc_hd__fill_2_368 VGND VPWR VPWR sky130_fd_sc_hd__fill_2
* cell instance sky130_fd_sc_hd__fill_2_369 r0 *1 0,0
Xsky130_fd_sc_hd__fill_2_369 VGND VPWR VPWR sky130_fd_sc_hd__fill_2
* cell instance sky130_fd_sc_hd__fill_2_370 r0 *1 0,0
Xsky130_fd_sc_hd__fill_2_370 VGND VPWR VPWR sky130_fd_sc_hd__fill_2
* cell instance sky130_fd_sc_hd__fill_2_371 r0 *1 0,0
Xsky130_fd_sc_hd__fill_2_371 VGND VPWR VPWR sky130_fd_sc_hd__fill_2
* cell instance sky130_fd_sc_hd__fill_2_372 r0 *1 0,0
Xsky130_fd_sc_hd__fill_2_372 VGND VPWR VPWR sky130_fd_sc_hd__fill_2
* cell instance sky130_fd_sc_hd__fill_2_373 r0 *1 0,0
Xsky130_fd_sc_hd__fill_2_373 VGND VPWR VPWR sky130_fd_sc_hd__fill_2
* cell instance sky130_fd_sc_hd__fill_2_374 r0 *1 0,0
Xsky130_fd_sc_hd__fill_2_374 VGND VPWR VPWR sky130_fd_sc_hd__fill_2
* cell instance sky130_fd_sc_hd__fill_2_375 r0 *1 0,0
Xsky130_fd_sc_hd__fill_2_375 VGND VPWR VPWR sky130_fd_sc_hd__fill_2
* cell instance sky130_fd_sc_hd__fill_2_376 r0 *1 0,0
Xsky130_fd_sc_hd__fill_2_376 VGND VPWR VPWR sky130_fd_sc_hd__fill_2
* cell instance sky130_fd_sc_hd__fill_2_377 r0 *1 0,0
Xsky130_fd_sc_hd__fill_2_377 VGND VPWR VPWR sky130_fd_sc_hd__fill_2
* cell instance sky130_fd_sc_hd__fill_2_378 r0 *1 0,0
Xsky130_fd_sc_hd__fill_2_378 VGND VPWR VPWR sky130_fd_sc_hd__fill_2
* cell instance sky130_fd_sc_hd__fill_2_379 r0 *1 0,0
Xsky130_fd_sc_hd__fill_2_379 VGND VPWR VPWR sky130_fd_sc_hd__fill_2
* cell instance sky130_fd_sc_hd__fill_2_380 r0 *1 0,0
Xsky130_fd_sc_hd__fill_2_380 VGND VPWR VPWR sky130_fd_sc_hd__fill_2
* cell instance sky130_fd_sc_hd__fill_2_381 r0 *1 0,0
Xsky130_fd_sc_hd__fill_2_381 VGND VPWR VPWR sky130_fd_sc_hd__fill_2
* cell instance sky130_fd_sc_hd__fill_2_382 r0 *1 0,0
Xsky130_fd_sc_hd__fill_2_382 VGND VPWR VPWR sky130_fd_sc_hd__fill_2
* cell instance sky130_fd_sc_hd__fill_2_383 r0 *1 0,0
Xsky130_fd_sc_hd__fill_2_383 VGND VPWR VPWR sky130_fd_sc_hd__fill_2
* cell instance sky130_fd_sc_hd__fill_2_384 r0 *1 0,0
Xsky130_fd_sc_hd__fill_2_384 VGND VPWR VPWR sky130_fd_sc_hd__fill_2
* cell instance sky130_fd_sc_hd__fill_2_385 r0 *1 0,0
Xsky130_fd_sc_hd__fill_2_385 VGND VPWR VPWR sky130_fd_sc_hd__fill_2
* cell instance sky130_fd_sc_hd__fill_2_386 r0 *1 0,0
Xsky130_fd_sc_hd__fill_2_386 VGND VPWR VPWR sky130_fd_sc_hd__fill_2
* cell instance sky130_fd_sc_hd__fill_2_387 r0 *1 0,0
Xsky130_fd_sc_hd__fill_2_387 VGND VPWR VPWR sky130_fd_sc_hd__fill_2
* cell instance sky130_fd_sc_hd__fill_2_388 r0 *1 0,0
Xsky130_fd_sc_hd__fill_2_388 VGND VPWR VPWR sky130_fd_sc_hd__fill_2
* cell instance sky130_fd_sc_hd__fill_2_389 r0 *1 0,0
Xsky130_fd_sc_hd__fill_2_389 VGND VPWR VPWR sky130_fd_sc_hd__fill_2
* cell instance sky130_fd_sc_hd__fill_2_390 r0 *1 0,0
Xsky130_fd_sc_hd__fill_2_390 VGND VPWR VPWR sky130_fd_sc_hd__fill_2
* cell instance sky130_fd_sc_hd__fill_2_391 r0 *1 0,0
Xsky130_fd_sc_hd__fill_2_391 VGND VPWR VPWR sky130_fd_sc_hd__fill_2
* cell instance sky130_fd_sc_hd__fill_2_392 r0 *1 0,0
Xsky130_fd_sc_hd__fill_2_392 VGND VPWR VPWR sky130_fd_sc_hd__fill_2
* cell instance sky130_fd_sc_hd__fill_2_393 r0 *1 0,0
Xsky130_fd_sc_hd__fill_2_393 VGND VPWR VPWR sky130_fd_sc_hd__fill_2
* cell instance sky130_fd_sc_hd__fill_2_394 r0 *1 0,0
Xsky130_fd_sc_hd__fill_2_394 VGND VPWR VPWR sky130_fd_sc_hd__fill_2
* cell instance sky130_fd_sc_hd__fill_2_395 r0 *1 0,0
Xsky130_fd_sc_hd__fill_2_395 VGND VPWR VPWR sky130_fd_sc_hd__fill_2
* cell instance sky130_fd_sc_hd__fill_2_396 r0 *1 0,0
Xsky130_fd_sc_hd__fill_2_396 VGND VPWR VPWR sky130_fd_sc_hd__fill_2
* cell instance sky130_fd_sc_hd__fill_2_397 r0 *1 0,0
Xsky130_fd_sc_hd__fill_2_397 VGND VPWR VPWR sky130_fd_sc_hd__fill_2
* cell instance sky130_fd_sc_hd__fill_2_398 r0 *1 0,0
Xsky130_fd_sc_hd__fill_2_398 VGND VPWR VPWR sky130_fd_sc_hd__fill_2
* cell instance sky130_fd_sc_hd__fill_2_399 r0 *1 0,0
Xsky130_fd_sc_hd__fill_2_399 VGND VPWR VPWR sky130_fd_sc_hd__fill_2
* cell instance sky130_fd_sc_hd__fill_2_400 r0 *1 0,0
Xsky130_fd_sc_hd__fill_2_400 VGND VPWR VPWR sky130_fd_sc_hd__fill_2
* cell instance sky130_fd_sc_hd__fill_2_401 r0 *1 0,0
Xsky130_fd_sc_hd__fill_2_401 VGND VPWR VPWR sky130_fd_sc_hd__fill_2
* cell instance sky130_fd_sc_hd__fill_2_402 r0 *1 0,0
Xsky130_fd_sc_hd__fill_2_402 VGND VPWR VPWR sky130_fd_sc_hd__fill_2
* cell instance sky130_fd_sc_hd__fill_2_403 r0 *1 0,0
Xsky130_fd_sc_hd__fill_2_403 VGND VPWR VPWR sky130_fd_sc_hd__fill_2
* cell instance sky130_fd_sc_hd__fill_2_404 r0 *1 0,0
Xsky130_fd_sc_hd__fill_2_404 VGND VPWR VPWR sky130_fd_sc_hd__fill_2
* cell instance sky130_fd_sc_hd__fill_2_405 r0 *1 0,0
Xsky130_fd_sc_hd__fill_2_405 VGND VPWR VPWR sky130_fd_sc_hd__fill_2
* cell instance sky130_fd_sc_hd__fill_2_406 r0 *1 0,0
Xsky130_fd_sc_hd__fill_2_406 VGND VPWR VPWR sky130_fd_sc_hd__fill_2
* cell instance sky130_fd_sc_hd__fill_2_407 r0 *1 0,0
Xsky130_fd_sc_hd__fill_2_407 VGND VPWR VPWR sky130_fd_sc_hd__fill_2
* cell instance sky130_fd_sc_hd__fill_2_408 r0 *1 0,0
Xsky130_fd_sc_hd__fill_2_408 VGND VPWR VPWR sky130_fd_sc_hd__fill_2
* cell instance sky130_fd_sc_hd__fill_2_409 r0 *1 0,0
Xsky130_fd_sc_hd__fill_2_409 VGND VPWR VPWR sky130_fd_sc_hd__fill_2
* cell instance sky130_fd_sc_hd__fill_2_410 r0 *1 0,0
Xsky130_fd_sc_hd__fill_2_410 VGND VPWR VPWR sky130_fd_sc_hd__fill_2
* cell instance sky130_fd_sc_hd__fill_2_411 r0 *1 0,0
Xsky130_fd_sc_hd__fill_2_411 VGND VPWR VPWR sky130_fd_sc_hd__fill_2
* cell instance sky130_fd_sc_hd__fill_2_412 r0 *1 0,0
Xsky130_fd_sc_hd__fill_2_412 VGND VPWR VPWR sky130_fd_sc_hd__fill_2
* cell instance sky130_fd_sc_hd__fill_2_413 r0 *1 0,0
Xsky130_fd_sc_hd__fill_2_413 VGND VPWR VPWR sky130_fd_sc_hd__fill_2
* cell instance sky130_fd_sc_hd__fill_2_414 r0 *1 0,0
Xsky130_fd_sc_hd__fill_2_414 VGND VPWR VPWR sky130_fd_sc_hd__fill_2
* cell instance sky130_fd_sc_hd__fill_2_415 r0 *1 0,0
Xsky130_fd_sc_hd__fill_2_415 VGND VPWR VPWR sky130_fd_sc_hd__fill_2
* cell instance sky130_fd_sc_hd__fill_2_416 r0 *1 0,0
Xsky130_fd_sc_hd__fill_2_416 VGND VPWR VPWR sky130_fd_sc_hd__fill_2
* cell instance sky130_fd_sc_hd__fill_2_417 r0 *1 0,0
Xsky130_fd_sc_hd__fill_2_417 VGND VPWR VPWR sky130_fd_sc_hd__fill_2
* cell instance sky130_fd_sc_hd__fill_2_418 r0 *1 0,0
Xsky130_fd_sc_hd__fill_2_418 VGND VPWR VPWR sky130_fd_sc_hd__fill_2
* cell instance sky130_fd_sc_hd__fill_2_419 r0 *1 0,0
Xsky130_fd_sc_hd__fill_2_419 VGND VPWR VPWR sky130_fd_sc_hd__fill_2
* cell instance sky130_fd_sc_hd__fill_2_420 r0 *1 0,0
Xsky130_fd_sc_hd__fill_2_420 VGND VPWR VPWR sky130_fd_sc_hd__fill_2
* cell instance sky130_fd_sc_hd__fill_2_421 r0 *1 0,0
Xsky130_fd_sc_hd__fill_2_421 VGND VPWR VPWR sky130_fd_sc_hd__fill_2
* cell instance sky130_fd_sc_hd__fill_2_422 r0 *1 0,0
Xsky130_fd_sc_hd__fill_2_422 VGND VPWR VPWR sky130_fd_sc_hd__fill_2
* cell instance sky130_fd_sc_hd__fill_2_423 r0 *1 0,0
Xsky130_fd_sc_hd__fill_2_423 VGND VPWR VPWR sky130_fd_sc_hd__fill_2
* cell instance sky130_fd_sc_hd__fill_2_424 r0 *1 0,0
Xsky130_fd_sc_hd__fill_2_424 VGND VPWR VPWR sky130_fd_sc_hd__fill_2
* cell instance sky130_fd_sc_hd__fill_2_425 r0 *1 0,0
Xsky130_fd_sc_hd__fill_2_425 VGND VPWR VPWR sky130_fd_sc_hd__fill_2
* cell instance sky130_fd_sc_hd__fill_2_426 r0 *1 0,0
Xsky130_fd_sc_hd__fill_2_426 VGND VPWR VPWR sky130_fd_sc_hd__fill_2
* cell instance sky130_fd_sc_hd__fill_2_427 r0 *1 0,0
Xsky130_fd_sc_hd__fill_2_427 VGND VPWR VPWR sky130_fd_sc_hd__fill_2
* cell instance sky130_fd_sc_hd__fill_2_428 r0 *1 0,0
Xsky130_fd_sc_hd__fill_2_428 VGND VPWR VPWR sky130_fd_sc_hd__fill_2
* cell instance sky130_fd_sc_hd__fill_2_429 r0 *1 0,0
Xsky130_fd_sc_hd__fill_2_429 VGND VPWR VPWR sky130_fd_sc_hd__fill_2
* cell instance sky130_fd_sc_hd__fill_2_430 r0 *1 0,0
Xsky130_fd_sc_hd__fill_2_430 VGND VPWR VPWR sky130_fd_sc_hd__fill_2
* cell instance sky130_fd_sc_hd__fill_2_431 r0 *1 0,0
Xsky130_fd_sc_hd__fill_2_431 VGND VPWR VPWR sky130_fd_sc_hd__fill_2
* cell instance sky130_fd_sc_hd__fill_2_432 r0 *1 0,0
Xsky130_fd_sc_hd__fill_2_432 VGND VPWR VPWR sky130_fd_sc_hd__fill_2
* cell instance sky130_fd_sc_hd__fill_2_433 r0 *1 0,0
Xsky130_fd_sc_hd__fill_2_433 VGND VPWR VPWR sky130_fd_sc_hd__fill_2
* cell instance sky130_fd_sc_hd__fill_2_434 r0 *1 0,0
Xsky130_fd_sc_hd__fill_2_434 VGND VPWR VPWR sky130_fd_sc_hd__fill_2
* cell instance sky130_fd_sc_hd__fill_2_435 r0 *1 0,0
Xsky130_fd_sc_hd__fill_2_435 VGND VPWR VPWR sky130_fd_sc_hd__fill_2
* cell instance sky130_fd_sc_hd__fill_2_436 r0 *1 0,0
Xsky130_fd_sc_hd__fill_2_436 VGND VPWR VPWR sky130_fd_sc_hd__fill_2
* cell instance sky130_fd_sc_hd__fill_2_437 r0 *1 0,0
Xsky130_fd_sc_hd__fill_2_437 VGND VPWR VPWR sky130_fd_sc_hd__fill_2
* cell instance sky130_fd_sc_hd__fill_2_438 r0 *1 0,0
Xsky130_fd_sc_hd__fill_2_438 VGND VPWR VPWR sky130_fd_sc_hd__fill_2
* cell instance sky130_fd_sc_hd__fill_2_439 r0 *1 0,0
Xsky130_fd_sc_hd__fill_2_439 VGND VPWR VPWR sky130_fd_sc_hd__fill_2
* cell instance sky130_fd_sc_hd__fill_2_440 r0 *1 0,0
Xsky130_fd_sc_hd__fill_2_440 VGND VPWR VPWR sky130_fd_sc_hd__fill_2
* cell instance sky130_fd_sc_hd__fill_2_441 r0 *1 0,0
Xsky130_fd_sc_hd__fill_2_441 VGND VPWR VPWR sky130_fd_sc_hd__fill_2
* cell instance sky130_fd_sc_hd__fill_2_442 r0 *1 0,0
Xsky130_fd_sc_hd__fill_2_442 VGND VPWR VPWR sky130_fd_sc_hd__fill_2
* cell instance sky130_fd_sc_hd__fill_2_443 r0 *1 0,0
Xsky130_fd_sc_hd__fill_2_443 VGND VPWR VPWR sky130_fd_sc_hd__fill_2
* cell instance sky130_fd_sc_hd__fill_2_444 r0 *1 0,0
Xsky130_fd_sc_hd__fill_2_444 VGND VPWR VPWR sky130_fd_sc_hd__fill_2
* cell instance sky130_fd_sc_hd__fill_2_445 r0 *1 0,0
Xsky130_fd_sc_hd__fill_2_445 VGND VPWR VPWR sky130_fd_sc_hd__fill_2
* cell instance sky130_fd_sc_hd__fill_2_446 r0 *1 0,0
Xsky130_fd_sc_hd__fill_2_446 VGND VPWR VPWR sky130_fd_sc_hd__fill_2
* cell instance sky130_fd_sc_hd__fill_2_447 r0 *1 0,0
Xsky130_fd_sc_hd__fill_2_447 VGND VPWR VPWR sky130_fd_sc_hd__fill_2
* cell instance sky130_fd_sc_hd__fill_2_448 r0 *1 0,0
Xsky130_fd_sc_hd__fill_2_448 VGND VPWR VPWR sky130_fd_sc_hd__fill_2
* cell instance sky130_fd_sc_hd__fill_2_449 r0 *1 0,0
Xsky130_fd_sc_hd__fill_2_449 VGND VPWR VPWR sky130_fd_sc_hd__fill_2
* cell instance sky130_fd_sc_hd__fill_2_450 r0 *1 0,0
Xsky130_fd_sc_hd__fill_2_450 VGND VPWR VPWR sky130_fd_sc_hd__fill_2
* cell instance sky130_fd_sc_hd__fill_2_451 r0 *1 0,0
Xsky130_fd_sc_hd__fill_2_451 VGND VPWR VPWR sky130_fd_sc_hd__fill_2
* cell instance sky130_fd_sc_hd__fill_2_452 r0 *1 0,0
Xsky130_fd_sc_hd__fill_2_452 VGND VPWR VPWR sky130_fd_sc_hd__fill_2
* cell instance sky130_fd_sc_hd__fill_2_453 r0 *1 0,0
Xsky130_fd_sc_hd__fill_2_453 VGND VPWR VPWR sky130_fd_sc_hd__fill_2
* cell instance sky130_fd_sc_hd__fill_2_454 r0 *1 0,0
Xsky130_fd_sc_hd__fill_2_454 VGND VPWR VPWR sky130_fd_sc_hd__fill_2
* cell instance sky130_fd_sc_hd__fill_2_455 r0 *1 0,0
Xsky130_fd_sc_hd__fill_2_455 VGND VPWR VPWR sky130_fd_sc_hd__fill_2
* cell instance sky130_fd_sc_hd__fill_2_456 r0 *1 0,0
Xsky130_fd_sc_hd__fill_2_456 VGND VPWR VPWR sky130_fd_sc_hd__fill_2
* cell instance sky130_fd_sc_hd__fill_2_457 r0 *1 0,0
Xsky130_fd_sc_hd__fill_2_457 VGND VPWR VPWR sky130_fd_sc_hd__fill_2
* cell instance sky130_fd_sc_hd__fill_2_458 r0 *1 0,0
Xsky130_fd_sc_hd__fill_2_458 VGND VPWR VPWR sky130_fd_sc_hd__fill_2
* cell instance sky130_fd_sc_hd__fill_2_459 r0 *1 0,0
Xsky130_fd_sc_hd__fill_2_459 VGND VPWR VPWR sky130_fd_sc_hd__fill_2
* cell instance sky130_fd_sc_hd__fill_2_460 r0 *1 0,0
Xsky130_fd_sc_hd__fill_2_460 VGND VPWR VPWR sky130_fd_sc_hd__fill_2
* cell instance sky130_fd_sc_hd__fill_2_461 r0 *1 0,0
Xsky130_fd_sc_hd__fill_2_461 VGND VPWR VPWR sky130_fd_sc_hd__fill_2
* cell instance sky130_fd_sc_hd__fill_2_462 r0 *1 0,0
Xsky130_fd_sc_hd__fill_2_462 VGND VPWR VPWR sky130_fd_sc_hd__fill_2
* cell instance sky130_fd_sc_hd__fill_2_463 r0 *1 0,0
Xsky130_fd_sc_hd__fill_2_463 VGND VPWR VPWR sky130_fd_sc_hd__fill_2
* cell instance sky130_fd_sc_hd__fill_2_464 r0 *1 0,0
Xsky130_fd_sc_hd__fill_2_464 VGND VPWR VPWR sky130_fd_sc_hd__fill_2
* cell instance sky130_fd_sc_hd__fill_2_465 r0 *1 0,0
Xsky130_fd_sc_hd__fill_2_465 VGND VPWR VPWR sky130_fd_sc_hd__fill_2
* cell instance sky130_fd_sc_hd__fill_2_466 r0 *1 0,0
Xsky130_fd_sc_hd__fill_2_466 VGND VPWR VPWR sky130_fd_sc_hd__fill_2
* cell instance sky130_fd_sc_hd__fill_2_467 r0 *1 0,0
Xsky130_fd_sc_hd__fill_2_467 VGND VPWR VPWR sky130_fd_sc_hd__fill_2
* cell instance sky130_fd_sc_hd__fill_2_468 r0 *1 0,0
Xsky130_fd_sc_hd__fill_2_468 VGND VPWR VPWR sky130_fd_sc_hd__fill_2
* cell instance sky130_fd_sc_hd__fill_2_469 r0 *1 0,0
Xsky130_fd_sc_hd__fill_2_469 VGND VPWR VPWR sky130_fd_sc_hd__fill_2
* cell instance sky130_fd_sc_hd__fill_2_470 r0 *1 0,0
Xsky130_fd_sc_hd__fill_2_470 VGND VPWR VPWR sky130_fd_sc_hd__fill_2
* cell instance sky130_fd_sc_hd__fill_2_471 r0 *1 0,0
Xsky130_fd_sc_hd__fill_2_471 VGND VPWR VPWR sky130_fd_sc_hd__fill_2
* cell instance sky130_fd_sc_hd__fill_2_472 r0 *1 0,0
Xsky130_fd_sc_hd__fill_2_472 VGND VPWR VPWR sky130_fd_sc_hd__fill_2
* cell instance sky130_fd_sc_hd__fill_2_473 r0 *1 0,0
Xsky130_fd_sc_hd__fill_2_473 VGND VPWR VPWR sky130_fd_sc_hd__fill_2
* cell instance sky130_fd_sc_hd__fill_2_474 r0 *1 0,0
Xsky130_fd_sc_hd__fill_2_474 VGND VPWR VPWR sky130_fd_sc_hd__fill_2
* cell instance sky130_fd_sc_hd__fill_2_475 r0 *1 0,0
Xsky130_fd_sc_hd__fill_2_475 VGND VPWR VPWR sky130_fd_sc_hd__fill_2
* cell instance sky130_fd_sc_hd__fill_2_476 r0 *1 0,0
Xsky130_fd_sc_hd__fill_2_476 VGND VPWR VPWR sky130_fd_sc_hd__fill_2
* cell instance sky130_fd_sc_hd__fill_2_477 r0 *1 0,0
Xsky130_fd_sc_hd__fill_2_477 VGND VPWR VPWR sky130_fd_sc_hd__fill_2
* cell instance sky130_fd_sc_hd__fill_2_478 r0 *1 0,0
Xsky130_fd_sc_hd__fill_2_478 VGND VPWR VPWR sky130_fd_sc_hd__fill_2
* cell instance sky130_fd_sc_hd__fill_2_479 r0 *1 0,0
Xsky130_fd_sc_hd__fill_2_479 VGND VPWR VPWR sky130_fd_sc_hd__fill_2
* cell instance sky130_fd_sc_hd__fill_2_480 r0 *1 0,0
Xsky130_fd_sc_hd__fill_2_480 VGND VPWR VPWR sky130_fd_sc_hd__fill_2
* cell instance sky130_fd_sc_hd__fill_2_481 r0 *1 0,0
Xsky130_fd_sc_hd__fill_2_481 VGND VPWR VPWR sky130_fd_sc_hd__fill_2
* cell instance sky130_fd_sc_hd__fill_2_482 r0 *1 0,0
Xsky130_fd_sc_hd__fill_2_482 VGND VPWR VPWR sky130_fd_sc_hd__fill_2
* cell instance sky130_fd_sc_hd__fill_2_483 r0 *1 0,0
Xsky130_fd_sc_hd__fill_2_483 VGND VPWR VPWR sky130_fd_sc_hd__fill_2
* cell instance sky130_fd_sc_hd__fill_2_484 r0 *1 0,0
Xsky130_fd_sc_hd__fill_2_484 VGND VPWR VPWR sky130_fd_sc_hd__fill_2
* cell instance sky130_fd_sc_hd__fill_2_485 r0 *1 0,0
Xsky130_fd_sc_hd__fill_2_485 VGND VPWR VPWR sky130_fd_sc_hd__fill_2
* cell instance sky130_fd_sc_hd__fill_2_486 r0 *1 0,0
Xsky130_fd_sc_hd__fill_2_486 VGND VPWR VPWR sky130_fd_sc_hd__fill_2
* cell instance sky130_fd_sc_hd__fill_2_487 r0 *1 0,0
Xsky130_fd_sc_hd__fill_2_487 VGND VPWR VPWR sky130_fd_sc_hd__fill_2
* cell instance sky130_fd_sc_hd__fill_2_488 r0 *1 0,0
Xsky130_fd_sc_hd__fill_2_488 VGND VPWR VPWR sky130_fd_sc_hd__fill_2
* cell instance sky130_fd_sc_hd__fill_2_489 r0 *1 0,0
Xsky130_fd_sc_hd__fill_2_489 VGND VPWR VPWR sky130_fd_sc_hd__fill_2
* cell instance sky130_fd_sc_hd__fill_2_490 r0 *1 0,0
Xsky130_fd_sc_hd__fill_2_490 VGND VPWR VPWR sky130_fd_sc_hd__fill_2
* cell instance sky130_fd_sc_hd__fill_2_491 r0 *1 0,0
Xsky130_fd_sc_hd__fill_2_491 VGND VPWR VPWR sky130_fd_sc_hd__fill_2
* cell instance sky130_fd_sc_hd__fill_2_492 r0 *1 0,0
Xsky130_fd_sc_hd__fill_2_492 VGND VPWR VPWR sky130_fd_sc_hd__fill_2
* cell instance sky130_fd_sc_hd__fill_2_493 r0 *1 0,0
Xsky130_fd_sc_hd__fill_2_493 VGND VPWR VPWR sky130_fd_sc_hd__fill_2
* cell instance sky130_fd_sc_hd__fill_2_494 r0 *1 0,0
Xsky130_fd_sc_hd__fill_2_494 VGND VPWR VPWR sky130_fd_sc_hd__fill_2
* cell instance sky130_fd_sc_hd__fill_2_495 r0 *1 0,0
Xsky130_fd_sc_hd__fill_2_495 VGND VPWR VPWR sky130_fd_sc_hd__fill_2
* cell instance sky130_fd_sc_hd__fill_2_496 r0 *1 0,0
Xsky130_fd_sc_hd__fill_2_496 VGND VPWR VPWR sky130_fd_sc_hd__fill_2
* cell instance sky130_fd_sc_hd__fill_2_497 r0 *1 0,0
Xsky130_fd_sc_hd__fill_2_497 VGND VPWR VPWR sky130_fd_sc_hd__fill_2
* cell instance sky130_fd_sc_hd__fill_2_498 r0 *1 0,0
Xsky130_fd_sc_hd__fill_2_498 VGND VPWR VPWR sky130_fd_sc_hd__fill_2
* cell instance sky130_fd_sc_hd__fill_2_499 r0 *1 0,0
Xsky130_fd_sc_hd__fill_2_499 VGND VPWR VPWR sky130_fd_sc_hd__fill_2
* cell instance sky130_fd_sc_hd__fill_2_500 r0 *1 0,0
Xsky130_fd_sc_hd__fill_2_500 VGND VPWR VPWR sky130_fd_sc_hd__fill_2
* cell instance sky130_fd_sc_hd__fill_2_501 r0 *1 0,0
Xsky130_fd_sc_hd__fill_2_501 VGND VPWR VPWR sky130_fd_sc_hd__fill_2
* cell instance sky130_fd_sc_hd__fill_2_502 r0 *1 0,0
Xsky130_fd_sc_hd__fill_2_502 VGND VPWR VPWR sky130_fd_sc_hd__fill_2
* cell instance sky130_fd_sc_hd__fill_2_503 r0 *1 0,0
Xsky130_fd_sc_hd__fill_2_503 VGND VPWR VPWR sky130_fd_sc_hd__fill_2
* cell instance sky130_fd_sc_hd__fill_2_504 r0 *1 0,0
Xsky130_fd_sc_hd__fill_2_504 VGND VPWR VPWR sky130_fd_sc_hd__fill_2
* cell instance sky130_fd_sc_hd__fill_2_505 r0 *1 0,0
Xsky130_fd_sc_hd__fill_2_505 VGND VPWR VPWR sky130_fd_sc_hd__fill_2
* cell instance sky130_fd_sc_hd__fill_2_506 r0 *1 0,0
Xsky130_fd_sc_hd__fill_2_506 VGND VPWR VPWR sky130_fd_sc_hd__fill_2
* cell instance sky130_fd_sc_hd__fill_2_507 r0 *1 0,0
Xsky130_fd_sc_hd__fill_2_507 VGND VPWR VPWR sky130_fd_sc_hd__fill_2
* cell instance sky130_fd_sc_hd__fill_2_508 r0 *1 0,0
Xsky130_fd_sc_hd__fill_2_508 VGND VPWR VPWR sky130_fd_sc_hd__fill_2
* cell instance sky130_fd_sc_hd__fill_2_509 r0 *1 0,0
Xsky130_fd_sc_hd__fill_2_509 VGND VPWR VPWR sky130_fd_sc_hd__fill_2
* cell instance sky130_fd_sc_hd__fill_2_510 r0 *1 0,0
Xsky130_fd_sc_hd__fill_2_510 VGND VPWR VPWR sky130_fd_sc_hd__fill_2
* cell instance sky130_fd_sc_hd__fill_2_511 r0 *1 0,0
Xsky130_fd_sc_hd__fill_2_511 VGND VPWR VPWR sky130_fd_sc_hd__fill_2
* cell instance sky130_fd_sc_hd__fill_2_512 r0 *1 0,0
Xsky130_fd_sc_hd__fill_2_512 VGND VPWR VPWR sky130_fd_sc_hd__fill_2
* cell instance sky130_fd_sc_hd__fill_2_513 r0 *1 0,0
Xsky130_fd_sc_hd__fill_2_513 VGND VPWR VPWR sky130_fd_sc_hd__fill_2
* cell instance sky130_fd_sc_hd__fill_2_514 r0 *1 0,0
Xsky130_fd_sc_hd__fill_2_514 VGND VPWR VPWR sky130_fd_sc_hd__fill_2
* cell instance sky130_fd_sc_hd__fill_2_515 r0 *1 0,0
Xsky130_fd_sc_hd__fill_2_515 VGND VPWR VPWR sky130_fd_sc_hd__fill_2
* cell instance sky130_fd_sc_hd__fill_2_516 r0 *1 0,0
Xsky130_fd_sc_hd__fill_2_516 VGND VPWR VPWR sky130_fd_sc_hd__fill_2
* cell instance sky130_fd_sc_hd__fill_2_517 r0 *1 0,0
Xsky130_fd_sc_hd__fill_2_517 VGND VPWR VPWR sky130_fd_sc_hd__fill_2
* cell instance sky130_fd_sc_hd__fill_2_518 r0 *1 0,0
Xsky130_fd_sc_hd__fill_2_518 VGND VPWR VPWR sky130_fd_sc_hd__fill_2
* cell instance sky130_fd_sc_hd__fill_2_519 r0 *1 0,0
Xsky130_fd_sc_hd__fill_2_519 VGND VPWR VPWR sky130_fd_sc_hd__fill_2
* cell instance sky130_fd_sc_hd__fill_2_520 r0 *1 0,0
Xsky130_fd_sc_hd__fill_2_520 VGND VPWR VPWR sky130_fd_sc_hd__fill_2
* cell instance sky130_fd_sc_hd__fill_2_521 r0 *1 0,0
Xsky130_fd_sc_hd__fill_2_521 VGND VPWR VPWR sky130_fd_sc_hd__fill_2
* cell instance sky130_fd_sc_hd__fill_2_522 r0 *1 0,0
Xsky130_fd_sc_hd__fill_2_522 VGND VPWR VPWR sky130_fd_sc_hd__fill_2
* cell instance sky130_fd_sc_hd__fill_2_523 r0 *1 0,0
Xsky130_fd_sc_hd__fill_2_523 VGND VPWR VPWR sky130_fd_sc_hd__fill_2
* cell instance sky130_fd_sc_hd__fill_2_524 r0 *1 0,0
Xsky130_fd_sc_hd__fill_2_524 VGND VPWR VPWR sky130_fd_sc_hd__fill_2
* cell instance sky130_fd_sc_hd__fill_2_525 r0 *1 0,0
Xsky130_fd_sc_hd__fill_2_525 VGND VPWR VPWR sky130_fd_sc_hd__fill_2
* cell instance sky130_fd_sc_hd__fill_2_526 r0 *1 0,0
Xsky130_fd_sc_hd__fill_2_526 VGND VPWR VPWR sky130_fd_sc_hd__fill_2
* cell instance sky130_fd_sc_hd__fill_2_527 r0 *1 0,0
Xsky130_fd_sc_hd__fill_2_527 VGND VPWR VPWR sky130_fd_sc_hd__fill_2
* cell instance sky130_fd_sc_hd__fill_2_528 r0 *1 0,0
Xsky130_fd_sc_hd__fill_2_528 VGND VPWR VPWR sky130_fd_sc_hd__fill_2
* cell instance sky130_fd_sc_hd__fill_2_529 r0 *1 0,0
Xsky130_fd_sc_hd__fill_2_529 VGND VPWR VPWR sky130_fd_sc_hd__fill_2
* cell instance sky130_fd_sc_hd__fill_2_530 r0 *1 0,0
Xsky130_fd_sc_hd__fill_2_530 VGND VPWR VPWR sky130_fd_sc_hd__fill_2
* cell instance sky130_fd_sc_hd__fill_2_531 r0 *1 0,0
Xsky130_fd_sc_hd__fill_2_531 VGND VPWR VPWR sky130_fd_sc_hd__fill_2
* cell instance sky130_fd_sc_hd__fill_2_532 r0 *1 0,0
Xsky130_fd_sc_hd__fill_2_532 VGND VPWR VPWR sky130_fd_sc_hd__fill_2
* cell instance sky130_fd_sc_hd__fill_2_533 r0 *1 0,0
Xsky130_fd_sc_hd__fill_2_533 VGND VPWR VPWR sky130_fd_sc_hd__fill_2
* cell instance sky130_fd_sc_hd__fill_2_534 r0 *1 0,0
Xsky130_fd_sc_hd__fill_2_534 VGND VPWR VPWR sky130_fd_sc_hd__fill_2
* cell instance sky130_fd_sc_hd__fill_2_535 r0 *1 0,0
Xsky130_fd_sc_hd__fill_2_535 VGND VPWR VPWR sky130_fd_sc_hd__fill_2
* cell instance sky130_fd_sc_hd__fill_2_536 r0 *1 0,0
Xsky130_fd_sc_hd__fill_2_536 VGND VPWR VPWR sky130_fd_sc_hd__fill_2
* cell instance sky130_fd_sc_hd__fill_2_537 r0 *1 0,0
Xsky130_fd_sc_hd__fill_2_537 VGND VPWR VPWR sky130_fd_sc_hd__fill_2
* cell instance sky130_fd_sc_hd__fill_2_538 r0 *1 0,0
Xsky130_fd_sc_hd__fill_2_538 VGND VPWR VPWR sky130_fd_sc_hd__fill_2
* cell instance sky130_fd_sc_hd__fill_2_539 r0 *1 0,0
Xsky130_fd_sc_hd__fill_2_539 VGND VPWR VPWR sky130_fd_sc_hd__fill_2
* cell instance sky130_fd_sc_hd__fill_2_540 r0 *1 0,0
Xsky130_fd_sc_hd__fill_2_540 VGND VPWR VPWR sky130_fd_sc_hd__fill_2
* cell instance sky130_fd_sc_hd__fill_2_541 r0 *1 0,0
Xsky130_fd_sc_hd__fill_2_541 VGND VPWR VPWR sky130_fd_sc_hd__fill_2
* cell instance sky130_fd_sc_hd__fill_2_542 r0 *1 0,0
Xsky130_fd_sc_hd__fill_2_542 VGND VPWR VPWR sky130_fd_sc_hd__fill_2
* cell instance sky130_fd_sc_hd__fill_2_543 r0 *1 0,0
Xsky130_fd_sc_hd__fill_2_543 VGND VPWR VPWR sky130_fd_sc_hd__fill_2
* cell instance sky130_fd_sc_hd__fill_2_544 r0 *1 0,0
Xsky130_fd_sc_hd__fill_2_544 VGND VPWR VPWR sky130_fd_sc_hd__fill_2
* cell instance sky130_fd_sc_hd__fill_2_545 r0 *1 0,0
Xsky130_fd_sc_hd__fill_2_545 VGND VPWR VPWR sky130_fd_sc_hd__fill_2
* cell instance sky130_fd_sc_hd__fill_2_546 r0 *1 0,0
Xsky130_fd_sc_hd__fill_2_546 VGND VPWR VPWR sky130_fd_sc_hd__fill_2
* cell instance sky130_fd_sc_hd__fill_2_547 r0 *1 0,0
Xsky130_fd_sc_hd__fill_2_547 VGND VPWR VPWR sky130_fd_sc_hd__fill_2
* cell instance sky130_fd_sc_hd__fill_2_548 r0 *1 0,0
Xsky130_fd_sc_hd__fill_2_548 VGND VPWR VPWR sky130_fd_sc_hd__fill_2
* cell instance sky130_fd_sc_hd__fill_2_549 r0 *1 0,0
Xsky130_fd_sc_hd__fill_2_549 VGND VPWR VPWR sky130_fd_sc_hd__fill_2
* cell instance sky130_fd_sc_hd__fill_2_550 r0 *1 0,0
Xsky130_fd_sc_hd__fill_2_550 VGND VPWR VPWR sky130_fd_sc_hd__fill_2
* cell instance sky130_fd_sc_hd__fill_2_551 r0 *1 0,0
Xsky130_fd_sc_hd__fill_2_551 VGND VPWR VPWR sky130_fd_sc_hd__fill_2
* cell instance sky130_fd_sc_hd__fill_2_552 r0 *1 0,0
Xsky130_fd_sc_hd__fill_2_552 VGND VPWR VPWR sky130_fd_sc_hd__fill_2
* cell instance sky130_fd_sc_hd__fill_2_553 r0 *1 0,0
Xsky130_fd_sc_hd__fill_2_553 VGND VPWR VPWR sky130_fd_sc_hd__fill_2
* cell instance sky130_fd_sc_hd__fill_2_554 r0 *1 0,0
Xsky130_fd_sc_hd__fill_2_554 VGND VPWR VPWR sky130_fd_sc_hd__fill_2
* cell instance sky130_fd_sc_hd__fill_2_555 r0 *1 0,0
Xsky130_fd_sc_hd__fill_2_555 VGND VPWR VPWR sky130_fd_sc_hd__fill_2
* cell instance sky130_fd_sc_hd__fill_2_556 r0 *1 0,0
Xsky130_fd_sc_hd__fill_2_556 VGND VPWR VPWR sky130_fd_sc_hd__fill_2
* cell instance sky130_fd_sc_hd__fill_2_557 r0 *1 0,0
Xsky130_fd_sc_hd__fill_2_557 VGND VPWR VPWR sky130_fd_sc_hd__fill_2
* cell instance sky130_fd_sc_hd__fill_2_558 r0 *1 0,0
Xsky130_fd_sc_hd__fill_2_558 VGND VPWR VPWR sky130_fd_sc_hd__fill_2
* cell instance sky130_fd_sc_hd__fill_2_559 r0 *1 0,0
Xsky130_fd_sc_hd__fill_2_559 VGND VPWR VPWR sky130_fd_sc_hd__fill_2
* cell instance sky130_fd_sc_hd__fill_2_560 r0 *1 0,0
Xsky130_fd_sc_hd__fill_2_560 VGND VPWR VPWR sky130_fd_sc_hd__fill_2
* cell instance sky130_fd_sc_hd__fill_2_561 r0 *1 0,0
Xsky130_fd_sc_hd__fill_2_561 VGND VPWR VPWR sky130_fd_sc_hd__fill_2
* cell instance sky130_fd_sc_hd__fill_2_562 r0 *1 0,0
Xsky130_fd_sc_hd__fill_2_562 VGND VPWR VPWR sky130_fd_sc_hd__fill_2
* cell instance sky130_fd_sc_hd__fill_2_563 r0 *1 0,0
Xsky130_fd_sc_hd__fill_2_563 VGND VPWR VPWR sky130_fd_sc_hd__fill_2
* cell instance sky130_fd_sc_hd__fill_2_564 r0 *1 0,0
Xsky130_fd_sc_hd__fill_2_564 VGND VPWR VPWR sky130_fd_sc_hd__fill_2
* cell instance sky130_fd_sc_hd__fill_2_565 r0 *1 0,0
Xsky130_fd_sc_hd__fill_2_565 VGND VPWR VPWR sky130_fd_sc_hd__fill_2
* cell instance sky130_fd_sc_hd__fill_2_566 r0 *1 0,0
Xsky130_fd_sc_hd__fill_2_566 VGND VPWR VPWR sky130_fd_sc_hd__fill_2
* cell instance sky130_fd_sc_hd__fill_2_567 r0 *1 0,0
Xsky130_fd_sc_hd__fill_2_567 VGND VPWR VPWR sky130_fd_sc_hd__fill_2
* cell instance sky130_fd_sc_hd__fill_2_568 r0 *1 0,0
Xsky130_fd_sc_hd__fill_2_568 VGND VPWR VPWR sky130_fd_sc_hd__fill_2
* cell instance sky130_fd_sc_hd__fill_2_569 r0 *1 0,0
Xsky130_fd_sc_hd__fill_2_569 VGND VPWR VPWR sky130_fd_sc_hd__fill_2
* cell instance sky130_fd_sc_hd__fill_2_570 r0 *1 0,0
Xsky130_fd_sc_hd__fill_2_570 VGND VPWR VPWR sky130_fd_sc_hd__fill_2
* cell instance sky130_fd_sc_hd__fill_2_571 r0 *1 0,0
Xsky130_fd_sc_hd__fill_2_571 VGND VPWR VPWR sky130_fd_sc_hd__fill_2
* cell instance sky130_fd_sc_hd__fill_2_572 r0 *1 0,0
Xsky130_fd_sc_hd__fill_2_572 VGND VPWR VPWR sky130_fd_sc_hd__fill_2
* cell instance sky130_fd_sc_hd__fill_2_573 r0 *1 0,0
Xsky130_fd_sc_hd__fill_2_573 VGND VPWR VPWR sky130_fd_sc_hd__fill_2
* cell instance sky130_fd_sc_hd__fill_2_574 r0 *1 0,0
Xsky130_fd_sc_hd__fill_2_574 VGND VPWR VPWR sky130_fd_sc_hd__fill_2
* cell instance sky130_fd_sc_hd__fill_2_575 r0 *1 0,0
Xsky130_fd_sc_hd__fill_2_575 VGND VPWR VPWR sky130_fd_sc_hd__fill_2
* cell instance sky130_fd_sc_hd__fill_2_576 r0 *1 0,0
Xsky130_fd_sc_hd__fill_2_576 VGND VPWR VPWR sky130_fd_sc_hd__fill_2
* cell instance sky130_fd_sc_hd__fill_2_577 r0 *1 0,0
Xsky130_fd_sc_hd__fill_2_577 VGND VPWR VPWR sky130_fd_sc_hd__fill_2
* cell instance sky130_fd_sc_hd__fill_2_578 r0 *1 0,0
Xsky130_fd_sc_hd__fill_2_578 VGND VPWR VPWR sky130_fd_sc_hd__fill_2
* cell instance sky130_fd_sc_hd__fill_2_579 r0 *1 0,0
Xsky130_fd_sc_hd__fill_2_579 VGND VPWR VPWR sky130_fd_sc_hd__fill_2
* cell instance sky130_fd_sc_hd__fill_2_580 r0 *1 0,0
Xsky130_fd_sc_hd__fill_2_580 VGND VPWR VPWR sky130_fd_sc_hd__fill_2
* cell instance sky130_fd_sc_hd__fill_2_581 r0 *1 0,0
Xsky130_fd_sc_hd__fill_2_581 VGND VPWR VPWR sky130_fd_sc_hd__fill_2
* cell instance sky130_fd_sc_hd__fill_2_582 r0 *1 0,0
Xsky130_fd_sc_hd__fill_2_582 VGND VPWR VPWR sky130_fd_sc_hd__fill_2
* cell instance sky130_fd_sc_hd__fill_2_583 r0 *1 0,0
Xsky130_fd_sc_hd__fill_2_583 VGND VPWR VPWR sky130_fd_sc_hd__fill_2
* cell instance sky130_fd_sc_hd__fill_2_584 r0 *1 0,0
Xsky130_fd_sc_hd__fill_2_584 VGND VPWR VPWR sky130_fd_sc_hd__fill_2
* cell instance sky130_fd_sc_hd__fill_2_585 r0 *1 0,0
Xsky130_fd_sc_hd__fill_2_585 VGND VPWR VPWR sky130_fd_sc_hd__fill_2
* cell instance sky130_fd_sc_hd__fill_2_586 r0 *1 0,0
Xsky130_fd_sc_hd__fill_2_586 VGND VPWR VPWR sky130_fd_sc_hd__fill_2
* cell instance sky130_fd_sc_hd__fill_2_587 r0 *1 0,0
Xsky130_fd_sc_hd__fill_2_587 VGND VPWR VPWR sky130_fd_sc_hd__fill_2
* cell instance sky130_fd_sc_hd__fill_2_588 r0 *1 0,0
Xsky130_fd_sc_hd__fill_2_588 VGND VPWR VPWR sky130_fd_sc_hd__fill_2
* cell instance sky130_fd_sc_hd__fill_2_589 r0 *1 0,0
Xsky130_fd_sc_hd__fill_2_589 VGND VPWR VPWR sky130_fd_sc_hd__fill_2
* cell instance sky130_fd_sc_hd__fill_2_590 r0 *1 0,0
Xsky130_fd_sc_hd__fill_2_590 VGND VPWR VPWR sky130_fd_sc_hd__fill_2
* cell instance sky130_fd_sc_hd__fill_2_591 r0 *1 0,0
Xsky130_fd_sc_hd__fill_2_591 VGND VPWR VPWR sky130_fd_sc_hd__fill_2
* cell instance sky130_fd_sc_hd__fill_2_592 r0 *1 0,0
Xsky130_fd_sc_hd__fill_2_592 VGND VPWR VPWR sky130_fd_sc_hd__fill_2
* cell instance sky130_fd_sc_hd__fill_2_593 r0 *1 0,0
Xsky130_fd_sc_hd__fill_2_593 VGND VPWR VPWR sky130_fd_sc_hd__fill_2
* cell instance sky130_fd_sc_hd__fill_2_594 r0 *1 0,0
Xsky130_fd_sc_hd__fill_2_594 VGND VPWR VPWR sky130_fd_sc_hd__fill_2
* cell instance sky130_fd_sc_hd__fill_2_595 r0 *1 0,0
Xsky130_fd_sc_hd__fill_2_595 VGND VPWR VPWR sky130_fd_sc_hd__fill_2
* cell instance sky130_fd_sc_hd__fill_2_596 r0 *1 0,0
Xsky130_fd_sc_hd__fill_2_596 VGND VPWR VPWR sky130_fd_sc_hd__fill_2
* cell instance sky130_fd_sc_hd__fill_2_597 r0 *1 0,0
Xsky130_fd_sc_hd__fill_2_597 VGND VPWR VPWR sky130_fd_sc_hd__fill_2
* cell instance sky130_fd_sc_hd__fill_2_598 r0 *1 0,0
Xsky130_fd_sc_hd__fill_2_598 VGND VPWR VPWR sky130_fd_sc_hd__fill_2
* cell instance sky130_fd_sc_hd__fill_2_599 r0 *1 0,0
Xsky130_fd_sc_hd__fill_2_599 VGND VPWR VPWR sky130_fd_sc_hd__fill_2
* cell instance sky130_fd_sc_hd__fill_2_600 r0 *1 0,0
Xsky130_fd_sc_hd__fill_2_600 VGND VPWR VPWR sky130_fd_sc_hd__fill_2
* cell instance sky130_fd_sc_hd__fill_2_601 r0 *1 0,0
Xsky130_fd_sc_hd__fill_2_601 VGND VPWR VPWR sky130_fd_sc_hd__fill_2
* cell instance sky130_fd_sc_hd__fill_2_602 r0 *1 0,0
Xsky130_fd_sc_hd__fill_2_602 VGND VPWR VPWR sky130_fd_sc_hd__fill_2
* cell instance sky130_fd_sc_hd__fill_2_603 r0 *1 0,0
Xsky130_fd_sc_hd__fill_2_603 VGND VPWR VPWR sky130_fd_sc_hd__fill_2
* cell instance sky130_fd_sc_hd__fill_2_604 r0 *1 0,0
Xsky130_fd_sc_hd__fill_2_604 VGND VPWR VPWR sky130_fd_sc_hd__fill_2
* cell instance sky130_fd_sc_hd__fill_2_605 r0 *1 0,0
Xsky130_fd_sc_hd__fill_2_605 VGND VPWR VPWR sky130_fd_sc_hd__fill_2
* cell instance sky130_fd_sc_hd__fill_2_606 r0 *1 0,0
Xsky130_fd_sc_hd__fill_2_606 VGND VPWR VPWR sky130_fd_sc_hd__fill_2
* cell instance sky130_fd_sc_hd__fill_2_607 r0 *1 0,0
Xsky130_fd_sc_hd__fill_2_607 VGND VPWR VPWR sky130_fd_sc_hd__fill_2
* cell instance sky130_fd_sc_hd__fill_2_608 r0 *1 0,0
Xsky130_fd_sc_hd__fill_2_608 VGND VPWR VPWR sky130_fd_sc_hd__fill_2
* cell instance sky130_fd_sc_hd__fill_2_609 r0 *1 0,0
Xsky130_fd_sc_hd__fill_2_609 VGND VPWR VPWR sky130_fd_sc_hd__fill_2
* cell instance sky130_fd_sc_hd__fill_2_610 r0 *1 0,0
Xsky130_fd_sc_hd__fill_2_610 VGND VPWR VPWR sky130_fd_sc_hd__fill_2
* cell instance sky130_fd_sc_hd__fill_2_611 r0 *1 0,0
Xsky130_fd_sc_hd__fill_2_611 VGND VPWR VPWR sky130_fd_sc_hd__fill_2
* cell instance sky130_fd_sc_hd__fill_2_612 r0 *1 0,0
Xsky130_fd_sc_hd__fill_2_612 VGND VPWR VPWR sky130_fd_sc_hd__fill_2
* cell instance sky130_fd_sc_hd__fill_2_613 r0 *1 0,0
Xsky130_fd_sc_hd__fill_2_613 VGND VPWR VPWR sky130_fd_sc_hd__fill_2
* cell instance sky130_fd_sc_hd__fill_2_614 r0 *1 0,0
Xsky130_fd_sc_hd__fill_2_614 VGND VPWR VPWR sky130_fd_sc_hd__fill_2
* cell instance sky130_fd_sc_hd__fill_2_615 r0 *1 0,0
Xsky130_fd_sc_hd__fill_2_615 VGND VPWR VPWR sky130_fd_sc_hd__fill_2
* cell instance sky130_fd_sc_hd__fill_2_616 r0 *1 0,0
Xsky130_fd_sc_hd__fill_2_616 VGND VPWR VPWR sky130_fd_sc_hd__fill_2
* cell instance sky130_fd_sc_hd__fill_2_617 r0 *1 0,0
Xsky130_fd_sc_hd__fill_2_617 VGND VPWR VPWR sky130_fd_sc_hd__fill_2
* cell instance sky130_fd_sc_hd__fill_2_618 r0 *1 0,0
Xsky130_fd_sc_hd__fill_2_618 VGND VPWR VPWR sky130_fd_sc_hd__fill_2
* cell instance sky130_fd_sc_hd__fill_2_619 r0 *1 0,0
Xsky130_fd_sc_hd__fill_2_619 VGND VPWR VPWR sky130_fd_sc_hd__fill_2
* cell instance sky130_fd_sc_hd__fill_2_620 r0 *1 0,0
Xsky130_fd_sc_hd__fill_2_620 VGND VPWR VPWR sky130_fd_sc_hd__fill_2
* cell instance sky130_fd_sc_hd__fill_2_621 r0 *1 0,0
Xsky130_fd_sc_hd__fill_2_621 VGND VPWR VPWR sky130_fd_sc_hd__fill_2
* cell instance sky130_fd_sc_hd__fill_2_622 r0 *1 0,0
Xsky130_fd_sc_hd__fill_2_622 VGND VPWR VPWR sky130_fd_sc_hd__fill_2
* cell instance sky130_fd_sc_hd__fill_2_623 r0 *1 0,0
Xsky130_fd_sc_hd__fill_2_623 VGND VPWR VPWR sky130_fd_sc_hd__fill_2
* cell instance sky130_fd_sc_hd__fill_2_624 r0 *1 0,0
Xsky130_fd_sc_hd__fill_2_624 VGND VPWR VPWR sky130_fd_sc_hd__fill_2
* cell instance sky130_fd_sc_hd__fill_2_625 r0 *1 0,0
Xsky130_fd_sc_hd__fill_2_625 VGND VPWR VPWR sky130_fd_sc_hd__fill_2
* cell instance sky130_fd_sc_hd__fill_2_626 r0 *1 0,0
Xsky130_fd_sc_hd__fill_2_626 VGND VPWR VPWR sky130_fd_sc_hd__fill_2
* cell instance sky130_fd_sc_hd__fill_2_627 r0 *1 0,0
Xsky130_fd_sc_hd__fill_2_627 VGND VPWR VPWR sky130_fd_sc_hd__fill_2
* cell instance sky130_fd_sc_hd__fill_2_628 r0 *1 0,0
Xsky130_fd_sc_hd__fill_2_628 VGND VPWR VPWR sky130_fd_sc_hd__fill_2
* cell instance sky130_fd_sc_hd__fill_2_629 r0 *1 0,0
Xsky130_fd_sc_hd__fill_2_629 VGND VPWR VPWR sky130_fd_sc_hd__fill_2
* cell instance sky130_fd_sc_hd__fill_2_630 r0 *1 0,0
Xsky130_fd_sc_hd__fill_2_630 VGND VPWR VPWR sky130_fd_sc_hd__fill_2
* cell instance sky130_fd_sc_hd__fill_2_631 r0 *1 0,0
Xsky130_fd_sc_hd__fill_2_631 VGND VPWR VPWR sky130_fd_sc_hd__fill_2
* cell instance sky130_fd_sc_hd__fill_2_632 r0 *1 0,0
Xsky130_fd_sc_hd__fill_2_632 VGND VPWR VPWR sky130_fd_sc_hd__fill_2
* cell instance sky130_fd_sc_hd__fill_2_633 r0 *1 0,0
Xsky130_fd_sc_hd__fill_2_633 VGND VPWR VPWR sky130_fd_sc_hd__fill_2
* cell instance sky130_fd_sc_hd__fill_2_634 r0 *1 0,0
Xsky130_fd_sc_hd__fill_2_634 VGND VPWR VPWR sky130_fd_sc_hd__fill_2
* cell instance sky130_fd_sc_hd__fill_2_635 r0 *1 0,0
Xsky130_fd_sc_hd__fill_2_635 VGND VPWR VPWR sky130_fd_sc_hd__fill_2
* cell instance sky130_fd_sc_hd__fill_2_636 r0 *1 0,0
Xsky130_fd_sc_hd__fill_2_636 VGND VPWR VPWR sky130_fd_sc_hd__fill_2
* cell instance sky130_fd_sc_hd__fill_2_637 r0 *1 0,0
Xsky130_fd_sc_hd__fill_2_637 VGND VPWR VPWR sky130_fd_sc_hd__fill_2
* cell instance sky130_fd_sc_hd__fill_2_638 r0 *1 0,0
Xsky130_fd_sc_hd__fill_2_638 VGND VPWR VPWR sky130_fd_sc_hd__fill_2
* cell instance sky130_fd_sc_hd__fill_2_639 r0 *1 0,0
Xsky130_fd_sc_hd__fill_2_639 VGND VPWR VPWR sky130_fd_sc_hd__fill_2
* cell instance sky130_fd_sc_hd__fill_2_640 r0 *1 0,0
Xsky130_fd_sc_hd__fill_2_640 VGND VPWR VPWR sky130_fd_sc_hd__fill_2
* cell instance sky130_fd_sc_hd__fill_2_641 r0 *1 0,0
Xsky130_fd_sc_hd__fill_2_641 VGND VPWR VPWR sky130_fd_sc_hd__fill_2
* cell instance sky130_fd_sc_hd__fill_2_642 r0 *1 0,0
Xsky130_fd_sc_hd__fill_2_642 VGND VPWR VPWR sky130_fd_sc_hd__fill_2
* cell instance sky130_fd_sc_hd__fill_2_643 r0 *1 0,0
Xsky130_fd_sc_hd__fill_2_643 VGND VPWR VPWR sky130_fd_sc_hd__fill_2
* cell instance sky130_fd_sc_hd__fill_2_644 r0 *1 0,0
Xsky130_fd_sc_hd__fill_2_644 VGND VPWR VPWR sky130_fd_sc_hd__fill_2
* cell instance sky130_fd_sc_hd__fill_2_645 r0 *1 0,0
Xsky130_fd_sc_hd__fill_2_645 VGND VPWR VPWR sky130_fd_sc_hd__fill_2
* cell instance sky130_fd_sc_hd__fill_2_646 r0 *1 0,0
Xsky130_fd_sc_hd__fill_2_646 VGND VPWR VPWR sky130_fd_sc_hd__fill_2
* cell instance sky130_fd_sc_hd__fill_2_647 r0 *1 0,0
Xsky130_fd_sc_hd__fill_2_647 VGND VPWR VPWR sky130_fd_sc_hd__fill_2
* cell instance sky130_fd_sc_hd__fill_2_648 r0 *1 0,0
Xsky130_fd_sc_hd__fill_2_648 VGND VPWR VPWR sky130_fd_sc_hd__fill_2
* cell instance sky130_fd_sc_hd__fill_2_649 r0 *1 0,0
Xsky130_fd_sc_hd__fill_2_649 VGND VPWR VPWR sky130_fd_sc_hd__fill_2
* cell instance sky130_fd_sc_hd__fill_2_650 r0 *1 0,0
Xsky130_fd_sc_hd__fill_2_650 VGND VPWR VPWR sky130_fd_sc_hd__fill_2
* cell instance sky130_fd_sc_hd__fill_2_651 r0 *1 0,0
Xsky130_fd_sc_hd__fill_2_651 VGND VPWR VPWR sky130_fd_sc_hd__fill_2
* cell instance sky130_fd_sc_hd__fill_2_652 r0 *1 0,0
Xsky130_fd_sc_hd__fill_2_652 VGND VPWR VPWR sky130_fd_sc_hd__fill_2
* cell instance sky130_fd_sc_hd__fill_2_653 r0 *1 0,0
Xsky130_fd_sc_hd__fill_2_653 VGND VPWR VPWR sky130_fd_sc_hd__fill_2
* cell instance sky130_fd_sc_hd__fill_2_654 r0 *1 0,0
Xsky130_fd_sc_hd__fill_2_654 VGND VPWR VPWR sky130_fd_sc_hd__fill_2
* cell instance sky130_fd_sc_hd__fill_2_655 r0 *1 0,0
Xsky130_fd_sc_hd__fill_2_655 VGND VPWR VPWR sky130_fd_sc_hd__fill_2
* cell instance sky130_fd_sc_hd__fill_2_656 r0 *1 0,0
Xsky130_fd_sc_hd__fill_2_656 VGND VPWR VPWR sky130_fd_sc_hd__fill_2
* cell instance sky130_fd_sc_hd__fill_2_657 r0 *1 0,0
Xsky130_fd_sc_hd__fill_2_657 VGND VPWR VPWR sky130_fd_sc_hd__fill_2
* cell instance sky130_fd_sc_hd__fill_2_658 r0 *1 0,0
Xsky130_fd_sc_hd__fill_2_658 VGND VPWR VPWR sky130_fd_sc_hd__fill_2
* cell instance sky130_fd_sc_hd__fill_2_659 r0 *1 0,0
Xsky130_fd_sc_hd__fill_2_659 VGND VPWR VPWR sky130_fd_sc_hd__fill_2
* cell instance sky130_fd_sc_hd__fill_2_660 r0 *1 0,0
Xsky130_fd_sc_hd__fill_2_660 VGND VPWR VPWR sky130_fd_sc_hd__fill_2
* cell instance sky130_fd_sc_hd__fill_2_661 r0 *1 0,0
Xsky130_fd_sc_hd__fill_2_661 VGND VPWR VPWR sky130_fd_sc_hd__fill_2
* cell instance sky130_fd_sc_hd__fill_2_662 r0 *1 0,0
Xsky130_fd_sc_hd__fill_2_662 VGND VPWR VPWR sky130_fd_sc_hd__fill_2
* cell instance sky130_fd_sc_hd__fill_2_663 r0 *1 0,0
Xsky130_fd_sc_hd__fill_2_663 VGND VPWR VPWR sky130_fd_sc_hd__fill_2
* cell instance sky130_fd_sc_hd__fill_2_664 r0 *1 0,0
Xsky130_fd_sc_hd__fill_2_664 VGND VPWR VPWR sky130_fd_sc_hd__fill_2
* cell instance sky130_fd_sc_hd__fill_2_665 r0 *1 0,0
Xsky130_fd_sc_hd__fill_2_665 VGND VPWR VPWR sky130_fd_sc_hd__fill_2
* cell instance sky130_fd_sc_hd__fill_2_666 r0 *1 0,0
Xsky130_fd_sc_hd__fill_2_666 VGND VPWR VPWR sky130_fd_sc_hd__fill_2
* cell instance sky130_fd_sc_hd__fill_2_667 r0 *1 0,0
Xsky130_fd_sc_hd__fill_2_667 VGND VPWR VPWR sky130_fd_sc_hd__fill_2
* cell instance sky130_fd_sc_hd__fill_2_668 r0 *1 0,0
Xsky130_fd_sc_hd__fill_2_668 VGND VPWR VPWR sky130_fd_sc_hd__fill_2
* cell instance sky130_fd_sc_hd__fill_2_669 r0 *1 0,0
Xsky130_fd_sc_hd__fill_2_669 VGND VPWR VPWR sky130_fd_sc_hd__fill_2
* cell instance sky130_fd_sc_hd__fill_2_670 r0 *1 0,0
Xsky130_fd_sc_hd__fill_2_670 VGND VPWR VPWR sky130_fd_sc_hd__fill_2
* cell instance sky130_fd_sc_hd__fill_2_671 r0 *1 0,0
Xsky130_fd_sc_hd__fill_2_671 VGND VPWR VPWR sky130_fd_sc_hd__fill_2
* cell instance sky130_fd_sc_hd__fill_2_672 r0 *1 0,0
Xsky130_fd_sc_hd__fill_2_672 VGND VPWR VPWR sky130_fd_sc_hd__fill_2
* cell instance sky130_fd_sc_hd__fill_2_673 r0 *1 0,0
Xsky130_fd_sc_hd__fill_2_673 VGND VPWR VPWR sky130_fd_sc_hd__fill_2
* cell instance sky130_fd_sc_hd__fill_2_674 r0 *1 0,0
Xsky130_fd_sc_hd__fill_2_674 VGND VPWR VPWR sky130_fd_sc_hd__fill_2
* cell instance sky130_fd_sc_hd__fill_2_675 r0 *1 0,0
Xsky130_fd_sc_hd__fill_2_675 VGND VPWR VPWR sky130_fd_sc_hd__fill_2
* cell instance sky130_fd_sc_hd__fill_2_676 r0 *1 0,0
Xsky130_fd_sc_hd__fill_2_676 VGND VPWR VPWR sky130_fd_sc_hd__fill_2
* cell instance sky130_fd_sc_hd__fill_2_677 r0 *1 0,0
Xsky130_fd_sc_hd__fill_2_677 VGND VPWR VPWR sky130_fd_sc_hd__fill_2
* cell instance sky130_fd_sc_hd__fill_2_678 r0 *1 0,0
Xsky130_fd_sc_hd__fill_2_678 VGND VPWR VPWR sky130_fd_sc_hd__fill_2
* cell instance sky130_fd_sc_hd__fill_2_679 r0 *1 0,0
Xsky130_fd_sc_hd__fill_2_679 VGND VPWR VPWR sky130_fd_sc_hd__fill_2
* cell instance sky130_fd_sc_hd__fill_2_680 r0 *1 0,0
Xsky130_fd_sc_hd__fill_2_680 VGND VPWR VPWR sky130_fd_sc_hd__fill_2
* cell instance sky130_fd_sc_hd__fill_2_681 r0 *1 0,0
Xsky130_fd_sc_hd__fill_2_681 VGND VPWR VPWR sky130_fd_sc_hd__fill_2
* cell instance sky130_fd_sc_hd__fill_2_682 r0 *1 0,0
Xsky130_fd_sc_hd__fill_2_682 VGND VPWR VPWR sky130_fd_sc_hd__fill_2
* cell instance sky130_fd_sc_hd__fill_2_683 r0 *1 0,0
Xsky130_fd_sc_hd__fill_2_683 VGND VPWR VPWR sky130_fd_sc_hd__fill_2
* cell instance sky130_fd_sc_hd__fill_2_684 r0 *1 0,0
Xsky130_fd_sc_hd__fill_2_684 VGND VPWR VPWR sky130_fd_sc_hd__fill_2
* cell instance sky130_fd_sc_hd__fill_2_685 r0 *1 0,0
Xsky130_fd_sc_hd__fill_2_685 VGND VPWR VPWR sky130_fd_sc_hd__fill_2
* cell instance sky130_fd_sc_hd__fill_2_686 r0 *1 0,0
Xsky130_fd_sc_hd__fill_2_686 VGND VPWR VPWR sky130_fd_sc_hd__fill_2
* cell instance sky130_fd_sc_hd__fill_2_687 r0 *1 0,0
Xsky130_fd_sc_hd__fill_2_687 VGND VPWR VPWR sky130_fd_sc_hd__fill_2
* cell instance sky130_fd_sc_hd__fill_2_688 r0 *1 0,0
Xsky130_fd_sc_hd__fill_2_688 VGND VPWR VPWR sky130_fd_sc_hd__fill_2
* cell instance sky130_fd_sc_hd__fill_2_689 r0 *1 0,0
Xsky130_fd_sc_hd__fill_2_689 VGND VPWR VPWR sky130_fd_sc_hd__fill_2
* cell instance sky130_fd_sc_hd__fill_2_690 r0 *1 0,0
Xsky130_fd_sc_hd__fill_2_690 VGND VPWR VPWR sky130_fd_sc_hd__fill_2
* cell instance sky130_fd_sc_hd__fill_2_691 r0 *1 0,0
Xsky130_fd_sc_hd__fill_2_691 VGND VPWR VPWR sky130_fd_sc_hd__fill_2
* cell instance sky130_fd_sc_hd__fill_2_692 r0 *1 0,0
Xsky130_fd_sc_hd__fill_2_692 VGND VPWR VPWR sky130_fd_sc_hd__fill_2
* cell instance sky130_fd_sc_hd__fill_2_693 r0 *1 0,0
Xsky130_fd_sc_hd__fill_2_693 VGND VPWR VPWR sky130_fd_sc_hd__fill_2
* cell instance sky130_fd_sc_hd__fill_2_694 r0 *1 0,0
Xsky130_fd_sc_hd__fill_2_694 VGND VPWR VPWR sky130_fd_sc_hd__fill_2
* cell instance sky130_fd_sc_hd__fill_2_695 r0 *1 0,0
Xsky130_fd_sc_hd__fill_2_695 VGND VPWR VPWR sky130_fd_sc_hd__fill_2
* cell instance sky130_fd_sc_hd__fill_2_696 r0 *1 0,0
Xsky130_fd_sc_hd__fill_2_696 VGND VPWR VPWR sky130_fd_sc_hd__fill_2
* cell instance sky130_fd_sc_hd__fill_2_697 r0 *1 0,0
Xsky130_fd_sc_hd__fill_2_697 VGND VPWR VPWR sky130_fd_sc_hd__fill_2
* cell instance sky130_fd_sc_hd__fill_2_698 r0 *1 0,0
Xsky130_fd_sc_hd__fill_2_698 VGND VPWR VPWR sky130_fd_sc_hd__fill_2
* cell instance sky130_fd_sc_hd__fill_2_699 r0 *1 0,0
Xsky130_fd_sc_hd__fill_2_699 VGND VPWR VPWR sky130_fd_sc_hd__fill_2
* cell instance sky130_fd_sc_hd__fill_2_700 r0 *1 0,0
Xsky130_fd_sc_hd__fill_2_700 VGND VPWR VPWR sky130_fd_sc_hd__fill_2
* cell instance sky130_fd_sc_hd__fill_2_701 r0 *1 0,0
Xsky130_fd_sc_hd__fill_2_701 VGND VPWR VPWR sky130_fd_sc_hd__fill_2
* cell instance sky130_fd_sc_hd__fill_2_702 r0 *1 0,0
Xsky130_fd_sc_hd__fill_2_702 VGND VPWR VPWR sky130_fd_sc_hd__fill_2
* cell instance sky130_fd_sc_hd__fill_2_703 r0 *1 0,0
Xsky130_fd_sc_hd__fill_2_703 VGND VPWR VPWR sky130_fd_sc_hd__fill_2
* cell instance sky130_fd_sc_hd__fill_2_704 r0 *1 0,0
Xsky130_fd_sc_hd__fill_2_704 VGND VPWR VPWR sky130_fd_sc_hd__fill_2
* cell instance sky130_fd_sc_hd__fill_2_705 r0 *1 0,0
Xsky130_fd_sc_hd__fill_2_705 VGND VPWR VPWR sky130_fd_sc_hd__fill_2
* cell instance sky130_fd_sc_hd__fill_2_706 r0 *1 0,0
Xsky130_fd_sc_hd__fill_2_706 VGND VPWR VPWR sky130_fd_sc_hd__fill_2
* cell instance sky130_fd_sc_hd__fill_2_707 r0 *1 0,0
Xsky130_fd_sc_hd__fill_2_707 VGND VPWR VPWR sky130_fd_sc_hd__fill_2
* cell instance sky130_fd_sc_hd__fill_2_708 r0 *1 0,0
Xsky130_fd_sc_hd__fill_2_708 VGND VPWR VPWR sky130_fd_sc_hd__fill_2
* cell instance sky130_fd_sc_hd__fill_2_709 r0 *1 0,0
Xsky130_fd_sc_hd__fill_2_709 VGND VPWR VPWR sky130_fd_sc_hd__fill_2
* cell instance sky130_fd_sc_hd__fill_2_710 r0 *1 0,0
Xsky130_fd_sc_hd__fill_2_710 VGND VPWR VPWR sky130_fd_sc_hd__fill_2
* cell instance sky130_fd_sc_hd__fill_2_711 r0 *1 0,0
Xsky130_fd_sc_hd__fill_2_711 VGND VPWR VPWR sky130_fd_sc_hd__fill_2
* cell instance sky130_fd_sc_hd__fill_2_712 r0 *1 0,0
Xsky130_fd_sc_hd__fill_2_712 VGND VPWR VPWR sky130_fd_sc_hd__fill_2
* cell instance sky130_fd_sc_hd__fill_2_713 r0 *1 0,0
Xsky130_fd_sc_hd__fill_2_713 VGND VPWR VPWR sky130_fd_sc_hd__fill_2
* cell instance sky130_fd_sc_hd__fill_2_714 r0 *1 0,0
Xsky130_fd_sc_hd__fill_2_714 VGND VPWR VPWR sky130_fd_sc_hd__fill_2
* cell instance sky130_fd_sc_hd__fill_2_715 r0 *1 0,0
Xsky130_fd_sc_hd__fill_2_715 VGND VPWR VPWR sky130_fd_sc_hd__fill_2
* cell instance sky130_fd_sc_hd__fill_2_716 r0 *1 0,0
Xsky130_fd_sc_hd__fill_2_716 VGND VPWR VPWR sky130_fd_sc_hd__fill_2
* cell instance sky130_fd_sc_hd__fill_2_717 r0 *1 0,0
Xsky130_fd_sc_hd__fill_2_717 VGND VPWR VPWR sky130_fd_sc_hd__fill_2
* cell instance sky130_fd_sc_hd__fill_2_718 r0 *1 0,0
Xsky130_fd_sc_hd__fill_2_718 VGND VPWR VPWR sky130_fd_sc_hd__fill_2
* cell instance sky130_fd_sc_hd__fill_2_719 r0 *1 0,0
Xsky130_fd_sc_hd__fill_2_719 VGND VPWR VPWR sky130_fd_sc_hd__fill_2
* cell instance sky130_fd_sc_hd__fill_2_720 r0 *1 0,0
Xsky130_fd_sc_hd__fill_2_720 VGND VPWR VPWR sky130_fd_sc_hd__fill_2
* cell instance sky130_fd_sc_hd__fill_2_721 r0 *1 0,0
Xsky130_fd_sc_hd__fill_2_721 VGND VPWR VPWR sky130_fd_sc_hd__fill_2
* cell instance sky130_fd_sc_hd__fill_2_722 r0 *1 0,0
Xsky130_fd_sc_hd__fill_2_722 VGND VPWR VPWR sky130_fd_sc_hd__fill_2
* cell instance sky130_fd_sc_hd__fill_2_723 r0 *1 0,0
Xsky130_fd_sc_hd__fill_2_723 VGND VPWR VPWR sky130_fd_sc_hd__fill_2
* cell instance sky130_fd_sc_hd__fill_2_724 r0 *1 0,0
Xsky130_fd_sc_hd__fill_2_724 VGND VPWR VPWR sky130_fd_sc_hd__fill_2
* cell instance sky130_fd_sc_hd__fill_2_725 r0 *1 0,0
Xsky130_fd_sc_hd__fill_2_725 VGND VPWR VPWR sky130_fd_sc_hd__fill_2
* cell instance sky130_fd_sc_hd__fill_2_726 r0 *1 0,0
Xsky130_fd_sc_hd__fill_2_726 VGND VPWR VPWR sky130_fd_sc_hd__fill_2
* cell instance sky130_fd_sc_hd__fill_2_727 r0 *1 0,0
Xsky130_fd_sc_hd__fill_2_727 VGND VPWR VPWR sky130_fd_sc_hd__fill_2
* cell instance sky130_fd_sc_hd__fill_2_728 r0 *1 0,0
Xsky130_fd_sc_hd__fill_2_728 VGND VPWR VPWR sky130_fd_sc_hd__fill_2
* cell instance sky130_fd_sc_hd__fill_2_729 r0 *1 0,0
Xsky130_fd_sc_hd__fill_2_729 VGND VPWR VPWR sky130_fd_sc_hd__fill_2
* cell instance sky130_fd_sc_hd__fill_2_730 r0 *1 0,0
Xsky130_fd_sc_hd__fill_2_730 VGND VPWR VPWR sky130_fd_sc_hd__fill_2
* cell instance sky130_fd_sc_hd__fill_2_731 r0 *1 0,0
Xsky130_fd_sc_hd__fill_2_731 VGND VPWR VPWR sky130_fd_sc_hd__fill_2
* cell instance sky130_fd_sc_hd__fill_2_732 r0 *1 0,0
Xsky130_fd_sc_hd__fill_2_732 VGND VPWR VPWR sky130_fd_sc_hd__fill_2
* cell instance sky130_fd_sc_hd__fill_2_733 r0 *1 0,0
Xsky130_fd_sc_hd__fill_2_733 VGND VPWR VPWR sky130_fd_sc_hd__fill_2
* cell instance sky130_fd_sc_hd__fill_2_734 r0 *1 0,0
Xsky130_fd_sc_hd__fill_2_734 VGND VPWR VPWR sky130_fd_sc_hd__fill_2
* cell instance sky130_fd_sc_hd__fill_2_735 r0 *1 0,0
Xsky130_fd_sc_hd__fill_2_735 VGND VPWR VPWR sky130_fd_sc_hd__fill_2
* cell instance sky130_fd_sc_hd__fill_2_736 r0 *1 0,0
Xsky130_fd_sc_hd__fill_2_736 VGND VPWR VPWR sky130_fd_sc_hd__fill_2
* cell instance sky130_fd_sc_hd__fill_2_737 r0 *1 0,0
Xsky130_fd_sc_hd__fill_2_737 VGND VPWR VPWR sky130_fd_sc_hd__fill_2
* cell instance sky130_fd_sc_hd__fill_2_738 r0 *1 0,0
Xsky130_fd_sc_hd__fill_2_738 VGND VPWR VPWR sky130_fd_sc_hd__fill_2
* cell instance sky130_fd_sc_hd__fill_2_739 r0 *1 0,0
Xsky130_fd_sc_hd__fill_2_739 VGND VPWR VPWR sky130_fd_sc_hd__fill_2
* cell instance sky130_fd_sc_hd__fill_2_740 r0 *1 0,0
Xsky130_fd_sc_hd__fill_2_740 VGND VPWR VPWR sky130_fd_sc_hd__fill_2
* cell instance sky130_fd_sc_hd__fill_2_741 r0 *1 0,0
Xsky130_fd_sc_hd__fill_2_741 VGND VPWR VPWR sky130_fd_sc_hd__fill_2
* cell instance sky130_fd_sc_hd__fill_2_742 r0 *1 0,0
Xsky130_fd_sc_hd__fill_2_742 VGND VPWR VPWR sky130_fd_sc_hd__fill_2
* cell instance sky130_fd_sc_hd__fill_2_743 r0 *1 0,0
Xsky130_fd_sc_hd__fill_2_743 VGND VPWR VPWR sky130_fd_sc_hd__fill_2
* cell instance sky130_fd_sc_hd__fill_2_744 r0 *1 0,0
Xsky130_fd_sc_hd__fill_2_744 VGND VPWR VPWR sky130_fd_sc_hd__fill_2
* cell instance sky130_fd_sc_hd__fill_2_745 r0 *1 0,0
Xsky130_fd_sc_hd__fill_2_745 VGND VPWR VPWR sky130_fd_sc_hd__fill_2
* cell instance sky130_fd_sc_hd__fill_2_746 r0 *1 0,0
Xsky130_fd_sc_hd__fill_2_746 VGND VPWR VPWR sky130_fd_sc_hd__fill_2
* cell instance sky130_fd_sc_hd__fill_2_747 r0 *1 0,0
Xsky130_fd_sc_hd__fill_2_747 VGND VPWR VPWR sky130_fd_sc_hd__fill_2
* cell instance sky130_fd_sc_hd__fill_2_748 r0 *1 0,0
Xsky130_fd_sc_hd__fill_2_748 VGND VPWR VPWR sky130_fd_sc_hd__fill_2
* cell instance sky130_fd_sc_hd__fill_2_749 r0 *1 0,0
Xsky130_fd_sc_hd__fill_2_749 VGND VPWR VPWR sky130_fd_sc_hd__fill_2
* cell instance sky130_fd_sc_hd__fill_2_750 r0 *1 0,0
Xsky130_fd_sc_hd__fill_2_750 VGND VPWR VPWR sky130_fd_sc_hd__fill_2
* cell instance sky130_fd_sc_hd__fill_2_751 r0 *1 0,0
Xsky130_fd_sc_hd__fill_2_751 VGND VPWR VPWR sky130_fd_sc_hd__fill_2
* cell instance sky130_fd_sc_hd__fill_2_752 r0 *1 0,0
Xsky130_fd_sc_hd__fill_2_752 VGND VPWR VPWR sky130_fd_sc_hd__fill_2
* cell instance sky130_fd_sc_hd__fill_2_753 r0 *1 0,0
Xsky130_fd_sc_hd__fill_2_753 VGND VPWR VPWR sky130_fd_sc_hd__fill_2
* cell instance sky130_fd_sc_hd__fill_2_754 r0 *1 0,0
Xsky130_fd_sc_hd__fill_2_754 VGND VPWR VPWR sky130_fd_sc_hd__fill_2
* cell instance sky130_fd_sc_hd__fill_2_755 r0 *1 0,0
Xsky130_fd_sc_hd__fill_2_755 VGND VPWR VPWR sky130_fd_sc_hd__fill_2
* cell instance sky130_fd_sc_hd__fill_2_756 r0 *1 0,0
Xsky130_fd_sc_hd__fill_2_756 VGND VPWR VPWR sky130_fd_sc_hd__fill_2
* cell instance sky130_fd_sc_hd__fill_2_757 r0 *1 0,0
Xsky130_fd_sc_hd__fill_2_757 VGND VPWR VPWR sky130_fd_sc_hd__fill_2
* cell instance sky130_fd_sc_hd__fill_2_758 r0 *1 0,0
Xsky130_fd_sc_hd__fill_2_758 VGND VPWR VPWR sky130_fd_sc_hd__fill_2
* cell instance sky130_fd_sc_hd__fill_2_759 r0 *1 0,0
Xsky130_fd_sc_hd__fill_2_759 VGND VPWR VPWR sky130_fd_sc_hd__fill_2
* cell instance sky130_fd_sc_hd__fill_2_760 r0 *1 0,0
Xsky130_fd_sc_hd__fill_2_760 VGND VPWR VPWR sky130_fd_sc_hd__fill_2
* cell instance sky130_fd_sc_hd__fill_2_761 r0 *1 0,0
Xsky130_fd_sc_hd__fill_2_761 VGND VPWR VPWR sky130_fd_sc_hd__fill_2
* cell instance sky130_fd_sc_hd__fill_2_762 r0 *1 0,0
Xsky130_fd_sc_hd__fill_2_762 VGND VPWR VPWR sky130_fd_sc_hd__fill_2
* cell instance sky130_fd_sc_hd__fill_2_763 r0 *1 0,0
Xsky130_fd_sc_hd__fill_2_763 VGND VPWR VPWR sky130_fd_sc_hd__fill_2
* cell instance sky130_fd_sc_hd__fill_2_764 r0 *1 0,0
Xsky130_fd_sc_hd__fill_2_764 VGND VPWR VPWR sky130_fd_sc_hd__fill_2
* cell instance sky130_fd_sc_hd__fill_2_765 r0 *1 0,0
Xsky130_fd_sc_hd__fill_2_765 VGND VPWR VPWR sky130_fd_sc_hd__fill_2
* cell instance sky130_fd_sc_hd__fill_2_766 r0 *1 0,0
Xsky130_fd_sc_hd__fill_2_766 VGND VPWR VPWR sky130_fd_sc_hd__fill_2
* cell instance sky130_fd_sc_hd__fill_2_767 r0 *1 0,0
Xsky130_fd_sc_hd__fill_2_767 VGND VPWR VPWR sky130_fd_sc_hd__fill_2
* cell instance sky130_fd_sc_hd__fill_2_768 r0 *1 0,0
Xsky130_fd_sc_hd__fill_2_768 VGND VPWR VPWR sky130_fd_sc_hd__fill_2
* cell instance sky130_fd_sc_hd__fill_2_769 r0 *1 0,0
Xsky130_fd_sc_hd__fill_2_769 VGND VPWR VPWR sky130_fd_sc_hd__fill_2
* cell instance sky130_fd_sc_hd__fill_2_770 r0 *1 0,0
Xsky130_fd_sc_hd__fill_2_770 VGND VPWR VPWR sky130_fd_sc_hd__fill_2
* cell instance sky130_fd_sc_hd__fill_2_771 r0 *1 0,0
Xsky130_fd_sc_hd__fill_2_771 VGND VPWR VPWR sky130_fd_sc_hd__fill_2
* cell instance sky130_fd_sc_hd__fill_2_772 r0 *1 0,0
Xsky130_fd_sc_hd__fill_2_772 VGND VPWR VPWR sky130_fd_sc_hd__fill_2
* cell instance sky130_fd_sc_hd__fill_2_773 r0 *1 0,0
Xsky130_fd_sc_hd__fill_2_773 VGND VPWR VPWR sky130_fd_sc_hd__fill_2
* cell instance sky130_fd_sc_hd__fill_2_774 r0 *1 0,0
Xsky130_fd_sc_hd__fill_2_774 VGND VPWR VPWR sky130_fd_sc_hd__fill_2
* cell instance sky130_fd_sc_hd__fill_2_775 r0 *1 0,0
Xsky130_fd_sc_hd__fill_2_775 VGND VPWR VPWR sky130_fd_sc_hd__fill_2
* cell instance sky130_fd_sc_hd__fill_2_776 r0 *1 0,0
Xsky130_fd_sc_hd__fill_2_776 VGND VPWR VPWR sky130_fd_sc_hd__fill_2
* cell instance sky130_fd_sc_hd__fill_2_777 r0 *1 0,0
Xsky130_fd_sc_hd__fill_2_777 VGND VPWR VPWR sky130_fd_sc_hd__fill_2
* cell instance sky130_fd_sc_hd__fill_2_778 r0 *1 0,0
Xsky130_fd_sc_hd__fill_2_778 VGND VPWR VPWR sky130_fd_sc_hd__fill_2
* cell instance sky130_fd_sc_hd__fill_2_779 r0 *1 0,0
Xsky130_fd_sc_hd__fill_2_779 VGND VPWR VPWR sky130_fd_sc_hd__fill_2
* cell instance sky130_fd_sc_hd__fill_2_780 r0 *1 0,0
Xsky130_fd_sc_hd__fill_2_780 VGND VPWR VPWR sky130_fd_sc_hd__fill_2
* cell instance sky130_fd_sc_hd__fill_2_781 r0 *1 0,0
Xsky130_fd_sc_hd__fill_2_781 VGND VPWR VPWR sky130_fd_sc_hd__fill_2
* cell instance sky130_fd_sc_hd__fill_2_782 r0 *1 0,0
Xsky130_fd_sc_hd__fill_2_782 VGND VPWR VPWR sky130_fd_sc_hd__fill_2
* cell instance sky130_fd_sc_hd__fill_2_783 r0 *1 0,0
Xsky130_fd_sc_hd__fill_2_783 VGND VPWR VPWR sky130_fd_sc_hd__fill_2
* cell instance sky130_fd_sc_hd__fill_2_784 r0 *1 0,0
Xsky130_fd_sc_hd__fill_2_784 VGND VPWR VPWR sky130_fd_sc_hd__fill_2
* cell instance sky130_fd_sc_hd__fill_2_785 r0 *1 0,0
Xsky130_fd_sc_hd__fill_2_785 VGND VPWR VPWR sky130_fd_sc_hd__fill_2
* cell instance sky130_fd_sc_hd__fill_2_786 r0 *1 0,0
Xsky130_fd_sc_hd__fill_2_786 VGND VPWR VPWR sky130_fd_sc_hd__fill_2
* cell instance sky130_fd_sc_hd__fill_2_787 r0 *1 0,0
Xsky130_fd_sc_hd__fill_2_787 VGND VPWR VPWR sky130_fd_sc_hd__fill_2
* cell instance sky130_fd_sc_hd__fill_2_788 r0 *1 0,0
Xsky130_fd_sc_hd__fill_2_788 VGND VPWR VPWR sky130_fd_sc_hd__fill_2
* cell instance sky130_fd_sc_hd__fill_2_789 r0 *1 0,0
Xsky130_fd_sc_hd__fill_2_789 VGND VPWR VPWR sky130_fd_sc_hd__fill_2
* cell instance sky130_fd_sc_hd__fill_2_790 r0 *1 0,0
Xsky130_fd_sc_hd__fill_2_790 VGND VPWR VPWR sky130_fd_sc_hd__fill_2
* cell instance sky130_fd_sc_hd__fill_2_791 r0 *1 0,0
Xsky130_fd_sc_hd__fill_2_791 VGND VPWR VPWR sky130_fd_sc_hd__fill_2
* cell instance sky130_fd_sc_hd__fill_2_792 r0 *1 0,0
Xsky130_fd_sc_hd__fill_2_792 VGND VPWR VPWR sky130_fd_sc_hd__fill_2
* cell instance sky130_fd_sc_hd__fill_2_793 r0 *1 0,0
Xsky130_fd_sc_hd__fill_2_793 VGND VPWR VPWR sky130_fd_sc_hd__fill_2
* cell instance sky130_fd_sc_hd__fill_2_794 r0 *1 0,0
Xsky130_fd_sc_hd__fill_2_794 VGND VPWR VPWR sky130_fd_sc_hd__fill_2
* cell instance sky130_fd_sc_hd__fill_2_795 r0 *1 0,0
Xsky130_fd_sc_hd__fill_2_795 VGND VPWR VPWR sky130_fd_sc_hd__fill_2
* cell instance sky130_fd_sc_hd__fill_2_796 r0 *1 0,0
Xsky130_fd_sc_hd__fill_2_796 VGND VPWR VPWR sky130_fd_sc_hd__fill_2
* cell instance sky130_fd_sc_hd__fill_2_797 r0 *1 0,0
Xsky130_fd_sc_hd__fill_2_797 VGND VPWR VPWR sky130_fd_sc_hd__fill_2
* cell instance sky130_fd_sc_hd__fill_2_798 r0 *1 0,0
Xsky130_fd_sc_hd__fill_2_798 VGND VPWR VPWR sky130_fd_sc_hd__fill_2
* cell instance sky130_fd_sc_hd__fill_2_799 r0 *1 0,0
Xsky130_fd_sc_hd__fill_2_799 VGND VPWR VPWR sky130_fd_sc_hd__fill_2
* cell instance sky130_fd_sc_hd__fill_2_800 r0 *1 0,0
Xsky130_fd_sc_hd__fill_2_800 VGND VPWR VPWR sky130_fd_sc_hd__fill_2
* cell instance sky130_fd_sc_hd__fill_2_801 r0 *1 0,0
Xsky130_fd_sc_hd__fill_2_801 VGND VPWR VPWR sky130_fd_sc_hd__fill_2
* cell instance sky130_fd_sc_hd__fill_2_802 r0 *1 0,0
Xsky130_fd_sc_hd__fill_2_802 VGND VPWR VPWR sky130_fd_sc_hd__fill_2
* cell instance sky130_fd_sc_hd__fill_2_803 r0 *1 0,0
Xsky130_fd_sc_hd__fill_2_803 VGND VPWR VPWR sky130_fd_sc_hd__fill_2
* cell instance sky130_fd_sc_hd__fill_2_804 r0 *1 0,0
Xsky130_fd_sc_hd__fill_2_804 VGND VPWR VPWR sky130_fd_sc_hd__fill_2
* cell instance sky130_fd_sc_hd__fill_2_805 r0 *1 0,0
Xsky130_fd_sc_hd__fill_2_805 VGND VPWR VPWR sky130_fd_sc_hd__fill_2
* cell instance sky130_fd_sc_hd__fill_2_806 r0 *1 0,0
Xsky130_fd_sc_hd__fill_2_806 VGND VPWR VPWR sky130_fd_sc_hd__fill_2
* cell instance sky130_fd_sc_hd__fill_2_807 r0 *1 0,0
Xsky130_fd_sc_hd__fill_2_807 VGND VPWR VPWR sky130_fd_sc_hd__fill_2
* cell instance sky130_fd_sc_hd__fill_2_808 r0 *1 0,0
Xsky130_fd_sc_hd__fill_2_808 VGND VPWR VPWR sky130_fd_sc_hd__fill_2
* cell instance sky130_fd_sc_hd__fill_2_809 r0 *1 0,0
Xsky130_fd_sc_hd__fill_2_809 VGND VPWR VPWR sky130_fd_sc_hd__fill_2
* cell instance sky130_fd_sc_hd__fill_2_810 r0 *1 0,0
Xsky130_fd_sc_hd__fill_2_810 VGND VPWR VPWR sky130_fd_sc_hd__fill_2
* cell instance sky130_fd_sc_hd__fill_2_811 r0 *1 0,0
Xsky130_fd_sc_hd__fill_2_811 VGND VPWR VPWR sky130_fd_sc_hd__fill_2
* cell instance sky130_fd_sc_hd__fill_2_812 r0 *1 0,0
Xsky130_fd_sc_hd__fill_2_812 VGND VPWR VPWR sky130_fd_sc_hd__fill_2
* cell instance sky130_fd_sc_hd__fill_2_813 r0 *1 0,0
Xsky130_fd_sc_hd__fill_2_813 VGND VPWR VPWR sky130_fd_sc_hd__fill_2
* cell instance sky130_fd_sc_hd__fill_2_814 r0 *1 0,0
Xsky130_fd_sc_hd__fill_2_814 VGND VPWR VPWR sky130_fd_sc_hd__fill_2
* cell instance sky130_fd_sc_hd__fill_2_815 r0 *1 0,0
Xsky130_fd_sc_hd__fill_2_815 VGND VPWR VPWR sky130_fd_sc_hd__fill_2
* cell instance sky130_fd_sc_hd__fill_2_816 r0 *1 0,0
Xsky130_fd_sc_hd__fill_2_816 VGND VPWR VPWR sky130_fd_sc_hd__fill_2
* cell instance sky130_fd_sc_hd__fill_2_817 r0 *1 0,0
Xsky130_fd_sc_hd__fill_2_817 VGND VPWR VPWR sky130_fd_sc_hd__fill_2
* cell instance sky130_fd_sc_hd__fill_2_818 r0 *1 0,0
Xsky130_fd_sc_hd__fill_2_818 VGND VPWR VPWR sky130_fd_sc_hd__fill_2
* cell instance sky130_fd_sc_hd__fill_2_819 r0 *1 0,0
Xsky130_fd_sc_hd__fill_2_819 VGND VPWR VPWR sky130_fd_sc_hd__fill_2
* cell instance sky130_fd_sc_hd__fill_2_820 r0 *1 0,0
Xsky130_fd_sc_hd__fill_2_820 VGND VPWR VPWR sky130_fd_sc_hd__fill_2
* cell instance sky130_fd_sc_hd__fill_2_821 r0 *1 0,0
Xsky130_fd_sc_hd__fill_2_821 VGND VPWR VPWR sky130_fd_sc_hd__fill_2
* cell instance sky130_fd_sc_hd__fill_2_822 r0 *1 0,0
Xsky130_fd_sc_hd__fill_2_822 VGND VPWR VPWR sky130_fd_sc_hd__fill_2
* cell instance sky130_fd_sc_hd__fill_2_823 r0 *1 0,0
Xsky130_fd_sc_hd__fill_2_823 VGND VPWR VPWR sky130_fd_sc_hd__fill_2
* cell instance sky130_fd_sc_hd__fill_2_824 r0 *1 0,0
Xsky130_fd_sc_hd__fill_2_824 VGND VPWR VPWR sky130_fd_sc_hd__fill_2
* cell instance sky130_fd_sc_hd__fill_2_825 r0 *1 0,0
Xsky130_fd_sc_hd__fill_2_825 VGND VPWR VPWR sky130_fd_sc_hd__fill_2
* cell instance sky130_fd_sc_hd__fill_2_826 r0 *1 0,0
Xsky130_fd_sc_hd__fill_2_826 VGND VPWR VPWR sky130_fd_sc_hd__fill_2
* cell instance sky130_fd_sc_hd__fill_2_827 r0 *1 0,0
Xsky130_fd_sc_hd__fill_2_827 VGND VPWR VPWR sky130_fd_sc_hd__fill_2
* cell instance sky130_fd_sc_hd__fill_2_828 r0 *1 0,0
Xsky130_fd_sc_hd__fill_2_828 VGND VPWR VPWR sky130_fd_sc_hd__fill_2
* cell instance sky130_fd_sc_hd__fill_2_829 r0 *1 0,0
Xsky130_fd_sc_hd__fill_2_829 VGND VPWR VPWR sky130_fd_sc_hd__fill_2
* cell instance sky130_fd_sc_hd__fill_2_830 r0 *1 0,0
Xsky130_fd_sc_hd__fill_2_830 VGND VPWR VPWR sky130_fd_sc_hd__fill_2
* cell instance sky130_fd_sc_hd__fill_2_831 r0 *1 0,0
Xsky130_fd_sc_hd__fill_2_831 VGND VPWR VPWR sky130_fd_sc_hd__fill_2
* cell instance sky130_fd_sc_hd__fill_2_832 r0 *1 0,0
Xsky130_fd_sc_hd__fill_2_832 VGND VPWR VPWR sky130_fd_sc_hd__fill_2
* cell instance sky130_fd_sc_hd__fill_2_833 r0 *1 0,0
Xsky130_fd_sc_hd__fill_2_833 VGND VPWR VPWR sky130_fd_sc_hd__fill_2
* cell instance sky130_fd_sc_hd__fill_2_834 r0 *1 0,0
Xsky130_fd_sc_hd__fill_2_834 VGND VPWR VPWR sky130_fd_sc_hd__fill_2
* cell instance sky130_fd_sc_hd__fill_2_835 r0 *1 0,0
Xsky130_fd_sc_hd__fill_2_835 VGND VPWR VPWR sky130_fd_sc_hd__fill_2
* cell instance sky130_fd_sc_hd__fill_2_836 r0 *1 0,0
Xsky130_fd_sc_hd__fill_2_836 VGND VPWR VPWR sky130_fd_sc_hd__fill_2
* cell instance sky130_fd_sc_hd__fill_2_837 r0 *1 0,0
Xsky130_fd_sc_hd__fill_2_837 VGND VPWR VPWR sky130_fd_sc_hd__fill_2
* cell instance sky130_fd_sc_hd__fill_2_838 r0 *1 0,0
Xsky130_fd_sc_hd__fill_2_838 VGND VPWR VPWR sky130_fd_sc_hd__fill_2
* cell instance sky130_fd_sc_hd__fill_2_839 r0 *1 0,0
Xsky130_fd_sc_hd__fill_2_839 VGND VPWR VPWR sky130_fd_sc_hd__fill_2
* cell instance sky130_fd_sc_hd__fill_2_840 r0 *1 0,0
Xsky130_fd_sc_hd__fill_2_840 VGND VPWR VPWR sky130_fd_sc_hd__fill_2
* cell instance sky130_fd_sc_hd__fill_2_841 r0 *1 0,0
Xsky130_fd_sc_hd__fill_2_841 VGND VPWR VPWR sky130_fd_sc_hd__fill_2
* cell instance sky130_fd_sc_hd__fill_2_842 r0 *1 0,0
Xsky130_fd_sc_hd__fill_2_842 VGND VPWR VPWR sky130_fd_sc_hd__fill_2
* cell instance sky130_fd_sc_hd__fill_2_843 r0 *1 0,0
Xsky130_fd_sc_hd__fill_2_843 VGND VPWR VPWR sky130_fd_sc_hd__fill_2
* cell instance sky130_fd_sc_hd__fill_2_844 r0 *1 0,0
Xsky130_fd_sc_hd__fill_2_844 VGND VPWR VPWR sky130_fd_sc_hd__fill_2
* cell instance sky130_fd_sc_hd__fill_2_845 r0 *1 0,0
Xsky130_fd_sc_hd__fill_2_845 VGND VPWR VPWR sky130_fd_sc_hd__fill_2
* cell instance sky130_fd_sc_hd__fill_2_846 r0 *1 0,0
Xsky130_fd_sc_hd__fill_2_846 VGND VPWR VPWR sky130_fd_sc_hd__fill_2
* cell instance sky130_fd_sc_hd__fill_2_847 r0 *1 0,0
Xsky130_fd_sc_hd__fill_2_847 VGND VPWR VPWR sky130_fd_sc_hd__fill_2
* cell instance sky130_fd_sc_hd__fill_2_848 r0 *1 0,0
Xsky130_fd_sc_hd__fill_2_848 VGND VPWR VPWR sky130_fd_sc_hd__fill_2
* cell instance sky130_fd_sc_hd__fill_2_849 r0 *1 0,0
Xsky130_fd_sc_hd__fill_2_849 VGND VPWR VPWR sky130_fd_sc_hd__fill_2
* cell instance sky130_fd_sc_hd__fill_2_850 r0 *1 0,0
Xsky130_fd_sc_hd__fill_2_850 VGND VPWR VPWR sky130_fd_sc_hd__fill_2
* cell instance sky130_fd_sc_hd__fill_2_851 r0 *1 0,0
Xsky130_fd_sc_hd__fill_2_851 VGND VPWR VPWR sky130_fd_sc_hd__fill_2
* cell instance sky130_fd_sc_hd__fill_2_852 r0 *1 0,0
Xsky130_fd_sc_hd__fill_2_852 VGND VPWR VPWR sky130_fd_sc_hd__fill_2
* cell instance sky130_fd_sc_hd__fill_2_853 r0 *1 0,0
Xsky130_fd_sc_hd__fill_2_853 VGND VPWR VPWR sky130_fd_sc_hd__fill_2
* cell instance sky130_fd_sc_hd__fill_2_854 r0 *1 0,0
Xsky130_fd_sc_hd__fill_2_854 VGND VPWR VPWR sky130_fd_sc_hd__fill_2
* cell instance sky130_fd_sc_hd__fill_2_855 r0 *1 0,0
Xsky130_fd_sc_hd__fill_2_855 VGND VPWR VPWR sky130_fd_sc_hd__fill_2
* cell instance sky130_fd_sc_hd__fill_2_856 r0 *1 0,0
Xsky130_fd_sc_hd__fill_2_856 VGND VPWR VPWR sky130_fd_sc_hd__fill_2
* cell instance sky130_fd_sc_hd__fill_2_857 r0 *1 0,0
Xsky130_fd_sc_hd__fill_2_857 VGND VPWR VPWR sky130_fd_sc_hd__fill_2
* cell instance sky130_fd_sc_hd__fill_2_858 r0 *1 0,0
Xsky130_fd_sc_hd__fill_2_858 VGND VPWR VPWR sky130_fd_sc_hd__fill_2
* cell instance sky130_fd_sc_hd__fill_2_859 r0 *1 0,0
Xsky130_fd_sc_hd__fill_2_859 VGND VPWR VPWR sky130_fd_sc_hd__fill_2
* cell instance sky130_fd_sc_hd__fill_2_860 r0 *1 0,0
Xsky130_fd_sc_hd__fill_2_860 VGND VPWR VPWR sky130_fd_sc_hd__fill_2
* cell instance sky130_fd_sc_hd__fill_2_861 r0 *1 0,0
Xsky130_fd_sc_hd__fill_2_861 VGND VPWR VPWR sky130_fd_sc_hd__fill_2
* cell instance sky130_fd_sc_hd__fill_2_862 r0 *1 0,0
Xsky130_fd_sc_hd__fill_2_862 VGND VPWR VPWR sky130_fd_sc_hd__fill_2
* cell instance sky130_fd_sc_hd__fill_2_863 r0 *1 0,0
Xsky130_fd_sc_hd__fill_2_863 VGND VPWR VPWR sky130_fd_sc_hd__fill_2
* cell instance sky130_fd_sc_hd__fill_2_864 r0 *1 0,0
Xsky130_fd_sc_hd__fill_2_864 VGND VPWR VPWR sky130_fd_sc_hd__fill_2
* cell instance sky130_fd_sc_hd__fill_2_865 r0 *1 0,0
Xsky130_fd_sc_hd__fill_2_865 VGND VPWR VPWR sky130_fd_sc_hd__fill_2
* cell instance sky130_fd_sc_hd__fill_2_866 r0 *1 0,0
Xsky130_fd_sc_hd__fill_2_866 VGND VPWR VPWR sky130_fd_sc_hd__fill_2
* cell instance sky130_fd_sc_hd__fill_2_867 r0 *1 0,0
Xsky130_fd_sc_hd__fill_2_867 VGND VPWR VPWR sky130_fd_sc_hd__fill_2
* cell instance sky130_fd_sc_hd__fill_2_868 r0 *1 0,0
Xsky130_fd_sc_hd__fill_2_868 VGND VPWR VPWR sky130_fd_sc_hd__fill_2
* cell instance sky130_fd_sc_hd__fill_2_869 r0 *1 0,0
Xsky130_fd_sc_hd__fill_2_869 VGND VPWR VPWR sky130_fd_sc_hd__fill_2
* cell instance sky130_fd_sc_hd__fill_2_870 r0 *1 0,0
Xsky130_fd_sc_hd__fill_2_870 VGND VPWR VPWR sky130_fd_sc_hd__fill_2
* cell instance sky130_fd_sc_hd__fill_2_871 r0 *1 0,0
Xsky130_fd_sc_hd__fill_2_871 VGND VPWR VPWR sky130_fd_sc_hd__fill_2
* cell instance sky130_fd_sc_hd__fill_2_872 r0 *1 0,0
Xsky130_fd_sc_hd__fill_2_872 VGND VPWR VPWR sky130_fd_sc_hd__fill_2
* cell instance sky130_fd_sc_hd__fill_2_873 r0 *1 0,0
Xsky130_fd_sc_hd__fill_2_873 VGND VPWR VPWR sky130_fd_sc_hd__fill_2
* cell instance sky130_fd_sc_hd__fill_2_874 r0 *1 0,0
Xsky130_fd_sc_hd__fill_2_874 VGND VPWR VPWR sky130_fd_sc_hd__fill_2
* cell instance sky130_fd_sc_hd__fill_2_875 r0 *1 0,0
Xsky130_fd_sc_hd__fill_2_875 VGND VPWR VPWR sky130_fd_sc_hd__fill_2
* cell instance sky130_fd_sc_hd__fill_2_876 r0 *1 0,0
Xsky130_fd_sc_hd__fill_2_876 VGND VPWR VPWR sky130_fd_sc_hd__fill_2
* cell instance sky130_fd_sc_hd__fill_2_877 r0 *1 0,0
Xsky130_fd_sc_hd__fill_2_877 VGND VPWR VPWR sky130_fd_sc_hd__fill_2
* cell instance sky130_fd_sc_hd__fill_2_878 r0 *1 0,0
Xsky130_fd_sc_hd__fill_2_878 VGND VPWR VPWR sky130_fd_sc_hd__fill_2
* cell instance sky130_fd_sc_hd__fill_2_879 r0 *1 0,0
Xsky130_fd_sc_hd__fill_2_879 VGND VPWR VPWR sky130_fd_sc_hd__fill_2
* cell instance sky130_fd_sc_hd__fill_2_880 r0 *1 0,0
Xsky130_fd_sc_hd__fill_2_880 VGND VPWR VPWR sky130_fd_sc_hd__fill_2
* cell instance sky130_fd_sc_hd__fill_2_881 r0 *1 0,0
Xsky130_fd_sc_hd__fill_2_881 VGND VPWR VPWR sky130_fd_sc_hd__fill_2
* cell instance sky130_fd_sc_hd__fill_2_882 r0 *1 0,0
Xsky130_fd_sc_hd__fill_2_882 VGND VPWR VPWR sky130_fd_sc_hd__fill_2
* cell instance sky130_fd_sc_hd__fill_2_883 r0 *1 0,0
Xsky130_fd_sc_hd__fill_2_883 VGND VPWR VPWR sky130_fd_sc_hd__fill_2
* cell instance sky130_fd_sc_hd__fill_2_884 r0 *1 0,0
Xsky130_fd_sc_hd__fill_2_884 VGND VPWR VPWR sky130_fd_sc_hd__fill_2
* cell instance sky130_fd_sc_hd__fill_2_885 r0 *1 0,0
Xsky130_fd_sc_hd__fill_2_885 VGND VPWR VPWR sky130_fd_sc_hd__fill_2
* cell instance sky130_fd_sc_hd__fill_2_886 r0 *1 0,0
Xsky130_fd_sc_hd__fill_2_886 VGND VPWR VPWR sky130_fd_sc_hd__fill_2
* cell instance sky130_fd_sc_hd__fill_2_887 r0 *1 0,0
Xsky130_fd_sc_hd__fill_2_887 VGND VPWR VPWR sky130_fd_sc_hd__fill_2
* cell instance sky130_fd_sc_hd__fill_2_888 r0 *1 0,0
Xsky130_fd_sc_hd__fill_2_888 VGND VPWR VPWR sky130_fd_sc_hd__fill_2
* cell instance sky130_fd_sc_hd__fill_2_889 r0 *1 0,0
Xsky130_fd_sc_hd__fill_2_889 VGND VPWR VPWR sky130_fd_sc_hd__fill_2
* cell instance sky130_fd_sc_hd__fill_2_890 r0 *1 0,0
Xsky130_fd_sc_hd__fill_2_890 VGND VPWR VPWR sky130_fd_sc_hd__fill_2
* cell instance sky130_fd_sc_hd__fill_2_891 r0 *1 0,0
Xsky130_fd_sc_hd__fill_2_891 VGND VPWR VPWR sky130_fd_sc_hd__fill_2
* cell instance sky130_fd_sc_hd__fill_2_892 r0 *1 0,0
Xsky130_fd_sc_hd__fill_2_892 VGND VPWR VPWR sky130_fd_sc_hd__fill_2
* cell instance sky130_fd_sc_hd__fill_2_893 r0 *1 0,0
Xsky130_fd_sc_hd__fill_2_893 VGND VPWR VPWR sky130_fd_sc_hd__fill_2
* cell instance sky130_fd_sc_hd__fill_2_894 r0 *1 0,0
Xsky130_fd_sc_hd__fill_2_894 VGND VPWR VPWR sky130_fd_sc_hd__fill_2
* cell instance sky130_fd_sc_hd__fill_2_895 r0 *1 0,0
Xsky130_fd_sc_hd__fill_2_895 VGND VPWR VPWR sky130_fd_sc_hd__fill_2
* cell instance sky130_fd_sc_hd__fill_2_896 r0 *1 0,0
Xsky130_fd_sc_hd__fill_2_896 VGND VPWR VPWR sky130_fd_sc_hd__fill_2
* cell instance sky130_fd_sc_hd__fill_2_897 r0 *1 0,0
Xsky130_fd_sc_hd__fill_2_897 VGND VPWR VPWR sky130_fd_sc_hd__fill_2
* cell instance sky130_fd_sc_hd__fill_2_898 r0 *1 0,0
Xsky130_fd_sc_hd__fill_2_898 VGND VPWR VPWR sky130_fd_sc_hd__fill_2
* cell instance sky130_fd_sc_hd__fill_2_899 r0 *1 0,0
Xsky130_fd_sc_hd__fill_2_899 VGND VPWR VPWR sky130_fd_sc_hd__fill_2
* cell instance sky130_fd_sc_hd__fill_2_900 r0 *1 0,0
Xsky130_fd_sc_hd__fill_2_900 VGND VPWR VPWR sky130_fd_sc_hd__fill_2
* cell instance sky130_fd_sc_hd__fill_2_901 r0 *1 0,0
Xsky130_fd_sc_hd__fill_2_901 VGND VPWR VPWR sky130_fd_sc_hd__fill_2
* cell instance sky130_fd_sc_hd__fill_2_902 r0 *1 0,0
Xsky130_fd_sc_hd__fill_2_902 VGND VPWR VPWR sky130_fd_sc_hd__fill_2
* cell instance sky130_fd_sc_hd__fill_2_903 r0 *1 0,0
Xsky130_fd_sc_hd__fill_2_903 VGND VPWR VPWR sky130_fd_sc_hd__fill_2
* cell instance sky130_fd_sc_hd__fill_2_904 r0 *1 0,0
Xsky130_fd_sc_hd__fill_2_904 VGND VPWR VPWR sky130_fd_sc_hd__fill_2
* cell instance sky130_fd_sc_hd__fill_2_905 r0 *1 0,0
Xsky130_fd_sc_hd__fill_2_905 VGND VPWR VPWR sky130_fd_sc_hd__fill_2
* cell instance sky130_fd_sc_hd__fill_2_906 r0 *1 0,0
Xsky130_fd_sc_hd__fill_2_906 VGND VPWR VPWR sky130_fd_sc_hd__fill_2
* cell instance sky130_fd_sc_hd__fill_2_907 r0 *1 0,0
Xsky130_fd_sc_hd__fill_2_907 VGND VPWR VPWR sky130_fd_sc_hd__fill_2
* cell instance sky130_fd_sc_hd__fill_2_908 r0 *1 0,0
Xsky130_fd_sc_hd__fill_2_908 VGND VPWR VPWR sky130_fd_sc_hd__fill_2
* cell instance sky130_fd_sc_hd__fill_2_909 r0 *1 0,0
Xsky130_fd_sc_hd__fill_2_909 VGND VPWR VPWR sky130_fd_sc_hd__fill_2
* cell instance sky130_fd_sc_hd__fill_2_910 r0 *1 0,0
Xsky130_fd_sc_hd__fill_2_910 VGND VPWR VPWR sky130_fd_sc_hd__fill_2
* cell instance sky130_fd_sc_hd__fill_2_911 r0 *1 0,0
Xsky130_fd_sc_hd__fill_2_911 VGND VPWR VPWR sky130_fd_sc_hd__fill_2
* cell instance sky130_fd_sc_hd__fill_2_912 r0 *1 0,0
Xsky130_fd_sc_hd__fill_2_912 VGND VPWR VPWR sky130_fd_sc_hd__fill_2
* cell instance sky130_fd_sc_hd__fill_2_913 r0 *1 0,0
Xsky130_fd_sc_hd__fill_2_913 VGND VPWR VPWR sky130_fd_sc_hd__fill_2
* cell instance sky130_fd_sc_hd__fill_2_914 r0 *1 0,0
Xsky130_fd_sc_hd__fill_2_914 VGND VPWR VPWR sky130_fd_sc_hd__fill_2
* cell instance sky130_fd_sc_hd__fill_2_915 r0 *1 0,0
Xsky130_fd_sc_hd__fill_2_915 VGND VPWR VPWR sky130_fd_sc_hd__fill_2
* cell instance sky130_fd_sc_hd__fill_2_916 r0 *1 0,0
Xsky130_fd_sc_hd__fill_2_916 VGND VPWR VPWR sky130_fd_sc_hd__fill_2
* cell instance sky130_fd_sc_hd__fill_2_917 r0 *1 0,0
Xsky130_fd_sc_hd__fill_2_917 VGND VPWR VPWR sky130_fd_sc_hd__fill_2
* cell instance sky130_fd_sc_hd__fill_2_918 r0 *1 0,0
Xsky130_fd_sc_hd__fill_2_918 VGND VPWR VPWR sky130_fd_sc_hd__fill_2
* cell instance sky130_fd_sc_hd__fill_2_919 r0 *1 0,0
Xsky130_fd_sc_hd__fill_2_919 VGND VPWR VPWR sky130_fd_sc_hd__fill_2
* cell instance sky130_fd_sc_hd__fill_2_920 r0 *1 0,0
Xsky130_fd_sc_hd__fill_2_920 VGND VPWR VPWR sky130_fd_sc_hd__fill_2
* cell instance sky130_fd_sc_hd__fill_2_921 r0 *1 0,0
Xsky130_fd_sc_hd__fill_2_921 VGND VPWR VPWR sky130_fd_sc_hd__fill_2
* cell instance sky130_fd_sc_hd__fill_2_922 r0 *1 0,0
Xsky130_fd_sc_hd__fill_2_922 VGND VPWR VPWR sky130_fd_sc_hd__fill_2
* cell instance sky130_fd_sc_hd__fill_2_923 r0 *1 0,0
Xsky130_fd_sc_hd__fill_2_923 VGND VPWR VPWR sky130_fd_sc_hd__fill_2
* cell instance sky130_fd_sc_hd__fill_2_924 r0 *1 0,0
Xsky130_fd_sc_hd__fill_2_924 VGND VPWR VPWR sky130_fd_sc_hd__fill_2
* cell instance sky130_fd_sc_hd__fill_2_925 r0 *1 0,0
Xsky130_fd_sc_hd__fill_2_925 VGND VPWR VPWR sky130_fd_sc_hd__fill_2
* cell instance sky130_fd_sc_hd__fill_2_926 r0 *1 0,0
Xsky130_fd_sc_hd__fill_2_926 VGND VPWR VPWR sky130_fd_sc_hd__fill_2
* cell instance sky130_fd_sc_hd__fill_2_927 r0 *1 0,0
Xsky130_fd_sc_hd__fill_2_927 VGND VPWR VPWR sky130_fd_sc_hd__fill_2
* cell instance sky130_fd_sc_hd__fill_2_928 r0 *1 0,0
Xsky130_fd_sc_hd__fill_2_928 VGND VPWR VPWR sky130_fd_sc_hd__fill_2
* cell instance sky130_fd_sc_hd__fill_2_929 r0 *1 0,0
Xsky130_fd_sc_hd__fill_2_929 VGND VPWR VPWR sky130_fd_sc_hd__fill_2
* cell instance sky130_fd_sc_hd__fill_2_930 r0 *1 0,0
Xsky130_fd_sc_hd__fill_2_930 VGND VPWR VPWR sky130_fd_sc_hd__fill_2
* cell instance sky130_fd_sc_hd__fill_2_931 r0 *1 0,0
Xsky130_fd_sc_hd__fill_2_931 VGND VPWR VPWR sky130_fd_sc_hd__fill_2
* cell instance sky130_fd_sc_hd__fill_2_932 r0 *1 0,0
Xsky130_fd_sc_hd__fill_2_932 VGND VPWR VPWR sky130_fd_sc_hd__fill_2
* cell instance sky130_fd_sc_hd__fill_2_933 r0 *1 0,0
Xsky130_fd_sc_hd__fill_2_933 VGND VPWR VPWR sky130_fd_sc_hd__fill_2
* cell instance sky130_fd_sc_hd__fill_2_934 r0 *1 0,0
Xsky130_fd_sc_hd__fill_2_934 VGND VPWR VPWR sky130_fd_sc_hd__fill_2
* cell instance sky130_fd_sc_hd__fill_2_935 r0 *1 0,0
Xsky130_fd_sc_hd__fill_2_935 VGND VPWR VPWR sky130_fd_sc_hd__fill_2
* cell instance sky130_fd_sc_hd__fill_2_936 r0 *1 0,0
Xsky130_fd_sc_hd__fill_2_936 VGND VPWR VPWR sky130_fd_sc_hd__fill_2
* cell instance sky130_fd_sc_hd__fill_2_937 r0 *1 0,0
Xsky130_fd_sc_hd__fill_2_937 VGND VPWR VPWR sky130_fd_sc_hd__fill_2
* cell instance sky130_fd_sc_hd__fill_2_938 r0 *1 0,0
Xsky130_fd_sc_hd__fill_2_938 VGND VPWR VPWR sky130_fd_sc_hd__fill_2
* cell instance sky130_fd_sc_hd__fill_2_939 r0 *1 0,0
Xsky130_fd_sc_hd__fill_2_939 VGND VPWR VPWR sky130_fd_sc_hd__fill_2
* cell instance sky130_fd_sc_hd__fill_2_940 r0 *1 0,0
Xsky130_fd_sc_hd__fill_2_940 VGND VPWR VPWR sky130_fd_sc_hd__fill_2
* cell instance sky130_fd_sc_hd__fill_2_941 r0 *1 0,0
Xsky130_fd_sc_hd__fill_2_941 VGND VPWR VPWR sky130_fd_sc_hd__fill_2
* cell instance sky130_fd_sc_hd__fill_2_942 r0 *1 0,0
Xsky130_fd_sc_hd__fill_2_942 VGND VPWR VPWR sky130_fd_sc_hd__fill_2
* cell instance sky130_fd_sc_hd__fill_2_943 r0 *1 0,0
Xsky130_fd_sc_hd__fill_2_943 VGND VPWR VPWR sky130_fd_sc_hd__fill_2
* cell instance sky130_fd_sc_hd__fill_2_944 r0 *1 0,0
Xsky130_fd_sc_hd__fill_2_944 VGND VPWR VPWR sky130_fd_sc_hd__fill_2
* cell instance sky130_fd_sc_hd__fill_2_945 r0 *1 0,0
Xsky130_fd_sc_hd__fill_2_945 VGND VPWR VPWR sky130_fd_sc_hd__fill_2
* cell instance sky130_fd_sc_hd__fill_2_946 r0 *1 0,0
Xsky130_fd_sc_hd__fill_2_946 VGND VPWR VPWR sky130_fd_sc_hd__fill_2
* cell instance sky130_fd_sc_hd__fill_2_947 r0 *1 0,0
Xsky130_fd_sc_hd__fill_2_947 VGND VPWR VPWR sky130_fd_sc_hd__fill_2
* cell instance sky130_fd_sc_hd__fill_2_948 r0 *1 0,0
Xsky130_fd_sc_hd__fill_2_948 VGND VPWR VPWR sky130_fd_sc_hd__fill_2
* cell instance sky130_fd_sc_hd__fill_2_949 r0 *1 0,0
Xsky130_fd_sc_hd__fill_2_949 VGND VPWR VPWR sky130_fd_sc_hd__fill_2
* cell instance sky130_fd_sc_hd__fill_2_950 r0 *1 0,0
Xsky130_fd_sc_hd__fill_2_950 VGND VPWR VPWR sky130_fd_sc_hd__fill_2
* cell instance sky130_fd_sc_hd__fill_2_951 r0 *1 0,0
Xsky130_fd_sc_hd__fill_2_951 VGND VPWR VPWR sky130_fd_sc_hd__fill_2
* cell instance sky130_fd_sc_hd__fill_2_952 r0 *1 0,0
Xsky130_fd_sc_hd__fill_2_952 VGND VPWR VPWR sky130_fd_sc_hd__fill_2
* cell instance sky130_fd_sc_hd__fill_2_953 r0 *1 0,0
Xsky130_fd_sc_hd__fill_2_953 VGND VPWR VPWR sky130_fd_sc_hd__fill_2
* cell instance sky130_fd_sc_hd__fill_2_954 r0 *1 0,0
Xsky130_fd_sc_hd__fill_2_954 VGND VPWR VPWR sky130_fd_sc_hd__fill_2
* cell instance sky130_fd_sc_hd__fill_2_955 r0 *1 0,0
Xsky130_fd_sc_hd__fill_2_955 VGND VPWR VPWR sky130_fd_sc_hd__fill_2
* cell instance sky130_fd_sc_hd__fill_2_956 r0 *1 0,0
Xsky130_fd_sc_hd__fill_2_956 VGND VPWR VPWR sky130_fd_sc_hd__fill_2
* cell instance sky130_fd_sc_hd__fill_2_957 r0 *1 0,0
Xsky130_fd_sc_hd__fill_2_957 VGND VPWR VPWR sky130_fd_sc_hd__fill_2
* cell instance sky130_fd_sc_hd__fill_2_958 r0 *1 0,0
Xsky130_fd_sc_hd__fill_2_958 VGND VPWR VPWR sky130_fd_sc_hd__fill_2
* cell instance sky130_fd_sc_hd__fill_2_959 r0 *1 0,0
Xsky130_fd_sc_hd__fill_2_959 VGND VPWR VPWR sky130_fd_sc_hd__fill_2
* cell instance sky130_fd_sc_hd__fill_2_960 r0 *1 0,0
Xsky130_fd_sc_hd__fill_2_960 VGND VPWR VPWR sky130_fd_sc_hd__fill_2
* cell instance sky130_fd_sc_hd__fill_2_961 r0 *1 0,0
Xsky130_fd_sc_hd__fill_2_961 VGND VPWR VPWR sky130_fd_sc_hd__fill_2
* cell instance sky130_fd_sc_hd__fill_2_962 r0 *1 0,0
Xsky130_fd_sc_hd__fill_2_962 VGND VPWR VPWR sky130_fd_sc_hd__fill_2
* cell instance sky130_fd_sc_hd__fill_2_963 r0 *1 0,0
Xsky130_fd_sc_hd__fill_2_963 VGND VPWR VPWR sky130_fd_sc_hd__fill_2
* cell instance sky130_fd_sc_hd__fill_2_964 r0 *1 0,0
Xsky130_fd_sc_hd__fill_2_964 VGND VPWR VPWR sky130_fd_sc_hd__fill_2
* cell instance sky130_fd_sc_hd__fill_2_965 r0 *1 0,0
Xsky130_fd_sc_hd__fill_2_965 VGND VPWR VPWR sky130_fd_sc_hd__fill_2
* cell instance sky130_fd_sc_hd__fill_2_966 r0 *1 0,0
Xsky130_fd_sc_hd__fill_2_966 VGND VPWR VPWR sky130_fd_sc_hd__fill_2
* cell instance sky130_fd_sc_hd__fill_2_967 r0 *1 0,0
Xsky130_fd_sc_hd__fill_2_967 VGND VPWR VPWR sky130_fd_sc_hd__fill_2
* cell instance sky130_fd_sc_hd__fill_2_968 r0 *1 0,0
Xsky130_fd_sc_hd__fill_2_968 VGND VPWR VPWR sky130_fd_sc_hd__fill_2
* cell instance sky130_fd_sc_hd__fill_2_969 r0 *1 0,0
Xsky130_fd_sc_hd__fill_2_969 VGND VPWR VPWR sky130_fd_sc_hd__fill_2
* cell instance sky130_fd_sc_hd__fill_2_970 r0 *1 0,0
Xsky130_fd_sc_hd__fill_2_970 VGND VPWR VPWR sky130_fd_sc_hd__fill_2
* cell instance sky130_fd_sc_hd__fill_2_971 r0 *1 0,0
Xsky130_fd_sc_hd__fill_2_971 VGND VPWR VPWR sky130_fd_sc_hd__fill_2
* cell instance sky130_fd_sc_hd__fill_2_972 r0 *1 0,0
Xsky130_fd_sc_hd__fill_2_972 VGND VPWR VPWR sky130_fd_sc_hd__fill_2
* cell instance sky130_fd_sc_hd__fill_2_973 r0 *1 0,0
Xsky130_fd_sc_hd__fill_2_973 VGND VPWR VPWR sky130_fd_sc_hd__fill_2
* cell instance sky130_fd_sc_hd__fill_2_974 r0 *1 0,0
Xsky130_fd_sc_hd__fill_2_974 VGND VPWR VPWR sky130_fd_sc_hd__fill_2
* cell instance sky130_fd_sc_hd__fill_2_975 r0 *1 0,0
Xsky130_fd_sc_hd__fill_2_975 VGND VPWR VPWR sky130_fd_sc_hd__fill_2
* cell instance sky130_fd_sc_hd__fill_2_976 r0 *1 0,0
Xsky130_fd_sc_hd__fill_2_976 VGND VPWR VPWR sky130_fd_sc_hd__fill_2
* cell instance sky130_fd_sc_hd__fill_2_977 r0 *1 0,0
Xsky130_fd_sc_hd__fill_2_977 VGND VPWR VPWR sky130_fd_sc_hd__fill_2
* cell instance sky130_fd_sc_hd__fill_2_978 r0 *1 0,0
Xsky130_fd_sc_hd__fill_2_978 VGND VPWR VPWR sky130_fd_sc_hd__fill_2
* cell instance sky130_fd_sc_hd__fill_2_979 r0 *1 0,0
Xsky130_fd_sc_hd__fill_2_979 VGND VPWR VPWR sky130_fd_sc_hd__fill_2
* cell instance sky130_fd_sc_hd__fill_2_980 r0 *1 0,0
Xsky130_fd_sc_hd__fill_2_980 VGND VPWR VPWR sky130_fd_sc_hd__fill_2
* cell instance sky130_fd_sc_hd__fill_2_981 r0 *1 0,0
Xsky130_fd_sc_hd__fill_2_981 VGND VPWR VPWR sky130_fd_sc_hd__fill_2
* cell instance sky130_fd_sc_hd__fill_2_982 r0 *1 0,0
Xsky130_fd_sc_hd__fill_2_982 VGND VPWR VPWR sky130_fd_sc_hd__fill_2
* cell instance sky130_fd_sc_hd__fill_2_983 r0 *1 0,0
Xsky130_fd_sc_hd__fill_2_983 VGND VPWR VPWR sky130_fd_sc_hd__fill_2
* cell instance sky130_fd_sc_hd__fill_2_984 r0 *1 0,0
Xsky130_fd_sc_hd__fill_2_984 VGND VPWR VPWR sky130_fd_sc_hd__fill_2
* cell instance sky130_fd_sc_hd__fill_2_985 r0 *1 0,0
Xsky130_fd_sc_hd__fill_2_985 VGND VPWR VPWR sky130_fd_sc_hd__fill_2
* cell instance sky130_fd_sc_hd__fill_2_986 r0 *1 0,0
Xsky130_fd_sc_hd__fill_2_986 VGND VPWR VPWR sky130_fd_sc_hd__fill_2
* cell instance sky130_fd_sc_hd__fill_2_987 r0 *1 0,0
Xsky130_fd_sc_hd__fill_2_987 VGND VPWR VPWR sky130_fd_sc_hd__fill_2
* cell instance sky130_fd_sc_hd__fill_2_988 r0 *1 0,0
Xsky130_fd_sc_hd__fill_2_988 VGND VPWR VPWR sky130_fd_sc_hd__fill_2
* cell instance sky130_fd_sc_hd__fill_2_989 r0 *1 0,0
Xsky130_fd_sc_hd__fill_2_989 VGND VPWR VPWR sky130_fd_sc_hd__fill_2
* cell instance sky130_fd_sc_hd__fill_2_990 r0 *1 0,0
Xsky130_fd_sc_hd__fill_2_990 VGND VPWR VPWR sky130_fd_sc_hd__fill_2
* cell instance sky130_fd_sc_hd__fill_2_991 r0 *1 0,0
Xsky130_fd_sc_hd__fill_2_991 VGND VPWR VPWR sky130_fd_sc_hd__fill_2
* cell instance sky130_fd_sc_hd__fill_2_992 r0 *1 0,0
Xsky130_fd_sc_hd__fill_2_992 VGND VPWR VPWR sky130_fd_sc_hd__fill_2
* cell instance sky130_fd_sc_hd__fill_2_993 r0 *1 0,0
Xsky130_fd_sc_hd__fill_2_993 VGND VPWR VPWR sky130_fd_sc_hd__fill_2
* cell instance sky130_fd_sc_hd__fill_2_994 r0 *1 0,0
Xsky130_fd_sc_hd__fill_2_994 VGND VPWR VPWR sky130_fd_sc_hd__fill_2
* cell instance sky130_fd_sc_hd__fill_2_995 r0 *1 0,0
Xsky130_fd_sc_hd__fill_2_995 VGND VPWR VPWR sky130_fd_sc_hd__fill_2
* cell instance sky130_fd_sc_hd__fill_2_996 r0 *1 0,0
Xsky130_fd_sc_hd__fill_2_996 VGND VPWR VPWR sky130_fd_sc_hd__fill_2
* cell instance sky130_fd_sc_hd__fill_2_997 r0 *1 0,0
Xsky130_fd_sc_hd__fill_2_997 VGND VPWR VPWR sky130_fd_sc_hd__fill_2
* cell instance sky130_fd_sc_hd__fill_2_998 r0 *1 0,0
Xsky130_fd_sc_hd__fill_2_998 VGND VPWR VPWR sky130_fd_sc_hd__fill_2
* cell instance sky130_fd_sc_hd__fill_2_999 r0 *1 0,0
Xsky130_fd_sc_hd__fill_2_999 VGND VPWR VPWR sky130_fd_sc_hd__fill_2
* cell instance sky130_fd_sc_hd__fill_2_1000 r0 *1 0,0
Xsky130_fd_sc_hd__fill_2_1000 VGND VPWR VPWR sky130_fd_sc_hd__fill_2
* cell instance sky130_fd_sc_hd__fill_2_1001 r0 *1 0,0
Xsky130_fd_sc_hd__fill_2_1001 VGND VPWR VPWR sky130_fd_sc_hd__fill_2
* cell instance sky130_fd_sc_hd__fill_2_1002 r0 *1 0,0
Xsky130_fd_sc_hd__fill_2_1002 VGND VPWR VPWR sky130_fd_sc_hd__fill_2
* cell instance sky130_fd_sc_hd__fill_2_1003 r0 *1 0,0
Xsky130_fd_sc_hd__fill_2_1003 VGND VPWR VPWR sky130_fd_sc_hd__fill_2
* cell instance sky130_fd_sc_hd__fill_2_1004 r0 *1 0,0
Xsky130_fd_sc_hd__fill_2_1004 VGND VPWR VPWR sky130_fd_sc_hd__fill_2
* cell instance sky130_fd_sc_hd__fill_2_1005 r0 *1 0,0
Xsky130_fd_sc_hd__fill_2_1005 VGND VPWR VPWR sky130_fd_sc_hd__fill_2
* cell instance sky130_fd_sc_hd__fill_2_1006 r0 *1 0,0
Xsky130_fd_sc_hd__fill_2_1006 VGND VPWR VPWR sky130_fd_sc_hd__fill_2
* cell instance sky130_fd_sc_hd__fill_2_1007 r0 *1 0,0
Xsky130_fd_sc_hd__fill_2_1007 VGND VPWR VPWR sky130_fd_sc_hd__fill_2
* cell instance sky130_fd_sc_hd__fill_2_1008 r0 *1 0,0
Xsky130_fd_sc_hd__fill_2_1008 VGND VPWR VPWR sky130_fd_sc_hd__fill_2
* cell instance sky130_fd_sc_hd__fill_2_1009 r0 *1 0,0
Xsky130_fd_sc_hd__fill_2_1009 VGND VPWR VPWR sky130_fd_sc_hd__fill_2
* cell instance sky130_fd_sc_hd__fill_2_1010 r0 *1 0,0
Xsky130_fd_sc_hd__fill_2_1010 VGND VPWR VPWR sky130_fd_sc_hd__fill_2
* cell instance sky130_fd_sc_hd__fill_2_1011 r0 *1 0,0
Xsky130_fd_sc_hd__fill_2_1011 VGND VPWR VPWR sky130_fd_sc_hd__fill_2
* cell instance sky130_fd_sc_hd__fill_2_1012 r0 *1 0,0
Xsky130_fd_sc_hd__fill_2_1012 VGND VPWR VPWR sky130_fd_sc_hd__fill_2
* cell instance sky130_fd_sc_hd__fill_2_1013 r0 *1 0,0
Xsky130_fd_sc_hd__fill_2_1013 VGND VPWR VPWR sky130_fd_sc_hd__fill_2
* cell instance sky130_fd_sc_hd__fill_2_1014 r0 *1 0,0
Xsky130_fd_sc_hd__fill_2_1014 VGND VPWR VPWR sky130_fd_sc_hd__fill_2
* cell instance sky130_fd_sc_hd__fill_2_1015 r0 *1 0,0
Xsky130_fd_sc_hd__fill_2_1015 VGND VPWR VPWR sky130_fd_sc_hd__fill_2
* cell instance sky130_fd_sc_hd__fill_2_1016 r0 *1 0,0
Xsky130_fd_sc_hd__fill_2_1016 VGND VPWR VPWR sky130_fd_sc_hd__fill_2
* cell instance sky130_fd_sc_hd__fill_2_1017 r0 *1 0,0
Xsky130_fd_sc_hd__fill_2_1017 VGND VPWR VPWR sky130_fd_sc_hd__fill_2
* cell instance sky130_fd_sc_hd__fill_2_1018 r0 *1 0,0
Xsky130_fd_sc_hd__fill_2_1018 VGND VPWR VPWR sky130_fd_sc_hd__fill_2
* cell instance sky130_fd_sc_hd__fill_2_1019 r0 *1 0,0
Xsky130_fd_sc_hd__fill_2_1019 VGND VPWR VPWR sky130_fd_sc_hd__fill_2
* cell instance sky130_fd_sc_hd__fill_2_1020 r0 *1 0,0
Xsky130_fd_sc_hd__fill_2_1020 VGND VPWR VPWR sky130_fd_sc_hd__fill_2
* cell instance sky130_fd_sc_hd__fill_2_1021 r0 *1 0,0
Xsky130_fd_sc_hd__fill_2_1021 VGND VPWR VPWR sky130_fd_sc_hd__fill_2
* cell instance sky130_fd_sc_hd__fill_2_1022 r0 *1 0,0
Xsky130_fd_sc_hd__fill_2_1022 VGND VPWR VPWR sky130_fd_sc_hd__fill_2
* cell instance sky130_fd_sc_hd__fill_2_1023 r0 *1 0,0
Xsky130_fd_sc_hd__fill_2_1023 VGND VPWR VPWR sky130_fd_sc_hd__fill_2
* cell instance sky130_fd_sc_hd__fill_2_1024 r0 *1 0,0
Xsky130_fd_sc_hd__fill_2_1024 VGND VPWR VPWR sky130_fd_sc_hd__fill_2
* cell instance sky130_fd_sc_hd__fill_2_1025 r0 *1 0,0
Xsky130_fd_sc_hd__fill_2_1025 VGND VPWR VPWR sky130_fd_sc_hd__fill_2
* cell instance sky130_fd_sc_hd__fill_2_1026 r0 *1 0,0
Xsky130_fd_sc_hd__fill_2_1026 VGND VPWR VPWR sky130_fd_sc_hd__fill_2
* cell instance sky130_fd_sc_hd__fill_2_1027 r0 *1 0,0
Xsky130_fd_sc_hd__fill_2_1027 VGND VPWR VPWR sky130_fd_sc_hd__fill_2
* cell instance sky130_fd_sc_hd__fill_2_1028 r0 *1 0,0
Xsky130_fd_sc_hd__fill_2_1028 VGND VPWR VPWR sky130_fd_sc_hd__fill_2
* cell instance sky130_fd_sc_hd__fill_2_1029 r0 *1 0,0
Xsky130_fd_sc_hd__fill_2_1029 VGND VPWR VPWR sky130_fd_sc_hd__fill_2
* cell instance sky130_fd_sc_hd__fill_2_1030 r0 *1 0,0
Xsky130_fd_sc_hd__fill_2_1030 VGND VPWR VPWR sky130_fd_sc_hd__fill_2
* cell instance sky130_fd_sc_hd__fill_2_1031 r0 *1 0,0
Xsky130_fd_sc_hd__fill_2_1031 VGND VPWR VPWR sky130_fd_sc_hd__fill_2
* cell instance sky130_fd_sc_hd__fill_2_1032 r0 *1 0,0
Xsky130_fd_sc_hd__fill_2_1032 VGND VPWR VPWR sky130_fd_sc_hd__fill_2
* cell instance sky130_fd_sc_hd__fill_2_1033 r0 *1 0,0
Xsky130_fd_sc_hd__fill_2_1033 VGND VPWR VPWR sky130_fd_sc_hd__fill_2
* cell instance sky130_fd_sc_hd__fill_2_1034 r0 *1 0,0
Xsky130_fd_sc_hd__fill_2_1034 VGND VPWR VPWR sky130_fd_sc_hd__fill_2
* cell instance sky130_fd_sc_hd__fill_2_1035 r0 *1 0,0
Xsky130_fd_sc_hd__fill_2_1035 VGND VPWR VPWR sky130_fd_sc_hd__fill_2
* cell instance sky130_fd_sc_hd__fill_2_1036 r0 *1 0,0
Xsky130_fd_sc_hd__fill_2_1036 VGND VPWR VPWR sky130_fd_sc_hd__fill_2
* cell instance sky130_fd_sc_hd__fill_2_1037 r0 *1 0,0
Xsky130_fd_sc_hd__fill_2_1037 VGND VPWR VPWR sky130_fd_sc_hd__fill_2
* cell instance sky130_fd_sc_hd__fill_2_1038 r0 *1 0,0
Xsky130_fd_sc_hd__fill_2_1038 VGND VPWR VPWR sky130_fd_sc_hd__fill_2
* cell instance sky130_fd_sc_hd__fill_2_1039 r0 *1 0,0
Xsky130_fd_sc_hd__fill_2_1039 VGND VPWR VPWR sky130_fd_sc_hd__fill_2
* cell instance sky130_fd_sc_hd__fill_2_1040 r0 *1 0,0
Xsky130_fd_sc_hd__fill_2_1040 VGND VPWR VPWR sky130_fd_sc_hd__fill_2
* cell instance sky130_fd_sc_hd__fill_2_1041 r0 *1 0,0
Xsky130_fd_sc_hd__fill_2_1041 VGND VPWR VPWR sky130_fd_sc_hd__fill_2
* cell instance sky130_fd_sc_hd__fill_2_1042 r0 *1 0,0
Xsky130_fd_sc_hd__fill_2_1042 VGND VPWR VPWR sky130_fd_sc_hd__fill_2
* cell instance sky130_fd_sc_hd__fill_2_1043 r0 *1 0,0
Xsky130_fd_sc_hd__fill_2_1043 VGND VPWR VPWR sky130_fd_sc_hd__fill_2
* cell instance sky130_fd_sc_hd__fill_2_1044 r0 *1 0,0
Xsky130_fd_sc_hd__fill_2_1044 VGND VPWR VPWR sky130_fd_sc_hd__fill_2
* cell instance sky130_fd_sc_hd__fill_2_1045 r0 *1 0,0
Xsky130_fd_sc_hd__fill_2_1045 VGND VPWR VPWR sky130_fd_sc_hd__fill_2
* cell instance sky130_fd_sc_hd__fill_2_1046 r0 *1 0,0
Xsky130_fd_sc_hd__fill_2_1046 VGND VPWR VPWR sky130_fd_sc_hd__fill_2
* cell instance sky130_fd_sc_hd__fill_2_1047 r0 *1 0,0
Xsky130_fd_sc_hd__fill_2_1047 VGND VPWR VPWR sky130_fd_sc_hd__fill_2
* cell instance sky130_fd_sc_hd__fill_2_1048 r0 *1 0,0
Xsky130_fd_sc_hd__fill_2_1048 VGND VPWR VPWR sky130_fd_sc_hd__fill_2
* cell instance sky130_fd_sc_hd__fill_2_1049 r0 *1 0,0
Xsky130_fd_sc_hd__fill_2_1049 VGND VPWR VPWR sky130_fd_sc_hd__fill_2
* cell instance sky130_fd_sc_hd__fill_2_1050 r0 *1 0,0
Xsky130_fd_sc_hd__fill_2_1050 VGND VPWR VPWR sky130_fd_sc_hd__fill_2
* cell instance sky130_fd_sc_hd__fill_2_1051 r0 *1 0,0
Xsky130_fd_sc_hd__fill_2_1051 VGND VPWR VPWR sky130_fd_sc_hd__fill_2
* cell instance sky130_fd_sc_hd__fill_2_1052 r0 *1 0,0
Xsky130_fd_sc_hd__fill_2_1052 VGND VPWR VPWR sky130_fd_sc_hd__fill_2
* cell instance sky130_fd_sc_hd__fill_2_1053 r0 *1 0,0
Xsky130_fd_sc_hd__fill_2_1053 VGND VPWR VPWR sky130_fd_sc_hd__fill_2
* cell instance sky130_fd_sc_hd__fill_2_1054 r0 *1 0,0
Xsky130_fd_sc_hd__fill_2_1054 VGND VPWR VPWR sky130_fd_sc_hd__fill_2
* cell instance sky130_fd_sc_hd__fill_2_1055 r0 *1 0,0
Xsky130_fd_sc_hd__fill_2_1055 VGND VPWR VPWR sky130_fd_sc_hd__fill_2
* cell instance sky130_fd_sc_hd__fill_2_1056 r0 *1 0,0
Xsky130_fd_sc_hd__fill_2_1056 VGND VPWR VPWR sky130_fd_sc_hd__fill_2
* cell instance sky130_fd_sc_hd__fill_2_1057 r0 *1 0,0
Xsky130_fd_sc_hd__fill_2_1057 VGND VPWR VPWR sky130_fd_sc_hd__fill_2
* cell instance sky130_fd_sc_hd__fill_2_1058 r0 *1 0,0
Xsky130_fd_sc_hd__fill_2_1058 VGND VPWR VPWR sky130_fd_sc_hd__fill_2
* cell instance sky130_fd_sc_hd__fill_2_1059 r0 *1 0,0
Xsky130_fd_sc_hd__fill_2_1059 VGND VPWR VPWR sky130_fd_sc_hd__fill_2
* cell instance sky130_fd_sc_hd__fill_2_1060 r0 *1 0,0
Xsky130_fd_sc_hd__fill_2_1060 VGND VPWR VPWR sky130_fd_sc_hd__fill_2
* cell instance sky130_fd_sc_hd__fill_2_1061 r0 *1 0,0
Xsky130_fd_sc_hd__fill_2_1061 VGND VPWR VPWR sky130_fd_sc_hd__fill_2
* cell instance sky130_fd_sc_hd__fill_2_1062 r0 *1 0,0
Xsky130_fd_sc_hd__fill_2_1062 VGND VPWR VPWR sky130_fd_sc_hd__fill_2
* cell instance sky130_fd_sc_hd__fill_2_1063 r0 *1 0,0
Xsky130_fd_sc_hd__fill_2_1063 VGND VPWR VPWR sky130_fd_sc_hd__fill_2
* cell instance sky130_fd_sc_hd__fill_2_1064 r0 *1 0,0
Xsky130_fd_sc_hd__fill_2_1064 VGND VPWR VPWR sky130_fd_sc_hd__fill_2
* cell instance sky130_fd_sc_hd__fill_2_1065 r0 *1 0,0
Xsky130_fd_sc_hd__fill_2_1065 VGND VPWR VPWR sky130_fd_sc_hd__fill_2
* cell instance sky130_fd_sc_hd__fill_2_1066 r0 *1 0,0
Xsky130_fd_sc_hd__fill_2_1066 VGND VPWR VPWR sky130_fd_sc_hd__fill_2
* cell instance sky130_fd_sc_hd__fill_2_1067 r0 *1 0,0
Xsky130_fd_sc_hd__fill_2_1067 VGND VPWR VPWR sky130_fd_sc_hd__fill_2
* cell instance sky130_fd_sc_hd__fill_2_1068 r0 *1 0,0
Xsky130_fd_sc_hd__fill_2_1068 VGND VPWR VPWR sky130_fd_sc_hd__fill_2
* cell instance sky130_fd_sc_hd__fill_2_1069 r0 *1 0,0
Xsky130_fd_sc_hd__fill_2_1069 VGND VPWR VPWR sky130_fd_sc_hd__fill_2
* cell instance sky130_fd_sc_hd__fill_2_1070 r0 *1 0,0
Xsky130_fd_sc_hd__fill_2_1070 VGND VPWR VPWR sky130_fd_sc_hd__fill_2
* cell instance sky130_fd_sc_hd__fill_2_1071 r0 *1 0,0
Xsky130_fd_sc_hd__fill_2_1071 VGND VPWR VPWR sky130_fd_sc_hd__fill_2
* cell instance sky130_fd_sc_hd__fill_2_1072 r0 *1 0,0
Xsky130_fd_sc_hd__fill_2_1072 VGND VPWR VPWR sky130_fd_sc_hd__fill_2
* cell instance sky130_fd_sc_hd__fill_2_1073 r0 *1 0,0
Xsky130_fd_sc_hd__fill_2_1073 VGND VPWR VPWR sky130_fd_sc_hd__fill_2
* cell instance sky130_fd_sc_hd__fill_2_1074 r0 *1 0,0
Xsky130_fd_sc_hd__fill_2_1074 VGND VPWR VPWR sky130_fd_sc_hd__fill_2
* cell instance sky130_fd_sc_hd__fill_2_1075 r0 *1 0,0
Xsky130_fd_sc_hd__fill_2_1075 VGND VPWR VPWR sky130_fd_sc_hd__fill_2
* cell instance sky130_fd_sc_hd__fill_2_1076 r0 *1 0,0
Xsky130_fd_sc_hd__fill_2_1076 VGND VPWR VPWR sky130_fd_sc_hd__fill_2
* cell instance sky130_fd_sc_hd__fill_2_1077 r0 *1 0,0
Xsky130_fd_sc_hd__fill_2_1077 VGND VPWR VPWR sky130_fd_sc_hd__fill_2
* cell instance sky130_fd_sc_hd__fill_2_1078 r0 *1 0,0
Xsky130_fd_sc_hd__fill_2_1078 VGND VPWR VPWR sky130_fd_sc_hd__fill_2
* cell instance sky130_fd_sc_hd__fill_2_1079 r0 *1 0,0
Xsky130_fd_sc_hd__fill_2_1079 VGND VPWR VPWR sky130_fd_sc_hd__fill_2
* cell instance sky130_fd_sc_hd__fill_2_1080 r0 *1 0,0
Xsky130_fd_sc_hd__fill_2_1080 VGND VPWR VPWR sky130_fd_sc_hd__fill_2
* cell instance sky130_fd_sc_hd__fill_2_1081 r0 *1 0,0
Xsky130_fd_sc_hd__fill_2_1081 VGND VPWR VPWR sky130_fd_sc_hd__fill_2
* cell instance sky130_fd_sc_hd__fill_2_1082 r0 *1 0,0
Xsky130_fd_sc_hd__fill_2_1082 VGND VPWR VPWR sky130_fd_sc_hd__fill_2
* cell instance sky130_fd_sc_hd__fill_2_1083 r0 *1 0,0
Xsky130_fd_sc_hd__fill_2_1083 VGND VPWR VPWR sky130_fd_sc_hd__fill_2
* cell instance sky130_fd_sc_hd__fill_2_1084 r0 *1 0,0
Xsky130_fd_sc_hd__fill_2_1084 VGND VPWR VPWR sky130_fd_sc_hd__fill_2
* cell instance sky130_fd_sc_hd__fill_2_1085 r0 *1 0,0
Xsky130_fd_sc_hd__fill_2_1085 VGND VPWR VPWR sky130_fd_sc_hd__fill_2
* cell instance sky130_fd_sc_hd__fill_2_1086 r0 *1 0,0
Xsky130_fd_sc_hd__fill_2_1086 VGND VPWR VPWR sky130_fd_sc_hd__fill_2
* cell instance sky130_fd_sc_hd__fill_2_1087 r0 *1 0,0
Xsky130_fd_sc_hd__fill_2_1087 VGND VPWR VPWR sky130_fd_sc_hd__fill_2
* cell instance sky130_fd_sc_hd__fill_2_1088 r0 *1 0,0
Xsky130_fd_sc_hd__fill_2_1088 VGND VPWR VPWR sky130_fd_sc_hd__fill_2
* cell instance sky130_fd_sc_hd__fill_2_1089 r0 *1 0,0
Xsky130_fd_sc_hd__fill_2_1089 VGND VPWR VPWR sky130_fd_sc_hd__fill_2
* cell instance sky130_fd_sc_hd__fill_2_1090 r0 *1 0,0
Xsky130_fd_sc_hd__fill_2_1090 VGND VPWR VPWR sky130_fd_sc_hd__fill_2
* cell instance sky130_fd_sc_hd__fill_2_1091 r0 *1 0,0
Xsky130_fd_sc_hd__fill_2_1091 VGND VPWR VPWR sky130_fd_sc_hd__fill_2
* cell instance sky130_fd_sc_hd__fill_2_1092 r0 *1 0,0
Xsky130_fd_sc_hd__fill_2_1092 VGND VPWR VPWR sky130_fd_sc_hd__fill_2
* cell instance sky130_fd_sc_hd__fill_2_1093 r0 *1 0,0
Xsky130_fd_sc_hd__fill_2_1093 VGND VPWR VPWR sky130_fd_sc_hd__fill_2
* cell instance sky130_fd_sc_hd__fill_2_1094 r0 *1 0,0
Xsky130_fd_sc_hd__fill_2_1094 VGND VPWR VPWR sky130_fd_sc_hd__fill_2
* cell instance sky130_fd_sc_hd__fill_2_1095 r0 *1 0,0
Xsky130_fd_sc_hd__fill_2_1095 VGND VPWR VPWR sky130_fd_sc_hd__fill_2
* cell instance sky130_fd_sc_hd__fill_2_1096 r0 *1 0,0
Xsky130_fd_sc_hd__fill_2_1096 VGND VPWR VPWR sky130_fd_sc_hd__fill_2
* cell instance sky130_fd_sc_hd__fill_2_1097 r0 *1 0,0
Xsky130_fd_sc_hd__fill_2_1097 VGND VPWR VPWR sky130_fd_sc_hd__fill_2
* cell instance sky130_fd_sc_hd__fill_2_1098 r0 *1 0,0
Xsky130_fd_sc_hd__fill_2_1098 VGND VPWR VPWR sky130_fd_sc_hd__fill_2
* cell instance sky130_fd_sc_hd__fill_2_1099 r0 *1 0,0
Xsky130_fd_sc_hd__fill_2_1099 VGND VPWR VPWR sky130_fd_sc_hd__fill_2
* cell instance sky130_fd_sc_hd__fill_2_1100 r0 *1 0,0
Xsky130_fd_sc_hd__fill_2_1100 VGND VPWR VPWR sky130_fd_sc_hd__fill_2
* cell instance sky130_fd_sc_hd__fill_2_1101 r0 *1 0,0
Xsky130_fd_sc_hd__fill_2_1101 VGND VPWR VPWR sky130_fd_sc_hd__fill_2
* cell instance sky130_fd_sc_hd__fill_2_1102 r0 *1 0,0
Xsky130_fd_sc_hd__fill_2_1102 VGND VPWR VPWR sky130_fd_sc_hd__fill_2
* cell instance sky130_fd_sc_hd__fill_2_1103 r0 *1 0,0
Xsky130_fd_sc_hd__fill_2_1103 VGND VPWR VPWR sky130_fd_sc_hd__fill_2
* cell instance sky130_fd_sc_hd__fill_2_1104 r0 *1 0,0
Xsky130_fd_sc_hd__fill_2_1104 VGND VPWR VPWR sky130_fd_sc_hd__fill_2
* cell instance sky130_fd_sc_hd__fill_2_1105 r0 *1 0,0
Xsky130_fd_sc_hd__fill_2_1105 VGND VPWR VPWR sky130_fd_sc_hd__fill_2
* cell instance sky130_fd_sc_hd__fill_2_1106 r0 *1 0,0
Xsky130_fd_sc_hd__fill_2_1106 VGND VPWR VPWR sky130_fd_sc_hd__fill_2
* cell instance sky130_fd_sc_hd__fill_2_1107 r0 *1 0,0
Xsky130_fd_sc_hd__fill_2_1107 VGND VPWR VPWR sky130_fd_sc_hd__fill_2
* cell instance sky130_fd_sc_hd__fill_2_1108 r0 *1 0,0
Xsky130_fd_sc_hd__fill_2_1108 VGND VPWR VPWR sky130_fd_sc_hd__fill_2
* cell instance sky130_fd_sc_hd__fill_2_1109 r0 *1 0,0
Xsky130_fd_sc_hd__fill_2_1109 VGND VPWR VPWR sky130_fd_sc_hd__fill_2
* cell instance sky130_fd_sc_hd__fill_2_1110 r0 *1 0,0
Xsky130_fd_sc_hd__fill_2_1110 VGND VPWR VPWR sky130_fd_sc_hd__fill_2
* cell instance sky130_fd_sc_hd__fill_2_1111 r0 *1 0,0
Xsky130_fd_sc_hd__fill_2_1111 VGND VPWR VPWR sky130_fd_sc_hd__fill_2
* cell instance sky130_fd_sc_hd__fill_2_1112 r0 *1 0,0
Xsky130_fd_sc_hd__fill_2_1112 VGND VPWR VPWR sky130_fd_sc_hd__fill_2
* cell instance sky130_fd_sc_hd__fill_2_1113 r0 *1 0,0
Xsky130_fd_sc_hd__fill_2_1113 VGND VPWR VPWR sky130_fd_sc_hd__fill_2
* cell instance sky130_fd_sc_hd__fill_2_1114 r0 *1 0,0
Xsky130_fd_sc_hd__fill_2_1114 VGND VPWR VPWR sky130_fd_sc_hd__fill_2
* cell instance sky130_fd_sc_hd__fill_2_1115 r0 *1 0,0
Xsky130_fd_sc_hd__fill_2_1115 VGND VPWR VPWR sky130_fd_sc_hd__fill_2
* cell instance sky130_fd_sc_hd__fill_2_1116 r0 *1 0,0
Xsky130_fd_sc_hd__fill_2_1116 VGND VPWR VPWR sky130_fd_sc_hd__fill_2
* cell instance sky130_fd_sc_hd__fill_2_1117 r0 *1 0,0
Xsky130_fd_sc_hd__fill_2_1117 VGND VPWR VPWR sky130_fd_sc_hd__fill_2
* cell instance sky130_fd_sc_hd__fill_2_1118 r0 *1 0,0
Xsky130_fd_sc_hd__fill_2_1118 VGND VPWR VPWR sky130_fd_sc_hd__fill_2
* cell instance sky130_fd_sc_hd__fill_2_1119 r0 *1 0,0
Xsky130_fd_sc_hd__fill_2_1119 VGND VPWR VPWR sky130_fd_sc_hd__fill_2
* cell instance sky130_fd_sc_hd__fill_2_1120 r0 *1 0,0
Xsky130_fd_sc_hd__fill_2_1120 VGND VPWR VPWR sky130_fd_sc_hd__fill_2
* cell instance sky130_fd_sc_hd__fill_2_1121 r0 *1 0,0
Xsky130_fd_sc_hd__fill_2_1121 VGND VPWR VPWR sky130_fd_sc_hd__fill_2
* cell instance sky130_fd_sc_hd__fill_4_0 r0 *1 0,0
Xsky130_fd_sc_hd__fill_4_0 VGND VPWR VPWR sky130_fd_sc_hd__fill_4
* cell instance sky130_fd_sc_hd__fill_4_1 r0 *1 0,0
Xsky130_fd_sc_hd__fill_4_1 VGND VPWR VPWR sky130_fd_sc_hd__fill_4
* cell instance sky130_fd_sc_hd__fill_4_2 r0 *1 0,0
Xsky130_fd_sc_hd__fill_4_2 VGND VPWR VPWR sky130_fd_sc_hd__fill_4
* cell instance sky130_fd_sc_hd__fill_4_3 r0 *1 0,0
Xsky130_fd_sc_hd__fill_4_3 VGND VPWR VPWR sky130_fd_sc_hd__fill_4
* cell instance sky130_fd_sc_hd__fill_4_4 r0 *1 0,0
Xsky130_fd_sc_hd__fill_4_4 VGND VPWR VPWR sky130_fd_sc_hd__fill_4
* cell instance sky130_fd_sc_hd__fill_4_5 r0 *1 0,0
Xsky130_fd_sc_hd__fill_4_5 VGND VPWR VPWR sky130_fd_sc_hd__fill_4
* cell instance sky130_fd_sc_hd__fill_4_6 r0 *1 0,0
Xsky130_fd_sc_hd__fill_4_6 VGND VPWR VPWR sky130_fd_sc_hd__fill_4
* cell instance sky130_fd_sc_hd__fill_4_7 r0 *1 0,0
Xsky130_fd_sc_hd__fill_4_7 VGND VPWR VPWR sky130_fd_sc_hd__fill_4
* cell instance sky130_fd_sc_hd__fill_4_8 r0 *1 0,0
Xsky130_fd_sc_hd__fill_4_8 VGND VPWR VPWR sky130_fd_sc_hd__fill_4
* cell instance sky130_fd_sc_hd__fill_4_9 r0 *1 0,0
Xsky130_fd_sc_hd__fill_4_9 VGND VPWR VPWR sky130_fd_sc_hd__fill_4
* cell instance sky130_fd_sc_hd__fill_4_10 r0 *1 0,0
Xsky130_fd_sc_hd__fill_4_10 VGND VPWR VPWR sky130_fd_sc_hd__fill_4
* cell instance sky130_fd_sc_hd__fill_4_11 r0 *1 0,0
Xsky130_fd_sc_hd__fill_4_11 VGND VPWR VPWR sky130_fd_sc_hd__fill_4
* cell instance sky130_fd_sc_hd__fill_4_12 r0 *1 0,0
Xsky130_fd_sc_hd__fill_4_12 VGND VPWR VPWR sky130_fd_sc_hd__fill_4
* cell instance sky130_fd_sc_hd__fill_4_13 r0 *1 0,0
Xsky130_fd_sc_hd__fill_4_13 VGND VPWR VPWR sky130_fd_sc_hd__fill_4
* cell instance sky130_fd_sc_hd__fill_4_14 r0 *1 0,0
Xsky130_fd_sc_hd__fill_4_14 VGND VPWR VPWR sky130_fd_sc_hd__fill_4
* cell instance sky130_fd_sc_hd__fill_4_15 r0 *1 0,0
Xsky130_fd_sc_hd__fill_4_15 VGND VPWR VPWR sky130_fd_sc_hd__fill_4
* cell instance sky130_fd_sc_hd__fill_4_16 r0 *1 0,0
Xsky130_fd_sc_hd__fill_4_16 VGND VPWR VPWR sky130_fd_sc_hd__fill_4
* cell instance sky130_fd_sc_hd__fill_4_17 r0 *1 0,0
Xsky130_fd_sc_hd__fill_4_17 VGND VPWR VPWR sky130_fd_sc_hd__fill_4
* cell instance sky130_fd_sc_hd__fill_4_18 r0 *1 0,0
Xsky130_fd_sc_hd__fill_4_18 VGND VPWR VPWR sky130_fd_sc_hd__fill_4
* cell instance sky130_fd_sc_hd__fill_4_19 r0 *1 0,0
Xsky130_fd_sc_hd__fill_4_19 VGND VPWR VPWR sky130_fd_sc_hd__fill_4
* cell instance sky130_fd_sc_hd__fill_4_20 r0 *1 0,0
Xsky130_fd_sc_hd__fill_4_20 VGND VPWR VPWR sky130_fd_sc_hd__fill_4
* cell instance sky130_fd_sc_hd__fill_4_21 r0 *1 0,0
Xsky130_fd_sc_hd__fill_4_21 VGND VPWR VPWR sky130_fd_sc_hd__fill_4
* cell instance sky130_fd_sc_hd__fill_4_22 r0 *1 0,0
Xsky130_fd_sc_hd__fill_4_22 VGND VPWR VPWR sky130_fd_sc_hd__fill_4
* cell instance sky130_fd_sc_hd__fill_4_23 r0 *1 0,0
Xsky130_fd_sc_hd__fill_4_23 VGND VPWR VPWR sky130_fd_sc_hd__fill_4
* cell instance sky130_fd_sc_hd__fill_4_24 r0 *1 0,0
Xsky130_fd_sc_hd__fill_4_24 VGND VPWR VPWR sky130_fd_sc_hd__fill_4
* cell instance sky130_fd_sc_hd__fill_4_25 r0 *1 0,0
Xsky130_fd_sc_hd__fill_4_25 VGND VPWR VPWR sky130_fd_sc_hd__fill_4
* cell instance sky130_fd_sc_hd__fill_4_26 r0 *1 0,0
Xsky130_fd_sc_hd__fill_4_26 VGND VPWR VPWR sky130_fd_sc_hd__fill_4
* cell instance sky130_fd_sc_hd__fill_4_27 r0 *1 0,0
Xsky130_fd_sc_hd__fill_4_27 VGND VPWR VPWR sky130_fd_sc_hd__fill_4
* cell instance sky130_fd_sc_hd__fill_4_28 r0 *1 0,0
Xsky130_fd_sc_hd__fill_4_28 VGND VPWR VPWR sky130_fd_sc_hd__fill_4
* cell instance sky130_fd_sc_hd__fill_4_29 r0 *1 0,0
Xsky130_fd_sc_hd__fill_4_29 VGND VPWR VPWR sky130_fd_sc_hd__fill_4
* cell instance sky130_fd_sc_hd__fill_4_30 r0 *1 0,0
Xsky130_fd_sc_hd__fill_4_30 VGND VPWR VPWR sky130_fd_sc_hd__fill_4
* cell instance sky130_fd_sc_hd__fill_4_31 r0 *1 0,0
Xsky130_fd_sc_hd__fill_4_31 VGND VPWR VPWR sky130_fd_sc_hd__fill_4
* cell instance sky130_fd_sc_hd__fill_4_32 r0 *1 0,0
Xsky130_fd_sc_hd__fill_4_32 VGND VPWR VPWR sky130_fd_sc_hd__fill_4
* cell instance sky130_fd_sc_hd__fill_4_33 r0 *1 0,0
Xsky130_fd_sc_hd__fill_4_33 VGND VPWR VPWR sky130_fd_sc_hd__fill_4
* cell instance sky130_fd_sc_hd__fill_4_34 r0 *1 0,0
Xsky130_fd_sc_hd__fill_4_34 VGND VPWR VPWR sky130_fd_sc_hd__fill_4
* cell instance sky130_fd_sc_hd__fill_4_35 r0 *1 0,0
Xsky130_fd_sc_hd__fill_4_35 VGND VPWR VPWR sky130_fd_sc_hd__fill_4
* cell instance sky130_fd_sc_hd__fill_4_36 r0 *1 0,0
Xsky130_fd_sc_hd__fill_4_36 VGND VPWR VPWR sky130_fd_sc_hd__fill_4
* cell instance sky130_fd_sc_hd__fill_4_37 r0 *1 0,0
Xsky130_fd_sc_hd__fill_4_37 VGND VPWR VPWR sky130_fd_sc_hd__fill_4
* cell instance sky130_fd_sc_hd__fill_4_38 r0 *1 0,0
Xsky130_fd_sc_hd__fill_4_38 VGND VPWR VPWR sky130_fd_sc_hd__fill_4
* cell instance sky130_fd_sc_hd__fill_4_39 r0 *1 0,0
Xsky130_fd_sc_hd__fill_4_39 VGND VPWR VPWR sky130_fd_sc_hd__fill_4
* cell instance sky130_fd_sc_hd__fill_4_40 r0 *1 0,0
Xsky130_fd_sc_hd__fill_4_40 VGND VPWR VPWR sky130_fd_sc_hd__fill_4
* cell instance sky130_fd_sc_hd__fill_4_41 r0 *1 0,0
Xsky130_fd_sc_hd__fill_4_41 VGND VPWR VPWR sky130_fd_sc_hd__fill_4
* cell instance sky130_fd_sc_hd__fill_4_42 r0 *1 0,0
Xsky130_fd_sc_hd__fill_4_42 VGND VPWR VPWR sky130_fd_sc_hd__fill_4
* cell instance sky130_fd_sc_hd__fill_4_43 r0 *1 0,0
Xsky130_fd_sc_hd__fill_4_43 VGND VPWR VPWR sky130_fd_sc_hd__fill_4
* cell instance sky130_fd_sc_hd__fill_4_44 r0 *1 0,0
Xsky130_fd_sc_hd__fill_4_44 VGND VPWR VPWR sky130_fd_sc_hd__fill_4
* cell instance sky130_fd_sc_hd__fill_4_45 r0 *1 0,0
Xsky130_fd_sc_hd__fill_4_45 VGND VPWR VPWR sky130_fd_sc_hd__fill_4
* cell instance sky130_fd_sc_hd__fill_4_46 r0 *1 0,0
Xsky130_fd_sc_hd__fill_4_46 VGND VPWR VPWR sky130_fd_sc_hd__fill_4
* cell instance sky130_fd_sc_hd__fill_4_47 r0 *1 0,0
Xsky130_fd_sc_hd__fill_4_47 VGND VPWR VPWR sky130_fd_sc_hd__fill_4
* cell instance sky130_fd_sc_hd__fill_4_48 r0 *1 0,0
Xsky130_fd_sc_hd__fill_4_48 VGND VPWR VPWR sky130_fd_sc_hd__fill_4
* cell instance sky130_fd_sc_hd__fill_4_49 r0 *1 0,0
Xsky130_fd_sc_hd__fill_4_49 VGND VPWR VPWR sky130_fd_sc_hd__fill_4
* cell instance sky130_fd_sc_hd__fill_4_50 r0 *1 0,0
Xsky130_fd_sc_hd__fill_4_50 VGND VPWR VPWR sky130_fd_sc_hd__fill_4
* cell instance sky130_fd_sc_hd__fill_4_51 r0 *1 0,0
Xsky130_fd_sc_hd__fill_4_51 VGND VPWR VPWR sky130_fd_sc_hd__fill_4
* cell instance sky130_fd_sc_hd__fill_4_52 r0 *1 0,0
Xsky130_fd_sc_hd__fill_4_52 VGND VPWR VPWR sky130_fd_sc_hd__fill_4
* cell instance sky130_fd_sc_hd__fill_4_53 r0 *1 0,0
Xsky130_fd_sc_hd__fill_4_53 VGND VPWR VPWR sky130_fd_sc_hd__fill_4
* cell instance sky130_fd_sc_hd__fill_4_54 r0 *1 0,0
Xsky130_fd_sc_hd__fill_4_54 VGND VPWR VPWR sky130_fd_sc_hd__fill_4
* cell instance sky130_fd_sc_hd__fill_4_55 r0 *1 0,0
Xsky130_fd_sc_hd__fill_4_55 VGND VPWR VPWR sky130_fd_sc_hd__fill_4
* cell instance sky130_fd_sc_hd__fill_4_56 r0 *1 0,0
Xsky130_fd_sc_hd__fill_4_56 VGND VPWR VPWR sky130_fd_sc_hd__fill_4
* cell instance sky130_fd_sc_hd__fill_4_57 r0 *1 0,0
Xsky130_fd_sc_hd__fill_4_57 VGND VPWR VPWR sky130_fd_sc_hd__fill_4
* cell instance sky130_fd_sc_hd__fill_4_58 r0 *1 0,0
Xsky130_fd_sc_hd__fill_4_58 VGND VPWR VPWR sky130_fd_sc_hd__fill_4
* cell instance sky130_fd_sc_hd__fill_4_59 r0 *1 0,0
Xsky130_fd_sc_hd__fill_4_59 VGND VPWR VPWR sky130_fd_sc_hd__fill_4
* cell instance sky130_fd_sc_hd__fill_4_60 r0 *1 0,0
Xsky130_fd_sc_hd__fill_4_60 VGND VPWR VPWR sky130_fd_sc_hd__fill_4
* cell instance sky130_fd_sc_hd__fill_4_61 r0 *1 0,0
Xsky130_fd_sc_hd__fill_4_61 VGND VPWR VPWR sky130_fd_sc_hd__fill_4
* cell instance sky130_fd_sc_hd__fill_4_62 r0 *1 0,0
Xsky130_fd_sc_hd__fill_4_62 VGND VPWR VPWR sky130_fd_sc_hd__fill_4
* cell instance sky130_fd_sc_hd__fill_4_63 r0 *1 0,0
Xsky130_fd_sc_hd__fill_4_63 VGND VPWR VPWR sky130_fd_sc_hd__fill_4
* cell instance sky130_fd_sc_hd__fill_4_64 r0 *1 0,0
Xsky130_fd_sc_hd__fill_4_64 VGND VPWR VPWR sky130_fd_sc_hd__fill_4
* cell instance sky130_fd_sc_hd__fill_4_65 r0 *1 0,0
Xsky130_fd_sc_hd__fill_4_65 VGND VPWR VPWR sky130_fd_sc_hd__fill_4
* cell instance sky130_fd_sc_hd__fill_4_66 r0 *1 0,0
Xsky130_fd_sc_hd__fill_4_66 VGND VPWR VPWR sky130_fd_sc_hd__fill_4
* cell instance sky130_fd_sc_hd__fill_4_67 r0 *1 0,0
Xsky130_fd_sc_hd__fill_4_67 VGND VPWR VPWR sky130_fd_sc_hd__fill_4
* cell instance sky130_fd_sc_hd__fill_4_68 r0 *1 0,0
Xsky130_fd_sc_hd__fill_4_68 VGND VPWR VPWR sky130_fd_sc_hd__fill_4
* cell instance sky130_fd_sc_hd__fill_4_69 r0 *1 0,0
Xsky130_fd_sc_hd__fill_4_69 VGND VPWR VPWR sky130_fd_sc_hd__fill_4
* cell instance sky130_fd_sc_hd__fill_4_70 r0 *1 0,0
Xsky130_fd_sc_hd__fill_4_70 VGND VPWR VPWR sky130_fd_sc_hd__fill_4
* cell instance sky130_fd_sc_hd__fill_4_71 r0 *1 0,0
Xsky130_fd_sc_hd__fill_4_71 VGND VPWR VPWR sky130_fd_sc_hd__fill_4
* cell instance sky130_fd_sc_hd__fill_4_72 r0 *1 0,0
Xsky130_fd_sc_hd__fill_4_72 VGND VPWR VPWR sky130_fd_sc_hd__fill_4
* cell instance sky130_fd_sc_hd__fill_4_73 r0 *1 0,0
Xsky130_fd_sc_hd__fill_4_73 VGND VPWR VPWR sky130_fd_sc_hd__fill_4
* cell instance sky130_fd_sc_hd__fill_4_74 r0 *1 0,0
Xsky130_fd_sc_hd__fill_4_74 VGND VPWR VPWR sky130_fd_sc_hd__fill_4
* cell instance sky130_fd_sc_hd__fill_4_75 r0 *1 0,0
Xsky130_fd_sc_hd__fill_4_75 VGND VPWR VPWR sky130_fd_sc_hd__fill_4
* cell instance sky130_fd_sc_hd__fill_4_76 r0 *1 0,0
Xsky130_fd_sc_hd__fill_4_76 VGND VPWR VPWR sky130_fd_sc_hd__fill_4
* cell instance sky130_fd_sc_hd__fill_4_77 r0 *1 0,0
Xsky130_fd_sc_hd__fill_4_77 VGND VPWR VPWR sky130_fd_sc_hd__fill_4
* cell instance sky130_fd_sc_hd__fill_4_78 r0 *1 0,0
Xsky130_fd_sc_hd__fill_4_78 VGND VPWR VPWR sky130_fd_sc_hd__fill_4
* cell instance sky130_fd_sc_hd__fill_4_79 r0 *1 0,0
Xsky130_fd_sc_hd__fill_4_79 VGND VPWR VPWR sky130_fd_sc_hd__fill_4
* cell instance sky130_fd_sc_hd__fill_4_80 r0 *1 0,0
Xsky130_fd_sc_hd__fill_4_80 VGND VPWR VPWR sky130_fd_sc_hd__fill_4
* cell instance sky130_fd_sc_hd__fill_4_81 r0 *1 0,0
Xsky130_fd_sc_hd__fill_4_81 VGND VPWR VPWR sky130_fd_sc_hd__fill_4
* cell instance sky130_fd_sc_hd__fill_4_82 r0 *1 0,0
Xsky130_fd_sc_hd__fill_4_82 VGND VPWR VPWR sky130_fd_sc_hd__fill_4
* cell instance sky130_fd_sc_hd__fill_4_83 r0 *1 0,0
Xsky130_fd_sc_hd__fill_4_83 VGND VPWR VPWR sky130_fd_sc_hd__fill_4
* cell instance sky130_fd_sc_hd__fill_4_84 r0 *1 0,0
Xsky130_fd_sc_hd__fill_4_84 VGND VPWR VPWR sky130_fd_sc_hd__fill_4
* cell instance sky130_fd_sc_hd__fill_4_85 r0 *1 0,0
Xsky130_fd_sc_hd__fill_4_85 VGND VPWR VPWR sky130_fd_sc_hd__fill_4
* cell instance sky130_fd_sc_hd__fill_4_86 r0 *1 0,0
Xsky130_fd_sc_hd__fill_4_86 VGND VPWR VPWR sky130_fd_sc_hd__fill_4
* cell instance sky130_fd_sc_hd__fill_4_87 r0 *1 0,0
Xsky130_fd_sc_hd__fill_4_87 VGND VPWR VPWR sky130_fd_sc_hd__fill_4
* cell instance sky130_fd_sc_hd__fill_4_88 r0 *1 0,0
Xsky130_fd_sc_hd__fill_4_88 VGND VPWR VPWR sky130_fd_sc_hd__fill_4
* cell instance sky130_fd_sc_hd__fill_4_89 r0 *1 0,0
Xsky130_fd_sc_hd__fill_4_89 VGND VPWR VPWR sky130_fd_sc_hd__fill_4
* cell instance sky130_fd_sc_hd__fill_4_90 r0 *1 0,0
Xsky130_fd_sc_hd__fill_4_90 VGND VPWR VPWR sky130_fd_sc_hd__fill_4
* cell instance sky130_fd_sc_hd__fill_4_91 r0 *1 0,0
Xsky130_fd_sc_hd__fill_4_91 VGND VPWR VPWR sky130_fd_sc_hd__fill_4
* cell instance sky130_fd_sc_hd__fill_4_92 r0 *1 0,0
Xsky130_fd_sc_hd__fill_4_92 VGND VPWR VPWR sky130_fd_sc_hd__fill_4
* cell instance sky130_fd_sc_hd__fill_4_93 r0 *1 0,0
Xsky130_fd_sc_hd__fill_4_93 VGND VPWR VPWR sky130_fd_sc_hd__fill_4
* cell instance sky130_fd_sc_hd__fill_4_94 r0 *1 0,0
Xsky130_fd_sc_hd__fill_4_94 VGND VPWR VPWR sky130_fd_sc_hd__fill_4
* cell instance sky130_fd_sc_hd__fill_4_95 r0 *1 0,0
Xsky130_fd_sc_hd__fill_4_95 VGND VPWR VPWR sky130_fd_sc_hd__fill_4
* cell instance sky130_fd_sc_hd__fill_4_96 r0 *1 0,0
Xsky130_fd_sc_hd__fill_4_96 VGND VPWR VPWR sky130_fd_sc_hd__fill_4
* cell instance sky130_fd_sc_hd__fill_4_97 r0 *1 0,0
Xsky130_fd_sc_hd__fill_4_97 VGND VPWR VPWR sky130_fd_sc_hd__fill_4
* cell instance sky130_fd_sc_hd__fill_4_98 r0 *1 0,0
Xsky130_fd_sc_hd__fill_4_98 VGND VPWR VPWR sky130_fd_sc_hd__fill_4
* cell instance sky130_fd_sc_hd__fill_4_99 r0 *1 0,0
Xsky130_fd_sc_hd__fill_4_99 VGND VPWR VPWR sky130_fd_sc_hd__fill_4
* cell instance sky130_fd_sc_hd__fill_4_100 r0 *1 0,0
Xsky130_fd_sc_hd__fill_4_100 VGND VPWR VPWR sky130_fd_sc_hd__fill_4
* cell instance sky130_fd_sc_hd__fill_4_101 r0 *1 0,0
Xsky130_fd_sc_hd__fill_4_101 VGND VPWR VPWR sky130_fd_sc_hd__fill_4
* cell instance sky130_fd_sc_hd__fill_4_102 r0 *1 0,0
Xsky130_fd_sc_hd__fill_4_102 VGND VPWR VPWR sky130_fd_sc_hd__fill_4
* cell instance sky130_fd_sc_hd__fill_4_103 r0 *1 0,0
Xsky130_fd_sc_hd__fill_4_103 VGND VPWR VPWR sky130_fd_sc_hd__fill_4
* cell instance sky130_fd_sc_hd__fill_4_104 r0 *1 0,0
Xsky130_fd_sc_hd__fill_4_104 VGND VPWR VPWR sky130_fd_sc_hd__fill_4
* cell instance sky130_fd_sc_hd__fill_4_105 r0 *1 0,0
Xsky130_fd_sc_hd__fill_4_105 VGND VPWR VPWR sky130_fd_sc_hd__fill_4
* cell instance sky130_fd_sc_hd__fill_4_106 r0 *1 0,0
Xsky130_fd_sc_hd__fill_4_106 VGND VPWR VPWR sky130_fd_sc_hd__fill_4
* cell instance sky130_fd_sc_hd__fill_4_107 r0 *1 0,0
Xsky130_fd_sc_hd__fill_4_107 VGND VPWR VPWR sky130_fd_sc_hd__fill_4
* cell instance sky130_fd_sc_hd__fill_4_108 r0 *1 0,0
Xsky130_fd_sc_hd__fill_4_108 VGND VPWR VPWR sky130_fd_sc_hd__fill_4
* cell instance sky130_fd_sc_hd__fill_4_109 r0 *1 0,0
Xsky130_fd_sc_hd__fill_4_109 VGND VPWR VPWR sky130_fd_sc_hd__fill_4
* cell instance sky130_fd_sc_hd__fill_4_110 r0 *1 0,0
Xsky130_fd_sc_hd__fill_4_110 VGND VPWR VPWR sky130_fd_sc_hd__fill_4
* cell instance sky130_fd_sc_hd__fill_4_111 r0 *1 0,0
Xsky130_fd_sc_hd__fill_4_111 VGND VPWR VPWR sky130_fd_sc_hd__fill_4
* cell instance sky130_fd_sc_hd__fill_4_112 r0 *1 0,0
Xsky130_fd_sc_hd__fill_4_112 VGND VPWR VPWR sky130_fd_sc_hd__fill_4
* cell instance sky130_fd_sc_hd__fill_4_113 r0 *1 0,0
Xsky130_fd_sc_hd__fill_4_113 VGND VPWR VPWR sky130_fd_sc_hd__fill_4
* cell instance sky130_fd_sc_hd__fill_4_114 r0 *1 0,0
Xsky130_fd_sc_hd__fill_4_114 VGND VPWR VPWR sky130_fd_sc_hd__fill_4
* cell instance sky130_fd_sc_hd__fill_4_115 r0 *1 0,0
Xsky130_fd_sc_hd__fill_4_115 VGND VPWR VPWR sky130_fd_sc_hd__fill_4
* cell instance sky130_fd_sc_hd__fill_4_116 r0 *1 0,0
Xsky130_fd_sc_hd__fill_4_116 VGND VPWR VPWR sky130_fd_sc_hd__fill_4
* cell instance sky130_fd_sc_hd__fill_4_117 r0 *1 0,0
Xsky130_fd_sc_hd__fill_4_117 VGND VPWR VPWR sky130_fd_sc_hd__fill_4
* cell instance sky130_fd_sc_hd__fill_4_118 r0 *1 0,0
Xsky130_fd_sc_hd__fill_4_118 VGND VPWR VPWR sky130_fd_sc_hd__fill_4
* cell instance sky130_fd_sc_hd__fill_4_119 r0 *1 0,0
Xsky130_fd_sc_hd__fill_4_119 VGND VPWR VPWR sky130_fd_sc_hd__fill_4
* cell instance sky130_fd_sc_hd__fill_4_120 r0 *1 0,0
Xsky130_fd_sc_hd__fill_4_120 VGND VPWR VPWR sky130_fd_sc_hd__fill_4
* cell instance sky130_fd_sc_hd__fill_4_121 r0 *1 0,0
Xsky130_fd_sc_hd__fill_4_121 VGND VPWR VPWR sky130_fd_sc_hd__fill_4
* cell instance sky130_fd_sc_hd__fill_4_122 r0 *1 0,0
Xsky130_fd_sc_hd__fill_4_122 VGND VPWR VPWR sky130_fd_sc_hd__fill_4
* cell instance sky130_fd_sc_hd__fill_4_123 r0 *1 0,0
Xsky130_fd_sc_hd__fill_4_123 VGND VPWR VPWR sky130_fd_sc_hd__fill_4
* cell instance sky130_fd_sc_hd__fill_4_124 r0 *1 0,0
Xsky130_fd_sc_hd__fill_4_124 VGND VPWR VPWR sky130_fd_sc_hd__fill_4
* cell instance sky130_fd_sc_hd__fill_4_125 r0 *1 0,0
Xsky130_fd_sc_hd__fill_4_125 VGND VPWR VPWR sky130_fd_sc_hd__fill_4
* cell instance sky130_fd_sc_hd__fill_4_126 r0 *1 0,0
Xsky130_fd_sc_hd__fill_4_126 VGND VPWR VPWR sky130_fd_sc_hd__fill_4
* cell instance sky130_fd_sc_hd__fill_4_127 r0 *1 0,0
Xsky130_fd_sc_hd__fill_4_127 VGND VPWR VPWR sky130_fd_sc_hd__fill_4
* cell instance sky130_fd_sc_hd__fill_4_128 r0 *1 0,0
Xsky130_fd_sc_hd__fill_4_128 VGND VPWR VPWR sky130_fd_sc_hd__fill_4
* cell instance sky130_fd_sc_hd__fill_4_129 r0 *1 0,0
Xsky130_fd_sc_hd__fill_4_129 VGND VPWR VPWR sky130_fd_sc_hd__fill_4
* cell instance sky130_fd_sc_hd__fill_4_130 r0 *1 0,0
Xsky130_fd_sc_hd__fill_4_130 VGND VPWR VPWR sky130_fd_sc_hd__fill_4
* cell instance sky130_fd_sc_hd__fill_4_131 r0 *1 0,0
Xsky130_fd_sc_hd__fill_4_131 VGND VPWR VPWR sky130_fd_sc_hd__fill_4
* cell instance sky130_fd_sc_hd__fill_4_132 r0 *1 0,0
Xsky130_fd_sc_hd__fill_4_132 VGND VPWR VPWR sky130_fd_sc_hd__fill_4
* cell instance sky130_fd_sc_hd__fill_4_133 r0 *1 0,0
Xsky130_fd_sc_hd__fill_4_133 VGND VPWR VPWR sky130_fd_sc_hd__fill_4
* cell instance sky130_fd_sc_hd__fill_4_134 r0 *1 0,0
Xsky130_fd_sc_hd__fill_4_134 VGND VPWR VPWR sky130_fd_sc_hd__fill_4
* cell instance sky130_fd_sc_hd__fill_4_135 r0 *1 0,0
Xsky130_fd_sc_hd__fill_4_135 VGND VPWR VPWR sky130_fd_sc_hd__fill_4
* cell instance sky130_fd_sc_hd__fill_4_136 r0 *1 0,0
Xsky130_fd_sc_hd__fill_4_136 VGND VPWR VPWR sky130_fd_sc_hd__fill_4
* cell instance sky130_fd_sc_hd__fill_4_137 r0 *1 0,0
Xsky130_fd_sc_hd__fill_4_137 VGND VPWR VPWR sky130_fd_sc_hd__fill_4
* cell instance sky130_fd_sc_hd__fill_4_138 r0 *1 0,0
Xsky130_fd_sc_hd__fill_4_138 VGND VPWR VPWR sky130_fd_sc_hd__fill_4
* cell instance sky130_fd_sc_hd__fill_4_139 r0 *1 0,0
Xsky130_fd_sc_hd__fill_4_139 VGND VPWR VPWR sky130_fd_sc_hd__fill_4
* cell instance sky130_fd_sc_hd__fill_4_140 r0 *1 0,0
Xsky130_fd_sc_hd__fill_4_140 VGND VPWR VPWR sky130_fd_sc_hd__fill_4
* cell instance sky130_fd_sc_hd__fill_4_141 r0 *1 0,0
Xsky130_fd_sc_hd__fill_4_141 VGND VPWR VPWR sky130_fd_sc_hd__fill_4
* cell instance sky130_fd_sc_hd__fill_4_142 r0 *1 0,0
Xsky130_fd_sc_hd__fill_4_142 VGND VPWR VPWR sky130_fd_sc_hd__fill_4
* cell instance sky130_fd_sc_hd__fill_4_143 r0 *1 0,0
Xsky130_fd_sc_hd__fill_4_143 VGND VPWR VPWR sky130_fd_sc_hd__fill_4
* cell instance sky130_fd_sc_hd__fill_4_144 r0 *1 0,0
Xsky130_fd_sc_hd__fill_4_144 VGND VPWR VPWR sky130_fd_sc_hd__fill_4
* cell instance sky130_fd_sc_hd__fill_4_145 r0 *1 0,0
Xsky130_fd_sc_hd__fill_4_145 VGND VPWR VPWR sky130_fd_sc_hd__fill_4
* cell instance sky130_fd_sc_hd__fill_4_146 r0 *1 0,0
Xsky130_fd_sc_hd__fill_4_146 VGND VPWR VPWR sky130_fd_sc_hd__fill_4
* cell instance sky130_fd_sc_hd__fill_4_147 r0 *1 0,0
Xsky130_fd_sc_hd__fill_4_147 VGND VPWR VPWR sky130_fd_sc_hd__fill_4
* cell instance sky130_fd_sc_hd__fill_4_148 r0 *1 0,0
Xsky130_fd_sc_hd__fill_4_148 VGND VPWR VPWR sky130_fd_sc_hd__fill_4
* cell instance sky130_fd_sc_hd__fill_4_149 r0 *1 0,0
Xsky130_fd_sc_hd__fill_4_149 VGND VPWR VPWR sky130_fd_sc_hd__fill_4
* cell instance sky130_fd_sc_hd__fill_4_150 r0 *1 0,0
Xsky130_fd_sc_hd__fill_4_150 VGND VPWR VPWR sky130_fd_sc_hd__fill_4
* cell instance sky130_fd_sc_hd__fill_4_151 r0 *1 0,0
Xsky130_fd_sc_hd__fill_4_151 VGND VPWR VPWR sky130_fd_sc_hd__fill_4
* cell instance sky130_fd_sc_hd__fill_4_152 r0 *1 0,0
Xsky130_fd_sc_hd__fill_4_152 VGND VPWR VPWR sky130_fd_sc_hd__fill_4
* cell instance sky130_fd_sc_hd__fill_4_153 r0 *1 0,0
Xsky130_fd_sc_hd__fill_4_153 VGND VPWR VPWR sky130_fd_sc_hd__fill_4
* cell instance sky130_fd_sc_hd__fill_4_154 r0 *1 0,0
Xsky130_fd_sc_hd__fill_4_154 VGND VPWR VPWR sky130_fd_sc_hd__fill_4
* cell instance sky130_fd_sc_hd__fill_4_155 r0 *1 0,0
Xsky130_fd_sc_hd__fill_4_155 VGND VPWR VPWR sky130_fd_sc_hd__fill_4
* cell instance sky130_fd_sc_hd__fill_4_156 r0 *1 0,0
Xsky130_fd_sc_hd__fill_4_156 VGND VPWR VPWR sky130_fd_sc_hd__fill_4
* cell instance sky130_fd_sc_hd__fill_4_157 r0 *1 0,0
Xsky130_fd_sc_hd__fill_4_157 VGND VPWR VPWR sky130_fd_sc_hd__fill_4
* cell instance sky130_fd_sc_hd__fill_4_158 r0 *1 0,0
Xsky130_fd_sc_hd__fill_4_158 VGND VPWR VPWR sky130_fd_sc_hd__fill_4
* cell instance sky130_fd_sc_hd__fill_4_159 r0 *1 0,0
Xsky130_fd_sc_hd__fill_4_159 VGND VPWR VPWR sky130_fd_sc_hd__fill_4
* cell instance sky130_fd_sc_hd__fill_4_160 r0 *1 0,0
Xsky130_fd_sc_hd__fill_4_160 VGND VPWR VPWR sky130_fd_sc_hd__fill_4
* cell instance sky130_fd_sc_hd__fill_4_161 r0 *1 0,0
Xsky130_fd_sc_hd__fill_4_161 VGND VPWR VPWR sky130_fd_sc_hd__fill_4
* cell instance sky130_fd_sc_hd__fill_4_162 r0 *1 0,0
Xsky130_fd_sc_hd__fill_4_162 VGND VPWR VPWR sky130_fd_sc_hd__fill_4
* cell instance sky130_fd_sc_hd__fill_4_163 r0 *1 0,0
Xsky130_fd_sc_hd__fill_4_163 VGND VPWR VPWR sky130_fd_sc_hd__fill_4
* cell instance sky130_fd_sc_hd__fill_4_164 r0 *1 0,0
Xsky130_fd_sc_hd__fill_4_164 VGND VPWR VPWR sky130_fd_sc_hd__fill_4
* cell instance sky130_fd_sc_hd__fill_4_165 r0 *1 0,0
Xsky130_fd_sc_hd__fill_4_165 VGND VPWR VPWR sky130_fd_sc_hd__fill_4
* cell instance sky130_fd_sc_hd__fill_4_166 r0 *1 0,0
Xsky130_fd_sc_hd__fill_4_166 VGND VPWR VPWR sky130_fd_sc_hd__fill_4
* cell instance sky130_fd_sc_hd__fill_4_167 r0 *1 0,0
Xsky130_fd_sc_hd__fill_4_167 VGND VPWR VPWR sky130_fd_sc_hd__fill_4
* cell instance sky130_fd_sc_hd__fill_4_168 r0 *1 0,0
Xsky130_fd_sc_hd__fill_4_168 VGND VPWR VPWR sky130_fd_sc_hd__fill_4
* cell instance sky130_fd_sc_hd__fill_4_169 r0 *1 0,0
Xsky130_fd_sc_hd__fill_4_169 VGND VPWR VPWR sky130_fd_sc_hd__fill_4
* cell instance sky130_fd_sc_hd__fill_4_170 r0 *1 0,0
Xsky130_fd_sc_hd__fill_4_170 VGND VPWR VPWR sky130_fd_sc_hd__fill_4
* cell instance sky130_fd_sc_hd__fill_4_171 r0 *1 0,0
Xsky130_fd_sc_hd__fill_4_171 VGND VPWR VPWR sky130_fd_sc_hd__fill_4
* cell instance sky130_fd_sc_hd__fill_4_172 r0 *1 0,0
Xsky130_fd_sc_hd__fill_4_172 VGND VPWR VPWR sky130_fd_sc_hd__fill_4
* cell instance sky130_fd_sc_hd__fill_4_173 r0 *1 0,0
Xsky130_fd_sc_hd__fill_4_173 VGND VPWR VPWR sky130_fd_sc_hd__fill_4
* cell instance sky130_fd_sc_hd__fill_4_174 r0 *1 0,0
Xsky130_fd_sc_hd__fill_4_174 VGND VPWR VPWR sky130_fd_sc_hd__fill_4
* cell instance sky130_fd_sc_hd__fill_4_175 r0 *1 0,0
Xsky130_fd_sc_hd__fill_4_175 VGND VPWR VPWR sky130_fd_sc_hd__fill_4
* cell instance sky130_fd_sc_hd__fill_4_176 r0 *1 0,0
Xsky130_fd_sc_hd__fill_4_176 VGND VPWR VPWR sky130_fd_sc_hd__fill_4
* cell instance sky130_fd_sc_hd__fill_4_177 r0 *1 0,0
Xsky130_fd_sc_hd__fill_4_177 VGND VPWR VPWR sky130_fd_sc_hd__fill_4
* cell instance sky130_fd_sc_hd__fill_4_178 r0 *1 0,0
Xsky130_fd_sc_hd__fill_4_178 VGND VPWR VPWR sky130_fd_sc_hd__fill_4
* cell instance sky130_fd_sc_hd__fill_4_179 r0 *1 0,0
Xsky130_fd_sc_hd__fill_4_179 VGND VPWR VPWR sky130_fd_sc_hd__fill_4
* cell instance sky130_fd_sc_hd__fill_4_180 r0 *1 0,0
Xsky130_fd_sc_hd__fill_4_180 VGND VPWR VPWR sky130_fd_sc_hd__fill_4
* cell instance sky130_fd_sc_hd__fill_4_181 r0 *1 0,0
Xsky130_fd_sc_hd__fill_4_181 VGND VPWR VPWR sky130_fd_sc_hd__fill_4
* cell instance sky130_fd_sc_hd__fill_4_182 r0 *1 0,0
Xsky130_fd_sc_hd__fill_4_182 VGND VPWR VPWR sky130_fd_sc_hd__fill_4
* cell instance sky130_fd_sc_hd__fill_4_183 r0 *1 0,0
Xsky130_fd_sc_hd__fill_4_183 VGND VPWR VPWR sky130_fd_sc_hd__fill_4
* cell instance sky130_fd_sc_hd__fill_4_184 r0 *1 0,0
Xsky130_fd_sc_hd__fill_4_184 VGND VPWR VPWR sky130_fd_sc_hd__fill_4
* cell instance sky130_fd_sc_hd__fill_4_185 r0 *1 0,0
Xsky130_fd_sc_hd__fill_4_185 VGND VPWR VPWR sky130_fd_sc_hd__fill_4
* cell instance sky130_fd_sc_hd__fill_4_186 r0 *1 0,0
Xsky130_fd_sc_hd__fill_4_186 VGND VPWR VPWR sky130_fd_sc_hd__fill_4
* cell instance sky130_fd_sc_hd__fill_4_187 r0 *1 0,0
Xsky130_fd_sc_hd__fill_4_187 VGND VPWR VPWR sky130_fd_sc_hd__fill_4
* cell instance sky130_fd_sc_hd__fill_4_188 r0 *1 0,0
Xsky130_fd_sc_hd__fill_4_188 VGND VPWR VPWR sky130_fd_sc_hd__fill_4
* cell instance sky130_fd_sc_hd__fill_4_189 r0 *1 0,0
Xsky130_fd_sc_hd__fill_4_189 VGND VPWR VPWR sky130_fd_sc_hd__fill_4
* cell instance sky130_fd_sc_hd__fill_4_190 r0 *1 0,0
Xsky130_fd_sc_hd__fill_4_190 VGND VPWR VPWR sky130_fd_sc_hd__fill_4
* cell instance sky130_fd_sc_hd__fill_4_191 r0 *1 0,0
Xsky130_fd_sc_hd__fill_4_191 VGND VPWR VPWR sky130_fd_sc_hd__fill_4
* cell instance sky130_fd_sc_hd__fill_4_192 r0 *1 0,0
Xsky130_fd_sc_hd__fill_4_192 VGND VPWR VPWR sky130_fd_sc_hd__fill_4
* cell instance sky130_fd_sc_hd__fill_4_193 r0 *1 0,0
Xsky130_fd_sc_hd__fill_4_193 VGND VPWR VPWR sky130_fd_sc_hd__fill_4
* cell instance sky130_fd_sc_hd__fill_4_194 r0 *1 0,0
Xsky130_fd_sc_hd__fill_4_194 VGND VPWR VPWR sky130_fd_sc_hd__fill_4
* cell instance sky130_fd_sc_hd__fill_4_195 r0 *1 0,0
Xsky130_fd_sc_hd__fill_4_195 VGND VPWR VPWR sky130_fd_sc_hd__fill_4
* cell instance sky130_fd_sc_hd__fill_4_196 r0 *1 0,0
Xsky130_fd_sc_hd__fill_4_196 VGND VPWR VPWR sky130_fd_sc_hd__fill_4
* cell instance sky130_fd_sc_hd__fill_4_197 r0 *1 0,0
Xsky130_fd_sc_hd__fill_4_197 VGND VPWR VPWR sky130_fd_sc_hd__fill_4
* cell instance sky130_fd_sc_hd__fill_4_198 r0 *1 0,0
Xsky130_fd_sc_hd__fill_4_198 VGND VPWR VPWR sky130_fd_sc_hd__fill_4
* cell instance sky130_fd_sc_hd__fill_4_199 r0 *1 0,0
Xsky130_fd_sc_hd__fill_4_199 VGND VPWR VPWR sky130_fd_sc_hd__fill_4
* cell instance sky130_fd_sc_hd__fill_4_200 r0 *1 0,0
Xsky130_fd_sc_hd__fill_4_200 VGND VPWR VPWR sky130_fd_sc_hd__fill_4
* cell instance sky130_fd_sc_hd__fill_4_201 r0 *1 0,0
Xsky130_fd_sc_hd__fill_4_201 VGND VPWR VPWR sky130_fd_sc_hd__fill_4
* cell instance sky130_fd_sc_hd__fill_4_202 r0 *1 0,0
Xsky130_fd_sc_hd__fill_4_202 VGND VPWR VPWR sky130_fd_sc_hd__fill_4
* cell instance sky130_fd_sc_hd__fill_4_203 r0 *1 0,0
Xsky130_fd_sc_hd__fill_4_203 VGND VPWR VPWR sky130_fd_sc_hd__fill_4
* cell instance sky130_fd_sc_hd__fill_4_204 r0 *1 0,0
Xsky130_fd_sc_hd__fill_4_204 VGND VPWR VPWR sky130_fd_sc_hd__fill_4
* cell instance sky130_fd_sc_hd__fill_4_205 r0 *1 0,0
Xsky130_fd_sc_hd__fill_4_205 VGND VPWR VPWR sky130_fd_sc_hd__fill_4
* cell instance sky130_fd_sc_hd__fill_4_206 r0 *1 0,0
Xsky130_fd_sc_hd__fill_4_206 VGND VPWR VPWR sky130_fd_sc_hd__fill_4
* cell instance sky130_fd_sc_hd__fill_4_207 r0 *1 0,0
Xsky130_fd_sc_hd__fill_4_207 VGND VPWR VPWR sky130_fd_sc_hd__fill_4
* cell instance sky130_fd_sc_hd__fill_4_208 r0 *1 0,0
Xsky130_fd_sc_hd__fill_4_208 VGND VPWR VPWR sky130_fd_sc_hd__fill_4
* cell instance sky130_fd_sc_hd__fill_4_209 r0 *1 0,0
Xsky130_fd_sc_hd__fill_4_209 VGND VPWR VPWR sky130_fd_sc_hd__fill_4
* cell instance sky130_fd_sc_hd__fill_4_210 r0 *1 0,0
Xsky130_fd_sc_hd__fill_4_210 VGND VPWR VPWR sky130_fd_sc_hd__fill_4
* cell instance sky130_fd_sc_hd__fill_4_211 r0 *1 0,0
Xsky130_fd_sc_hd__fill_4_211 VGND VPWR VPWR sky130_fd_sc_hd__fill_4
* cell instance sky130_fd_sc_hd__fill_4_212 r0 *1 0,0
Xsky130_fd_sc_hd__fill_4_212 VGND VPWR VPWR sky130_fd_sc_hd__fill_4
* cell instance sky130_fd_sc_hd__fill_4_213 r0 *1 0,0
Xsky130_fd_sc_hd__fill_4_213 VGND VPWR VPWR sky130_fd_sc_hd__fill_4
* cell instance sky130_fd_sc_hd__fill_4_214 r0 *1 0,0
Xsky130_fd_sc_hd__fill_4_214 VGND VPWR VPWR sky130_fd_sc_hd__fill_4
* cell instance sky130_fd_sc_hd__fill_4_215 r0 *1 0,0
Xsky130_fd_sc_hd__fill_4_215 VGND VPWR VPWR sky130_fd_sc_hd__fill_4
* cell instance sky130_fd_sc_hd__fill_4_216 r0 *1 0,0
Xsky130_fd_sc_hd__fill_4_216 VGND VPWR VPWR sky130_fd_sc_hd__fill_4
* cell instance sky130_fd_sc_hd__fill_4_217 r0 *1 0,0
Xsky130_fd_sc_hd__fill_4_217 VGND VPWR VPWR sky130_fd_sc_hd__fill_4
* cell instance sky130_fd_sc_hd__fill_4_218 r0 *1 0,0
Xsky130_fd_sc_hd__fill_4_218 VGND VPWR VPWR sky130_fd_sc_hd__fill_4
* cell instance sky130_fd_sc_hd__fill_4_219 r0 *1 0,0
Xsky130_fd_sc_hd__fill_4_219 VGND VPWR VPWR sky130_fd_sc_hd__fill_4
* cell instance sky130_fd_sc_hd__fill_4_220 r0 *1 0,0
Xsky130_fd_sc_hd__fill_4_220 VGND VPWR VPWR sky130_fd_sc_hd__fill_4
* cell instance sky130_fd_sc_hd__fill_4_221 r0 *1 0,0
Xsky130_fd_sc_hd__fill_4_221 VGND VPWR VPWR sky130_fd_sc_hd__fill_4
* cell instance sky130_fd_sc_hd__fill_4_222 r0 *1 0,0
Xsky130_fd_sc_hd__fill_4_222 VGND VPWR VPWR sky130_fd_sc_hd__fill_4
* cell instance sky130_fd_sc_hd__fill_4_223 r0 *1 0,0
Xsky130_fd_sc_hd__fill_4_223 VGND VPWR VPWR sky130_fd_sc_hd__fill_4
* cell instance sky130_fd_sc_hd__fill_4_224 r0 *1 0,0
Xsky130_fd_sc_hd__fill_4_224 VGND VPWR VPWR sky130_fd_sc_hd__fill_4
* cell instance sky130_fd_sc_hd__fill_4_225 r0 *1 0,0
Xsky130_fd_sc_hd__fill_4_225 VGND VPWR VPWR sky130_fd_sc_hd__fill_4
* cell instance sky130_fd_sc_hd__fill_4_226 r0 *1 0,0
Xsky130_fd_sc_hd__fill_4_226 VGND VPWR VPWR sky130_fd_sc_hd__fill_4
* cell instance sky130_fd_sc_hd__fill_4_227 r0 *1 0,0
Xsky130_fd_sc_hd__fill_4_227 VGND VPWR VPWR sky130_fd_sc_hd__fill_4
* cell instance sky130_fd_sc_hd__fill_4_228 r0 *1 0,0
Xsky130_fd_sc_hd__fill_4_228 VGND VPWR VPWR sky130_fd_sc_hd__fill_4
* cell instance sky130_fd_sc_hd__fill_4_229 r0 *1 0,0
Xsky130_fd_sc_hd__fill_4_229 VGND VPWR VPWR sky130_fd_sc_hd__fill_4
* cell instance sky130_fd_sc_hd__fill_4_230 r0 *1 0,0
Xsky130_fd_sc_hd__fill_4_230 VGND VPWR VPWR sky130_fd_sc_hd__fill_4
* cell instance sky130_fd_sc_hd__fill_4_231 r0 *1 0,0
Xsky130_fd_sc_hd__fill_4_231 VGND VPWR VPWR sky130_fd_sc_hd__fill_4
* cell instance sky130_fd_sc_hd__fill_4_232 r0 *1 0,0
Xsky130_fd_sc_hd__fill_4_232 VGND VPWR VPWR sky130_fd_sc_hd__fill_4
* cell instance sky130_fd_sc_hd__fill_4_233 r0 *1 0,0
Xsky130_fd_sc_hd__fill_4_233 VGND VPWR VPWR sky130_fd_sc_hd__fill_4
* cell instance sky130_fd_sc_hd__fill_4_234 r0 *1 0,0
Xsky130_fd_sc_hd__fill_4_234 VGND VPWR VPWR sky130_fd_sc_hd__fill_4
* cell instance sky130_fd_sc_hd__fill_4_235 r0 *1 0,0
Xsky130_fd_sc_hd__fill_4_235 VGND VPWR VPWR sky130_fd_sc_hd__fill_4
* cell instance sky130_fd_sc_hd__fill_4_236 r0 *1 0,0
Xsky130_fd_sc_hd__fill_4_236 VGND VPWR VPWR sky130_fd_sc_hd__fill_4
* cell instance sky130_fd_sc_hd__fill_4_237 r0 *1 0,0
Xsky130_fd_sc_hd__fill_4_237 VGND VPWR VPWR sky130_fd_sc_hd__fill_4
* cell instance sky130_fd_sc_hd__fill_4_238 r0 *1 0,0
Xsky130_fd_sc_hd__fill_4_238 VGND VPWR VPWR sky130_fd_sc_hd__fill_4
* cell instance sky130_fd_sc_hd__fill_4_239 r0 *1 0,0
Xsky130_fd_sc_hd__fill_4_239 VGND VPWR VPWR sky130_fd_sc_hd__fill_4
* cell instance sky130_fd_sc_hd__fill_4_240 r0 *1 0,0
Xsky130_fd_sc_hd__fill_4_240 VGND VPWR VPWR sky130_fd_sc_hd__fill_4
* cell instance sky130_fd_sc_hd__fill_4_241 r0 *1 0,0
Xsky130_fd_sc_hd__fill_4_241 VGND VPWR VPWR sky130_fd_sc_hd__fill_4
* cell instance sky130_fd_sc_hd__fill_4_242 r0 *1 0,0
Xsky130_fd_sc_hd__fill_4_242 VGND VPWR VPWR sky130_fd_sc_hd__fill_4
* cell instance sky130_fd_sc_hd__fill_4_243 r0 *1 0,0
Xsky130_fd_sc_hd__fill_4_243 VGND VPWR VPWR sky130_fd_sc_hd__fill_4
* cell instance sky130_fd_sc_hd__fill_4_244 r0 *1 0,0
Xsky130_fd_sc_hd__fill_4_244 VGND VPWR VPWR sky130_fd_sc_hd__fill_4
* cell instance sky130_fd_sc_hd__fill_4_245 r0 *1 0,0
Xsky130_fd_sc_hd__fill_4_245 VGND VPWR VPWR sky130_fd_sc_hd__fill_4
* cell instance sky130_fd_sc_hd__fill_4_246 r0 *1 0,0
Xsky130_fd_sc_hd__fill_4_246 VGND VPWR VPWR sky130_fd_sc_hd__fill_4
* cell instance sky130_fd_sc_hd__fill_4_247 r0 *1 0,0
Xsky130_fd_sc_hd__fill_4_247 VGND VPWR VPWR sky130_fd_sc_hd__fill_4
* cell instance sky130_fd_sc_hd__fill_4_248 r0 *1 0,0
Xsky130_fd_sc_hd__fill_4_248 VGND VPWR VPWR sky130_fd_sc_hd__fill_4
* cell instance sky130_fd_sc_hd__fill_4_249 r0 *1 0,0
Xsky130_fd_sc_hd__fill_4_249 VGND VPWR VPWR sky130_fd_sc_hd__fill_4
* cell instance sky130_fd_sc_hd__fill_4_250 r0 *1 0,0
Xsky130_fd_sc_hd__fill_4_250 VGND VPWR VPWR sky130_fd_sc_hd__fill_4
* cell instance sky130_fd_sc_hd__fill_4_251 r0 *1 0,0
Xsky130_fd_sc_hd__fill_4_251 VGND VPWR VPWR sky130_fd_sc_hd__fill_4
* cell instance sky130_fd_sc_hd__fill_4_252 r0 *1 0,0
Xsky130_fd_sc_hd__fill_4_252 VGND VPWR VPWR sky130_fd_sc_hd__fill_4
* cell instance sky130_fd_sc_hd__fill_4_253 r0 *1 0,0
Xsky130_fd_sc_hd__fill_4_253 VGND VPWR VPWR sky130_fd_sc_hd__fill_4
* cell instance sky130_fd_sc_hd__fill_4_254 r0 *1 0,0
Xsky130_fd_sc_hd__fill_4_254 VGND VPWR VPWR sky130_fd_sc_hd__fill_4
* cell instance sky130_fd_sc_hd__fill_4_255 r0 *1 0,0
Xsky130_fd_sc_hd__fill_4_255 VGND VPWR VPWR sky130_fd_sc_hd__fill_4
* cell instance sky130_fd_sc_hd__fill_4_256 r0 *1 0,0
Xsky130_fd_sc_hd__fill_4_256 VGND VPWR VPWR sky130_fd_sc_hd__fill_4
* cell instance sky130_fd_sc_hd__fill_4_257 r0 *1 0,0
Xsky130_fd_sc_hd__fill_4_257 VGND VPWR VPWR sky130_fd_sc_hd__fill_4
* cell instance sky130_fd_sc_hd__fill_4_258 r0 *1 0,0
Xsky130_fd_sc_hd__fill_4_258 VGND VPWR VPWR sky130_fd_sc_hd__fill_4
* cell instance sky130_fd_sc_hd__fill_4_259 r0 *1 0,0
Xsky130_fd_sc_hd__fill_4_259 VGND VPWR VPWR sky130_fd_sc_hd__fill_4
* cell instance sky130_fd_sc_hd__fill_4_260 r0 *1 0,0
Xsky130_fd_sc_hd__fill_4_260 VGND VPWR VPWR sky130_fd_sc_hd__fill_4
* cell instance sky130_fd_sc_hd__fill_4_261 r0 *1 0,0
Xsky130_fd_sc_hd__fill_4_261 VGND VPWR VPWR sky130_fd_sc_hd__fill_4
* cell instance sky130_fd_sc_hd__fill_4_262 r0 *1 0,0
Xsky130_fd_sc_hd__fill_4_262 VGND VPWR VPWR sky130_fd_sc_hd__fill_4
* cell instance sky130_fd_sc_hd__fill_4_263 r0 *1 0,0
Xsky130_fd_sc_hd__fill_4_263 VGND VPWR VPWR sky130_fd_sc_hd__fill_4
* cell instance sky130_fd_sc_hd__fill_4_264 r0 *1 0,0
Xsky130_fd_sc_hd__fill_4_264 VGND VPWR VPWR sky130_fd_sc_hd__fill_4
* cell instance sky130_fd_sc_hd__fill_4_265 r0 *1 0,0
Xsky130_fd_sc_hd__fill_4_265 VGND VPWR VPWR sky130_fd_sc_hd__fill_4
* cell instance sky130_fd_sc_hd__fill_4_266 r0 *1 0,0
Xsky130_fd_sc_hd__fill_4_266 VGND VPWR VPWR sky130_fd_sc_hd__fill_4
* cell instance sky130_fd_sc_hd__fill_4_267 r0 *1 0,0
Xsky130_fd_sc_hd__fill_4_267 VGND VPWR VPWR sky130_fd_sc_hd__fill_4
* cell instance sky130_fd_sc_hd__fill_4_268 r0 *1 0,0
Xsky130_fd_sc_hd__fill_4_268 VGND VPWR VPWR sky130_fd_sc_hd__fill_4
* cell instance sky130_fd_sc_hd__fill_4_269 r0 *1 0,0
Xsky130_fd_sc_hd__fill_4_269 VGND VPWR VPWR sky130_fd_sc_hd__fill_4
* cell instance sky130_fd_sc_hd__fill_4_270 r0 *1 0,0
Xsky130_fd_sc_hd__fill_4_270 VGND VPWR VPWR sky130_fd_sc_hd__fill_4
* cell instance sky130_fd_sc_hd__fill_4_271 r0 *1 0,0
Xsky130_fd_sc_hd__fill_4_271 VGND VPWR VPWR sky130_fd_sc_hd__fill_4
* cell instance sky130_fd_sc_hd__fill_4_272 r0 *1 0,0
Xsky130_fd_sc_hd__fill_4_272 VGND VPWR VPWR sky130_fd_sc_hd__fill_4
* cell instance sky130_fd_sc_hd__fill_4_273 r0 *1 0,0
Xsky130_fd_sc_hd__fill_4_273 VGND VPWR VPWR sky130_fd_sc_hd__fill_4
* cell instance sky130_fd_sc_hd__fill_4_274 r0 *1 0,0
Xsky130_fd_sc_hd__fill_4_274 VGND VPWR VPWR sky130_fd_sc_hd__fill_4
* cell instance sky130_fd_sc_hd__fill_4_275 r0 *1 0,0
Xsky130_fd_sc_hd__fill_4_275 VGND VPWR VPWR sky130_fd_sc_hd__fill_4
* cell instance sky130_fd_sc_hd__fill_4_276 r0 *1 0,0
Xsky130_fd_sc_hd__fill_4_276 VGND VPWR VPWR sky130_fd_sc_hd__fill_4
* cell instance sky130_fd_sc_hd__fill_4_277 r0 *1 0,0
Xsky130_fd_sc_hd__fill_4_277 VGND VPWR VPWR sky130_fd_sc_hd__fill_4
* cell instance sky130_fd_sc_hd__fill_4_278 r0 *1 0,0
Xsky130_fd_sc_hd__fill_4_278 VGND VPWR VPWR sky130_fd_sc_hd__fill_4
* cell instance sky130_fd_sc_hd__fill_4_279 r0 *1 0,0
Xsky130_fd_sc_hd__fill_4_279 VGND VPWR VPWR sky130_fd_sc_hd__fill_4
* cell instance sky130_fd_sc_hd__fill_4_280 r0 *1 0,0
Xsky130_fd_sc_hd__fill_4_280 VGND VPWR VPWR sky130_fd_sc_hd__fill_4
* cell instance sky130_fd_sc_hd__fill_4_281 r0 *1 0,0
Xsky130_fd_sc_hd__fill_4_281 VGND VPWR VPWR sky130_fd_sc_hd__fill_4
* cell instance sky130_fd_sc_hd__fill_4_282 r0 *1 0,0
Xsky130_fd_sc_hd__fill_4_282 VGND VPWR VPWR sky130_fd_sc_hd__fill_4
* cell instance sky130_fd_sc_hd__fill_4_283 r0 *1 0,0
Xsky130_fd_sc_hd__fill_4_283 VGND VPWR VPWR sky130_fd_sc_hd__fill_4
* cell instance sky130_fd_sc_hd__fill_4_284 r0 *1 0,0
Xsky130_fd_sc_hd__fill_4_284 VGND VPWR VPWR sky130_fd_sc_hd__fill_4
* cell instance sky130_fd_sc_hd__fill_4_285 r0 *1 0,0
Xsky130_fd_sc_hd__fill_4_285 VGND VPWR VPWR sky130_fd_sc_hd__fill_4
* cell instance sky130_fd_sc_hd__fill_4_286 r0 *1 0,0
Xsky130_fd_sc_hd__fill_4_286 VGND VPWR VPWR sky130_fd_sc_hd__fill_4
* cell instance sky130_fd_sc_hd__fill_4_287 r0 *1 0,0
Xsky130_fd_sc_hd__fill_4_287 VGND VPWR VPWR sky130_fd_sc_hd__fill_4
* cell instance sky130_fd_sc_hd__fill_4_288 r0 *1 0,0
Xsky130_fd_sc_hd__fill_4_288 VGND VPWR VPWR sky130_fd_sc_hd__fill_4
* cell instance sky130_fd_sc_hd__fill_4_289 r0 *1 0,0
Xsky130_fd_sc_hd__fill_4_289 VGND VPWR VPWR sky130_fd_sc_hd__fill_4
* cell instance sky130_fd_sc_hd__fill_4_290 r0 *1 0,0
Xsky130_fd_sc_hd__fill_4_290 VGND VPWR VPWR sky130_fd_sc_hd__fill_4
* cell instance sky130_fd_sc_hd__fill_4_291 r0 *1 0,0
Xsky130_fd_sc_hd__fill_4_291 VGND VPWR VPWR sky130_fd_sc_hd__fill_4
* cell instance sky130_fd_sc_hd__fill_4_292 r0 *1 0,0
Xsky130_fd_sc_hd__fill_4_292 VGND VPWR VPWR sky130_fd_sc_hd__fill_4
* cell instance sky130_fd_sc_hd__fill_4_293 r0 *1 0,0
Xsky130_fd_sc_hd__fill_4_293 VGND VPWR VPWR sky130_fd_sc_hd__fill_4
* cell instance sky130_fd_sc_hd__fill_4_294 r0 *1 0,0
Xsky130_fd_sc_hd__fill_4_294 VGND VPWR VPWR sky130_fd_sc_hd__fill_4
* cell instance sky130_fd_sc_hd__fill_4_295 r0 *1 0,0
Xsky130_fd_sc_hd__fill_4_295 VGND VPWR VPWR sky130_fd_sc_hd__fill_4
* cell instance sky130_fd_sc_hd__fill_4_296 r0 *1 0,0
Xsky130_fd_sc_hd__fill_4_296 VGND VPWR VPWR sky130_fd_sc_hd__fill_4
* cell instance sky130_fd_sc_hd__fill_4_297 r0 *1 0,0
Xsky130_fd_sc_hd__fill_4_297 VGND VPWR VPWR sky130_fd_sc_hd__fill_4
* cell instance sky130_fd_sc_hd__fill_4_298 r0 *1 0,0
Xsky130_fd_sc_hd__fill_4_298 VGND VPWR VPWR sky130_fd_sc_hd__fill_4
* cell instance sky130_fd_sc_hd__fill_4_299 r0 *1 0,0
Xsky130_fd_sc_hd__fill_4_299 VGND VPWR VPWR sky130_fd_sc_hd__fill_4
* cell instance sky130_fd_sc_hd__fill_4_300 r0 *1 0,0
Xsky130_fd_sc_hd__fill_4_300 VGND VPWR VPWR sky130_fd_sc_hd__fill_4
* cell instance sky130_fd_sc_hd__fill_4_301 r0 *1 0,0
Xsky130_fd_sc_hd__fill_4_301 VGND VPWR VPWR sky130_fd_sc_hd__fill_4
* cell instance sky130_fd_sc_hd__fill_4_302 r0 *1 0,0
Xsky130_fd_sc_hd__fill_4_302 VGND VPWR VPWR sky130_fd_sc_hd__fill_4
* cell instance sky130_fd_sc_hd__fill_4_303 r0 *1 0,0
Xsky130_fd_sc_hd__fill_4_303 VGND VPWR VPWR sky130_fd_sc_hd__fill_4
* cell instance sky130_fd_sc_hd__fill_4_304 r0 *1 0,0
Xsky130_fd_sc_hd__fill_4_304 VGND VPWR VPWR sky130_fd_sc_hd__fill_4
* cell instance sky130_fd_sc_hd__fill_4_305 r0 *1 0,0
Xsky130_fd_sc_hd__fill_4_305 VGND VPWR VPWR sky130_fd_sc_hd__fill_4
* cell instance sky130_fd_sc_hd__fill_4_306 r0 *1 0,0
Xsky130_fd_sc_hd__fill_4_306 VGND VPWR VPWR sky130_fd_sc_hd__fill_4
* cell instance sky130_fd_sc_hd__fill_4_307 r0 *1 0,0
Xsky130_fd_sc_hd__fill_4_307 VGND VPWR VPWR sky130_fd_sc_hd__fill_4
* cell instance sky130_fd_sc_hd__fill_4_308 r0 *1 0,0
Xsky130_fd_sc_hd__fill_4_308 VGND VPWR VPWR sky130_fd_sc_hd__fill_4
* cell instance sky130_fd_sc_hd__fill_4_309 r0 *1 0,0
Xsky130_fd_sc_hd__fill_4_309 VGND VPWR VPWR sky130_fd_sc_hd__fill_4
* cell instance sky130_fd_sc_hd__fill_4_310 r0 *1 0,0
Xsky130_fd_sc_hd__fill_4_310 VGND VPWR VPWR sky130_fd_sc_hd__fill_4
* cell instance sky130_fd_sc_hd__fill_4_311 r0 *1 0,0
Xsky130_fd_sc_hd__fill_4_311 VGND VPWR VPWR sky130_fd_sc_hd__fill_4
* cell instance sky130_fd_sc_hd__fill_4_312 r0 *1 0,0
Xsky130_fd_sc_hd__fill_4_312 VGND VPWR VPWR sky130_fd_sc_hd__fill_4
* cell instance sky130_fd_sc_hd__fill_4_313 r0 *1 0,0
Xsky130_fd_sc_hd__fill_4_313 VGND VPWR VPWR sky130_fd_sc_hd__fill_4
* cell instance sky130_fd_sc_hd__fill_4_314 r0 *1 0,0
Xsky130_fd_sc_hd__fill_4_314 VGND VPWR VPWR sky130_fd_sc_hd__fill_4
* cell instance sky130_fd_sc_hd__fill_4_315 r0 *1 0,0
Xsky130_fd_sc_hd__fill_4_315 VGND VPWR VPWR sky130_fd_sc_hd__fill_4
* cell instance sky130_fd_sc_hd__fill_4_316 r0 *1 0,0
Xsky130_fd_sc_hd__fill_4_316 VGND VPWR VPWR sky130_fd_sc_hd__fill_4
* cell instance sky130_fd_sc_hd__fill_4_317 r0 *1 0,0
Xsky130_fd_sc_hd__fill_4_317 VGND VPWR VPWR sky130_fd_sc_hd__fill_4
* cell instance sky130_fd_sc_hd__fill_4_318 r0 *1 0,0
Xsky130_fd_sc_hd__fill_4_318 VGND VPWR VPWR sky130_fd_sc_hd__fill_4
* cell instance sky130_fd_sc_hd__fill_4_319 r0 *1 0,0
Xsky130_fd_sc_hd__fill_4_319 VGND VPWR VPWR sky130_fd_sc_hd__fill_4
* cell instance sky130_fd_sc_hd__fill_4_320 r0 *1 0,0
Xsky130_fd_sc_hd__fill_4_320 VGND VPWR VPWR sky130_fd_sc_hd__fill_4
* cell instance sky130_fd_sc_hd__fill_4_321 r0 *1 0,0
Xsky130_fd_sc_hd__fill_4_321 VGND VPWR VPWR sky130_fd_sc_hd__fill_4
* cell instance sky130_fd_sc_hd__fill_4_322 r0 *1 0,0
Xsky130_fd_sc_hd__fill_4_322 VGND VPWR VPWR sky130_fd_sc_hd__fill_4
* cell instance sky130_fd_sc_hd__fill_4_323 r0 *1 0,0
Xsky130_fd_sc_hd__fill_4_323 VGND VPWR VPWR sky130_fd_sc_hd__fill_4
* cell instance sky130_fd_sc_hd__fill_4_324 r0 *1 0,0
Xsky130_fd_sc_hd__fill_4_324 VGND VPWR VPWR sky130_fd_sc_hd__fill_4
* cell instance sky130_fd_sc_hd__fill_4_325 r0 *1 0,0
Xsky130_fd_sc_hd__fill_4_325 VGND VPWR VPWR sky130_fd_sc_hd__fill_4
* cell instance sky130_fd_sc_hd__fill_4_326 r0 *1 0,0
Xsky130_fd_sc_hd__fill_4_326 VGND VPWR VPWR sky130_fd_sc_hd__fill_4
* cell instance sky130_fd_sc_hd__fill_4_327 r0 *1 0,0
Xsky130_fd_sc_hd__fill_4_327 VGND VPWR VPWR sky130_fd_sc_hd__fill_4
* cell instance sky130_fd_sc_hd__fill_4_328 r0 *1 0,0
Xsky130_fd_sc_hd__fill_4_328 VGND VPWR VPWR sky130_fd_sc_hd__fill_4
* cell instance sky130_fd_sc_hd__fill_4_329 r0 *1 0,0
Xsky130_fd_sc_hd__fill_4_329 VGND VPWR VPWR sky130_fd_sc_hd__fill_4
* cell instance sky130_fd_sc_hd__fill_4_330 r0 *1 0,0
Xsky130_fd_sc_hd__fill_4_330 VGND VPWR VPWR sky130_fd_sc_hd__fill_4
* cell instance sky130_fd_sc_hd__fill_4_331 r0 *1 0,0
Xsky130_fd_sc_hd__fill_4_331 VGND VPWR VPWR sky130_fd_sc_hd__fill_4
* cell instance sky130_fd_sc_hd__fill_4_332 r0 *1 0,0
Xsky130_fd_sc_hd__fill_4_332 VGND VPWR VPWR sky130_fd_sc_hd__fill_4
* cell instance sky130_fd_sc_hd__fill_4_333 r0 *1 0,0
Xsky130_fd_sc_hd__fill_4_333 VGND VPWR VPWR sky130_fd_sc_hd__fill_4
* cell instance sky130_fd_sc_hd__fill_4_334 r0 *1 0,0
Xsky130_fd_sc_hd__fill_4_334 VGND VPWR VPWR sky130_fd_sc_hd__fill_4
* cell instance sky130_fd_sc_hd__fill_4_335 r0 *1 0,0
Xsky130_fd_sc_hd__fill_4_335 VGND VPWR VPWR sky130_fd_sc_hd__fill_4
* cell instance sky130_fd_sc_hd__fill_4_336 r0 *1 0,0
Xsky130_fd_sc_hd__fill_4_336 VGND VPWR VPWR sky130_fd_sc_hd__fill_4
* cell instance sky130_fd_sc_hd__fill_4_337 r0 *1 0,0
Xsky130_fd_sc_hd__fill_4_337 VGND VPWR VPWR sky130_fd_sc_hd__fill_4
* cell instance sky130_fd_sc_hd__fill_4_338 r0 *1 0,0
Xsky130_fd_sc_hd__fill_4_338 VGND VPWR VPWR sky130_fd_sc_hd__fill_4
* cell instance sky130_fd_sc_hd__fill_4_339 r0 *1 0,0
Xsky130_fd_sc_hd__fill_4_339 VGND VPWR VPWR sky130_fd_sc_hd__fill_4
* cell instance sky130_fd_sc_hd__fill_4_340 r0 *1 0,0
Xsky130_fd_sc_hd__fill_4_340 VGND VPWR VPWR sky130_fd_sc_hd__fill_4
* cell instance sky130_fd_sc_hd__fill_4_341 r0 *1 0,0
Xsky130_fd_sc_hd__fill_4_341 VGND VPWR VPWR sky130_fd_sc_hd__fill_4
* cell instance sky130_fd_sc_hd__fill_4_342 r0 *1 0,0
Xsky130_fd_sc_hd__fill_4_342 VGND VPWR VPWR sky130_fd_sc_hd__fill_4
* cell instance sky130_fd_sc_hd__fill_4_343 r0 *1 0,0
Xsky130_fd_sc_hd__fill_4_343 VGND VPWR VPWR sky130_fd_sc_hd__fill_4
* cell instance sky130_fd_sc_hd__fill_4_344 r0 *1 0,0
Xsky130_fd_sc_hd__fill_4_344 VGND VPWR VPWR sky130_fd_sc_hd__fill_4
* cell instance sky130_fd_sc_hd__fill_4_345 r0 *1 0,0
Xsky130_fd_sc_hd__fill_4_345 VGND VPWR VPWR sky130_fd_sc_hd__fill_4
* cell instance sky130_fd_sc_hd__fill_4_346 r0 *1 0,0
Xsky130_fd_sc_hd__fill_4_346 VGND VPWR VPWR sky130_fd_sc_hd__fill_4
* cell instance sky130_fd_sc_hd__fill_4_347 r0 *1 0,0
Xsky130_fd_sc_hd__fill_4_347 VGND VPWR VPWR sky130_fd_sc_hd__fill_4
* cell instance sky130_fd_sc_hd__fill_4_348 r0 *1 0,0
Xsky130_fd_sc_hd__fill_4_348 VGND VPWR VPWR sky130_fd_sc_hd__fill_4
* cell instance sky130_fd_sc_hd__fill_4_349 r0 *1 0,0
Xsky130_fd_sc_hd__fill_4_349 VGND VPWR VPWR sky130_fd_sc_hd__fill_4
* cell instance sky130_fd_sc_hd__fill_4_350 r0 *1 0,0
Xsky130_fd_sc_hd__fill_4_350 VGND VPWR VPWR sky130_fd_sc_hd__fill_4
* cell instance sky130_fd_sc_hd__fill_4_351 r0 *1 0,0
Xsky130_fd_sc_hd__fill_4_351 VGND VPWR VPWR sky130_fd_sc_hd__fill_4
* cell instance sky130_fd_sc_hd__fill_4_352 r0 *1 0,0
Xsky130_fd_sc_hd__fill_4_352 VGND VPWR VPWR sky130_fd_sc_hd__fill_4
* cell instance sky130_fd_sc_hd__fill_4_353 r0 *1 0,0
Xsky130_fd_sc_hd__fill_4_353 VGND VPWR VPWR sky130_fd_sc_hd__fill_4
* cell instance sky130_fd_sc_hd__fill_4_354 r0 *1 0,0
Xsky130_fd_sc_hd__fill_4_354 VGND VPWR VPWR sky130_fd_sc_hd__fill_4
* cell instance sky130_fd_sc_hd__fill_4_355 r0 *1 0,0
Xsky130_fd_sc_hd__fill_4_355 VGND VPWR VPWR sky130_fd_sc_hd__fill_4
* cell instance sky130_fd_sc_hd__fill_4_356 r0 *1 0,0
Xsky130_fd_sc_hd__fill_4_356 VGND VPWR VPWR sky130_fd_sc_hd__fill_4
* cell instance sky130_fd_sc_hd__fill_4_357 r0 *1 0,0
Xsky130_fd_sc_hd__fill_4_357 VGND VPWR VPWR sky130_fd_sc_hd__fill_4
* cell instance sky130_fd_sc_hd__fill_4_358 r0 *1 0,0
Xsky130_fd_sc_hd__fill_4_358 VGND VPWR VPWR sky130_fd_sc_hd__fill_4
* cell instance sky130_fd_sc_hd__fill_4_359 r0 *1 0,0
Xsky130_fd_sc_hd__fill_4_359 VGND VPWR VPWR sky130_fd_sc_hd__fill_4
* cell instance sky130_fd_sc_hd__fill_4_360 r0 *1 0,0
Xsky130_fd_sc_hd__fill_4_360 VGND VPWR VPWR sky130_fd_sc_hd__fill_4
* cell instance sky130_fd_sc_hd__fill_4_361 r0 *1 0,0
Xsky130_fd_sc_hd__fill_4_361 VGND VPWR VPWR sky130_fd_sc_hd__fill_4
* cell instance sky130_fd_sc_hd__fill_4_362 r0 *1 0,0
Xsky130_fd_sc_hd__fill_4_362 VGND VPWR VPWR sky130_fd_sc_hd__fill_4
* cell instance sky130_fd_sc_hd__fill_4_363 r0 *1 0,0
Xsky130_fd_sc_hd__fill_4_363 VGND VPWR VPWR sky130_fd_sc_hd__fill_4
* cell instance sky130_fd_sc_hd__fill_4_364 r0 *1 0,0
Xsky130_fd_sc_hd__fill_4_364 VGND VPWR VPWR sky130_fd_sc_hd__fill_4
* cell instance sky130_fd_sc_hd__fill_4_365 r0 *1 0,0
Xsky130_fd_sc_hd__fill_4_365 VGND VPWR VPWR sky130_fd_sc_hd__fill_4
* cell instance sky130_fd_sc_hd__fill_4_366 r0 *1 0,0
Xsky130_fd_sc_hd__fill_4_366 VGND VPWR VPWR sky130_fd_sc_hd__fill_4
* cell instance sky130_fd_sc_hd__fill_4_367 r0 *1 0,0
Xsky130_fd_sc_hd__fill_4_367 VGND VPWR VPWR sky130_fd_sc_hd__fill_4
* cell instance sky130_fd_sc_hd__fill_4_368 r0 *1 0,0
Xsky130_fd_sc_hd__fill_4_368 VGND VPWR VPWR sky130_fd_sc_hd__fill_4
* cell instance sky130_fd_sc_hd__fill_4_369 r0 *1 0,0
Xsky130_fd_sc_hd__fill_4_369 VGND VPWR VPWR sky130_fd_sc_hd__fill_4
* cell instance sky130_fd_sc_hd__fill_4_370 r0 *1 0,0
Xsky130_fd_sc_hd__fill_4_370 VGND VPWR VPWR sky130_fd_sc_hd__fill_4
* cell instance sky130_fd_sc_hd__fill_4_371 r0 *1 0,0
Xsky130_fd_sc_hd__fill_4_371 VGND VPWR VPWR sky130_fd_sc_hd__fill_4
* cell instance sky130_fd_sc_hd__fill_4_372 r0 *1 0,0
Xsky130_fd_sc_hd__fill_4_372 VGND VPWR VPWR sky130_fd_sc_hd__fill_4
* cell instance sky130_fd_sc_hd__fill_4_373 r0 *1 0,0
Xsky130_fd_sc_hd__fill_4_373 VGND VPWR VPWR sky130_fd_sc_hd__fill_4
* cell instance sky130_fd_sc_hd__fill_4_374 r0 *1 0,0
Xsky130_fd_sc_hd__fill_4_374 VGND VPWR VPWR sky130_fd_sc_hd__fill_4
* cell instance sky130_fd_sc_hd__fill_4_375 r0 *1 0,0
Xsky130_fd_sc_hd__fill_4_375 VGND VPWR VPWR sky130_fd_sc_hd__fill_4
* cell instance sky130_fd_sc_hd__fill_4_376 r0 *1 0,0
Xsky130_fd_sc_hd__fill_4_376 VGND VPWR VPWR sky130_fd_sc_hd__fill_4
* cell instance sky130_fd_sc_hd__fill_4_377 r0 *1 0,0
Xsky130_fd_sc_hd__fill_4_377 VGND VPWR VPWR sky130_fd_sc_hd__fill_4
* cell instance sky130_fd_sc_hd__fill_4_378 r0 *1 0,0
Xsky130_fd_sc_hd__fill_4_378 VGND VPWR VPWR sky130_fd_sc_hd__fill_4
* cell instance sky130_fd_sc_hd__fill_4_379 r0 *1 0,0
Xsky130_fd_sc_hd__fill_4_379 VGND VPWR VPWR sky130_fd_sc_hd__fill_4
* cell instance sky130_fd_sc_hd__fill_4_380 r0 *1 0,0
Xsky130_fd_sc_hd__fill_4_380 VGND VPWR VPWR sky130_fd_sc_hd__fill_4
* cell instance sky130_fd_sc_hd__fill_4_381 r0 *1 0,0
Xsky130_fd_sc_hd__fill_4_381 VGND VPWR VPWR sky130_fd_sc_hd__fill_4
* cell instance sky130_fd_sc_hd__fill_4_382 r0 *1 0,0
Xsky130_fd_sc_hd__fill_4_382 VGND VPWR VPWR sky130_fd_sc_hd__fill_4
* cell instance sky130_fd_sc_hd__fill_4_383 r0 *1 0,0
Xsky130_fd_sc_hd__fill_4_383 VGND VPWR VPWR sky130_fd_sc_hd__fill_4
* cell instance sky130_fd_sc_hd__fill_4_384 r0 *1 0,0
Xsky130_fd_sc_hd__fill_4_384 VGND VPWR VPWR sky130_fd_sc_hd__fill_4
* cell instance sky130_fd_sc_hd__fill_4_385 r0 *1 0,0
Xsky130_fd_sc_hd__fill_4_385 VGND VPWR VPWR sky130_fd_sc_hd__fill_4
* cell instance sky130_fd_sc_hd__fill_4_386 r0 *1 0,0
Xsky130_fd_sc_hd__fill_4_386 VGND VPWR VPWR sky130_fd_sc_hd__fill_4
* cell instance sky130_fd_sc_hd__fill_4_387 r0 *1 0,0
Xsky130_fd_sc_hd__fill_4_387 VGND VPWR VPWR sky130_fd_sc_hd__fill_4
* cell instance sky130_fd_sc_hd__fill_4_388 r0 *1 0,0
Xsky130_fd_sc_hd__fill_4_388 VGND VPWR VPWR sky130_fd_sc_hd__fill_4
* cell instance sky130_fd_sc_hd__fill_4_389 r0 *1 0,0
Xsky130_fd_sc_hd__fill_4_389 VGND VPWR VPWR sky130_fd_sc_hd__fill_4
* cell instance sky130_fd_sc_hd__fill_4_390 r0 *1 0,0
Xsky130_fd_sc_hd__fill_4_390 VGND VPWR VPWR sky130_fd_sc_hd__fill_4
* cell instance sky130_fd_sc_hd__fill_4_391 r0 *1 0,0
Xsky130_fd_sc_hd__fill_4_391 VGND VPWR VPWR sky130_fd_sc_hd__fill_4
* cell instance sky130_fd_sc_hd__fill_4_392 r0 *1 0,0
Xsky130_fd_sc_hd__fill_4_392 VGND VPWR VPWR sky130_fd_sc_hd__fill_4
* cell instance sky130_fd_sc_hd__fill_4_393 r0 *1 0,0
Xsky130_fd_sc_hd__fill_4_393 VGND VPWR VPWR sky130_fd_sc_hd__fill_4
* cell instance sky130_fd_sc_hd__fill_4_394 r0 *1 0,0
Xsky130_fd_sc_hd__fill_4_394 VGND VPWR VPWR sky130_fd_sc_hd__fill_4
* cell instance sky130_fd_sc_hd__fill_4_395 r0 *1 0,0
Xsky130_fd_sc_hd__fill_4_395 VGND VPWR VPWR sky130_fd_sc_hd__fill_4
* cell instance sky130_fd_sc_hd__fill_4_396 r0 *1 0,0
Xsky130_fd_sc_hd__fill_4_396 VGND VPWR VPWR sky130_fd_sc_hd__fill_4
* cell instance sky130_fd_sc_hd__fill_4_397 r0 *1 0,0
Xsky130_fd_sc_hd__fill_4_397 VGND VPWR VPWR sky130_fd_sc_hd__fill_4
* cell instance sky130_fd_sc_hd__fill_4_398 r0 *1 0,0
Xsky130_fd_sc_hd__fill_4_398 VGND VPWR VPWR sky130_fd_sc_hd__fill_4
* cell instance sky130_fd_sc_hd__fill_4_399 r0 *1 0,0
Xsky130_fd_sc_hd__fill_4_399 VGND VPWR VPWR sky130_fd_sc_hd__fill_4
* cell instance sky130_fd_sc_hd__fill_4_400 r0 *1 0,0
Xsky130_fd_sc_hd__fill_4_400 VGND VPWR VPWR sky130_fd_sc_hd__fill_4
* cell instance sky130_fd_sc_hd__fill_4_401 r0 *1 0,0
Xsky130_fd_sc_hd__fill_4_401 VGND VPWR VPWR sky130_fd_sc_hd__fill_4
* cell instance sky130_fd_sc_hd__fill_4_402 r0 *1 0,0
Xsky130_fd_sc_hd__fill_4_402 VGND VPWR VPWR sky130_fd_sc_hd__fill_4
* cell instance sky130_fd_sc_hd__fill_4_403 r0 *1 0,0
Xsky130_fd_sc_hd__fill_4_403 VGND VPWR VPWR sky130_fd_sc_hd__fill_4
* cell instance sky130_fd_sc_hd__fill_4_404 r0 *1 0,0
Xsky130_fd_sc_hd__fill_4_404 VGND VPWR VPWR sky130_fd_sc_hd__fill_4
* cell instance sky130_fd_sc_hd__fill_4_405 r0 *1 0,0
Xsky130_fd_sc_hd__fill_4_405 VGND VPWR VPWR sky130_fd_sc_hd__fill_4
* cell instance sky130_fd_sc_hd__fill_4_406 r0 *1 0,0
Xsky130_fd_sc_hd__fill_4_406 VGND VPWR VPWR sky130_fd_sc_hd__fill_4
* cell instance sky130_fd_sc_hd__fill_4_407 r0 *1 0,0
Xsky130_fd_sc_hd__fill_4_407 VGND VPWR VPWR sky130_fd_sc_hd__fill_4
* cell instance sky130_fd_sc_hd__fill_4_408 r0 *1 0,0
Xsky130_fd_sc_hd__fill_4_408 VGND VPWR VPWR sky130_fd_sc_hd__fill_4
* cell instance sky130_fd_sc_hd__fill_4_409 r0 *1 0,0
Xsky130_fd_sc_hd__fill_4_409 VGND VPWR VPWR sky130_fd_sc_hd__fill_4
* cell instance sky130_fd_sc_hd__fill_4_410 r0 *1 0,0
Xsky130_fd_sc_hd__fill_4_410 VGND VPWR VPWR sky130_fd_sc_hd__fill_4
* cell instance sky130_fd_sc_hd__fill_4_411 r0 *1 0,0
Xsky130_fd_sc_hd__fill_4_411 VGND VPWR VPWR sky130_fd_sc_hd__fill_4
* cell instance sky130_fd_sc_hd__fill_4_412 r0 *1 0,0
Xsky130_fd_sc_hd__fill_4_412 VGND VPWR VPWR sky130_fd_sc_hd__fill_4
* cell instance sky130_fd_sc_hd__fill_4_413 r0 *1 0,0
Xsky130_fd_sc_hd__fill_4_413 VGND VPWR VPWR sky130_fd_sc_hd__fill_4
* cell instance sky130_fd_sc_hd__fill_4_414 r0 *1 0,0
Xsky130_fd_sc_hd__fill_4_414 VGND VPWR VPWR sky130_fd_sc_hd__fill_4
* cell instance sky130_fd_sc_hd__fill_4_415 r0 *1 0,0
Xsky130_fd_sc_hd__fill_4_415 VGND VPWR VPWR sky130_fd_sc_hd__fill_4
* cell instance sky130_fd_sc_hd__fill_4_416 r0 *1 0,0
Xsky130_fd_sc_hd__fill_4_416 VGND VPWR VPWR sky130_fd_sc_hd__fill_4
* cell instance sky130_fd_sc_hd__fill_4_417 r0 *1 0,0
Xsky130_fd_sc_hd__fill_4_417 VGND VPWR VPWR sky130_fd_sc_hd__fill_4
* cell instance sky130_fd_sc_hd__fill_4_418 r0 *1 0,0
Xsky130_fd_sc_hd__fill_4_418 VGND VPWR VPWR sky130_fd_sc_hd__fill_4
* cell instance sky130_fd_sc_hd__fill_4_419 r0 *1 0,0
Xsky130_fd_sc_hd__fill_4_419 VGND VPWR VPWR sky130_fd_sc_hd__fill_4
* cell instance sky130_fd_sc_hd__fill_4_420 r0 *1 0,0
Xsky130_fd_sc_hd__fill_4_420 VGND VPWR VPWR sky130_fd_sc_hd__fill_4
* cell instance sky130_fd_sc_hd__fill_4_421 r0 *1 0,0
Xsky130_fd_sc_hd__fill_4_421 VGND VPWR VPWR sky130_fd_sc_hd__fill_4
* cell instance sky130_fd_sc_hd__fill_4_422 r0 *1 0,0
Xsky130_fd_sc_hd__fill_4_422 VGND VPWR VPWR sky130_fd_sc_hd__fill_4
* cell instance sky130_fd_sc_hd__fill_4_423 r0 *1 0,0
Xsky130_fd_sc_hd__fill_4_423 VGND VPWR VPWR sky130_fd_sc_hd__fill_4
* cell instance sky130_fd_sc_hd__fill_4_424 r0 *1 0,0
Xsky130_fd_sc_hd__fill_4_424 VGND VPWR VPWR sky130_fd_sc_hd__fill_4
* cell instance sky130_fd_sc_hd__fill_4_425 r0 *1 0,0
Xsky130_fd_sc_hd__fill_4_425 VGND VPWR VPWR sky130_fd_sc_hd__fill_4
* cell instance sky130_fd_sc_hd__fill_4_426 r0 *1 0,0
Xsky130_fd_sc_hd__fill_4_426 VGND VPWR VPWR sky130_fd_sc_hd__fill_4
* cell instance sky130_fd_sc_hd__fill_4_427 r0 *1 0,0
Xsky130_fd_sc_hd__fill_4_427 VGND VPWR VPWR sky130_fd_sc_hd__fill_4
* cell instance sky130_fd_sc_hd__fill_4_428 r0 *1 0,0
Xsky130_fd_sc_hd__fill_4_428 VGND VPWR VPWR sky130_fd_sc_hd__fill_4
* cell instance sky130_fd_sc_hd__fill_4_429 r0 *1 0,0
Xsky130_fd_sc_hd__fill_4_429 VGND VPWR VPWR sky130_fd_sc_hd__fill_4
* cell instance sky130_fd_sc_hd__fill_4_430 r0 *1 0,0
Xsky130_fd_sc_hd__fill_4_430 VGND VPWR VPWR sky130_fd_sc_hd__fill_4
* cell instance sky130_fd_sc_hd__fill_4_431 r0 *1 0,0
Xsky130_fd_sc_hd__fill_4_431 VGND VPWR VPWR sky130_fd_sc_hd__fill_4
* cell instance sky130_fd_sc_hd__fill_4_432 r0 *1 0,0
Xsky130_fd_sc_hd__fill_4_432 VGND VPWR VPWR sky130_fd_sc_hd__fill_4
* cell instance sky130_fd_sc_hd__fill_4_433 r0 *1 0,0
Xsky130_fd_sc_hd__fill_4_433 VGND VPWR VPWR sky130_fd_sc_hd__fill_4
* cell instance sky130_fd_sc_hd__fill_4_434 r0 *1 0,0
Xsky130_fd_sc_hd__fill_4_434 VGND VPWR VPWR sky130_fd_sc_hd__fill_4
* cell instance sky130_fd_sc_hd__fill_4_435 r0 *1 0,0
Xsky130_fd_sc_hd__fill_4_435 VGND VPWR VPWR sky130_fd_sc_hd__fill_4
* cell instance sky130_fd_sc_hd__fill_4_436 r0 *1 0,0
Xsky130_fd_sc_hd__fill_4_436 VGND VPWR VPWR sky130_fd_sc_hd__fill_4
* cell instance sky130_fd_sc_hd__fill_4_437 r0 *1 0,0
Xsky130_fd_sc_hd__fill_4_437 VGND VPWR VPWR sky130_fd_sc_hd__fill_4
* cell instance sky130_fd_sc_hd__fill_4_438 r0 *1 0,0
Xsky130_fd_sc_hd__fill_4_438 VGND VPWR VPWR sky130_fd_sc_hd__fill_4
* cell instance sky130_fd_sc_hd__fill_4_439 r0 *1 0,0
Xsky130_fd_sc_hd__fill_4_439 VGND VPWR VPWR sky130_fd_sc_hd__fill_4
* cell instance sky130_fd_sc_hd__fill_4_440 r0 *1 0,0
Xsky130_fd_sc_hd__fill_4_440 VGND VPWR VPWR sky130_fd_sc_hd__fill_4
* cell instance sky130_fd_sc_hd__fill_4_441 r0 *1 0,0
Xsky130_fd_sc_hd__fill_4_441 VGND VPWR VPWR sky130_fd_sc_hd__fill_4
* cell instance sky130_fd_sc_hd__fill_4_442 r0 *1 0,0
Xsky130_fd_sc_hd__fill_4_442 VGND VPWR VPWR sky130_fd_sc_hd__fill_4
* cell instance sky130_fd_sc_hd__fill_4_443 r0 *1 0,0
Xsky130_fd_sc_hd__fill_4_443 VGND VPWR VPWR sky130_fd_sc_hd__fill_4
* cell instance sky130_fd_sc_hd__fill_4_444 r0 *1 0,0
Xsky130_fd_sc_hd__fill_4_444 VGND VPWR VPWR sky130_fd_sc_hd__fill_4
* cell instance sky130_fd_sc_hd__fill_4_445 r0 *1 0,0
Xsky130_fd_sc_hd__fill_4_445 VGND VPWR VPWR sky130_fd_sc_hd__fill_4
* cell instance sky130_fd_sc_hd__fill_4_446 r0 *1 0,0
Xsky130_fd_sc_hd__fill_4_446 VGND VPWR VPWR sky130_fd_sc_hd__fill_4
* cell instance sky130_fd_sc_hd__fill_4_447 r0 *1 0,0
Xsky130_fd_sc_hd__fill_4_447 VGND VPWR VPWR sky130_fd_sc_hd__fill_4
* cell instance sky130_fd_sc_hd__fill_4_448 r0 *1 0,0
Xsky130_fd_sc_hd__fill_4_448 VGND VPWR VPWR sky130_fd_sc_hd__fill_4
* cell instance sky130_fd_sc_hd__fill_4_449 r0 *1 0,0
Xsky130_fd_sc_hd__fill_4_449 VGND VPWR VPWR sky130_fd_sc_hd__fill_4
* cell instance sky130_fd_sc_hd__fill_4_450 r0 *1 0,0
Xsky130_fd_sc_hd__fill_4_450 VGND VPWR VPWR sky130_fd_sc_hd__fill_4
* cell instance sky130_fd_sc_hd__fill_4_451 r0 *1 0,0
Xsky130_fd_sc_hd__fill_4_451 VGND VPWR VPWR sky130_fd_sc_hd__fill_4
* cell instance sky130_fd_sc_hd__fill_4_452 r0 *1 0,0
Xsky130_fd_sc_hd__fill_4_452 VGND VPWR VPWR sky130_fd_sc_hd__fill_4
* cell instance sky130_fd_sc_hd__fill_4_453 r0 *1 0,0
Xsky130_fd_sc_hd__fill_4_453 VGND VPWR VPWR sky130_fd_sc_hd__fill_4
* cell instance sky130_fd_sc_hd__fill_4_454 r0 *1 0,0
Xsky130_fd_sc_hd__fill_4_454 VGND VPWR VPWR sky130_fd_sc_hd__fill_4
* cell instance sky130_fd_sc_hd__fill_4_455 r0 *1 0,0
Xsky130_fd_sc_hd__fill_4_455 VGND VPWR VPWR sky130_fd_sc_hd__fill_4
* cell instance sky130_fd_sc_hd__fill_4_456 r0 *1 0,0
Xsky130_fd_sc_hd__fill_4_456 VGND VPWR VPWR sky130_fd_sc_hd__fill_4
* cell instance sky130_fd_sc_hd__fill_4_457 r0 *1 0,0
Xsky130_fd_sc_hd__fill_4_457 VGND VPWR VPWR sky130_fd_sc_hd__fill_4
* cell instance sky130_fd_sc_hd__fill_4_458 r0 *1 0,0
Xsky130_fd_sc_hd__fill_4_458 VGND VPWR VPWR sky130_fd_sc_hd__fill_4
* cell instance sky130_fd_sc_hd__fill_4_459 r0 *1 0,0
Xsky130_fd_sc_hd__fill_4_459 VGND VPWR VPWR sky130_fd_sc_hd__fill_4
* cell instance sky130_fd_sc_hd__fill_4_460 r0 *1 0,0
Xsky130_fd_sc_hd__fill_4_460 VGND VPWR VPWR sky130_fd_sc_hd__fill_4
* cell instance sky130_fd_sc_hd__fill_4_461 r0 *1 0,0
Xsky130_fd_sc_hd__fill_4_461 VGND VPWR VPWR sky130_fd_sc_hd__fill_4
* cell instance sky130_fd_sc_hd__fill_4_462 r0 *1 0,0
Xsky130_fd_sc_hd__fill_4_462 VGND VPWR VPWR sky130_fd_sc_hd__fill_4
* cell instance sky130_fd_sc_hd__fill_4_463 r0 *1 0,0
Xsky130_fd_sc_hd__fill_4_463 VGND VPWR VPWR sky130_fd_sc_hd__fill_4
* cell instance sky130_fd_sc_hd__fill_4_464 r0 *1 0,0
Xsky130_fd_sc_hd__fill_4_464 VGND VPWR VPWR sky130_fd_sc_hd__fill_4
* cell instance sky130_fd_sc_hd__fill_4_465 r0 *1 0,0
Xsky130_fd_sc_hd__fill_4_465 VGND VPWR VPWR sky130_fd_sc_hd__fill_4
* cell instance sky130_fd_sc_hd__fill_4_466 r0 *1 0,0
Xsky130_fd_sc_hd__fill_4_466 VGND VPWR VPWR sky130_fd_sc_hd__fill_4
* cell instance sky130_fd_sc_hd__fill_4_467 r0 *1 0,0
Xsky130_fd_sc_hd__fill_4_467 VGND VPWR VPWR sky130_fd_sc_hd__fill_4
* cell instance sky130_fd_sc_hd__fill_4_468 r0 *1 0,0
Xsky130_fd_sc_hd__fill_4_468 VGND VPWR VPWR sky130_fd_sc_hd__fill_4
* cell instance sky130_fd_sc_hd__fill_4_469 r0 *1 0,0
Xsky130_fd_sc_hd__fill_4_469 VGND VPWR VPWR sky130_fd_sc_hd__fill_4
* cell instance sky130_fd_sc_hd__fill_4_470 r0 *1 0,0
Xsky130_fd_sc_hd__fill_4_470 VGND VPWR VPWR sky130_fd_sc_hd__fill_4
* cell instance sky130_fd_sc_hd__fill_4_471 r0 *1 0,0
Xsky130_fd_sc_hd__fill_4_471 VGND VPWR VPWR sky130_fd_sc_hd__fill_4
* cell instance sky130_fd_sc_hd__fill_4_472 r0 *1 0,0
Xsky130_fd_sc_hd__fill_4_472 VGND VPWR VPWR sky130_fd_sc_hd__fill_4
* cell instance sky130_fd_sc_hd__fill_4_473 r0 *1 0,0
Xsky130_fd_sc_hd__fill_4_473 VGND VPWR VPWR sky130_fd_sc_hd__fill_4
* cell instance sky130_fd_sc_hd__fill_4_474 r0 *1 0,0
Xsky130_fd_sc_hd__fill_4_474 VGND VPWR VPWR sky130_fd_sc_hd__fill_4
* cell instance sky130_fd_sc_hd__fill_4_475 r0 *1 0,0
Xsky130_fd_sc_hd__fill_4_475 VGND VPWR VPWR sky130_fd_sc_hd__fill_4
* cell instance sky130_fd_sc_hd__fill_4_476 r0 *1 0,0
Xsky130_fd_sc_hd__fill_4_476 VGND VPWR VPWR sky130_fd_sc_hd__fill_4
* cell instance sky130_fd_sc_hd__fill_4_477 r0 *1 0,0
Xsky130_fd_sc_hd__fill_4_477 VGND VPWR VPWR sky130_fd_sc_hd__fill_4
* cell instance sky130_fd_sc_hd__fill_4_478 r0 *1 0,0
Xsky130_fd_sc_hd__fill_4_478 VGND VPWR VPWR sky130_fd_sc_hd__fill_4
* cell instance sky130_fd_sc_hd__fill_4_479 r0 *1 0,0
Xsky130_fd_sc_hd__fill_4_479 VGND VPWR VPWR sky130_fd_sc_hd__fill_4
* cell instance sky130_fd_sc_hd__fill_4_480 r0 *1 0,0
Xsky130_fd_sc_hd__fill_4_480 VGND VPWR VPWR sky130_fd_sc_hd__fill_4
* cell instance sky130_fd_sc_hd__fill_4_481 r0 *1 0,0
Xsky130_fd_sc_hd__fill_4_481 VGND VPWR VPWR sky130_fd_sc_hd__fill_4
* cell instance sky130_fd_sc_hd__fill_4_482 r0 *1 0,0
Xsky130_fd_sc_hd__fill_4_482 VGND VPWR VPWR sky130_fd_sc_hd__fill_4
* cell instance sky130_fd_sc_hd__fill_4_483 r0 *1 0,0
Xsky130_fd_sc_hd__fill_4_483 VGND VPWR VPWR sky130_fd_sc_hd__fill_4
* cell instance sky130_fd_sc_hd__fill_4_484 r0 *1 0,0
Xsky130_fd_sc_hd__fill_4_484 VGND VPWR VPWR sky130_fd_sc_hd__fill_4
* cell instance sky130_fd_sc_hd__fill_4_485 r0 *1 0,0
Xsky130_fd_sc_hd__fill_4_485 VGND VPWR VPWR sky130_fd_sc_hd__fill_4
* cell instance sky130_fd_sc_hd__fill_4_486 r0 *1 0,0
Xsky130_fd_sc_hd__fill_4_486 VGND VPWR VPWR sky130_fd_sc_hd__fill_4
* cell instance sky130_fd_sc_hd__fill_4_487 r0 *1 0,0
Xsky130_fd_sc_hd__fill_4_487 VGND VPWR VPWR sky130_fd_sc_hd__fill_4
* cell instance sky130_fd_sc_hd__fill_4_488 r0 *1 0,0
Xsky130_fd_sc_hd__fill_4_488 VGND VPWR VPWR sky130_fd_sc_hd__fill_4
* cell instance sky130_fd_sc_hd__fill_4_489 r0 *1 0,0
Xsky130_fd_sc_hd__fill_4_489 VGND VPWR VPWR sky130_fd_sc_hd__fill_4
* cell instance sky130_fd_sc_hd__fill_4_490 r0 *1 0,0
Xsky130_fd_sc_hd__fill_4_490 VGND VPWR VPWR sky130_fd_sc_hd__fill_4
* cell instance sky130_fd_sc_hd__fill_4_491 r0 *1 0,0
Xsky130_fd_sc_hd__fill_4_491 VGND VPWR VPWR sky130_fd_sc_hd__fill_4
* cell instance sky130_fd_sc_hd__fill_4_492 r0 *1 0,0
Xsky130_fd_sc_hd__fill_4_492 VGND VPWR VPWR sky130_fd_sc_hd__fill_4
* cell instance sky130_fd_sc_hd__fill_4_493 r0 *1 0,0
Xsky130_fd_sc_hd__fill_4_493 VGND VPWR VPWR sky130_fd_sc_hd__fill_4
* cell instance sky130_fd_sc_hd__fill_4_494 r0 *1 0,0
Xsky130_fd_sc_hd__fill_4_494 VGND VPWR VPWR sky130_fd_sc_hd__fill_4
* cell instance sky130_fd_sc_hd__fill_4_495 r0 *1 0,0
Xsky130_fd_sc_hd__fill_4_495 VGND VPWR VPWR sky130_fd_sc_hd__fill_4
* cell instance sky130_fd_sc_hd__fill_4_496 r0 *1 0,0
Xsky130_fd_sc_hd__fill_4_496 VGND VPWR VPWR sky130_fd_sc_hd__fill_4
* cell instance sky130_fd_sc_hd__fill_4_497 r0 *1 0,0
Xsky130_fd_sc_hd__fill_4_497 VGND VPWR VPWR sky130_fd_sc_hd__fill_4
* cell instance sky130_fd_sc_hd__fill_4_498 r0 *1 0,0
Xsky130_fd_sc_hd__fill_4_498 VGND VPWR VPWR sky130_fd_sc_hd__fill_4
* cell instance sky130_fd_sc_hd__fill_4_499 r0 *1 0,0
Xsky130_fd_sc_hd__fill_4_499 VGND VPWR VPWR sky130_fd_sc_hd__fill_4
* cell instance sky130_fd_sc_hd__fill_4_500 r0 *1 0,0
Xsky130_fd_sc_hd__fill_4_500 VGND VPWR VPWR sky130_fd_sc_hd__fill_4
* cell instance sky130_fd_sc_hd__fill_4_501 r0 *1 0,0
Xsky130_fd_sc_hd__fill_4_501 VGND VPWR VPWR sky130_fd_sc_hd__fill_4
* cell instance sky130_fd_sc_hd__fill_4_502 r0 *1 0,0
Xsky130_fd_sc_hd__fill_4_502 VGND VPWR VPWR sky130_fd_sc_hd__fill_4
* cell instance sky130_fd_sc_hd__fill_4_503 r0 *1 0,0
Xsky130_fd_sc_hd__fill_4_503 VGND VPWR VPWR sky130_fd_sc_hd__fill_4
* cell instance sky130_fd_sc_hd__fill_4_504 r0 *1 0,0
Xsky130_fd_sc_hd__fill_4_504 VGND VPWR VPWR sky130_fd_sc_hd__fill_4
* cell instance sky130_fd_sc_hd__fill_4_505 r0 *1 0,0
Xsky130_fd_sc_hd__fill_4_505 VGND VPWR VPWR sky130_fd_sc_hd__fill_4
* cell instance sky130_fd_sc_hd__fill_4_506 r0 *1 0,0
Xsky130_fd_sc_hd__fill_4_506 VGND VPWR VPWR sky130_fd_sc_hd__fill_4
* cell instance sky130_fd_sc_hd__fill_4_507 r0 *1 0,0
Xsky130_fd_sc_hd__fill_4_507 VGND VPWR VPWR sky130_fd_sc_hd__fill_4
* cell instance sky130_fd_sc_hd__fill_4_508 r0 *1 0,0
Xsky130_fd_sc_hd__fill_4_508 VGND VPWR VPWR sky130_fd_sc_hd__fill_4
* cell instance sky130_fd_sc_hd__fill_4_509 r0 *1 0,0
Xsky130_fd_sc_hd__fill_4_509 VGND VPWR VPWR sky130_fd_sc_hd__fill_4
* cell instance sky130_fd_sc_hd__fill_4_510 r0 *1 0,0
Xsky130_fd_sc_hd__fill_4_510 VGND VPWR VPWR sky130_fd_sc_hd__fill_4
* cell instance sky130_fd_sc_hd__fill_4_511 r0 *1 0,0
Xsky130_fd_sc_hd__fill_4_511 VGND VPWR VPWR sky130_fd_sc_hd__fill_4
* cell instance sky130_fd_sc_hd__fill_4_512 r0 *1 0,0
Xsky130_fd_sc_hd__fill_4_512 VGND VPWR VPWR sky130_fd_sc_hd__fill_4
* cell instance sky130_fd_sc_hd__fill_4_513 r0 *1 0,0
Xsky130_fd_sc_hd__fill_4_513 VGND VPWR VPWR sky130_fd_sc_hd__fill_4
* cell instance sky130_fd_sc_hd__fill_4_514 r0 *1 0,0
Xsky130_fd_sc_hd__fill_4_514 VGND VPWR VPWR sky130_fd_sc_hd__fill_4
* cell instance sky130_fd_sc_hd__fill_4_515 r0 *1 0,0
Xsky130_fd_sc_hd__fill_4_515 VGND VPWR VPWR sky130_fd_sc_hd__fill_4
* cell instance sky130_fd_sc_hd__fill_4_516 r0 *1 0,0
Xsky130_fd_sc_hd__fill_4_516 VGND VPWR VPWR sky130_fd_sc_hd__fill_4
* cell instance sky130_fd_sc_hd__fill_4_517 r0 *1 0,0
Xsky130_fd_sc_hd__fill_4_517 VGND VPWR VPWR sky130_fd_sc_hd__fill_4
* cell instance sky130_fd_sc_hd__fill_4_518 r0 *1 0,0
Xsky130_fd_sc_hd__fill_4_518 VGND VPWR VPWR sky130_fd_sc_hd__fill_4
* cell instance sky130_fd_sc_hd__fill_4_519 r0 *1 0,0
Xsky130_fd_sc_hd__fill_4_519 VGND VPWR VPWR sky130_fd_sc_hd__fill_4
* cell instance sky130_fd_sc_hd__fill_4_520 r0 *1 0,0
Xsky130_fd_sc_hd__fill_4_520 VGND VPWR VPWR sky130_fd_sc_hd__fill_4
* cell instance sky130_fd_sc_hd__fill_4_521 r0 *1 0,0
Xsky130_fd_sc_hd__fill_4_521 VGND VPWR VPWR sky130_fd_sc_hd__fill_4
* cell instance sky130_fd_sc_hd__fill_4_522 r0 *1 0,0
Xsky130_fd_sc_hd__fill_4_522 VGND VPWR VPWR sky130_fd_sc_hd__fill_4
* cell instance sky130_fd_sc_hd__fill_4_523 r0 *1 0,0
Xsky130_fd_sc_hd__fill_4_523 VGND VPWR VPWR sky130_fd_sc_hd__fill_4
* cell instance sky130_fd_sc_hd__fill_4_524 r0 *1 0,0
Xsky130_fd_sc_hd__fill_4_524 VGND VPWR VPWR sky130_fd_sc_hd__fill_4
* cell instance sky130_fd_sc_hd__fill_4_525 r0 *1 0,0
Xsky130_fd_sc_hd__fill_4_525 VGND VPWR VPWR sky130_fd_sc_hd__fill_4
* cell instance sky130_fd_sc_hd__fill_4_526 r0 *1 0,0
Xsky130_fd_sc_hd__fill_4_526 VGND VPWR VPWR sky130_fd_sc_hd__fill_4
* cell instance sky130_fd_sc_hd__fill_4_527 r0 *1 0,0
Xsky130_fd_sc_hd__fill_4_527 VGND VPWR VPWR sky130_fd_sc_hd__fill_4
* cell instance sky130_fd_sc_hd__fill_4_528 r0 *1 0,0
Xsky130_fd_sc_hd__fill_4_528 VGND VPWR VPWR sky130_fd_sc_hd__fill_4
* cell instance sky130_fd_sc_hd__fill_4_529 r0 *1 0,0
Xsky130_fd_sc_hd__fill_4_529 VGND VPWR VPWR sky130_fd_sc_hd__fill_4
* cell instance sky130_fd_sc_hd__fill_4_530 r0 *1 0,0
Xsky130_fd_sc_hd__fill_4_530 VGND VPWR VPWR sky130_fd_sc_hd__fill_4
* cell instance sky130_fd_sc_hd__fill_4_531 r0 *1 0,0
Xsky130_fd_sc_hd__fill_4_531 VGND VPWR VPWR sky130_fd_sc_hd__fill_4
* cell instance sky130_fd_sc_hd__fill_4_532 r0 *1 0,0
Xsky130_fd_sc_hd__fill_4_532 VGND VPWR VPWR sky130_fd_sc_hd__fill_4
* cell instance sky130_fd_sc_hd__fill_4_533 r0 *1 0,0
Xsky130_fd_sc_hd__fill_4_533 VGND VPWR VPWR sky130_fd_sc_hd__fill_4
* cell instance sky130_fd_sc_hd__fill_4_534 r0 *1 0,0
Xsky130_fd_sc_hd__fill_4_534 VGND VPWR VPWR sky130_fd_sc_hd__fill_4
* cell instance sky130_fd_sc_hd__fill_4_535 r0 *1 0,0
Xsky130_fd_sc_hd__fill_4_535 VGND VPWR VPWR sky130_fd_sc_hd__fill_4
* cell instance sky130_fd_sc_hd__fill_4_536 r0 *1 0,0
Xsky130_fd_sc_hd__fill_4_536 VGND VPWR VPWR sky130_fd_sc_hd__fill_4
* cell instance sky130_fd_sc_hd__fill_4_537 r0 *1 0,0
Xsky130_fd_sc_hd__fill_4_537 VGND VPWR VPWR sky130_fd_sc_hd__fill_4
* cell instance sky130_fd_sc_hd__fill_4_538 r0 *1 0,0
Xsky130_fd_sc_hd__fill_4_538 VGND VPWR VPWR sky130_fd_sc_hd__fill_4
* cell instance sky130_fd_sc_hd__fill_4_539 r0 *1 0,0
Xsky130_fd_sc_hd__fill_4_539 VGND VPWR VPWR sky130_fd_sc_hd__fill_4
* cell instance sky130_fd_sc_hd__fill_4_540 r0 *1 0,0
Xsky130_fd_sc_hd__fill_4_540 VGND VPWR VPWR sky130_fd_sc_hd__fill_4
* cell instance sky130_fd_sc_hd__fill_4_541 r0 *1 0,0
Xsky130_fd_sc_hd__fill_4_541 VGND VPWR VPWR sky130_fd_sc_hd__fill_4
* cell instance sky130_fd_sc_hd__fill_4_542 r0 *1 0,0
Xsky130_fd_sc_hd__fill_4_542 VGND VPWR VPWR sky130_fd_sc_hd__fill_4
* cell instance sky130_fd_sc_hd__fill_4_543 r0 *1 0,0
Xsky130_fd_sc_hd__fill_4_543 VGND VPWR VPWR sky130_fd_sc_hd__fill_4
* cell instance sky130_fd_sc_hd__fill_4_544 r0 *1 0,0
Xsky130_fd_sc_hd__fill_4_544 VGND VPWR VPWR sky130_fd_sc_hd__fill_4
* cell instance sky130_fd_sc_hd__fill_4_545 r0 *1 0,0
Xsky130_fd_sc_hd__fill_4_545 VGND VPWR VPWR sky130_fd_sc_hd__fill_4
* cell instance sky130_fd_sc_hd__fill_4_546 r0 *1 0,0
Xsky130_fd_sc_hd__fill_4_546 VGND VPWR VPWR sky130_fd_sc_hd__fill_4
* cell instance sky130_fd_sc_hd__fill_4_547 r0 *1 0,0
Xsky130_fd_sc_hd__fill_4_547 VGND VPWR VPWR sky130_fd_sc_hd__fill_4
* cell instance sky130_fd_sc_hd__fill_4_548 r0 *1 0,0
Xsky130_fd_sc_hd__fill_4_548 VGND VPWR VPWR sky130_fd_sc_hd__fill_4
* cell instance sky130_fd_sc_hd__fill_4_549 r0 *1 0,0
Xsky130_fd_sc_hd__fill_4_549 VGND VPWR VPWR sky130_fd_sc_hd__fill_4
* cell instance sky130_fd_sc_hd__fill_4_550 r0 *1 0,0
Xsky130_fd_sc_hd__fill_4_550 VGND VPWR VPWR sky130_fd_sc_hd__fill_4
* cell instance sky130_fd_sc_hd__fill_4_551 r0 *1 0,0
Xsky130_fd_sc_hd__fill_4_551 VGND VPWR VPWR sky130_fd_sc_hd__fill_4
* cell instance sky130_fd_sc_hd__fill_4_552 r0 *1 0,0
Xsky130_fd_sc_hd__fill_4_552 VGND VPWR VPWR sky130_fd_sc_hd__fill_4
* cell instance sky130_fd_sc_hd__fill_4_553 r0 *1 0,0
Xsky130_fd_sc_hd__fill_4_553 VGND VPWR VPWR sky130_fd_sc_hd__fill_4
* cell instance sky130_fd_sc_hd__fill_4_554 r0 *1 0,0
Xsky130_fd_sc_hd__fill_4_554 VGND VPWR VPWR sky130_fd_sc_hd__fill_4
* cell instance sky130_fd_sc_hd__fill_4_555 r0 *1 0,0
Xsky130_fd_sc_hd__fill_4_555 VGND VPWR VPWR sky130_fd_sc_hd__fill_4
* cell instance sky130_fd_sc_hd__fill_4_556 r0 *1 0,0
Xsky130_fd_sc_hd__fill_4_556 VGND VPWR VPWR sky130_fd_sc_hd__fill_4
* cell instance sky130_fd_sc_hd__fill_4_557 r0 *1 0,0
Xsky130_fd_sc_hd__fill_4_557 VGND VPWR VPWR sky130_fd_sc_hd__fill_4
* cell instance sky130_fd_sc_hd__fill_4_558 r0 *1 0,0
Xsky130_fd_sc_hd__fill_4_558 VGND VPWR VPWR sky130_fd_sc_hd__fill_4
* cell instance sky130_fd_sc_hd__fill_4_559 r0 *1 0,0
Xsky130_fd_sc_hd__fill_4_559 VGND VPWR VPWR sky130_fd_sc_hd__fill_4
* cell instance sky130_fd_sc_hd__fill_4_560 r0 *1 0,0
Xsky130_fd_sc_hd__fill_4_560 VGND VPWR VPWR sky130_fd_sc_hd__fill_4
* cell instance sky130_fd_sc_hd__fill_4_561 r0 *1 0,0
Xsky130_fd_sc_hd__fill_4_561 VGND VPWR VPWR sky130_fd_sc_hd__fill_4
* cell instance sky130_fd_sc_hd__fill_4_562 r0 *1 0,0
Xsky130_fd_sc_hd__fill_4_562 VGND VPWR VPWR sky130_fd_sc_hd__fill_4
* cell instance sky130_fd_sc_hd__fill_4_563 r0 *1 0,0
Xsky130_fd_sc_hd__fill_4_563 VGND VPWR VPWR sky130_fd_sc_hd__fill_4
* cell instance sky130_fd_sc_hd__fill_4_564 r0 *1 0,0
Xsky130_fd_sc_hd__fill_4_564 VGND VPWR VPWR sky130_fd_sc_hd__fill_4
* cell instance sky130_fd_sc_hd__fill_4_565 r0 *1 0,0
Xsky130_fd_sc_hd__fill_4_565 VGND VPWR VPWR sky130_fd_sc_hd__fill_4
* cell instance sky130_fd_sc_hd__fill_4_566 r0 *1 0,0
Xsky130_fd_sc_hd__fill_4_566 VGND VPWR VPWR sky130_fd_sc_hd__fill_4
* cell instance sky130_fd_sc_hd__fill_4_567 r0 *1 0,0
Xsky130_fd_sc_hd__fill_4_567 VGND VPWR VPWR sky130_fd_sc_hd__fill_4
* cell instance sky130_fd_sc_hd__fill_4_568 r0 *1 0,0
Xsky130_fd_sc_hd__fill_4_568 VGND VPWR VPWR sky130_fd_sc_hd__fill_4
* cell instance sky130_fd_sc_hd__fill_4_569 r0 *1 0,0
Xsky130_fd_sc_hd__fill_4_569 VGND VPWR VPWR sky130_fd_sc_hd__fill_4
* cell instance sky130_fd_sc_hd__fill_4_570 r0 *1 0,0
Xsky130_fd_sc_hd__fill_4_570 VGND VPWR VPWR sky130_fd_sc_hd__fill_4
* cell instance sky130_fd_sc_hd__fill_4_571 r0 *1 0,0
Xsky130_fd_sc_hd__fill_4_571 VGND VPWR VPWR sky130_fd_sc_hd__fill_4
* cell instance sky130_fd_sc_hd__fill_4_572 r0 *1 0,0
Xsky130_fd_sc_hd__fill_4_572 VGND VPWR VPWR sky130_fd_sc_hd__fill_4
* cell instance sky130_fd_sc_hd__fill_4_573 r0 *1 0,0
Xsky130_fd_sc_hd__fill_4_573 VGND VPWR VPWR sky130_fd_sc_hd__fill_4
* cell instance sky130_fd_sc_hd__fill_4_574 r0 *1 0,0
Xsky130_fd_sc_hd__fill_4_574 VGND VPWR VPWR sky130_fd_sc_hd__fill_4
* cell instance sky130_fd_sc_hd__fill_4_575 r0 *1 0,0
Xsky130_fd_sc_hd__fill_4_575 VGND VPWR VPWR sky130_fd_sc_hd__fill_4
* cell instance sky130_fd_sc_hd__fill_4_576 r0 *1 0,0
Xsky130_fd_sc_hd__fill_4_576 VGND VPWR VPWR sky130_fd_sc_hd__fill_4
* cell instance sky130_fd_sc_hd__fill_4_577 r0 *1 0,0
Xsky130_fd_sc_hd__fill_4_577 VGND VPWR VPWR sky130_fd_sc_hd__fill_4
* cell instance sky130_fd_sc_hd__fill_4_578 r0 *1 0,0
Xsky130_fd_sc_hd__fill_4_578 VGND VPWR VPWR sky130_fd_sc_hd__fill_4
* cell instance sky130_fd_sc_hd__fill_4_579 r0 *1 0,0
Xsky130_fd_sc_hd__fill_4_579 VGND VPWR VPWR sky130_fd_sc_hd__fill_4
* cell instance sky130_fd_sc_hd__fill_4_580 r0 *1 0,0
Xsky130_fd_sc_hd__fill_4_580 VGND VPWR VPWR sky130_fd_sc_hd__fill_4
* cell instance sky130_fd_sc_hd__fill_4_581 r0 *1 0,0
Xsky130_fd_sc_hd__fill_4_581 VGND VPWR VPWR sky130_fd_sc_hd__fill_4
* cell instance sky130_fd_sc_hd__fill_4_582 r0 *1 0,0
Xsky130_fd_sc_hd__fill_4_582 VGND VPWR VPWR sky130_fd_sc_hd__fill_4
* cell instance sky130_fd_sc_hd__fill_4_583 r0 *1 0,0
Xsky130_fd_sc_hd__fill_4_583 VGND VPWR VPWR sky130_fd_sc_hd__fill_4
* cell instance sky130_fd_sc_hd__fill_4_584 r0 *1 0,0
Xsky130_fd_sc_hd__fill_4_584 VGND VPWR VPWR sky130_fd_sc_hd__fill_4
* cell instance sky130_fd_sc_hd__fill_4_585 r0 *1 0,0
Xsky130_fd_sc_hd__fill_4_585 VGND VPWR VPWR sky130_fd_sc_hd__fill_4
* cell instance sky130_fd_sc_hd__fill_4_586 r0 *1 0,0
Xsky130_fd_sc_hd__fill_4_586 VGND VPWR VPWR sky130_fd_sc_hd__fill_4
* cell instance sky130_fd_sc_hd__fill_4_587 r0 *1 0,0
Xsky130_fd_sc_hd__fill_4_587 VGND VPWR VPWR sky130_fd_sc_hd__fill_4
* cell instance sky130_fd_sc_hd__fill_4_588 r0 *1 0,0
Xsky130_fd_sc_hd__fill_4_588 VGND VPWR VPWR sky130_fd_sc_hd__fill_4
* cell instance sky130_fd_sc_hd__fill_4_589 r0 *1 0,0
Xsky130_fd_sc_hd__fill_4_589 VGND VPWR VPWR sky130_fd_sc_hd__fill_4
* cell instance sky130_fd_sc_hd__fill_4_590 r0 *1 0,0
Xsky130_fd_sc_hd__fill_4_590 VGND VPWR VPWR sky130_fd_sc_hd__fill_4
* cell instance sky130_fd_sc_hd__fill_4_591 r0 *1 0,0
Xsky130_fd_sc_hd__fill_4_591 VGND VPWR VPWR sky130_fd_sc_hd__fill_4
* cell instance sky130_fd_sc_hd__fill_4_592 r0 *1 0,0
Xsky130_fd_sc_hd__fill_4_592 VGND VPWR VPWR sky130_fd_sc_hd__fill_4
* cell instance sky130_fd_sc_hd__fill_4_593 r0 *1 0,0
Xsky130_fd_sc_hd__fill_4_593 VGND VPWR VPWR sky130_fd_sc_hd__fill_4
* cell instance sky130_fd_sc_hd__fill_4_594 r0 *1 0,0
Xsky130_fd_sc_hd__fill_4_594 VGND VPWR VPWR sky130_fd_sc_hd__fill_4
* cell instance sky130_fd_sc_hd__fill_4_595 r0 *1 0,0
Xsky130_fd_sc_hd__fill_4_595 VGND VPWR VPWR sky130_fd_sc_hd__fill_4
* cell instance sky130_fd_sc_hd__fill_4_596 r0 *1 0,0
Xsky130_fd_sc_hd__fill_4_596 VGND VPWR VPWR sky130_fd_sc_hd__fill_4
* cell instance sky130_fd_sc_hd__fill_4_597 r0 *1 0,0
Xsky130_fd_sc_hd__fill_4_597 VGND VPWR VPWR sky130_fd_sc_hd__fill_4
* cell instance sky130_fd_sc_hd__fill_4_598 r0 *1 0,0
Xsky130_fd_sc_hd__fill_4_598 VGND VPWR VPWR sky130_fd_sc_hd__fill_4
* cell instance sky130_fd_sc_hd__fill_4_599 r0 *1 0,0
Xsky130_fd_sc_hd__fill_4_599 VGND VPWR VPWR sky130_fd_sc_hd__fill_4
* cell instance sky130_fd_sc_hd__fill_4_600 r0 *1 0,0
Xsky130_fd_sc_hd__fill_4_600 VGND VPWR VPWR sky130_fd_sc_hd__fill_4
* cell instance sky130_fd_sc_hd__fill_4_601 r0 *1 0,0
Xsky130_fd_sc_hd__fill_4_601 VGND VPWR VPWR sky130_fd_sc_hd__fill_4
* cell instance sky130_fd_sc_hd__fill_4_602 r0 *1 0,0
Xsky130_fd_sc_hd__fill_4_602 VGND VPWR VPWR sky130_fd_sc_hd__fill_4
* cell instance sky130_fd_sc_hd__fill_4_603 r0 *1 0,0
Xsky130_fd_sc_hd__fill_4_603 VGND VPWR VPWR sky130_fd_sc_hd__fill_4
* cell instance sky130_fd_sc_hd__fill_4_604 r0 *1 0,0
Xsky130_fd_sc_hd__fill_4_604 VGND VPWR VPWR sky130_fd_sc_hd__fill_4
* cell instance sky130_fd_sc_hd__fill_4_605 r0 *1 0,0
Xsky130_fd_sc_hd__fill_4_605 VGND VPWR VPWR sky130_fd_sc_hd__fill_4
* cell instance sky130_fd_sc_hd__fill_4_606 r0 *1 0,0
Xsky130_fd_sc_hd__fill_4_606 VGND VPWR VPWR sky130_fd_sc_hd__fill_4
* cell instance sky130_fd_sc_hd__fill_4_607 r0 *1 0,0
Xsky130_fd_sc_hd__fill_4_607 VGND VPWR VPWR sky130_fd_sc_hd__fill_4
* cell instance sky130_fd_sc_hd__fill_4_608 r0 *1 0,0
Xsky130_fd_sc_hd__fill_4_608 VGND VPWR VPWR sky130_fd_sc_hd__fill_4
* cell instance sky130_fd_sc_hd__fill_4_609 r0 *1 0,0
Xsky130_fd_sc_hd__fill_4_609 VGND VPWR VPWR sky130_fd_sc_hd__fill_4
* cell instance sky130_fd_sc_hd__fill_4_610 r0 *1 0,0
Xsky130_fd_sc_hd__fill_4_610 VGND VPWR VPWR sky130_fd_sc_hd__fill_4
* cell instance sky130_fd_sc_hd__fill_4_611 r0 *1 0,0
Xsky130_fd_sc_hd__fill_4_611 VGND VPWR VPWR sky130_fd_sc_hd__fill_4
* cell instance sky130_fd_sc_hd__fill_4_612 r0 *1 0,0
Xsky130_fd_sc_hd__fill_4_612 VGND VPWR VPWR sky130_fd_sc_hd__fill_4
* cell instance sky130_fd_sc_hd__fill_4_613 r0 *1 0,0
Xsky130_fd_sc_hd__fill_4_613 VGND VPWR VPWR sky130_fd_sc_hd__fill_4
* cell instance sky130_fd_sc_hd__fill_4_614 r0 *1 0,0
Xsky130_fd_sc_hd__fill_4_614 VGND VPWR VPWR sky130_fd_sc_hd__fill_4
* cell instance sky130_fd_sc_hd__fill_4_615 r0 *1 0,0
Xsky130_fd_sc_hd__fill_4_615 VGND VPWR VPWR sky130_fd_sc_hd__fill_4
* cell instance sky130_fd_sc_hd__fill_4_616 r0 *1 0,0
Xsky130_fd_sc_hd__fill_4_616 VGND VPWR VPWR sky130_fd_sc_hd__fill_4
* cell instance sky130_fd_sc_hd__fill_4_617 r0 *1 0,0
Xsky130_fd_sc_hd__fill_4_617 VGND VPWR VPWR sky130_fd_sc_hd__fill_4
* cell instance sky130_fd_sc_hd__fill_4_618 r0 *1 0,0
Xsky130_fd_sc_hd__fill_4_618 VGND VPWR VPWR sky130_fd_sc_hd__fill_4
* cell instance sky130_fd_sc_hd__fill_4_619 r0 *1 0,0
Xsky130_fd_sc_hd__fill_4_619 VGND VPWR VPWR sky130_fd_sc_hd__fill_4
* cell instance sky130_fd_sc_hd__fill_4_620 r0 *1 0,0
Xsky130_fd_sc_hd__fill_4_620 VGND VPWR VPWR sky130_fd_sc_hd__fill_4
* cell instance sky130_fd_sc_hd__fill_4_621 r0 *1 0,0
Xsky130_fd_sc_hd__fill_4_621 VGND VPWR VPWR sky130_fd_sc_hd__fill_4
* cell instance sky130_fd_sc_hd__fill_4_622 r0 *1 0,0
Xsky130_fd_sc_hd__fill_4_622 VGND VPWR VPWR sky130_fd_sc_hd__fill_4
* cell instance sky130_fd_sc_hd__fill_4_623 r0 *1 0,0
Xsky130_fd_sc_hd__fill_4_623 VGND VPWR VPWR sky130_fd_sc_hd__fill_4
* cell instance sky130_fd_sc_hd__fill_4_624 r0 *1 0,0
Xsky130_fd_sc_hd__fill_4_624 VGND VPWR VPWR sky130_fd_sc_hd__fill_4
* cell instance sky130_fd_sc_hd__fill_4_625 r0 *1 0,0
Xsky130_fd_sc_hd__fill_4_625 VGND VPWR VPWR sky130_fd_sc_hd__fill_4
* cell instance sky130_fd_sc_hd__fill_4_626 r0 *1 0,0
Xsky130_fd_sc_hd__fill_4_626 VGND VPWR VPWR sky130_fd_sc_hd__fill_4
* cell instance sky130_fd_sc_hd__fill_4_627 r0 *1 0,0
Xsky130_fd_sc_hd__fill_4_627 VGND VPWR VPWR sky130_fd_sc_hd__fill_4
* cell instance sky130_fd_sc_hd__fill_4_628 r0 *1 0,0
Xsky130_fd_sc_hd__fill_4_628 VGND VPWR VPWR sky130_fd_sc_hd__fill_4
* cell instance sky130_fd_sc_hd__fill_4_629 r0 *1 0,0
Xsky130_fd_sc_hd__fill_4_629 VGND VPWR VPWR sky130_fd_sc_hd__fill_4
* cell instance sky130_fd_sc_hd__fill_4_630 r0 *1 0,0
Xsky130_fd_sc_hd__fill_4_630 VGND VPWR VPWR sky130_fd_sc_hd__fill_4
* cell instance sky130_fd_sc_hd__fill_4_631 r0 *1 0,0
Xsky130_fd_sc_hd__fill_4_631 VGND VPWR VPWR sky130_fd_sc_hd__fill_4
* cell instance sky130_fd_sc_hd__fill_4_632 r0 *1 0,0
Xsky130_fd_sc_hd__fill_4_632 VGND VPWR VPWR sky130_fd_sc_hd__fill_4
* cell instance sky130_fd_sc_hd__fill_4_633 r0 *1 0,0
Xsky130_fd_sc_hd__fill_4_633 VGND VPWR VPWR sky130_fd_sc_hd__fill_4
* cell instance sky130_fd_sc_hd__fill_4_634 r0 *1 0,0
Xsky130_fd_sc_hd__fill_4_634 VGND VPWR VPWR sky130_fd_sc_hd__fill_4
* cell instance sky130_fd_sc_hd__fill_4_635 r0 *1 0,0
Xsky130_fd_sc_hd__fill_4_635 VGND VPWR VPWR sky130_fd_sc_hd__fill_4
* cell instance sky130_fd_sc_hd__fill_4_636 r0 *1 0,0
Xsky130_fd_sc_hd__fill_4_636 VGND VPWR VPWR sky130_fd_sc_hd__fill_4
* cell instance sky130_fd_sc_hd__fill_4_637 r0 *1 0,0
Xsky130_fd_sc_hd__fill_4_637 VGND VPWR VPWR sky130_fd_sc_hd__fill_4
* cell instance sky130_fd_sc_hd__fill_4_638 r0 *1 0,0
Xsky130_fd_sc_hd__fill_4_638 VGND VPWR VPWR sky130_fd_sc_hd__fill_4
* cell instance sky130_fd_sc_hd__fill_4_639 r0 *1 0,0
Xsky130_fd_sc_hd__fill_4_639 VGND VPWR VPWR sky130_fd_sc_hd__fill_4
* cell instance sky130_fd_sc_hd__fill_4_640 r0 *1 0,0
Xsky130_fd_sc_hd__fill_4_640 VGND VPWR VPWR sky130_fd_sc_hd__fill_4
* cell instance sky130_fd_sc_hd__fill_4_641 r0 *1 0,0
Xsky130_fd_sc_hd__fill_4_641 VGND VPWR VPWR sky130_fd_sc_hd__fill_4
* cell instance sky130_fd_sc_hd__fill_4_642 r0 *1 0,0
Xsky130_fd_sc_hd__fill_4_642 VGND VPWR VPWR sky130_fd_sc_hd__fill_4
* cell instance sky130_fd_sc_hd__fill_4_643 r0 *1 0,0
Xsky130_fd_sc_hd__fill_4_643 VGND VPWR VPWR sky130_fd_sc_hd__fill_4
* cell instance sky130_fd_sc_hd__fill_4_644 r0 *1 0,0
Xsky130_fd_sc_hd__fill_4_644 VGND VPWR VPWR sky130_fd_sc_hd__fill_4
* cell instance sky130_fd_sc_hd__fill_4_645 r0 *1 0,0
Xsky130_fd_sc_hd__fill_4_645 VGND VPWR VPWR sky130_fd_sc_hd__fill_4
* cell instance sky130_fd_sc_hd__fill_4_646 r0 *1 0,0
Xsky130_fd_sc_hd__fill_4_646 VGND VPWR VPWR sky130_fd_sc_hd__fill_4
* cell instance sky130_fd_sc_hd__fill_4_647 r0 *1 0,0
Xsky130_fd_sc_hd__fill_4_647 VGND VPWR VPWR sky130_fd_sc_hd__fill_4
* cell instance sky130_fd_sc_hd__fill_4_648 r0 *1 0,0
Xsky130_fd_sc_hd__fill_4_648 VGND VPWR VPWR sky130_fd_sc_hd__fill_4
* cell instance sky130_fd_sc_hd__fill_4_649 r0 *1 0,0
Xsky130_fd_sc_hd__fill_4_649 VGND VPWR VPWR sky130_fd_sc_hd__fill_4
* cell instance sky130_fd_sc_hd__fill_4_650 r0 *1 0,0
Xsky130_fd_sc_hd__fill_4_650 VGND VPWR VPWR sky130_fd_sc_hd__fill_4
* cell instance sky130_fd_sc_hd__fill_4_651 r0 *1 0,0
Xsky130_fd_sc_hd__fill_4_651 VGND VPWR VPWR sky130_fd_sc_hd__fill_4
* cell instance sky130_fd_sc_hd__fill_4_652 r0 *1 0,0
Xsky130_fd_sc_hd__fill_4_652 VGND VPWR VPWR sky130_fd_sc_hd__fill_4
* cell instance sky130_fd_sc_hd__fill_4_653 r0 *1 0,0
Xsky130_fd_sc_hd__fill_4_653 VGND VPWR VPWR sky130_fd_sc_hd__fill_4
* cell instance sky130_fd_sc_hd__fill_4_654 r0 *1 0,0
Xsky130_fd_sc_hd__fill_4_654 VGND VPWR VPWR sky130_fd_sc_hd__fill_4
* cell instance sky130_fd_sc_hd__fill_4_655 r0 *1 0,0
Xsky130_fd_sc_hd__fill_4_655 VGND VPWR VPWR sky130_fd_sc_hd__fill_4
* cell instance sky130_fd_sc_hd__fill_4_656 r0 *1 0,0
Xsky130_fd_sc_hd__fill_4_656 VGND VPWR VPWR sky130_fd_sc_hd__fill_4
* cell instance sky130_fd_sc_hd__fill_4_657 r0 *1 0,0
Xsky130_fd_sc_hd__fill_4_657 VGND VPWR VPWR sky130_fd_sc_hd__fill_4
* cell instance sky130_fd_sc_hd__fill_4_658 r0 *1 0,0
Xsky130_fd_sc_hd__fill_4_658 VGND VPWR VPWR sky130_fd_sc_hd__fill_4
* cell instance sky130_fd_sc_hd__fill_4_659 r0 *1 0,0
Xsky130_fd_sc_hd__fill_4_659 VGND VPWR VPWR sky130_fd_sc_hd__fill_4
* cell instance sky130_fd_sc_hd__fill_4_660 r0 *1 0,0
Xsky130_fd_sc_hd__fill_4_660 VGND VPWR VPWR sky130_fd_sc_hd__fill_4
* cell instance sky130_fd_sc_hd__fill_4_661 r0 *1 0,0
Xsky130_fd_sc_hd__fill_4_661 VGND VPWR VPWR sky130_fd_sc_hd__fill_4
* cell instance sky130_fd_sc_hd__fill_4_662 r0 *1 0,0
Xsky130_fd_sc_hd__fill_4_662 VGND VPWR VPWR sky130_fd_sc_hd__fill_4
* cell instance sky130_fd_sc_hd__fill_4_663 r0 *1 0,0
Xsky130_fd_sc_hd__fill_4_663 VGND VPWR VPWR sky130_fd_sc_hd__fill_4
* cell instance sky130_fd_sc_hd__fill_4_664 r0 *1 0,0
Xsky130_fd_sc_hd__fill_4_664 VGND VPWR VPWR sky130_fd_sc_hd__fill_4
* cell instance sky130_fd_sc_hd__fill_4_665 r0 *1 0,0
Xsky130_fd_sc_hd__fill_4_665 VGND VPWR VPWR sky130_fd_sc_hd__fill_4
* cell instance sky130_fd_sc_hd__fill_4_666 r0 *1 0,0
Xsky130_fd_sc_hd__fill_4_666 VGND VPWR VPWR sky130_fd_sc_hd__fill_4
* cell instance sky130_fd_sc_hd__fill_4_667 r0 *1 0,0
Xsky130_fd_sc_hd__fill_4_667 VGND VPWR VPWR sky130_fd_sc_hd__fill_4
* cell instance sky130_fd_sc_hd__fill_4_668 r0 *1 0,0
Xsky130_fd_sc_hd__fill_4_668 VGND VPWR VPWR sky130_fd_sc_hd__fill_4
* cell instance sky130_fd_sc_hd__fill_4_669 r0 *1 0,0
Xsky130_fd_sc_hd__fill_4_669 VGND VPWR VPWR sky130_fd_sc_hd__fill_4
* cell instance sky130_fd_sc_hd__fill_4_670 r0 *1 0,0
Xsky130_fd_sc_hd__fill_4_670 VGND VPWR VPWR sky130_fd_sc_hd__fill_4
* cell instance sky130_fd_sc_hd__fill_4_671 r0 *1 0,0
Xsky130_fd_sc_hd__fill_4_671 VGND VPWR VPWR sky130_fd_sc_hd__fill_4
* cell instance sky130_fd_sc_hd__fill_4_672 r0 *1 0,0
Xsky130_fd_sc_hd__fill_4_672 VGND VPWR VPWR sky130_fd_sc_hd__fill_4
* cell instance sky130_fd_sc_hd__fill_4_673 r0 *1 0,0
Xsky130_fd_sc_hd__fill_4_673 VGND VPWR VPWR sky130_fd_sc_hd__fill_4
* cell instance sky130_fd_sc_hd__fill_4_674 r0 *1 0,0
Xsky130_fd_sc_hd__fill_4_674 VGND VPWR VPWR sky130_fd_sc_hd__fill_4
* cell instance sky130_fd_sc_hd__fill_4_675 r0 *1 0,0
Xsky130_fd_sc_hd__fill_4_675 VGND VPWR VPWR sky130_fd_sc_hd__fill_4
* cell instance sky130_fd_sc_hd__fill_4_676 r0 *1 0,0
Xsky130_fd_sc_hd__fill_4_676 VGND VPWR VPWR sky130_fd_sc_hd__fill_4
* cell instance sky130_fd_sc_hd__fill_4_677 r0 *1 0,0
Xsky130_fd_sc_hd__fill_4_677 VGND VPWR VPWR sky130_fd_sc_hd__fill_4
* cell instance sky130_fd_sc_hd__fill_4_678 r0 *1 0,0
Xsky130_fd_sc_hd__fill_4_678 VGND VPWR VPWR sky130_fd_sc_hd__fill_4
* cell instance sky130_fd_sc_hd__fill_4_679 r0 *1 0,0
Xsky130_fd_sc_hd__fill_4_679 VGND VPWR VPWR sky130_fd_sc_hd__fill_4
* cell instance sky130_fd_sc_hd__fill_4_680 r0 *1 0,0
Xsky130_fd_sc_hd__fill_4_680 VGND VPWR VPWR sky130_fd_sc_hd__fill_4
* cell instance sky130_fd_sc_hd__fill_4_681 r0 *1 0,0
Xsky130_fd_sc_hd__fill_4_681 VGND VPWR VPWR sky130_fd_sc_hd__fill_4
* cell instance sky130_fd_sc_hd__fill_4_682 r0 *1 0,0
Xsky130_fd_sc_hd__fill_4_682 VGND VPWR VPWR sky130_fd_sc_hd__fill_4
* cell instance sky130_fd_sc_hd__fill_4_683 r0 *1 0,0
Xsky130_fd_sc_hd__fill_4_683 VGND VPWR VPWR sky130_fd_sc_hd__fill_4
* cell instance sky130_fd_sc_hd__fill_4_684 r0 *1 0,0
Xsky130_fd_sc_hd__fill_4_684 VGND VPWR VPWR sky130_fd_sc_hd__fill_4
* cell instance sky130_fd_sc_hd__fill_4_685 r0 *1 0,0
Xsky130_fd_sc_hd__fill_4_685 VGND VPWR VPWR sky130_fd_sc_hd__fill_4
* cell instance sky130_fd_sc_hd__fill_4_686 r0 *1 0,0
Xsky130_fd_sc_hd__fill_4_686 VGND VPWR VPWR sky130_fd_sc_hd__fill_4
* cell instance sky130_fd_sc_hd__fill_4_687 r0 *1 0,0
Xsky130_fd_sc_hd__fill_4_687 VGND VPWR VPWR sky130_fd_sc_hd__fill_4
* cell instance sky130_fd_sc_hd__fill_4_688 r0 *1 0,0
Xsky130_fd_sc_hd__fill_4_688 VGND VPWR VPWR sky130_fd_sc_hd__fill_4
* cell instance sky130_fd_sc_hd__fill_4_689 r0 *1 0,0
Xsky130_fd_sc_hd__fill_4_689 VGND VPWR VPWR sky130_fd_sc_hd__fill_4
* cell instance sky130_fd_sc_hd__fill_4_690 r0 *1 0,0
Xsky130_fd_sc_hd__fill_4_690 VGND VPWR VPWR sky130_fd_sc_hd__fill_4
* cell instance sky130_fd_sc_hd__fill_4_691 r0 *1 0,0
Xsky130_fd_sc_hd__fill_4_691 VGND VPWR VPWR sky130_fd_sc_hd__fill_4
* cell instance sky130_fd_sc_hd__fill_4_692 r0 *1 0,0
Xsky130_fd_sc_hd__fill_4_692 VGND VPWR VPWR sky130_fd_sc_hd__fill_4
* cell instance sky130_fd_sc_hd__fill_4_693 r0 *1 0,0
Xsky130_fd_sc_hd__fill_4_693 VGND VPWR VPWR sky130_fd_sc_hd__fill_4
* cell instance sky130_fd_sc_hd__fill_4_694 r0 *1 0,0
Xsky130_fd_sc_hd__fill_4_694 VGND VPWR VPWR sky130_fd_sc_hd__fill_4
* cell instance sky130_fd_sc_hd__fill_4_695 r0 *1 0,0
Xsky130_fd_sc_hd__fill_4_695 VGND VPWR VPWR sky130_fd_sc_hd__fill_4
* cell instance sky130_fd_sc_hd__fill_4_696 r0 *1 0,0
Xsky130_fd_sc_hd__fill_4_696 VGND VPWR VPWR sky130_fd_sc_hd__fill_4
* cell instance sky130_fd_sc_hd__fill_4_697 r0 *1 0,0
Xsky130_fd_sc_hd__fill_4_697 VGND VPWR VPWR sky130_fd_sc_hd__fill_4
* cell instance sky130_fd_sc_hd__fill_4_698 r0 *1 0,0
Xsky130_fd_sc_hd__fill_4_698 VGND VPWR VPWR sky130_fd_sc_hd__fill_4
* cell instance sky130_fd_sc_hd__fill_4_699 r0 *1 0,0
Xsky130_fd_sc_hd__fill_4_699 VGND VPWR VPWR sky130_fd_sc_hd__fill_4
* cell instance sky130_fd_sc_hd__fill_4_700 r0 *1 0,0
Xsky130_fd_sc_hd__fill_4_700 VGND VPWR VPWR sky130_fd_sc_hd__fill_4
* cell instance sky130_fd_sc_hd__fill_4_701 r0 *1 0,0
Xsky130_fd_sc_hd__fill_4_701 VGND VPWR VPWR sky130_fd_sc_hd__fill_4
* cell instance sky130_fd_sc_hd__fill_4_702 r0 *1 0,0
Xsky130_fd_sc_hd__fill_4_702 VGND VPWR VPWR sky130_fd_sc_hd__fill_4
* cell instance sky130_fd_sc_hd__fill_4_703 r0 *1 0,0
Xsky130_fd_sc_hd__fill_4_703 VGND VPWR VPWR sky130_fd_sc_hd__fill_4
* cell instance sky130_fd_sc_hd__fill_4_704 r0 *1 0,0
Xsky130_fd_sc_hd__fill_4_704 VGND VPWR VPWR sky130_fd_sc_hd__fill_4
* cell instance sky130_fd_sc_hd__fill_4_705 r0 *1 0,0
Xsky130_fd_sc_hd__fill_4_705 VGND VPWR VPWR sky130_fd_sc_hd__fill_4
* cell instance sky130_fd_sc_hd__fill_4_706 r0 *1 0,0
Xsky130_fd_sc_hd__fill_4_706 VGND VPWR VPWR sky130_fd_sc_hd__fill_4
* cell instance sky130_fd_sc_hd__fill_4_707 r0 *1 0,0
Xsky130_fd_sc_hd__fill_4_707 VGND VPWR VPWR sky130_fd_sc_hd__fill_4
* cell instance sky130_fd_sc_hd__fill_4_708 r0 *1 0,0
Xsky130_fd_sc_hd__fill_4_708 VGND VPWR VPWR sky130_fd_sc_hd__fill_4
* cell instance sky130_fd_sc_hd__fill_4_709 r0 *1 0,0
Xsky130_fd_sc_hd__fill_4_709 VGND VPWR VPWR sky130_fd_sc_hd__fill_4
* cell instance sky130_fd_sc_hd__fill_4_710 r0 *1 0,0
Xsky130_fd_sc_hd__fill_4_710 VGND VPWR VPWR sky130_fd_sc_hd__fill_4
* cell instance sky130_fd_sc_hd__fill_4_711 r0 *1 0,0
Xsky130_fd_sc_hd__fill_4_711 VGND VPWR VPWR sky130_fd_sc_hd__fill_4
* cell instance sky130_fd_sc_hd__fill_4_712 r0 *1 0,0
Xsky130_fd_sc_hd__fill_4_712 VGND VPWR VPWR sky130_fd_sc_hd__fill_4
* cell instance sky130_fd_sc_hd__fill_4_713 r0 *1 0,0
Xsky130_fd_sc_hd__fill_4_713 VGND VPWR VPWR sky130_fd_sc_hd__fill_4
* cell instance sky130_fd_sc_hd__fill_4_714 r0 *1 0,0
Xsky130_fd_sc_hd__fill_4_714 VGND VPWR VPWR sky130_fd_sc_hd__fill_4
* cell instance sky130_fd_sc_hd__fill_4_715 r0 *1 0,0
Xsky130_fd_sc_hd__fill_4_715 VGND VPWR VPWR sky130_fd_sc_hd__fill_4
* cell instance sky130_fd_sc_hd__fill_4_716 r0 *1 0,0
Xsky130_fd_sc_hd__fill_4_716 VGND VPWR VPWR sky130_fd_sc_hd__fill_4
* cell instance sky130_fd_sc_hd__fill_4_717 r0 *1 0,0
Xsky130_fd_sc_hd__fill_4_717 VGND VPWR VPWR sky130_fd_sc_hd__fill_4
* cell instance sky130_fd_sc_hd__fill_4_718 r0 *1 0,0
Xsky130_fd_sc_hd__fill_4_718 VGND VPWR VPWR sky130_fd_sc_hd__fill_4
* cell instance sky130_fd_sc_hd__fill_4_719 r0 *1 0,0
Xsky130_fd_sc_hd__fill_4_719 VGND VPWR VPWR sky130_fd_sc_hd__fill_4
* cell instance sky130_fd_sc_hd__fill_4_720 r0 *1 0,0
Xsky130_fd_sc_hd__fill_4_720 VGND VPWR VPWR sky130_fd_sc_hd__fill_4
* cell instance sky130_fd_sc_hd__fill_4_721 r0 *1 0,0
Xsky130_fd_sc_hd__fill_4_721 VGND VPWR VPWR sky130_fd_sc_hd__fill_4
* cell instance sky130_fd_sc_hd__fill_4_722 r0 *1 0,0
Xsky130_fd_sc_hd__fill_4_722 VGND VPWR VPWR sky130_fd_sc_hd__fill_4
* cell instance sky130_fd_sc_hd__fill_4_723 r0 *1 0,0
Xsky130_fd_sc_hd__fill_4_723 VGND VPWR VPWR sky130_fd_sc_hd__fill_4
* cell instance sky130_fd_sc_hd__fill_4_724 r0 *1 0,0
Xsky130_fd_sc_hd__fill_4_724 VGND VPWR VPWR sky130_fd_sc_hd__fill_4
* cell instance sky130_fd_sc_hd__fill_4_725 r0 *1 0,0
Xsky130_fd_sc_hd__fill_4_725 VGND VPWR VPWR sky130_fd_sc_hd__fill_4
* cell instance sky130_fd_sc_hd__fill_4_726 r0 *1 0,0
Xsky130_fd_sc_hd__fill_4_726 VGND VPWR VPWR sky130_fd_sc_hd__fill_4
* cell instance sky130_fd_sc_hd__fill_4_727 r0 *1 0,0
Xsky130_fd_sc_hd__fill_4_727 VGND VPWR VPWR sky130_fd_sc_hd__fill_4
* cell instance sky130_fd_sc_hd__fill_4_728 r0 *1 0,0
Xsky130_fd_sc_hd__fill_4_728 VGND VPWR VPWR sky130_fd_sc_hd__fill_4
* cell instance sky130_fd_sc_hd__fill_4_729 r0 *1 0,0
Xsky130_fd_sc_hd__fill_4_729 VGND VPWR VPWR sky130_fd_sc_hd__fill_4
* cell instance sky130_fd_sc_hd__fill_4_730 r0 *1 0,0
Xsky130_fd_sc_hd__fill_4_730 VGND VPWR VPWR sky130_fd_sc_hd__fill_4
* cell instance sky130_fd_sc_hd__fill_4_731 r0 *1 0,0
Xsky130_fd_sc_hd__fill_4_731 VGND VPWR VPWR sky130_fd_sc_hd__fill_4
* cell instance sky130_fd_sc_hd__fill_4_732 r0 *1 0,0
Xsky130_fd_sc_hd__fill_4_732 VGND VPWR VPWR sky130_fd_sc_hd__fill_4
* cell instance sky130_fd_sc_hd__fill_4_733 r0 *1 0,0
Xsky130_fd_sc_hd__fill_4_733 VGND VPWR VPWR sky130_fd_sc_hd__fill_4
* cell instance sky130_fd_sc_hd__fill_4_734 r0 *1 0,0
Xsky130_fd_sc_hd__fill_4_734 VGND VPWR VPWR sky130_fd_sc_hd__fill_4
* cell instance sky130_fd_sc_hd__fill_4_735 r0 *1 0,0
Xsky130_fd_sc_hd__fill_4_735 VGND VPWR VPWR sky130_fd_sc_hd__fill_4
* cell instance sky130_fd_sc_hd__fill_4_736 r0 *1 0,0
Xsky130_fd_sc_hd__fill_4_736 VGND VPWR VPWR sky130_fd_sc_hd__fill_4
* cell instance sky130_fd_sc_hd__fill_4_737 r0 *1 0,0
Xsky130_fd_sc_hd__fill_4_737 VGND VPWR VPWR sky130_fd_sc_hd__fill_4
* cell instance sky130_fd_sc_hd__fill_4_738 r0 *1 0,0
Xsky130_fd_sc_hd__fill_4_738 VGND VPWR VPWR sky130_fd_sc_hd__fill_4
* cell instance sky130_fd_sc_hd__fill_4_739 r0 *1 0,0
Xsky130_fd_sc_hd__fill_4_739 VGND VPWR VPWR sky130_fd_sc_hd__fill_4
* cell instance sky130_fd_sc_hd__fill_4_740 r0 *1 0,0
Xsky130_fd_sc_hd__fill_4_740 VGND VPWR VPWR sky130_fd_sc_hd__fill_4
* cell instance sky130_fd_sc_hd__fill_4_741 r0 *1 0,0
Xsky130_fd_sc_hd__fill_4_741 VGND VPWR VPWR sky130_fd_sc_hd__fill_4
* cell instance sky130_fd_sc_hd__fill_4_742 r0 *1 0,0
Xsky130_fd_sc_hd__fill_4_742 VGND VPWR VPWR sky130_fd_sc_hd__fill_4
* cell instance sky130_fd_sc_hd__fill_4_743 r0 *1 0,0
Xsky130_fd_sc_hd__fill_4_743 VGND VPWR VPWR sky130_fd_sc_hd__fill_4
* cell instance sky130_fd_sc_hd__fill_4_744 r0 *1 0,0
Xsky130_fd_sc_hd__fill_4_744 VGND VPWR VPWR sky130_fd_sc_hd__fill_4
* cell instance sky130_fd_sc_hd__fill_4_745 r0 *1 0,0
Xsky130_fd_sc_hd__fill_4_745 VGND VPWR VPWR sky130_fd_sc_hd__fill_4
* cell instance sky130_fd_sc_hd__fill_4_746 r0 *1 0,0
Xsky130_fd_sc_hd__fill_4_746 VGND VPWR VPWR sky130_fd_sc_hd__fill_4
* cell instance sky130_fd_sc_hd__fill_4_747 r0 *1 0,0
Xsky130_fd_sc_hd__fill_4_747 VGND VPWR VPWR sky130_fd_sc_hd__fill_4
* cell instance sky130_fd_sc_hd__fill_4_748 r0 *1 0,0
Xsky130_fd_sc_hd__fill_4_748 VGND VPWR VPWR sky130_fd_sc_hd__fill_4
* cell instance sky130_fd_sc_hd__fill_4_749 r0 *1 0,0
Xsky130_fd_sc_hd__fill_4_749 VGND VPWR VPWR sky130_fd_sc_hd__fill_4
* cell instance sky130_fd_sc_hd__fill_4_750 r0 *1 0,0
Xsky130_fd_sc_hd__fill_4_750 VGND VPWR VPWR sky130_fd_sc_hd__fill_4
* cell instance sky130_fd_sc_hd__fill_4_751 r0 *1 0,0
Xsky130_fd_sc_hd__fill_4_751 VGND VPWR VPWR sky130_fd_sc_hd__fill_4
* cell instance sky130_fd_sc_hd__fill_4_752 r0 *1 0,0
Xsky130_fd_sc_hd__fill_4_752 VGND VPWR VPWR sky130_fd_sc_hd__fill_4
* cell instance sky130_fd_sc_hd__fill_4_753 r0 *1 0,0
Xsky130_fd_sc_hd__fill_4_753 VGND VPWR VPWR sky130_fd_sc_hd__fill_4
* cell instance sky130_fd_sc_hd__fill_4_754 r0 *1 0,0
Xsky130_fd_sc_hd__fill_4_754 VGND VPWR VPWR sky130_fd_sc_hd__fill_4
* cell instance sky130_fd_sc_hd__fill_4_755 r0 *1 0,0
Xsky130_fd_sc_hd__fill_4_755 VGND VPWR VPWR sky130_fd_sc_hd__fill_4
* cell instance sky130_fd_sc_hd__fill_4_756 r0 *1 0,0
Xsky130_fd_sc_hd__fill_4_756 VGND VPWR VPWR sky130_fd_sc_hd__fill_4
* cell instance sky130_fd_sc_hd__fill_4_757 r0 *1 0,0
Xsky130_fd_sc_hd__fill_4_757 VGND VPWR VPWR sky130_fd_sc_hd__fill_4
* cell instance sky130_fd_sc_hd__fill_4_758 r0 *1 0,0
Xsky130_fd_sc_hd__fill_4_758 VGND VPWR VPWR sky130_fd_sc_hd__fill_4
* cell instance sky130_fd_sc_hd__fill_4_759 r0 *1 0,0
Xsky130_fd_sc_hd__fill_4_759 VGND VPWR VPWR sky130_fd_sc_hd__fill_4
* cell instance sky130_fd_sc_hd__fill_4_760 r0 *1 0,0
Xsky130_fd_sc_hd__fill_4_760 VGND VPWR VPWR sky130_fd_sc_hd__fill_4
* cell instance sky130_fd_sc_hd__fill_4_761 r0 *1 0,0
Xsky130_fd_sc_hd__fill_4_761 VGND VPWR VPWR sky130_fd_sc_hd__fill_4
* cell instance sky130_fd_sc_hd__fill_4_762 r0 *1 0,0
Xsky130_fd_sc_hd__fill_4_762 VGND VPWR VPWR sky130_fd_sc_hd__fill_4
* cell instance sky130_fd_sc_hd__fill_4_763 r0 *1 0,0
Xsky130_fd_sc_hd__fill_4_763 VGND VPWR VPWR sky130_fd_sc_hd__fill_4
* cell instance sky130_fd_sc_hd__fill_4_764 r0 *1 0,0
Xsky130_fd_sc_hd__fill_4_764 VGND VPWR VPWR sky130_fd_sc_hd__fill_4
* cell instance sky130_fd_sc_hd__fill_4_765 r0 *1 0,0
Xsky130_fd_sc_hd__fill_4_765 VGND VPWR VPWR sky130_fd_sc_hd__fill_4
* cell instance sky130_fd_sc_hd__fill_4_766 r0 *1 0,0
Xsky130_fd_sc_hd__fill_4_766 VGND VPWR VPWR sky130_fd_sc_hd__fill_4
* cell instance sky130_fd_sc_hd__fill_4_767 r0 *1 0,0
Xsky130_fd_sc_hd__fill_4_767 VGND VPWR VPWR sky130_fd_sc_hd__fill_4
* cell instance sky130_fd_sc_hd__fill_4_768 r0 *1 0,0
Xsky130_fd_sc_hd__fill_4_768 VGND VPWR VPWR sky130_fd_sc_hd__fill_4
* cell instance sky130_fd_sc_hd__fill_4_769 r0 *1 0,0
Xsky130_fd_sc_hd__fill_4_769 VGND VPWR VPWR sky130_fd_sc_hd__fill_4
* cell instance sky130_fd_sc_hd__fill_4_770 r0 *1 0,0
Xsky130_fd_sc_hd__fill_4_770 VGND VPWR VPWR sky130_fd_sc_hd__fill_4
* cell instance sky130_fd_sc_hd__fill_4_771 r0 *1 0,0
Xsky130_fd_sc_hd__fill_4_771 VGND VPWR VPWR sky130_fd_sc_hd__fill_4
* cell instance sky130_fd_sc_hd__fill_4_772 r0 *1 0,0
Xsky130_fd_sc_hd__fill_4_772 VGND VPWR VPWR sky130_fd_sc_hd__fill_4
* cell instance sky130_fd_sc_hd__fill_4_773 r0 *1 0,0
Xsky130_fd_sc_hd__fill_4_773 VGND VPWR VPWR sky130_fd_sc_hd__fill_4
* cell instance sky130_fd_sc_hd__fill_4_774 r0 *1 0,0
Xsky130_fd_sc_hd__fill_4_774 VGND VPWR VPWR sky130_fd_sc_hd__fill_4
* cell instance sky130_fd_sc_hd__fill_4_775 r0 *1 0,0
Xsky130_fd_sc_hd__fill_4_775 VGND VPWR VPWR sky130_fd_sc_hd__fill_4
* cell instance sky130_fd_sc_hd__fill_4_776 r0 *1 0,0
Xsky130_fd_sc_hd__fill_4_776 VGND VPWR VPWR sky130_fd_sc_hd__fill_4
* cell instance sky130_fd_sc_hd__fill_4_777 r0 *1 0,0
Xsky130_fd_sc_hd__fill_4_777 VGND VPWR VPWR sky130_fd_sc_hd__fill_4
* cell instance sky130_fd_sc_hd__fill_4_778 r0 *1 0,0
Xsky130_fd_sc_hd__fill_4_778 VGND VPWR VPWR sky130_fd_sc_hd__fill_4
* cell instance sky130_fd_sc_hd__fill_4_779 r0 *1 0,0
Xsky130_fd_sc_hd__fill_4_779 VGND VPWR VPWR sky130_fd_sc_hd__fill_4
* cell instance sky130_fd_sc_hd__fill_4_780 r0 *1 0,0
Xsky130_fd_sc_hd__fill_4_780 VGND VPWR VPWR sky130_fd_sc_hd__fill_4
* cell instance sky130_fd_sc_hd__fill_4_781 r0 *1 0,0
Xsky130_fd_sc_hd__fill_4_781 VGND VPWR VPWR sky130_fd_sc_hd__fill_4
* cell instance sky130_fd_sc_hd__fill_4_782 r0 *1 0,0
Xsky130_fd_sc_hd__fill_4_782 VGND VPWR VPWR sky130_fd_sc_hd__fill_4
* cell instance sky130_fd_sc_hd__fill_4_783 r0 *1 0,0
Xsky130_fd_sc_hd__fill_4_783 VGND VPWR VPWR sky130_fd_sc_hd__fill_4
* cell instance sky130_fd_sc_hd__fill_4_784 r0 *1 0,0
Xsky130_fd_sc_hd__fill_4_784 VGND VPWR VPWR sky130_fd_sc_hd__fill_4
* cell instance sky130_fd_sc_hd__fill_4_785 r0 *1 0,0
Xsky130_fd_sc_hd__fill_4_785 VGND VPWR VPWR sky130_fd_sc_hd__fill_4
* cell instance sky130_fd_sc_hd__fill_4_786 r0 *1 0,0
Xsky130_fd_sc_hd__fill_4_786 VGND VPWR VPWR sky130_fd_sc_hd__fill_4
* cell instance sky130_fd_sc_hd__fill_4_787 r0 *1 0,0
Xsky130_fd_sc_hd__fill_4_787 VGND VPWR VPWR sky130_fd_sc_hd__fill_4
* cell instance sky130_fd_sc_hd__fill_4_788 r0 *1 0,0
Xsky130_fd_sc_hd__fill_4_788 VGND VPWR VPWR sky130_fd_sc_hd__fill_4
* cell instance sky130_fd_sc_hd__fill_4_789 r0 *1 0,0
Xsky130_fd_sc_hd__fill_4_789 VGND VPWR VPWR sky130_fd_sc_hd__fill_4
* cell instance sky130_fd_sc_hd__fill_4_790 r0 *1 0,0
Xsky130_fd_sc_hd__fill_4_790 VGND VPWR VPWR sky130_fd_sc_hd__fill_4
* cell instance sky130_fd_sc_hd__fill_4_791 r0 *1 0,0
Xsky130_fd_sc_hd__fill_4_791 VGND VPWR VPWR sky130_fd_sc_hd__fill_4
* cell instance sky130_fd_sc_hd__fill_4_792 r0 *1 0,0
Xsky130_fd_sc_hd__fill_4_792 VGND VPWR VPWR sky130_fd_sc_hd__fill_4
* cell instance sky130_fd_sc_hd__fill_4_793 r0 *1 0,0
Xsky130_fd_sc_hd__fill_4_793 VGND VPWR VPWR sky130_fd_sc_hd__fill_4
* cell instance sky130_fd_sc_hd__fill_4_794 r0 *1 0,0
Xsky130_fd_sc_hd__fill_4_794 VGND VPWR VPWR sky130_fd_sc_hd__fill_4
* cell instance sky130_fd_sc_hd__fill_4_795 r0 *1 0,0
Xsky130_fd_sc_hd__fill_4_795 VGND VPWR VPWR sky130_fd_sc_hd__fill_4
* cell instance sky130_fd_sc_hd__fill_4_796 r0 *1 0,0
Xsky130_fd_sc_hd__fill_4_796 VGND VPWR VPWR sky130_fd_sc_hd__fill_4
* cell instance sky130_fd_sc_hd__fill_4_797 r0 *1 0,0
Xsky130_fd_sc_hd__fill_4_797 VGND VPWR VPWR sky130_fd_sc_hd__fill_4
* cell instance sky130_fd_sc_hd__fill_4_798 r0 *1 0,0
Xsky130_fd_sc_hd__fill_4_798 VGND VPWR VPWR sky130_fd_sc_hd__fill_4
* cell instance sky130_fd_sc_hd__fill_4_799 r0 *1 0,0
Xsky130_fd_sc_hd__fill_4_799 VGND VPWR VPWR sky130_fd_sc_hd__fill_4
* cell instance sky130_fd_sc_hd__fill_4_800 r0 *1 0,0
Xsky130_fd_sc_hd__fill_4_800 VGND VPWR VPWR sky130_fd_sc_hd__fill_4
* cell instance sky130_fd_sc_hd__fill_4_801 r0 *1 0,0
Xsky130_fd_sc_hd__fill_4_801 VGND VPWR VPWR sky130_fd_sc_hd__fill_4
* cell instance sky130_fd_sc_hd__fill_4_802 r0 *1 0,0
Xsky130_fd_sc_hd__fill_4_802 VGND VPWR VPWR sky130_fd_sc_hd__fill_4
* cell instance sky130_fd_sc_hd__fill_4_803 r0 *1 0,0
Xsky130_fd_sc_hd__fill_4_803 VGND VPWR VPWR sky130_fd_sc_hd__fill_4
* cell instance sky130_fd_sc_hd__fill_4_804 r0 *1 0,0
Xsky130_fd_sc_hd__fill_4_804 VGND VPWR VPWR sky130_fd_sc_hd__fill_4
* cell instance sky130_fd_sc_hd__fill_4_805 r0 *1 0,0
Xsky130_fd_sc_hd__fill_4_805 VGND VPWR VPWR sky130_fd_sc_hd__fill_4
* cell instance sky130_fd_sc_hd__fill_4_806 r0 *1 0,0
Xsky130_fd_sc_hd__fill_4_806 VGND VPWR VPWR sky130_fd_sc_hd__fill_4
* cell instance sky130_fd_sc_hd__fill_4_807 r0 *1 0,0
Xsky130_fd_sc_hd__fill_4_807 VGND VPWR VPWR sky130_fd_sc_hd__fill_4
* cell instance sky130_fd_sc_hd__fill_4_808 r0 *1 0,0
Xsky130_fd_sc_hd__fill_4_808 VGND VPWR VPWR sky130_fd_sc_hd__fill_4
* cell instance sky130_fd_sc_hd__fill_4_809 r0 *1 0,0
Xsky130_fd_sc_hd__fill_4_809 VGND VPWR VPWR sky130_fd_sc_hd__fill_4
* cell instance sky130_fd_sc_hd__fill_4_810 r0 *1 0,0
Xsky130_fd_sc_hd__fill_4_810 VGND VPWR VPWR sky130_fd_sc_hd__fill_4
* cell instance sky130_fd_sc_hd__fill_4_811 r0 *1 0,0
Xsky130_fd_sc_hd__fill_4_811 VGND VPWR VPWR sky130_fd_sc_hd__fill_4
* cell instance sky130_fd_sc_hd__fill_4_812 r0 *1 0,0
Xsky130_fd_sc_hd__fill_4_812 VGND VPWR VPWR sky130_fd_sc_hd__fill_4
* cell instance sky130_fd_sc_hd__fill_4_813 r0 *1 0,0
Xsky130_fd_sc_hd__fill_4_813 VGND VPWR VPWR sky130_fd_sc_hd__fill_4
* cell instance sky130_fd_sc_hd__fill_4_814 r0 *1 0,0
Xsky130_fd_sc_hd__fill_4_814 VGND VPWR VPWR sky130_fd_sc_hd__fill_4
* cell instance sky130_fd_sc_hd__fill_4_815 r0 *1 0,0
Xsky130_fd_sc_hd__fill_4_815 VGND VPWR VPWR sky130_fd_sc_hd__fill_4
* cell instance sky130_fd_sc_hd__fill_4_816 r0 *1 0,0
Xsky130_fd_sc_hd__fill_4_816 VGND VPWR VPWR sky130_fd_sc_hd__fill_4
* cell instance sky130_fd_sc_hd__fill_4_817 r0 *1 0,0
Xsky130_fd_sc_hd__fill_4_817 VGND VPWR VPWR sky130_fd_sc_hd__fill_4
* cell instance sky130_fd_sc_hd__fill_4_818 r0 *1 0,0
Xsky130_fd_sc_hd__fill_4_818 VGND VPWR VPWR sky130_fd_sc_hd__fill_4
* cell instance sky130_fd_sc_hd__fill_4_819 r0 *1 0,0
Xsky130_fd_sc_hd__fill_4_819 VGND VPWR VPWR sky130_fd_sc_hd__fill_4
* cell instance sky130_fd_sc_hd__fill_4_820 r0 *1 0,0
Xsky130_fd_sc_hd__fill_4_820 VGND VPWR VPWR sky130_fd_sc_hd__fill_4
* cell instance sky130_fd_sc_hd__fill_4_821 r0 *1 0,0
Xsky130_fd_sc_hd__fill_4_821 VGND VPWR VPWR sky130_fd_sc_hd__fill_4
* cell instance sky130_fd_sc_hd__fill_4_822 r0 *1 0,0
Xsky130_fd_sc_hd__fill_4_822 VGND VPWR VPWR sky130_fd_sc_hd__fill_4
* cell instance sky130_fd_sc_hd__fill_4_823 r0 *1 0,0
Xsky130_fd_sc_hd__fill_4_823 VGND VPWR VPWR sky130_fd_sc_hd__fill_4
* cell instance sky130_fd_sc_hd__fill_4_824 r0 *1 0,0
Xsky130_fd_sc_hd__fill_4_824 VGND VPWR VPWR sky130_fd_sc_hd__fill_4
* cell instance sky130_fd_sc_hd__fill_4_825 r0 *1 0,0
Xsky130_fd_sc_hd__fill_4_825 VGND VPWR VPWR sky130_fd_sc_hd__fill_4
* cell instance sky130_fd_sc_hd__fill_4_826 r0 *1 0,0
Xsky130_fd_sc_hd__fill_4_826 VGND VPWR VPWR sky130_fd_sc_hd__fill_4
* cell instance sky130_fd_sc_hd__fill_4_827 r0 *1 0,0
Xsky130_fd_sc_hd__fill_4_827 VGND VPWR VPWR sky130_fd_sc_hd__fill_4
* cell instance sky130_fd_sc_hd__fill_4_828 r0 *1 0,0
Xsky130_fd_sc_hd__fill_4_828 VGND VPWR VPWR sky130_fd_sc_hd__fill_4
* cell instance sky130_fd_sc_hd__fill_4_829 r0 *1 0,0
Xsky130_fd_sc_hd__fill_4_829 VGND VPWR VPWR sky130_fd_sc_hd__fill_4
* cell instance sky130_fd_sc_hd__fill_4_830 r0 *1 0,0
Xsky130_fd_sc_hd__fill_4_830 VGND VPWR VPWR sky130_fd_sc_hd__fill_4
* cell instance sky130_fd_sc_hd__fill_4_831 r0 *1 0,0
Xsky130_fd_sc_hd__fill_4_831 VGND VPWR VPWR sky130_fd_sc_hd__fill_4
* cell instance sky130_fd_sc_hd__fill_4_832 r0 *1 0,0
Xsky130_fd_sc_hd__fill_4_832 VGND VPWR VPWR sky130_fd_sc_hd__fill_4
* cell instance sky130_fd_sc_hd__fill_4_833 r0 *1 0,0
Xsky130_fd_sc_hd__fill_4_833 VGND VPWR VPWR sky130_fd_sc_hd__fill_4
* cell instance sky130_fd_sc_hd__fill_4_834 r0 *1 0,0
Xsky130_fd_sc_hd__fill_4_834 VGND VPWR VPWR sky130_fd_sc_hd__fill_4
* cell instance sky130_fd_sc_hd__fill_4_835 r0 *1 0,0
Xsky130_fd_sc_hd__fill_4_835 VGND VPWR VPWR sky130_fd_sc_hd__fill_4
* cell instance sky130_fd_sc_hd__fill_4_836 r0 *1 0,0
Xsky130_fd_sc_hd__fill_4_836 VGND VPWR VPWR sky130_fd_sc_hd__fill_4
* cell instance sky130_fd_sc_hd__fill_4_837 r0 *1 0,0
Xsky130_fd_sc_hd__fill_4_837 VGND VPWR VPWR sky130_fd_sc_hd__fill_4
* cell instance sky130_fd_sc_hd__fill_4_838 r0 *1 0,0
Xsky130_fd_sc_hd__fill_4_838 VGND VPWR VPWR sky130_fd_sc_hd__fill_4
* cell instance sky130_fd_sc_hd__fill_4_839 r0 *1 0,0
Xsky130_fd_sc_hd__fill_4_839 VGND VPWR VPWR sky130_fd_sc_hd__fill_4
* cell instance sky130_fd_sc_hd__fill_4_840 r0 *1 0,0
Xsky130_fd_sc_hd__fill_4_840 VGND VPWR VPWR sky130_fd_sc_hd__fill_4
* cell instance sky130_fd_sc_hd__fill_4_841 r0 *1 0,0
Xsky130_fd_sc_hd__fill_4_841 VGND VPWR VPWR sky130_fd_sc_hd__fill_4
* cell instance sky130_fd_sc_hd__fill_4_842 r0 *1 0,0
Xsky130_fd_sc_hd__fill_4_842 VGND VPWR VPWR sky130_fd_sc_hd__fill_4
* cell instance sky130_fd_sc_hd__fill_4_843 r0 *1 0,0
Xsky130_fd_sc_hd__fill_4_843 VGND VPWR VPWR sky130_fd_sc_hd__fill_4
* cell instance sky130_fd_sc_hd__fill_4_844 r0 *1 0,0
Xsky130_fd_sc_hd__fill_4_844 VGND VPWR VPWR sky130_fd_sc_hd__fill_4
* cell instance sky130_fd_sc_hd__fill_4_845 r0 *1 0,0
Xsky130_fd_sc_hd__fill_4_845 VGND VPWR VPWR sky130_fd_sc_hd__fill_4
* cell instance sky130_fd_sc_hd__fill_4_846 r0 *1 0,0
Xsky130_fd_sc_hd__fill_4_846 VGND VPWR VPWR sky130_fd_sc_hd__fill_4
* cell instance sky130_fd_sc_hd__fill_4_847 r0 *1 0,0
Xsky130_fd_sc_hd__fill_4_847 VGND VPWR VPWR sky130_fd_sc_hd__fill_4
* cell instance sky130_fd_sc_hd__fill_4_848 r0 *1 0,0
Xsky130_fd_sc_hd__fill_4_848 VGND VPWR VPWR sky130_fd_sc_hd__fill_4
* cell instance sky130_fd_sc_hd__fill_4_849 r0 *1 0,0
Xsky130_fd_sc_hd__fill_4_849 VGND VPWR VPWR sky130_fd_sc_hd__fill_4
* cell instance sky130_fd_sc_hd__fill_4_850 r0 *1 0,0
Xsky130_fd_sc_hd__fill_4_850 VGND VPWR VPWR sky130_fd_sc_hd__fill_4
* cell instance sky130_fd_sc_hd__fill_4_851 r0 *1 0,0
Xsky130_fd_sc_hd__fill_4_851 VGND VPWR VPWR sky130_fd_sc_hd__fill_4
* cell instance sky130_fd_sc_hd__fill_4_852 r0 *1 0,0
Xsky130_fd_sc_hd__fill_4_852 VGND VPWR VPWR sky130_fd_sc_hd__fill_4
* cell instance sky130_fd_sc_hd__fill_4_853 r0 *1 0,0
Xsky130_fd_sc_hd__fill_4_853 VGND VPWR VPWR sky130_fd_sc_hd__fill_4
* cell instance sky130_fd_sc_hd__fill_4_854 r0 *1 0,0
Xsky130_fd_sc_hd__fill_4_854 VGND VPWR VPWR sky130_fd_sc_hd__fill_4
* cell instance sky130_fd_sc_hd__fill_4_855 r0 *1 0,0
Xsky130_fd_sc_hd__fill_4_855 VGND VPWR VPWR sky130_fd_sc_hd__fill_4
* cell instance sky130_fd_sc_hd__fill_4_856 r0 *1 0,0
Xsky130_fd_sc_hd__fill_4_856 VGND VPWR VPWR sky130_fd_sc_hd__fill_4
* cell instance sky130_fd_sc_hd__fill_4_857 r0 *1 0,0
Xsky130_fd_sc_hd__fill_4_857 VGND VPWR VPWR sky130_fd_sc_hd__fill_4
* cell instance sky130_fd_sc_hd__fill_4_858 r0 *1 0,0
Xsky130_fd_sc_hd__fill_4_858 VGND VPWR VPWR sky130_fd_sc_hd__fill_4
* cell instance sky130_fd_sc_hd__fill_4_859 r0 *1 0,0
Xsky130_fd_sc_hd__fill_4_859 VGND VPWR VPWR sky130_fd_sc_hd__fill_4
* cell instance sky130_fd_sc_hd__fill_4_860 r0 *1 0,0
Xsky130_fd_sc_hd__fill_4_860 VGND VPWR VPWR sky130_fd_sc_hd__fill_4
* cell instance sky130_fd_sc_hd__fill_8_0 r0 *1 0,0
Xsky130_fd_sc_hd__fill_8_0 VGND VPWR VPWR sky130_fd_sc_hd__fill_8
* cell instance sky130_fd_sc_hd__fill_8_1 r0 *1 0,0
Xsky130_fd_sc_hd__fill_8_1 VGND VPWR VPWR sky130_fd_sc_hd__fill_8
* cell instance sky130_fd_sc_hd__fill_8_2 r0 *1 0,0
Xsky130_fd_sc_hd__fill_8_2 VGND VPWR VPWR sky130_fd_sc_hd__fill_8
* cell instance sky130_fd_sc_hd__fill_8_3 r0 *1 0,0
Xsky130_fd_sc_hd__fill_8_3 VGND VPWR VPWR sky130_fd_sc_hd__fill_8
* cell instance sky130_fd_sc_hd__fill_8_4 r0 *1 0,0
Xsky130_fd_sc_hd__fill_8_4 VGND VPWR VPWR sky130_fd_sc_hd__fill_8
* cell instance sky130_fd_sc_hd__fill_8_5 r0 *1 0,0
Xsky130_fd_sc_hd__fill_8_5 VGND VPWR VPWR sky130_fd_sc_hd__fill_8
* cell instance sky130_fd_sc_hd__fill_8_6 r0 *1 0,0
Xsky130_fd_sc_hd__fill_8_6 VGND VPWR VPWR sky130_fd_sc_hd__fill_8
* cell instance sky130_fd_sc_hd__fill_8_7 r0 *1 0,0
Xsky130_fd_sc_hd__fill_8_7 VGND VPWR VPWR sky130_fd_sc_hd__fill_8
* cell instance sky130_fd_sc_hd__fill_8_8 r0 *1 0,0
Xsky130_fd_sc_hd__fill_8_8 VGND VPWR VPWR sky130_fd_sc_hd__fill_8
* cell instance sky130_fd_sc_hd__fill_8_9 r0 *1 0,0
Xsky130_fd_sc_hd__fill_8_9 VGND VPWR VPWR sky130_fd_sc_hd__fill_8
* cell instance sky130_fd_sc_hd__fill_8_10 r0 *1 0,0
Xsky130_fd_sc_hd__fill_8_10 VGND VPWR VPWR sky130_fd_sc_hd__fill_8
* cell instance sky130_fd_sc_hd__fill_8_11 r0 *1 0,0
Xsky130_fd_sc_hd__fill_8_11 VGND VPWR VPWR sky130_fd_sc_hd__fill_8
* cell instance sky130_fd_sc_hd__fill_8_12 r0 *1 0,0
Xsky130_fd_sc_hd__fill_8_12 VGND VPWR VPWR sky130_fd_sc_hd__fill_8
* cell instance sky130_fd_sc_hd__fill_8_13 r0 *1 0,0
Xsky130_fd_sc_hd__fill_8_13 VGND VPWR VPWR sky130_fd_sc_hd__fill_8
* cell instance sky130_fd_sc_hd__fill_8_14 r0 *1 0,0
Xsky130_fd_sc_hd__fill_8_14 VGND VPWR VPWR sky130_fd_sc_hd__fill_8
* cell instance sky130_fd_sc_hd__fill_8_15 r0 *1 0,0
Xsky130_fd_sc_hd__fill_8_15 VGND VPWR VPWR sky130_fd_sc_hd__fill_8
* cell instance sky130_fd_sc_hd__fill_8_16 r0 *1 0,0
Xsky130_fd_sc_hd__fill_8_16 VGND VPWR VPWR sky130_fd_sc_hd__fill_8
* cell instance sky130_fd_sc_hd__fill_8_17 r0 *1 0,0
Xsky130_fd_sc_hd__fill_8_17 VGND VPWR VPWR sky130_fd_sc_hd__fill_8
* cell instance sky130_fd_sc_hd__fill_8_18 r0 *1 0,0
Xsky130_fd_sc_hd__fill_8_18 VGND VPWR VPWR sky130_fd_sc_hd__fill_8
* cell instance sky130_fd_sc_hd__fill_8_19 r0 *1 0,0
Xsky130_fd_sc_hd__fill_8_19 VGND VPWR VPWR sky130_fd_sc_hd__fill_8
* cell instance sky130_fd_sc_hd__fill_8_20 r0 *1 0,0
Xsky130_fd_sc_hd__fill_8_20 VGND VPWR VPWR sky130_fd_sc_hd__fill_8
* cell instance sky130_fd_sc_hd__fill_8_21 r0 *1 0,0
Xsky130_fd_sc_hd__fill_8_21 VGND VPWR VPWR sky130_fd_sc_hd__fill_8
* cell instance sky130_fd_sc_hd__fill_8_22 r0 *1 0,0
Xsky130_fd_sc_hd__fill_8_22 VGND VPWR VPWR sky130_fd_sc_hd__fill_8
* cell instance sky130_fd_sc_hd__fill_8_23 r0 *1 0,0
Xsky130_fd_sc_hd__fill_8_23 VGND VPWR VPWR sky130_fd_sc_hd__fill_8
* cell instance sky130_fd_sc_hd__fill_8_24 r0 *1 0,0
Xsky130_fd_sc_hd__fill_8_24 VGND VPWR VPWR sky130_fd_sc_hd__fill_8
* cell instance sky130_fd_sc_hd__fill_8_25 r0 *1 0,0
Xsky130_fd_sc_hd__fill_8_25 VGND VPWR VPWR sky130_fd_sc_hd__fill_8
* cell instance sky130_fd_sc_hd__fill_8_26 r0 *1 0,0
Xsky130_fd_sc_hd__fill_8_26 VGND VPWR VPWR sky130_fd_sc_hd__fill_8
* cell instance sky130_fd_sc_hd__fill_8_27 r0 *1 0,0
Xsky130_fd_sc_hd__fill_8_27 VGND VPWR VPWR sky130_fd_sc_hd__fill_8
* cell instance sky130_fd_sc_hd__fill_8_28 r0 *1 0,0
Xsky130_fd_sc_hd__fill_8_28 VGND VPWR VPWR sky130_fd_sc_hd__fill_8
* cell instance sky130_fd_sc_hd__fill_8_29 r0 *1 0,0
Xsky130_fd_sc_hd__fill_8_29 VGND VPWR VPWR sky130_fd_sc_hd__fill_8
* cell instance sky130_fd_sc_hd__fill_8_30 r0 *1 0,0
Xsky130_fd_sc_hd__fill_8_30 VGND VPWR VPWR sky130_fd_sc_hd__fill_8
* cell instance sky130_fd_sc_hd__fill_8_31 r0 *1 0,0
Xsky130_fd_sc_hd__fill_8_31 VGND VPWR VPWR sky130_fd_sc_hd__fill_8
* cell instance sky130_fd_sc_hd__fill_8_32 r0 *1 0,0
Xsky130_fd_sc_hd__fill_8_32 VGND VPWR VPWR sky130_fd_sc_hd__fill_8
* cell instance sky130_fd_sc_hd__fill_8_33 r0 *1 0,0
Xsky130_fd_sc_hd__fill_8_33 VGND VPWR VPWR sky130_fd_sc_hd__fill_8
* cell instance sky130_fd_sc_hd__fill_8_34 r0 *1 0,0
Xsky130_fd_sc_hd__fill_8_34 VGND VPWR VPWR sky130_fd_sc_hd__fill_8
* cell instance sky130_fd_sc_hd__fill_8_35 r0 *1 0,0
Xsky130_fd_sc_hd__fill_8_35 VGND VPWR VPWR sky130_fd_sc_hd__fill_8
* cell instance sky130_fd_sc_hd__fill_8_36 r0 *1 0,0
Xsky130_fd_sc_hd__fill_8_36 VGND VPWR VPWR sky130_fd_sc_hd__fill_8
* cell instance sky130_fd_sc_hd__fill_8_37 r0 *1 0,0
Xsky130_fd_sc_hd__fill_8_37 VGND VPWR VPWR sky130_fd_sc_hd__fill_8
* cell instance sky130_fd_sc_hd__fill_8_38 r0 *1 0,0
Xsky130_fd_sc_hd__fill_8_38 VGND VPWR VPWR sky130_fd_sc_hd__fill_8
* cell instance sky130_fd_sc_hd__fill_8_39 r0 *1 0,0
Xsky130_fd_sc_hd__fill_8_39 VGND VPWR VPWR sky130_fd_sc_hd__fill_8
* cell instance sky130_fd_sc_hd__fill_8_40 r0 *1 0,0
Xsky130_fd_sc_hd__fill_8_40 VGND VPWR VPWR sky130_fd_sc_hd__fill_8
* cell instance sky130_fd_sc_hd__fill_8_41 r0 *1 0,0
Xsky130_fd_sc_hd__fill_8_41 VGND VPWR VPWR sky130_fd_sc_hd__fill_8
* cell instance sky130_fd_sc_hd__fill_8_42 r0 *1 0,0
Xsky130_fd_sc_hd__fill_8_42 VGND VPWR VPWR sky130_fd_sc_hd__fill_8
* cell instance sky130_fd_sc_hd__fill_8_43 r0 *1 0,0
Xsky130_fd_sc_hd__fill_8_43 VGND VPWR VPWR sky130_fd_sc_hd__fill_8
* cell instance sky130_fd_sc_hd__fill_8_44 r0 *1 0,0
Xsky130_fd_sc_hd__fill_8_44 VGND VPWR VPWR sky130_fd_sc_hd__fill_8
* cell instance sky130_fd_sc_hd__fill_8_45 r0 *1 0,0
Xsky130_fd_sc_hd__fill_8_45 VGND VPWR VPWR sky130_fd_sc_hd__fill_8
* cell instance sky130_fd_sc_hd__fill_8_46 r0 *1 0,0
Xsky130_fd_sc_hd__fill_8_46 VGND VPWR VPWR sky130_fd_sc_hd__fill_8
* cell instance sky130_fd_sc_hd__fill_8_47 r0 *1 0,0
Xsky130_fd_sc_hd__fill_8_47 VGND VPWR VPWR sky130_fd_sc_hd__fill_8
* cell instance sky130_fd_sc_hd__fill_8_48 r0 *1 0,0
Xsky130_fd_sc_hd__fill_8_48 VGND VPWR VPWR sky130_fd_sc_hd__fill_8
* cell instance sky130_fd_sc_hd__fill_8_49 r0 *1 0,0
Xsky130_fd_sc_hd__fill_8_49 VGND VPWR VPWR sky130_fd_sc_hd__fill_8
* cell instance sky130_fd_sc_hd__fill_8_50 r0 *1 0,0
Xsky130_fd_sc_hd__fill_8_50 VGND VPWR VPWR sky130_fd_sc_hd__fill_8
* cell instance sky130_fd_sc_hd__fill_8_51 r0 *1 0,0
Xsky130_fd_sc_hd__fill_8_51 VGND VPWR VPWR sky130_fd_sc_hd__fill_8
* cell instance sky130_fd_sc_hd__fill_8_52 r0 *1 0,0
Xsky130_fd_sc_hd__fill_8_52 VGND VPWR VPWR sky130_fd_sc_hd__fill_8
* cell instance sky130_fd_sc_hd__fill_8_53 r0 *1 0,0
Xsky130_fd_sc_hd__fill_8_53 VGND VPWR VPWR sky130_fd_sc_hd__fill_8
* cell instance sky130_fd_sc_hd__fill_8_54 r0 *1 0,0
Xsky130_fd_sc_hd__fill_8_54 VGND VPWR VPWR sky130_fd_sc_hd__fill_8
* cell instance sky130_fd_sc_hd__fill_8_55 r0 *1 0,0
Xsky130_fd_sc_hd__fill_8_55 VGND VPWR VPWR sky130_fd_sc_hd__fill_8
* cell instance sky130_fd_sc_hd__fill_8_56 r0 *1 0,0
Xsky130_fd_sc_hd__fill_8_56 VGND VPWR VPWR sky130_fd_sc_hd__fill_8
* cell instance sky130_fd_sc_hd__fill_8_57 r0 *1 0,0
Xsky130_fd_sc_hd__fill_8_57 VGND VPWR VPWR sky130_fd_sc_hd__fill_8
* cell instance sky130_fd_sc_hd__fill_8_58 r0 *1 0,0
Xsky130_fd_sc_hd__fill_8_58 VGND VPWR VPWR sky130_fd_sc_hd__fill_8
* cell instance sky130_fd_sc_hd__fill_8_59 r0 *1 0,0
Xsky130_fd_sc_hd__fill_8_59 VGND VPWR VPWR sky130_fd_sc_hd__fill_8
* cell instance sky130_fd_sc_hd__fill_8_60 r0 *1 0,0
Xsky130_fd_sc_hd__fill_8_60 VGND VPWR VPWR sky130_fd_sc_hd__fill_8
* cell instance sky130_fd_sc_hd__fill_8_61 r0 *1 0,0
Xsky130_fd_sc_hd__fill_8_61 VGND VPWR VPWR sky130_fd_sc_hd__fill_8
* cell instance sky130_fd_sc_hd__fill_8_62 r0 *1 0,0
Xsky130_fd_sc_hd__fill_8_62 VGND VPWR VPWR sky130_fd_sc_hd__fill_8
* cell instance sky130_fd_sc_hd__fill_8_63 r0 *1 0,0
Xsky130_fd_sc_hd__fill_8_63 VGND VPWR VPWR sky130_fd_sc_hd__fill_8
* cell instance sky130_fd_sc_hd__fill_8_64 r0 *1 0,0
Xsky130_fd_sc_hd__fill_8_64 VGND VPWR VPWR sky130_fd_sc_hd__fill_8
* cell instance sky130_fd_sc_hd__fill_8_65 r0 *1 0,0
Xsky130_fd_sc_hd__fill_8_65 VGND VPWR VPWR sky130_fd_sc_hd__fill_8
* cell instance sky130_fd_sc_hd__fill_8_66 r0 *1 0,0
Xsky130_fd_sc_hd__fill_8_66 VGND VPWR VPWR sky130_fd_sc_hd__fill_8
* cell instance sky130_fd_sc_hd__fill_8_67 r0 *1 0,0
Xsky130_fd_sc_hd__fill_8_67 VGND VPWR VPWR sky130_fd_sc_hd__fill_8
* cell instance sky130_fd_sc_hd__fill_8_68 r0 *1 0,0
Xsky130_fd_sc_hd__fill_8_68 VGND VPWR VPWR sky130_fd_sc_hd__fill_8
* cell instance sky130_fd_sc_hd__fill_8_69 r0 *1 0,0
Xsky130_fd_sc_hd__fill_8_69 VGND VPWR VPWR sky130_fd_sc_hd__fill_8
* cell instance sky130_fd_sc_hd__fill_8_70 r0 *1 0,0
Xsky130_fd_sc_hd__fill_8_70 VGND VPWR VPWR sky130_fd_sc_hd__fill_8
* cell instance sky130_fd_sc_hd__fill_8_71 r0 *1 0,0
Xsky130_fd_sc_hd__fill_8_71 VGND VPWR VPWR sky130_fd_sc_hd__fill_8
* cell instance sky130_fd_sc_hd__fill_8_72 r0 *1 0,0
Xsky130_fd_sc_hd__fill_8_72 VGND VPWR VPWR sky130_fd_sc_hd__fill_8
* cell instance sky130_fd_sc_hd__fill_8_73 r0 *1 0,0
Xsky130_fd_sc_hd__fill_8_73 VGND VPWR VPWR sky130_fd_sc_hd__fill_8
* cell instance sky130_fd_sc_hd__fill_8_74 r0 *1 0,0
Xsky130_fd_sc_hd__fill_8_74 VGND VPWR VPWR sky130_fd_sc_hd__fill_8
* cell instance sky130_fd_sc_hd__fill_8_75 r0 *1 0,0
Xsky130_fd_sc_hd__fill_8_75 VGND VPWR VPWR sky130_fd_sc_hd__fill_8
* cell instance sky130_fd_sc_hd__fill_8_76 r0 *1 0,0
Xsky130_fd_sc_hd__fill_8_76 VGND VPWR VPWR sky130_fd_sc_hd__fill_8
* cell instance sky130_fd_sc_hd__fill_8_77 r0 *1 0,0
Xsky130_fd_sc_hd__fill_8_77 VGND VPWR VPWR sky130_fd_sc_hd__fill_8
* cell instance sky130_fd_sc_hd__fill_8_78 r0 *1 0,0
Xsky130_fd_sc_hd__fill_8_78 VGND VPWR VPWR sky130_fd_sc_hd__fill_8
* cell instance sky130_fd_sc_hd__fill_8_79 r0 *1 0,0
Xsky130_fd_sc_hd__fill_8_79 VGND VPWR VPWR sky130_fd_sc_hd__fill_8
* cell instance sky130_fd_sc_hd__fill_8_80 r0 *1 0,0
Xsky130_fd_sc_hd__fill_8_80 VGND VPWR VPWR sky130_fd_sc_hd__fill_8
* cell instance sky130_fd_sc_hd__fill_8_81 r0 *1 0,0
Xsky130_fd_sc_hd__fill_8_81 VGND VPWR VPWR sky130_fd_sc_hd__fill_8
* cell instance sky130_fd_sc_hd__fill_8_82 r0 *1 0,0
Xsky130_fd_sc_hd__fill_8_82 VGND VPWR VPWR sky130_fd_sc_hd__fill_8
* cell instance sky130_fd_sc_hd__fill_8_83 r0 *1 0,0
Xsky130_fd_sc_hd__fill_8_83 VGND VPWR VPWR sky130_fd_sc_hd__fill_8
* cell instance sky130_fd_sc_hd__fill_8_84 r0 *1 0,0
Xsky130_fd_sc_hd__fill_8_84 VGND VPWR VPWR sky130_fd_sc_hd__fill_8
* cell instance sky130_fd_sc_hd__fill_8_85 r0 *1 0,0
Xsky130_fd_sc_hd__fill_8_85 VGND VPWR VPWR sky130_fd_sc_hd__fill_8
* cell instance sky130_fd_sc_hd__fill_8_86 r0 *1 0,0
Xsky130_fd_sc_hd__fill_8_86 VGND VPWR VPWR sky130_fd_sc_hd__fill_8
* cell instance sky130_fd_sc_hd__fill_8_87 r0 *1 0,0
Xsky130_fd_sc_hd__fill_8_87 VGND VPWR VPWR sky130_fd_sc_hd__fill_8
* cell instance sky130_fd_sc_hd__fill_8_88 r0 *1 0,0
Xsky130_fd_sc_hd__fill_8_88 VGND VPWR VPWR sky130_fd_sc_hd__fill_8
* cell instance sky130_fd_sc_hd__fill_8_89 r0 *1 0,0
Xsky130_fd_sc_hd__fill_8_89 VGND VPWR VPWR sky130_fd_sc_hd__fill_8
* cell instance sky130_fd_sc_hd__fill_8_90 r0 *1 0,0
Xsky130_fd_sc_hd__fill_8_90 VGND VPWR VPWR sky130_fd_sc_hd__fill_8
* cell instance sky130_fd_sc_hd__fill_8_91 r0 *1 0,0
Xsky130_fd_sc_hd__fill_8_91 VGND VPWR VPWR sky130_fd_sc_hd__fill_8
* cell instance sky130_fd_sc_hd__fill_8_92 r0 *1 0,0
Xsky130_fd_sc_hd__fill_8_92 VGND VPWR VPWR sky130_fd_sc_hd__fill_8
* cell instance sky130_fd_sc_hd__fill_8_93 r0 *1 0,0
Xsky130_fd_sc_hd__fill_8_93 VGND VPWR VPWR sky130_fd_sc_hd__fill_8
* cell instance sky130_fd_sc_hd__fill_8_94 r0 *1 0,0
Xsky130_fd_sc_hd__fill_8_94 VGND VPWR VPWR sky130_fd_sc_hd__fill_8
* cell instance sky130_fd_sc_hd__fill_8_95 r0 *1 0,0
Xsky130_fd_sc_hd__fill_8_95 VGND VPWR VPWR sky130_fd_sc_hd__fill_8
* cell instance sky130_fd_sc_hd__fill_8_96 r0 *1 0,0
Xsky130_fd_sc_hd__fill_8_96 VGND VPWR VPWR sky130_fd_sc_hd__fill_8
* cell instance sky130_fd_sc_hd__fill_8_97 r0 *1 0,0
Xsky130_fd_sc_hd__fill_8_97 VGND VPWR VPWR sky130_fd_sc_hd__fill_8
* cell instance sky130_fd_sc_hd__fill_8_98 r0 *1 0,0
Xsky130_fd_sc_hd__fill_8_98 VGND VPWR VPWR sky130_fd_sc_hd__fill_8
* cell instance sky130_fd_sc_hd__fill_8_99 r0 *1 0,0
Xsky130_fd_sc_hd__fill_8_99 VGND VPWR VPWR sky130_fd_sc_hd__fill_8
* cell instance sky130_fd_sc_hd__fill_8_100 r0 *1 0,0
Xsky130_fd_sc_hd__fill_8_100 VGND VPWR VPWR sky130_fd_sc_hd__fill_8
* cell instance sky130_fd_sc_hd__fill_8_101 r0 *1 0,0
Xsky130_fd_sc_hd__fill_8_101 VGND VPWR VPWR sky130_fd_sc_hd__fill_8
* cell instance sky130_fd_sc_hd__fill_8_102 r0 *1 0,0
Xsky130_fd_sc_hd__fill_8_102 VGND VPWR VPWR sky130_fd_sc_hd__fill_8
* cell instance sky130_fd_sc_hd__fill_8_103 r0 *1 0,0
Xsky130_fd_sc_hd__fill_8_103 VGND VPWR VPWR sky130_fd_sc_hd__fill_8
* cell instance sky130_fd_sc_hd__fill_8_104 r0 *1 0,0
Xsky130_fd_sc_hd__fill_8_104 VGND VPWR VPWR sky130_fd_sc_hd__fill_8
* cell instance sky130_fd_sc_hd__fill_8_105 r0 *1 0,0
Xsky130_fd_sc_hd__fill_8_105 VGND VPWR VPWR sky130_fd_sc_hd__fill_8
* cell instance sky130_fd_sc_hd__fill_8_106 r0 *1 0,0
Xsky130_fd_sc_hd__fill_8_106 VGND VPWR VPWR sky130_fd_sc_hd__fill_8
* cell instance sky130_fd_sc_hd__fill_8_107 r0 *1 0,0
Xsky130_fd_sc_hd__fill_8_107 VGND VPWR VPWR sky130_fd_sc_hd__fill_8
* cell instance sky130_fd_sc_hd__fill_8_108 r0 *1 0,0
Xsky130_fd_sc_hd__fill_8_108 VGND VPWR VPWR sky130_fd_sc_hd__fill_8
* cell instance sky130_fd_sc_hd__fill_8_109 r0 *1 0,0
Xsky130_fd_sc_hd__fill_8_109 VGND VPWR VPWR sky130_fd_sc_hd__fill_8
* cell instance sky130_fd_sc_hd__fill_8_110 r0 *1 0,0
Xsky130_fd_sc_hd__fill_8_110 VGND VPWR VPWR sky130_fd_sc_hd__fill_8
* cell instance sky130_fd_sc_hd__fill_8_111 r0 *1 0,0
Xsky130_fd_sc_hd__fill_8_111 VGND VPWR VPWR sky130_fd_sc_hd__fill_8
* cell instance sky130_fd_sc_hd__fill_8_112 r0 *1 0,0
Xsky130_fd_sc_hd__fill_8_112 VGND VPWR VPWR sky130_fd_sc_hd__fill_8
* cell instance sky130_fd_sc_hd__fill_8_113 r0 *1 0,0
Xsky130_fd_sc_hd__fill_8_113 VGND VPWR VPWR sky130_fd_sc_hd__fill_8
* cell instance sky130_fd_sc_hd__fill_8_114 r0 *1 0,0
Xsky130_fd_sc_hd__fill_8_114 VGND VPWR VPWR sky130_fd_sc_hd__fill_8
* cell instance sky130_fd_sc_hd__fill_8_115 r0 *1 0,0
Xsky130_fd_sc_hd__fill_8_115 VGND VPWR VPWR sky130_fd_sc_hd__fill_8
* cell instance sky130_fd_sc_hd__fill_8_116 r0 *1 0,0
Xsky130_fd_sc_hd__fill_8_116 VGND VPWR VPWR sky130_fd_sc_hd__fill_8
* cell instance sky130_fd_sc_hd__fill_8_117 r0 *1 0,0
Xsky130_fd_sc_hd__fill_8_117 VGND VPWR VPWR sky130_fd_sc_hd__fill_8
* cell instance sky130_fd_sc_hd__fill_8_118 r0 *1 0,0
Xsky130_fd_sc_hd__fill_8_118 VGND VPWR VPWR sky130_fd_sc_hd__fill_8
* cell instance sky130_fd_sc_hd__fill_8_119 r0 *1 0,0
Xsky130_fd_sc_hd__fill_8_119 VGND VPWR VPWR sky130_fd_sc_hd__fill_8
* cell instance sky130_fd_sc_hd__fill_8_120 r0 *1 0,0
Xsky130_fd_sc_hd__fill_8_120 VGND VPWR VPWR sky130_fd_sc_hd__fill_8
* cell instance sky130_fd_sc_hd__fill_8_121 r0 *1 0,0
Xsky130_fd_sc_hd__fill_8_121 VGND VPWR VPWR sky130_fd_sc_hd__fill_8
* cell instance sky130_fd_sc_hd__fill_8_122 r0 *1 0,0
Xsky130_fd_sc_hd__fill_8_122 VGND VPWR VPWR sky130_fd_sc_hd__fill_8
* cell instance sky130_fd_sc_hd__fill_8_123 r0 *1 0,0
Xsky130_fd_sc_hd__fill_8_123 VGND VPWR VPWR sky130_fd_sc_hd__fill_8
* cell instance sky130_fd_sc_hd__fill_8_124 r0 *1 0,0
Xsky130_fd_sc_hd__fill_8_124 VGND VPWR VPWR sky130_fd_sc_hd__fill_8
* cell instance sky130_fd_sc_hd__fill_8_125 r0 *1 0,0
Xsky130_fd_sc_hd__fill_8_125 VGND VPWR VPWR sky130_fd_sc_hd__fill_8
* cell instance sky130_fd_sc_hd__fill_8_126 r0 *1 0,0
Xsky130_fd_sc_hd__fill_8_126 VGND VPWR VPWR sky130_fd_sc_hd__fill_8
* cell instance sky130_fd_sc_hd__fill_8_127 r0 *1 0,0
Xsky130_fd_sc_hd__fill_8_127 VGND VPWR VPWR sky130_fd_sc_hd__fill_8
* cell instance sky130_fd_sc_hd__fill_8_128 r0 *1 0,0
Xsky130_fd_sc_hd__fill_8_128 VGND VPWR VPWR sky130_fd_sc_hd__fill_8
* cell instance sky130_fd_sc_hd__fill_8_129 r0 *1 0,0
Xsky130_fd_sc_hd__fill_8_129 VGND VPWR VPWR sky130_fd_sc_hd__fill_8
* cell instance sky130_fd_sc_hd__fill_8_130 r0 *1 0,0
Xsky130_fd_sc_hd__fill_8_130 VGND VPWR VPWR sky130_fd_sc_hd__fill_8
* cell instance sky130_fd_sc_hd__fill_8_131 r0 *1 0,0
Xsky130_fd_sc_hd__fill_8_131 VGND VPWR VPWR sky130_fd_sc_hd__fill_8
* cell instance sky130_fd_sc_hd__fill_8_132 r0 *1 0,0
Xsky130_fd_sc_hd__fill_8_132 VGND VPWR VPWR sky130_fd_sc_hd__fill_8
* cell instance sky130_fd_sc_hd__fill_8_133 r0 *1 0,0
Xsky130_fd_sc_hd__fill_8_133 VGND VPWR VPWR sky130_fd_sc_hd__fill_8
* cell instance sky130_fd_sc_hd__fill_8_134 r0 *1 0,0
Xsky130_fd_sc_hd__fill_8_134 VGND VPWR VPWR sky130_fd_sc_hd__fill_8
* cell instance sky130_fd_sc_hd__fill_8_135 r0 *1 0,0
Xsky130_fd_sc_hd__fill_8_135 VGND VPWR VPWR sky130_fd_sc_hd__fill_8
* cell instance sky130_fd_sc_hd__fill_8_136 r0 *1 0,0
Xsky130_fd_sc_hd__fill_8_136 VGND VPWR VPWR sky130_fd_sc_hd__fill_8
* cell instance sky130_fd_sc_hd__fill_8_137 r0 *1 0,0
Xsky130_fd_sc_hd__fill_8_137 VGND VPWR VPWR sky130_fd_sc_hd__fill_8
* cell instance sky130_fd_sc_hd__fill_8_138 r0 *1 0,0
Xsky130_fd_sc_hd__fill_8_138 VGND VPWR VPWR sky130_fd_sc_hd__fill_8
* cell instance sky130_fd_sc_hd__fill_8_139 r0 *1 0,0
Xsky130_fd_sc_hd__fill_8_139 VGND VPWR VPWR sky130_fd_sc_hd__fill_8
* cell instance sky130_fd_sc_hd__fill_8_140 r0 *1 0,0
Xsky130_fd_sc_hd__fill_8_140 VGND VPWR VPWR sky130_fd_sc_hd__fill_8
* cell instance sky130_fd_sc_hd__fill_8_141 r0 *1 0,0
Xsky130_fd_sc_hd__fill_8_141 VGND VPWR VPWR sky130_fd_sc_hd__fill_8
* cell instance sky130_fd_sc_hd__fill_8_142 r0 *1 0,0
Xsky130_fd_sc_hd__fill_8_142 VGND VPWR VPWR sky130_fd_sc_hd__fill_8
* cell instance sky130_fd_sc_hd__fill_8_143 r0 *1 0,0
Xsky130_fd_sc_hd__fill_8_143 VGND VPWR VPWR sky130_fd_sc_hd__fill_8
* cell instance sky130_fd_sc_hd__fill_8_144 r0 *1 0,0
Xsky130_fd_sc_hd__fill_8_144 VGND VPWR VPWR sky130_fd_sc_hd__fill_8
* cell instance sky130_fd_sc_hd__fill_8_145 r0 *1 0,0
Xsky130_fd_sc_hd__fill_8_145 VGND VPWR VPWR sky130_fd_sc_hd__fill_8
* cell instance sky130_fd_sc_hd__fill_8_146 r0 *1 0,0
Xsky130_fd_sc_hd__fill_8_146 VGND VPWR VPWR sky130_fd_sc_hd__fill_8
* cell instance sky130_fd_sc_hd__fill_8_147 r0 *1 0,0
Xsky130_fd_sc_hd__fill_8_147 VGND VPWR VPWR sky130_fd_sc_hd__fill_8
* cell instance sky130_fd_sc_hd__fill_8_148 r0 *1 0,0
Xsky130_fd_sc_hd__fill_8_148 VGND VPWR VPWR sky130_fd_sc_hd__fill_8
* cell instance sky130_fd_sc_hd__fill_8_149 r0 *1 0,0
Xsky130_fd_sc_hd__fill_8_149 VGND VPWR VPWR sky130_fd_sc_hd__fill_8
* cell instance sky130_fd_sc_hd__fill_8_150 r0 *1 0,0
Xsky130_fd_sc_hd__fill_8_150 VGND VPWR VPWR sky130_fd_sc_hd__fill_8
* cell instance sky130_fd_sc_hd__fill_8_151 r0 *1 0,0
Xsky130_fd_sc_hd__fill_8_151 VGND VPWR VPWR sky130_fd_sc_hd__fill_8
* cell instance sky130_fd_sc_hd__fill_8_152 r0 *1 0,0
Xsky130_fd_sc_hd__fill_8_152 VGND VPWR VPWR sky130_fd_sc_hd__fill_8
* cell instance sky130_fd_sc_hd__fill_8_153 r0 *1 0,0
Xsky130_fd_sc_hd__fill_8_153 VGND VPWR VPWR sky130_fd_sc_hd__fill_8
* cell instance sky130_fd_sc_hd__fill_8_154 r0 *1 0,0
Xsky130_fd_sc_hd__fill_8_154 VGND VPWR VPWR sky130_fd_sc_hd__fill_8
* cell instance sky130_fd_sc_hd__fill_8_155 r0 *1 0,0
Xsky130_fd_sc_hd__fill_8_155 VGND VPWR VPWR sky130_fd_sc_hd__fill_8
* cell instance sky130_fd_sc_hd__fill_8_156 r0 *1 0,0
Xsky130_fd_sc_hd__fill_8_156 VGND VPWR VPWR sky130_fd_sc_hd__fill_8
* cell instance sky130_fd_sc_hd__fill_8_157 r0 *1 0,0
Xsky130_fd_sc_hd__fill_8_157 VGND VPWR VPWR sky130_fd_sc_hd__fill_8
* cell instance sky130_fd_sc_hd__fill_8_158 r0 *1 0,0
Xsky130_fd_sc_hd__fill_8_158 VGND VPWR VPWR sky130_fd_sc_hd__fill_8
* cell instance sky130_fd_sc_hd__fill_8_159 r0 *1 0,0
Xsky130_fd_sc_hd__fill_8_159 VGND VPWR VPWR sky130_fd_sc_hd__fill_8
* cell instance sky130_fd_sc_hd__fill_8_160 r0 *1 0,0
Xsky130_fd_sc_hd__fill_8_160 VGND VPWR VPWR sky130_fd_sc_hd__fill_8
* cell instance sky130_fd_sc_hd__fill_8_161 r0 *1 0,0
Xsky130_fd_sc_hd__fill_8_161 VGND VPWR VPWR sky130_fd_sc_hd__fill_8
* cell instance sky130_fd_sc_hd__fill_8_162 r0 *1 0,0
Xsky130_fd_sc_hd__fill_8_162 VGND VPWR VPWR sky130_fd_sc_hd__fill_8
* cell instance sky130_fd_sc_hd__fill_8_163 r0 *1 0,0
Xsky130_fd_sc_hd__fill_8_163 VGND VPWR VPWR sky130_fd_sc_hd__fill_8
* cell instance sky130_fd_sc_hd__fill_8_164 r0 *1 0,0
Xsky130_fd_sc_hd__fill_8_164 VGND VPWR VPWR sky130_fd_sc_hd__fill_8
* cell instance sky130_fd_sc_hd__fill_8_165 r0 *1 0,0
Xsky130_fd_sc_hd__fill_8_165 VGND VPWR VPWR sky130_fd_sc_hd__fill_8
* cell instance sky130_fd_sc_hd__fill_8_166 r0 *1 0,0
Xsky130_fd_sc_hd__fill_8_166 VGND VPWR VPWR sky130_fd_sc_hd__fill_8
* cell instance sky130_fd_sc_hd__fill_8_167 r0 *1 0,0
Xsky130_fd_sc_hd__fill_8_167 VGND VPWR VPWR sky130_fd_sc_hd__fill_8
* cell instance sky130_fd_sc_hd__fill_8_168 r0 *1 0,0
Xsky130_fd_sc_hd__fill_8_168 VGND VPWR VPWR sky130_fd_sc_hd__fill_8
* cell instance sky130_fd_sc_hd__fill_8_169 r0 *1 0,0
Xsky130_fd_sc_hd__fill_8_169 VGND VPWR VPWR sky130_fd_sc_hd__fill_8
* cell instance sky130_fd_sc_hd__fill_8_170 r0 *1 0,0
Xsky130_fd_sc_hd__fill_8_170 VGND VPWR VPWR sky130_fd_sc_hd__fill_8
* cell instance sky130_fd_sc_hd__fill_8_171 r0 *1 0,0
Xsky130_fd_sc_hd__fill_8_171 VGND VPWR VPWR sky130_fd_sc_hd__fill_8
* cell instance sky130_fd_sc_hd__fill_8_172 r0 *1 0,0
Xsky130_fd_sc_hd__fill_8_172 VGND VPWR VPWR sky130_fd_sc_hd__fill_8
* cell instance sky130_fd_sc_hd__fill_8_173 r0 *1 0,0
Xsky130_fd_sc_hd__fill_8_173 VGND VPWR VPWR sky130_fd_sc_hd__fill_8
* cell instance sky130_fd_sc_hd__fill_8_174 r0 *1 0,0
Xsky130_fd_sc_hd__fill_8_174 VGND VPWR VPWR sky130_fd_sc_hd__fill_8
* cell instance sky130_fd_sc_hd__fill_8_175 r0 *1 0,0
Xsky130_fd_sc_hd__fill_8_175 VGND VPWR VPWR sky130_fd_sc_hd__fill_8
* cell instance sky130_fd_sc_hd__fill_8_176 r0 *1 0,0
Xsky130_fd_sc_hd__fill_8_176 VGND VPWR VPWR sky130_fd_sc_hd__fill_8
* cell instance sky130_fd_sc_hd__fill_8_177 r0 *1 0,0
Xsky130_fd_sc_hd__fill_8_177 VGND VPWR VPWR sky130_fd_sc_hd__fill_8
* cell instance sky130_fd_sc_hd__fill_8_178 r0 *1 0,0
Xsky130_fd_sc_hd__fill_8_178 VGND VPWR VPWR sky130_fd_sc_hd__fill_8
* cell instance sky130_fd_sc_hd__fill_8_179 r0 *1 0,0
Xsky130_fd_sc_hd__fill_8_179 VGND VPWR VPWR sky130_fd_sc_hd__fill_8
* cell instance sky130_fd_sc_hd__fill_8_180 r0 *1 0,0
Xsky130_fd_sc_hd__fill_8_180 VGND VPWR VPWR sky130_fd_sc_hd__fill_8
* cell instance sky130_fd_sc_hd__fill_8_181 r0 *1 0,0
Xsky130_fd_sc_hd__fill_8_181 VGND VPWR VPWR sky130_fd_sc_hd__fill_8
* cell instance sky130_fd_sc_hd__fill_8_182 r0 *1 0,0
Xsky130_fd_sc_hd__fill_8_182 VGND VPWR VPWR sky130_fd_sc_hd__fill_8
* cell instance sky130_fd_sc_hd__fill_8_183 r0 *1 0,0
Xsky130_fd_sc_hd__fill_8_183 VGND VPWR VPWR sky130_fd_sc_hd__fill_8
* cell instance sky130_fd_sc_hd__fill_8_184 r0 *1 0,0
Xsky130_fd_sc_hd__fill_8_184 VGND VPWR VPWR sky130_fd_sc_hd__fill_8
* cell instance sky130_fd_sc_hd__fill_8_185 r0 *1 0,0
Xsky130_fd_sc_hd__fill_8_185 VGND VPWR VPWR sky130_fd_sc_hd__fill_8
* cell instance sky130_fd_sc_hd__fill_8_186 r0 *1 0,0
Xsky130_fd_sc_hd__fill_8_186 VGND VPWR VPWR sky130_fd_sc_hd__fill_8
* cell instance sky130_fd_sc_hd__fill_8_187 r0 *1 0,0
Xsky130_fd_sc_hd__fill_8_187 VGND VPWR VPWR sky130_fd_sc_hd__fill_8
* cell instance sky130_fd_sc_hd__fill_8_188 r0 *1 0,0
Xsky130_fd_sc_hd__fill_8_188 VGND VPWR VPWR sky130_fd_sc_hd__fill_8
* cell instance sky130_fd_sc_hd__fill_8_189 r0 *1 0,0
Xsky130_fd_sc_hd__fill_8_189 VGND VPWR VPWR sky130_fd_sc_hd__fill_8
* cell instance sky130_fd_sc_hd__fill_8_190 r0 *1 0,0
Xsky130_fd_sc_hd__fill_8_190 VGND VPWR VPWR sky130_fd_sc_hd__fill_8
* cell instance sky130_fd_sc_hd__fill_8_191 r0 *1 0,0
Xsky130_fd_sc_hd__fill_8_191 VGND VPWR VPWR sky130_fd_sc_hd__fill_8
* cell instance sky130_fd_sc_hd__fill_8_192 r0 *1 0,0
Xsky130_fd_sc_hd__fill_8_192 VGND VPWR VPWR sky130_fd_sc_hd__fill_8
* cell instance sky130_fd_sc_hd__fill_8_193 r0 *1 0,0
Xsky130_fd_sc_hd__fill_8_193 VGND VPWR VPWR sky130_fd_sc_hd__fill_8
* cell instance sky130_fd_sc_hd__fill_8_194 r0 *1 0,0
Xsky130_fd_sc_hd__fill_8_194 VGND VPWR VPWR sky130_fd_sc_hd__fill_8
* cell instance sky130_fd_sc_hd__fill_8_195 r0 *1 0,0
Xsky130_fd_sc_hd__fill_8_195 VGND VPWR VPWR sky130_fd_sc_hd__fill_8
* cell instance sky130_fd_sc_hd__fill_8_196 r0 *1 0,0
Xsky130_fd_sc_hd__fill_8_196 VGND VPWR VPWR sky130_fd_sc_hd__fill_8
* cell instance sky130_fd_sc_hd__fill_8_197 r0 *1 0,0
Xsky130_fd_sc_hd__fill_8_197 VGND VPWR VPWR sky130_fd_sc_hd__fill_8
* cell instance sky130_fd_sc_hd__fill_8_198 r0 *1 0,0
Xsky130_fd_sc_hd__fill_8_198 VGND VPWR VPWR sky130_fd_sc_hd__fill_8
* cell instance sky130_fd_sc_hd__fill_8_199 r0 *1 0,0
Xsky130_fd_sc_hd__fill_8_199 VGND VPWR VPWR sky130_fd_sc_hd__fill_8
* cell instance sky130_fd_sc_hd__fill_8_200 r0 *1 0,0
Xsky130_fd_sc_hd__fill_8_200 VGND VPWR VPWR sky130_fd_sc_hd__fill_8
* cell instance sky130_fd_sc_hd__fill_8_201 r0 *1 0,0
Xsky130_fd_sc_hd__fill_8_201 VGND VPWR VPWR sky130_fd_sc_hd__fill_8
* cell instance sky130_fd_sc_hd__fill_8_202 r0 *1 0,0
Xsky130_fd_sc_hd__fill_8_202 VGND VPWR VPWR sky130_fd_sc_hd__fill_8
* cell instance sky130_fd_sc_hd__fill_8_203 r0 *1 0,0
Xsky130_fd_sc_hd__fill_8_203 VGND VPWR VPWR sky130_fd_sc_hd__fill_8
* cell instance sky130_fd_sc_hd__fill_8_204 r0 *1 0,0
Xsky130_fd_sc_hd__fill_8_204 VGND VPWR VPWR sky130_fd_sc_hd__fill_8
* cell instance sky130_fd_sc_hd__fill_8_205 r0 *1 0,0
Xsky130_fd_sc_hd__fill_8_205 VGND VPWR VPWR sky130_fd_sc_hd__fill_8
* cell instance sky130_fd_sc_hd__fill_8_206 r0 *1 0,0
Xsky130_fd_sc_hd__fill_8_206 VGND VPWR VPWR sky130_fd_sc_hd__fill_8
* cell instance sky130_fd_sc_hd__fill_8_207 r0 *1 0,0
Xsky130_fd_sc_hd__fill_8_207 VGND VPWR VPWR sky130_fd_sc_hd__fill_8
* cell instance sky130_fd_sc_hd__fill_8_208 r0 *1 0,0
Xsky130_fd_sc_hd__fill_8_208 VGND VPWR VPWR sky130_fd_sc_hd__fill_8
* cell instance sky130_fd_sc_hd__fill_8_209 r0 *1 0,0
Xsky130_fd_sc_hd__fill_8_209 VGND VPWR VPWR sky130_fd_sc_hd__fill_8
* cell instance sky130_fd_sc_hd__fill_8_210 r0 *1 0,0
Xsky130_fd_sc_hd__fill_8_210 VGND VPWR VPWR sky130_fd_sc_hd__fill_8
* cell instance sky130_fd_sc_hd__fill_8_211 r0 *1 0,0
Xsky130_fd_sc_hd__fill_8_211 VGND VPWR VPWR sky130_fd_sc_hd__fill_8
* cell instance sky130_fd_sc_hd__fill_8_212 r0 *1 0,0
Xsky130_fd_sc_hd__fill_8_212 VGND VPWR VPWR sky130_fd_sc_hd__fill_8
* cell instance sky130_fd_sc_hd__fill_8_213 r0 *1 0,0
Xsky130_fd_sc_hd__fill_8_213 VGND VPWR VPWR sky130_fd_sc_hd__fill_8
* cell instance sky130_fd_sc_hd__fill_8_214 r0 *1 0,0
Xsky130_fd_sc_hd__fill_8_214 VGND VPWR VPWR sky130_fd_sc_hd__fill_8
* cell instance sky130_fd_sc_hd__fill_8_215 r0 *1 0,0
Xsky130_fd_sc_hd__fill_8_215 VGND VPWR VPWR sky130_fd_sc_hd__fill_8
* cell instance sky130_fd_sc_hd__fill_8_216 r0 *1 0,0
Xsky130_fd_sc_hd__fill_8_216 VGND VPWR VPWR sky130_fd_sc_hd__fill_8
* cell instance sky130_fd_sc_hd__fill_8_217 r0 *1 0,0
Xsky130_fd_sc_hd__fill_8_217 VGND VPWR VPWR sky130_fd_sc_hd__fill_8
* cell instance sky130_fd_sc_hd__fill_8_218 r0 *1 0,0
Xsky130_fd_sc_hd__fill_8_218 VGND VPWR VPWR sky130_fd_sc_hd__fill_8
* cell instance sky130_fd_sc_hd__fill_8_219 r0 *1 0,0
Xsky130_fd_sc_hd__fill_8_219 VGND VPWR VPWR sky130_fd_sc_hd__fill_8
* cell instance sky130_fd_sc_hd__fill_8_220 r0 *1 0,0
Xsky130_fd_sc_hd__fill_8_220 VGND VPWR VPWR sky130_fd_sc_hd__fill_8
* cell instance sky130_fd_sc_hd__fill_8_221 r0 *1 0,0
Xsky130_fd_sc_hd__fill_8_221 VGND VPWR VPWR sky130_fd_sc_hd__fill_8
* cell instance sky130_fd_sc_hd__fill_8_222 r0 *1 0,0
Xsky130_fd_sc_hd__fill_8_222 VGND VPWR VPWR sky130_fd_sc_hd__fill_8
* cell instance sky130_fd_sc_hd__fill_8_223 r0 *1 0,0
Xsky130_fd_sc_hd__fill_8_223 VGND VPWR VPWR sky130_fd_sc_hd__fill_8
* cell instance sky130_fd_sc_hd__fill_8_224 r0 *1 0,0
Xsky130_fd_sc_hd__fill_8_224 VGND VPWR VPWR sky130_fd_sc_hd__fill_8
* cell instance sky130_fd_sc_hd__fill_8_225 r0 *1 0,0
Xsky130_fd_sc_hd__fill_8_225 VGND VPWR VPWR sky130_fd_sc_hd__fill_8
* cell instance sky130_fd_sc_hd__fill_8_226 r0 *1 0,0
Xsky130_fd_sc_hd__fill_8_226 VGND VPWR VPWR sky130_fd_sc_hd__fill_8
* cell instance sky130_fd_sc_hd__fill_8_227 r0 *1 0,0
Xsky130_fd_sc_hd__fill_8_227 VGND VPWR VPWR sky130_fd_sc_hd__fill_8
* cell instance sky130_fd_sc_hd__fill_8_228 r0 *1 0,0
Xsky130_fd_sc_hd__fill_8_228 VGND VPWR VPWR sky130_fd_sc_hd__fill_8
* cell instance sky130_fd_sc_hd__fill_8_229 r0 *1 0,0
Xsky130_fd_sc_hd__fill_8_229 VGND VPWR VPWR sky130_fd_sc_hd__fill_8
* cell instance sky130_fd_sc_hd__fill_8_230 r0 *1 0,0
Xsky130_fd_sc_hd__fill_8_230 VGND VPWR VPWR sky130_fd_sc_hd__fill_8
* cell instance sky130_fd_sc_hd__fill_8_231 r0 *1 0,0
Xsky130_fd_sc_hd__fill_8_231 VGND VPWR VPWR sky130_fd_sc_hd__fill_8
* cell instance sky130_fd_sc_hd__fill_8_232 r0 *1 0,0
Xsky130_fd_sc_hd__fill_8_232 VGND VPWR VPWR sky130_fd_sc_hd__fill_8
* cell instance sky130_fd_sc_hd__fill_8_233 r0 *1 0,0
Xsky130_fd_sc_hd__fill_8_233 VGND VPWR VPWR sky130_fd_sc_hd__fill_8
* cell instance sky130_fd_sc_hd__fill_8_234 r0 *1 0,0
Xsky130_fd_sc_hd__fill_8_234 VGND VPWR VPWR sky130_fd_sc_hd__fill_8
* cell instance sky130_fd_sc_hd__fill_8_235 r0 *1 0,0
Xsky130_fd_sc_hd__fill_8_235 VGND VPWR VPWR sky130_fd_sc_hd__fill_8
* cell instance sky130_fd_sc_hd__fill_8_236 r0 *1 0,0
Xsky130_fd_sc_hd__fill_8_236 VGND VPWR VPWR sky130_fd_sc_hd__fill_8
* cell instance sky130_fd_sc_hd__fill_8_237 r0 *1 0,0
Xsky130_fd_sc_hd__fill_8_237 VGND VPWR VPWR sky130_fd_sc_hd__fill_8
* cell instance sky130_fd_sc_hd__fill_8_238 r0 *1 0,0
Xsky130_fd_sc_hd__fill_8_238 VGND VPWR VPWR sky130_fd_sc_hd__fill_8
* cell instance sky130_fd_sc_hd__fill_8_239 r0 *1 0,0
Xsky130_fd_sc_hd__fill_8_239 VGND VPWR VPWR sky130_fd_sc_hd__fill_8
* cell instance sky130_fd_sc_hd__fill_8_240 r0 *1 0,0
Xsky130_fd_sc_hd__fill_8_240 VGND VPWR VPWR sky130_fd_sc_hd__fill_8
* cell instance sky130_fd_sc_hd__fill_8_241 r0 *1 0,0
Xsky130_fd_sc_hd__fill_8_241 VGND VPWR VPWR sky130_fd_sc_hd__fill_8
* cell instance sky130_fd_sc_hd__fill_8_242 r0 *1 0,0
Xsky130_fd_sc_hd__fill_8_242 VGND VPWR VPWR sky130_fd_sc_hd__fill_8
* cell instance sky130_fd_sc_hd__fill_8_243 r0 *1 0,0
Xsky130_fd_sc_hd__fill_8_243 VGND VPWR VPWR sky130_fd_sc_hd__fill_8
* cell instance sky130_fd_sc_hd__fill_8_244 r0 *1 0,0
Xsky130_fd_sc_hd__fill_8_244 VGND VPWR VPWR sky130_fd_sc_hd__fill_8
* cell instance sky130_fd_sc_hd__fill_8_245 r0 *1 0,0
Xsky130_fd_sc_hd__fill_8_245 VGND VPWR VPWR sky130_fd_sc_hd__fill_8
* cell instance sky130_fd_sc_hd__fill_8_246 r0 *1 0,0
Xsky130_fd_sc_hd__fill_8_246 VGND VPWR VPWR sky130_fd_sc_hd__fill_8
* cell instance sky130_fd_sc_hd__fill_8_247 r0 *1 0,0
Xsky130_fd_sc_hd__fill_8_247 VGND VPWR VPWR sky130_fd_sc_hd__fill_8
* cell instance sky130_fd_sc_hd__fill_8_248 r0 *1 0,0
Xsky130_fd_sc_hd__fill_8_248 VGND VPWR VPWR sky130_fd_sc_hd__fill_8
* cell instance sky130_fd_sc_hd__fill_8_249 r0 *1 0,0
Xsky130_fd_sc_hd__fill_8_249 VGND VPWR VPWR sky130_fd_sc_hd__fill_8
* cell instance sky130_fd_sc_hd__fill_8_250 r0 *1 0,0
Xsky130_fd_sc_hd__fill_8_250 VGND VPWR VPWR sky130_fd_sc_hd__fill_8
* cell instance sky130_fd_sc_hd__fill_8_251 r0 *1 0,0
Xsky130_fd_sc_hd__fill_8_251 VGND VPWR VPWR sky130_fd_sc_hd__fill_8
* cell instance sky130_fd_sc_hd__fill_8_252 r0 *1 0,0
Xsky130_fd_sc_hd__fill_8_252 VGND VPWR VPWR sky130_fd_sc_hd__fill_8
* cell instance sky130_fd_sc_hd__fill_8_253 r0 *1 0,0
Xsky130_fd_sc_hd__fill_8_253 VGND VPWR VPWR sky130_fd_sc_hd__fill_8
* cell instance sky130_fd_sc_hd__fill_8_254 r0 *1 0,0
Xsky130_fd_sc_hd__fill_8_254 VGND VPWR VPWR sky130_fd_sc_hd__fill_8
* cell instance sky130_fd_sc_hd__fill_8_255 r0 *1 0,0
Xsky130_fd_sc_hd__fill_8_255 VGND VPWR VPWR sky130_fd_sc_hd__fill_8
* cell instance sky130_fd_sc_hd__fill_8_256 r0 *1 0,0
Xsky130_fd_sc_hd__fill_8_256 VGND VPWR VPWR sky130_fd_sc_hd__fill_8
* cell instance sky130_fd_sc_hd__fill_8_257 r0 *1 0,0
Xsky130_fd_sc_hd__fill_8_257 VGND VPWR VPWR sky130_fd_sc_hd__fill_8
* cell instance sky130_fd_sc_hd__fill_8_258 r0 *1 0,0
Xsky130_fd_sc_hd__fill_8_258 VGND VPWR VPWR sky130_fd_sc_hd__fill_8
* cell instance sky130_fd_sc_hd__fill_8_259 r0 *1 0,0
Xsky130_fd_sc_hd__fill_8_259 VGND VPWR VPWR sky130_fd_sc_hd__fill_8
* cell instance sky130_fd_sc_hd__fill_8_260 r0 *1 0,0
Xsky130_fd_sc_hd__fill_8_260 VGND VPWR VPWR sky130_fd_sc_hd__fill_8
* cell instance sky130_fd_sc_hd__fill_8_261 r0 *1 0,0
Xsky130_fd_sc_hd__fill_8_261 VGND VPWR VPWR sky130_fd_sc_hd__fill_8
* cell instance sky130_fd_sc_hd__fill_8_262 r0 *1 0,0
Xsky130_fd_sc_hd__fill_8_262 VGND VPWR VPWR sky130_fd_sc_hd__fill_8
* cell instance sky130_fd_sc_hd__fill_8_263 r0 *1 0,0
Xsky130_fd_sc_hd__fill_8_263 VGND VPWR VPWR sky130_fd_sc_hd__fill_8
* cell instance sky130_fd_sc_hd__fill_8_264 r0 *1 0,0
Xsky130_fd_sc_hd__fill_8_264 VGND VPWR VPWR sky130_fd_sc_hd__fill_8
* cell instance sky130_fd_sc_hd__fill_8_265 r0 *1 0,0
Xsky130_fd_sc_hd__fill_8_265 VGND VPWR VPWR sky130_fd_sc_hd__fill_8
* cell instance sky130_fd_sc_hd__fill_8_266 r0 *1 0,0
Xsky130_fd_sc_hd__fill_8_266 VGND VPWR VPWR sky130_fd_sc_hd__fill_8
* cell instance sky130_fd_sc_hd__fill_8_267 r0 *1 0,0
Xsky130_fd_sc_hd__fill_8_267 VGND VPWR VPWR sky130_fd_sc_hd__fill_8
* cell instance sky130_fd_sc_hd__fill_8_268 r0 *1 0,0
Xsky130_fd_sc_hd__fill_8_268 VGND VPWR VPWR sky130_fd_sc_hd__fill_8
* cell instance sky130_fd_sc_hd__fill_8_269 r0 *1 0,0
Xsky130_fd_sc_hd__fill_8_269 VGND VPWR VPWR sky130_fd_sc_hd__fill_8
* cell instance sky130_fd_sc_hd__fill_8_270 r0 *1 0,0
Xsky130_fd_sc_hd__fill_8_270 VGND VPWR VPWR sky130_fd_sc_hd__fill_8
* cell instance sky130_fd_sc_hd__fill_8_271 r0 *1 0,0
Xsky130_fd_sc_hd__fill_8_271 VGND VPWR VPWR sky130_fd_sc_hd__fill_8
* cell instance sky130_fd_sc_hd__fill_8_272 r0 *1 0,0
Xsky130_fd_sc_hd__fill_8_272 VGND VPWR VPWR sky130_fd_sc_hd__fill_8
* cell instance sky130_fd_sc_hd__fill_8_273 r0 *1 0,0
Xsky130_fd_sc_hd__fill_8_273 VGND VPWR VPWR sky130_fd_sc_hd__fill_8
* cell instance sky130_fd_sc_hd__fill_8_274 r0 *1 0,0
Xsky130_fd_sc_hd__fill_8_274 VGND VPWR VPWR sky130_fd_sc_hd__fill_8
* cell instance sky130_fd_sc_hd__fill_8_275 r0 *1 0,0
Xsky130_fd_sc_hd__fill_8_275 VGND VPWR VPWR sky130_fd_sc_hd__fill_8
* cell instance sky130_fd_sc_hd__fill_8_276 r0 *1 0,0
Xsky130_fd_sc_hd__fill_8_276 VGND VPWR VPWR sky130_fd_sc_hd__fill_8
* cell instance sky130_fd_sc_hd__fill_8_277 r0 *1 0,0
Xsky130_fd_sc_hd__fill_8_277 VGND VPWR VPWR sky130_fd_sc_hd__fill_8
* cell instance sky130_fd_sc_hd__fill_8_278 r0 *1 0,0
Xsky130_fd_sc_hd__fill_8_278 VGND VPWR VPWR sky130_fd_sc_hd__fill_8
* cell instance sky130_fd_sc_hd__fill_8_279 r0 *1 0,0
Xsky130_fd_sc_hd__fill_8_279 VGND VPWR VPWR sky130_fd_sc_hd__fill_8
* cell instance sky130_fd_sc_hd__fill_8_280 r0 *1 0,0
Xsky130_fd_sc_hd__fill_8_280 VGND VPWR VPWR sky130_fd_sc_hd__fill_8
* cell instance sky130_fd_sc_hd__fill_8_281 r0 *1 0,0
Xsky130_fd_sc_hd__fill_8_281 VGND VPWR VPWR sky130_fd_sc_hd__fill_8
* cell instance sky130_fd_sc_hd__fill_8_282 r0 *1 0,0
Xsky130_fd_sc_hd__fill_8_282 VGND VPWR VPWR sky130_fd_sc_hd__fill_8
* cell instance sky130_fd_sc_hd__fill_8_283 r0 *1 0,0
Xsky130_fd_sc_hd__fill_8_283 VGND VPWR VPWR sky130_fd_sc_hd__fill_8
* cell instance sky130_fd_sc_hd__fill_8_284 r0 *1 0,0
Xsky130_fd_sc_hd__fill_8_284 VGND VPWR VPWR sky130_fd_sc_hd__fill_8
* cell instance sky130_fd_sc_hd__fill_8_285 r0 *1 0,0
Xsky130_fd_sc_hd__fill_8_285 VGND VPWR VPWR sky130_fd_sc_hd__fill_8
* cell instance sky130_fd_sc_hd__fill_8_286 r0 *1 0,0
Xsky130_fd_sc_hd__fill_8_286 VGND VPWR VPWR sky130_fd_sc_hd__fill_8
* cell instance sky130_fd_sc_hd__fill_8_287 r0 *1 0,0
Xsky130_fd_sc_hd__fill_8_287 VGND VPWR VPWR sky130_fd_sc_hd__fill_8
* cell instance sky130_fd_sc_hd__fill_8_288 r0 *1 0,0
Xsky130_fd_sc_hd__fill_8_288 VGND VPWR VPWR sky130_fd_sc_hd__fill_8
* cell instance sky130_fd_sc_hd__fill_8_289 r0 *1 0,0
Xsky130_fd_sc_hd__fill_8_289 VGND VPWR VPWR sky130_fd_sc_hd__fill_8
* cell instance sky130_fd_sc_hd__fill_8_290 r0 *1 0,0
Xsky130_fd_sc_hd__fill_8_290 VGND VPWR VPWR sky130_fd_sc_hd__fill_8
* cell instance sky130_fd_sc_hd__fill_8_291 r0 *1 0,0
Xsky130_fd_sc_hd__fill_8_291 VGND VPWR VPWR sky130_fd_sc_hd__fill_8
* cell instance sky130_fd_sc_hd__fill_8_292 r0 *1 0,0
Xsky130_fd_sc_hd__fill_8_292 VGND VPWR VPWR sky130_fd_sc_hd__fill_8
* cell instance sky130_fd_sc_hd__fill_8_293 r0 *1 0,0
Xsky130_fd_sc_hd__fill_8_293 VGND VPWR VPWR sky130_fd_sc_hd__fill_8
* cell instance sky130_fd_sc_hd__fill_8_294 r0 *1 0,0
Xsky130_fd_sc_hd__fill_8_294 VGND VPWR VPWR sky130_fd_sc_hd__fill_8
* cell instance sky130_fd_sc_hd__fill_8_295 r0 *1 0,0
Xsky130_fd_sc_hd__fill_8_295 VGND VPWR VPWR sky130_fd_sc_hd__fill_8
* cell instance sky130_fd_sc_hd__fill_8_296 r0 *1 0,0
Xsky130_fd_sc_hd__fill_8_296 VGND VPWR VPWR sky130_fd_sc_hd__fill_8
* cell instance sky130_fd_sc_hd__fill_8_297 r0 *1 0,0
Xsky130_fd_sc_hd__fill_8_297 VGND VPWR VPWR sky130_fd_sc_hd__fill_8
* cell instance sky130_fd_sc_hd__fill_8_298 r0 *1 0,0
Xsky130_fd_sc_hd__fill_8_298 VGND VPWR VPWR sky130_fd_sc_hd__fill_8
* cell instance sky130_fd_sc_hd__fill_8_299 r0 *1 0,0
Xsky130_fd_sc_hd__fill_8_299 VGND VPWR VPWR sky130_fd_sc_hd__fill_8
* cell instance sky130_fd_sc_hd__fill_8_300 r0 *1 0,0
Xsky130_fd_sc_hd__fill_8_300 VGND VPWR VPWR sky130_fd_sc_hd__fill_8
* cell instance sky130_fd_sc_hd__fill_8_301 r0 *1 0,0
Xsky130_fd_sc_hd__fill_8_301 VGND VPWR VPWR sky130_fd_sc_hd__fill_8
* cell instance sky130_fd_sc_hd__fill_8_302 r0 *1 0,0
Xsky130_fd_sc_hd__fill_8_302 VGND VPWR VPWR sky130_fd_sc_hd__fill_8
* cell instance sky130_fd_sc_hd__fill_8_303 r0 *1 0,0
Xsky130_fd_sc_hd__fill_8_303 VGND VPWR VPWR sky130_fd_sc_hd__fill_8
* cell instance sky130_fd_sc_hd__fill_8_304 r0 *1 0,0
Xsky130_fd_sc_hd__fill_8_304 VGND VPWR VPWR sky130_fd_sc_hd__fill_8
* cell instance sky130_fd_sc_hd__fill_8_305 r0 *1 0,0
Xsky130_fd_sc_hd__fill_8_305 VGND VPWR VPWR sky130_fd_sc_hd__fill_8
* cell instance sky130_fd_sc_hd__fill_8_306 r0 *1 0,0
Xsky130_fd_sc_hd__fill_8_306 VGND VPWR VPWR sky130_fd_sc_hd__fill_8
* cell instance sky130_fd_sc_hd__fill_8_307 r0 *1 0,0
Xsky130_fd_sc_hd__fill_8_307 VGND VPWR VPWR sky130_fd_sc_hd__fill_8
* cell instance sky130_fd_sc_hd__fill_8_308 r0 *1 0,0
Xsky130_fd_sc_hd__fill_8_308 VGND VPWR VPWR sky130_fd_sc_hd__fill_8
* cell instance sky130_fd_sc_hd__fill_8_309 r0 *1 0,0
Xsky130_fd_sc_hd__fill_8_309 VGND VPWR VPWR sky130_fd_sc_hd__fill_8
* cell instance sky130_fd_sc_hd__fill_8_310 r0 *1 0,0
Xsky130_fd_sc_hd__fill_8_310 VGND VPWR VPWR sky130_fd_sc_hd__fill_8
* cell instance sky130_fd_sc_hd__fill_8_311 r0 *1 0,0
Xsky130_fd_sc_hd__fill_8_311 VGND VPWR VPWR sky130_fd_sc_hd__fill_8
* cell instance sky130_fd_sc_hd__fill_8_312 r0 *1 0,0
Xsky130_fd_sc_hd__fill_8_312 VGND VPWR VPWR sky130_fd_sc_hd__fill_8
* cell instance sky130_fd_sc_hd__fill_8_313 r0 *1 0,0
Xsky130_fd_sc_hd__fill_8_313 VGND VPWR VPWR sky130_fd_sc_hd__fill_8
* cell instance sky130_fd_sc_hd__fill_8_314 r0 *1 0,0
Xsky130_fd_sc_hd__fill_8_314 VGND VPWR VPWR sky130_fd_sc_hd__fill_8
* cell instance sky130_fd_sc_hd__fill_8_315 r0 *1 0,0
Xsky130_fd_sc_hd__fill_8_315 VGND VPWR VPWR sky130_fd_sc_hd__fill_8
* cell instance sky130_fd_sc_hd__fill_8_316 r0 *1 0,0
Xsky130_fd_sc_hd__fill_8_316 VGND VPWR VPWR sky130_fd_sc_hd__fill_8
* cell instance sky130_fd_sc_hd__fill_8_317 r0 *1 0,0
Xsky130_fd_sc_hd__fill_8_317 VGND VPWR VPWR sky130_fd_sc_hd__fill_8
* cell instance sky130_fd_sc_hd__fill_8_318 r0 *1 0,0
Xsky130_fd_sc_hd__fill_8_318 VGND VPWR VPWR sky130_fd_sc_hd__fill_8
* cell instance sky130_fd_sc_hd__fill_8_319 r0 *1 0,0
Xsky130_fd_sc_hd__fill_8_319 VGND VPWR VPWR sky130_fd_sc_hd__fill_8
* cell instance sky130_fd_sc_hd__fill_8_320 r0 *1 0,0
Xsky130_fd_sc_hd__fill_8_320 VGND VPWR VPWR sky130_fd_sc_hd__fill_8
* cell instance sky130_fd_sc_hd__fill_8_321 r0 *1 0,0
Xsky130_fd_sc_hd__fill_8_321 VGND VPWR VPWR sky130_fd_sc_hd__fill_8
* cell instance sky130_fd_sc_hd__fill_8_322 r0 *1 0,0
Xsky130_fd_sc_hd__fill_8_322 VGND VPWR VPWR sky130_fd_sc_hd__fill_8
* cell instance sky130_fd_sc_hd__fill_8_323 r0 *1 0,0
Xsky130_fd_sc_hd__fill_8_323 VGND VPWR VPWR sky130_fd_sc_hd__fill_8
* cell instance sky130_fd_sc_hd__fill_8_324 r0 *1 0,0
Xsky130_fd_sc_hd__fill_8_324 VGND VPWR VPWR sky130_fd_sc_hd__fill_8
* cell instance sky130_fd_sc_hd__fill_8_325 r0 *1 0,0
Xsky130_fd_sc_hd__fill_8_325 VGND VPWR VPWR sky130_fd_sc_hd__fill_8
* cell instance sky130_fd_sc_hd__fill_8_326 r0 *1 0,0
Xsky130_fd_sc_hd__fill_8_326 VGND VPWR VPWR sky130_fd_sc_hd__fill_8
* cell instance sky130_fd_sc_hd__fill_8_327 r0 *1 0,0
Xsky130_fd_sc_hd__fill_8_327 VGND VPWR VPWR sky130_fd_sc_hd__fill_8
* cell instance sky130_fd_sc_hd__fill_8_328 r0 *1 0,0
Xsky130_fd_sc_hd__fill_8_328 VGND VPWR VPWR sky130_fd_sc_hd__fill_8
* cell instance sky130_fd_sc_hd__fill_8_329 r0 *1 0,0
Xsky130_fd_sc_hd__fill_8_329 VGND VPWR VPWR sky130_fd_sc_hd__fill_8
* cell instance sky130_fd_sc_hd__fill_8_330 r0 *1 0,0
Xsky130_fd_sc_hd__fill_8_330 VGND VPWR VPWR sky130_fd_sc_hd__fill_8
* cell instance sky130_fd_sc_hd__fill_8_331 r0 *1 0,0
Xsky130_fd_sc_hd__fill_8_331 VGND VPWR VPWR sky130_fd_sc_hd__fill_8
* cell instance sky130_fd_sc_hd__fill_8_332 r0 *1 0,0
Xsky130_fd_sc_hd__fill_8_332 VGND VPWR VPWR sky130_fd_sc_hd__fill_8
* cell instance sky130_fd_sc_hd__fill_8_333 r0 *1 0,0
Xsky130_fd_sc_hd__fill_8_333 VGND VPWR VPWR sky130_fd_sc_hd__fill_8
* cell instance sky130_fd_sc_hd__fill_8_334 r0 *1 0,0
Xsky130_fd_sc_hd__fill_8_334 VGND VPWR VPWR sky130_fd_sc_hd__fill_8
* cell instance sky130_fd_sc_hd__fill_8_335 r0 *1 0,0
Xsky130_fd_sc_hd__fill_8_335 VGND VPWR VPWR sky130_fd_sc_hd__fill_8
* cell instance sky130_fd_sc_hd__fill_8_336 r0 *1 0,0
Xsky130_fd_sc_hd__fill_8_336 VGND VPWR VPWR sky130_fd_sc_hd__fill_8
* cell instance sky130_fd_sc_hd__fill_8_337 r0 *1 0,0
Xsky130_fd_sc_hd__fill_8_337 VGND VPWR VPWR sky130_fd_sc_hd__fill_8
* cell instance sky130_fd_sc_hd__fill_8_338 r0 *1 0,0
Xsky130_fd_sc_hd__fill_8_338 VGND VPWR VPWR sky130_fd_sc_hd__fill_8
* cell instance sky130_fd_sc_hd__fill_8_339 r0 *1 0,0
Xsky130_fd_sc_hd__fill_8_339 VGND VPWR VPWR sky130_fd_sc_hd__fill_8
* cell instance sky130_fd_sc_hd__fill_8_340 r0 *1 0,0
Xsky130_fd_sc_hd__fill_8_340 VGND VPWR VPWR sky130_fd_sc_hd__fill_8
* cell instance sky130_fd_sc_hd__fill_8_341 r0 *1 0,0
Xsky130_fd_sc_hd__fill_8_341 VGND VPWR VPWR sky130_fd_sc_hd__fill_8
* cell instance sky130_fd_sc_hd__fill_8_342 r0 *1 0,0
Xsky130_fd_sc_hd__fill_8_342 VGND VPWR VPWR sky130_fd_sc_hd__fill_8
* cell instance sky130_fd_sc_hd__fill_8_343 r0 *1 0,0
Xsky130_fd_sc_hd__fill_8_343 VGND VPWR VPWR sky130_fd_sc_hd__fill_8
* cell instance sky130_fd_sc_hd__fill_8_344 r0 *1 0,0
Xsky130_fd_sc_hd__fill_8_344 VGND VPWR VPWR sky130_fd_sc_hd__fill_8
* cell instance sky130_fd_sc_hd__fill_8_345 r0 *1 0,0
Xsky130_fd_sc_hd__fill_8_345 VGND VPWR VPWR sky130_fd_sc_hd__fill_8
* cell instance sky130_fd_sc_hd__fill_8_346 r0 *1 0,0
Xsky130_fd_sc_hd__fill_8_346 VGND VPWR VPWR sky130_fd_sc_hd__fill_8
* cell instance sky130_fd_sc_hd__fill_8_347 r0 *1 0,0
Xsky130_fd_sc_hd__fill_8_347 VGND VPWR VPWR sky130_fd_sc_hd__fill_8
* cell instance sky130_fd_sc_hd__fill_8_348 r0 *1 0,0
Xsky130_fd_sc_hd__fill_8_348 VGND VPWR VPWR sky130_fd_sc_hd__fill_8
* cell instance sky130_fd_sc_hd__fill_8_349 r0 *1 0,0
Xsky130_fd_sc_hd__fill_8_349 VGND VPWR VPWR sky130_fd_sc_hd__fill_8
* cell instance sky130_fd_sc_hd__fill_8_350 r0 *1 0,0
Xsky130_fd_sc_hd__fill_8_350 VGND VPWR VPWR sky130_fd_sc_hd__fill_8
* cell instance sky130_fd_sc_hd__fill_8_351 r0 *1 0,0
Xsky130_fd_sc_hd__fill_8_351 VGND VPWR VPWR sky130_fd_sc_hd__fill_8
* cell instance sky130_fd_sc_hd__fill_8_352 r0 *1 0,0
Xsky130_fd_sc_hd__fill_8_352 VGND VPWR VPWR sky130_fd_sc_hd__fill_8
* cell instance sky130_fd_sc_hd__fill_8_353 r0 *1 0,0
Xsky130_fd_sc_hd__fill_8_353 VGND VPWR VPWR sky130_fd_sc_hd__fill_8
* cell instance sky130_fd_sc_hd__fill_8_354 r0 *1 0,0
Xsky130_fd_sc_hd__fill_8_354 VGND VPWR VPWR sky130_fd_sc_hd__fill_8
* cell instance sky130_fd_sc_hd__fill_8_355 r0 *1 0,0
Xsky130_fd_sc_hd__fill_8_355 VGND VPWR VPWR sky130_fd_sc_hd__fill_8
* cell instance sky130_fd_sc_hd__fill_8_356 r0 *1 0,0
Xsky130_fd_sc_hd__fill_8_356 VGND VPWR VPWR sky130_fd_sc_hd__fill_8
* cell instance sky130_fd_sc_hd__fill_8_357 r0 *1 0,0
Xsky130_fd_sc_hd__fill_8_357 VGND VPWR VPWR sky130_fd_sc_hd__fill_8
* cell instance sky130_fd_sc_hd__fill_8_358 r0 *1 0,0
Xsky130_fd_sc_hd__fill_8_358 VGND VPWR VPWR sky130_fd_sc_hd__fill_8
* cell instance sky130_fd_sc_hd__fill_8_359 r0 *1 0,0
Xsky130_fd_sc_hd__fill_8_359 VGND VPWR VPWR sky130_fd_sc_hd__fill_8
* cell instance sky130_fd_sc_hd__fill_8_360 r0 *1 0,0
Xsky130_fd_sc_hd__fill_8_360 VGND VPWR VPWR sky130_fd_sc_hd__fill_8
* cell instance sky130_fd_sc_hd__fill_8_361 r0 *1 0,0
Xsky130_fd_sc_hd__fill_8_361 VGND VPWR VPWR sky130_fd_sc_hd__fill_8
* cell instance sky130_fd_sc_hd__fill_8_362 r0 *1 0,0
Xsky130_fd_sc_hd__fill_8_362 VGND VPWR VPWR sky130_fd_sc_hd__fill_8
* cell instance sky130_fd_sc_hd__fill_8_363 r0 *1 0,0
Xsky130_fd_sc_hd__fill_8_363 VGND VPWR VPWR sky130_fd_sc_hd__fill_8
* cell instance sky130_fd_sc_hd__fill_8_364 r0 *1 0,0
Xsky130_fd_sc_hd__fill_8_364 VGND VPWR VPWR sky130_fd_sc_hd__fill_8
* cell instance sky130_fd_sc_hd__fill_8_365 r0 *1 0,0
Xsky130_fd_sc_hd__fill_8_365 VGND VPWR VPWR sky130_fd_sc_hd__fill_8
* cell instance sky130_fd_sc_hd__fill_8_366 r0 *1 0,0
Xsky130_fd_sc_hd__fill_8_366 VGND VPWR VPWR sky130_fd_sc_hd__fill_8
* cell instance sky130_fd_sc_hd__fill_8_367 r0 *1 0,0
Xsky130_fd_sc_hd__fill_8_367 VGND VPWR VPWR sky130_fd_sc_hd__fill_8
* cell instance sky130_fd_sc_hd__fill_8_368 r0 *1 0,0
Xsky130_fd_sc_hd__fill_8_368 VGND VPWR VPWR sky130_fd_sc_hd__fill_8
* cell instance sky130_fd_sc_hd__fill_8_369 r0 *1 0,0
Xsky130_fd_sc_hd__fill_8_369 VGND VPWR VPWR sky130_fd_sc_hd__fill_8
* cell instance sky130_fd_sc_hd__fill_8_370 r0 *1 0,0
Xsky130_fd_sc_hd__fill_8_370 VGND VPWR VPWR sky130_fd_sc_hd__fill_8
* cell instance sky130_fd_sc_hd__fill_8_371 r0 *1 0,0
Xsky130_fd_sc_hd__fill_8_371 VGND VPWR VPWR sky130_fd_sc_hd__fill_8
* cell instance sky130_fd_sc_hd__fill_8_372 r0 *1 0,0
Xsky130_fd_sc_hd__fill_8_372 VGND VPWR VPWR sky130_fd_sc_hd__fill_8
* cell instance sky130_fd_sc_hd__fill_8_373 r0 *1 0,0
Xsky130_fd_sc_hd__fill_8_373 VGND VPWR VPWR sky130_fd_sc_hd__fill_8
* cell instance sky130_fd_sc_hd__fill_8_374 r0 *1 0,0
Xsky130_fd_sc_hd__fill_8_374 VGND VPWR VPWR sky130_fd_sc_hd__fill_8
* cell instance sky130_fd_sc_hd__fill_8_375 r0 *1 0,0
Xsky130_fd_sc_hd__fill_8_375 VGND VPWR VPWR sky130_fd_sc_hd__fill_8
* cell instance sky130_fd_sc_hd__fill_8_376 r0 *1 0,0
Xsky130_fd_sc_hd__fill_8_376 VGND VPWR VPWR sky130_fd_sc_hd__fill_8
* cell instance sky130_fd_sc_hd__fill_8_377 r0 *1 0,0
Xsky130_fd_sc_hd__fill_8_377 VGND VPWR VPWR sky130_fd_sc_hd__fill_8
* cell instance sky130_fd_sc_hd__fill_8_378 r0 *1 0,0
Xsky130_fd_sc_hd__fill_8_378 VGND VPWR VPWR sky130_fd_sc_hd__fill_8
* cell instance sky130_fd_sc_hd__fill_8_379 r0 *1 0,0
Xsky130_fd_sc_hd__fill_8_379 VGND VPWR VPWR sky130_fd_sc_hd__fill_8
* cell instance sky130_fd_sc_hd__fill_8_380 r0 *1 0,0
Xsky130_fd_sc_hd__fill_8_380 VGND VPWR VPWR sky130_fd_sc_hd__fill_8
* cell instance sky130_fd_sc_hd__fill_8_381 r0 *1 0,0
Xsky130_fd_sc_hd__fill_8_381 VGND VPWR VPWR sky130_fd_sc_hd__fill_8
* cell instance sky130_fd_sc_hd__fill_8_382 r0 *1 0,0
Xsky130_fd_sc_hd__fill_8_382 VGND VPWR VPWR sky130_fd_sc_hd__fill_8
* cell instance sky130_fd_sc_hd__fill_8_383 r0 *1 0,0
Xsky130_fd_sc_hd__fill_8_383 VGND VPWR VPWR sky130_fd_sc_hd__fill_8
* cell instance sky130_fd_sc_hd__fill_8_384 r0 *1 0,0
Xsky130_fd_sc_hd__fill_8_384 VGND VPWR VPWR sky130_fd_sc_hd__fill_8
* cell instance sky130_fd_sc_hd__fill_8_385 r0 *1 0,0
Xsky130_fd_sc_hd__fill_8_385 VGND VPWR VPWR sky130_fd_sc_hd__fill_8
* cell instance sky130_fd_sc_hd__fill_8_386 r0 *1 0,0
Xsky130_fd_sc_hd__fill_8_386 VGND VPWR VPWR sky130_fd_sc_hd__fill_8
* cell instance sky130_fd_sc_hd__fill_8_387 r0 *1 0,0
Xsky130_fd_sc_hd__fill_8_387 VGND VPWR VPWR sky130_fd_sc_hd__fill_8
* cell instance sky130_fd_sc_hd__fill_8_388 r0 *1 0,0
Xsky130_fd_sc_hd__fill_8_388 VGND VPWR VPWR sky130_fd_sc_hd__fill_8
* cell instance sky130_fd_sc_hd__fill_8_389 r0 *1 0,0
Xsky130_fd_sc_hd__fill_8_389 VGND VPWR VPWR sky130_fd_sc_hd__fill_8
* cell instance sky130_fd_sc_hd__fill_8_390 r0 *1 0,0
Xsky130_fd_sc_hd__fill_8_390 VGND VPWR VPWR sky130_fd_sc_hd__fill_8
* cell instance sky130_fd_sc_hd__fill_8_391 r0 *1 0,0
Xsky130_fd_sc_hd__fill_8_391 VGND VPWR VPWR sky130_fd_sc_hd__fill_8
* cell instance sky130_fd_sc_hd__fill_8_392 r0 *1 0,0
Xsky130_fd_sc_hd__fill_8_392 VGND VPWR VPWR sky130_fd_sc_hd__fill_8
* cell instance sky130_fd_sc_hd__fill_8_393 r0 *1 0,0
Xsky130_fd_sc_hd__fill_8_393 VGND VPWR VPWR sky130_fd_sc_hd__fill_8
* cell instance sky130_fd_sc_hd__fill_8_394 r0 *1 0,0
Xsky130_fd_sc_hd__fill_8_394 VGND VPWR VPWR sky130_fd_sc_hd__fill_8
* cell instance sky130_fd_sc_hd__fill_8_395 r0 *1 0,0
Xsky130_fd_sc_hd__fill_8_395 VGND VPWR VPWR sky130_fd_sc_hd__fill_8
* cell instance sky130_fd_sc_hd__fill_8_396 r0 *1 0,0
Xsky130_fd_sc_hd__fill_8_396 VGND VPWR VPWR sky130_fd_sc_hd__fill_8
* cell instance sky130_fd_sc_hd__fill_8_397 r0 *1 0,0
Xsky130_fd_sc_hd__fill_8_397 VGND VPWR VPWR sky130_fd_sc_hd__fill_8
* cell instance sky130_fd_sc_hd__fill_8_398 r0 *1 0,0
Xsky130_fd_sc_hd__fill_8_398 VGND VPWR VPWR sky130_fd_sc_hd__fill_8
* cell instance sky130_fd_sc_hd__fill_8_399 r0 *1 0,0
Xsky130_fd_sc_hd__fill_8_399 VGND VPWR VPWR sky130_fd_sc_hd__fill_8
* cell instance sky130_fd_sc_hd__fill_8_400 r0 *1 0,0
Xsky130_fd_sc_hd__fill_8_400 VGND VPWR VPWR sky130_fd_sc_hd__fill_8
* cell instance sky130_fd_sc_hd__fill_8_401 r0 *1 0,0
Xsky130_fd_sc_hd__fill_8_401 VGND VPWR VPWR sky130_fd_sc_hd__fill_8
* cell instance sky130_fd_sc_hd__fill_8_402 r0 *1 0,0
Xsky130_fd_sc_hd__fill_8_402 VGND VPWR VPWR sky130_fd_sc_hd__fill_8
* cell instance sky130_fd_sc_hd__fill_8_403 r0 *1 0,0
Xsky130_fd_sc_hd__fill_8_403 VGND VPWR VPWR sky130_fd_sc_hd__fill_8
* cell instance sky130_fd_sc_hd__fill_8_404 r0 *1 0,0
Xsky130_fd_sc_hd__fill_8_404 VGND VPWR VPWR sky130_fd_sc_hd__fill_8
* cell instance sky130_fd_sc_hd__fill_8_405 r0 *1 0,0
Xsky130_fd_sc_hd__fill_8_405 VGND VPWR VPWR sky130_fd_sc_hd__fill_8
* cell instance sky130_fd_sc_hd__fill_8_406 r0 *1 0,0
Xsky130_fd_sc_hd__fill_8_406 VGND VPWR VPWR sky130_fd_sc_hd__fill_8
* cell instance sky130_fd_sc_hd__fill_8_407 r0 *1 0,0
Xsky130_fd_sc_hd__fill_8_407 VGND VPWR VPWR sky130_fd_sc_hd__fill_8
* cell instance sky130_fd_sc_hd__fill_8_408 r0 *1 0,0
Xsky130_fd_sc_hd__fill_8_408 VGND VPWR VPWR sky130_fd_sc_hd__fill_8
* cell instance sky130_fd_sc_hd__fill_8_409 r0 *1 0,0
Xsky130_fd_sc_hd__fill_8_409 VGND VPWR VPWR sky130_fd_sc_hd__fill_8
* cell instance sky130_fd_sc_hd__fill_8_410 r0 *1 0,0
Xsky130_fd_sc_hd__fill_8_410 VGND VPWR VPWR sky130_fd_sc_hd__fill_8
* cell instance sky130_fd_sc_hd__fill_8_411 r0 *1 0,0
Xsky130_fd_sc_hd__fill_8_411 VGND VPWR VPWR sky130_fd_sc_hd__fill_8
* cell instance sky130_fd_sc_hd__fill_8_412 r0 *1 0,0
Xsky130_fd_sc_hd__fill_8_412 VGND VPWR VPWR sky130_fd_sc_hd__fill_8
* cell instance sky130_fd_sc_hd__fill_8_413 r0 *1 0,0
Xsky130_fd_sc_hd__fill_8_413 VGND VPWR VPWR sky130_fd_sc_hd__fill_8
* cell instance sky130_fd_sc_hd__fill_8_414 r0 *1 0,0
Xsky130_fd_sc_hd__fill_8_414 VGND VPWR VPWR sky130_fd_sc_hd__fill_8
* cell instance sky130_fd_sc_hd__fill_8_415 r0 *1 0,0
Xsky130_fd_sc_hd__fill_8_415 VGND VPWR VPWR sky130_fd_sc_hd__fill_8
* cell instance sky130_fd_sc_hd__fill_8_416 r0 *1 0,0
Xsky130_fd_sc_hd__fill_8_416 VGND VPWR VPWR sky130_fd_sc_hd__fill_8
* cell instance sky130_fd_sc_hd__fill_8_417 r0 *1 0,0
Xsky130_fd_sc_hd__fill_8_417 VGND VPWR VPWR sky130_fd_sc_hd__fill_8
* cell instance sky130_fd_sc_hd__fill_8_418 r0 *1 0,0
Xsky130_fd_sc_hd__fill_8_418 VGND VPWR VPWR sky130_fd_sc_hd__fill_8
* cell instance sky130_fd_sc_hd__fill_8_419 r0 *1 0,0
Xsky130_fd_sc_hd__fill_8_419 VGND VPWR VPWR sky130_fd_sc_hd__fill_8
* cell instance sky130_fd_sc_hd__fill_8_420 r0 *1 0,0
Xsky130_fd_sc_hd__fill_8_420 VGND VPWR VPWR sky130_fd_sc_hd__fill_8
* cell instance sky130_fd_sc_hd__fill_8_421 r0 *1 0,0
Xsky130_fd_sc_hd__fill_8_421 VGND VPWR VPWR sky130_fd_sc_hd__fill_8
* cell instance sky130_fd_sc_hd__fill_8_422 r0 *1 0,0
Xsky130_fd_sc_hd__fill_8_422 VGND VPWR VPWR sky130_fd_sc_hd__fill_8
* cell instance sky130_fd_sc_hd__fill_8_423 r0 *1 0,0
Xsky130_fd_sc_hd__fill_8_423 VGND VPWR VPWR sky130_fd_sc_hd__fill_8
* cell instance sky130_fd_sc_hd__fill_8_424 r0 *1 0,0
Xsky130_fd_sc_hd__fill_8_424 VGND VPWR VPWR sky130_fd_sc_hd__fill_8
* cell instance sky130_fd_sc_hd__fill_8_425 r0 *1 0,0
Xsky130_fd_sc_hd__fill_8_425 VGND VPWR VPWR sky130_fd_sc_hd__fill_8
* cell instance sky130_fd_sc_hd__fill_8_426 r0 *1 0,0
Xsky130_fd_sc_hd__fill_8_426 VGND VPWR VPWR sky130_fd_sc_hd__fill_8
* cell instance sky130_fd_sc_hd__fill_8_427 r0 *1 0,0
Xsky130_fd_sc_hd__fill_8_427 VGND VPWR VPWR sky130_fd_sc_hd__fill_8
* cell instance sky130_fd_sc_hd__fill_8_428 r0 *1 0,0
Xsky130_fd_sc_hd__fill_8_428 VGND VPWR VPWR sky130_fd_sc_hd__fill_8
* cell instance sky130_fd_sc_hd__fill_8_429 r0 *1 0,0
Xsky130_fd_sc_hd__fill_8_429 VGND VPWR VPWR sky130_fd_sc_hd__fill_8
* cell instance sky130_fd_sc_hd__fill_8_430 r0 *1 0,0
Xsky130_fd_sc_hd__fill_8_430 VGND VPWR VPWR sky130_fd_sc_hd__fill_8
* cell instance sky130_fd_sc_hd__fill_8_431 r0 *1 0,0
Xsky130_fd_sc_hd__fill_8_431 VGND VPWR VPWR sky130_fd_sc_hd__fill_8
* cell instance sky130_fd_sc_hd__fill_8_432 r0 *1 0,0
Xsky130_fd_sc_hd__fill_8_432 VGND VPWR VPWR sky130_fd_sc_hd__fill_8
* cell instance sky130_fd_sc_hd__fill_8_433 r0 *1 0,0
Xsky130_fd_sc_hd__fill_8_433 VGND VPWR VPWR sky130_fd_sc_hd__fill_8
* cell instance sky130_fd_sc_hd__fill_8_434 r0 *1 0,0
Xsky130_fd_sc_hd__fill_8_434 VGND VPWR VPWR sky130_fd_sc_hd__fill_8
* cell instance sky130_fd_sc_hd__fill_8_435 r0 *1 0,0
Xsky130_fd_sc_hd__fill_8_435 VGND VPWR VPWR sky130_fd_sc_hd__fill_8
* cell instance sky130_fd_sc_hd__fill_8_436 r0 *1 0,0
Xsky130_fd_sc_hd__fill_8_436 VGND VPWR VPWR sky130_fd_sc_hd__fill_8
* cell instance sky130_fd_sc_hd__fill_8_437 r0 *1 0,0
Xsky130_fd_sc_hd__fill_8_437 VGND VPWR VPWR sky130_fd_sc_hd__fill_8
* cell instance sky130_fd_sc_hd__fill_8_438 r0 *1 0,0
Xsky130_fd_sc_hd__fill_8_438 VGND VPWR VPWR sky130_fd_sc_hd__fill_8
* cell instance sky130_fd_sc_hd__fill_8_439 r0 *1 0,0
Xsky130_fd_sc_hd__fill_8_439 VGND VPWR VPWR sky130_fd_sc_hd__fill_8
* cell instance sky130_fd_sc_hd__fill_8_440 r0 *1 0,0
Xsky130_fd_sc_hd__fill_8_440 VGND VPWR VPWR sky130_fd_sc_hd__fill_8
* cell instance sky130_fd_sc_hd__fill_8_441 r0 *1 0,0
Xsky130_fd_sc_hd__fill_8_441 VGND VPWR VPWR sky130_fd_sc_hd__fill_8
* cell instance sky130_fd_sc_hd__fill_8_442 r0 *1 0,0
Xsky130_fd_sc_hd__fill_8_442 VGND VPWR VPWR sky130_fd_sc_hd__fill_8
* cell instance sky130_fd_sc_hd__fill_8_443 r0 *1 0,0
Xsky130_fd_sc_hd__fill_8_443 VGND VPWR VPWR sky130_fd_sc_hd__fill_8
* cell instance sky130_fd_sc_hd__fill_8_444 r0 *1 0,0
Xsky130_fd_sc_hd__fill_8_444 VGND VPWR VPWR sky130_fd_sc_hd__fill_8
* cell instance sky130_fd_sc_hd__fill_8_445 r0 *1 0,0
Xsky130_fd_sc_hd__fill_8_445 VGND VPWR VPWR sky130_fd_sc_hd__fill_8
* cell instance sky130_fd_sc_hd__fill_8_446 r0 *1 0,0
Xsky130_fd_sc_hd__fill_8_446 VGND VPWR VPWR sky130_fd_sc_hd__fill_8
* cell instance sky130_fd_sc_hd__fill_8_447 r0 *1 0,0
Xsky130_fd_sc_hd__fill_8_447 VGND VPWR VPWR sky130_fd_sc_hd__fill_8
* cell instance sky130_fd_sc_hd__fill_8_448 r0 *1 0,0
Xsky130_fd_sc_hd__fill_8_448 VGND VPWR VPWR sky130_fd_sc_hd__fill_8
* cell instance sky130_fd_sc_hd__fill_8_449 r0 *1 0,0
Xsky130_fd_sc_hd__fill_8_449 VGND VPWR VPWR sky130_fd_sc_hd__fill_8
* cell instance sky130_fd_sc_hd__fill_8_450 r0 *1 0,0
Xsky130_fd_sc_hd__fill_8_450 VGND VPWR VPWR sky130_fd_sc_hd__fill_8
* cell instance sky130_fd_sc_hd__fill_8_451 r0 *1 0,0
Xsky130_fd_sc_hd__fill_8_451 VGND VPWR VPWR sky130_fd_sc_hd__fill_8
* cell instance sky130_fd_sc_hd__fill_8_452 r0 *1 0,0
Xsky130_fd_sc_hd__fill_8_452 VGND VPWR VPWR sky130_fd_sc_hd__fill_8
* cell instance sky130_fd_sc_hd__fill_8_453 r0 *1 0,0
Xsky130_fd_sc_hd__fill_8_453 VGND VPWR VPWR sky130_fd_sc_hd__fill_8
* cell instance sky130_fd_sc_hd__fill_8_454 r0 *1 0,0
Xsky130_fd_sc_hd__fill_8_454 VGND VPWR VPWR sky130_fd_sc_hd__fill_8
* cell instance sky130_fd_sc_hd__fill_8_455 r0 *1 0,0
Xsky130_fd_sc_hd__fill_8_455 VGND VPWR VPWR sky130_fd_sc_hd__fill_8
* cell instance sky130_fd_sc_hd__fill_8_456 r0 *1 0,0
Xsky130_fd_sc_hd__fill_8_456 VGND VPWR VPWR sky130_fd_sc_hd__fill_8
* cell instance sky130_fd_sc_hd__fill_8_457 r0 *1 0,0
Xsky130_fd_sc_hd__fill_8_457 VGND VPWR VPWR sky130_fd_sc_hd__fill_8
* cell instance sky130_fd_sc_hd__fill_8_458 r0 *1 0,0
Xsky130_fd_sc_hd__fill_8_458 VGND VPWR VPWR sky130_fd_sc_hd__fill_8
* cell instance sky130_fd_sc_hd__fill_8_459 r0 *1 0,0
Xsky130_fd_sc_hd__fill_8_459 VGND VPWR VPWR sky130_fd_sc_hd__fill_8
* cell instance sky130_fd_sc_hd__fill_8_460 r0 *1 0,0
Xsky130_fd_sc_hd__fill_8_460 VGND VPWR VPWR sky130_fd_sc_hd__fill_8
* cell instance sky130_fd_sc_hd__fill_8_461 r0 *1 0,0
Xsky130_fd_sc_hd__fill_8_461 VGND VPWR VPWR sky130_fd_sc_hd__fill_8
* cell instance sky130_fd_sc_hd__fill_8_462 r0 *1 0,0
Xsky130_fd_sc_hd__fill_8_462 VGND VPWR VPWR sky130_fd_sc_hd__fill_8
* cell instance sky130_fd_sc_hd__fill_8_463 r0 *1 0,0
Xsky130_fd_sc_hd__fill_8_463 VGND VPWR VPWR sky130_fd_sc_hd__fill_8
* cell instance sky130_fd_sc_hd__fill_8_464 r0 *1 0,0
Xsky130_fd_sc_hd__fill_8_464 VGND VPWR VPWR sky130_fd_sc_hd__fill_8
* cell instance sky130_fd_sc_hd__fill_8_465 r0 *1 0,0
Xsky130_fd_sc_hd__fill_8_465 VGND VPWR VPWR sky130_fd_sc_hd__fill_8
* cell instance sky130_fd_sc_hd__fill_8_466 r0 *1 0,0
Xsky130_fd_sc_hd__fill_8_466 VGND VPWR VPWR sky130_fd_sc_hd__fill_8
* cell instance sky130_fd_sc_hd__fill_8_467 r0 *1 0,0
Xsky130_fd_sc_hd__fill_8_467 VGND VPWR VPWR sky130_fd_sc_hd__fill_8
* cell instance sky130_fd_sc_hd__fill_8_468 r0 *1 0,0
Xsky130_fd_sc_hd__fill_8_468 VGND VPWR VPWR sky130_fd_sc_hd__fill_8
* cell instance sky130_fd_sc_hd__fill_8_469 r0 *1 0,0
Xsky130_fd_sc_hd__fill_8_469 VGND VPWR VPWR sky130_fd_sc_hd__fill_8
* cell instance sky130_fd_sc_hd__fill_8_470 r0 *1 0,0
Xsky130_fd_sc_hd__fill_8_470 VGND VPWR VPWR sky130_fd_sc_hd__fill_8
* cell instance sky130_fd_sc_hd__fill_8_471 r0 *1 0,0
Xsky130_fd_sc_hd__fill_8_471 VGND VPWR VPWR sky130_fd_sc_hd__fill_8
* cell instance sky130_fd_sc_hd__fill_8_472 r0 *1 0,0
Xsky130_fd_sc_hd__fill_8_472 VGND VPWR VPWR sky130_fd_sc_hd__fill_8
* cell instance sky130_fd_sc_hd__fill_8_473 r0 *1 0,0
Xsky130_fd_sc_hd__fill_8_473 VGND VPWR VPWR sky130_fd_sc_hd__fill_8
* cell instance sky130_fd_sc_hd__fill_8_474 r0 *1 0,0
Xsky130_fd_sc_hd__fill_8_474 VGND VPWR VPWR sky130_fd_sc_hd__fill_8
* cell instance sky130_fd_sc_hd__fill_8_475 r0 *1 0,0
Xsky130_fd_sc_hd__fill_8_475 VGND VPWR VPWR sky130_fd_sc_hd__fill_8
* cell instance sky130_fd_sc_hd__fill_8_476 r0 *1 0,0
Xsky130_fd_sc_hd__fill_8_476 VGND VPWR VPWR sky130_fd_sc_hd__fill_8
* cell instance sky130_fd_sc_hd__fill_8_477 r0 *1 0,0
Xsky130_fd_sc_hd__fill_8_477 VGND VPWR VPWR sky130_fd_sc_hd__fill_8
* cell instance sky130_fd_sc_hd__fill_8_478 r0 *1 0,0
Xsky130_fd_sc_hd__fill_8_478 VGND VPWR VPWR sky130_fd_sc_hd__fill_8
* cell instance sky130_fd_sc_hd__fill_8_479 r0 *1 0,0
Xsky130_fd_sc_hd__fill_8_479 VGND VPWR VPWR sky130_fd_sc_hd__fill_8
* cell instance sky130_fd_sc_hd__fill_8_480 r0 *1 0,0
Xsky130_fd_sc_hd__fill_8_480 VGND VPWR VPWR sky130_fd_sc_hd__fill_8
* cell instance sky130_fd_sc_hd__fill_8_481 r0 *1 0,0
Xsky130_fd_sc_hd__fill_8_481 VGND VPWR VPWR sky130_fd_sc_hd__fill_8
* cell instance sky130_fd_sc_hd__fill_8_482 r0 *1 0,0
Xsky130_fd_sc_hd__fill_8_482 VGND VPWR VPWR sky130_fd_sc_hd__fill_8
* cell instance sky130_fd_sc_hd__fill_8_483 r0 *1 0,0
Xsky130_fd_sc_hd__fill_8_483 VGND VPWR VPWR sky130_fd_sc_hd__fill_8
* cell instance sky130_fd_sc_hd__fill_8_484 r0 *1 0,0
Xsky130_fd_sc_hd__fill_8_484 VGND VPWR VPWR sky130_fd_sc_hd__fill_8
* cell instance sky130_fd_sc_hd__fill_8_485 r0 *1 0,0
Xsky130_fd_sc_hd__fill_8_485 VGND VPWR VPWR sky130_fd_sc_hd__fill_8
* cell instance sky130_fd_sc_hd__fill_8_486 r0 *1 0,0
Xsky130_fd_sc_hd__fill_8_486 VGND VPWR VPWR sky130_fd_sc_hd__fill_8
* cell instance sky130_fd_sc_hd__fill_8_487 r0 *1 0,0
Xsky130_fd_sc_hd__fill_8_487 VGND VPWR VPWR sky130_fd_sc_hd__fill_8
* cell instance sky130_fd_sc_hd__fill_8_488 r0 *1 0,0
Xsky130_fd_sc_hd__fill_8_488 VGND VPWR VPWR sky130_fd_sc_hd__fill_8
* cell instance sky130_fd_sc_hd__fill_8_489 r0 *1 0,0
Xsky130_fd_sc_hd__fill_8_489 VGND VPWR VPWR sky130_fd_sc_hd__fill_8
* cell instance sky130_fd_sc_hd__fill_8_490 r0 *1 0,0
Xsky130_fd_sc_hd__fill_8_490 VGND VPWR VPWR sky130_fd_sc_hd__fill_8
* cell instance sky130_fd_sc_hd__fill_8_491 r0 *1 0,0
Xsky130_fd_sc_hd__fill_8_491 VGND VPWR VPWR sky130_fd_sc_hd__fill_8
* cell instance sky130_fd_sc_hd__fill_8_492 r0 *1 0,0
Xsky130_fd_sc_hd__fill_8_492 VGND VPWR VPWR sky130_fd_sc_hd__fill_8
* cell instance sky130_fd_sc_hd__fill_8_493 r0 *1 0,0
Xsky130_fd_sc_hd__fill_8_493 VGND VPWR VPWR sky130_fd_sc_hd__fill_8
* cell instance sky130_fd_sc_hd__fill_8_494 r0 *1 0,0
Xsky130_fd_sc_hd__fill_8_494 VGND VPWR VPWR sky130_fd_sc_hd__fill_8
* cell instance sky130_fd_sc_hd__fill_8_495 r0 *1 0,0
Xsky130_fd_sc_hd__fill_8_495 VGND VPWR VPWR sky130_fd_sc_hd__fill_8
* cell instance sky130_fd_sc_hd__fill_8_496 r0 *1 0,0
Xsky130_fd_sc_hd__fill_8_496 VGND VPWR VPWR sky130_fd_sc_hd__fill_8
* cell instance sky130_fd_sc_hd__fill_8_497 r0 *1 0,0
Xsky130_fd_sc_hd__fill_8_497 VGND VPWR VPWR sky130_fd_sc_hd__fill_8
* cell instance sky130_fd_sc_hd__fill_8_498 r0 *1 0,0
Xsky130_fd_sc_hd__fill_8_498 VGND VPWR VPWR sky130_fd_sc_hd__fill_8
* cell instance sky130_fd_sc_hd__fill_8_499 r0 *1 0,0
Xsky130_fd_sc_hd__fill_8_499 VGND VPWR VPWR sky130_fd_sc_hd__fill_8
* cell instance sky130_fd_sc_hd__fill_8_500 r0 *1 0,0
Xsky130_fd_sc_hd__fill_8_500 VGND VPWR VPWR sky130_fd_sc_hd__fill_8
* cell instance sky130_fd_sc_hd__fill_8_501 r0 *1 0,0
Xsky130_fd_sc_hd__fill_8_501 VGND VPWR VPWR sky130_fd_sc_hd__fill_8
* cell instance sky130_fd_sc_hd__fill_8_502 r0 *1 0,0
Xsky130_fd_sc_hd__fill_8_502 VGND VPWR VPWR sky130_fd_sc_hd__fill_8
* cell instance sky130_fd_sc_hd__fill_8_503 r0 *1 0,0
Xsky130_fd_sc_hd__fill_8_503 VGND VPWR VPWR sky130_fd_sc_hd__fill_8
* cell instance sky130_fd_sc_hd__fill_8_504 r0 *1 0,0
Xsky130_fd_sc_hd__fill_8_504 VGND VPWR VPWR sky130_fd_sc_hd__fill_8
* cell instance sky130_fd_sc_hd__fill_8_505 r0 *1 0,0
Xsky130_fd_sc_hd__fill_8_505 VGND VPWR VPWR sky130_fd_sc_hd__fill_8
* cell instance sky130_fd_sc_hd__fill_8_506 r0 *1 0,0
Xsky130_fd_sc_hd__fill_8_506 VGND VPWR VPWR sky130_fd_sc_hd__fill_8
* cell instance sky130_fd_sc_hd__fill_8_507 r0 *1 0,0
Xsky130_fd_sc_hd__fill_8_507 VGND VPWR VPWR sky130_fd_sc_hd__fill_8
* cell instance sky130_fd_sc_hd__fill_8_508 r0 *1 0,0
Xsky130_fd_sc_hd__fill_8_508 VGND VPWR VPWR sky130_fd_sc_hd__fill_8
* cell instance sky130_fd_sc_hd__fill_8_509 r0 *1 0,0
Xsky130_fd_sc_hd__fill_8_509 VGND VPWR VPWR sky130_fd_sc_hd__fill_8
* cell instance sky130_fd_sc_hd__fill_8_510 r0 *1 0,0
Xsky130_fd_sc_hd__fill_8_510 VGND VPWR VPWR sky130_fd_sc_hd__fill_8
* cell instance sky130_fd_sc_hd__fill_8_511 r0 *1 0,0
Xsky130_fd_sc_hd__fill_8_511 VGND VPWR VPWR sky130_fd_sc_hd__fill_8
* cell instance sky130_fd_sc_hd__fill_8_512 r0 *1 0,0
Xsky130_fd_sc_hd__fill_8_512 VGND VPWR VPWR sky130_fd_sc_hd__fill_8
* cell instance sky130_fd_sc_hd__fill_8_513 r0 *1 0,0
Xsky130_fd_sc_hd__fill_8_513 VGND VPWR VPWR sky130_fd_sc_hd__fill_8
* cell instance sky130_fd_sc_hd__fill_8_514 r0 *1 0,0
Xsky130_fd_sc_hd__fill_8_514 VGND VPWR VPWR sky130_fd_sc_hd__fill_8
* cell instance sky130_fd_sc_hd__fill_8_515 r0 *1 0,0
Xsky130_fd_sc_hd__fill_8_515 VGND VPWR VPWR sky130_fd_sc_hd__fill_8
* cell instance sky130_fd_sc_hd__fill_8_516 r0 *1 0,0
Xsky130_fd_sc_hd__fill_8_516 VGND VPWR VPWR sky130_fd_sc_hd__fill_8
* cell instance sky130_fd_sc_hd__fill_8_517 r0 *1 0,0
Xsky130_fd_sc_hd__fill_8_517 VGND VPWR VPWR sky130_fd_sc_hd__fill_8
* cell instance sky130_fd_sc_hd__fill_8_518 r0 *1 0,0
Xsky130_fd_sc_hd__fill_8_518 VGND VPWR VPWR sky130_fd_sc_hd__fill_8
* cell instance sky130_fd_sc_hd__fill_8_519 r0 *1 0,0
Xsky130_fd_sc_hd__fill_8_519 VGND VPWR VPWR sky130_fd_sc_hd__fill_8
* cell instance sky130_fd_sc_hd__fill_8_520 r0 *1 0,0
Xsky130_fd_sc_hd__fill_8_520 VGND VPWR VPWR sky130_fd_sc_hd__fill_8
* cell instance sky130_fd_sc_hd__fill_8_521 r0 *1 0,0
Xsky130_fd_sc_hd__fill_8_521 VGND VPWR VPWR sky130_fd_sc_hd__fill_8
* cell instance sky130_fd_sc_hd__fill_8_522 r0 *1 0,0
Xsky130_fd_sc_hd__fill_8_522 VGND VPWR VPWR sky130_fd_sc_hd__fill_8
* cell instance sky130_fd_sc_hd__fill_8_523 r0 *1 0,0
Xsky130_fd_sc_hd__fill_8_523 VGND VPWR VPWR sky130_fd_sc_hd__fill_8
* cell instance sky130_fd_sc_hd__fill_8_524 r0 *1 0,0
Xsky130_fd_sc_hd__fill_8_524 VGND VPWR VPWR sky130_fd_sc_hd__fill_8
* cell instance sky130_fd_sc_hd__fill_8_525 r0 *1 0,0
Xsky130_fd_sc_hd__fill_8_525 VGND VPWR VPWR sky130_fd_sc_hd__fill_8
* cell instance sky130_fd_sc_hd__fill_8_526 r0 *1 0,0
Xsky130_fd_sc_hd__fill_8_526 VGND VPWR VPWR sky130_fd_sc_hd__fill_8
* cell instance sky130_fd_sc_hd__fill_8_527 r0 *1 0,0
Xsky130_fd_sc_hd__fill_8_527 VGND VPWR VPWR sky130_fd_sc_hd__fill_8
* cell instance sky130_fd_sc_hd__fill_8_528 r0 *1 0,0
Xsky130_fd_sc_hd__fill_8_528 VGND VPWR VPWR sky130_fd_sc_hd__fill_8
* cell instance sky130_fd_sc_hd__fill_8_529 r0 *1 0,0
Xsky130_fd_sc_hd__fill_8_529 VGND VPWR VPWR sky130_fd_sc_hd__fill_8
* cell instance sky130_fd_sc_hd__fill_8_530 r0 *1 0,0
Xsky130_fd_sc_hd__fill_8_530 VGND VPWR VPWR sky130_fd_sc_hd__fill_8
* cell instance sky130_fd_sc_hd__fill_8_531 r0 *1 0,0
Xsky130_fd_sc_hd__fill_8_531 VGND VPWR VPWR sky130_fd_sc_hd__fill_8
* cell instance sky130_fd_sc_hd__fill_8_532 r0 *1 0,0
Xsky130_fd_sc_hd__fill_8_532 VGND VPWR VPWR sky130_fd_sc_hd__fill_8
* cell instance sky130_fd_sc_hd__fill_8_533 r0 *1 0,0
Xsky130_fd_sc_hd__fill_8_533 VGND VPWR VPWR sky130_fd_sc_hd__fill_8
* cell instance sky130_fd_sc_hd__fill_8_534 r0 *1 0,0
Xsky130_fd_sc_hd__fill_8_534 VGND VPWR VPWR sky130_fd_sc_hd__fill_8
* cell instance sky130_fd_sc_hd__fill_8_535 r0 *1 0,0
Xsky130_fd_sc_hd__fill_8_535 VGND VPWR VPWR sky130_fd_sc_hd__fill_8
* cell instance sky130_fd_sc_hd__fill_8_536 r0 *1 0,0
Xsky130_fd_sc_hd__fill_8_536 VGND VPWR VPWR sky130_fd_sc_hd__fill_8
* cell instance sky130_fd_sc_hd__fill_8_537 r0 *1 0,0
Xsky130_fd_sc_hd__fill_8_537 VGND VPWR VPWR sky130_fd_sc_hd__fill_8
* cell instance sky130_fd_sc_hd__fill_8_538 r0 *1 0,0
Xsky130_fd_sc_hd__fill_8_538 VGND VPWR VPWR sky130_fd_sc_hd__fill_8
* cell instance sky130_fd_sc_hd__fill_8_539 r0 *1 0,0
Xsky130_fd_sc_hd__fill_8_539 VGND VPWR VPWR sky130_fd_sc_hd__fill_8
* cell instance sky130_fd_sc_hd__fill_8_540 r0 *1 0,0
Xsky130_fd_sc_hd__fill_8_540 VGND VPWR VPWR sky130_fd_sc_hd__fill_8
* cell instance sky130_fd_sc_hd__fill_8_541 r0 *1 0,0
Xsky130_fd_sc_hd__fill_8_541 VGND VPWR VPWR sky130_fd_sc_hd__fill_8
* cell instance sky130_fd_sc_hd__fill_8_542 r0 *1 0,0
Xsky130_fd_sc_hd__fill_8_542 VGND VPWR VPWR sky130_fd_sc_hd__fill_8
* cell instance sky130_fd_sc_hd__fill_8_543 r0 *1 0,0
Xsky130_fd_sc_hd__fill_8_543 VGND VPWR VPWR sky130_fd_sc_hd__fill_8
* cell instance sky130_fd_sc_hd__fill_8_544 r0 *1 0,0
Xsky130_fd_sc_hd__fill_8_544 VGND VPWR VPWR sky130_fd_sc_hd__fill_8
* cell instance sky130_fd_sc_hd__fill_8_545 r0 *1 0,0
Xsky130_fd_sc_hd__fill_8_545 VGND VPWR VPWR sky130_fd_sc_hd__fill_8
* cell instance sky130_fd_sc_hd__fill_8_546 r0 *1 0,0
Xsky130_fd_sc_hd__fill_8_546 VGND VPWR VPWR sky130_fd_sc_hd__fill_8
* cell instance sky130_fd_sc_hd__fill_8_547 r0 *1 0,0
Xsky130_fd_sc_hd__fill_8_547 VGND VPWR VPWR sky130_fd_sc_hd__fill_8
* cell instance sky130_fd_sc_hd__fill_8_548 r0 *1 0,0
Xsky130_fd_sc_hd__fill_8_548 VGND VPWR VPWR sky130_fd_sc_hd__fill_8
* cell instance sky130_fd_sc_hd__fill_8_549 r0 *1 0,0
Xsky130_fd_sc_hd__fill_8_549 VGND VPWR VPWR sky130_fd_sc_hd__fill_8
* cell instance sky130_fd_sc_hd__fill_8_550 r0 *1 0,0
Xsky130_fd_sc_hd__fill_8_550 VGND VPWR VPWR sky130_fd_sc_hd__fill_8
* cell instance sky130_fd_sc_hd__fill_8_551 r0 *1 0,0
Xsky130_fd_sc_hd__fill_8_551 VGND VPWR VPWR sky130_fd_sc_hd__fill_8
* cell instance sky130_fd_sc_hd__fill_8_552 r0 *1 0,0
Xsky130_fd_sc_hd__fill_8_552 VGND VPWR VPWR sky130_fd_sc_hd__fill_8
* cell instance sky130_fd_sc_hd__fill_8_553 r0 *1 0,0
Xsky130_fd_sc_hd__fill_8_553 VGND VPWR VPWR sky130_fd_sc_hd__fill_8
* cell instance sky130_fd_sc_hd__fill_8_554 r0 *1 0,0
Xsky130_fd_sc_hd__fill_8_554 VGND VPWR VPWR sky130_fd_sc_hd__fill_8
* cell instance sky130_fd_sc_hd__fill_8_555 r0 *1 0,0
Xsky130_fd_sc_hd__fill_8_555 VGND VPWR VPWR sky130_fd_sc_hd__fill_8
* cell instance sky130_fd_sc_hd__fill_8_556 r0 *1 0,0
Xsky130_fd_sc_hd__fill_8_556 VGND VPWR VPWR sky130_fd_sc_hd__fill_8
* cell instance sky130_fd_sc_hd__fill_8_557 r0 *1 0,0
Xsky130_fd_sc_hd__fill_8_557 VGND VPWR VPWR sky130_fd_sc_hd__fill_8
* cell instance sky130_fd_sc_hd__fill_8_558 r0 *1 0,0
Xsky130_fd_sc_hd__fill_8_558 VGND VPWR VPWR sky130_fd_sc_hd__fill_8
* cell instance sky130_fd_sc_hd__fill_8_559 r0 *1 0,0
Xsky130_fd_sc_hd__fill_8_559 VGND VPWR VPWR sky130_fd_sc_hd__fill_8
* cell instance sky130_fd_sc_hd__fill_8_560 r0 *1 0,0
Xsky130_fd_sc_hd__fill_8_560 VGND VPWR VPWR sky130_fd_sc_hd__fill_8
* cell instance sky130_fd_sc_hd__fill_8_561 r0 *1 0,0
Xsky130_fd_sc_hd__fill_8_561 VGND VPWR VPWR sky130_fd_sc_hd__fill_8
* cell instance sky130_fd_sc_hd__fill_8_562 r0 *1 0,0
Xsky130_fd_sc_hd__fill_8_562 VGND VPWR VPWR sky130_fd_sc_hd__fill_8
* cell instance sky130_fd_sc_hd__fill_8_563 r0 *1 0,0
Xsky130_fd_sc_hd__fill_8_563 VGND VPWR VPWR sky130_fd_sc_hd__fill_8
* cell instance sky130_fd_sc_hd__fill_8_564 r0 *1 0,0
Xsky130_fd_sc_hd__fill_8_564 VGND VPWR VPWR sky130_fd_sc_hd__fill_8
* cell instance sky130_fd_sc_hd__fill_8_565 r0 *1 0,0
Xsky130_fd_sc_hd__fill_8_565 VGND VPWR VPWR sky130_fd_sc_hd__fill_8
* cell instance sky130_fd_sc_hd__fill_8_566 r0 *1 0,0
Xsky130_fd_sc_hd__fill_8_566 VGND VPWR VPWR sky130_fd_sc_hd__fill_8
* cell instance sky130_fd_sc_hd__fill_8_567 r0 *1 0,0
Xsky130_fd_sc_hd__fill_8_567 VGND VPWR VPWR sky130_fd_sc_hd__fill_8
* cell instance sky130_fd_sc_hd__fill_8_568 r0 *1 0,0
Xsky130_fd_sc_hd__fill_8_568 VGND VPWR VPWR sky130_fd_sc_hd__fill_8
* cell instance sky130_fd_sc_hd__fill_8_569 r0 *1 0,0
Xsky130_fd_sc_hd__fill_8_569 VGND VPWR VPWR sky130_fd_sc_hd__fill_8
* cell instance sky130_fd_sc_hd__fill_8_570 r0 *1 0,0
Xsky130_fd_sc_hd__fill_8_570 VGND VPWR VPWR sky130_fd_sc_hd__fill_8
* cell instance sky130_fd_sc_hd__fill_8_571 r0 *1 0,0
Xsky130_fd_sc_hd__fill_8_571 VGND VPWR VPWR sky130_fd_sc_hd__fill_8
* cell instance sky130_fd_sc_hd__fill_8_572 r0 *1 0,0
Xsky130_fd_sc_hd__fill_8_572 VGND VPWR VPWR sky130_fd_sc_hd__fill_8
* cell instance sky130_fd_sc_hd__fill_8_573 r0 *1 0,0
Xsky130_fd_sc_hd__fill_8_573 VGND VPWR VPWR sky130_fd_sc_hd__fill_8
* cell instance sky130_fd_sc_hd__fill_8_574 r0 *1 0,0
Xsky130_fd_sc_hd__fill_8_574 VGND VPWR VPWR sky130_fd_sc_hd__fill_8
* cell instance sky130_fd_sc_hd__fill_8_575 r0 *1 0,0
Xsky130_fd_sc_hd__fill_8_575 VGND VPWR VPWR sky130_fd_sc_hd__fill_8
* cell instance sky130_fd_sc_hd__fill_8_576 r0 *1 0,0
Xsky130_fd_sc_hd__fill_8_576 VGND VPWR VPWR sky130_fd_sc_hd__fill_8
* cell instance sky130_fd_sc_hd__fill_8_577 r0 *1 0,0
Xsky130_fd_sc_hd__fill_8_577 VGND VPWR VPWR sky130_fd_sc_hd__fill_8
* cell instance sky130_fd_sc_hd__fill_8_578 r0 *1 0,0
Xsky130_fd_sc_hd__fill_8_578 VGND VPWR VPWR sky130_fd_sc_hd__fill_8
* cell instance sky130_fd_sc_hd__fill_8_579 r0 *1 0,0
Xsky130_fd_sc_hd__fill_8_579 VGND VPWR VPWR sky130_fd_sc_hd__fill_8
* cell instance sky130_fd_sc_hd__fill_8_580 r0 *1 0,0
Xsky130_fd_sc_hd__fill_8_580 VGND VPWR VPWR sky130_fd_sc_hd__fill_8
* cell instance sky130_fd_sc_hd__fill_8_581 r0 *1 0,0
Xsky130_fd_sc_hd__fill_8_581 VGND VPWR VPWR sky130_fd_sc_hd__fill_8
* cell instance sky130_fd_sc_hd__fill_8_582 r0 *1 0,0
Xsky130_fd_sc_hd__fill_8_582 VGND VPWR VPWR sky130_fd_sc_hd__fill_8
* cell instance sky130_fd_sc_hd__fill_8_583 r0 *1 0,0
Xsky130_fd_sc_hd__fill_8_583 VGND VPWR VPWR sky130_fd_sc_hd__fill_8
* cell instance sky130_fd_sc_hd__fill_8_584 r0 *1 0,0
Xsky130_fd_sc_hd__fill_8_584 VGND VPWR VPWR sky130_fd_sc_hd__fill_8
* cell instance sky130_fd_sc_hd__fill_8_585 r0 *1 0,0
Xsky130_fd_sc_hd__fill_8_585 VGND VPWR VPWR sky130_fd_sc_hd__fill_8
* cell instance sky130_fd_sc_hd__fill_8_586 r0 *1 0,0
Xsky130_fd_sc_hd__fill_8_586 VGND VPWR VPWR sky130_fd_sc_hd__fill_8
* cell instance sky130_fd_sc_hd__fill_8_587 r0 *1 0,0
Xsky130_fd_sc_hd__fill_8_587 VGND VPWR VPWR sky130_fd_sc_hd__fill_8
* cell instance sky130_fd_sc_hd__fill_8_588 r0 *1 0,0
Xsky130_fd_sc_hd__fill_8_588 VGND VPWR VPWR sky130_fd_sc_hd__fill_8
* cell instance sky130_fd_sc_hd__fill_8_589 r0 *1 0,0
Xsky130_fd_sc_hd__fill_8_589 VGND VPWR VPWR sky130_fd_sc_hd__fill_8
* cell instance sky130_fd_sc_hd__fill_8_590 r0 *1 0,0
Xsky130_fd_sc_hd__fill_8_590 VGND VPWR VPWR sky130_fd_sc_hd__fill_8
* cell instance sky130_fd_sc_hd__fill_8_591 r0 *1 0,0
Xsky130_fd_sc_hd__fill_8_591 VGND VPWR VPWR sky130_fd_sc_hd__fill_8
* cell instance sky130_fd_sc_hd__fill_8_592 r0 *1 0,0
Xsky130_fd_sc_hd__fill_8_592 VGND VPWR VPWR sky130_fd_sc_hd__fill_8
* cell instance sky130_fd_sc_hd__fill_8_593 r0 *1 0,0
Xsky130_fd_sc_hd__fill_8_593 VGND VPWR VPWR sky130_fd_sc_hd__fill_8
* cell instance sky130_fd_sc_hd__fill_8_594 r0 *1 0,0
Xsky130_fd_sc_hd__fill_8_594 VGND VPWR VPWR sky130_fd_sc_hd__fill_8
* cell instance sky130_fd_sc_hd__fill_8_595 r0 *1 0,0
Xsky130_fd_sc_hd__fill_8_595 VGND VPWR VPWR sky130_fd_sc_hd__fill_8
* cell instance sky130_fd_sc_hd__fill_8_596 r0 *1 0,0
Xsky130_fd_sc_hd__fill_8_596 VGND VPWR VPWR sky130_fd_sc_hd__fill_8
* cell instance sky130_fd_sc_hd__fill_8_597 r0 *1 0,0
Xsky130_fd_sc_hd__fill_8_597 VGND VPWR VPWR sky130_fd_sc_hd__fill_8
* cell instance sky130_fd_sc_hd__fill_8_598 r0 *1 0,0
Xsky130_fd_sc_hd__fill_8_598 VGND VPWR VPWR sky130_fd_sc_hd__fill_8
* cell instance sky130_fd_sc_hd__fill_8_599 r0 *1 0,0
Xsky130_fd_sc_hd__fill_8_599 VGND VPWR VPWR sky130_fd_sc_hd__fill_8
* cell instance sky130_fd_sc_hd__fill_8_600 r0 *1 0,0
Xsky130_fd_sc_hd__fill_8_600 VGND VPWR VPWR sky130_fd_sc_hd__fill_8
* cell instance sky130_fd_sc_hd__fill_8_601 r0 *1 0,0
Xsky130_fd_sc_hd__fill_8_601 VGND VPWR VPWR sky130_fd_sc_hd__fill_8
* cell instance sky130_fd_sc_hd__fill_8_602 r0 *1 0,0
Xsky130_fd_sc_hd__fill_8_602 VGND VPWR VPWR sky130_fd_sc_hd__fill_8
* cell instance sky130_fd_sc_hd__fill_8_603 r0 *1 0,0
Xsky130_fd_sc_hd__fill_8_603 VGND VPWR VPWR sky130_fd_sc_hd__fill_8
* cell instance sky130_fd_sc_hd__fill_8_604 r0 *1 0,0
Xsky130_fd_sc_hd__fill_8_604 VGND VPWR VPWR sky130_fd_sc_hd__fill_8
* cell instance sky130_fd_sc_hd__fill_8_605 r0 *1 0,0
Xsky130_fd_sc_hd__fill_8_605 VGND VPWR VPWR sky130_fd_sc_hd__fill_8
* cell instance sky130_fd_sc_hd__fill_8_606 r0 *1 0,0
Xsky130_fd_sc_hd__fill_8_606 VGND VPWR VPWR sky130_fd_sc_hd__fill_8
* cell instance sky130_fd_sc_hd__fill_8_607 r0 *1 0,0
Xsky130_fd_sc_hd__fill_8_607 VGND VPWR VPWR sky130_fd_sc_hd__fill_8
* cell instance sky130_fd_sc_hd__fill_8_608 r0 *1 0,0
Xsky130_fd_sc_hd__fill_8_608 VGND VPWR VPWR sky130_fd_sc_hd__fill_8
* cell instance sky130_fd_sc_hd__fill_8_609 r0 *1 0,0
Xsky130_fd_sc_hd__fill_8_609 VGND VPWR VPWR sky130_fd_sc_hd__fill_8
* cell instance sky130_fd_sc_hd__fill_8_610 r0 *1 0,0
Xsky130_fd_sc_hd__fill_8_610 VGND VPWR VPWR sky130_fd_sc_hd__fill_8
* cell instance sky130_fd_sc_hd__fill_8_611 r0 *1 0,0
Xsky130_fd_sc_hd__fill_8_611 VGND VPWR VPWR sky130_fd_sc_hd__fill_8
* cell instance sky130_fd_sc_hd__fill_8_612 r0 *1 0,0
Xsky130_fd_sc_hd__fill_8_612 VGND VPWR VPWR sky130_fd_sc_hd__fill_8
* cell instance sky130_fd_sc_hd__fill_8_613 r0 *1 0,0
Xsky130_fd_sc_hd__fill_8_613 VGND VPWR VPWR sky130_fd_sc_hd__fill_8
* cell instance sky130_fd_sc_hd__fill_8_614 r0 *1 0,0
Xsky130_fd_sc_hd__fill_8_614 VGND VPWR VPWR sky130_fd_sc_hd__fill_8
* cell instance sky130_fd_sc_hd__fill_8_615 r0 *1 0,0
Xsky130_fd_sc_hd__fill_8_615 VGND VPWR VPWR sky130_fd_sc_hd__fill_8
* cell instance sky130_fd_sc_hd__fill_8_616 r0 *1 0,0
Xsky130_fd_sc_hd__fill_8_616 VGND VPWR VPWR sky130_fd_sc_hd__fill_8
* cell instance sky130_fd_sc_hd__fill_8_617 r0 *1 0,0
Xsky130_fd_sc_hd__fill_8_617 VGND VPWR VPWR sky130_fd_sc_hd__fill_8
* cell instance sky130_fd_sc_hd__fill_8_618 r0 *1 0,0
Xsky130_fd_sc_hd__fill_8_618 VGND VPWR VPWR sky130_fd_sc_hd__fill_8
* cell instance sky130_fd_sc_hd__fill_8_619 r0 *1 0,0
Xsky130_fd_sc_hd__fill_8_619 VGND VPWR VPWR sky130_fd_sc_hd__fill_8
* cell instance sky130_fd_sc_hd__fill_8_620 r0 *1 0,0
Xsky130_fd_sc_hd__fill_8_620 VGND VPWR VPWR sky130_fd_sc_hd__fill_8
* cell instance sky130_fd_sc_hd__fill_8_621 r0 *1 0,0
Xsky130_fd_sc_hd__fill_8_621 VGND VPWR VPWR sky130_fd_sc_hd__fill_8
* cell instance sky130_fd_sc_hd__fill_8_622 r0 *1 0,0
Xsky130_fd_sc_hd__fill_8_622 VGND VPWR VPWR sky130_fd_sc_hd__fill_8
* cell instance sky130_fd_sc_hd__fill_8_623 r0 *1 0,0
Xsky130_fd_sc_hd__fill_8_623 VGND VPWR VPWR sky130_fd_sc_hd__fill_8
* cell instance sky130_fd_sc_hd__fill_8_624 r0 *1 0,0
Xsky130_fd_sc_hd__fill_8_624 VGND VPWR VPWR sky130_fd_sc_hd__fill_8
* cell instance sky130_fd_sc_hd__fill_8_625 r0 *1 0,0
Xsky130_fd_sc_hd__fill_8_625 VGND VPWR VPWR sky130_fd_sc_hd__fill_8
* cell instance sky130_fd_sc_hd__fill_8_626 r0 *1 0,0
Xsky130_fd_sc_hd__fill_8_626 VGND VPWR VPWR sky130_fd_sc_hd__fill_8
* cell instance sky130_fd_sc_hd__fill_8_627 r0 *1 0,0
Xsky130_fd_sc_hd__fill_8_627 VGND VPWR VPWR sky130_fd_sc_hd__fill_8
* cell instance sky130_fd_sc_hd__fill_8_628 r0 *1 0,0
Xsky130_fd_sc_hd__fill_8_628 VGND VPWR VPWR sky130_fd_sc_hd__fill_8
* cell instance sky130_fd_sc_hd__fill_8_629 r0 *1 0,0
Xsky130_fd_sc_hd__fill_8_629 VGND VPWR VPWR sky130_fd_sc_hd__fill_8
* cell instance sky130_fd_sc_hd__fill_8_630 r0 *1 0,0
Xsky130_fd_sc_hd__fill_8_630 VGND VPWR VPWR sky130_fd_sc_hd__fill_8
* cell instance sky130_fd_sc_hd__fill_8_631 r0 *1 0,0
Xsky130_fd_sc_hd__fill_8_631 VGND VPWR VPWR sky130_fd_sc_hd__fill_8
* cell instance sky130_fd_sc_hd__fill_8_632 r0 *1 0,0
Xsky130_fd_sc_hd__fill_8_632 VGND VPWR VPWR sky130_fd_sc_hd__fill_8
* cell instance sky130_fd_sc_hd__fill_8_633 r0 *1 0,0
Xsky130_fd_sc_hd__fill_8_633 VGND VPWR VPWR sky130_fd_sc_hd__fill_8
* cell instance sky130_fd_sc_hd__fill_8_634 r0 *1 0,0
Xsky130_fd_sc_hd__fill_8_634 VGND VPWR VPWR sky130_fd_sc_hd__fill_8
* cell instance sky130_fd_sc_hd__fill_8_635 r0 *1 0,0
Xsky130_fd_sc_hd__fill_8_635 VGND VPWR VPWR sky130_fd_sc_hd__fill_8
* cell instance sky130_fd_sc_hd__fill_8_636 r0 *1 0,0
Xsky130_fd_sc_hd__fill_8_636 VGND VPWR VPWR sky130_fd_sc_hd__fill_8
* cell instance sky130_fd_sc_hd__fill_8_637 r0 *1 0,0
Xsky130_fd_sc_hd__fill_8_637 VGND VPWR VPWR sky130_fd_sc_hd__fill_8
* cell instance sky130_fd_sc_hd__fill_8_638 r0 *1 0,0
Xsky130_fd_sc_hd__fill_8_638 VGND VPWR VPWR sky130_fd_sc_hd__fill_8
* cell instance sky130_fd_sc_hd__fill_8_639 r0 *1 0,0
Xsky130_fd_sc_hd__fill_8_639 VGND VPWR VPWR sky130_fd_sc_hd__fill_8
* cell instance sky130_fd_sc_hd__fill_8_640 r0 *1 0,0
Xsky130_fd_sc_hd__fill_8_640 VGND VPWR VPWR sky130_fd_sc_hd__fill_8
* cell instance sky130_fd_sc_hd__fill_8_641 r0 *1 0,0
Xsky130_fd_sc_hd__fill_8_641 VGND VPWR VPWR sky130_fd_sc_hd__fill_8
* cell instance sky130_fd_sc_hd__fill_8_642 r0 *1 0,0
Xsky130_fd_sc_hd__fill_8_642 VGND VPWR VPWR sky130_fd_sc_hd__fill_8
* cell instance sky130_fd_sc_hd__fill_8_643 r0 *1 0,0
Xsky130_fd_sc_hd__fill_8_643 VGND VPWR VPWR sky130_fd_sc_hd__fill_8
* cell instance sky130_fd_sc_hd__fill_8_644 r0 *1 0,0
Xsky130_fd_sc_hd__fill_8_644 VGND VPWR VPWR sky130_fd_sc_hd__fill_8
* cell instance sky130_fd_sc_hd__fill_8_645 r0 *1 0,0
Xsky130_fd_sc_hd__fill_8_645 VGND VPWR VPWR sky130_fd_sc_hd__fill_8
* cell instance sky130_fd_sc_hd__fill_8_646 r0 *1 0,0
Xsky130_fd_sc_hd__fill_8_646 VGND VPWR VPWR sky130_fd_sc_hd__fill_8
* cell instance sky130_fd_sc_hd__fill_8_647 r0 *1 0,0
Xsky130_fd_sc_hd__fill_8_647 VGND VPWR VPWR sky130_fd_sc_hd__fill_8
* cell instance sky130_fd_sc_hd__fill_8_648 r0 *1 0,0
Xsky130_fd_sc_hd__fill_8_648 VGND VPWR VPWR sky130_fd_sc_hd__fill_8
* cell instance sky130_fd_sc_hd__fill_8_649 r0 *1 0,0
Xsky130_fd_sc_hd__fill_8_649 VGND VPWR VPWR sky130_fd_sc_hd__fill_8
* cell instance sky130_fd_sc_hd__fill_8_650 r0 *1 0,0
Xsky130_fd_sc_hd__fill_8_650 VGND VPWR VPWR sky130_fd_sc_hd__fill_8
* cell instance sky130_fd_sc_hd__fill_8_651 r0 *1 0,0
Xsky130_fd_sc_hd__fill_8_651 VGND VPWR VPWR sky130_fd_sc_hd__fill_8
* cell instance sky130_fd_sc_hd__fill_8_652 r0 *1 0,0
Xsky130_fd_sc_hd__fill_8_652 VGND VPWR VPWR sky130_fd_sc_hd__fill_8
* cell instance sky130_fd_sc_hd__fill_8_653 r0 *1 0,0
Xsky130_fd_sc_hd__fill_8_653 VGND VPWR VPWR sky130_fd_sc_hd__fill_8
* cell instance sky130_fd_sc_hd__fill_8_654 r0 *1 0,0
Xsky130_fd_sc_hd__fill_8_654 VGND VPWR VPWR sky130_fd_sc_hd__fill_8
* cell instance sky130_fd_sc_hd__fill_8_655 r0 *1 0,0
Xsky130_fd_sc_hd__fill_8_655 VGND VPWR VPWR sky130_fd_sc_hd__fill_8
* cell instance sky130_fd_sc_hd__fill_8_656 r0 *1 0,0
Xsky130_fd_sc_hd__fill_8_656 VGND VPWR VPWR sky130_fd_sc_hd__fill_8
* cell instance sky130_fd_sc_hd__fill_8_657 r0 *1 0,0
Xsky130_fd_sc_hd__fill_8_657 VGND VPWR VPWR sky130_fd_sc_hd__fill_8
* cell instance sky130_fd_sc_hd__fill_8_658 r0 *1 0,0
Xsky130_fd_sc_hd__fill_8_658 VGND VPWR VPWR sky130_fd_sc_hd__fill_8
* cell instance sky130_fd_sc_hd__fill_8_659 r0 *1 0,0
Xsky130_fd_sc_hd__fill_8_659 VGND VPWR VPWR sky130_fd_sc_hd__fill_8
* cell instance sky130_fd_sc_hd__fill_8_660 r0 *1 0,0
Xsky130_fd_sc_hd__fill_8_660 VGND VPWR VPWR sky130_fd_sc_hd__fill_8
* cell instance sky130_fd_sc_hd__fill_8_661 r0 *1 0,0
Xsky130_fd_sc_hd__fill_8_661 VGND VPWR VPWR sky130_fd_sc_hd__fill_8
* cell instance sky130_fd_sc_hd__fill_8_662 r0 *1 0,0
Xsky130_fd_sc_hd__fill_8_662 VGND VPWR VPWR sky130_fd_sc_hd__fill_8
* cell instance sky130_fd_sc_hd__fill_8_663 r0 *1 0,0
Xsky130_fd_sc_hd__fill_8_663 VGND VPWR VPWR sky130_fd_sc_hd__fill_8
* cell instance sky130_fd_sc_hd__fill_8_664 r0 *1 0,0
Xsky130_fd_sc_hd__fill_8_664 VGND VPWR VPWR sky130_fd_sc_hd__fill_8
* cell instance sky130_fd_sc_hd__fill_8_665 r0 *1 0,0
Xsky130_fd_sc_hd__fill_8_665 VGND VPWR VPWR sky130_fd_sc_hd__fill_8
* cell instance sky130_fd_sc_hd__fill_8_666 r0 *1 0,0
Xsky130_fd_sc_hd__fill_8_666 VGND VPWR VPWR sky130_fd_sc_hd__fill_8
* cell instance sky130_fd_sc_hd__fill_8_667 r0 *1 0,0
Xsky130_fd_sc_hd__fill_8_667 VGND VPWR VPWR sky130_fd_sc_hd__fill_8
* cell instance sky130_fd_sc_hd__fill_8_668 r0 *1 0,0
Xsky130_fd_sc_hd__fill_8_668 VGND VPWR VPWR sky130_fd_sc_hd__fill_8
* cell instance sky130_fd_sc_hd__fill_8_669 r0 *1 0,0
Xsky130_fd_sc_hd__fill_8_669 VGND VPWR VPWR sky130_fd_sc_hd__fill_8
* cell instance sky130_fd_sc_hd__fill_8_670 r0 *1 0,0
Xsky130_fd_sc_hd__fill_8_670 VGND VPWR VPWR sky130_fd_sc_hd__fill_8
* cell instance sky130_fd_sc_hd__fill_8_671 r0 *1 0,0
Xsky130_fd_sc_hd__fill_8_671 VGND VPWR VPWR sky130_fd_sc_hd__fill_8
* cell instance sky130_fd_sc_hd__fill_8_672 r0 *1 0,0
Xsky130_fd_sc_hd__fill_8_672 VGND VPWR VPWR sky130_fd_sc_hd__fill_8
* cell instance sky130_fd_sc_hd__fill_8_673 r0 *1 0,0
Xsky130_fd_sc_hd__fill_8_673 VGND VPWR VPWR sky130_fd_sc_hd__fill_8
* cell instance sky130_fd_sc_hd__fill_8_674 r0 *1 0,0
Xsky130_fd_sc_hd__fill_8_674 VGND VPWR VPWR sky130_fd_sc_hd__fill_8
* cell instance sky130_fd_sc_hd__fill_8_675 r0 *1 0,0
Xsky130_fd_sc_hd__fill_8_675 VGND VPWR VPWR sky130_fd_sc_hd__fill_8
* cell instance sky130_fd_sc_hd__fill_8_676 r0 *1 0,0
Xsky130_fd_sc_hd__fill_8_676 VGND VPWR VPWR sky130_fd_sc_hd__fill_8
* cell instance sky130_fd_sc_hd__fill_8_677 r0 *1 0,0
Xsky130_fd_sc_hd__fill_8_677 VGND VPWR VPWR sky130_fd_sc_hd__fill_8
* cell instance sky130_fd_sc_hd__fill_8_678 r0 *1 0,0
Xsky130_fd_sc_hd__fill_8_678 VGND VPWR VPWR sky130_fd_sc_hd__fill_8
* cell instance sky130_fd_sc_hd__fill_8_679 r0 *1 0,0
Xsky130_fd_sc_hd__fill_8_679 VGND VPWR VPWR sky130_fd_sc_hd__fill_8
* cell instance sky130_fd_sc_hd__fill_8_680 r0 *1 0,0
Xsky130_fd_sc_hd__fill_8_680 VGND VPWR VPWR sky130_fd_sc_hd__fill_8
* cell instance sky130_fd_sc_hd__fill_8_681 r0 *1 0,0
Xsky130_fd_sc_hd__fill_8_681 VGND VPWR VPWR sky130_fd_sc_hd__fill_8
* cell instance sky130_fd_sc_hd__fill_8_682 r0 *1 0,0
Xsky130_fd_sc_hd__fill_8_682 VGND VPWR VPWR sky130_fd_sc_hd__fill_8
* cell instance sky130_fd_sc_hd__fill_8_683 r0 *1 0,0
Xsky130_fd_sc_hd__fill_8_683 VGND VPWR VPWR sky130_fd_sc_hd__fill_8
* cell instance sky130_fd_sc_hd__fill_8_684 r0 *1 0,0
Xsky130_fd_sc_hd__fill_8_684 VGND VPWR VPWR sky130_fd_sc_hd__fill_8
* cell instance sky130_fd_sc_hd__fill_8_685 r0 *1 0,0
Xsky130_fd_sc_hd__fill_8_685 VGND VPWR VPWR sky130_fd_sc_hd__fill_8
* cell instance sky130_fd_sc_hd__fill_8_686 r0 *1 0,0
Xsky130_fd_sc_hd__fill_8_686 VGND VPWR VPWR sky130_fd_sc_hd__fill_8
* cell instance sky130_fd_sc_hd__fill_8_687 r0 *1 0,0
Xsky130_fd_sc_hd__fill_8_687 VGND VPWR VPWR sky130_fd_sc_hd__fill_8
* cell instance sky130_fd_sc_hd__fill_8_688 r0 *1 0,0
Xsky130_fd_sc_hd__fill_8_688 VGND VPWR VPWR sky130_fd_sc_hd__fill_8
* cell instance sky130_fd_sc_hd__fill_8_689 r0 *1 0,0
Xsky130_fd_sc_hd__fill_8_689 VGND VPWR VPWR sky130_fd_sc_hd__fill_8
* cell instance sky130_fd_sc_hd__fill_8_690 r0 *1 0,0
Xsky130_fd_sc_hd__fill_8_690 VGND VPWR VPWR sky130_fd_sc_hd__fill_8
* cell instance sky130_fd_sc_hd__fill_8_691 r0 *1 0,0
Xsky130_fd_sc_hd__fill_8_691 VGND VPWR VPWR sky130_fd_sc_hd__fill_8
* cell instance sky130_fd_sc_hd__fill_8_692 r0 *1 0,0
Xsky130_fd_sc_hd__fill_8_692 VGND VPWR VPWR sky130_fd_sc_hd__fill_8
* cell instance sky130_fd_sc_hd__fill_8_693 r0 *1 0,0
Xsky130_fd_sc_hd__fill_8_693 VGND VPWR VPWR sky130_fd_sc_hd__fill_8
* cell instance sky130_fd_sc_hd__fill_8_694 r0 *1 0,0
Xsky130_fd_sc_hd__fill_8_694 VGND VPWR VPWR sky130_fd_sc_hd__fill_8
* cell instance sky130_fd_sc_hd__fill_8_695 r0 *1 0,0
Xsky130_fd_sc_hd__fill_8_695 VGND VPWR VPWR sky130_fd_sc_hd__fill_8
* cell instance sky130_fd_sc_hd__fill_8_696 r0 *1 0,0
Xsky130_fd_sc_hd__fill_8_696 VGND VPWR VPWR sky130_fd_sc_hd__fill_8
* cell instance sky130_fd_sc_hd__fill_8_697 r0 *1 0,0
Xsky130_fd_sc_hd__fill_8_697 VGND VPWR VPWR sky130_fd_sc_hd__fill_8
* cell instance sky130_fd_sc_hd__fill_8_698 r0 *1 0,0
Xsky130_fd_sc_hd__fill_8_698 VGND VPWR VPWR sky130_fd_sc_hd__fill_8
* cell instance sky130_fd_sc_hd__fill_8_699 r0 *1 0,0
Xsky130_fd_sc_hd__fill_8_699 VGND VPWR VPWR sky130_fd_sc_hd__fill_8
* cell instance sky130_fd_sc_hd__fill_8_700 r0 *1 0,0
Xsky130_fd_sc_hd__fill_8_700 VGND VPWR VPWR sky130_fd_sc_hd__fill_8
* cell instance sky130_fd_sc_hd__fill_8_701 r0 *1 0,0
Xsky130_fd_sc_hd__fill_8_701 VGND VPWR VPWR sky130_fd_sc_hd__fill_8
* cell instance sky130_fd_sc_hd__fill_8_702 r0 *1 0,0
Xsky130_fd_sc_hd__fill_8_702 VGND VPWR VPWR sky130_fd_sc_hd__fill_8
* cell instance sky130_fd_sc_hd__fill_8_703 r0 *1 0,0
Xsky130_fd_sc_hd__fill_8_703 VGND VPWR VPWR sky130_fd_sc_hd__fill_8
* cell instance sky130_fd_sc_hd__fill_8_704 r0 *1 0,0
Xsky130_fd_sc_hd__fill_8_704 VGND VPWR VPWR sky130_fd_sc_hd__fill_8
* cell instance sky130_fd_sc_hd__fill_8_705 r0 *1 0,0
Xsky130_fd_sc_hd__fill_8_705 VGND VPWR VPWR sky130_fd_sc_hd__fill_8
* cell instance sky130_fd_sc_hd__fill_8_706 r0 *1 0,0
Xsky130_fd_sc_hd__fill_8_706 VGND VPWR VPWR sky130_fd_sc_hd__fill_8
* cell instance sky130_fd_sc_hd__fill_8_707 r0 *1 0,0
Xsky130_fd_sc_hd__fill_8_707 VGND VPWR VPWR sky130_fd_sc_hd__fill_8
* cell instance sky130_fd_sc_hd__fill_8_708 r0 *1 0,0
Xsky130_fd_sc_hd__fill_8_708 VGND VPWR VPWR sky130_fd_sc_hd__fill_8
* cell instance sky130_fd_sc_hd__fill_8_709 r0 *1 0,0
Xsky130_fd_sc_hd__fill_8_709 VGND VPWR VPWR sky130_fd_sc_hd__fill_8
* cell instance sky130_fd_sc_hd__fill_8_710 r0 *1 0,0
Xsky130_fd_sc_hd__fill_8_710 VGND VPWR VPWR sky130_fd_sc_hd__fill_8
* cell instance sky130_fd_sc_hd__fill_8_711 r0 *1 0,0
Xsky130_fd_sc_hd__fill_8_711 VGND VPWR VPWR sky130_fd_sc_hd__fill_8
* cell instance sky130_fd_sc_hd__fill_8_712 r0 *1 0,0
Xsky130_fd_sc_hd__fill_8_712 VGND VPWR VPWR sky130_fd_sc_hd__fill_8
* cell instance sky130_fd_sc_hd__fill_8_713 r0 *1 0,0
Xsky130_fd_sc_hd__fill_8_713 VGND VPWR VPWR sky130_fd_sc_hd__fill_8
* cell instance sky130_fd_sc_hd__fill_8_714 r0 *1 0,0
Xsky130_fd_sc_hd__fill_8_714 VGND VPWR VPWR sky130_fd_sc_hd__fill_8
* cell instance sky130_fd_sc_hd__fill_8_715 r0 *1 0,0
Xsky130_fd_sc_hd__fill_8_715 VGND VPWR VPWR sky130_fd_sc_hd__fill_8
* cell instance sky130_fd_sc_hd__fill_8_716 r0 *1 0,0
Xsky130_fd_sc_hd__fill_8_716 VGND VPWR VPWR sky130_fd_sc_hd__fill_8
* cell instance sky130_fd_sc_hd__fill_8_717 r0 *1 0,0
Xsky130_fd_sc_hd__fill_8_717 VGND VPWR VPWR sky130_fd_sc_hd__fill_8
* cell instance sky130_fd_sc_hd__fill_8_718 r0 *1 0,0
Xsky130_fd_sc_hd__fill_8_718 VGND VPWR VPWR sky130_fd_sc_hd__fill_8
* cell instance sky130_fd_sc_hd__fill_8_719 r0 *1 0,0
Xsky130_fd_sc_hd__fill_8_719 VGND VPWR VPWR sky130_fd_sc_hd__fill_8
* cell instance sky130_fd_sc_hd__fill_8_720 r0 *1 0,0
Xsky130_fd_sc_hd__fill_8_720 VGND VPWR VPWR sky130_fd_sc_hd__fill_8
* cell instance sky130_fd_sc_hd__fill_8_721 r0 *1 0,0
Xsky130_fd_sc_hd__fill_8_721 VGND VPWR VPWR sky130_fd_sc_hd__fill_8
* cell instance sky130_fd_sc_hd__fill_8_722 r0 *1 0,0
Xsky130_fd_sc_hd__fill_8_722 VGND VPWR VPWR sky130_fd_sc_hd__fill_8
* cell instance sky130_fd_sc_hd__fill_8_723 r0 *1 0,0
Xsky130_fd_sc_hd__fill_8_723 VGND VPWR VPWR sky130_fd_sc_hd__fill_8
* cell instance sky130_fd_sc_hd__fill_8_724 r0 *1 0,0
Xsky130_fd_sc_hd__fill_8_724 VGND VPWR VPWR sky130_fd_sc_hd__fill_8
* cell instance sky130_fd_sc_hd__fill_8_725 r0 *1 0,0
Xsky130_fd_sc_hd__fill_8_725 VGND VPWR VPWR sky130_fd_sc_hd__fill_8
* cell instance sky130_fd_sc_hd__fill_8_726 r0 *1 0,0
Xsky130_fd_sc_hd__fill_8_726 VGND VPWR VPWR sky130_fd_sc_hd__fill_8
* cell instance sky130_fd_sc_hd__fill_8_727 r0 *1 0,0
Xsky130_fd_sc_hd__fill_8_727 VGND VPWR VPWR sky130_fd_sc_hd__fill_8
* cell instance sky130_fd_sc_hd__fill_8_728 r0 *1 0,0
Xsky130_fd_sc_hd__fill_8_728 VGND VPWR VPWR sky130_fd_sc_hd__fill_8
* cell instance sky130_fd_sc_hd__fill_8_729 r0 *1 0,0
Xsky130_fd_sc_hd__fill_8_729 VGND VPWR VPWR sky130_fd_sc_hd__fill_8
* cell instance sky130_fd_sc_hd__fill_8_730 r0 *1 0,0
Xsky130_fd_sc_hd__fill_8_730 VGND VPWR VPWR sky130_fd_sc_hd__fill_8
* cell instance sky130_fd_sc_hd__fill_8_731 r0 *1 0,0
Xsky130_fd_sc_hd__fill_8_731 VGND VPWR VPWR sky130_fd_sc_hd__fill_8
* cell instance sky130_fd_sc_hd__fill_8_732 r0 *1 0,0
Xsky130_fd_sc_hd__fill_8_732 VGND VPWR VPWR sky130_fd_sc_hd__fill_8
* cell instance sky130_fd_sc_hd__fill_8_733 r0 *1 0,0
Xsky130_fd_sc_hd__fill_8_733 VGND VPWR VPWR sky130_fd_sc_hd__fill_8
* cell instance sky130_fd_sc_hd__fill_8_734 r0 *1 0,0
Xsky130_fd_sc_hd__fill_8_734 VGND VPWR VPWR sky130_fd_sc_hd__fill_8
* cell instance sky130_fd_sc_hd__fill_8_735 r0 *1 0,0
Xsky130_fd_sc_hd__fill_8_735 VGND VPWR VPWR sky130_fd_sc_hd__fill_8
* cell instance sky130_fd_sc_hd__fill_8_736 r0 *1 0,0
Xsky130_fd_sc_hd__fill_8_736 VGND VPWR VPWR sky130_fd_sc_hd__fill_8
* cell instance sky130_fd_sc_hd__fill_8_737 r0 *1 0,0
Xsky130_fd_sc_hd__fill_8_737 VGND VPWR VPWR sky130_fd_sc_hd__fill_8
* cell instance sky130_fd_sc_hd__fill_8_738 r0 *1 0,0
Xsky130_fd_sc_hd__fill_8_738 VGND VPWR VPWR sky130_fd_sc_hd__fill_8
* cell instance sky130_fd_sc_hd__fill_8_739 r0 *1 0,0
Xsky130_fd_sc_hd__fill_8_739 VGND VPWR VPWR sky130_fd_sc_hd__fill_8
* cell instance sky130_fd_sc_hd__fill_8_740 r0 *1 0,0
Xsky130_fd_sc_hd__fill_8_740 VGND VPWR VPWR sky130_fd_sc_hd__fill_8
* cell instance sky130_fd_sc_hd__fill_8_741 r0 *1 0,0
Xsky130_fd_sc_hd__fill_8_741 VGND VPWR VPWR sky130_fd_sc_hd__fill_8
* cell instance sky130_fd_sc_hd__fill_8_742 r0 *1 0,0
Xsky130_fd_sc_hd__fill_8_742 VGND VPWR VPWR sky130_fd_sc_hd__fill_8
* cell instance sky130_fd_sc_hd__fill_8_743 r0 *1 0,0
Xsky130_fd_sc_hd__fill_8_743 VGND VPWR VPWR sky130_fd_sc_hd__fill_8
* cell instance sky130_fd_sc_hd__fill_8_744 r0 *1 0,0
Xsky130_fd_sc_hd__fill_8_744 VGND VPWR VPWR sky130_fd_sc_hd__fill_8
* cell instance sky130_fd_sc_hd__fill_8_745 r0 *1 0,0
Xsky130_fd_sc_hd__fill_8_745 VGND VPWR VPWR sky130_fd_sc_hd__fill_8
* cell instance sky130_fd_sc_hd__fill_8_746 r0 *1 0,0
Xsky130_fd_sc_hd__fill_8_746 VGND VPWR VPWR sky130_fd_sc_hd__fill_8
* cell instance sky130_fd_sc_hd__fill_8_747 r0 *1 0,0
Xsky130_fd_sc_hd__fill_8_747 VGND VPWR VPWR sky130_fd_sc_hd__fill_8
* cell instance sky130_fd_sc_hd__fill_8_748 r0 *1 0,0
Xsky130_fd_sc_hd__fill_8_748 VGND VPWR VPWR sky130_fd_sc_hd__fill_8
* cell instance sky130_fd_sc_hd__fill_8_749 r0 *1 0,0
Xsky130_fd_sc_hd__fill_8_749 VGND VPWR VPWR sky130_fd_sc_hd__fill_8
* cell instance sky130_fd_sc_hd__fill_8_750 r0 *1 0,0
Xsky130_fd_sc_hd__fill_8_750 VGND VPWR VPWR sky130_fd_sc_hd__fill_8
* cell instance sky130_fd_sc_hd__fill_8_751 r0 *1 0,0
Xsky130_fd_sc_hd__fill_8_751 VGND VPWR VPWR sky130_fd_sc_hd__fill_8
* cell instance sky130_fd_sc_hd__fill_8_752 r0 *1 0,0
Xsky130_fd_sc_hd__fill_8_752 VGND VPWR VPWR sky130_fd_sc_hd__fill_8
* cell instance sky130_fd_sc_hd__fill_8_753 r0 *1 0,0
Xsky130_fd_sc_hd__fill_8_753 VGND VPWR VPWR sky130_fd_sc_hd__fill_8
* cell instance sky130_fd_sc_hd__fill_8_754 r0 *1 0,0
Xsky130_fd_sc_hd__fill_8_754 VGND VPWR VPWR sky130_fd_sc_hd__fill_8
* cell instance sky130_fd_sc_hd__fill_8_755 r0 *1 0,0
Xsky130_fd_sc_hd__fill_8_755 VGND VPWR VPWR sky130_fd_sc_hd__fill_8
* cell instance sky130_fd_sc_hd__fill_8_756 r0 *1 0,0
Xsky130_fd_sc_hd__fill_8_756 VGND VPWR VPWR sky130_fd_sc_hd__fill_8
* cell instance sky130_fd_sc_hd__fill_8_757 r0 *1 0,0
Xsky130_fd_sc_hd__fill_8_757 VGND VPWR VPWR sky130_fd_sc_hd__fill_8
* cell instance sky130_fd_sc_hd__fill_8_758 r0 *1 0,0
Xsky130_fd_sc_hd__fill_8_758 VGND VPWR VPWR sky130_fd_sc_hd__fill_8
* cell instance sky130_fd_sc_hd__fill_8_759 r0 *1 0,0
Xsky130_fd_sc_hd__fill_8_759 VGND VPWR VPWR sky130_fd_sc_hd__fill_8
* cell instance sky130_fd_sc_hd__fill_8_760 r0 *1 0,0
Xsky130_fd_sc_hd__fill_8_760 VGND VPWR VPWR sky130_fd_sc_hd__fill_8
* cell instance sky130_fd_sc_hd__fill_8_761 r0 *1 0,0
Xsky130_fd_sc_hd__fill_8_761 VGND VPWR VPWR sky130_fd_sc_hd__fill_8
* cell instance sky130_fd_sc_hd__fill_8_762 r0 *1 0,0
Xsky130_fd_sc_hd__fill_8_762 VGND VPWR VPWR sky130_fd_sc_hd__fill_8
* cell instance sky130_fd_sc_hd__fill_8_763 r0 *1 0,0
Xsky130_fd_sc_hd__fill_8_763 VGND VPWR VPWR sky130_fd_sc_hd__fill_8
* cell instance sky130_fd_sc_hd__fill_8_764 r0 *1 0,0
Xsky130_fd_sc_hd__fill_8_764 VGND VPWR VPWR sky130_fd_sc_hd__fill_8
* cell instance sky130_fd_sc_hd__fill_8_765 r0 *1 0,0
Xsky130_fd_sc_hd__fill_8_765 VGND VPWR VPWR sky130_fd_sc_hd__fill_8
* cell instance sky130_fd_sc_hd__fill_8_766 r0 *1 0,0
Xsky130_fd_sc_hd__fill_8_766 VGND VPWR VPWR sky130_fd_sc_hd__fill_8
* cell instance sky130_fd_sc_hd__fill_8_767 r0 *1 0,0
Xsky130_fd_sc_hd__fill_8_767 VGND VPWR VPWR sky130_fd_sc_hd__fill_8
* cell instance sky130_fd_sc_hd__fill_8_768 r0 *1 0,0
Xsky130_fd_sc_hd__fill_8_768 VGND VPWR VPWR sky130_fd_sc_hd__fill_8
* cell instance sky130_fd_sc_hd__fill_8_769 r0 *1 0,0
Xsky130_fd_sc_hd__fill_8_769 VGND VPWR VPWR sky130_fd_sc_hd__fill_8
* cell instance sky130_fd_sc_hd__fill_8_770 r0 *1 0,0
Xsky130_fd_sc_hd__fill_8_770 VGND VPWR VPWR sky130_fd_sc_hd__fill_8
* cell instance sky130_fd_sc_hd__fill_8_771 r0 *1 0,0
Xsky130_fd_sc_hd__fill_8_771 VGND VPWR VPWR sky130_fd_sc_hd__fill_8
* cell instance sky130_fd_sc_hd__fill_8_772 r0 *1 0,0
Xsky130_fd_sc_hd__fill_8_772 VGND VPWR VPWR sky130_fd_sc_hd__fill_8
* cell instance sky130_fd_sc_hd__fill_8_773 r0 *1 0,0
Xsky130_fd_sc_hd__fill_8_773 VGND VPWR VPWR sky130_fd_sc_hd__fill_8
* cell instance sky130_fd_sc_hd__fill_8_774 r0 *1 0,0
Xsky130_fd_sc_hd__fill_8_774 VGND VPWR VPWR sky130_fd_sc_hd__fill_8
* cell instance sky130_fd_sc_hd__fill_8_775 r0 *1 0,0
Xsky130_fd_sc_hd__fill_8_775 VGND VPWR VPWR sky130_fd_sc_hd__fill_8
* cell instance sky130_fd_sc_hd__fill_8_776 r0 *1 0,0
Xsky130_fd_sc_hd__fill_8_776 VGND VPWR VPWR sky130_fd_sc_hd__fill_8
* cell instance sky130_fd_sc_hd__fill_8_777 r0 *1 0,0
Xsky130_fd_sc_hd__fill_8_777 VGND VPWR VPWR sky130_fd_sc_hd__fill_8
* cell instance sky130_fd_sc_hd__fill_8_778 r0 *1 0,0
Xsky130_fd_sc_hd__fill_8_778 VGND VPWR VPWR sky130_fd_sc_hd__fill_8
* cell instance sky130_fd_sc_hd__fill_8_779 r0 *1 0,0
Xsky130_fd_sc_hd__fill_8_779 VGND VPWR VPWR sky130_fd_sc_hd__fill_8
* cell instance sky130_fd_sc_hd__fill_8_780 r0 *1 0,0
Xsky130_fd_sc_hd__fill_8_780 VGND VPWR VPWR sky130_fd_sc_hd__fill_8
* cell instance sky130_fd_sc_hd__fill_8_781 r0 *1 0,0
Xsky130_fd_sc_hd__fill_8_781 VGND VPWR VPWR sky130_fd_sc_hd__fill_8
* cell instance sky130_fd_sc_hd__fill_8_782 r0 *1 0,0
Xsky130_fd_sc_hd__fill_8_782 VGND VPWR VPWR sky130_fd_sc_hd__fill_8
* cell instance sky130_fd_sc_hd__fill_8_783 r0 *1 0,0
Xsky130_fd_sc_hd__fill_8_783 VGND VPWR VPWR sky130_fd_sc_hd__fill_8
* cell instance sky130_fd_sc_hd__fill_8_784 r0 *1 0,0
Xsky130_fd_sc_hd__fill_8_784 VGND VPWR VPWR sky130_fd_sc_hd__fill_8
* cell instance sky130_fd_sc_hd__fill_8_785 r0 *1 0,0
Xsky130_fd_sc_hd__fill_8_785 VGND VPWR VPWR sky130_fd_sc_hd__fill_8
* cell instance sky130_fd_sc_hd__fill_8_786 r0 *1 0,0
Xsky130_fd_sc_hd__fill_8_786 VGND VPWR VPWR sky130_fd_sc_hd__fill_8
* cell instance sky130_fd_sc_hd__fill_8_787 r0 *1 0,0
Xsky130_fd_sc_hd__fill_8_787 VGND VPWR VPWR sky130_fd_sc_hd__fill_8
* cell instance sky130_fd_sc_hd__fill_8_788 r0 *1 0,0
Xsky130_fd_sc_hd__fill_8_788 VGND VPWR VPWR sky130_fd_sc_hd__fill_8
* cell instance sky130_fd_sc_hd__fill_8_789 r0 *1 0,0
Xsky130_fd_sc_hd__fill_8_789 VGND VPWR VPWR sky130_fd_sc_hd__fill_8
* cell instance sky130_fd_sc_hd__fill_8_790 r0 *1 0,0
Xsky130_fd_sc_hd__fill_8_790 VGND VPWR VPWR sky130_fd_sc_hd__fill_8
* cell instance sky130_fd_sc_hd__fill_8_791 r0 *1 0,0
Xsky130_fd_sc_hd__fill_8_791 VGND VPWR VPWR sky130_fd_sc_hd__fill_8
* cell instance sky130_fd_sc_hd__fill_8_792 r0 *1 0,0
Xsky130_fd_sc_hd__fill_8_792 VGND VPWR VPWR sky130_fd_sc_hd__fill_8
* cell instance sky130_fd_sc_hd__fill_8_793 r0 *1 0,0
Xsky130_fd_sc_hd__fill_8_793 VGND VPWR VPWR sky130_fd_sc_hd__fill_8
* cell instance sky130_fd_sc_hd__fill_8_794 r0 *1 0,0
Xsky130_fd_sc_hd__fill_8_794 VGND VPWR VPWR sky130_fd_sc_hd__fill_8
* cell instance sky130_fd_sc_hd__fill_8_795 r0 *1 0,0
Xsky130_fd_sc_hd__fill_8_795 VGND VPWR VPWR sky130_fd_sc_hd__fill_8
* cell instance sky130_fd_sc_hd__fill_8_796 r0 *1 0,0
Xsky130_fd_sc_hd__fill_8_796 VGND VPWR VPWR sky130_fd_sc_hd__fill_8
* cell instance sky130_fd_sc_hd__fill_8_797 r0 *1 0,0
Xsky130_fd_sc_hd__fill_8_797 VGND VPWR VPWR sky130_fd_sc_hd__fill_8
* cell instance sky130_fd_sc_hd__fill_8_798 r0 *1 0,0
Xsky130_fd_sc_hd__fill_8_798 VGND VPWR VPWR sky130_fd_sc_hd__fill_8
* cell instance sky130_fd_sc_hd__fill_8_799 r0 *1 0,0
Xsky130_fd_sc_hd__fill_8_799 VGND VPWR VPWR sky130_fd_sc_hd__fill_8
* cell instance sky130_fd_sc_hd__fill_8_800 r0 *1 0,0
Xsky130_fd_sc_hd__fill_8_800 VGND VPWR VPWR sky130_fd_sc_hd__fill_8
* cell instance sky130_fd_sc_hd__fill_8_801 r0 *1 0,0
Xsky130_fd_sc_hd__fill_8_801 VGND VPWR VPWR sky130_fd_sc_hd__fill_8
* cell instance sky130_fd_sc_hd__fill_8_802 r0 *1 0,0
Xsky130_fd_sc_hd__fill_8_802 VGND VPWR VPWR sky130_fd_sc_hd__fill_8
* cell instance sky130_fd_sc_hd__fill_8_803 r0 *1 0,0
Xsky130_fd_sc_hd__fill_8_803 VGND VPWR VPWR sky130_fd_sc_hd__fill_8
* cell instance sky130_fd_sc_hd__fill_8_804 r0 *1 0,0
Xsky130_fd_sc_hd__fill_8_804 VGND VPWR VPWR sky130_fd_sc_hd__fill_8
* cell instance sky130_fd_sc_hd__fill_8_805 r0 *1 0,0
Xsky130_fd_sc_hd__fill_8_805 VGND VPWR VPWR sky130_fd_sc_hd__fill_8
* cell instance sky130_fd_sc_hd__fill_8_806 r0 *1 0,0
Xsky130_fd_sc_hd__fill_8_806 VGND VPWR VPWR sky130_fd_sc_hd__fill_8
* cell instance sky130_fd_sc_hd__fill_8_807 r0 *1 0,0
Xsky130_fd_sc_hd__fill_8_807 VGND VPWR VPWR sky130_fd_sc_hd__fill_8
* cell instance sky130_fd_sc_hd__fill_8_808 r0 *1 0,0
Xsky130_fd_sc_hd__fill_8_808 VGND VPWR VPWR sky130_fd_sc_hd__fill_8
* cell instance sky130_fd_sc_hd__fill_8_809 r0 *1 0,0
Xsky130_fd_sc_hd__fill_8_809 VGND VPWR VPWR sky130_fd_sc_hd__fill_8
* cell instance sky130_fd_sc_hd__fill_8_810 r0 *1 0,0
Xsky130_fd_sc_hd__fill_8_810 VGND VPWR VPWR sky130_fd_sc_hd__fill_8
* cell instance sky130_fd_sc_hd__fill_8_811 r0 *1 0,0
Xsky130_fd_sc_hd__fill_8_811 VGND VPWR VPWR sky130_fd_sc_hd__fill_8
* cell instance sky130_fd_sc_hd__fill_8_812 r0 *1 0,0
Xsky130_fd_sc_hd__fill_8_812 VGND VPWR VPWR sky130_fd_sc_hd__fill_8
* cell instance sky130_fd_sc_hd__fill_8_813 r0 *1 0,0
Xsky130_fd_sc_hd__fill_8_813 VGND VPWR VPWR sky130_fd_sc_hd__fill_8
* cell instance sky130_fd_sc_hd__fill_8_814 r0 *1 0,0
Xsky130_fd_sc_hd__fill_8_814 VGND VPWR VPWR sky130_fd_sc_hd__fill_8
* cell instance sky130_fd_sc_hd__fill_8_815 r0 *1 0,0
Xsky130_fd_sc_hd__fill_8_815 VGND VPWR VPWR sky130_fd_sc_hd__fill_8
* cell instance sky130_fd_sc_hd__fill_8_816 r0 *1 0,0
Xsky130_fd_sc_hd__fill_8_816 VGND VPWR VPWR sky130_fd_sc_hd__fill_8
* cell instance sky130_fd_sc_hd__fill_8_817 r0 *1 0,0
Xsky130_fd_sc_hd__fill_8_817 VGND VPWR VPWR sky130_fd_sc_hd__fill_8
* cell instance sky130_fd_sc_hd__fill_8_818 r0 *1 0,0
Xsky130_fd_sc_hd__fill_8_818 VGND VPWR VPWR sky130_fd_sc_hd__fill_8
* cell instance sky130_fd_sc_hd__fill_8_819 r0 *1 0,0
Xsky130_fd_sc_hd__fill_8_819 VGND VPWR VPWR sky130_fd_sc_hd__fill_8
* cell instance sky130_fd_sc_hd__fill_8_820 r0 *1 0,0
Xsky130_fd_sc_hd__fill_8_820 VGND VPWR VPWR sky130_fd_sc_hd__fill_8
* cell instance sky130_fd_sc_hd__fill_8_821 r0 *1 0,0
Xsky130_fd_sc_hd__fill_8_821 VGND VPWR VPWR sky130_fd_sc_hd__fill_8
* cell instance sky130_fd_sc_hd__fill_8_822 r0 *1 0,0
Xsky130_fd_sc_hd__fill_8_822 VGND VPWR VPWR sky130_fd_sc_hd__fill_8
* cell instance sky130_fd_sc_hd__fill_8_823 r0 *1 0,0
Xsky130_fd_sc_hd__fill_8_823 VGND VPWR VPWR sky130_fd_sc_hd__fill_8
* cell instance sky130_fd_sc_hd__fill_8_824 r0 *1 0,0
Xsky130_fd_sc_hd__fill_8_824 VGND VPWR VPWR sky130_fd_sc_hd__fill_8
* cell instance sky130_fd_sc_hd__fill_8_825 r0 *1 0,0
Xsky130_fd_sc_hd__fill_8_825 VGND VPWR VPWR sky130_fd_sc_hd__fill_8
* cell instance sky130_fd_sc_hd__fill_8_826 r0 *1 0,0
Xsky130_fd_sc_hd__fill_8_826 VGND VPWR VPWR sky130_fd_sc_hd__fill_8
* cell instance sky130_fd_sc_hd__fill_8_827 r0 *1 0,0
Xsky130_fd_sc_hd__fill_8_827 VGND VPWR VPWR sky130_fd_sc_hd__fill_8
* cell instance sky130_fd_sc_hd__fill_8_828 r0 *1 0,0
Xsky130_fd_sc_hd__fill_8_828 VGND VPWR VPWR sky130_fd_sc_hd__fill_8
* cell instance sky130_fd_sc_hd__fill_8_829 r0 *1 0,0
Xsky130_fd_sc_hd__fill_8_829 VGND VPWR VPWR sky130_fd_sc_hd__fill_8
* cell instance sky130_fd_sc_hd__fill_8_830 r0 *1 0,0
Xsky130_fd_sc_hd__fill_8_830 VGND VPWR VPWR sky130_fd_sc_hd__fill_8
* cell instance sky130_fd_sc_hd__fill_8_831 r0 *1 0,0
Xsky130_fd_sc_hd__fill_8_831 VGND VPWR VPWR sky130_fd_sc_hd__fill_8
* cell instance sky130_fd_sc_hd__fill_8_832 r0 *1 0,0
Xsky130_fd_sc_hd__fill_8_832 VGND VPWR VPWR sky130_fd_sc_hd__fill_8
* cell instance sky130_fd_sc_hd__fill_8_833 r0 *1 0,0
Xsky130_fd_sc_hd__fill_8_833 VGND VPWR VPWR sky130_fd_sc_hd__fill_8
* cell instance sky130_fd_sc_hd__fill_8_834 r0 *1 0,0
Xsky130_fd_sc_hd__fill_8_834 VGND VPWR VPWR sky130_fd_sc_hd__fill_8
* cell instance sky130_fd_sc_hd__fill_8_835 r0 *1 0,0
Xsky130_fd_sc_hd__fill_8_835 VGND VPWR VPWR sky130_fd_sc_hd__fill_8
* cell instance sky130_fd_sc_hd__fill_8_836 r0 *1 0,0
Xsky130_fd_sc_hd__fill_8_836 VGND VPWR VPWR sky130_fd_sc_hd__fill_8
* cell instance sky130_fd_sc_hd__fill_8_837 r0 *1 0,0
Xsky130_fd_sc_hd__fill_8_837 VGND VPWR VPWR sky130_fd_sc_hd__fill_8
* cell instance sky130_fd_sc_hd__fill_8_838 r0 *1 0,0
Xsky130_fd_sc_hd__fill_8_838 VGND VPWR VPWR sky130_fd_sc_hd__fill_8
* cell instance sky130_fd_sc_hd__fill_8_839 r0 *1 0,0
Xsky130_fd_sc_hd__fill_8_839 VGND VPWR VPWR sky130_fd_sc_hd__fill_8
* cell instance sky130_fd_sc_hd__fill_8_840 r0 *1 0,0
Xsky130_fd_sc_hd__fill_8_840 VGND VPWR VPWR sky130_fd_sc_hd__fill_8
* cell instance sky130_fd_sc_hd__fill_8_841 r0 *1 0,0
Xsky130_fd_sc_hd__fill_8_841 VGND VPWR VPWR sky130_fd_sc_hd__fill_8
* cell instance sky130_fd_sc_hd__fill_8_842 r0 *1 0,0
Xsky130_fd_sc_hd__fill_8_842 VGND VPWR VPWR sky130_fd_sc_hd__fill_8
* cell instance sky130_fd_sc_hd__fill_8_843 r0 *1 0,0
Xsky130_fd_sc_hd__fill_8_843 VGND VPWR VPWR sky130_fd_sc_hd__fill_8
* cell instance sky130_fd_sc_hd__fill_8_844 r0 *1 0,0
Xsky130_fd_sc_hd__fill_8_844 VGND VPWR VPWR sky130_fd_sc_hd__fill_8
* cell instance sky130_fd_sc_hd__fill_8_845 r0 *1 0,0
Xsky130_fd_sc_hd__fill_8_845 VGND VPWR VPWR sky130_fd_sc_hd__fill_8
* cell instance sky130_fd_sc_hd__fill_8_846 r0 *1 0,0
Xsky130_fd_sc_hd__fill_8_846 VGND VPWR VPWR sky130_fd_sc_hd__fill_8
* cell instance sky130_fd_sc_hd__fill_8_847 r0 *1 0,0
Xsky130_fd_sc_hd__fill_8_847 VGND VPWR VPWR sky130_fd_sc_hd__fill_8
* cell instance sky130_fd_sc_hd__fill_8_848 r0 *1 0,0
Xsky130_fd_sc_hd__fill_8_848 VGND VPWR VPWR sky130_fd_sc_hd__fill_8
* cell instance sky130_fd_sc_hd__fill_8_849 r0 *1 0,0
Xsky130_fd_sc_hd__fill_8_849 VGND VPWR VPWR sky130_fd_sc_hd__fill_8
* cell instance sky130_fd_sc_hd__fill_8_850 r0 *1 0,0
Xsky130_fd_sc_hd__fill_8_850 VGND VPWR VPWR sky130_fd_sc_hd__fill_8
* cell instance sky130_fd_sc_hd__fill_8_851 r0 *1 0,0
Xsky130_fd_sc_hd__fill_8_851 VGND VPWR VPWR sky130_fd_sc_hd__fill_8
* cell instance sky130_fd_sc_hd__fill_8_852 r0 *1 0,0
Xsky130_fd_sc_hd__fill_8_852 VGND VPWR VPWR sky130_fd_sc_hd__fill_8
* cell instance sky130_fd_sc_hd__fill_8_853 r0 *1 0,0
Xsky130_fd_sc_hd__fill_8_853 VGND VPWR VPWR sky130_fd_sc_hd__fill_8
* cell instance sky130_fd_sc_hd__fill_8_854 r0 *1 0,0
Xsky130_fd_sc_hd__fill_8_854 VGND VPWR VPWR sky130_fd_sc_hd__fill_8
* cell instance sky130_fd_sc_hd__fill_8_855 r0 *1 0,0
Xsky130_fd_sc_hd__fill_8_855 VGND VPWR VPWR sky130_fd_sc_hd__fill_8
* cell instance sky130_fd_sc_hd__fill_8_856 r0 *1 0,0
Xsky130_fd_sc_hd__fill_8_856 VGND VPWR VPWR sky130_fd_sc_hd__fill_8
* cell instance sky130_fd_sc_hd__fill_8_857 r0 *1 0,0
Xsky130_fd_sc_hd__fill_8_857 VGND VPWR VPWR sky130_fd_sc_hd__fill_8
* cell instance sky130_fd_sc_hd__fill_8_858 r0 *1 0,0
Xsky130_fd_sc_hd__fill_8_858 VGND VPWR VPWR sky130_fd_sc_hd__fill_8
* cell instance sky130_fd_sc_hd__fill_8_859 r0 *1 0,0
Xsky130_fd_sc_hd__fill_8_859 VGND VPWR VPWR sky130_fd_sc_hd__fill_8
* cell instance sky130_fd_sc_hd__fill_8_860 r0 *1 0,0
Xsky130_fd_sc_hd__fill_8_860 VGND VPWR VPWR sky130_fd_sc_hd__fill_8
* cell instance sky130_fd_sc_hd__fill_8_861 r0 *1 0,0
Xsky130_fd_sc_hd__fill_8_861 VGND VPWR VPWR sky130_fd_sc_hd__fill_8
* cell instance sky130_fd_sc_hd__fill_8_862 r0 *1 0,0
Xsky130_fd_sc_hd__fill_8_862 VGND VPWR VPWR sky130_fd_sc_hd__fill_8
* cell instance sky130_fd_sc_hd__fill_8_863 r0 *1 0,0
Xsky130_fd_sc_hd__fill_8_863 VGND VPWR VPWR sky130_fd_sc_hd__fill_8
* cell instance sky130_fd_sc_hd__fill_8_864 r0 *1 0,0
Xsky130_fd_sc_hd__fill_8_864 VGND VPWR VPWR sky130_fd_sc_hd__fill_8
* cell instance sky130_fd_sc_hd__fill_8_865 r0 *1 0,0
Xsky130_fd_sc_hd__fill_8_865 VGND VPWR VPWR sky130_fd_sc_hd__fill_8
* cell instance sky130_fd_sc_hd__fill_8_866 r0 *1 0,0
Xsky130_fd_sc_hd__fill_8_866 VGND VPWR VPWR sky130_fd_sc_hd__fill_8
* cell instance sky130_fd_sc_hd__fill_8_867 r0 *1 0,0
Xsky130_fd_sc_hd__fill_8_867 VGND VPWR VPWR sky130_fd_sc_hd__fill_8
* cell instance sky130_fd_sc_hd__fill_8_868 r0 *1 0,0
Xsky130_fd_sc_hd__fill_8_868 VGND VPWR VPWR sky130_fd_sc_hd__fill_8
* cell instance sky130_fd_sc_hd__fill_8_869 r0 *1 0,0
Xsky130_fd_sc_hd__fill_8_869 VGND VPWR VPWR sky130_fd_sc_hd__fill_8
* cell instance sky130_fd_sc_hd__fill_8_870 r0 *1 0,0
Xsky130_fd_sc_hd__fill_8_870 VGND VPWR VPWR sky130_fd_sc_hd__fill_8
* cell instance sky130_fd_sc_hd__fill_8_871 r0 *1 0,0
Xsky130_fd_sc_hd__fill_8_871 VGND VPWR VPWR sky130_fd_sc_hd__fill_8
* cell instance sky130_fd_sc_hd__fill_8_872 r0 *1 0,0
Xsky130_fd_sc_hd__fill_8_872 VGND VPWR VPWR sky130_fd_sc_hd__fill_8
* cell instance sky130_fd_sc_hd__fill_8_873 r0 *1 0,0
Xsky130_fd_sc_hd__fill_8_873 VGND VPWR VPWR sky130_fd_sc_hd__fill_8
* cell instance sky130_fd_sc_hd__fill_8_874 r0 *1 0,0
Xsky130_fd_sc_hd__fill_8_874 VGND VPWR VPWR sky130_fd_sc_hd__fill_8
* cell instance sky130_fd_sc_hd__fill_8_875 r0 *1 0,0
Xsky130_fd_sc_hd__fill_8_875 VGND VPWR VPWR sky130_fd_sc_hd__fill_8
* cell instance sky130_fd_sc_hd__fill_8_876 r0 *1 0,0
Xsky130_fd_sc_hd__fill_8_876 VGND VPWR VPWR sky130_fd_sc_hd__fill_8
* cell instance sky130_fd_sc_hd__fill_8_877 r0 *1 0,0
Xsky130_fd_sc_hd__fill_8_877 VGND VPWR VPWR sky130_fd_sc_hd__fill_8
* cell instance sky130_fd_sc_hd__fill_8_878 r0 *1 0,0
Xsky130_fd_sc_hd__fill_8_878 VGND VPWR VPWR sky130_fd_sc_hd__fill_8
* cell instance sky130_fd_sc_hd__fill_8_879 r0 *1 0,0
Xsky130_fd_sc_hd__fill_8_879 VGND VPWR VPWR sky130_fd_sc_hd__fill_8
* cell instance sky130_fd_sc_hd__fill_8_880 r0 *1 0,0
Xsky130_fd_sc_hd__fill_8_880 VGND VPWR VPWR sky130_fd_sc_hd__fill_8
* cell instance sky130_fd_sc_hd__fill_8_881 r0 *1 0,0
Xsky130_fd_sc_hd__fill_8_881 VGND VPWR VPWR sky130_fd_sc_hd__fill_8
* cell instance sky130_fd_sc_hd__fill_8_882 r0 *1 0,0
Xsky130_fd_sc_hd__fill_8_882 VGND VPWR VPWR sky130_fd_sc_hd__fill_8
* cell instance sky130_fd_sc_hd__fill_8_883 r0 *1 0,0
Xsky130_fd_sc_hd__fill_8_883 VGND VPWR VPWR sky130_fd_sc_hd__fill_8
* cell instance sky130_fd_sc_hd__fill_8_884 r0 *1 0,0
Xsky130_fd_sc_hd__fill_8_884 VGND VPWR VPWR sky130_fd_sc_hd__fill_8
* cell instance sky130_fd_sc_hd__fill_8_885 r0 *1 0,0
Xsky130_fd_sc_hd__fill_8_885 VGND VPWR VPWR sky130_fd_sc_hd__fill_8
* cell instance sky130_fd_sc_hd__fill_8_886 r0 *1 0,0
Xsky130_fd_sc_hd__fill_8_886 VGND VPWR VPWR sky130_fd_sc_hd__fill_8
* cell instance sky130_fd_sc_hd__fill_8_887 r0 *1 0,0
Xsky130_fd_sc_hd__fill_8_887 VGND VPWR VPWR sky130_fd_sc_hd__fill_8
* cell instance sky130_fd_sc_hd__fill_8_888 r0 *1 0,0
Xsky130_fd_sc_hd__fill_8_888 VGND VPWR VPWR sky130_fd_sc_hd__fill_8
* cell instance sky130_fd_sc_hd__fill_8_889 r0 *1 0,0
Xsky130_fd_sc_hd__fill_8_889 VGND VPWR VPWR sky130_fd_sc_hd__fill_8
* cell instance sky130_fd_sc_hd__fill_8_890 r0 *1 0,0
Xsky130_fd_sc_hd__fill_8_890 VGND VPWR VPWR sky130_fd_sc_hd__fill_8
* cell instance sky130_fd_sc_hd__fill_8_891 r0 *1 0,0
Xsky130_fd_sc_hd__fill_8_891 VGND VPWR VPWR sky130_fd_sc_hd__fill_8
* cell instance sky130_fd_sc_hd__fill_8_892 r0 *1 0,0
Xsky130_fd_sc_hd__fill_8_892 VGND VPWR VPWR sky130_fd_sc_hd__fill_8
* cell instance sky130_fd_sc_hd__fill_8_893 r0 *1 0,0
Xsky130_fd_sc_hd__fill_8_893 VGND VPWR VPWR sky130_fd_sc_hd__fill_8
* cell instance sky130_fd_sc_hd__fill_8_894 r0 *1 0,0
Xsky130_fd_sc_hd__fill_8_894 VGND VPWR VPWR sky130_fd_sc_hd__fill_8
* cell instance sky130_fd_sc_hd__fill_8_895 r0 *1 0,0
Xsky130_fd_sc_hd__fill_8_895 VGND VPWR VPWR sky130_fd_sc_hd__fill_8
* cell instance sky130_fd_sc_hd__fill_8_896 r0 *1 0,0
Xsky130_fd_sc_hd__fill_8_896 VGND VPWR VPWR sky130_fd_sc_hd__fill_8
* cell instance sky130_fd_sc_hd__fill_8_897 r0 *1 0,0
Xsky130_fd_sc_hd__fill_8_897 VGND VPWR VPWR sky130_fd_sc_hd__fill_8
* cell instance sky130_fd_sc_hd__fill_8_898 r0 *1 0,0
Xsky130_fd_sc_hd__fill_8_898 VGND VPWR VPWR sky130_fd_sc_hd__fill_8
* cell instance sky130_fd_sc_hd__fill_8_899 r0 *1 0,0
Xsky130_fd_sc_hd__fill_8_899 VGND VPWR VPWR sky130_fd_sc_hd__fill_8
* cell instance sky130_fd_sc_hd__fill_8_900 r0 *1 0,0
Xsky130_fd_sc_hd__fill_8_900 VGND VPWR VPWR sky130_fd_sc_hd__fill_8
* cell instance sky130_fd_sc_hd__fill_8_901 r0 *1 0,0
Xsky130_fd_sc_hd__fill_8_901 VGND VPWR VPWR sky130_fd_sc_hd__fill_8
* cell instance sky130_fd_sc_hd__fill_8_902 r0 *1 0,0
Xsky130_fd_sc_hd__fill_8_902 VGND VPWR VPWR sky130_fd_sc_hd__fill_8
* cell instance sky130_fd_sc_hd__fill_8_903 r0 *1 0,0
Xsky130_fd_sc_hd__fill_8_903 VGND VPWR VPWR sky130_fd_sc_hd__fill_8
* cell instance sky130_fd_sc_hd__fill_8_904 r0 *1 0,0
Xsky130_fd_sc_hd__fill_8_904 VGND VPWR VPWR sky130_fd_sc_hd__fill_8
* cell instance sky130_fd_sc_hd__fill_8_905 r0 *1 0,0
Xsky130_fd_sc_hd__fill_8_905 VGND VPWR VPWR sky130_fd_sc_hd__fill_8
* cell instance sky130_fd_sc_hd__fill_8_906 r0 *1 0,0
Xsky130_fd_sc_hd__fill_8_906 VGND VPWR VPWR sky130_fd_sc_hd__fill_8
* cell instance sky130_fd_sc_hd__fill_8_907 r0 *1 0,0
Xsky130_fd_sc_hd__fill_8_907 VGND VPWR VPWR sky130_fd_sc_hd__fill_8
* cell instance sky130_fd_sc_hd__fill_8_908 r0 *1 0,0
Xsky130_fd_sc_hd__fill_8_908 VGND VPWR VPWR sky130_fd_sc_hd__fill_8
* cell instance sky130_fd_sc_hd__fill_8_909 r0 *1 0,0
Xsky130_fd_sc_hd__fill_8_909 VGND VPWR VPWR sky130_fd_sc_hd__fill_8
* cell instance sky130_fd_sc_hd__fill_8_910 r0 *1 0,0
Xsky130_fd_sc_hd__fill_8_910 VGND VPWR VPWR sky130_fd_sc_hd__fill_8
* cell instance sky130_fd_sc_hd__fill_8_911 r0 *1 0,0
Xsky130_fd_sc_hd__fill_8_911 VGND VPWR VPWR sky130_fd_sc_hd__fill_8
* cell instance sky130_fd_sc_hd__fill_8_912 r0 *1 0,0
Xsky130_fd_sc_hd__fill_8_912 VGND VPWR VPWR sky130_fd_sc_hd__fill_8
* cell instance sky130_fd_sc_hd__fill_8_913 r0 *1 0,0
Xsky130_fd_sc_hd__fill_8_913 VGND VPWR VPWR sky130_fd_sc_hd__fill_8
* cell instance sky130_fd_sc_hd__fill_8_914 r0 *1 0,0
Xsky130_fd_sc_hd__fill_8_914 VGND VPWR VPWR sky130_fd_sc_hd__fill_8
* cell instance sky130_fd_sc_hd__fill_8_915 r0 *1 0,0
Xsky130_fd_sc_hd__fill_8_915 VGND VPWR VPWR sky130_fd_sc_hd__fill_8
* cell instance sky130_fd_sc_hd__fill_8_916 r0 *1 0,0
Xsky130_fd_sc_hd__fill_8_916 VGND VPWR VPWR sky130_fd_sc_hd__fill_8
* cell instance sky130_fd_sc_hd__fill_8_917 r0 *1 0,0
Xsky130_fd_sc_hd__fill_8_917 VGND VPWR VPWR sky130_fd_sc_hd__fill_8
* cell instance sky130_fd_sc_hd__fill_8_918 r0 *1 0,0
Xsky130_fd_sc_hd__fill_8_918 VGND VPWR VPWR sky130_fd_sc_hd__fill_8
* cell instance sky130_fd_sc_hd__fill_8_919 r0 *1 0,0
Xsky130_fd_sc_hd__fill_8_919 VGND VPWR VPWR sky130_fd_sc_hd__fill_8
* cell instance sky130_fd_sc_hd__fill_8_920 r0 *1 0,0
Xsky130_fd_sc_hd__fill_8_920 VGND VPWR VPWR sky130_fd_sc_hd__fill_8
* cell instance sky130_fd_sc_hd__fill_8_921 r0 *1 0,0
Xsky130_fd_sc_hd__fill_8_921 VGND VPWR VPWR sky130_fd_sc_hd__fill_8
* cell instance sky130_fd_sc_hd__fill_8_922 r0 *1 0,0
Xsky130_fd_sc_hd__fill_8_922 VGND VPWR VPWR sky130_fd_sc_hd__fill_8
* cell instance sky130_fd_sc_hd__fill_8_923 r0 *1 0,0
Xsky130_fd_sc_hd__fill_8_923 VGND VPWR VPWR sky130_fd_sc_hd__fill_8
* cell instance sky130_fd_sc_hd__fill_8_924 r0 *1 0,0
Xsky130_fd_sc_hd__fill_8_924 VGND VPWR VPWR sky130_fd_sc_hd__fill_8
* cell instance sky130_fd_sc_hd__fill_8_925 r0 *1 0,0
Xsky130_fd_sc_hd__fill_8_925 VGND VPWR VPWR sky130_fd_sc_hd__fill_8
* cell instance sky130_fd_sc_hd__fill_8_926 r0 *1 0,0
Xsky130_fd_sc_hd__fill_8_926 VGND VPWR VPWR sky130_fd_sc_hd__fill_8
* cell instance sky130_fd_sc_hd__fill_8_927 r0 *1 0,0
Xsky130_fd_sc_hd__fill_8_927 VGND VPWR VPWR sky130_fd_sc_hd__fill_8
* cell instance sky130_fd_sc_hd__fill_8_928 r0 *1 0,0
Xsky130_fd_sc_hd__fill_8_928 VGND VPWR VPWR sky130_fd_sc_hd__fill_8
* cell instance sky130_fd_sc_hd__fill_8_929 r0 *1 0,0
Xsky130_fd_sc_hd__fill_8_929 VGND VPWR VPWR sky130_fd_sc_hd__fill_8
* cell instance sky130_fd_sc_hd__fill_8_930 r0 *1 0,0
Xsky130_fd_sc_hd__fill_8_930 VGND VPWR VPWR sky130_fd_sc_hd__fill_8
* cell instance sky130_fd_sc_hd__fill_8_931 r0 *1 0,0
Xsky130_fd_sc_hd__fill_8_931 VGND VPWR VPWR sky130_fd_sc_hd__fill_8
* cell instance sky130_fd_sc_hd__fill_8_932 r0 *1 0,0
Xsky130_fd_sc_hd__fill_8_932 VGND VPWR VPWR sky130_fd_sc_hd__fill_8
* cell instance sky130_fd_sc_hd__fill_8_933 r0 *1 0,0
Xsky130_fd_sc_hd__fill_8_933 VGND VPWR VPWR sky130_fd_sc_hd__fill_8
* cell instance sky130_fd_sc_hd__fill_8_934 r0 *1 0,0
Xsky130_fd_sc_hd__fill_8_934 VGND VPWR VPWR sky130_fd_sc_hd__fill_8
* cell instance sky130_fd_sc_hd__fill_8_935 r0 *1 0,0
Xsky130_fd_sc_hd__fill_8_935 VGND VPWR VPWR sky130_fd_sc_hd__fill_8
* cell instance sky130_fd_sc_hd__fill_8_936 r0 *1 0,0
Xsky130_fd_sc_hd__fill_8_936 VGND VPWR VPWR sky130_fd_sc_hd__fill_8
* cell instance sky130_fd_sc_hd__fill_8_937 r0 *1 0,0
Xsky130_fd_sc_hd__fill_8_937 VGND VPWR VPWR sky130_fd_sc_hd__fill_8
* cell instance sky130_fd_sc_hd__fill_8_938 r0 *1 0,0
Xsky130_fd_sc_hd__fill_8_938 VGND VPWR VPWR sky130_fd_sc_hd__fill_8
* cell instance sky130_fd_sc_hd__fill_8_939 r0 *1 0,0
Xsky130_fd_sc_hd__fill_8_939 VGND VPWR VPWR sky130_fd_sc_hd__fill_8
* cell instance sky130_fd_sc_hd__fill_8_940 r0 *1 0,0
Xsky130_fd_sc_hd__fill_8_940 VGND VPWR VPWR sky130_fd_sc_hd__fill_8
* cell instance sky130_fd_sc_hd__fill_8_941 r0 *1 0,0
Xsky130_fd_sc_hd__fill_8_941 VGND VPWR VPWR sky130_fd_sc_hd__fill_8
* cell instance sky130_fd_sc_hd__fill_8_942 r0 *1 0,0
Xsky130_fd_sc_hd__fill_8_942 VGND VPWR VPWR sky130_fd_sc_hd__fill_8
* cell instance sky130_fd_sc_hd__fill_8_943 r0 *1 0,0
Xsky130_fd_sc_hd__fill_8_943 VGND VPWR VPWR sky130_fd_sc_hd__fill_8
* cell instance sky130_fd_sc_hd__fill_8_944 r0 *1 0,0
Xsky130_fd_sc_hd__fill_8_944 VGND VPWR VPWR sky130_fd_sc_hd__fill_8
* cell instance sky130_fd_sc_hd__fill_8_945 r0 *1 0,0
Xsky130_fd_sc_hd__fill_8_945 VGND VPWR VPWR sky130_fd_sc_hd__fill_8
* cell instance sky130_fd_sc_hd__fill_8_946 r0 *1 0,0
Xsky130_fd_sc_hd__fill_8_946 VGND VPWR VPWR sky130_fd_sc_hd__fill_8
* cell instance sky130_fd_sc_hd__fill_8_947 r0 *1 0,0
Xsky130_fd_sc_hd__fill_8_947 VGND VPWR VPWR sky130_fd_sc_hd__fill_8
* cell instance sky130_fd_sc_hd__fill_8_948 r0 *1 0,0
Xsky130_fd_sc_hd__fill_8_948 VGND VPWR VPWR sky130_fd_sc_hd__fill_8
* cell instance sky130_fd_sc_hd__fill_8_949 r0 *1 0,0
Xsky130_fd_sc_hd__fill_8_949 VGND VPWR VPWR sky130_fd_sc_hd__fill_8
* cell instance sky130_fd_sc_hd__fill_8_950 r0 *1 0,0
Xsky130_fd_sc_hd__fill_8_950 VGND VPWR VPWR sky130_fd_sc_hd__fill_8
* cell instance sky130_fd_sc_hd__fill_8_951 r0 *1 0,0
Xsky130_fd_sc_hd__fill_8_951 VGND VPWR VPWR sky130_fd_sc_hd__fill_8
* cell instance sky130_fd_sc_hd__fill_8_952 r0 *1 0,0
Xsky130_fd_sc_hd__fill_8_952 VGND VPWR VPWR sky130_fd_sc_hd__fill_8
* cell instance sky130_fd_sc_hd__fill_8_953 r0 *1 0,0
Xsky130_fd_sc_hd__fill_8_953 VGND VPWR VPWR sky130_fd_sc_hd__fill_8
* cell instance sky130_fd_sc_hd__fill_8_954 r0 *1 0,0
Xsky130_fd_sc_hd__fill_8_954 VGND VPWR VPWR sky130_fd_sc_hd__fill_8
* cell instance sky130_fd_sc_hd__fill_8_955 r0 *1 0,0
Xsky130_fd_sc_hd__fill_8_955 VGND VPWR VPWR sky130_fd_sc_hd__fill_8
* cell instance sky130_fd_sc_hd__fill_8_956 r0 *1 0,0
Xsky130_fd_sc_hd__fill_8_956 VGND VPWR VPWR sky130_fd_sc_hd__fill_8
* cell instance sky130_fd_sc_hd__fill_8_957 r0 *1 0,0
Xsky130_fd_sc_hd__fill_8_957 VGND VPWR VPWR sky130_fd_sc_hd__fill_8
* cell instance sky130_fd_sc_hd__fill_8_958 r0 *1 0,0
Xsky130_fd_sc_hd__fill_8_958 VGND VPWR VPWR sky130_fd_sc_hd__fill_8
* cell instance sky130_fd_sc_hd__fill_8_959 r0 *1 0,0
Xsky130_fd_sc_hd__fill_8_959 VGND VPWR VPWR sky130_fd_sc_hd__fill_8
* cell instance sky130_fd_sc_hd__fill_8_960 r0 *1 0,0
Xsky130_fd_sc_hd__fill_8_960 VGND VPWR VPWR sky130_fd_sc_hd__fill_8
* cell instance sky130_fd_sc_hd__fill_8_961 r0 *1 0,0
Xsky130_fd_sc_hd__fill_8_961 VGND VPWR VPWR sky130_fd_sc_hd__fill_8
* cell instance sky130_fd_sc_hd__fill_8_962 r0 *1 0,0
Xsky130_fd_sc_hd__fill_8_962 VGND VPWR VPWR sky130_fd_sc_hd__fill_8
* cell instance sky130_fd_sc_hd__fill_8_963 r0 *1 0,0
Xsky130_fd_sc_hd__fill_8_963 VGND VPWR VPWR sky130_fd_sc_hd__fill_8
* cell instance sky130_fd_sc_hd__fill_8_964 r0 *1 0,0
Xsky130_fd_sc_hd__fill_8_964 VGND VPWR VPWR sky130_fd_sc_hd__fill_8
* cell instance sky130_fd_sc_hd__fill_8_965 r0 *1 0,0
Xsky130_fd_sc_hd__fill_8_965 VGND VPWR VPWR sky130_fd_sc_hd__fill_8
* cell instance sky130_fd_sc_hd__fill_8_966 r0 *1 0,0
Xsky130_fd_sc_hd__fill_8_966 VGND VPWR VPWR sky130_fd_sc_hd__fill_8
* cell instance sky130_fd_sc_hd__fill_8_967 r0 *1 0,0
Xsky130_fd_sc_hd__fill_8_967 VGND VPWR VPWR sky130_fd_sc_hd__fill_8
* cell instance sky130_fd_sc_hd__fill_8_968 r0 *1 0,0
Xsky130_fd_sc_hd__fill_8_968 VGND VPWR VPWR sky130_fd_sc_hd__fill_8
* cell instance sky130_fd_sc_hd__fill_8_969 r0 *1 0,0
Xsky130_fd_sc_hd__fill_8_969 VGND VPWR VPWR sky130_fd_sc_hd__fill_8
* cell instance sky130_fd_sc_hd__fill_8_970 r0 *1 0,0
Xsky130_fd_sc_hd__fill_8_970 VGND VPWR VPWR sky130_fd_sc_hd__fill_8
* cell instance sky130_fd_sc_hd__fill_8_971 r0 *1 0,0
Xsky130_fd_sc_hd__fill_8_971 VGND VPWR VPWR sky130_fd_sc_hd__fill_8
* cell instance sky130_fd_sc_hd__fill_8_972 r0 *1 0,0
Xsky130_fd_sc_hd__fill_8_972 VGND VPWR VPWR sky130_fd_sc_hd__fill_8
* cell instance sky130_fd_sc_hd__fill_8_973 r0 *1 0,0
Xsky130_fd_sc_hd__fill_8_973 VGND VPWR VPWR sky130_fd_sc_hd__fill_8
* cell instance sky130_fd_sc_hd__fill_8_974 r0 *1 0,0
Xsky130_fd_sc_hd__fill_8_974 VGND VPWR VPWR sky130_fd_sc_hd__fill_8
* cell instance sky130_fd_sc_hd__fill_8_975 r0 *1 0,0
Xsky130_fd_sc_hd__fill_8_975 VGND VPWR VPWR sky130_fd_sc_hd__fill_8
* cell instance sky130_fd_sc_hd__fill_8_976 r0 *1 0,0
Xsky130_fd_sc_hd__fill_8_976 VGND VPWR VPWR sky130_fd_sc_hd__fill_8
* cell instance sky130_fd_sc_hd__fill_8_977 r0 *1 0,0
Xsky130_fd_sc_hd__fill_8_977 VGND VPWR VPWR sky130_fd_sc_hd__fill_8
* cell instance sky130_fd_sc_hd__fill_8_978 r0 *1 0,0
Xsky130_fd_sc_hd__fill_8_978 VGND VPWR VPWR sky130_fd_sc_hd__fill_8
* cell instance sky130_fd_sc_hd__fill_8_979 r0 *1 0,0
Xsky130_fd_sc_hd__fill_8_979 VGND VPWR VPWR sky130_fd_sc_hd__fill_8
* cell instance sky130_fd_sc_hd__fill_8_980 r0 *1 0,0
Xsky130_fd_sc_hd__fill_8_980 VGND VPWR VPWR sky130_fd_sc_hd__fill_8
* cell instance sky130_fd_sc_hd__fill_8_981 r0 *1 0,0
Xsky130_fd_sc_hd__fill_8_981 VGND VPWR VPWR sky130_fd_sc_hd__fill_8
* cell instance sky130_fd_sc_hd__fill_8_982 r0 *1 0,0
Xsky130_fd_sc_hd__fill_8_982 VGND VPWR VPWR sky130_fd_sc_hd__fill_8
* cell instance sky130_fd_sc_hd__fill_8_983 r0 *1 0,0
Xsky130_fd_sc_hd__fill_8_983 VGND VPWR VPWR sky130_fd_sc_hd__fill_8
* cell instance sky130_fd_sc_hd__fill_8_984 r0 *1 0,0
Xsky130_fd_sc_hd__fill_8_984 VGND VPWR VPWR sky130_fd_sc_hd__fill_8
* cell instance sky130_fd_sc_hd__fill_8_985 r0 *1 0,0
Xsky130_fd_sc_hd__fill_8_985 VGND VPWR VPWR sky130_fd_sc_hd__fill_8
* cell instance sky130_fd_sc_hd__fill_8_986 r0 *1 0,0
Xsky130_fd_sc_hd__fill_8_986 VGND VPWR VPWR sky130_fd_sc_hd__fill_8
* cell instance sky130_fd_sc_hd__fill_8_987 r0 *1 0,0
Xsky130_fd_sc_hd__fill_8_987 VGND VPWR VPWR sky130_fd_sc_hd__fill_8
* cell instance sky130_fd_sc_hd__fill_8_988 r0 *1 0,0
Xsky130_fd_sc_hd__fill_8_988 VGND VPWR VPWR sky130_fd_sc_hd__fill_8
* cell instance sky130_fd_sc_hd__fill_8_989 r0 *1 0,0
Xsky130_fd_sc_hd__fill_8_989 VGND VPWR VPWR sky130_fd_sc_hd__fill_8
* cell instance sky130_fd_sc_hd__fill_8_990 r0 *1 0,0
Xsky130_fd_sc_hd__fill_8_990 VGND VPWR VPWR sky130_fd_sc_hd__fill_8
* cell instance sky130_fd_sc_hd__fill_8_991 r0 *1 0,0
Xsky130_fd_sc_hd__fill_8_991 VGND VPWR VPWR sky130_fd_sc_hd__fill_8
* cell instance sky130_fd_sc_hd__fill_8_992 r0 *1 0,0
Xsky130_fd_sc_hd__fill_8_992 VGND VPWR VPWR sky130_fd_sc_hd__fill_8
* cell instance sky130_fd_sc_hd__fill_8_993 r0 *1 0,0
Xsky130_fd_sc_hd__fill_8_993 VGND VPWR VPWR sky130_fd_sc_hd__fill_8
* cell instance sky130_fd_sc_hd__fill_8_994 r0 *1 0,0
Xsky130_fd_sc_hd__fill_8_994 VGND VPWR VPWR sky130_fd_sc_hd__fill_8
* cell instance sky130_fd_sc_hd__fill_8_995 r0 *1 0,0
Xsky130_fd_sc_hd__fill_8_995 VGND VPWR VPWR sky130_fd_sc_hd__fill_8
* cell instance sky130_fd_sc_hd__fill_8_996 r0 *1 0,0
Xsky130_fd_sc_hd__fill_8_996 VGND VPWR VPWR sky130_fd_sc_hd__fill_8
* cell instance sky130_fd_sc_hd__fill_8_997 r0 *1 0,0
Xsky130_fd_sc_hd__fill_8_997 VGND VPWR VPWR sky130_fd_sc_hd__fill_8
* cell instance sky130_fd_sc_hd__fill_8_998 r0 *1 0,0
Xsky130_fd_sc_hd__fill_8_998 VGND VPWR VPWR sky130_fd_sc_hd__fill_8
* cell instance sky130_fd_sc_hd__fill_8_999 r0 *1 0,0
Xsky130_fd_sc_hd__fill_8_999 VGND VPWR VPWR sky130_fd_sc_hd__fill_8
* cell instance sky130_fd_sc_hd__fill_8_1000 r0 *1 0,0
Xsky130_fd_sc_hd__fill_8_1000 VGND VPWR VPWR sky130_fd_sc_hd__fill_8
* cell instance sky130_fd_sc_hd__fill_8_1001 r0 *1 0,0
Xsky130_fd_sc_hd__fill_8_1001 VGND VPWR VPWR sky130_fd_sc_hd__fill_8
* cell instance sky130_fd_sc_hd__fill_8_1002 r0 *1 0,0
Xsky130_fd_sc_hd__fill_8_1002 VGND VPWR VPWR sky130_fd_sc_hd__fill_8
* cell instance sky130_fd_sc_hd__fill_8_1003 r0 *1 0,0
Xsky130_fd_sc_hd__fill_8_1003 VGND VPWR VPWR sky130_fd_sc_hd__fill_8
* cell instance sky130_fd_sc_hd__fill_8_1004 r0 *1 0,0
Xsky130_fd_sc_hd__fill_8_1004 VGND VPWR VPWR sky130_fd_sc_hd__fill_8
* cell instance sky130_fd_sc_hd__fill_8_1005 r0 *1 0,0
Xsky130_fd_sc_hd__fill_8_1005 VGND VPWR VPWR sky130_fd_sc_hd__fill_8
* cell instance sky130_fd_sc_hd__fill_8_1006 r0 *1 0,0
Xsky130_fd_sc_hd__fill_8_1006 VGND VPWR VPWR sky130_fd_sc_hd__fill_8
* cell instance sky130_fd_sc_hd__fill_8_1007 r0 *1 0,0
Xsky130_fd_sc_hd__fill_8_1007 VGND VPWR VPWR sky130_fd_sc_hd__fill_8
* cell instance sky130_fd_sc_hd__fill_8_1008 r0 *1 0,0
Xsky130_fd_sc_hd__fill_8_1008 VGND VPWR VPWR sky130_fd_sc_hd__fill_8
* cell instance sky130_fd_sc_hd__fill_8_1009 r0 *1 0,0
Xsky130_fd_sc_hd__fill_8_1009 VGND VPWR VPWR sky130_fd_sc_hd__fill_8
* cell instance sky130_fd_sc_hd__fill_8_1010 r0 *1 0,0
Xsky130_fd_sc_hd__fill_8_1010 VGND VPWR VPWR sky130_fd_sc_hd__fill_8
* cell instance sky130_fd_sc_hd__fill_8_1011 r0 *1 0,0
Xsky130_fd_sc_hd__fill_8_1011 VGND VPWR VPWR sky130_fd_sc_hd__fill_8
* cell instance sky130_fd_sc_hd__fill_8_1012 r0 *1 0,0
Xsky130_fd_sc_hd__fill_8_1012 VGND VPWR VPWR sky130_fd_sc_hd__fill_8
* cell instance sky130_fd_sc_hd__fill_8_1013 r0 *1 0,0
Xsky130_fd_sc_hd__fill_8_1013 VGND VPWR VPWR sky130_fd_sc_hd__fill_8
* cell instance sky130_fd_sc_hd__fill_8_1014 r0 *1 0,0
Xsky130_fd_sc_hd__fill_8_1014 VGND VPWR VPWR sky130_fd_sc_hd__fill_8
* cell instance sky130_fd_sc_hd__fill_8_1015 r0 *1 0,0
Xsky130_fd_sc_hd__fill_8_1015 VGND VPWR VPWR sky130_fd_sc_hd__fill_8
* cell instance sky130_fd_sc_hd__fill_8_1016 r0 *1 0,0
Xsky130_fd_sc_hd__fill_8_1016 VGND VPWR VPWR sky130_fd_sc_hd__fill_8
* cell instance sky130_fd_sc_hd__fill_8_1017 r0 *1 0,0
Xsky130_fd_sc_hd__fill_8_1017 VGND VPWR VPWR sky130_fd_sc_hd__fill_8
* cell instance sky130_fd_sc_hd__fill_8_1018 r0 *1 0,0
Xsky130_fd_sc_hd__fill_8_1018 VGND VPWR VPWR sky130_fd_sc_hd__fill_8
* cell instance sky130_fd_sc_hd__fill_8_1019 r0 *1 0,0
Xsky130_fd_sc_hd__fill_8_1019 VGND VPWR VPWR sky130_fd_sc_hd__fill_8
* cell instance sky130_fd_sc_hd__fill_8_1020 r0 *1 0,0
Xsky130_fd_sc_hd__fill_8_1020 VGND VPWR VPWR sky130_fd_sc_hd__fill_8
* cell instance sky130_fd_sc_hd__fill_8_1021 r0 *1 0,0
Xsky130_fd_sc_hd__fill_8_1021 VGND VPWR VPWR sky130_fd_sc_hd__fill_8
* cell instance sky130_fd_sc_hd__fill_8_1022 r0 *1 0,0
Xsky130_fd_sc_hd__fill_8_1022 VGND VPWR VPWR sky130_fd_sc_hd__fill_8
* cell instance sky130_fd_sc_hd__fill_8_1023 r0 *1 0,0
Xsky130_fd_sc_hd__fill_8_1023 VGND VPWR VPWR sky130_fd_sc_hd__fill_8
* cell instance sky130_fd_sc_hd__fill_8_1024 r0 *1 0,0
Xsky130_fd_sc_hd__fill_8_1024 VGND VPWR VPWR sky130_fd_sc_hd__fill_8
* cell instance sky130_fd_sc_hd__fill_8_1025 r0 *1 0,0
Xsky130_fd_sc_hd__fill_8_1025 VGND VPWR VPWR sky130_fd_sc_hd__fill_8
* cell instance sky130_fd_sc_hd__fill_8_1026 r0 *1 0,0
Xsky130_fd_sc_hd__fill_8_1026 VGND VPWR VPWR sky130_fd_sc_hd__fill_8
* cell instance sky130_fd_sc_hd__fill_8_1027 r0 *1 0,0
Xsky130_fd_sc_hd__fill_8_1027 VGND VPWR VPWR sky130_fd_sc_hd__fill_8
* cell instance sky130_fd_sc_hd__fill_8_1028 r0 *1 0,0
Xsky130_fd_sc_hd__fill_8_1028 VGND VPWR VPWR sky130_fd_sc_hd__fill_8
* cell instance sky130_fd_sc_hd__fill_8_1029 r0 *1 0,0
Xsky130_fd_sc_hd__fill_8_1029 VGND VPWR VPWR sky130_fd_sc_hd__fill_8
* cell instance sky130_fd_sc_hd__fill_8_1030 r0 *1 0,0
Xsky130_fd_sc_hd__fill_8_1030 VGND VPWR VPWR sky130_fd_sc_hd__fill_8
* cell instance sky130_fd_sc_hd__fill_8_1031 r0 *1 0,0
Xsky130_fd_sc_hd__fill_8_1031 VGND VPWR VPWR sky130_fd_sc_hd__fill_8
* cell instance sky130_fd_sc_hd__fill_8_1032 r0 *1 0,0
Xsky130_fd_sc_hd__fill_8_1032 VGND VPWR VPWR sky130_fd_sc_hd__fill_8
* cell instance sky130_fd_sc_hd__fill_8_1033 r0 *1 0,0
Xsky130_fd_sc_hd__fill_8_1033 VGND VPWR VPWR sky130_fd_sc_hd__fill_8
* cell instance sky130_fd_sc_hd__fill_8_1034 r0 *1 0,0
Xsky130_fd_sc_hd__fill_8_1034 VGND VPWR VPWR sky130_fd_sc_hd__fill_8
* cell instance sky130_fd_sc_hd__fill_8_1035 r0 *1 0,0
Xsky130_fd_sc_hd__fill_8_1035 VGND VPWR VPWR sky130_fd_sc_hd__fill_8
* cell instance sky130_fd_sc_hd__fill_8_1036 r0 *1 0,0
Xsky130_fd_sc_hd__fill_8_1036 VGND VPWR VPWR sky130_fd_sc_hd__fill_8
* cell instance sky130_fd_sc_hd__fill_8_1037 r0 *1 0,0
Xsky130_fd_sc_hd__fill_8_1037 VGND VPWR VPWR sky130_fd_sc_hd__fill_8
* cell instance sky130_fd_sc_hd__fill_8_1038 r0 *1 0,0
Xsky130_fd_sc_hd__fill_8_1038 VGND VPWR VPWR sky130_fd_sc_hd__fill_8
* cell instance sky130_fd_sc_hd__fill_8_1039 r0 *1 0,0
Xsky130_fd_sc_hd__fill_8_1039 VGND VPWR VPWR sky130_fd_sc_hd__fill_8
* cell instance sky130_fd_sc_hd__fill_8_1040 r0 *1 0,0
Xsky130_fd_sc_hd__fill_8_1040 VGND VPWR VPWR sky130_fd_sc_hd__fill_8
* cell instance sky130_fd_sc_hd__fill_8_1041 r0 *1 0,0
Xsky130_fd_sc_hd__fill_8_1041 VGND VPWR VPWR sky130_fd_sc_hd__fill_8
* cell instance sky130_fd_sc_hd__fill_8_1042 r0 *1 0,0
Xsky130_fd_sc_hd__fill_8_1042 VGND VPWR VPWR sky130_fd_sc_hd__fill_8
* cell instance sky130_fd_sc_hd__fill_8_1043 r0 *1 0,0
Xsky130_fd_sc_hd__fill_8_1043 VGND VPWR VPWR sky130_fd_sc_hd__fill_8
* cell instance sky130_fd_sc_hd__fill_8_1044 r0 *1 0,0
Xsky130_fd_sc_hd__fill_8_1044 VGND VPWR VPWR sky130_fd_sc_hd__fill_8
* cell instance sky130_fd_sc_hd__fill_8_1045 r0 *1 0,0
Xsky130_fd_sc_hd__fill_8_1045 VGND VPWR VPWR sky130_fd_sc_hd__fill_8
* cell instance sky130_fd_sc_hd__fill_8_1046 r0 *1 0,0
Xsky130_fd_sc_hd__fill_8_1046 VGND VPWR VPWR sky130_fd_sc_hd__fill_8
* cell instance sky130_fd_sc_hd__fill_8_1047 r0 *1 0,0
Xsky130_fd_sc_hd__fill_8_1047 VGND VPWR VPWR sky130_fd_sc_hd__fill_8
* cell instance sky130_fd_sc_hd__fill_8_1048 r0 *1 0,0
Xsky130_fd_sc_hd__fill_8_1048 VGND VPWR VPWR sky130_fd_sc_hd__fill_8
* cell instance sky130_fd_sc_hd__fill_8_1049 r0 *1 0,0
Xsky130_fd_sc_hd__fill_8_1049 VGND VPWR VPWR sky130_fd_sc_hd__fill_8
* cell instance sky130_fd_sc_hd__fill_8_1050 r0 *1 0,0
Xsky130_fd_sc_hd__fill_8_1050 VGND VPWR VPWR sky130_fd_sc_hd__fill_8
* cell instance sky130_fd_sc_hd__fill_8_1051 r0 *1 0,0
Xsky130_fd_sc_hd__fill_8_1051 VGND VPWR VPWR sky130_fd_sc_hd__fill_8
* cell instance sky130_fd_sc_hd__fill_8_1052 r0 *1 0,0
Xsky130_fd_sc_hd__fill_8_1052 VGND VPWR VPWR sky130_fd_sc_hd__fill_8
* cell instance sky130_fd_sc_hd__fill_8_1053 r0 *1 0,0
Xsky130_fd_sc_hd__fill_8_1053 VGND VPWR VPWR sky130_fd_sc_hd__fill_8
* cell instance sky130_fd_sc_hd__fill_8_1054 r0 *1 0,0
Xsky130_fd_sc_hd__fill_8_1054 VGND VPWR VPWR sky130_fd_sc_hd__fill_8
* cell instance sky130_fd_sc_hd__fill_8_1055 r0 *1 0,0
Xsky130_fd_sc_hd__fill_8_1055 VGND VPWR VPWR sky130_fd_sc_hd__fill_8
* cell instance sky130_fd_sc_hd__fill_8_1056 r0 *1 0,0
Xsky130_fd_sc_hd__fill_8_1056 VGND VPWR VPWR sky130_fd_sc_hd__fill_8
* cell instance sky130_fd_sc_hd__fill_8_1057 r0 *1 0,0
Xsky130_fd_sc_hd__fill_8_1057 VGND VPWR VPWR sky130_fd_sc_hd__fill_8
* cell instance sky130_fd_sc_hd__fill_8_1058 r0 *1 0,0
Xsky130_fd_sc_hd__fill_8_1058 VGND VPWR VPWR sky130_fd_sc_hd__fill_8
* cell instance sky130_fd_sc_hd__fill_8_1059 r0 *1 0,0
Xsky130_fd_sc_hd__fill_8_1059 VGND VPWR VPWR sky130_fd_sc_hd__fill_8
* cell instance sky130_fd_sc_hd__fill_8_1060 r0 *1 0,0
Xsky130_fd_sc_hd__fill_8_1060 VGND VPWR VPWR sky130_fd_sc_hd__fill_8
* cell instance sky130_fd_sc_hd__fill_8_1061 r0 *1 0,0
Xsky130_fd_sc_hd__fill_8_1061 VGND VPWR VPWR sky130_fd_sc_hd__fill_8
* cell instance sky130_fd_sc_hd__fill_8_1062 r0 *1 0,0
Xsky130_fd_sc_hd__fill_8_1062 VGND VPWR VPWR sky130_fd_sc_hd__fill_8
* cell instance sky130_fd_sc_hd__fill_8_1063 r0 *1 0,0
Xsky130_fd_sc_hd__fill_8_1063 VGND VPWR VPWR sky130_fd_sc_hd__fill_8
* cell instance sky130_fd_sc_hd__fill_8_1064 r0 *1 0,0
Xsky130_fd_sc_hd__fill_8_1064 VGND VPWR VPWR sky130_fd_sc_hd__fill_8
* cell instance sky130_fd_sc_hd__fill_8_1065 r0 *1 0,0
Xsky130_fd_sc_hd__fill_8_1065 VGND VPWR VPWR sky130_fd_sc_hd__fill_8
* cell instance sky130_fd_sc_hd__fill_8_1066 r0 *1 0,0
Xsky130_fd_sc_hd__fill_8_1066 VGND VPWR VPWR sky130_fd_sc_hd__fill_8
* cell instance sky130_fd_sc_hd__fill_8_1067 r0 *1 0,0
Xsky130_fd_sc_hd__fill_8_1067 VGND VPWR VPWR sky130_fd_sc_hd__fill_8
* cell instance sky130_fd_sc_hd__fill_8_1068 r0 *1 0,0
Xsky130_fd_sc_hd__fill_8_1068 VGND VPWR VPWR sky130_fd_sc_hd__fill_8
* cell instance sky130_fd_sc_hd__fill_8_1069 r0 *1 0,0
Xsky130_fd_sc_hd__fill_8_1069 VGND VPWR VPWR sky130_fd_sc_hd__fill_8
* cell instance sky130_fd_sc_hd__fill_8_1070 r0 *1 0,0
Xsky130_fd_sc_hd__fill_8_1070 VGND VPWR VPWR sky130_fd_sc_hd__fill_8
* cell instance sky130_fd_sc_hd__fill_8_1071 r0 *1 0,0
Xsky130_fd_sc_hd__fill_8_1071 VGND VPWR VPWR sky130_fd_sc_hd__fill_8
* cell instance sky130_fd_sc_hd__fill_8_1072 r0 *1 0,0
Xsky130_fd_sc_hd__fill_8_1072 VGND VPWR VPWR sky130_fd_sc_hd__fill_8
* cell instance sky130_fd_sc_hd__fill_8_1073 r0 *1 0,0
Xsky130_fd_sc_hd__fill_8_1073 VGND VPWR VPWR sky130_fd_sc_hd__fill_8
* cell instance sky130_fd_sc_hd__fill_8_1074 r0 *1 0,0
Xsky130_fd_sc_hd__fill_8_1074 VGND VPWR VPWR sky130_fd_sc_hd__fill_8
* cell instance sky130_fd_sc_hd__fill_8_1075 r0 *1 0,0
Xsky130_fd_sc_hd__fill_8_1075 VGND VPWR VPWR sky130_fd_sc_hd__fill_8
* cell instance sky130_fd_sc_hd__fill_8_1076 r0 *1 0,0
Xsky130_fd_sc_hd__fill_8_1076 VGND VPWR VPWR sky130_fd_sc_hd__fill_8
* cell instance sky130_fd_sc_hd__fill_8_1077 r0 *1 0,0
Xsky130_fd_sc_hd__fill_8_1077 VGND VPWR VPWR sky130_fd_sc_hd__fill_8
* cell instance sky130_fd_sc_hd__fill_8_1078 r0 *1 0,0
Xsky130_fd_sc_hd__fill_8_1078 VGND VPWR VPWR sky130_fd_sc_hd__fill_8
* cell instance sky130_fd_sc_hd__fill_8_1079 r0 *1 0,0
Xsky130_fd_sc_hd__fill_8_1079 VGND VPWR VPWR sky130_fd_sc_hd__fill_8
* cell instance sky130_fd_sc_hd__fill_8_1080 r0 *1 0,0
Xsky130_fd_sc_hd__fill_8_1080 VGND VPWR VPWR sky130_fd_sc_hd__fill_8
* cell instance sky130_fd_sc_hd__fill_8_1081 r0 *1 0,0
Xsky130_fd_sc_hd__fill_8_1081 VGND VPWR VPWR sky130_fd_sc_hd__fill_8
* cell instance sky130_fd_sc_hd__fill_8_1082 r0 *1 0,0
Xsky130_fd_sc_hd__fill_8_1082 VGND VPWR VPWR sky130_fd_sc_hd__fill_8
* cell instance sky130_fd_sc_hd__fill_8_1083 r0 *1 0,0
Xsky130_fd_sc_hd__fill_8_1083 VGND VPWR VPWR sky130_fd_sc_hd__fill_8
* cell instance sky130_fd_sc_hd__fill_8_1084 r0 *1 0,0
Xsky130_fd_sc_hd__fill_8_1084 VGND VPWR VPWR sky130_fd_sc_hd__fill_8
* cell instance sky130_fd_sc_hd__fill_8_1085 r0 *1 0,0
Xsky130_fd_sc_hd__fill_8_1085 VGND VPWR VPWR sky130_fd_sc_hd__fill_8
* cell instance sky130_fd_sc_hd__fill_8_1086 r0 *1 0,0
Xsky130_fd_sc_hd__fill_8_1086 VGND VPWR VPWR sky130_fd_sc_hd__fill_8
* cell instance sky130_fd_sc_hd__fill_8_1087 r0 *1 0,0
Xsky130_fd_sc_hd__fill_8_1087 VGND VPWR VPWR sky130_fd_sc_hd__fill_8
* cell instance sky130_fd_sc_hd__fill_8_1088 r0 *1 0,0
Xsky130_fd_sc_hd__fill_8_1088 VGND VPWR VPWR sky130_fd_sc_hd__fill_8
* cell instance sky130_fd_sc_hd__fill_8_1089 r0 *1 0,0
Xsky130_fd_sc_hd__fill_8_1089 VGND VPWR VPWR sky130_fd_sc_hd__fill_8
* cell instance sky130_fd_sc_hd__fill_8_1090 r0 *1 0,0
Xsky130_fd_sc_hd__fill_8_1090 VGND VPWR VPWR sky130_fd_sc_hd__fill_8
* cell instance sky130_fd_sc_hd__fill_8_1091 r0 *1 0,0
Xsky130_fd_sc_hd__fill_8_1091 VGND VPWR VPWR sky130_fd_sc_hd__fill_8
* cell instance sky130_fd_sc_hd__fill_8_1092 r0 *1 0,0
Xsky130_fd_sc_hd__fill_8_1092 VGND VPWR VPWR sky130_fd_sc_hd__fill_8
* cell instance sky130_fd_sc_hd__fill_8_1093 r0 *1 0,0
Xsky130_fd_sc_hd__fill_8_1093 VGND VPWR VPWR sky130_fd_sc_hd__fill_8
* cell instance sky130_fd_sc_hd__fill_8_1094 r0 *1 0,0
Xsky130_fd_sc_hd__fill_8_1094 VGND VPWR VPWR sky130_fd_sc_hd__fill_8
* cell instance sky130_fd_sc_hd__fill_8_1095 r0 *1 0,0
Xsky130_fd_sc_hd__fill_8_1095 VGND VPWR VPWR sky130_fd_sc_hd__fill_8
* cell instance sky130_fd_sc_hd__fill_8_1096 r0 *1 0,0
Xsky130_fd_sc_hd__fill_8_1096 VGND VPWR VPWR sky130_fd_sc_hd__fill_8
* cell instance sky130_fd_sc_hd__fill_8_1097 r0 *1 0,0
Xsky130_fd_sc_hd__fill_8_1097 VGND VPWR VPWR sky130_fd_sc_hd__fill_8
* cell instance sky130_fd_sc_hd__fill_8_1098 r0 *1 0,0
Xsky130_fd_sc_hd__fill_8_1098 VGND VPWR VPWR sky130_fd_sc_hd__fill_8
* cell instance sky130_fd_sc_hd__fill_8_1099 r0 *1 0,0
Xsky130_fd_sc_hd__fill_8_1099 VGND VPWR VPWR sky130_fd_sc_hd__fill_8
* cell instance sky130_fd_sc_hd__fill_8_1100 r0 *1 0,0
Xsky130_fd_sc_hd__fill_8_1100 VGND VPWR VPWR sky130_fd_sc_hd__fill_8
* cell instance sky130_fd_sc_hd__fill_8_1101 r0 *1 0,0
Xsky130_fd_sc_hd__fill_8_1101 VGND VPWR VPWR sky130_fd_sc_hd__fill_8
* cell instance sky130_fd_sc_hd__fill_8_1102 r0 *1 0,0
Xsky130_fd_sc_hd__fill_8_1102 VGND VPWR VPWR sky130_fd_sc_hd__fill_8
* cell instance sky130_fd_sc_hd__fill_8_1103 r0 *1 0,0
Xsky130_fd_sc_hd__fill_8_1103 VGND VPWR VPWR sky130_fd_sc_hd__fill_8
* cell instance sky130_fd_sc_hd__fill_8_1104 r0 *1 0,0
Xsky130_fd_sc_hd__fill_8_1104 VGND VPWR VPWR sky130_fd_sc_hd__fill_8
* cell instance sky130_fd_sc_hd__fill_8_1105 r0 *1 0,0
Xsky130_fd_sc_hd__fill_8_1105 VGND VPWR VPWR sky130_fd_sc_hd__fill_8
* cell instance sky130_fd_sc_hd__fill_8_1106 r0 *1 0,0
Xsky130_fd_sc_hd__fill_8_1106 VGND VPWR VPWR sky130_fd_sc_hd__fill_8
* cell instance sky130_fd_sc_hd__fill_8_1107 r0 *1 0,0
Xsky130_fd_sc_hd__fill_8_1107 VGND VPWR VPWR sky130_fd_sc_hd__fill_8
* cell instance sky130_fd_sc_hd__fill_8_1108 r0 *1 0,0
Xsky130_fd_sc_hd__fill_8_1108 VGND VPWR VPWR sky130_fd_sc_hd__fill_8
* cell instance sky130_fd_sc_hd__fill_8_1109 r0 *1 0,0
Xsky130_fd_sc_hd__fill_8_1109 VGND VPWR VPWR sky130_fd_sc_hd__fill_8
* cell instance sky130_fd_sc_hd__fill_8_1110 r0 *1 0,0
Xsky130_fd_sc_hd__fill_8_1110 VGND VPWR VPWR sky130_fd_sc_hd__fill_8
* cell instance sky130_fd_sc_hd__fill_8_1111 r0 *1 0,0
Xsky130_fd_sc_hd__fill_8_1111 VGND VPWR VPWR sky130_fd_sc_hd__fill_8
* cell instance sky130_fd_sc_hd__fill_8_1112 r0 *1 0,0
Xsky130_fd_sc_hd__fill_8_1112 VGND VPWR VPWR sky130_fd_sc_hd__fill_8
* cell instance sky130_fd_sc_hd__fill_8_1113 r0 *1 0,0
Xsky130_fd_sc_hd__fill_8_1113 VGND VPWR VPWR sky130_fd_sc_hd__fill_8
* cell instance sky130_fd_sc_hd__fill_8_1114 r0 *1 0,0
Xsky130_fd_sc_hd__fill_8_1114 VGND VPWR VPWR sky130_fd_sc_hd__fill_8
* cell instance sky130_fd_sc_hd__fill_8_1115 r0 *1 0,0
Xsky130_fd_sc_hd__fill_8_1115 VGND VPWR VPWR sky130_fd_sc_hd__fill_8
* cell instance sky130_fd_sc_hd__fill_8_1116 r0 *1 0,0
Xsky130_fd_sc_hd__fill_8_1116 VGND VPWR VPWR sky130_fd_sc_hd__fill_8
* cell instance sky130_fd_sc_hd__fill_8_1117 r0 *1 0,0
Xsky130_fd_sc_hd__fill_8_1117 VGND VPWR VPWR sky130_fd_sc_hd__fill_8
* cell instance sky130_fd_sc_hd__fill_8_1118 r0 *1 0,0
Xsky130_fd_sc_hd__fill_8_1118 VGND VPWR VPWR sky130_fd_sc_hd__fill_8
* cell instance sky130_fd_sc_hd__fill_8_1119 r0 *1 0,0
Xsky130_fd_sc_hd__fill_8_1119 VGND VPWR VPWR sky130_fd_sc_hd__fill_8
* cell instance sky130_fd_sc_hd__fill_8_1120 r0 *1 0,0
Xsky130_fd_sc_hd__fill_8_1120 VGND VPWR VPWR sky130_fd_sc_hd__fill_8
* cell instance sky130_fd_sc_hd__fill_8_1121 r0 *1 0,0
Xsky130_fd_sc_hd__fill_8_1121 VGND VPWR VPWR sky130_fd_sc_hd__fill_8
* cell instance sky130_fd_sc_hd__fill_8_1122 r0 *1 0,0
Xsky130_fd_sc_hd__fill_8_1122 VGND VPWR VPWR sky130_fd_sc_hd__fill_8
* cell instance sky130_fd_sc_hd__fill_8_1123 r0 *1 0,0
Xsky130_fd_sc_hd__fill_8_1123 VGND VPWR VPWR sky130_fd_sc_hd__fill_8
* cell instance sky130_fd_sc_hd__fill_8_1124 r0 *1 0,0
Xsky130_fd_sc_hd__fill_8_1124 VGND VPWR VPWR sky130_fd_sc_hd__fill_8
* cell instance sky130_fd_sc_hd__fill_8_1125 r0 *1 0,0
Xsky130_fd_sc_hd__fill_8_1125 VGND VPWR VPWR sky130_fd_sc_hd__fill_8
* cell instance sky130_fd_sc_hd__fill_8_1126 r0 *1 0,0
Xsky130_fd_sc_hd__fill_8_1126 VGND VPWR VPWR sky130_fd_sc_hd__fill_8
* cell instance sky130_fd_sc_hd__fill_8_1127 r0 *1 0,0
Xsky130_fd_sc_hd__fill_8_1127 VGND VPWR VPWR sky130_fd_sc_hd__fill_8
* cell instance sky130_fd_sc_hd__fill_8_1128 r0 *1 0,0
Xsky130_fd_sc_hd__fill_8_1128 VGND VPWR VPWR sky130_fd_sc_hd__fill_8
* cell instance sky130_fd_sc_hd__fill_8_1129 r0 *1 0,0
Xsky130_fd_sc_hd__fill_8_1129 VGND VPWR VPWR sky130_fd_sc_hd__fill_8
* cell instance sky130_fd_sc_hd__fill_8_1130 r0 *1 0,0
Xsky130_fd_sc_hd__fill_8_1130 VGND VPWR VPWR sky130_fd_sc_hd__fill_8
* cell instance sky130_fd_sc_hd__fill_8_1131 r0 *1 0,0
Xsky130_fd_sc_hd__fill_8_1131 VGND VPWR VPWR sky130_fd_sc_hd__fill_8
* cell instance sky130_fd_sc_hd__fill_8_1132 r0 *1 0,0
Xsky130_fd_sc_hd__fill_8_1132 VGND VPWR VPWR sky130_fd_sc_hd__fill_8
* cell instance sky130_fd_sc_hd__fill_8_1133 r0 *1 0,0
Xsky130_fd_sc_hd__fill_8_1133 VGND VPWR VPWR sky130_fd_sc_hd__fill_8
* cell instance sky130_fd_sc_hd__fill_8_1134 r0 *1 0,0
Xsky130_fd_sc_hd__fill_8_1134 VGND VPWR VPWR sky130_fd_sc_hd__fill_8
* cell instance sky130_fd_sc_hd__fill_8_1135 r0 *1 0,0
Xsky130_fd_sc_hd__fill_8_1135 VGND VPWR VPWR sky130_fd_sc_hd__fill_8
* cell instance sky130_fd_sc_hd__fill_8_1136 r0 *1 0,0
Xsky130_fd_sc_hd__fill_8_1136 VGND VPWR VPWR sky130_fd_sc_hd__fill_8
* cell instance sky130_fd_sc_hd__fill_8_1137 r0 *1 0,0
Xsky130_fd_sc_hd__fill_8_1137 VGND VPWR VPWR sky130_fd_sc_hd__fill_8
* cell instance sky130_fd_sc_hd__fill_8_1138 r0 *1 0,0
Xsky130_fd_sc_hd__fill_8_1138 VGND VPWR VPWR sky130_fd_sc_hd__fill_8
* cell instance sky130_fd_sc_hd__fill_8_1139 r0 *1 0,0
Xsky130_fd_sc_hd__fill_8_1139 VGND VPWR VPWR sky130_fd_sc_hd__fill_8
* cell instance sky130_fd_sc_hd__fill_8_1140 r0 *1 0,0
Xsky130_fd_sc_hd__fill_8_1140 VGND VPWR VPWR sky130_fd_sc_hd__fill_8
* cell instance sky130_fd_sc_hd__fill_8_1141 r0 *1 0,0
Xsky130_fd_sc_hd__fill_8_1141 VGND VPWR VPWR sky130_fd_sc_hd__fill_8
* cell instance sky130_fd_sc_hd__fill_8_1142 r0 *1 0,0
Xsky130_fd_sc_hd__fill_8_1142 VGND VPWR VPWR sky130_fd_sc_hd__fill_8
* cell instance sky130_fd_sc_hd__fill_8_1143 r0 *1 0,0
Xsky130_fd_sc_hd__fill_8_1143 VGND VPWR VPWR sky130_fd_sc_hd__fill_8
* cell instance sky130_fd_sc_hd__fill_8_1144 r0 *1 0,0
Xsky130_fd_sc_hd__fill_8_1144 VGND VPWR VPWR sky130_fd_sc_hd__fill_8
* cell instance sky130_fd_sc_hd__fill_8_1145 r0 *1 0,0
Xsky130_fd_sc_hd__fill_8_1145 VGND VPWR VPWR sky130_fd_sc_hd__fill_8
* cell instance sky130_fd_sc_hd__fill_8_1146 r0 *1 0,0
Xsky130_fd_sc_hd__fill_8_1146 VGND VPWR VPWR sky130_fd_sc_hd__fill_8
* cell instance sky130_fd_sc_hd__fill_8_1147 r0 *1 0,0
Xsky130_fd_sc_hd__fill_8_1147 VGND VPWR VPWR sky130_fd_sc_hd__fill_8
* cell instance sky130_fd_sc_hd__fill_8_1148 r0 *1 0,0
Xsky130_fd_sc_hd__fill_8_1148 VGND VPWR VPWR sky130_fd_sc_hd__fill_8
* cell instance sky130_fd_sc_hd__fill_8_1149 r0 *1 0,0
Xsky130_fd_sc_hd__fill_8_1149 VGND VPWR VPWR sky130_fd_sc_hd__fill_8
* cell instance sky130_fd_sc_hd__fill_8_1150 r0 *1 0,0
Xsky130_fd_sc_hd__fill_8_1150 VGND VPWR VPWR sky130_fd_sc_hd__fill_8
* cell instance sky130_fd_sc_hd__fill_8_1151 r0 *1 0,0
Xsky130_fd_sc_hd__fill_8_1151 VGND VPWR VPWR sky130_fd_sc_hd__fill_8
* cell instance sky130_fd_sc_hd__fill_8_1152 r0 *1 0,0
Xsky130_fd_sc_hd__fill_8_1152 VGND VPWR VPWR sky130_fd_sc_hd__fill_8
* cell instance sky130_fd_sc_hd__fill_8_1153 r0 *1 0,0
Xsky130_fd_sc_hd__fill_8_1153 VGND VPWR VPWR sky130_fd_sc_hd__fill_8
* cell instance sky130_fd_sc_hd__fill_8_1154 r0 *1 0,0
Xsky130_fd_sc_hd__fill_8_1154 VGND VPWR VPWR sky130_fd_sc_hd__fill_8
* cell instance sky130_fd_sc_hd__fill_8_1155 r0 *1 0,0
Xsky130_fd_sc_hd__fill_8_1155 VGND VPWR VPWR sky130_fd_sc_hd__fill_8
* cell instance sky130_fd_sc_hd__fill_8_1156 r0 *1 0,0
Xsky130_fd_sc_hd__fill_8_1156 VGND VPWR VPWR sky130_fd_sc_hd__fill_8
* cell instance sky130_fd_sc_hd__fill_8_1157 r0 *1 0,0
Xsky130_fd_sc_hd__fill_8_1157 VGND VPWR VPWR sky130_fd_sc_hd__fill_8
* cell instance sky130_fd_sc_hd__fill_8_1158 r0 *1 0,0
Xsky130_fd_sc_hd__fill_8_1158 VGND VPWR VPWR sky130_fd_sc_hd__fill_8
* cell instance sky130_fd_sc_hd__fill_8_1159 r0 *1 0,0
Xsky130_fd_sc_hd__fill_8_1159 VGND VPWR VPWR sky130_fd_sc_hd__fill_8
* cell instance sky130_fd_sc_hd__fill_8_1160 r0 *1 0,0
Xsky130_fd_sc_hd__fill_8_1160 VGND VPWR VPWR sky130_fd_sc_hd__fill_8
* cell instance sky130_fd_sc_hd__fill_8_1161 r0 *1 0,0
Xsky130_fd_sc_hd__fill_8_1161 VGND VPWR VPWR sky130_fd_sc_hd__fill_8
* cell instance sky130_fd_sc_hd__fill_8_1162 r0 *1 0,0
Xsky130_fd_sc_hd__fill_8_1162 VGND VPWR VPWR sky130_fd_sc_hd__fill_8
* cell instance sky130_fd_sc_hd__fill_8_1163 r0 *1 0,0
Xsky130_fd_sc_hd__fill_8_1163 VGND VPWR VPWR sky130_fd_sc_hd__fill_8
* cell instance sky130_fd_sc_hd__fill_8_1164 r0 *1 0,0
Xsky130_fd_sc_hd__fill_8_1164 VGND VPWR VPWR sky130_fd_sc_hd__fill_8
* cell instance sky130_fd_sc_hd__fill_8_1165 r0 *1 0,0
Xsky130_fd_sc_hd__fill_8_1165 VGND VPWR VPWR sky130_fd_sc_hd__fill_8
* cell instance sky130_fd_sc_hd__fill_8_1166 r0 *1 0,0
Xsky130_fd_sc_hd__fill_8_1166 VGND VPWR VPWR sky130_fd_sc_hd__fill_8
* cell instance sky130_fd_sc_hd__fill_8_1167 r0 *1 0,0
Xsky130_fd_sc_hd__fill_8_1167 VGND VPWR VPWR sky130_fd_sc_hd__fill_8
* cell instance sky130_fd_sc_hd__fill_8_1168 r0 *1 0,0
Xsky130_fd_sc_hd__fill_8_1168 VGND VPWR VPWR sky130_fd_sc_hd__fill_8
* cell instance sky130_fd_sc_hd__fill_8_1169 r0 *1 0,0
Xsky130_fd_sc_hd__fill_8_1169 VGND VPWR VPWR sky130_fd_sc_hd__fill_8
* cell instance sky130_fd_sc_hd__fill_8_1170 r0 *1 0,0
Xsky130_fd_sc_hd__fill_8_1170 VGND VPWR VPWR sky130_fd_sc_hd__fill_8
* cell instance sky130_fd_sc_hd__fill_8_1171 r0 *1 0,0
Xsky130_fd_sc_hd__fill_8_1171 VGND VPWR VPWR sky130_fd_sc_hd__fill_8
* cell instance sky130_fd_sc_hd__fill_8_1172 r0 *1 0,0
Xsky130_fd_sc_hd__fill_8_1172 VGND VPWR VPWR sky130_fd_sc_hd__fill_8
* cell instance sky130_fd_sc_hd__fill_8_1173 r0 *1 0,0
Xsky130_fd_sc_hd__fill_8_1173 VGND VPWR VPWR sky130_fd_sc_hd__fill_8
* cell instance sky130_fd_sc_hd__fill_8_1174 r0 *1 0,0
Xsky130_fd_sc_hd__fill_8_1174 VGND VPWR VPWR sky130_fd_sc_hd__fill_8
* cell instance sky130_fd_sc_hd__fill_8_1175 r0 *1 0,0
Xsky130_fd_sc_hd__fill_8_1175 VGND VPWR VPWR sky130_fd_sc_hd__fill_8
* cell instance sky130_fd_sc_hd__fill_8_1176 r0 *1 0,0
Xsky130_fd_sc_hd__fill_8_1176 VGND VPWR VPWR sky130_fd_sc_hd__fill_8
* cell instance sky130_fd_sc_hd__fill_8_1177 r0 *1 0,0
Xsky130_fd_sc_hd__fill_8_1177 VGND VPWR VPWR sky130_fd_sc_hd__fill_8
* cell instance sky130_fd_sc_hd__fill_8_1178 r0 *1 0,0
Xsky130_fd_sc_hd__fill_8_1178 VGND VPWR VPWR sky130_fd_sc_hd__fill_8
* cell instance sky130_fd_sc_hd__fill_8_1179 r0 *1 0,0
Xsky130_fd_sc_hd__fill_8_1179 VGND VPWR VPWR sky130_fd_sc_hd__fill_8
* cell instance sky130_fd_sc_hd__fill_8_1180 r0 *1 0,0
Xsky130_fd_sc_hd__fill_8_1180 VGND VPWR VPWR sky130_fd_sc_hd__fill_8
* cell instance sky130_fd_sc_hd__fill_8_1181 r0 *1 0,0
Xsky130_fd_sc_hd__fill_8_1181 VGND VPWR VPWR sky130_fd_sc_hd__fill_8
* cell instance sky130_fd_sc_hd__fill_8_1182 r0 *1 0,0
Xsky130_fd_sc_hd__fill_8_1182 VGND VPWR VPWR sky130_fd_sc_hd__fill_8
* cell instance sky130_fd_sc_hd__fill_8_1183 r0 *1 0,0
Xsky130_fd_sc_hd__fill_8_1183 VGND VPWR VPWR sky130_fd_sc_hd__fill_8
* cell instance sky130_fd_sc_hd__fill_8_1184 r0 *1 0,0
Xsky130_fd_sc_hd__fill_8_1184 VGND VPWR VPWR sky130_fd_sc_hd__fill_8
* cell instance sky130_fd_sc_hd__fill_8_1185 r0 *1 0,0
Xsky130_fd_sc_hd__fill_8_1185 VGND VPWR VPWR sky130_fd_sc_hd__fill_8
* cell instance sky130_fd_sc_hd__fill_8_1186 r0 *1 0,0
Xsky130_fd_sc_hd__fill_8_1186 VGND VPWR VPWR sky130_fd_sc_hd__fill_8
* cell instance sky130_fd_sc_hd__fill_8_1187 r0 *1 0,0
Xsky130_fd_sc_hd__fill_8_1187 VGND VPWR VPWR sky130_fd_sc_hd__fill_8
* cell instance sky130_fd_sc_hd__fill_8_1188 r0 *1 0,0
Xsky130_fd_sc_hd__fill_8_1188 VGND VPWR VPWR sky130_fd_sc_hd__fill_8
* cell instance sky130_fd_sc_hd__fill_8_1189 r0 *1 0,0
Xsky130_fd_sc_hd__fill_8_1189 VGND VPWR VPWR sky130_fd_sc_hd__fill_8
* cell instance sky130_fd_sc_hd__fill_8_1190 r0 *1 0,0
Xsky130_fd_sc_hd__fill_8_1190 VGND VPWR VPWR sky130_fd_sc_hd__fill_8
* cell instance sky130_fd_sc_hd__fill_8_1191 r0 *1 0,0
Xsky130_fd_sc_hd__fill_8_1191 VGND VPWR VPWR sky130_fd_sc_hd__fill_8
* cell instance sky130_fd_sc_hd__fill_8_1192 r0 *1 0,0
Xsky130_fd_sc_hd__fill_8_1192 VGND VPWR VPWR sky130_fd_sc_hd__fill_8
* cell instance sky130_fd_sc_hd__fill_8_1193 r0 *1 0,0
Xsky130_fd_sc_hd__fill_8_1193 VGND VPWR VPWR sky130_fd_sc_hd__fill_8
* cell instance sky130_fd_sc_hd__fill_8_1194 r0 *1 0,0
Xsky130_fd_sc_hd__fill_8_1194 VGND VPWR VPWR sky130_fd_sc_hd__fill_8
* cell instance sky130_fd_sc_hd__fill_8_1195 r0 *1 0,0
Xsky130_fd_sc_hd__fill_8_1195 VGND VPWR VPWR sky130_fd_sc_hd__fill_8
* cell instance sky130_fd_sc_hd__fill_8_1196 r0 *1 0,0
Xsky130_fd_sc_hd__fill_8_1196 VGND VPWR VPWR sky130_fd_sc_hd__fill_8
* cell instance sky130_fd_sc_hd__fill_8_1197 r0 *1 0,0
Xsky130_fd_sc_hd__fill_8_1197 VGND VPWR VPWR sky130_fd_sc_hd__fill_8
* cell instance sky130_fd_sc_hd__fill_8_1198 r0 *1 0,0
Xsky130_fd_sc_hd__fill_8_1198 VGND VPWR VPWR sky130_fd_sc_hd__fill_8
* cell instance sky130_fd_sc_hd__fill_8_1199 r0 *1 0,0
Xsky130_fd_sc_hd__fill_8_1199 VGND VPWR VPWR sky130_fd_sc_hd__fill_8
* cell instance sky130_fd_sc_hd__fill_8_1200 r0 *1 0,0
Xsky130_fd_sc_hd__fill_8_1200 VGND VPWR VPWR sky130_fd_sc_hd__fill_8
* cell instance sky130_fd_sc_hd__fill_8_1201 r0 *1 0,0
Xsky130_fd_sc_hd__fill_8_1201 VGND VPWR VPWR sky130_fd_sc_hd__fill_8
* cell instance sky130_fd_sc_hd__fill_8_1202 r0 *1 0,0
Xsky130_fd_sc_hd__fill_8_1202 VGND VPWR VPWR sky130_fd_sc_hd__fill_8
* cell instance sky130_fd_sc_hd__fill_8_1203 r0 *1 0,0
Xsky130_fd_sc_hd__fill_8_1203 VGND VPWR VPWR sky130_fd_sc_hd__fill_8
* cell instance sky130_fd_sc_hd__fill_8_1204 r0 *1 0,0
Xsky130_fd_sc_hd__fill_8_1204 VGND VPWR VPWR sky130_fd_sc_hd__fill_8
* cell instance sky130_fd_sc_hd__fill_8_1205 r0 *1 0,0
Xsky130_fd_sc_hd__fill_8_1205 VGND VPWR VPWR sky130_fd_sc_hd__fill_8
* cell instance sky130_fd_sc_hd__fill_8_1206 r0 *1 0,0
Xsky130_fd_sc_hd__fill_8_1206 VGND VPWR VPWR sky130_fd_sc_hd__fill_8
* cell instance sky130_fd_sc_hd__fill_8_1207 r0 *1 0,0
Xsky130_fd_sc_hd__fill_8_1207 VGND VPWR VPWR sky130_fd_sc_hd__fill_8
* cell instance sky130_fd_sc_hd__fill_8_1208 r0 *1 0,0
Xsky130_fd_sc_hd__fill_8_1208 VGND VPWR VPWR sky130_fd_sc_hd__fill_8
* cell instance sky130_fd_sc_hd__fill_8_1209 r0 *1 0,0
Xsky130_fd_sc_hd__fill_8_1209 VGND VPWR VPWR sky130_fd_sc_hd__fill_8
* cell instance sky130_fd_sc_hd__fill_8_1210 r0 *1 0,0
Xsky130_fd_sc_hd__fill_8_1210 VGND VPWR VPWR sky130_fd_sc_hd__fill_8
* cell instance sky130_fd_sc_hd__fill_8_1211 r0 *1 0,0
Xsky130_fd_sc_hd__fill_8_1211 VGND VPWR VPWR sky130_fd_sc_hd__fill_8
* cell instance sky130_fd_sc_hd__fill_8_1212 r0 *1 0,0
Xsky130_fd_sc_hd__fill_8_1212 VGND VPWR VPWR sky130_fd_sc_hd__fill_8
* cell instance sky130_fd_sc_hd__fill_8_1213 r0 *1 0,0
Xsky130_fd_sc_hd__fill_8_1213 VGND VPWR VPWR sky130_fd_sc_hd__fill_8
* cell instance sky130_fd_sc_hd__fill_8_1214 r0 *1 0,0
Xsky130_fd_sc_hd__fill_8_1214 VGND VPWR VPWR sky130_fd_sc_hd__fill_8
* cell instance sky130_fd_sc_hd__fill_8_1215 r0 *1 0,0
Xsky130_fd_sc_hd__fill_8_1215 VGND VPWR VPWR sky130_fd_sc_hd__fill_8
* cell instance sky130_fd_sc_hd__fill_8_1216 r0 *1 0,0
Xsky130_fd_sc_hd__fill_8_1216 VGND VPWR VPWR sky130_fd_sc_hd__fill_8
* cell instance sky130_fd_sc_hd__fill_8_1217 r0 *1 0,0
Xsky130_fd_sc_hd__fill_8_1217 VGND VPWR VPWR sky130_fd_sc_hd__fill_8
* cell instance sky130_fd_sc_hd__fill_8_1218 r0 *1 0,0
Xsky130_fd_sc_hd__fill_8_1218 VGND VPWR VPWR sky130_fd_sc_hd__fill_8
* cell instance sky130_fd_sc_hd__fill_8_1219 r0 *1 0,0
Xsky130_fd_sc_hd__fill_8_1219 VGND VPWR VPWR sky130_fd_sc_hd__fill_8
* cell instance sky130_fd_sc_hd__fill_8_1220 r0 *1 0,0
Xsky130_fd_sc_hd__fill_8_1220 VGND VPWR VPWR sky130_fd_sc_hd__fill_8
* cell instance sky130_fd_sc_hd__fill_8_1221 r0 *1 0,0
Xsky130_fd_sc_hd__fill_8_1221 VGND VPWR VPWR sky130_fd_sc_hd__fill_8
* cell instance sky130_fd_sc_hd__fill_8_1222 r0 *1 0,0
Xsky130_fd_sc_hd__fill_8_1222 VGND VPWR VPWR sky130_fd_sc_hd__fill_8
* cell instance sky130_fd_sc_hd__fill_8_1223 r0 *1 0,0
Xsky130_fd_sc_hd__fill_8_1223 VGND VPWR VPWR sky130_fd_sc_hd__fill_8
* cell instance sky130_fd_sc_hd__fill_8_1224 r0 *1 0,0
Xsky130_fd_sc_hd__fill_8_1224 VGND VPWR VPWR sky130_fd_sc_hd__fill_8
* cell instance sky130_fd_sc_hd__fill_8_1225 r0 *1 0,0
Xsky130_fd_sc_hd__fill_8_1225 VGND VPWR VPWR sky130_fd_sc_hd__fill_8
* cell instance sky130_fd_sc_hd__fill_8_1226 r0 *1 0,0
Xsky130_fd_sc_hd__fill_8_1226 VGND VPWR VPWR sky130_fd_sc_hd__fill_8
* cell instance sky130_fd_sc_hd__fill_8_1227 r0 *1 0,0
Xsky130_fd_sc_hd__fill_8_1227 VGND VPWR VPWR sky130_fd_sc_hd__fill_8
* cell instance sky130_fd_sc_hd__fill_8_1228 r0 *1 0,0
Xsky130_fd_sc_hd__fill_8_1228 VGND VPWR VPWR sky130_fd_sc_hd__fill_8
* cell instance sky130_fd_sc_hd__fill_8_1229 r0 *1 0,0
Xsky130_fd_sc_hd__fill_8_1229 VGND VPWR VPWR sky130_fd_sc_hd__fill_8
* cell instance sky130_fd_sc_hd__fill_8_1230 r0 *1 0,0
Xsky130_fd_sc_hd__fill_8_1230 VGND VPWR VPWR sky130_fd_sc_hd__fill_8
* cell instance sky130_fd_sc_hd__fill_8_1231 r0 *1 0,0
Xsky130_fd_sc_hd__fill_8_1231 VGND VPWR VPWR sky130_fd_sc_hd__fill_8
* cell instance sky130_fd_sc_hd__fill_8_1232 r0 *1 0,0
Xsky130_fd_sc_hd__fill_8_1232 VGND VPWR VPWR sky130_fd_sc_hd__fill_8
* cell instance sky130_fd_sc_hd__fill_8_1233 r0 *1 0,0
Xsky130_fd_sc_hd__fill_8_1233 VGND VPWR VPWR sky130_fd_sc_hd__fill_8
* cell instance sky130_fd_sc_hd__fill_8_1234 r0 *1 0,0
Xsky130_fd_sc_hd__fill_8_1234 VGND VPWR VPWR sky130_fd_sc_hd__fill_8
* cell instance sky130_fd_sc_hd__fill_8_1235 r0 *1 0,0
Xsky130_fd_sc_hd__fill_8_1235 VGND VPWR VPWR sky130_fd_sc_hd__fill_8
* cell instance sky130_fd_sc_hd__fill_8_1236 r0 *1 0,0
Xsky130_fd_sc_hd__fill_8_1236 VGND VPWR VPWR sky130_fd_sc_hd__fill_8
* cell instance sky130_fd_sc_hd__fill_8_1237 r0 *1 0,0
Xsky130_fd_sc_hd__fill_8_1237 VGND VPWR VPWR sky130_fd_sc_hd__fill_8
* cell instance sky130_fd_sc_hd__fill_8_1238 r0 *1 0,0
Xsky130_fd_sc_hd__fill_8_1238 VGND VPWR VPWR sky130_fd_sc_hd__fill_8
* cell instance sky130_fd_sc_hd__fill_8_1239 r0 *1 0,0
Xsky130_fd_sc_hd__fill_8_1239 VGND VPWR VPWR sky130_fd_sc_hd__fill_8
* cell instance sky130_fd_sc_hd__fill_8_1240 r0 *1 0,0
Xsky130_fd_sc_hd__fill_8_1240 VGND VPWR VPWR sky130_fd_sc_hd__fill_8
* cell instance sky130_fd_sc_hd__fill_8_1241 r0 *1 0,0
Xsky130_fd_sc_hd__fill_8_1241 VGND VPWR VPWR sky130_fd_sc_hd__fill_8
* cell instance sky130_fd_sc_hd__fill_8_1242 r0 *1 0,0
Xsky130_fd_sc_hd__fill_8_1242 VGND VPWR VPWR sky130_fd_sc_hd__fill_8
* cell instance sky130_fd_sc_hd__fill_8_1243 r0 *1 0,0
Xsky130_fd_sc_hd__fill_8_1243 VGND VPWR VPWR sky130_fd_sc_hd__fill_8
* cell instance sky130_fd_sc_hd__fill_8_1244 r0 *1 0,0
Xsky130_fd_sc_hd__fill_8_1244 VGND VPWR VPWR sky130_fd_sc_hd__fill_8
* cell instance sky130_fd_sc_hd__fill_8_1245 r0 *1 0,0
Xsky130_fd_sc_hd__fill_8_1245 VGND VPWR VPWR sky130_fd_sc_hd__fill_8
* cell instance sky130_fd_sc_hd__fill_8_1246 r0 *1 0,0
Xsky130_fd_sc_hd__fill_8_1246 VGND VPWR VPWR sky130_fd_sc_hd__fill_8
* cell instance sky130_fd_sc_hd__fill_8_1247 r0 *1 0,0
Xsky130_fd_sc_hd__fill_8_1247 VGND VPWR VPWR sky130_fd_sc_hd__fill_8
* cell instance sky130_fd_sc_hd__fill_8_1248 r0 *1 0,0
Xsky130_fd_sc_hd__fill_8_1248 VGND VPWR VPWR sky130_fd_sc_hd__fill_8
* cell instance sky130_fd_sc_hd__fill_8_1249 r0 *1 0,0
Xsky130_fd_sc_hd__fill_8_1249 VGND VPWR VPWR sky130_fd_sc_hd__fill_8
* cell instance sky130_fd_sc_hd__fill_8_1250 r0 *1 0,0
Xsky130_fd_sc_hd__fill_8_1250 VGND VPWR VPWR sky130_fd_sc_hd__fill_8
* cell instance sky130_fd_sc_hd__fill_8_1251 r0 *1 0,0
Xsky130_fd_sc_hd__fill_8_1251 VGND VPWR VPWR sky130_fd_sc_hd__fill_8
* cell instance sky130_fd_sc_hd__fill_8_1252 r0 *1 0,0
Xsky130_fd_sc_hd__fill_8_1252 VGND VPWR VPWR sky130_fd_sc_hd__fill_8
* cell instance sky130_fd_sc_hd__fill_8_1253 r0 *1 0,0
Xsky130_fd_sc_hd__fill_8_1253 VGND VPWR VPWR sky130_fd_sc_hd__fill_8
* cell instance sky130_fd_sc_hd__fill_8_1254 r0 *1 0,0
Xsky130_fd_sc_hd__fill_8_1254 VGND VPWR VPWR sky130_fd_sc_hd__fill_8
* cell instance sky130_fd_sc_hd__fill_8_1255 r0 *1 0,0
Xsky130_fd_sc_hd__fill_8_1255 VGND VPWR VPWR sky130_fd_sc_hd__fill_8
* cell instance sky130_fd_sc_hd__fill_8_1256 r0 *1 0,0
Xsky130_fd_sc_hd__fill_8_1256 VGND VPWR VPWR sky130_fd_sc_hd__fill_8
* cell instance sky130_fd_sc_hd__fill_8_1257 r0 *1 0,0
Xsky130_fd_sc_hd__fill_8_1257 VGND VPWR VPWR sky130_fd_sc_hd__fill_8
* cell instance sky130_fd_sc_hd__fill_8_1258 r0 *1 0,0
Xsky130_fd_sc_hd__fill_8_1258 VGND VPWR VPWR sky130_fd_sc_hd__fill_8
* cell instance sky130_fd_sc_hd__fill_8_1259 r0 *1 0,0
Xsky130_fd_sc_hd__fill_8_1259 VGND VPWR VPWR sky130_fd_sc_hd__fill_8
* cell instance sky130_fd_sc_hd__fill_8_1260 r0 *1 0,0
Xsky130_fd_sc_hd__fill_8_1260 VGND VPWR VPWR sky130_fd_sc_hd__fill_8
* cell instance sky130_fd_sc_hd__fill_8_1261 r0 *1 0,0
Xsky130_fd_sc_hd__fill_8_1261 VGND VPWR VPWR sky130_fd_sc_hd__fill_8
* cell instance sky130_fd_sc_hd__fill_8_1262 r0 *1 0,0
Xsky130_fd_sc_hd__fill_8_1262 VGND VPWR VPWR sky130_fd_sc_hd__fill_8
* cell instance sky130_fd_sc_hd__fill_8_1263 r0 *1 0,0
Xsky130_fd_sc_hd__fill_8_1263 VGND VPWR VPWR sky130_fd_sc_hd__fill_8
* cell instance sky130_fd_sc_hd__fill_8_1264 r0 *1 0,0
Xsky130_fd_sc_hd__fill_8_1264 VGND VPWR VPWR sky130_fd_sc_hd__fill_8
* cell instance sky130_fd_sc_hd__fill_8_1265 r0 *1 0,0
Xsky130_fd_sc_hd__fill_8_1265 VGND VPWR VPWR sky130_fd_sc_hd__fill_8
* cell instance sky130_fd_sc_hd__fill_8_1266 r0 *1 0,0
Xsky130_fd_sc_hd__fill_8_1266 VGND VPWR VPWR sky130_fd_sc_hd__fill_8
* cell instance sky130_fd_sc_hd__fill_8_1267 r0 *1 0,0
Xsky130_fd_sc_hd__fill_8_1267 VGND VPWR VPWR sky130_fd_sc_hd__fill_8
* cell instance sky130_fd_sc_hd__fill_8_1268 r0 *1 0,0
Xsky130_fd_sc_hd__fill_8_1268 VGND VPWR VPWR sky130_fd_sc_hd__fill_8
* cell instance sky130_fd_sc_hd__fill_8_1269 r0 *1 0,0
Xsky130_fd_sc_hd__fill_8_1269 VGND VPWR VPWR sky130_fd_sc_hd__fill_8
* cell instance sky130_fd_sc_hd__fill_8_1270 r0 *1 0,0
Xsky130_fd_sc_hd__fill_8_1270 VGND VPWR VPWR sky130_fd_sc_hd__fill_8
* cell instance sky130_fd_sc_hd__fill_8_1271 r0 *1 0,0
Xsky130_fd_sc_hd__fill_8_1271 VGND VPWR VPWR sky130_fd_sc_hd__fill_8
* cell instance sky130_fd_sc_hd__fill_8_1272 r0 *1 0,0
Xsky130_fd_sc_hd__fill_8_1272 VGND VPWR VPWR sky130_fd_sc_hd__fill_8
* cell instance sky130_fd_sc_hd__fill_8_1273 r0 *1 0,0
Xsky130_fd_sc_hd__fill_8_1273 VGND VPWR VPWR sky130_fd_sc_hd__fill_8
* cell instance sky130_fd_sc_hd__fill_8_1274 r0 *1 0,0
Xsky130_fd_sc_hd__fill_8_1274 VGND VPWR VPWR sky130_fd_sc_hd__fill_8
* cell instance sky130_fd_sc_hd__fill_8_1275 r0 *1 0,0
Xsky130_fd_sc_hd__fill_8_1275 VGND VPWR VPWR sky130_fd_sc_hd__fill_8
* cell instance sky130_fd_sc_hd__fill_8_1276 r0 *1 0,0
Xsky130_fd_sc_hd__fill_8_1276 VGND VPWR VPWR sky130_fd_sc_hd__fill_8
* cell instance sky130_fd_sc_hd__fill_8_1277 r0 *1 0,0
Xsky130_fd_sc_hd__fill_8_1277 VGND VPWR VPWR sky130_fd_sc_hd__fill_8
* cell instance sky130_fd_sc_hd__fill_8_1278 r0 *1 0,0
Xsky130_fd_sc_hd__fill_8_1278 VGND VPWR VPWR sky130_fd_sc_hd__fill_8
* cell instance sky130_fd_sc_hd__fill_8_1279 r0 *1 0,0
Xsky130_fd_sc_hd__fill_8_1279 VGND VPWR VPWR sky130_fd_sc_hd__fill_8
* cell instance sky130_fd_sc_hd__fill_8_1280 r0 *1 0,0
Xsky130_fd_sc_hd__fill_8_1280 VGND VPWR VPWR sky130_fd_sc_hd__fill_8
* cell instance sky130_fd_sc_hd__fill_8_1281 r0 *1 0,0
Xsky130_fd_sc_hd__fill_8_1281 VGND VPWR VPWR sky130_fd_sc_hd__fill_8
* cell instance sky130_fd_sc_hd__fill_8_1282 r0 *1 0,0
Xsky130_fd_sc_hd__fill_8_1282 VGND VPWR VPWR sky130_fd_sc_hd__fill_8
* cell instance sky130_fd_sc_hd__fill_8_1283 r0 *1 0,0
Xsky130_fd_sc_hd__fill_8_1283 VGND VPWR VPWR sky130_fd_sc_hd__fill_8
* cell instance sky130_fd_sc_hd__fill_8_1284 r0 *1 0,0
Xsky130_fd_sc_hd__fill_8_1284 VGND VPWR VPWR sky130_fd_sc_hd__fill_8
* cell instance sky130_fd_sc_hd__fill_8_1285 r0 *1 0,0
Xsky130_fd_sc_hd__fill_8_1285 VGND VPWR VPWR sky130_fd_sc_hd__fill_8
* cell instance sky130_fd_sc_hd__fill_8_1286 r0 *1 0,0
Xsky130_fd_sc_hd__fill_8_1286 VGND VPWR VPWR sky130_fd_sc_hd__fill_8
* cell instance sky130_fd_sc_hd__fill_8_1287 r0 *1 0,0
Xsky130_fd_sc_hd__fill_8_1287 VGND VPWR VPWR sky130_fd_sc_hd__fill_8
* cell instance sky130_fd_sc_hd__fill_8_1288 r0 *1 0,0
Xsky130_fd_sc_hd__fill_8_1288 VGND VPWR VPWR sky130_fd_sc_hd__fill_8
* cell instance sky130_fd_sc_hd__fill_8_1289 r0 *1 0,0
Xsky130_fd_sc_hd__fill_8_1289 VGND VPWR VPWR sky130_fd_sc_hd__fill_8
* cell instance sky130_fd_sc_hd__fill_8_1290 r0 *1 0,0
Xsky130_fd_sc_hd__fill_8_1290 VGND VPWR VPWR sky130_fd_sc_hd__fill_8
* cell instance sky130_fd_sc_hd__fill_8_1291 r0 *1 0,0
Xsky130_fd_sc_hd__fill_8_1291 VGND VPWR VPWR sky130_fd_sc_hd__fill_8
* cell instance sky130_fd_sc_hd__fill_8_1292 r0 *1 0,0
Xsky130_fd_sc_hd__fill_8_1292 VGND VPWR VPWR sky130_fd_sc_hd__fill_8
* cell instance sky130_fd_sc_hd__fill_8_1293 r0 *1 0,0
Xsky130_fd_sc_hd__fill_8_1293 VGND VPWR VPWR sky130_fd_sc_hd__fill_8
* cell instance sky130_fd_sc_hd__fill_8_1294 r0 *1 0,0
Xsky130_fd_sc_hd__fill_8_1294 VGND VPWR VPWR sky130_fd_sc_hd__fill_8
* cell instance sky130_fd_sc_hd__fill_8_1295 r0 *1 0,0
Xsky130_fd_sc_hd__fill_8_1295 VGND VPWR VPWR sky130_fd_sc_hd__fill_8
* cell instance sky130_fd_sc_hd__fill_8_1296 r0 *1 0,0
Xsky130_fd_sc_hd__fill_8_1296 VGND VPWR VPWR sky130_fd_sc_hd__fill_8
* cell instance sky130_fd_sc_hd__fill_8_1297 r0 *1 0,0
Xsky130_fd_sc_hd__fill_8_1297 VGND VPWR VPWR sky130_fd_sc_hd__fill_8
* cell instance sky130_fd_sc_hd__fill_8_1298 r0 *1 0,0
Xsky130_fd_sc_hd__fill_8_1298 VGND VPWR VPWR sky130_fd_sc_hd__fill_8
* cell instance sky130_fd_sc_hd__fill_8_1299 r0 *1 0,0
Xsky130_fd_sc_hd__fill_8_1299 VGND VPWR VPWR sky130_fd_sc_hd__fill_8
* cell instance sky130_fd_sc_hd__fill_8_1300 r0 *1 0,0
Xsky130_fd_sc_hd__fill_8_1300 VGND VPWR VPWR sky130_fd_sc_hd__fill_8
* cell instance sky130_fd_sc_hd__fill_8_1301 r0 *1 0,0
Xsky130_fd_sc_hd__fill_8_1301 VGND VPWR VPWR sky130_fd_sc_hd__fill_8
* cell instance sky130_fd_sc_hd__fill_8_1302 r0 *1 0,0
Xsky130_fd_sc_hd__fill_8_1302 VGND VPWR VPWR sky130_fd_sc_hd__fill_8
* cell instance sky130_fd_sc_hd__fill_8_1303 r0 *1 0,0
Xsky130_fd_sc_hd__fill_8_1303 VGND VPWR VPWR sky130_fd_sc_hd__fill_8
* cell instance sky130_fd_sc_hd__fill_8_1304 r0 *1 0,0
Xsky130_fd_sc_hd__fill_8_1304 VGND VPWR VPWR sky130_fd_sc_hd__fill_8
* cell instance sky130_fd_sc_hd__fill_8_1305 r0 *1 0,0
Xsky130_fd_sc_hd__fill_8_1305 VGND VPWR VPWR sky130_fd_sc_hd__fill_8
* cell instance sky130_fd_sc_hd__fill_8_1306 r0 *1 0,0
Xsky130_fd_sc_hd__fill_8_1306 VGND VPWR VPWR sky130_fd_sc_hd__fill_8
* cell instance sky130_fd_sc_hd__fill_8_1307 r0 *1 0,0
Xsky130_fd_sc_hd__fill_8_1307 VGND VPWR VPWR sky130_fd_sc_hd__fill_8
* cell instance sky130_fd_sc_hd__fill_8_1308 r0 *1 0,0
Xsky130_fd_sc_hd__fill_8_1308 VGND VPWR VPWR sky130_fd_sc_hd__fill_8
* cell instance sky130_fd_sc_hd__fill_8_1309 r0 *1 0,0
Xsky130_fd_sc_hd__fill_8_1309 VGND VPWR VPWR sky130_fd_sc_hd__fill_8
* cell instance sky130_fd_sc_hd__fill_8_1310 r0 *1 0,0
Xsky130_fd_sc_hd__fill_8_1310 VGND VPWR VPWR sky130_fd_sc_hd__fill_8
* cell instance sky130_fd_sc_hd__fill_8_1311 r0 *1 0,0
Xsky130_fd_sc_hd__fill_8_1311 VGND VPWR VPWR sky130_fd_sc_hd__fill_8
* cell instance sky130_fd_sc_hd__fill_8_1312 r0 *1 0,0
Xsky130_fd_sc_hd__fill_8_1312 VGND VPWR VPWR sky130_fd_sc_hd__fill_8
* cell instance sky130_fd_sc_hd__fill_8_1313 r0 *1 0,0
Xsky130_fd_sc_hd__fill_8_1313 VGND VPWR VPWR sky130_fd_sc_hd__fill_8
* cell instance sky130_fd_sc_hd__fill_8_1314 r0 *1 0,0
Xsky130_fd_sc_hd__fill_8_1314 VGND VPWR VPWR sky130_fd_sc_hd__fill_8
* cell instance sky130_fd_sc_hd__fill_8_1315 r0 *1 0,0
Xsky130_fd_sc_hd__fill_8_1315 VGND VPWR VPWR sky130_fd_sc_hd__fill_8
* cell instance sky130_fd_sc_hd__fill_8_1316 r0 *1 0,0
Xsky130_fd_sc_hd__fill_8_1316 VGND VPWR VPWR sky130_fd_sc_hd__fill_8
* cell instance sky130_fd_sc_hd__fill_8_1317 r0 *1 0,0
Xsky130_fd_sc_hd__fill_8_1317 VGND VPWR VPWR sky130_fd_sc_hd__fill_8
* cell instance sky130_fd_sc_hd__fill_8_1318 r0 *1 0,0
Xsky130_fd_sc_hd__fill_8_1318 VGND VPWR VPWR sky130_fd_sc_hd__fill_8
* cell instance sky130_fd_sc_hd__fill_8_1319 r0 *1 0,0
Xsky130_fd_sc_hd__fill_8_1319 VGND VPWR VPWR sky130_fd_sc_hd__fill_8
* cell instance sky130_fd_sc_hd__fill_8_1320 r0 *1 0,0
Xsky130_fd_sc_hd__fill_8_1320 VGND VPWR VPWR sky130_fd_sc_hd__fill_8
* cell instance sky130_fd_sc_hd__fill_8_1321 r0 *1 0,0
Xsky130_fd_sc_hd__fill_8_1321 VGND VPWR VPWR sky130_fd_sc_hd__fill_8
* cell instance sky130_fd_sc_hd__fill_8_1322 r0 *1 0,0
Xsky130_fd_sc_hd__fill_8_1322 VGND VPWR VPWR sky130_fd_sc_hd__fill_8
* cell instance sky130_fd_sc_hd__fill_8_1323 r0 *1 0,0
Xsky130_fd_sc_hd__fill_8_1323 VGND VPWR VPWR sky130_fd_sc_hd__fill_8
* cell instance sky130_fd_sc_hd__fill_8_1324 r0 *1 0,0
Xsky130_fd_sc_hd__fill_8_1324 VGND VPWR VPWR sky130_fd_sc_hd__fill_8
* cell instance sky130_fd_sc_hd__fill_8_1325 r0 *1 0,0
Xsky130_fd_sc_hd__fill_8_1325 VGND VPWR VPWR sky130_fd_sc_hd__fill_8
* cell instance sky130_fd_sc_hd__fill_8_1326 r0 *1 0,0
Xsky130_fd_sc_hd__fill_8_1326 VGND VPWR VPWR sky130_fd_sc_hd__fill_8
* cell instance sky130_fd_sc_hd__fill_8_1327 r0 *1 0,0
Xsky130_fd_sc_hd__fill_8_1327 VGND VPWR VPWR sky130_fd_sc_hd__fill_8
* cell instance sky130_fd_sc_hd__fill_8_1328 r0 *1 0,0
Xsky130_fd_sc_hd__fill_8_1328 VGND VPWR VPWR sky130_fd_sc_hd__fill_8
* cell instance sky130_fd_sc_hd__fill_8_1329 r0 *1 0,0
Xsky130_fd_sc_hd__fill_8_1329 VGND VPWR VPWR sky130_fd_sc_hd__fill_8
* cell instance sky130_fd_sc_hd__fill_8_1330 r0 *1 0,0
Xsky130_fd_sc_hd__fill_8_1330 VGND VPWR VPWR sky130_fd_sc_hd__fill_8
* cell instance sky130_fd_sc_hd__fill_8_1331 r0 *1 0,0
Xsky130_fd_sc_hd__fill_8_1331 VGND VPWR VPWR sky130_fd_sc_hd__fill_8
* cell instance sky130_fd_sc_hd__fill_8_1332 r0 *1 0,0
Xsky130_fd_sc_hd__fill_8_1332 VGND VPWR VPWR sky130_fd_sc_hd__fill_8
* cell instance sky130_fd_sc_hd__fill_8_1333 r0 *1 0,0
Xsky130_fd_sc_hd__fill_8_1333 VGND VPWR VPWR sky130_fd_sc_hd__fill_8
* cell instance sky130_fd_sc_hd__fill_8_1334 r0 *1 0,0
Xsky130_fd_sc_hd__fill_8_1334 VGND VPWR VPWR sky130_fd_sc_hd__fill_8
* cell instance sky130_fd_sc_hd__fill_8_1335 r0 *1 0,0
Xsky130_fd_sc_hd__fill_8_1335 VGND VPWR VPWR sky130_fd_sc_hd__fill_8
* cell instance sky130_fd_sc_hd__fill_8_1336 r0 *1 0,0
Xsky130_fd_sc_hd__fill_8_1336 VGND VPWR VPWR sky130_fd_sc_hd__fill_8
* cell instance sky130_fd_sc_hd__fill_8_1337 r0 *1 0,0
Xsky130_fd_sc_hd__fill_8_1337 VGND VPWR VPWR sky130_fd_sc_hd__fill_8
* cell instance sky130_fd_sc_hd__fill_8_1338 r0 *1 0,0
Xsky130_fd_sc_hd__fill_8_1338 VGND VPWR VPWR sky130_fd_sc_hd__fill_8
* cell instance sky130_fd_sc_hd__fill_8_1339 r0 *1 0,0
Xsky130_fd_sc_hd__fill_8_1339 VGND VPWR VPWR sky130_fd_sc_hd__fill_8
* cell instance sky130_fd_sc_hd__fill_8_1340 r0 *1 0,0
Xsky130_fd_sc_hd__fill_8_1340 VGND VPWR VPWR sky130_fd_sc_hd__fill_8
* cell instance sky130_fd_sc_hd__fill_8_1341 r0 *1 0,0
Xsky130_fd_sc_hd__fill_8_1341 VGND VPWR VPWR sky130_fd_sc_hd__fill_8
* cell instance sky130_fd_sc_hd__fill_8_1342 r0 *1 0,0
Xsky130_fd_sc_hd__fill_8_1342 VGND VPWR VPWR sky130_fd_sc_hd__fill_8
* cell instance sky130_fd_sc_hd__fill_8_1343 r0 *1 0,0
Xsky130_fd_sc_hd__fill_8_1343 VGND VPWR VPWR sky130_fd_sc_hd__fill_8
* cell instance sky130_fd_sc_hd__fill_8_1344 r0 *1 0,0
Xsky130_fd_sc_hd__fill_8_1344 VGND VPWR VPWR sky130_fd_sc_hd__fill_8
* cell instance sky130_fd_sc_hd__fill_8_1345 r0 *1 0,0
Xsky130_fd_sc_hd__fill_8_1345 VGND VPWR VPWR sky130_fd_sc_hd__fill_8
* cell instance sky130_fd_sc_hd__fill_8_1346 r0 *1 0,0
Xsky130_fd_sc_hd__fill_8_1346 VGND VPWR VPWR sky130_fd_sc_hd__fill_8
* cell instance sky130_fd_sc_hd__fill_8_1347 r0 *1 0,0
Xsky130_fd_sc_hd__fill_8_1347 VGND VPWR VPWR sky130_fd_sc_hd__fill_8
* cell instance sky130_fd_sc_hd__fill_8_1348 r0 *1 0,0
Xsky130_fd_sc_hd__fill_8_1348 VGND VPWR VPWR sky130_fd_sc_hd__fill_8
* cell instance sky130_fd_sc_hd__fill_8_1349 r0 *1 0,0
Xsky130_fd_sc_hd__fill_8_1349 VGND VPWR VPWR sky130_fd_sc_hd__fill_8
* cell instance sky130_fd_sc_hd__fill_8_1350 r0 *1 0,0
Xsky130_fd_sc_hd__fill_8_1350 VGND VPWR VPWR sky130_fd_sc_hd__fill_8
* cell instance sky130_fd_sc_hd__fill_8_1351 r0 *1 0,0
Xsky130_fd_sc_hd__fill_8_1351 VGND VPWR VPWR sky130_fd_sc_hd__fill_8
* cell instance sky130_fd_sc_hd__fill_8_1352 r0 *1 0,0
Xsky130_fd_sc_hd__fill_8_1352 VGND VPWR VPWR sky130_fd_sc_hd__fill_8
* cell instance sky130_fd_sc_hd__fill_8_1353 r0 *1 0,0
Xsky130_fd_sc_hd__fill_8_1353 VGND VPWR VPWR sky130_fd_sc_hd__fill_8
* cell instance sky130_fd_sc_hd__fill_8_1354 r0 *1 0,0
Xsky130_fd_sc_hd__fill_8_1354 VGND VPWR VPWR sky130_fd_sc_hd__fill_8
* cell instance sky130_fd_sc_hd__fill_8_1355 r0 *1 0,0
Xsky130_fd_sc_hd__fill_8_1355 VGND VPWR VPWR sky130_fd_sc_hd__fill_8
* cell instance sky130_fd_sc_hd__fill_8_1356 r0 *1 0,0
Xsky130_fd_sc_hd__fill_8_1356 VGND VPWR VPWR sky130_fd_sc_hd__fill_8
* cell instance sky130_fd_sc_hd__fill_8_1357 r0 *1 0,0
Xsky130_fd_sc_hd__fill_8_1357 VGND VPWR VPWR sky130_fd_sc_hd__fill_8
* cell instance sky130_fd_sc_hd__fill_8_1358 r0 *1 0,0
Xsky130_fd_sc_hd__fill_8_1358 VGND VPWR VPWR sky130_fd_sc_hd__fill_8
* cell instance sky130_fd_sc_hd__fill_8_1359 r0 *1 0,0
Xsky130_fd_sc_hd__fill_8_1359 VGND VPWR VPWR sky130_fd_sc_hd__fill_8
* cell instance sky130_fd_sc_hd__fill_8_1360 r0 *1 0,0
Xsky130_fd_sc_hd__fill_8_1360 VGND VPWR VPWR sky130_fd_sc_hd__fill_8
* cell instance sky130_fd_sc_hd__fill_8_1361 r0 *1 0,0
Xsky130_fd_sc_hd__fill_8_1361 VGND VPWR VPWR sky130_fd_sc_hd__fill_8
* cell instance sky130_fd_sc_hd__fill_8_1362 r0 *1 0,0
Xsky130_fd_sc_hd__fill_8_1362 VGND VPWR VPWR sky130_fd_sc_hd__fill_8
* cell instance sky130_fd_sc_hd__fill_8_1363 r0 *1 0,0
Xsky130_fd_sc_hd__fill_8_1363 VGND VPWR VPWR sky130_fd_sc_hd__fill_8
* cell instance sky130_fd_sc_hd__fill_8_1364 r0 *1 0,0
Xsky130_fd_sc_hd__fill_8_1364 VGND VPWR VPWR sky130_fd_sc_hd__fill_8
* cell instance sky130_fd_sc_hd__fill_8_1365 r0 *1 0,0
Xsky130_fd_sc_hd__fill_8_1365 VGND VPWR VPWR sky130_fd_sc_hd__fill_8
* cell instance sky130_fd_sc_hd__fill_8_1366 r0 *1 0,0
Xsky130_fd_sc_hd__fill_8_1366 VGND VPWR VPWR sky130_fd_sc_hd__fill_8
* cell instance sky130_fd_sc_hd__fill_8_1367 r0 *1 0,0
Xsky130_fd_sc_hd__fill_8_1367 VGND VPWR VPWR sky130_fd_sc_hd__fill_8
* cell instance sky130_fd_sc_hd__fill_8_1368 r0 *1 0,0
Xsky130_fd_sc_hd__fill_8_1368 VGND VPWR VPWR sky130_fd_sc_hd__fill_8
* cell instance sky130_fd_sc_hd__fill_8_1369 r0 *1 0,0
Xsky130_fd_sc_hd__fill_8_1369 VGND VPWR VPWR sky130_fd_sc_hd__fill_8
* cell instance sky130_fd_sc_hd__fill_8_1370 r0 *1 0,0
Xsky130_fd_sc_hd__fill_8_1370 VGND VPWR VPWR sky130_fd_sc_hd__fill_8
* cell instance sky130_fd_sc_hd__fill_8_1371 r0 *1 0,0
Xsky130_fd_sc_hd__fill_8_1371 VGND VPWR VPWR sky130_fd_sc_hd__fill_8
* cell instance sky130_fd_sc_hd__fill_8_1372 r0 *1 0,0
Xsky130_fd_sc_hd__fill_8_1372 VGND VPWR VPWR sky130_fd_sc_hd__fill_8
* cell instance sky130_fd_sc_hd__fill_8_1373 r0 *1 0,0
Xsky130_fd_sc_hd__fill_8_1373 VGND VPWR VPWR sky130_fd_sc_hd__fill_8
* cell instance sky130_fd_sc_hd__fill_8_1374 r0 *1 0,0
Xsky130_fd_sc_hd__fill_8_1374 VGND VPWR VPWR sky130_fd_sc_hd__fill_8
* cell instance sky130_fd_sc_hd__fill_8_1375 r0 *1 0,0
Xsky130_fd_sc_hd__fill_8_1375 VGND VPWR VPWR sky130_fd_sc_hd__fill_8
* cell instance sky130_fd_sc_hd__fill_8_1376 r0 *1 0,0
Xsky130_fd_sc_hd__fill_8_1376 VGND VPWR VPWR sky130_fd_sc_hd__fill_8
* cell instance sky130_fd_sc_hd__fill_8_1377 r0 *1 0,0
Xsky130_fd_sc_hd__fill_8_1377 VGND VPWR VPWR sky130_fd_sc_hd__fill_8
* cell instance sky130_fd_sc_hd__fill_8_1378 r0 *1 0,0
Xsky130_fd_sc_hd__fill_8_1378 VGND VPWR VPWR sky130_fd_sc_hd__fill_8
* cell instance sky130_fd_sc_hd__fill_8_1379 r0 *1 0,0
Xsky130_fd_sc_hd__fill_8_1379 VGND VPWR VPWR sky130_fd_sc_hd__fill_8
* cell instance sky130_fd_sc_hd__fill_8_1380 r0 *1 0,0
Xsky130_fd_sc_hd__fill_8_1380 VGND VPWR VPWR sky130_fd_sc_hd__fill_8
* cell instance sky130_fd_sc_hd__fill_8_1381 r0 *1 0,0
Xsky130_fd_sc_hd__fill_8_1381 VGND VPWR VPWR sky130_fd_sc_hd__fill_8
* cell instance sky130_fd_sc_hd__fill_8_1382 r0 *1 0,0
Xsky130_fd_sc_hd__fill_8_1382 VGND VPWR VPWR sky130_fd_sc_hd__fill_8
* cell instance sky130_fd_sc_hd__fill_8_1383 r0 *1 0,0
Xsky130_fd_sc_hd__fill_8_1383 VGND VPWR VPWR sky130_fd_sc_hd__fill_8
* cell instance sky130_fd_sc_hd__fill_8_1384 r0 *1 0,0
Xsky130_fd_sc_hd__fill_8_1384 VGND VPWR VPWR sky130_fd_sc_hd__fill_8
* cell instance sky130_fd_sc_hd__fill_8_1385 r0 *1 0,0
Xsky130_fd_sc_hd__fill_8_1385 VGND VPWR VPWR sky130_fd_sc_hd__fill_8
* cell instance sky130_fd_sc_hd__fill_8_1386 r0 *1 0,0
Xsky130_fd_sc_hd__fill_8_1386 VGND VPWR VPWR sky130_fd_sc_hd__fill_8
* cell instance sky130_fd_sc_hd__fill_8_1387 r0 *1 0,0
Xsky130_fd_sc_hd__fill_8_1387 VGND VPWR VPWR sky130_fd_sc_hd__fill_8
* cell instance sky130_fd_sc_hd__fill_8_1388 r0 *1 0,0
Xsky130_fd_sc_hd__fill_8_1388 VGND VPWR VPWR sky130_fd_sc_hd__fill_8
* cell instance sky130_fd_sc_hd__fill_8_1389 r0 *1 0,0
Xsky130_fd_sc_hd__fill_8_1389 VGND VPWR VPWR sky130_fd_sc_hd__fill_8
* cell instance sky130_fd_sc_hd__fill_8_1390 r0 *1 0,0
Xsky130_fd_sc_hd__fill_8_1390 VGND VPWR VPWR sky130_fd_sc_hd__fill_8
* cell instance sky130_fd_sc_hd__fill_8_1391 r0 *1 0,0
Xsky130_fd_sc_hd__fill_8_1391 VGND VPWR VPWR sky130_fd_sc_hd__fill_8
* cell instance sky130_fd_sc_hd__fill_8_1392 r0 *1 0,0
Xsky130_fd_sc_hd__fill_8_1392 VGND VPWR VPWR sky130_fd_sc_hd__fill_8
* cell instance sky130_fd_sc_hd__fill_8_1393 r0 *1 0,0
Xsky130_fd_sc_hd__fill_8_1393 VGND VPWR VPWR sky130_fd_sc_hd__fill_8
* cell instance sky130_fd_sc_hd__fill_8_1394 r0 *1 0,0
Xsky130_fd_sc_hd__fill_8_1394 VGND VPWR VPWR sky130_fd_sc_hd__fill_8
* cell instance sky130_fd_sc_hd__fill_8_1395 r0 *1 0,0
Xsky130_fd_sc_hd__fill_8_1395 VGND VPWR VPWR sky130_fd_sc_hd__fill_8
* cell instance sky130_fd_sc_hd__fill_8_1396 r0 *1 0,0
Xsky130_fd_sc_hd__fill_8_1396 VGND VPWR VPWR sky130_fd_sc_hd__fill_8
* cell instance sky130_fd_sc_hd__fill_8_1397 r0 *1 0,0
Xsky130_fd_sc_hd__fill_8_1397 VGND VPWR VPWR sky130_fd_sc_hd__fill_8
* cell instance sky130_fd_sc_hd__fill_8_1398 r0 *1 0,0
Xsky130_fd_sc_hd__fill_8_1398 VGND VPWR VPWR sky130_fd_sc_hd__fill_8
* cell instance sky130_fd_sc_hd__fill_8_1399 r0 *1 0,0
Xsky130_fd_sc_hd__fill_8_1399 VGND VPWR VPWR sky130_fd_sc_hd__fill_8
* cell instance sky130_fd_sc_hd__fill_8_1400 r0 *1 0,0
Xsky130_fd_sc_hd__fill_8_1400 VGND VPWR VPWR sky130_fd_sc_hd__fill_8
* cell instance sky130_fd_sc_hd__fill_8_1401 r0 *1 0,0
Xsky130_fd_sc_hd__fill_8_1401 VGND VPWR VPWR sky130_fd_sc_hd__fill_8
* cell instance sky130_fd_sc_hd__fill_8_1402 r0 *1 0,0
Xsky130_fd_sc_hd__fill_8_1402 VGND VPWR VPWR sky130_fd_sc_hd__fill_8
* cell instance sky130_fd_sc_hd__fill_8_1403 r0 *1 0,0
Xsky130_fd_sc_hd__fill_8_1403 VGND VPWR VPWR sky130_fd_sc_hd__fill_8
* cell instance sky130_fd_sc_hd__fill_8_1404 r0 *1 0,0
Xsky130_fd_sc_hd__fill_8_1404 VGND VPWR VPWR sky130_fd_sc_hd__fill_8
* cell instance sky130_fd_sc_hd__fill_8_1405 r0 *1 0,0
Xsky130_fd_sc_hd__fill_8_1405 VGND VPWR VPWR sky130_fd_sc_hd__fill_8
* cell instance sky130_fd_sc_hd__fill_8_1406 r0 *1 0,0
Xsky130_fd_sc_hd__fill_8_1406 VGND VPWR VPWR sky130_fd_sc_hd__fill_8
* cell instance sky130_fd_sc_hd__fill_8_1407 r0 *1 0,0
Xsky130_fd_sc_hd__fill_8_1407 VGND VPWR VPWR sky130_fd_sc_hd__fill_8
* cell instance sky130_fd_sc_hd__fill_8_1408 r0 *1 0,0
Xsky130_fd_sc_hd__fill_8_1408 VGND VPWR VPWR sky130_fd_sc_hd__fill_8
* cell instance sky130_fd_sc_hd__fill_8_1409 r0 *1 0,0
Xsky130_fd_sc_hd__fill_8_1409 VGND VPWR VPWR sky130_fd_sc_hd__fill_8
* cell instance sky130_fd_sc_hd__fill_8_1410 r0 *1 0,0
Xsky130_fd_sc_hd__fill_8_1410 VGND VPWR VPWR sky130_fd_sc_hd__fill_8
* cell instance sky130_fd_sc_hd__fill_8_1411 r0 *1 0,0
Xsky130_fd_sc_hd__fill_8_1411 VGND VPWR VPWR sky130_fd_sc_hd__fill_8
* cell instance sky130_fd_sc_hd__fill_8_1412 r0 *1 0,0
Xsky130_fd_sc_hd__fill_8_1412 VGND VPWR VPWR sky130_fd_sc_hd__fill_8
* cell instance sky130_fd_sc_hd__fill_8_1413 r0 *1 0,0
Xsky130_fd_sc_hd__fill_8_1413 VGND VPWR VPWR sky130_fd_sc_hd__fill_8
* cell instance sky130_fd_sc_hd__fill_8_1414 r0 *1 0,0
Xsky130_fd_sc_hd__fill_8_1414 VGND VPWR VPWR sky130_fd_sc_hd__fill_8
* cell instance sky130_fd_sc_hd__fill_8_1415 r0 *1 0,0
Xsky130_fd_sc_hd__fill_8_1415 VGND VPWR VPWR sky130_fd_sc_hd__fill_8
* cell instance sky130_fd_sc_hd__fill_8_1416 r0 *1 0,0
Xsky130_fd_sc_hd__fill_8_1416 VGND VPWR VPWR sky130_fd_sc_hd__fill_8
* cell instance sky130_fd_sc_hd__fill_8_1417 r0 *1 0,0
Xsky130_fd_sc_hd__fill_8_1417 VGND VPWR VPWR sky130_fd_sc_hd__fill_8
* cell instance sky130_fd_sc_hd__fill_8_1418 r0 *1 0,0
Xsky130_fd_sc_hd__fill_8_1418 VGND VPWR VPWR sky130_fd_sc_hd__fill_8
* cell instance sky130_fd_sc_hd__fill_8_1419 r0 *1 0,0
Xsky130_fd_sc_hd__fill_8_1419 VGND VPWR VPWR sky130_fd_sc_hd__fill_8
* cell instance sky130_fd_sc_hd__fill_8_1420 r0 *1 0,0
Xsky130_fd_sc_hd__fill_8_1420 VGND VPWR VPWR sky130_fd_sc_hd__fill_8
* cell instance sky130_fd_sc_hd__fill_8_1421 r0 *1 0,0
Xsky130_fd_sc_hd__fill_8_1421 VGND VPWR VPWR sky130_fd_sc_hd__fill_8
* cell instance sky130_fd_sc_hd__fill_8_1422 r0 *1 0,0
Xsky130_fd_sc_hd__fill_8_1422 VGND VPWR VPWR sky130_fd_sc_hd__fill_8
* cell instance sky130_fd_sc_hd__fill_8_1423 r0 *1 0,0
Xsky130_fd_sc_hd__fill_8_1423 VGND VPWR VPWR sky130_fd_sc_hd__fill_8
* cell instance sky130_fd_sc_hd__fill_8_1424 r0 *1 0,0
Xsky130_fd_sc_hd__fill_8_1424 VGND VPWR VPWR sky130_fd_sc_hd__fill_8
* cell instance sky130_fd_sc_hd__fill_8_1425 r0 *1 0,0
Xsky130_fd_sc_hd__fill_8_1425 VGND VPWR VPWR sky130_fd_sc_hd__fill_8
* cell instance sky130_fd_sc_hd__fill_8_1426 r0 *1 0,0
Xsky130_fd_sc_hd__fill_8_1426 VGND VPWR VPWR sky130_fd_sc_hd__fill_8
* cell instance sky130_fd_sc_hd__fill_8_1427 r0 *1 0,0
Xsky130_fd_sc_hd__fill_8_1427 VGND VPWR VPWR sky130_fd_sc_hd__fill_8
* cell instance sky130_fd_sc_hd__fill_8_1428 r0 *1 0,0
Xsky130_fd_sc_hd__fill_8_1428 VGND VPWR VPWR sky130_fd_sc_hd__fill_8
* cell instance sky130_fd_sc_hd__fill_8_1429 r0 *1 0,0
Xsky130_fd_sc_hd__fill_8_1429 VGND VPWR VPWR sky130_fd_sc_hd__fill_8
* cell instance sky130_fd_sc_hd__fill_8_1430 r0 *1 0,0
Xsky130_fd_sc_hd__fill_8_1430 VGND VPWR VPWR sky130_fd_sc_hd__fill_8
* cell instance sky130_fd_sc_hd__fill_8_1431 r0 *1 0,0
Xsky130_fd_sc_hd__fill_8_1431 VGND VPWR VPWR sky130_fd_sc_hd__fill_8
* cell instance sky130_fd_sc_hd__fill_8_1432 r0 *1 0,0
Xsky130_fd_sc_hd__fill_8_1432 VGND VPWR VPWR sky130_fd_sc_hd__fill_8
* cell instance sky130_fd_sc_hd__fill_8_1433 r0 *1 0,0
Xsky130_fd_sc_hd__fill_8_1433 VGND VPWR VPWR sky130_fd_sc_hd__fill_8
* cell instance sky130_fd_sc_hd__fill_8_1434 r0 *1 0,0
Xsky130_fd_sc_hd__fill_8_1434 VGND VPWR VPWR sky130_fd_sc_hd__fill_8
* cell instance sky130_fd_sc_hd__fill_8_1435 r0 *1 0,0
Xsky130_fd_sc_hd__fill_8_1435 VGND VPWR VPWR sky130_fd_sc_hd__fill_8
* cell instance sky130_fd_sc_hd__fill_8_1436 r0 *1 0,0
Xsky130_fd_sc_hd__fill_8_1436 VGND VPWR VPWR sky130_fd_sc_hd__fill_8
* cell instance sky130_fd_sc_hd__fill_8_1437 r0 *1 0,0
Xsky130_fd_sc_hd__fill_8_1437 VGND VPWR VPWR sky130_fd_sc_hd__fill_8
* cell instance sky130_fd_sc_hd__fill_8_1438 r0 *1 0,0
Xsky130_fd_sc_hd__fill_8_1438 VGND VPWR VPWR sky130_fd_sc_hd__fill_8
* cell instance sky130_fd_sc_hd__fill_8_1439 r0 *1 0,0
Xsky130_fd_sc_hd__fill_8_1439 VGND VPWR VPWR sky130_fd_sc_hd__fill_8
* cell instance sky130_fd_sc_hd__fill_8_1440 r0 *1 0,0
Xsky130_fd_sc_hd__fill_8_1440 VGND VPWR VPWR sky130_fd_sc_hd__fill_8
* cell instance sky130_fd_sc_hd__fill_8_1441 r0 *1 0,0
Xsky130_fd_sc_hd__fill_8_1441 VGND VPWR VPWR sky130_fd_sc_hd__fill_8
* cell instance sky130_fd_sc_hd__fill_8_1442 r0 *1 0,0
Xsky130_fd_sc_hd__fill_8_1442 VGND VPWR VPWR sky130_fd_sc_hd__fill_8
* cell instance sky130_fd_sc_hd__fill_8_1443 r0 *1 0,0
Xsky130_fd_sc_hd__fill_8_1443 VGND VPWR VPWR sky130_fd_sc_hd__fill_8
* cell instance sky130_fd_sc_hd__fill_8_1444 r0 *1 0,0
Xsky130_fd_sc_hd__fill_8_1444 VGND VPWR VPWR sky130_fd_sc_hd__fill_8
* cell instance sky130_fd_sc_hd__fill_8_1445 r0 *1 0,0
Xsky130_fd_sc_hd__fill_8_1445 VGND VPWR VPWR sky130_fd_sc_hd__fill_8
* cell instance sky130_fd_sc_hd__fill_8_1446 r0 *1 0,0
Xsky130_fd_sc_hd__fill_8_1446 VGND VPWR VPWR sky130_fd_sc_hd__fill_8
* cell instance sky130_fd_sc_hd__fill_8_1447 r0 *1 0,0
Xsky130_fd_sc_hd__fill_8_1447 VGND VPWR VPWR sky130_fd_sc_hd__fill_8
* cell instance sky130_fd_sc_hd__fill_8_1448 r0 *1 0,0
Xsky130_fd_sc_hd__fill_8_1448 VGND VPWR VPWR sky130_fd_sc_hd__fill_8
* cell instance sky130_fd_sc_hd__fill_8_1449 r0 *1 0,0
Xsky130_fd_sc_hd__fill_8_1449 VGND VPWR VPWR sky130_fd_sc_hd__fill_8
* cell instance sky130_fd_sc_hd__fill_8_1450 r0 *1 0,0
Xsky130_fd_sc_hd__fill_8_1450 VGND VPWR VPWR sky130_fd_sc_hd__fill_8
* cell instance sky130_fd_sc_hd__fill_8_1451 r0 *1 0,0
Xsky130_fd_sc_hd__fill_8_1451 VGND VPWR VPWR sky130_fd_sc_hd__fill_8
* cell instance sky130_fd_sc_hd__fill_8_1452 r0 *1 0,0
Xsky130_fd_sc_hd__fill_8_1452 VGND VPWR VPWR sky130_fd_sc_hd__fill_8
* cell instance sky130_fd_sc_hd__fill_8_1453 r0 *1 0,0
Xsky130_fd_sc_hd__fill_8_1453 VGND VPWR VPWR sky130_fd_sc_hd__fill_8
* cell instance sky130_fd_sc_hd__fill_8_1454 r0 *1 0,0
Xsky130_fd_sc_hd__fill_8_1454 VGND VPWR VPWR sky130_fd_sc_hd__fill_8
* cell instance sky130_fd_sc_hd__fill_8_1455 r0 *1 0,0
Xsky130_fd_sc_hd__fill_8_1455 VGND VPWR VPWR sky130_fd_sc_hd__fill_8
* cell instance sky130_fd_sc_hd__fill_8_1456 r0 *1 0,0
Xsky130_fd_sc_hd__fill_8_1456 VGND VPWR VPWR sky130_fd_sc_hd__fill_8
* cell instance sky130_fd_sc_hd__fill_8_1457 r0 *1 0,0
Xsky130_fd_sc_hd__fill_8_1457 VGND VPWR VPWR sky130_fd_sc_hd__fill_8
* cell instance sky130_fd_sc_hd__fill_8_1458 r0 *1 0,0
Xsky130_fd_sc_hd__fill_8_1458 VGND VPWR VPWR sky130_fd_sc_hd__fill_8
* cell instance sky130_fd_sc_hd__fill_8_1459 r0 *1 0,0
Xsky130_fd_sc_hd__fill_8_1459 VGND VPWR VPWR sky130_fd_sc_hd__fill_8
* cell instance sky130_fd_sc_hd__fill_8_1460 r0 *1 0,0
Xsky130_fd_sc_hd__fill_8_1460 VGND VPWR VPWR sky130_fd_sc_hd__fill_8
* cell instance sky130_fd_sc_hd__fill_8_1461 r0 *1 0,0
Xsky130_fd_sc_hd__fill_8_1461 VGND VPWR VPWR sky130_fd_sc_hd__fill_8
* cell instance sky130_fd_sc_hd__fill_8_1462 r0 *1 0,0
Xsky130_fd_sc_hd__fill_8_1462 VGND VPWR VPWR sky130_fd_sc_hd__fill_8
* cell instance sky130_fd_sc_hd__fill_8_1463 r0 *1 0,0
Xsky130_fd_sc_hd__fill_8_1463 VGND VPWR VPWR sky130_fd_sc_hd__fill_8
* cell instance sky130_fd_sc_hd__fill_8_1464 r0 *1 0,0
Xsky130_fd_sc_hd__fill_8_1464 VGND VPWR VPWR sky130_fd_sc_hd__fill_8
* cell instance sky130_fd_sc_hd__fill_8_1465 r0 *1 0,0
Xsky130_fd_sc_hd__fill_8_1465 VGND VPWR VPWR sky130_fd_sc_hd__fill_8
* cell instance sky130_fd_sc_hd__fill_8_1466 r0 *1 0,0
Xsky130_fd_sc_hd__fill_8_1466 VGND VPWR VPWR sky130_fd_sc_hd__fill_8
* cell instance sky130_fd_sc_hd__fill_8_1467 r0 *1 0,0
Xsky130_fd_sc_hd__fill_8_1467 VGND VPWR VPWR sky130_fd_sc_hd__fill_8
* cell instance sky130_fd_sc_hd__fill_8_1468 r0 *1 0,0
Xsky130_fd_sc_hd__fill_8_1468 VGND VPWR VPWR sky130_fd_sc_hd__fill_8
* cell instance sky130_fd_sc_hd__fill_8_1469 r0 *1 0,0
Xsky130_fd_sc_hd__fill_8_1469 VGND VPWR VPWR sky130_fd_sc_hd__fill_8
* cell instance sky130_fd_sc_hd__fill_8_1470 r0 *1 0,0
Xsky130_fd_sc_hd__fill_8_1470 VGND VPWR VPWR sky130_fd_sc_hd__fill_8
* cell instance sky130_fd_sc_hd__fill_8_1471 r0 *1 0,0
Xsky130_fd_sc_hd__fill_8_1471 VGND VPWR VPWR sky130_fd_sc_hd__fill_8
* cell instance sky130_fd_sc_hd__fill_8_1472 r0 *1 0,0
Xsky130_fd_sc_hd__fill_8_1472 VGND VPWR VPWR sky130_fd_sc_hd__fill_8
* cell instance sky130_fd_sc_hd__fill_8_1473 r0 *1 0,0
Xsky130_fd_sc_hd__fill_8_1473 VGND VPWR VPWR sky130_fd_sc_hd__fill_8
* cell instance sky130_fd_sc_hd__fill_8_1474 r0 *1 0,0
Xsky130_fd_sc_hd__fill_8_1474 VGND VPWR VPWR sky130_fd_sc_hd__fill_8
* cell instance sky130_fd_sc_hd__fill_8_1475 r0 *1 0,0
Xsky130_fd_sc_hd__fill_8_1475 VGND VPWR VPWR sky130_fd_sc_hd__fill_8
* cell instance sky130_fd_sc_hd__fill_8_1476 r0 *1 0,0
Xsky130_fd_sc_hd__fill_8_1476 VGND VPWR VPWR sky130_fd_sc_hd__fill_8
* cell instance sky130_fd_sc_hd__fill_8_1477 r0 *1 0,0
Xsky130_fd_sc_hd__fill_8_1477 VGND VPWR VPWR sky130_fd_sc_hd__fill_8
* cell instance sky130_fd_sc_hd__fill_8_1478 r0 *1 0,0
Xsky130_fd_sc_hd__fill_8_1478 VGND VPWR VPWR sky130_fd_sc_hd__fill_8
* cell instance sky130_fd_sc_hd__fill_8_1479 r0 *1 0,0
Xsky130_fd_sc_hd__fill_8_1479 VGND VPWR VPWR sky130_fd_sc_hd__fill_8
* cell instance sky130_fd_sc_hd__fill_8_1480 r0 *1 0,0
Xsky130_fd_sc_hd__fill_8_1480 VGND VPWR VPWR sky130_fd_sc_hd__fill_8
* cell instance sky130_fd_sc_hd__fill_8_1481 r0 *1 0,0
Xsky130_fd_sc_hd__fill_8_1481 VGND VPWR VPWR sky130_fd_sc_hd__fill_8
* cell instance sky130_fd_sc_hd__fill_8_1482 r0 *1 0,0
Xsky130_fd_sc_hd__fill_8_1482 VGND VPWR VPWR sky130_fd_sc_hd__fill_8
* cell instance sky130_fd_sc_hd__fill_8_1483 r0 *1 0,0
Xsky130_fd_sc_hd__fill_8_1483 VGND VPWR VPWR sky130_fd_sc_hd__fill_8
* cell instance sky130_fd_sc_hd__fill_8_1484 r0 *1 0,0
Xsky130_fd_sc_hd__fill_8_1484 VGND VPWR VPWR sky130_fd_sc_hd__fill_8
* cell instance sky130_fd_sc_hd__fill_8_1485 r0 *1 0,0
Xsky130_fd_sc_hd__fill_8_1485 VGND VPWR VPWR sky130_fd_sc_hd__fill_8
* cell instance sky130_fd_sc_hd__fill_8_1486 r0 *1 0,0
Xsky130_fd_sc_hd__fill_8_1486 VGND VPWR VPWR sky130_fd_sc_hd__fill_8
* cell instance sky130_fd_sc_hd__fill_8_1487 r0 *1 0,0
Xsky130_fd_sc_hd__fill_8_1487 VGND VPWR VPWR sky130_fd_sc_hd__fill_8
* cell instance sky130_fd_sc_hd__fill_8_1488 r0 *1 0,0
Xsky130_fd_sc_hd__fill_8_1488 VGND VPWR VPWR sky130_fd_sc_hd__fill_8
* cell instance sky130_fd_sc_hd__fill_8_1489 r0 *1 0,0
Xsky130_fd_sc_hd__fill_8_1489 VGND VPWR VPWR sky130_fd_sc_hd__fill_8
* cell instance sky130_fd_sc_hd__fill_8_1490 r0 *1 0,0
Xsky130_fd_sc_hd__fill_8_1490 VGND VPWR VPWR sky130_fd_sc_hd__fill_8
* cell instance sky130_fd_sc_hd__fill_8_1491 r0 *1 0,0
Xsky130_fd_sc_hd__fill_8_1491 VGND VPWR VPWR sky130_fd_sc_hd__fill_8
* cell instance sky130_fd_sc_hd__fill_8_1492 r0 *1 0,0
Xsky130_fd_sc_hd__fill_8_1492 VGND VPWR VPWR sky130_fd_sc_hd__fill_8
* cell instance sky130_fd_sc_hd__fill_8_1493 r0 *1 0,0
Xsky130_fd_sc_hd__fill_8_1493 VGND VPWR VPWR sky130_fd_sc_hd__fill_8
* cell instance sky130_fd_sc_hd__fill_8_1494 r0 *1 0,0
Xsky130_fd_sc_hd__fill_8_1494 VGND VPWR VPWR sky130_fd_sc_hd__fill_8
* cell instance sky130_fd_sc_hd__fill_8_1495 r0 *1 0,0
Xsky130_fd_sc_hd__fill_8_1495 VGND VPWR VPWR sky130_fd_sc_hd__fill_8
* cell instance sky130_fd_sc_hd__fill_8_1496 r0 *1 0,0
Xsky130_fd_sc_hd__fill_8_1496 VGND VPWR VPWR sky130_fd_sc_hd__fill_8
* cell instance sky130_fd_sc_hd__fill_8_1497 r0 *1 0,0
Xsky130_fd_sc_hd__fill_8_1497 VGND VPWR VPWR sky130_fd_sc_hd__fill_8
* cell instance sky130_fd_sc_hd__fill_8_1498 r0 *1 0,0
Xsky130_fd_sc_hd__fill_8_1498 VGND VPWR VPWR sky130_fd_sc_hd__fill_8
* cell instance sky130_fd_sc_hd__fill_8_1499 r0 *1 0,0
Xsky130_fd_sc_hd__fill_8_1499 VGND VPWR VPWR sky130_fd_sc_hd__fill_8
* cell instance sky130_fd_sc_hd__fill_8_1500 r0 *1 0,0
Xsky130_fd_sc_hd__fill_8_1500 VGND VPWR VPWR sky130_fd_sc_hd__fill_8
* cell instance sky130_fd_sc_hd__fill_8_1501 r0 *1 0,0
Xsky130_fd_sc_hd__fill_8_1501 VGND VPWR VPWR sky130_fd_sc_hd__fill_8
* cell instance sky130_fd_sc_hd__fill_8_1502 r0 *1 0,0
Xsky130_fd_sc_hd__fill_8_1502 VGND VPWR VPWR sky130_fd_sc_hd__fill_8
* cell instance sky130_fd_sc_hd__fill_8_1503 r0 *1 0,0
Xsky130_fd_sc_hd__fill_8_1503 VGND VPWR VPWR sky130_fd_sc_hd__fill_8
* cell instance sky130_fd_sc_hd__fill_8_1504 r0 *1 0,0
Xsky130_fd_sc_hd__fill_8_1504 VGND VPWR VPWR sky130_fd_sc_hd__fill_8
* cell instance sky130_fd_sc_hd__fill_8_1505 r0 *1 0,0
Xsky130_fd_sc_hd__fill_8_1505 VGND VPWR VPWR sky130_fd_sc_hd__fill_8
* cell instance sky130_fd_sc_hd__fill_8_1506 r0 *1 0,0
Xsky130_fd_sc_hd__fill_8_1506 VGND VPWR VPWR sky130_fd_sc_hd__fill_8
* cell instance sky130_fd_sc_hd__fill_8_1507 r0 *1 0,0
Xsky130_fd_sc_hd__fill_8_1507 VGND VPWR VPWR sky130_fd_sc_hd__fill_8
* cell instance sky130_fd_sc_hd__fill_8_1508 r0 *1 0,0
Xsky130_fd_sc_hd__fill_8_1508 VGND VPWR VPWR sky130_fd_sc_hd__fill_8
* cell instance sky130_fd_sc_hd__fill_8_1509 r0 *1 0,0
Xsky130_fd_sc_hd__fill_8_1509 VGND VPWR VPWR sky130_fd_sc_hd__fill_8
* cell instance sky130_fd_sc_hd__fill_8_1510 r0 *1 0,0
Xsky130_fd_sc_hd__fill_8_1510 VGND VPWR VPWR sky130_fd_sc_hd__fill_8
* cell instance sky130_fd_sc_hd__fill_8_1511 r0 *1 0,0
Xsky130_fd_sc_hd__fill_8_1511 VGND VPWR VPWR sky130_fd_sc_hd__fill_8
* cell instance sky130_fd_sc_hd__fill_8_1512 r0 *1 0,0
Xsky130_fd_sc_hd__fill_8_1512 VGND VPWR VPWR sky130_fd_sc_hd__fill_8
* cell instance sky130_fd_sc_hd__fill_8_1513 r0 *1 0,0
Xsky130_fd_sc_hd__fill_8_1513 VGND VPWR VPWR sky130_fd_sc_hd__fill_8
* cell instance sky130_fd_sc_hd__fill_8_1514 r0 *1 0,0
Xsky130_fd_sc_hd__fill_8_1514 VGND VPWR VPWR sky130_fd_sc_hd__fill_8
* cell instance sky130_fd_sc_hd__fill_8_1515 r0 *1 0,0
Xsky130_fd_sc_hd__fill_8_1515 VGND VPWR VPWR sky130_fd_sc_hd__fill_8
* cell instance sky130_fd_sc_hd__fill_8_1516 r0 *1 0,0
Xsky130_fd_sc_hd__fill_8_1516 VGND VPWR VPWR sky130_fd_sc_hd__fill_8
* cell instance sky130_fd_sc_hd__fill_8_1517 r0 *1 0,0
Xsky130_fd_sc_hd__fill_8_1517 VGND VPWR VPWR sky130_fd_sc_hd__fill_8
* cell instance sky130_fd_sc_hd__fill_8_1518 r0 *1 0,0
Xsky130_fd_sc_hd__fill_8_1518 VGND VPWR VPWR sky130_fd_sc_hd__fill_8
* cell instance sky130_fd_sc_hd__fill_8_1519 r0 *1 0,0
Xsky130_fd_sc_hd__fill_8_1519 VGND VPWR VPWR sky130_fd_sc_hd__fill_8
* cell instance sky130_fd_sc_hd__fill_8_1520 r0 *1 0,0
Xsky130_fd_sc_hd__fill_8_1520 VGND VPWR VPWR sky130_fd_sc_hd__fill_8
* cell instance sky130_fd_sc_hd__fill_8_1521 r0 *1 0,0
Xsky130_fd_sc_hd__fill_8_1521 VGND VPWR VPWR sky130_fd_sc_hd__fill_8
* cell instance sky130_fd_sc_hd__fill_8_1522 r0 *1 0,0
Xsky130_fd_sc_hd__fill_8_1522 VGND VPWR VPWR sky130_fd_sc_hd__fill_8
* cell instance sky130_fd_sc_hd__fill_8_1523 r0 *1 0,0
Xsky130_fd_sc_hd__fill_8_1523 VGND VPWR VPWR sky130_fd_sc_hd__fill_8
* cell instance sky130_fd_sc_hd__fill_8_1524 r0 *1 0,0
Xsky130_fd_sc_hd__fill_8_1524 VGND VPWR VPWR sky130_fd_sc_hd__fill_8
* cell instance sky130_fd_sc_hd__fill_8_1525 r0 *1 0,0
Xsky130_fd_sc_hd__fill_8_1525 VGND VPWR VPWR sky130_fd_sc_hd__fill_8
* cell instance sky130_fd_sc_hd__fill_8_1526 r0 *1 0,0
Xsky130_fd_sc_hd__fill_8_1526 VGND VPWR VPWR sky130_fd_sc_hd__fill_8
* cell instance sky130_fd_sc_hd__fill_8_1527 r0 *1 0,0
Xsky130_fd_sc_hd__fill_8_1527 VGND VPWR VPWR sky130_fd_sc_hd__fill_8
* cell instance sky130_fd_sc_hd__fill_8_1528 r0 *1 0,0
Xsky130_fd_sc_hd__fill_8_1528 VGND VPWR VPWR sky130_fd_sc_hd__fill_8
* cell instance sky130_fd_sc_hd__fill_8_1529 r0 *1 0,0
Xsky130_fd_sc_hd__fill_8_1529 VGND VPWR VPWR sky130_fd_sc_hd__fill_8
* cell instance sky130_fd_sc_hd__fill_8_1530 r0 *1 0,0
Xsky130_fd_sc_hd__fill_8_1530 VGND VPWR VPWR sky130_fd_sc_hd__fill_8
* cell instance sky130_fd_sc_hd__fill_8_1531 r0 *1 0,0
Xsky130_fd_sc_hd__fill_8_1531 VGND VPWR VPWR sky130_fd_sc_hd__fill_8
* cell instance sky130_fd_sc_hd__fill_8_1532 r0 *1 0,0
Xsky130_fd_sc_hd__fill_8_1532 VGND VPWR VPWR sky130_fd_sc_hd__fill_8
* cell instance sky130_fd_sc_hd__fill_8_1533 r0 *1 0,0
Xsky130_fd_sc_hd__fill_8_1533 VGND VPWR VPWR sky130_fd_sc_hd__fill_8
* cell instance sky130_fd_sc_hd__fill_8_1534 r0 *1 0,0
Xsky130_fd_sc_hd__fill_8_1534 VGND VPWR VPWR sky130_fd_sc_hd__fill_8
* cell instance sky130_fd_sc_hd__fill_8_1535 r0 *1 0,0
Xsky130_fd_sc_hd__fill_8_1535 VGND VPWR VPWR sky130_fd_sc_hd__fill_8
* cell instance sky130_fd_sc_hd__fill_8_1536 r0 *1 0,0
Xsky130_fd_sc_hd__fill_8_1536 VGND VPWR VPWR sky130_fd_sc_hd__fill_8
* cell instance sky130_fd_sc_hd__fill_8_1537 r0 *1 0,0
Xsky130_fd_sc_hd__fill_8_1537 VGND VPWR VPWR sky130_fd_sc_hd__fill_8
* cell instance sky130_fd_sc_hd__fill_8_1538 r0 *1 0,0
Xsky130_fd_sc_hd__fill_8_1538 VGND VPWR VPWR sky130_fd_sc_hd__fill_8
* cell instance sky130_fd_sc_hd__fill_8_1539 r0 *1 0,0
Xsky130_fd_sc_hd__fill_8_1539 VGND VPWR VPWR sky130_fd_sc_hd__fill_8
* cell instance sky130_fd_sc_hd__fill_8_1540 r0 *1 0,0
Xsky130_fd_sc_hd__fill_8_1540 VGND VPWR VPWR sky130_fd_sc_hd__fill_8
* cell instance sky130_fd_sc_hd__fill_8_1541 r0 *1 0,0
Xsky130_fd_sc_hd__fill_8_1541 VGND VPWR VPWR sky130_fd_sc_hd__fill_8
* cell instance sky130_fd_sc_hd__fill_8_1542 r0 *1 0,0
Xsky130_fd_sc_hd__fill_8_1542 VGND VPWR VPWR sky130_fd_sc_hd__fill_8
* cell instance sky130_fd_sc_hd__fill_8_1543 r0 *1 0,0
Xsky130_fd_sc_hd__fill_8_1543 VGND VPWR VPWR sky130_fd_sc_hd__fill_8
* cell instance sky130_fd_sc_hd__fill_8_1544 r0 *1 0,0
Xsky130_fd_sc_hd__fill_8_1544 VGND VPWR VPWR sky130_fd_sc_hd__fill_8
* cell instance sky130_fd_sc_hd__fill_8_1545 r0 *1 0,0
Xsky130_fd_sc_hd__fill_8_1545 VGND VPWR VPWR sky130_fd_sc_hd__fill_8
* cell instance sky130_fd_sc_hd__fill_8_1546 r0 *1 0,0
Xsky130_fd_sc_hd__fill_8_1546 VGND VPWR VPWR sky130_fd_sc_hd__fill_8
* cell instance sky130_fd_sc_hd__fill_8_1547 r0 *1 0,0
Xsky130_fd_sc_hd__fill_8_1547 VGND VPWR VPWR sky130_fd_sc_hd__fill_8
* cell instance sky130_fd_sc_hd__fill_8_1548 r0 *1 0,0
Xsky130_fd_sc_hd__fill_8_1548 VGND VPWR VPWR sky130_fd_sc_hd__fill_8
* cell instance sky130_fd_sc_hd__fill_8_1549 r0 *1 0,0
Xsky130_fd_sc_hd__fill_8_1549 VGND VPWR VPWR sky130_fd_sc_hd__fill_8
* cell instance sky130_fd_sc_hd__fill_8_1550 r0 *1 0,0
Xsky130_fd_sc_hd__fill_8_1550 VGND VPWR VPWR sky130_fd_sc_hd__fill_8
* cell instance sky130_fd_sc_hd__fill_8_1551 r0 *1 0,0
Xsky130_fd_sc_hd__fill_8_1551 VGND VPWR VPWR sky130_fd_sc_hd__fill_8
* cell instance sky130_fd_sc_hd__fill_8_1552 r0 *1 0,0
Xsky130_fd_sc_hd__fill_8_1552 VGND VPWR VPWR sky130_fd_sc_hd__fill_8
* cell instance sky130_fd_sc_hd__fill_8_1553 r0 *1 0,0
Xsky130_fd_sc_hd__fill_8_1553 VGND VPWR VPWR sky130_fd_sc_hd__fill_8
* cell instance sky130_fd_sc_hd__fill_8_1554 r0 *1 0,0
Xsky130_fd_sc_hd__fill_8_1554 VGND VPWR VPWR sky130_fd_sc_hd__fill_8
* cell instance sky130_fd_sc_hd__fill_8_1555 r0 *1 0,0
Xsky130_fd_sc_hd__fill_8_1555 VGND VPWR VPWR sky130_fd_sc_hd__fill_8
* cell instance sky130_fd_sc_hd__fill_8_1556 r0 *1 0,0
Xsky130_fd_sc_hd__fill_8_1556 VGND VPWR VPWR sky130_fd_sc_hd__fill_8
* cell instance sky130_fd_sc_hd__fill_8_1557 r0 *1 0,0
Xsky130_fd_sc_hd__fill_8_1557 VGND VPWR VPWR sky130_fd_sc_hd__fill_8
* cell instance sky130_fd_sc_hd__fill_8_1558 r0 *1 0,0
Xsky130_fd_sc_hd__fill_8_1558 VGND VPWR VPWR sky130_fd_sc_hd__fill_8
* cell instance sky130_fd_sc_hd__fill_8_1559 r0 *1 0,0
Xsky130_fd_sc_hd__fill_8_1559 VGND VPWR VPWR sky130_fd_sc_hd__fill_8
* cell instance sky130_fd_sc_hd__fill_8_1560 r0 *1 0,0
Xsky130_fd_sc_hd__fill_8_1560 VGND VPWR VPWR sky130_fd_sc_hd__fill_8
* cell instance sky130_fd_sc_hd__fill_8_1561 r0 *1 0,0
Xsky130_fd_sc_hd__fill_8_1561 VGND VPWR VPWR sky130_fd_sc_hd__fill_8
* cell instance sky130_fd_sc_hd__fill_8_1562 r0 *1 0,0
Xsky130_fd_sc_hd__fill_8_1562 VGND VPWR VPWR sky130_fd_sc_hd__fill_8
* cell instance sky130_fd_sc_hd__fill_8_1563 r0 *1 0,0
Xsky130_fd_sc_hd__fill_8_1563 VGND VPWR VPWR sky130_fd_sc_hd__fill_8
* cell instance sky130_fd_sc_hd__fill_8_1564 r0 *1 0,0
Xsky130_fd_sc_hd__fill_8_1564 VGND VPWR VPWR sky130_fd_sc_hd__fill_8
* cell instance sky130_fd_sc_hd__fill_8_1565 r0 *1 0,0
Xsky130_fd_sc_hd__fill_8_1565 VGND VPWR VPWR sky130_fd_sc_hd__fill_8
* cell instance sky130_fd_sc_hd__fill_8_1566 r0 *1 0,0
Xsky130_fd_sc_hd__fill_8_1566 VGND VPWR VPWR sky130_fd_sc_hd__fill_8
* cell instance sky130_fd_sc_hd__fill_8_1567 r0 *1 0,0
Xsky130_fd_sc_hd__fill_8_1567 VGND VPWR VPWR sky130_fd_sc_hd__fill_8
* cell instance sky130_fd_sc_hd__fill_8_1568 r0 *1 0,0
Xsky130_fd_sc_hd__fill_8_1568 VGND VPWR VPWR sky130_fd_sc_hd__fill_8
* cell instance sky130_fd_sc_hd__fill_8_1569 r0 *1 0,0
Xsky130_fd_sc_hd__fill_8_1569 VGND VPWR VPWR sky130_fd_sc_hd__fill_8
* cell instance sky130_fd_sc_hd__fill_8_1570 r0 *1 0,0
Xsky130_fd_sc_hd__fill_8_1570 VGND VPWR VPWR sky130_fd_sc_hd__fill_8
* cell instance sky130_fd_sc_hd__fill_8_1571 r0 *1 0,0
Xsky130_fd_sc_hd__fill_8_1571 VGND VPWR VPWR sky130_fd_sc_hd__fill_8
* cell instance sky130_fd_sc_hd__fill_8_1572 r0 *1 0,0
Xsky130_fd_sc_hd__fill_8_1572 VGND VPWR VPWR sky130_fd_sc_hd__fill_8
* cell instance sky130_fd_sc_hd__fill_8_1573 r0 *1 0,0
Xsky130_fd_sc_hd__fill_8_1573 VGND VPWR VPWR sky130_fd_sc_hd__fill_8
* cell instance sky130_fd_sc_hd__fill_8_1574 r0 *1 0,0
Xsky130_fd_sc_hd__fill_8_1574 VGND VPWR VPWR sky130_fd_sc_hd__fill_8
* cell instance sky130_fd_sc_hd__fill_8_1575 r0 *1 0,0
Xsky130_fd_sc_hd__fill_8_1575 VGND VPWR VPWR sky130_fd_sc_hd__fill_8
* cell instance sky130_fd_sc_hd__fill_8_1576 r0 *1 0,0
Xsky130_fd_sc_hd__fill_8_1576 VGND VPWR VPWR sky130_fd_sc_hd__fill_8
* cell instance sky130_fd_sc_hd__fill_8_1577 r0 *1 0,0
Xsky130_fd_sc_hd__fill_8_1577 VGND VPWR VPWR sky130_fd_sc_hd__fill_8
* cell instance sky130_fd_sc_hd__fill_8_1578 r0 *1 0,0
Xsky130_fd_sc_hd__fill_8_1578 VGND VPWR VPWR sky130_fd_sc_hd__fill_8
* cell instance sky130_fd_sc_hd__fill_8_1579 r0 *1 0,0
Xsky130_fd_sc_hd__fill_8_1579 VGND VPWR VPWR sky130_fd_sc_hd__fill_8
* cell instance sky130_fd_sc_hd__fill_8_1580 r0 *1 0,0
Xsky130_fd_sc_hd__fill_8_1580 VGND VPWR VPWR sky130_fd_sc_hd__fill_8
* cell instance sky130_fd_sc_hd__fill_8_1581 r0 *1 0,0
Xsky130_fd_sc_hd__fill_8_1581 VGND VPWR VPWR sky130_fd_sc_hd__fill_8
* cell instance sky130_fd_sc_hd__fill_8_1582 r0 *1 0,0
Xsky130_fd_sc_hd__fill_8_1582 VGND VPWR VPWR sky130_fd_sc_hd__fill_8
* cell instance sky130_fd_sc_hd__fill_8_1583 r0 *1 0,0
Xsky130_fd_sc_hd__fill_8_1583 VGND VPWR VPWR sky130_fd_sc_hd__fill_8
* cell instance sky130_fd_sc_hd__fill_8_1584 r0 *1 0,0
Xsky130_fd_sc_hd__fill_8_1584 VGND VPWR VPWR sky130_fd_sc_hd__fill_8
* cell instance sky130_fd_sc_hd__fill_8_1585 r0 *1 0,0
Xsky130_fd_sc_hd__fill_8_1585 VGND VPWR VPWR sky130_fd_sc_hd__fill_8
* cell instance sky130_fd_sc_hd__fill_8_1586 r0 *1 0,0
Xsky130_fd_sc_hd__fill_8_1586 VGND VPWR VPWR sky130_fd_sc_hd__fill_8
* cell instance sky130_fd_sc_hd__fill_8_1587 r0 *1 0,0
Xsky130_fd_sc_hd__fill_8_1587 VGND VPWR VPWR sky130_fd_sc_hd__fill_8
* cell instance sky130_fd_sc_hd__fill_8_1588 r0 *1 0,0
Xsky130_fd_sc_hd__fill_8_1588 VGND VPWR VPWR sky130_fd_sc_hd__fill_8
* cell instance sky130_fd_sc_hd__fill_8_1589 r0 *1 0,0
Xsky130_fd_sc_hd__fill_8_1589 VGND VPWR VPWR sky130_fd_sc_hd__fill_8
* cell instance sky130_fd_sc_hd__fill_8_1590 r0 *1 0,0
Xsky130_fd_sc_hd__fill_8_1590 VGND VPWR VPWR sky130_fd_sc_hd__fill_8
* cell instance sky130_fd_sc_hd__fill_8_1591 r0 *1 0,0
Xsky130_fd_sc_hd__fill_8_1591 VGND VPWR VPWR sky130_fd_sc_hd__fill_8
* cell instance sky130_fd_sc_hd__fill_8_1592 r0 *1 0,0
Xsky130_fd_sc_hd__fill_8_1592 VGND VPWR VPWR sky130_fd_sc_hd__fill_8
* cell instance sky130_fd_sc_hd__fill_8_1593 r0 *1 0,0
Xsky130_fd_sc_hd__fill_8_1593 VGND VPWR VPWR sky130_fd_sc_hd__fill_8
* cell instance sky130_fd_sc_hd__fill_8_1594 r0 *1 0,0
Xsky130_fd_sc_hd__fill_8_1594 VGND VPWR VPWR sky130_fd_sc_hd__fill_8
* cell instance sky130_fd_sc_hd__fill_8_1595 r0 *1 0,0
Xsky130_fd_sc_hd__fill_8_1595 VGND VPWR VPWR sky130_fd_sc_hd__fill_8
* cell instance sky130_fd_sc_hd__fill_8_1596 r0 *1 0,0
Xsky130_fd_sc_hd__fill_8_1596 VGND VPWR VPWR sky130_fd_sc_hd__fill_8
* cell instance sky130_fd_sc_hd__fill_8_1597 r0 *1 0,0
Xsky130_fd_sc_hd__fill_8_1597 VGND VPWR VPWR sky130_fd_sc_hd__fill_8
* cell instance sky130_fd_sc_hd__fill_8_1598 r0 *1 0,0
Xsky130_fd_sc_hd__fill_8_1598 VGND VPWR VPWR sky130_fd_sc_hd__fill_8
* cell instance sky130_fd_sc_hd__fill_8_1599 r0 *1 0,0
Xsky130_fd_sc_hd__fill_8_1599 VGND VPWR VPWR sky130_fd_sc_hd__fill_8
* cell instance sky130_fd_sc_hd__fill_8_1600 r0 *1 0,0
Xsky130_fd_sc_hd__fill_8_1600 VGND VPWR VPWR sky130_fd_sc_hd__fill_8
* cell instance sky130_fd_sc_hd__fill_8_1601 r0 *1 0,0
Xsky130_fd_sc_hd__fill_8_1601 VGND VPWR VPWR sky130_fd_sc_hd__fill_8
* cell instance sky130_fd_sc_hd__fill_8_1602 r0 *1 0,0
Xsky130_fd_sc_hd__fill_8_1602 VGND VPWR VPWR sky130_fd_sc_hd__fill_8
* cell instance sky130_fd_sc_hd__fill_8_1603 r0 *1 0,0
Xsky130_fd_sc_hd__fill_8_1603 VGND VPWR VPWR sky130_fd_sc_hd__fill_8
* cell instance sky130_fd_sc_hd__fill_8_1604 r0 *1 0,0
Xsky130_fd_sc_hd__fill_8_1604 VGND VPWR VPWR sky130_fd_sc_hd__fill_8
* cell instance sky130_fd_sc_hd__fill_8_1605 r0 *1 0,0
Xsky130_fd_sc_hd__fill_8_1605 VGND VPWR VPWR sky130_fd_sc_hd__fill_8
* cell instance sky130_fd_sc_hd__fill_8_1606 r0 *1 0,0
Xsky130_fd_sc_hd__fill_8_1606 VGND VPWR VPWR sky130_fd_sc_hd__fill_8
* cell instance sky130_fd_sc_hd__fill_8_1607 r0 *1 0,0
Xsky130_fd_sc_hd__fill_8_1607 VGND VPWR VPWR sky130_fd_sc_hd__fill_8
* cell instance sky130_fd_sc_hd__fill_8_1608 r0 *1 0,0
Xsky130_fd_sc_hd__fill_8_1608 VGND VPWR VPWR sky130_fd_sc_hd__fill_8
* cell instance sky130_fd_sc_hd__fill_8_1609 r0 *1 0,0
Xsky130_fd_sc_hd__fill_8_1609 VGND VPWR VPWR sky130_fd_sc_hd__fill_8
* cell instance sky130_fd_sc_hd__fill_8_1610 r0 *1 0,0
Xsky130_fd_sc_hd__fill_8_1610 VGND VPWR VPWR sky130_fd_sc_hd__fill_8
* cell instance sky130_fd_sc_hd__fill_8_1611 r0 *1 0,0
Xsky130_fd_sc_hd__fill_8_1611 VGND VPWR VPWR sky130_fd_sc_hd__fill_8
* cell instance sky130_fd_sc_hd__fill_8_1612 r0 *1 0,0
Xsky130_fd_sc_hd__fill_8_1612 VGND VPWR VPWR sky130_fd_sc_hd__fill_8
* cell instance sky130_fd_sc_hd__fill_8_1613 r0 *1 0,0
Xsky130_fd_sc_hd__fill_8_1613 VGND VPWR VPWR sky130_fd_sc_hd__fill_8
* cell instance sky130_fd_sc_hd__fill_8_1614 r0 *1 0,0
Xsky130_fd_sc_hd__fill_8_1614 VGND VPWR VPWR sky130_fd_sc_hd__fill_8
* cell instance sky130_fd_sc_hd__fill_8_1615 r0 *1 0,0
Xsky130_fd_sc_hd__fill_8_1615 VGND VPWR VPWR sky130_fd_sc_hd__fill_8
* cell instance sky130_fd_sc_hd__fill_8_1616 r0 *1 0,0
Xsky130_fd_sc_hd__fill_8_1616 VGND VPWR VPWR sky130_fd_sc_hd__fill_8
* cell instance sky130_fd_sc_hd__fill_8_1617 r0 *1 0,0
Xsky130_fd_sc_hd__fill_8_1617 VGND VPWR VPWR sky130_fd_sc_hd__fill_8
* cell instance sky130_fd_sc_hd__fill_8_1618 r0 *1 0,0
Xsky130_fd_sc_hd__fill_8_1618 VGND VPWR VPWR sky130_fd_sc_hd__fill_8
* cell instance sky130_fd_sc_hd__fill_8_1619 r0 *1 0,0
Xsky130_fd_sc_hd__fill_8_1619 VGND VPWR VPWR sky130_fd_sc_hd__fill_8
* cell instance sky130_fd_sc_hd__fill_8_1620 r0 *1 0,0
Xsky130_fd_sc_hd__fill_8_1620 VGND VPWR VPWR sky130_fd_sc_hd__fill_8
* cell instance sky130_fd_sc_hd__fill_8_1621 r0 *1 0,0
Xsky130_fd_sc_hd__fill_8_1621 VGND VPWR VPWR sky130_fd_sc_hd__fill_8
* cell instance sky130_fd_sc_hd__fill_8_1622 r0 *1 0,0
Xsky130_fd_sc_hd__fill_8_1622 VGND VPWR VPWR sky130_fd_sc_hd__fill_8
* cell instance sky130_fd_sc_hd__fill_8_1623 r0 *1 0,0
Xsky130_fd_sc_hd__fill_8_1623 VGND VPWR VPWR sky130_fd_sc_hd__fill_8
* cell instance sky130_fd_sc_hd__fill_8_1624 r0 *1 0,0
Xsky130_fd_sc_hd__fill_8_1624 VGND VPWR VPWR sky130_fd_sc_hd__fill_8
* cell instance sky130_fd_sc_hd__fill_8_1625 r0 *1 0,0
Xsky130_fd_sc_hd__fill_8_1625 VGND VPWR VPWR sky130_fd_sc_hd__fill_8
* cell instance sky130_fd_sc_hd__fill_8_1626 r0 *1 0,0
Xsky130_fd_sc_hd__fill_8_1626 VGND VPWR VPWR sky130_fd_sc_hd__fill_8
* cell instance sky130_fd_sc_hd__fill_8_1627 r0 *1 0,0
Xsky130_fd_sc_hd__fill_8_1627 VGND VPWR VPWR sky130_fd_sc_hd__fill_8
* cell instance sky130_fd_sc_hd__fill_8_1628 r0 *1 0,0
Xsky130_fd_sc_hd__fill_8_1628 VGND VPWR VPWR sky130_fd_sc_hd__fill_8
* cell instance sky130_fd_sc_hd__fill_8_1629 r0 *1 0,0
Xsky130_fd_sc_hd__fill_8_1629 VGND VPWR VPWR sky130_fd_sc_hd__fill_8
* cell instance sky130_fd_sc_hd__fill_8_1630 r0 *1 0,0
Xsky130_fd_sc_hd__fill_8_1630 VGND VPWR VPWR sky130_fd_sc_hd__fill_8
* cell instance sky130_fd_sc_hd__fill_8_1631 r0 *1 0,0
Xsky130_fd_sc_hd__fill_8_1631 VGND VPWR VPWR sky130_fd_sc_hd__fill_8
* cell instance sky130_fd_sc_hd__fill_8_1632 r0 *1 0,0
Xsky130_fd_sc_hd__fill_8_1632 VGND VPWR VPWR sky130_fd_sc_hd__fill_8
* cell instance sky130_fd_sc_hd__fill_8_1633 r0 *1 0,0
Xsky130_fd_sc_hd__fill_8_1633 VGND VPWR VPWR sky130_fd_sc_hd__fill_8
* cell instance sky130_fd_sc_hd__fill_8_1634 r0 *1 0,0
Xsky130_fd_sc_hd__fill_8_1634 VGND VPWR VPWR sky130_fd_sc_hd__fill_8
* cell instance sky130_fd_sc_hd__fill_8_1635 r0 *1 0,0
Xsky130_fd_sc_hd__fill_8_1635 VGND VPWR VPWR sky130_fd_sc_hd__fill_8
* cell instance sky130_fd_sc_hd__fill_8_1636 r0 *1 0,0
Xsky130_fd_sc_hd__fill_8_1636 VGND VPWR VPWR sky130_fd_sc_hd__fill_8
* cell instance sky130_fd_sc_hd__fill_8_1637 r0 *1 0,0
Xsky130_fd_sc_hd__fill_8_1637 VGND VPWR VPWR sky130_fd_sc_hd__fill_8
* cell instance sky130_fd_sc_hd__fill_8_1638 r0 *1 0,0
Xsky130_fd_sc_hd__fill_8_1638 VGND VPWR VPWR sky130_fd_sc_hd__fill_8
* cell instance sky130_fd_sc_hd__fill_8_1639 r0 *1 0,0
Xsky130_fd_sc_hd__fill_8_1639 VGND VPWR VPWR sky130_fd_sc_hd__fill_8
* cell instance sky130_fd_sc_hd__fill_8_1640 r0 *1 0,0
Xsky130_fd_sc_hd__fill_8_1640 VGND VPWR VPWR sky130_fd_sc_hd__fill_8
* cell instance sky130_fd_sc_hd__fill_8_1641 r0 *1 0,0
Xsky130_fd_sc_hd__fill_8_1641 VGND VPWR VPWR sky130_fd_sc_hd__fill_8
* cell instance sky130_fd_sc_hd__fill_8_1642 r0 *1 0,0
Xsky130_fd_sc_hd__fill_8_1642 VGND VPWR VPWR sky130_fd_sc_hd__fill_8
* cell instance sky130_fd_sc_hd__fill_8_1643 r0 *1 0,0
Xsky130_fd_sc_hd__fill_8_1643 VGND VPWR VPWR sky130_fd_sc_hd__fill_8
* cell instance sky130_fd_sc_hd__fill_8_1644 r0 *1 0,0
Xsky130_fd_sc_hd__fill_8_1644 VGND VPWR VPWR sky130_fd_sc_hd__fill_8
* cell instance sky130_fd_sc_hd__fill_8_1645 r0 *1 0,0
Xsky130_fd_sc_hd__fill_8_1645 VGND VPWR VPWR sky130_fd_sc_hd__fill_8
* cell instance sky130_fd_sc_hd__fill_8_1646 r0 *1 0,0
Xsky130_fd_sc_hd__fill_8_1646 VGND VPWR VPWR sky130_fd_sc_hd__fill_8
* cell instance sky130_fd_sc_hd__fill_8_1647 r0 *1 0,0
Xsky130_fd_sc_hd__fill_8_1647 VGND VPWR VPWR sky130_fd_sc_hd__fill_8
* cell instance sky130_fd_sc_hd__fill_8_1648 r0 *1 0,0
Xsky130_fd_sc_hd__fill_8_1648 VGND VPWR VPWR sky130_fd_sc_hd__fill_8
* cell instance sky130_fd_sc_hd__fill_8_1649 r0 *1 0,0
Xsky130_fd_sc_hd__fill_8_1649 VGND VPWR VPWR sky130_fd_sc_hd__fill_8
* cell instance sky130_fd_sc_hd__fill_8_1650 r0 *1 0,0
Xsky130_fd_sc_hd__fill_8_1650 VGND VPWR VPWR sky130_fd_sc_hd__fill_8
* cell instance sky130_fd_sc_hd__fill_8_1651 r0 *1 0,0
Xsky130_fd_sc_hd__fill_8_1651 VGND VPWR VPWR sky130_fd_sc_hd__fill_8
* cell instance sky130_fd_sc_hd__fill_8_1652 r0 *1 0,0
Xsky130_fd_sc_hd__fill_8_1652 VGND VPWR VPWR sky130_fd_sc_hd__fill_8
* cell instance sky130_fd_sc_hd__fill_8_1653 r0 *1 0,0
Xsky130_fd_sc_hd__fill_8_1653 VGND VPWR VPWR sky130_fd_sc_hd__fill_8
* cell instance sky130_fd_sc_hd__fill_8_1654 r0 *1 0,0
Xsky130_fd_sc_hd__fill_8_1654 VGND VPWR VPWR sky130_fd_sc_hd__fill_8
* cell instance sky130_fd_sc_hd__fill_8_1655 r0 *1 0,0
Xsky130_fd_sc_hd__fill_8_1655 VGND VPWR VPWR sky130_fd_sc_hd__fill_8
* cell instance sky130_fd_sc_hd__fill_8_1656 r0 *1 0,0
Xsky130_fd_sc_hd__fill_8_1656 VGND VPWR VPWR sky130_fd_sc_hd__fill_8
* cell instance sky130_fd_sc_hd__fill_8_1657 r0 *1 0,0
Xsky130_fd_sc_hd__fill_8_1657 VGND VPWR VPWR sky130_fd_sc_hd__fill_8
* cell instance sky130_fd_sc_hd__fill_8_1658 r0 *1 0,0
Xsky130_fd_sc_hd__fill_8_1658 VGND VPWR VPWR sky130_fd_sc_hd__fill_8
* cell instance sky130_fd_sc_hd__fill_8_1659 r0 *1 0,0
Xsky130_fd_sc_hd__fill_8_1659 VGND VPWR VPWR sky130_fd_sc_hd__fill_8
* cell instance sky130_fd_sc_hd__fill_8_1660 r0 *1 0,0
Xsky130_fd_sc_hd__fill_8_1660 VGND VPWR VPWR sky130_fd_sc_hd__fill_8
* cell instance sky130_fd_sc_hd__fill_8_1661 r0 *1 0,0
Xsky130_fd_sc_hd__fill_8_1661 VGND VPWR VPWR sky130_fd_sc_hd__fill_8
* cell instance sky130_fd_sc_hd__fill_8_1662 r0 *1 0,0
Xsky130_fd_sc_hd__fill_8_1662 VGND VPWR VPWR sky130_fd_sc_hd__fill_8
* cell instance sky130_fd_sc_hd__fill_8_1663 r0 *1 0,0
Xsky130_fd_sc_hd__fill_8_1663 VGND VPWR VPWR sky130_fd_sc_hd__fill_8
* cell instance sky130_fd_sc_hd__fill_8_1664 r0 *1 0,0
Xsky130_fd_sc_hd__fill_8_1664 VGND VPWR VPWR sky130_fd_sc_hd__fill_8
* cell instance sky130_fd_sc_hd__fill_8_1665 r0 *1 0,0
Xsky130_fd_sc_hd__fill_8_1665 VGND VPWR VPWR sky130_fd_sc_hd__fill_8
* cell instance sky130_fd_sc_hd__fill_8_1666 r0 *1 0,0
Xsky130_fd_sc_hd__fill_8_1666 VGND VPWR VPWR sky130_fd_sc_hd__fill_8
* cell instance sky130_fd_sc_hd__fill_8_1667 r0 *1 0,0
Xsky130_fd_sc_hd__fill_8_1667 VGND VPWR VPWR sky130_fd_sc_hd__fill_8
* cell instance sky130_fd_sc_hd__fill_8_1668 r0 *1 0,0
Xsky130_fd_sc_hd__fill_8_1668 VGND VPWR VPWR sky130_fd_sc_hd__fill_8
* cell instance sky130_fd_sc_hd__fill_8_1669 r0 *1 0,0
Xsky130_fd_sc_hd__fill_8_1669 VGND VPWR VPWR sky130_fd_sc_hd__fill_8
* cell instance sky130_fd_sc_hd__fill_8_1670 r0 *1 0,0
Xsky130_fd_sc_hd__fill_8_1670 VGND VPWR VPWR sky130_fd_sc_hd__fill_8
* cell instance sky130_fd_sc_hd__fill_8_1671 r0 *1 0,0
Xsky130_fd_sc_hd__fill_8_1671 VGND VPWR VPWR sky130_fd_sc_hd__fill_8
* cell instance sky130_fd_sc_hd__fill_8_1672 r0 *1 0,0
Xsky130_fd_sc_hd__fill_8_1672 VGND VPWR VPWR sky130_fd_sc_hd__fill_8
* cell instance sky130_fd_sc_hd__fill_8_1673 r0 *1 0,0
Xsky130_fd_sc_hd__fill_8_1673 VGND VPWR VPWR sky130_fd_sc_hd__fill_8
* cell instance sky130_fd_sc_hd__fill_8_1674 r0 *1 0,0
Xsky130_fd_sc_hd__fill_8_1674 VGND VPWR VPWR sky130_fd_sc_hd__fill_8
* cell instance sky130_fd_sc_hd__fill_8_1675 r0 *1 0,0
Xsky130_fd_sc_hd__fill_8_1675 VGND VPWR VPWR sky130_fd_sc_hd__fill_8
* cell instance sky130_fd_sc_hd__fill_8_1676 r0 *1 0,0
Xsky130_fd_sc_hd__fill_8_1676 VGND VPWR VPWR sky130_fd_sc_hd__fill_8
* cell instance sky130_fd_sc_hd__fill_8_1677 r0 *1 0,0
Xsky130_fd_sc_hd__fill_8_1677 VGND VPWR VPWR sky130_fd_sc_hd__fill_8
* cell instance sky130_fd_sc_hd__fill_8_1678 r0 *1 0,0
Xsky130_fd_sc_hd__fill_8_1678 VGND VPWR VPWR sky130_fd_sc_hd__fill_8
* cell instance sky130_fd_sc_hd__fill_8_1679 r0 *1 0,0
Xsky130_fd_sc_hd__fill_8_1679 VGND VPWR VPWR sky130_fd_sc_hd__fill_8
* cell instance sky130_fd_sc_hd__fill_8_1680 r0 *1 0,0
Xsky130_fd_sc_hd__fill_8_1680 VGND VPWR VPWR sky130_fd_sc_hd__fill_8
* cell instance sky130_fd_sc_hd__fill_8_1681 r0 *1 0,0
Xsky130_fd_sc_hd__fill_8_1681 VGND VPWR VPWR sky130_fd_sc_hd__fill_8
* cell instance sky130_fd_sc_hd__fill_8_1682 r0 *1 0,0
Xsky130_fd_sc_hd__fill_8_1682 VGND VPWR VPWR sky130_fd_sc_hd__fill_8
* cell instance sky130_fd_sc_hd__fill_8_1683 r0 *1 0,0
Xsky130_fd_sc_hd__fill_8_1683 VGND VPWR VPWR sky130_fd_sc_hd__fill_8
* cell instance sky130_fd_sc_hd__fill_8_1684 r0 *1 0,0
Xsky130_fd_sc_hd__fill_8_1684 VGND VPWR VPWR sky130_fd_sc_hd__fill_8
* cell instance sky130_fd_sc_hd__fill_8_1685 r0 *1 0,0
Xsky130_fd_sc_hd__fill_8_1685 VGND VPWR VPWR sky130_fd_sc_hd__fill_8
* cell instance sky130_fd_sc_hd__fill_8_1686 r0 *1 0,0
Xsky130_fd_sc_hd__fill_8_1686 VGND VPWR VPWR sky130_fd_sc_hd__fill_8
* cell instance sky130_fd_sc_hd__fill_8_1687 r0 *1 0,0
Xsky130_fd_sc_hd__fill_8_1687 VGND VPWR VPWR sky130_fd_sc_hd__fill_8
* cell instance sky130_fd_sc_hd__fill_8_1688 r0 *1 0,0
Xsky130_fd_sc_hd__fill_8_1688 VGND VPWR VPWR sky130_fd_sc_hd__fill_8
* cell instance sky130_fd_sc_hd__fill_8_1689 r0 *1 0,0
Xsky130_fd_sc_hd__fill_8_1689 VGND VPWR VPWR sky130_fd_sc_hd__fill_8
* cell instance sky130_fd_sc_hd__fill_8_1690 r0 *1 0,0
Xsky130_fd_sc_hd__fill_8_1690 VGND VPWR VPWR sky130_fd_sc_hd__fill_8
* cell instance sky130_fd_sc_hd__fill_8_1691 r0 *1 0,0
Xsky130_fd_sc_hd__fill_8_1691 VGND VPWR VPWR sky130_fd_sc_hd__fill_8
* cell instance sky130_fd_sc_hd__fill_8_1692 r0 *1 0,0
Xsky130_fd_sc_hd__fill_8_1692 VGND VPWR VPWR sky130_fd_sc_hd__fill_8
* cell instance sky130_fd_sc_hd__fill_8_1693 r0 *1 0,0
Xsky130_fd_sc_hd__fill_8_1693 VGND VPWR VPWR sky130_fd_sc_hd__fill_8
* cell instance sky130_fd_sc_hd__fill_8_1694 r0 *1 0,0
Xsky130_fd_sc_hd__fill_8_1694 VGND VPWR VPWR sky130_fd_sc_hd__fill_8
* cell instance sky130_fd_sc_hd__fill_8_1695 r0 *1 0,0
Xsky130_fd_sc_hd__fill_8_1695 VGND VPWR VPWR sky130_fd_sc_hd__fill_8
* cell instance sky130_fd_sc_hd__fill_8_1696 r0 *1 0,0
Xsky130_fd_sc_hd__fill_8_1696 VGND VPWR VPWR sky130_fd_sc_hd__fill_8
* cell instance sky130_fd_sc_hd__fill_8_1697 r0 *1 0,0
Xsky130_fd_sc_hd__fill_8_1697 VGND VPWR VPWR sky130_fd_sc_hd__fill_8
* cell instance sky130_fd_sc_hd__fill_8_1698 r0 *1 0,0
Xsky130_fd_sc_hd__fill_8_1698 VGND VPWR VPWR sky130_fd_sc_hd__fill_8
* cell instance sky130_fd_sc_hd__fill_8_1699 r0 *1 0,0
Xsky130_fd_sc_hd__fill_8_1699 VGND VPWR VPWR sky130_fd_sc_hd__fill_8
* cell instance sky130_fd_sc_hd__fill_8_1700 r0 *1 0,0
Xsky130_fd_sc_hd__fill_8_1700 VGND VPWR VPWR sky130_fd_sc_hd__fill_8
* cell instance sky130_fd_sc_hd__fill_8_1701 r0 *1 0,0
Xsky130_fd_sc_hd__fill_8_1701 VGND VPWR VPWR sky130_fd_sc_hd__fill_8
* cell instance sky130_fd_sc_hd__fill_8_1702 r0 *1 0,0
Xsky130_fd_sc_hd__fill_8_1702 VGND VPWR VPWR sky130_fd_sc_hd__fill_8
* cell instance sky130_fd_sc_hd__fill_8_1703 r0 *1 0,0
Xsky130_fd_sc_hd__fill_8_1703 VGND VPWR VPWR sky130_fd_sc_hd__fill_8
* cell instance sky130_fd_sc_hd__fill_8_1704 r0 *1 0,0
Xsky130_fd_sc_hd__fill_8_1704 VGND VPWR VPWR sky130_fd_sc_hd__fill_8
* cell instance sky130_fd_sc_hd__fill_8_1705 r0 *1 0,0
Xsky130_fd_sc_hd__fill_8_1705 VGND VPWR VPWR sky130_fd_sc_hd__fill_8
* cell instance sky130_fd_sc_hd__fill_8_1706 r0 *1 0,0
Xsky130_fd_sc_hd__fill_8_1706 VGND VPWR VPWR sky130_fd_sc_hd__fill_8
* cell instance sky130_fd_sc_hd__fill_8_1707 r0 *1 0,0
Xsky130_fd_sc_hd__fill_8_1707 VGND VPWR VPWR sky130_fd_sc_hd__fill_8
* cell instance sky130_fd_sc_hd__fill_8_1708 r0 *1 0,0
Xsky130_fd_sc_hd__fill_8_1708 VGND VPWR VPWR sky130_fd_sc_hd__fill_8
* cell instance sky130_fd_sc_hd__fill_8_1709 r0 *1 0,0
Xsky130_fd_sc_hd__fill_8_1709 VGND VPWR VPWR sky130_fd_sc_hd__fill_8
* cell instance sky130_fd_sc_hd__fill_8_1710 r0 *1 0,0
Xsky130_fd_sc_hd__fill_8_1710 VGND VPWR VPWR sky130_fd_sc_hd__fill_8
* cell instance sky130_fd_sc_hd__fill_8_1711 r0 *1 0,0
Xsky130_fd_sc_hd__fill_8_1711 VGND VPWR VPWR sky130_fd_sc_hd__fill_8
* cell instance sky130_fd_sc_hd__fill_8_1712 r0 *1 0,0
Xsky130_fd_sc_hd__fill_8_1712 VGND VPWR VPWR sky130_fd_sc_hd__fill_8
* cell instance sky130_fd_sc_hd__fill_8_1713 r0 *1 0,0
Xsky130_fd_sc_hd__fill_8_1713 VGND VPWR VPWR sky130_fd_sc_hd__fill_8
* cell instance sky130_fd_sc_hd__fill_8_1714 r0 *1 0,0
Xsky130_fd_sc_hd__fill_8_1714 VGND VPWR VPWR sky130_fd_sc_hd__fill_8
* cell instance sky130_fd_sc_hd__fill_8_1715 r0 *1 0,0
Xsky130_fd_sc_hd__fill_8_1715 VGND VPWR VPWR sky130_fd_sc_hd__fill_8
* cell instance sky130_fd_sc_hd__fill_8_1716 r0 *1 0,0
Xsky130_fd_sc_hd__fill_8_1716 VGND VPWR VPWR sky130_fd_sc_hd__fill_8
* cell instance sky130_fd_sc_hd__fill_8_1717 r0 *1 0,0
Xsky130_fd_sc_hd__fill_8_1717 VGND VPWR VPWR sky130_fd_sc_hd__fill_8
* cell instance sky130_fd_sc_hd__fill_8_1718 r0 *1 0,0
Xsky130_fd_sc_hd__fill_8_1718 VGND VPWR VPWR sky130_fd_sc_hd__fill_8
* cell instance sky130_fd_sc_hd__fill_8_1719 r0 *1 0,0
Xsky130_fd_sc_hd__fill_8_1719 VGND VPWR VPWR sky130_fd_sc_hd__fill_8
* cell instance sky130_fd_sc_hd__fill_8_1720 r0 *1 0,0
Xsky130_fd_sc_hd__fill_8_1720 VGND VPWR VPWR sky130_fd_sc_hd__fill_8
* cell instance sky130_fd_sc_hd__fill_8_1721 r0 *1 0,0
Xsky130_fd_sc_hd__fill_8_1721 VGND VPWR VPWR sky130_fd_sc_hd__fill_8
* cell instance sky130_fd_sc_hd__fill_8_1722 r0 *1 0,0
Xsky130_fd_sc_hd__fill_8_1722 VGND VPWR VPWR sky130_fd_sc_hd__fill_8
* cell instance sky130_fd_sc_hd__fill_8_1723 r0 *1 0,0
Xsky130_fd_sc_hd__fill_8_1723 VGND VPWR VPWR sky130_fd_sc_hd__fill_8
* cell instance sky130_fd_sc_hd__fill_8_1724 r0 *1 0,0
Xsky130_fd_sc_hd__fill_8_1724 VGND VPWR VPWR sky130_fd_sc_hd__fill_8
* cell instance sky130_fd_sc_hd__fill_8_1725 r0 *1 0,0
Xsky130_fd_sc_hd__fill_8_1725 VGND VPWR VPWR sky130_fd_sc_hd__fill_8
* cell instance sky130_fd_sc_hd__fill_8_1726 r0 *1 0,0
Xsky130_fd_sc_hd__fill_8_1726 VGND VPWR VPWR sky130_fd_sc_hd__fill_8
* cell instance sky130_fd_sc_hd__fill_8_1727 r0 *1 0,0
Xsky130_fd_sc_hd__fill_8_1727 VGND VPWR VPWR sky130_fd_sc_hd__fill_8
* cell instance sky130_fd_sc_hd__fill_8_1728 r0 *1 0,0
Xsky130_fd_sc_hd__fill_8_1728 VGND VPWR VPWR sky130_fd_sc_hd__fill_8
* cell instance sky130_fd_sc_hd__fill_8_1729 r0 *1 0,0
Xsky130_fd_sc_hd__fill_8_1729 VGND VPWR VPWR sky130_fd_sc_hd__fill_8
* cell instance sky130_fd_sc_hd__fill_8_1730 r0 *1 0,0
Xsky130_fd_sc_hd__fill_8_1730 VGND VPWR VPWR sky130_fd_sc_hd__fill_8
* cell instance sky130_fd_sc_hd__fill_8_1731 r0 *1 0,0
Xsky130_fd_sc_hd__fill_8_1731 VGND VPWR VPWR sky130_fd_sc_hd__fill_8
* cell instance sky130_fd_sc_hd__fill_8_1732 r0 *1 0,0
Xsky130_fd_sc_hd__fill_8_1732 VGND VPWR VPWR sky130_fd_sc_hd__fill_8
* cell instance sky130_fd_sc_hd__fill_8_1733 r0 *1 0,0
Xsky130_fd_sc_hd__fill_8_1733 VGND VPWR VPWR sky130_fd_sc_hd__fill_8
* cell instance sky130_fd_sc_hd__fill_8_1734 r0 *1 0,0
Xsky130_fd_sc_hd__fill_8_1734 VGND VPWR VPWR sky130_fd_sc_hd__fill_8
* cell instance sky130_fd_sc_hd__fill_8_1735 r0 *1 0,0
Xsky130_fd_sc_hd__fill_8_1735 VGND VPWR VPWR sky130_fd_sc_hd__fill_8
* cell instance sky130_fd_sc_hd__fill_8_1736 r0 *1 0,0
Xsky130_fd_sc_hd__fill_8_1736 VGND VPWR VPWR sky130_fd_sc_hd__fill_8
* cell instance sky130_fd_sc_hd__fill_8_1737 r0 *1 0,0
Xsky130_fd_sc_hd__fill_8_1737 VGND VPWR VPWR sky130_fd_sc_hd__fill_8
* cell instance sky130_fd_sc_hd__fill_8_1738 r0 *1 0,0
Xsky130_fd_sc_hd__fill_8_1738 VGND VPWR VPWR sky130_fd_sc_hd__fill_8
* cell instance sky130_fd_sc_hd__fill_8_1739 r0 *1 0,0
Xsky130_fd_sc_hd__fill_8_1739 VGND VPWR VPWR sky130_fd_sc_hd__fill_8
* cell instance sky130_fd_sc_hd__fill_8_1740 r0 *1 0,0
Xsky130_fd_sc_hd__fill_8_1740 VGND VPWR VPWR sky130_fd_sc_hd__fill_8
* cell instance sky130_fd_sc_hd__fill_8_1741 r0 *1 0,0
Xsky130_fd_sc_hd__fill_8_1741 VGND VPWR VPWR sky130_fd_sc_hd__fill_8
* cell instance sky130_fd_sc_hd__fill_8_1742 r0 *1 0,0
Xsky130_fd_sc_hd__fill_8_1742 VGND VPWR VPWR sky130_fd_sc_hd__fill_8
* cell instance sky130_fd_sc_hd__fill_8_1743 r0 *1 0,0
Xsky130_fd_sc_hd__fill_8_1743 VGND VPWR VPWR sky130_fd_sc_hd__fill_8
* cell instance sky130_fd_sc_hd__fill_8_1744 r0 *1 0,0
Xsky130_fd_sc_hd__fill_8_1744 VGND VPWR VPWR sky130_fd_sc_hd__fill_8
* cell instance sky130_fd_sc_hd__fill_8_1745 r0 *1 0,0
Xsky130_fd_sc_hd__fill_8_1745 VGND VPWR VPWR sky130_fd_sc_hd__fill_8
* cell instance sky130_fd_sc_hd__fill_8_1746 r0 *1 0,0
Xsky130_fd_sc_hd__fill_8_1746 VGND VPWR VPWR sky130_fd_sc_hd__fill_8
* cell instance sky130_fd_sc_hd__fill_8_1747 r0 *1 0,0
Xsky130_fd_sc_hd__fill_8_1747 VGND VPWR VPWR sky130_fd_sc_hd__fill_8
* cell instance sky130_fd_sc_hd__fill_8_1748 r0 *1 0,0
Xsky130_fd_sc_hd__fill_8_1748 VGND VPWR VPWR sky130_fd_sc_hd__fill_8
* cell instance sky130_fd_sc_hd__fill_8_1749 r0 *1 0,0
Xsky130_fd_sc_hd__fill_8_1749 VGND VPWR VPWR sky130_fd_sc_hd__fill_8
* cell instance sky130_fd_sc_hd__fill_8_1750 r0 *1 0,0
Xsky130_fd_sc_hd__fill_8_1750 VGND VPWR VPWR sky130_fd_sc_hd__fill_8
* cell instance sky130_fd_sc_hd__fill_8_1751 r0 *1 0,0
Xsky130_fd_sc_hd__fill_8_1751 VGND VPWR VPWR sky130_fd_sc_hd__fill_8
* cell instance sky130_fd_sc_hd__fill_8_1752 r0 *1 0,0
Xsky130_fd_sc_hd__fill_8_1752 VGND VPWR VPWR sky130_fd_sc_hd__fill_8
* cell instance sky130_fd_sc_hd__fill_8_1753 r0 *1 0,0
Xsky130_fd_sc_hd__fill_8_1753 VGND VPWR VPWR sky130_fd_sc_hd__fill_8
* cell instance sky130_fd_sc_hd__fill_8_1754 r0 *1 0,0
Xsky130_fd_sc_hd__fill_8_1754 VGND VPWR VPWR sky130_fd_sc_hd__fill_8
* cell instance sky130_fd_sc_hd__fill_8_1755 r0 *1 0,0
Xsky130_fd_sc_hd__fill_8_1755 VGND VPWR VPWR sky130_fd_sc_hd__fill_8
* cell instance sky130_fd_sc_hd__fill_8_1756 r0 *1 0,0
Xsky130_fd_sc_hd__fill_8_1756 VGND VPWR VPWR sky130_fd_sc_hd__fill_8
* cell instance sky130_fd_sc_hd__fill_8_1757 r0 *1 0,0
Xsky130_fd_sc_hd__fill_8_1757 VGND VPWR VPWR sky130_fd_sc_hd__fill_8
* cell instance sky130_fd_sc_hd__fill_8_1758 r0 *1 0,0
Xsky130_fd_sc_hd__fill_8_1758 VGND VPWR VPWR sky130_fd_sc_hd__fill_8
* cell instance sky130_fd_sc_hd__fill_8_1759 r0 *1 0,0
Xsky130_fd_sc_hd__fill_8_1759 VGND VPWR VPWR sky130_fd_sc_hd__fill_8
* cell instance sky130_fd_sc_hd__fill_8_1760 r0 *1 0,0
Xsky130_fd_sc_hd__fill_8_1760 VGND VPWR VPWR sky130_fd_sc_hd__fill_8
* cell instance sky130_fd_sc_hd__fill_8_1761 r0 *1 0,0
Xsky130_fd_sc_hd__fill_8_1761 VGND VPWR VPWR sky130_fd_sc_hd__fill_8
* cell instance sky130_fd_sc_hd__fill_8_1762 r0 *1 0,0
Xsky130_fd_sc_hd__fill_8_1762 VGND VPWR VPWR sky130_fd_sc_hd__fill_8
* cell instance sky130_fd_sc_hd__fill_8_1763 r0 *1 0,0
Xsky130_fd_sc_hd__fill_8_1763 VGND VPWR VPWR sky130_fd_sc_hd__fill_8
* cell instance sky130_fd_sc_hd__fill_8_1764 r0 *1 0,0
Xsky130_fd_sc_hd__fill_8_1764 VGND VPWR VPWR sky130_fd_sc_hd__fill_8
* cell instance sky130_fd_sc_hd__fill_8_1765 r0 *1 0,0
Xsky130_fd_sc_hd__fill_8_1765 VGND VPWR VPWR sky130_fd_sc_hd__fill_8
* cell instance sky130_fd_sc_hd__fill_8_1766 r0 *1 0,0
Xsky130_fd_sc_hd__fill_8_1766 VGND VPWR VPWR sky130_fd_sc_hd__fill_8
* cell instance sky130_fd_sc_hd__fill_8_1767 r0 *1 0,0
Xsky130_fd_sc_hd__fill_8_1767 VGND VPWR VPWR sky130_fd_sc_hd__fill_8
* cell instance sky130_fd_sc_hd__fill_8_1768 r0 *1 0,0
Xsky130_fd_sc_hd__fill_8_1768 VGND VPWR VPWR sky130_fd_sc_hd__fill_8
* cell instance sky130_fd_sc_hd__fill_8_1769 r0 *1 0,0
Xsky130_fd_sc_hd__fill_8_1769 VGND VPWR VPWR sky130_fd_sc_hd__fill_8
* cell instance sky130_fd_sc_hd__fill_8_1770 r0 *1 0,0
Xsky130_fd_sc_hd__fill_8_1770 VGND VPWR VPWR sky130_fd_sc_hd__fill_8
* cell instance sky130_fd_sc_hd__fill_8_1771 r0 *1 0,0
Xsky130_fd_sc_hd__fill_8_1771 VGND VPWR VPWR sky130_fd_sc_hd__fill_8
* cell instance sky130_fd_sc_hd__fill_8_1772 r0 *1 0,0
Xsky130_fd_sc_hd__fill_8_1772 VGND VPWR VPWR sky130_fd_sc_hd__fill_8
* cell instance sky130_fd_sc_hd__fill_8_1773 r0 *1 0,0
Xsky130_fd_sc_hd__fill_8_1773 VGND VPWR VPWR sky130_fd_sc_hd__fill_8
* cell instance sky130_fd_sc_hd__fill_8_1774 r0 *1 0,0
Xsky130_fd_sc_hd__fill_8_1774 VGND VPWR VPWR sky130_fd_sc_hd__fill_8
* cell instance sky130_fd_sc_hd__fill_8_1775 r0 *1 0,0
Xsky130_fd_sc_hd__fill_8_1775 VGND VPWR VPWR sky130_fd_sc_hd__fill_8
* cell instance sky130_fd_sc_hd__fill_8_1776 r0 *1 0,0
Xsky130_fd_sc_hd__fill_8_1776 VGND VPWR VPWR sky130_fd_sc_hd__fill_8
* cell instance sky130_fd_sc_hd__fill_8_1777 r0 *1 0,0
Xsky130_fd_sc_hd__fill_8_1777 VGND VPWR VPWR sky130_fd_sc_hd__fill_8
* cell instance sky130_fd_sc_hd__fill_8_1778 r0 *1 0,0
Xsky130_fd_sc_hd__fill_8_1778 VGND VPWR VPWR sky130_fd_sc_hd__fill_8
* cell instance sky130_fd_sc_hd__fill_8_1779 r0 *1 0,0
Xsky130_fd_sc_hd__fill_8_1779 VGND VPWR VPWR sky130_fd_sc_hd__fill_8
* cell instance sky130_fd_sc_hd__fill_8_1780 r0 *1 0,0
Xsky130_fd_sc_hd__fill_8_1780 VGND VPWR VPWR sky130_fd_sc_hd__fill_8
* cell instance sky130_fd_sc_hd__fill_8_1781 r0 *1 0,0
Xsky130_fd_sc_hd__fill_8_1781 VGND VPWR VPWR sky130_fd_sc_hd__fill_8
* cell instance sky130_fd_sc_hd__fill_8_1782 r0 *1 0,0
Xsky130_fd_sc_hd__fill_8_1782 VGND VPWR VPWR sky130_fd_sc_hd__fill_8
* cell instance sky130_fd_sc_hd__fill_8_1783 r0 *1 0,0
Xsky130_fd_sc_hd__fill_8_1783 VGND VPWR VPWR sky130_fd_sc_hd__fill_8
* cell instance sky130_fd_sc_hd__fill_8_1784 r0 *1 0,0
Xsky130_fd_sc_hd__fill_8_1784 VGND VPWR VPWR sky130_fd_sc_hd__fill_8
* cell instance sky130_fd_sc_hd__fill_8_1785 r0 *1 0,0
Xsky130_fd_sc_hd__fill_8_1785 VGND VPWR VPWR sky130_fd_sc_hd__fill_8
* cell instance sky130_fd_sc_hd__fill_8_1786 r0 *1 0,0
Xsky130_fd_sc_hd__fill_8_1786 VGND VPWR VPWR sky130_fd_sc_hd__fill_8
* cell instance sky130_fd_sc_hd__fill_8_1787 r0 *1 0,0
Xsky130_fd_sc_hd__fill_8_1787 VGND VPWR VPWR sky130_fd_sc_hd__fill_8
* cell instance sky130_fd_sc_hd__fill_8_1788 r0 *1 0,0
Xsky130_fd_sc_hd__fill_8_1788 VGND VPWR VPWR sky130_fd_sc_hd__fill_8
* cell instance sky130_fd_sc_hd__fill_8_1789 r0 *1 0,0
Xsky130_fd_sc_hd__fill_8_1789 VGND VPWR VPWR sky130_fd_sc_hd__fill_8
* cell instance sky130_fd_sc_hd__fill_8_1790 r0 *1 0,0
Xsky130_fd_sc_hd__fill_8_1790 VGND VPWR VPWR sky130_fd_sc_hd__fill_8
* cell instance sky130_fd_sc_hd__fill_8_1791 r0 *1 0,0
Xsky130_fd_sc_hd__fill_8_1791 VGND VPWR VPWR sky130_fd_sc_hd__fill_8
* cell instance sky130_fd_sc_hd__fill_8_1792 r0 *1 0,0
Xsky130_fd_sc_hd__fill_8_1792 VGND VPWR VPWR sky130_fd_sc_hd__fill_8
* cell instance sky130_fd_sc_hd__fill_8_1793 r0 *1 0,0
Xsky130_fd_sc_hd__fill_8_1793 VGND VPWR VPWR sky130_fd_sc_hd__fill_8
* cell instance sky130_fd_sc_hd__fill_8_1794 r0 *1 0,0
Xsky130_fd_sc_hd__fill_8_1794 VGND VPWR VPWR sky130_fd_sc_hd__fill_8
* cell instance sky130_fd_sc_hd__fill_8_1795 r0 *1 0,0
Xsky130_fd_sc_hd__fill_8_1795 VGND VPWR VPWR sky130_fd_sc_hd__fill_8
* cell instance sky130_fd_sc_hd__fill_8_1796 r0 *1 0,0
Xsky130_fd_sc_hd__fill_8_1796 VGND VPWR VPWR sky130_fd_sc_hd__fill_8
* cell instance sky130_fd_sc_hd__fill_8_1797 r0 *1 0,0
Xsky130_fd_sc_hd__fill_8_1797 VGND VPWR VPWR sky130_fd_sc_hd__fill_8
* cell instance sky130_fd_sc_hd__fill_8_1798 r0 *1 0,0
Xsky130_fd_sc_hd__fill_8_1798 VGND VPWR VPWR sky130_fd_sc_hd__fill_8
* cell instance sky130_fd_sc_hd__fill_8_1799 r0 *1 0,0
Xsky130_fd_sc_hd__fill_8_1799 VGND VPWR VPWR sky130_fd_sc_hd__fill_8
* cell instance sky130_fd_sc_hd__fill_8_1800 r0 *1 0,0
Xsky130_fd_sc_hd__fill_8_1800 VGND VPWR VPWR sky130_fd_sc_hd__fill_8
* cell instance sky130_fd_sc_hd__fill_8_1801 r0 *1 0,0
Xsky130_fd_sc_hd__fill_8_1801 VGND VPWR VPWR sky130_fd_sc_hd__fill_8
* cell instance sky130_fd_sc_hd__fill_8_1802 r0 *1 0,0
Xsky130_fd_sc_hd__fill_8_1802 VGND VPWR VPWR sky130_fd_sc_hd__fill_8
* cell instance sky130_fd_sc_hd__fill_8_1803 r0 *1 0,0
Xsky130_fd_sc_hd__fill_8_1803 VGND VPWR VPWR sky130_fd_sc_hd__fill_8
* cell instance sky130_fd_sc_hd__fill_8_1804 r0 *1 0,0
Xsky130_fd_sc_hd__fill_8_1804 VGND VPWR VPWR sky130_fd_sc_hd__fill_8
* cell instance sky130_fd_sc_hd__fill_8_1805 r0 *1 0,0
Xsky130_fd_sc_hd__fill_8_1805 VGND VPWR VPWR sky130_fd_sc_hd__fill_8
* cell instance sky130_fd_sc_hd__fill_8_1806 r0 *1 0,0
Xsky130_fd_sc_hd__fill_8_1806 VGND VPWR VPWR sky130_fd_sc_hd__fill_8
* cell instance sky130_fd_sc_hd__fill_8_1807 r0 *1 0,0
Xsky130_fd_sc_hd__fill_8_1807 VGND VPWR VPWR sky130_fd_sc_hd__fill_8
* cell instance sky130_fd_sc_hd__fill_8_1808 r0 *1 0,0
Xsky130_fd_sc_hd__fill_8_1808 VGND VPWR VPWR sky130_fd_sc_hd__fill_8
* cell instance sky130_fd_sc_hd__fill_8_1809 r0 *1 0,0
Xsky130_fd_sc_hd__fill_8_1809 VGND VPWR VPWR sky130_fd_sc_hd__fill_8
* cell instance sky130_fd_sc_hd__fill_8_1810 r0 *1 0,0
Xsky130_fd_sc_hd__fill_8_1810 VGND VPWR VPWR sky130_fd_sc_hd__fill_8
* cell instance sky130_fd_sc_hd__fill_8_1811 r0 *1 0,0
Xsky130_fd_sc_hd__fill_8_1811 VGND VPWR VPWR sky130_fd_sc_hd__fill_8
* cell instance sky130_fd_sc_hd__fill_8_1812 r0 *1 0,0
Xsky130_fd_sc_hd__fill_8_1812 VGND VPWR VPWR sky130_fd_sc_hd__fill_8
* cell instance sky130_fd_sc_hd__fill_8_1813 r0 *1 0,0
Xsky130_fd_sc_hd__fill_8_1813 VGND VPWR VPWR sky130_fd_sc_hd__fill_8
* cell instance sky130_fd_sc_hd__fill_8_1814 r0 *1 0,0
Xsky130_fd_sc_hd__fill_8_1814 VGND VPWR VPWR sky130_fd_sc_hd__fill_8
* cell instance sky130_fd_sc_hd__fill_8_1815 r0 *1 0,0
Xsky130_fd_sc_hd__fill_8_1815 VGND VPWR VPWR sky130_fd_sc_hd__fill_8
* cell instance sky130_fd_sc_hd__fill_8_1816 r0 *1 0,0
Xsky130_fd_sc_hd__fill_8_1816 VGND VPWR VPWR sky130_fd_sc_hd__fill_8
* cell instance sky130_fd_sc_hd__fill_8_1817 r0 *1 0,0
Xsky130_fd_sc_hd__fill_8_1817 VGND VPWR VPWR sky130_fd_sc_hd__fill_8
* cell instance sky130_fd_sc_hd__fill_8_1818 r0 *1 0,0
Xsky130_fd_sc_hd__fill_8_1818 VGND VPWR VPWR sky130_fd_sc_hd__fill_8
* cell instance sky130_fd_sc_hd__fill_8_1819 r0 *1 0,0
Xsky130_fd_sc_hd__fill_8_1819 VGND VPWR VPWR sky130_fd_sc_hd__fill_8
* cell instance sky130_fd_sc_hd__fill_8_1820 r0 *1 0,0
Xsky130_fd_sc_hd__fill_8_1820 VGND VPWR VPWR sky130_fd_sc_hd__fill_8
* cell instance sky130_fd_sc_hd__fill_8_1821 r0 *1 0,0
Xsky130_fd_sc_hd__fill_8_1821 VGND VPWR VPWR sky130_fd_sc_hd__fill_8
* cell instance sky130_fd_sc_hd__fill_8_1822 r0 *1 0,0
Xsky130_fd_sc_hd__fill_8_1822 VGND VPWR VPWR sky130_fd_sc_hd__fill_8
* cell instance sky130_fd_sc_hd__fill_8_1823 r0 *1 0,0
Xsky130_fd_sc_hd__fill_8_1823 VGND VPWR VPWR sky130_fd_sc_hd__fill_8
* cell instance sky130_fd_sc_hd__fill_8_1824 r0 *1 0,0
Xsky130_fd_sc_hd__fill_8_1824 VGND VPWR VPWR sky130_fd_sc_hd__fill_8
* cell instance sky130_fd_sc_hd__fill_8_1825 r0 *1 0,0
Xsky130_fd_sc_hd__fill_8_1825 VGND VPWR VPWR sky130_fd_sc_hd__fill_8
* cell instance sky130_fd_sc_hd__fill_8_1826 r0 *1 0,0
Xsky130_fd_sc_hd__fill_8_1826 VGND VPWR VPWR sky130_fd_sc_hd__fill_8
* cell instance sky130_fd_sc_hd__fill_8_1827 r0 *1 0,0
Xsky130_fd_sc_hd__fill_8_1827 VGND VPWR VPWR sky130_fd_sc_hd__fill_8
* cell instance sky130_fd_sc_hd__fill_8_1828 r0 *1 0,0
Xsky130_fd_sc_hd__fill_8_1828 VGND VPWR VPWR sky130_fd_sc_hd__fill_8
* cell instance sky130_fd_sc_hd__fill_8_1829 r0 *1 0,0
Xsky130_fd_sc_hd__fill_8_1829 VGND VPWR VPWR sky130_fd_sc_hd__fill_8
* cell instance sky130_fd_sc_hd__fill_8_1830 r0 *1 0,0
Xsky130_fd_sc_hd__fill_8_1830 VGND VPWR VPWR sky130_fd_sc_hd__fill_8
* cell instance sky130_fd_sc_hd__fill_8_1831 r0 *1 0,0
Xsky130_fd_sc_hd__fill_8_1831 VGND VPWR VPWR sky130_fd_sc_hd__fill_8
* cell instance sky130_fd_sc_hd__fill_8_1832 r0 *1 0,0
Xsky130_fd_sc_hd__fill_8_1832 VGND VPWR VPWR sky130_fd_sc_hd__fill_8
* cell instance sky130_fd_sc_hd__fill_8_1833 r0 *1 0,0
Xsky130_fd_sc_hd__fill_8_1833 VGND VPWR VPWR sky130_fd_sc_hd__fill_8
* cell instance sky130_fd_sc_hd__fill_8_1834 r0 *1 0,0
Xsky130_fd_sc_hd__fill_8_1834 VGND VPWR VPWR sky130_fd_sc_hd__fill_8
* cell instance sky130_fd_sc_hd__fill_8_1835 r0 *1 0,0
Xsky130_fd_sc_hd__fill_8_1835 VGND VPWR VPWR sky130_fd_sc_hd__fill_8
* cell instance sky130_fd_sc_hd__fill_8_1836 r0 *1 0,0
Xsky130_fd_sc_hd__fill_8_1836 VGND VPWR VPWR sky130_fd_sc_hd__fill_8
* cell instance sky130_fd_sc_hd__fill_8_1837 r0 *1 0,0
Xsky130_fd_sc_hd__fill_8_1837 VGND VPWR VPWR sky130_fd_sc_hd__fill_8
* cell instance sky130_fd_sc_hd__fill_8_1838 r0 *1 0,0
Xsky130_fd_sc_hd__fill_8_1838 VGND VPWR VPWR sky130_fd_sc_hd__fill_8
* cell instance sky130_fd_sc_hd__fill_8_1839 r0 *1 0,0
Xsky130_fd_sc_hd__fill_8_1839 VGND VPWR VPWR sky130_fd_sc_hd__fill_8
* cell instance sky130_fd_sc_hd__fill_8_1840 r0 *1 0,0
Xsky130_fd_sc_hd__fill_8_1840 VGND VPWR VPWR sky130_fd_sc_hd__fill_8
* cell instance sky130_fd_sc_hd__fill_8_1841 r0 *1 0,0
Xsky130_fd_sc_hd__fill_8_1841 VGND VPWR VPWR sky130_fd_sc_hd__fill_8
* cell instance sky130_fd_sc_hd__fill_8_1842 r0 *1 0,0
Xsky130_fd_sc_hd__fill_8_1842 VGND VPWR VPWR sky130_fd_sc_hd__fill_8
* cell instance sky130_fd_sc_hd__fill_8_1843 r0 *1 0,0
Xsky130_fd_sc_hd__fill_8_1843 VGND VPWR VPWR sky130_fd_sc_hd__fill_8
* cell instance sky130_fd_sc_hd__fill_8_1844 r0 *1 0,0
Xsky130_fd_sc_hd__fill_8_1844 VGND VPWR VPWR sky130_fd_sc_hd__fill_8
* cell instance sky130_fd_sc_hd__fill_8_1845 r0 *1 0,0
Xsky130_fd_sc_hd__fill_8_1845 VGND VPWR VPWR sky130_fd_sc_hd__fill_8
* cell instance sky130_fd_sc_hd__fill_8_1846 r0 *1 0,0
Xsky130_fd_sc_hd__fill_8_1846 VGND VPWR VPWR sky130_fd_sc_hd__fill_8
* cell instance sky130_fd_sc_hd__fill_8_1847 r0 *1 0,0
Xsky130_fd_sc_hd__fill_8_1847 VGND VPWR VPWR sky130_fd_sc_hd__fill_8
* cell instance sky130_fd_sc_hd__fill_8_1848 r0 *1 0,0
Xsky130_fd_sc_hd__fill_8_1848 VGND VPWR VPWR sky130_fd_sc_hd__fill_8
* cell instance sky130_fd_sc_hd__fill_8_1849 r0 *1 0,0
Xsky130_fd_sc_hd__fill_8_1849 VGND VPWR VPWR sky130_fd_sc_hd__fill_8
* cell instance sky130_fd_sc_hd__fill_8_1850 r0 *1 0,0
Xsky130_fd_sc_hd__fill_8_1850 VGND VPWR VPWR sky130_fd_sc_hd__fill_8
* cell instance sky130_fd_sc_hd__fill_8_1851 r0 *1 0,0
Xsky130_fd_sc_hd__fill_8_1851 VGND VPWR VPWR sky130_fd_sc_hd__fill_8
* cell instance sky130_fd_sc_hd__fill_8_1852 r0 *1 0,0
Xsky130_fd_sc_hd__fill_8_1852 VGND VPWR VPWR sky130_fd_sc_hd__fill_8
* cell instance sky130_fd_sc_hd__fill_8_1853 r0 *1 0,0
Xsky130_fd_sc_hd__fill_8_1853 VGND VPWR VPWR sky130_fd_sc_hd__fill_8
* cell instance sky130_fd_sc_hd__fill_8_1854 r0 *1 0,0
Xsky130_fd_sc_hd__fill_8_1854 VGND VPWR VPWR sky130_fd_sc_hd__fill_8
* cell instance sky130_fd_sc_hd__fill_8_1855 r0 *1 0,0
Xsky130_fd_sc_hd__fill_8_1855 VGND VPWR VPWR sky130_fd_sc_hd__fill_8
* cell instance sky130_fd_sc_hd__fill_8_1856 r0 *1 0,0
Xsky130_fd_sc_hd__fill_8_1856 VGND VPWR VPWR sky130_fd_sc_hd__fill_8
* cell instance sky130_fd_sc_hd__fill_8_1857 r0 *1 0,0
Xsky130_fd_sc_hd__fill_8_1857 VGND VPWR VPWR sky130_fd_sc_hd__fill_8
* cell instance sky130_fd_sc_hd__fill_8_1858 r0 *1 0,0
Xsky130_fd_sc_hd__fill_8_1858 VGND VPWR VPWR sky130_fd_sc_hd__fill_8
* cell instance sky130_fd_sc_hd__fill_8_1859 r0 *1 0,0
Xsky130_fd_sc_hd__fill_8_1859 VGND VPWR VPWR sky130_fd_sc_hd__fill_8
* cell instance sky130_fd_sc_hd__fill_8_1860 r0 *1 0,0
Xsky130_fd_sc_hd__fill_8_1860 VGND VPWR VPWR sky130_fd_sc_hd__fill_8
* cell instance sky130_fd_sc_hd__fill_8_1861 r0 *1 0,0
Xsky130_fd_sc_hd__fill_8_1861 VGND VPWR VPWR sky130_fd_sc_hd__fill_8
* cell instance sky130_fd_sc_hd__fill_8_1862 r0 *1 0,0
Xsky130_fd_sc_hd__fill_8_1862 VGND VPWR VPWR sky130_fd_sc_hd__fill_8
* cell instance sky130_fd_sc_hd__fill_8_1863 r0 *1 0,0
Xsky130_fd_sc_hd__fill_8_1863 VGND VPWR VPWR sky130_fd_sc_hd__fill_8
* cell instance sky130_fd_sc_hd__fill_8_1864 r0 *1 0,0
Xsky130_fd_sc_hd__fill_8_1864 VGND VPWR VPWR sky130_fd_sc_hd__fill_8
* cell instance sky130_fd_sc_hd__fill_8_1865 r0 *1 0,0
Xsky130_fd_sc_hd__fill_8_1865 VGND VPWR VPWR sky130_fd_sc_hd__fill_8
* cell instance sky130_fd_sc_hd__fill_8_1866 r0 *1 0,0
Xsky130_fd_sc_hd__fill_8_1866 VGND VPWR VPWR sky130_fd_sc_hd__fill_8
* cell instance sky130_fd_sc_hd__fill_8_1867 r0 *1 0,0
Xsky130_fd_sc_hd__fill_8_1867 VGND VPWR VPWR sky130_fd_sc_hd__fill_8
* cell instance sky130_fd_sc_hd__fill_8_1868 r0 *1 0,0
Xsky130_fd_sc_hd__fill_8_1868 VGND VPWR VPWR sky130_fd_sc_hd__fill_8
* cell instance sky130_fd_sc_hd__fill_8_1869 r0 *1 0,0
Xsky130_fd_sc_hd__fill_8_1869 VGND VPWR VPWR sky130_fd_sc_hd__fill_8
* cell instance sky130_fd_sc_hd__fill_8_1870 r0 *1 0,0
Xsky130_fd_sc_hd__fill_8_1870 VGND VPWR VPWR sky130_fd_sc_hd__fill_8
* cell instance sky130_fd_sc_hd__fill_8_1871 r0 *1 0,0
Xsky130_fd_sc_hd__fill_8_1871 VGND VPWR VPWR sky130_fd_sc_hd__fill_8
* cell instance sky130_fd_sc_hd__fill_8_1872 r0 *1 0,0
Xsky130_fd_sc_hd__fill_8_1872 VGND VPWR VPWR sky130_fd_sc_hd__fill_8
* cell instance sky130_fd_sc_hd__fill_8_1873 r0 *1 0,0
Xsky130_fd_sc_hd__fill_8_1873 VGND VPWR VPWR sky130_fd_sc_hd__fill_8
* cell instance sky130_fd_sc_hd__fill_8_1874 r0 *1 0,0
Xsky130_fd_sc_hd__fill_8_1874 VGND VPWR VPWR sky130_fd_sc_hd__fill_8
* cell instance sky130_fd_sc_hd__fill_8_1875 r0 *1 0,0
Xsky130_fd_sc_hd__fill_8_1875 VGND VPWR VPWR sky130_fd_sc_hd__fill_8
* cell instance sky130_fd_sc_hd__fill_8_1876 r0 *1 0,0
Xsky130_fd_sc_hd__fill_8_1876 VGND VPWR VPWR sky130_fd_sc_hd__fill_8
* cell instance sky130_fd_sc_hd__fill_8_1877 r0 *1 0,0
Xsky130_fd_sc_hd__fill_8_1877 VGND VPWR VPWR sky130_fd_sc_hd__fill_8
* cell instance sky130_fd_sc_hd__fill_8_1878 r0 *1 0,0
Xsky130_fd_sc_hd__fill_8_1878 VGND VPWR VPWR sky130_fd_sc_hd__fill_8
* cell instance sky130_fd_sc_hd__fill_8_1879 r0 *1 0,0
Xsky130_fd_sc_hd__fill_8_1879 VGND VPWR VPWR sky130_fd_sc_hd__fill_8
* cell instance sky130_fd_sc_hd__fill_8_1880 r0 *1 0,0
Xsky130_fd_sc_hd__fill_8_1880 VGND VPWR VPWR sky130_fd_sc_hd__fill_8
* cell instance sky130_fd_sc_hd__fill_8_1881 r0 *1 0,0
Xsky130_fd_sc_hd__fill_8_1881 VGND VPWR VPWR sky130_fd_sc_hd__fill_8
* cell instance sky130_fd_sc_hd__fill_8_1882 r0 *1 0,0
Xsky130_fd_sc_hd__fill_8_1882 VGND VPWR VPWR sky130_fd_sc_hd__fill_8
* cell instance sky130_fd_sc_hd__fill_8_1883 r0 *1 0,0
Xsky130_fd_sc_hd__fill_8_1883 VGND VPWR VPWR sky130_fd_sc_hd__fill_8
* cell instance sky130_fd_sc_hd__fill_8_1884 r0 *1 0,0
Xsky130_fd_sc_hd__fill_8_1884 VGND VPWR VPWR sky130_fd_sc_hd__fill_8
* cell instance sky130_fd_sc_hd__fill_8_1885 r0 *1 0,0
Xsky130_fd_sc_hd__fill_8_1885 VGND VPWR VPWR sky130_fd_sc_hd__fill_8
* cell instance sky130_fd_sc_hd__fill_8_1886 r0 *1 0,0
Xsky130_fd_sc_hd__fill_8_1886 VGND VPWR VPWR sky130_fd_sc_hd__fill_8
* cell instance sky130_fd_sc_hd__fill_8_1887 r0 *1 0,0
Xsky130_fd_sc_hd__fill_8_1887 VGND VPWR VPWR sky130_fd_sc_hd__fill_8
* cell instance sky130_fd_sc_hd__fill_8_1888 r0 *1 0,0
Xsky130_fd_sc_hd__fill_8_1888 VGND VPWR VPWR sky130_fd_sc_hd__fill_8
* cell instance sky130_fd_sc_hd__fill_8_1889 r0 *1 0,0
Xsky130_fd_sc_hd__fill_8_1889 VGND VPWR VPWR sky130_fd_sc_hd__fill_8
* cell instance sky130_fd_sc_hd__fill_8_1890 r0 *1 0,0
Xsky130_fd_sc_hd__fill_8_1890 VGND VPWR VPWR sky130_fd_sc_hd__fill_8
* cell instance sky130_fd_sc_hd__fill_8_1891 r0 *1 0,0
Xsky130_fd_sc_hd__fill_8_1891 VGND VPWR VPWR sky130_fd_sc_hd__fill_8
* cell instance sky130_fd_sc_hd__fill_8_1892 r0 *1 0,0
Xsky130_fd_sc_hd__fill_8_1892 VGND VPWR VPWR sky130_fd_sc_hd__fill_8
* cell instance sky130_fd_sc_hd__fill_8_1893 r0 *1 0,0
Xsky130_fd_sc_hd__fill_8_1893 VGND VPWR VPWR sky130_fd_sc_hd__fill_8
* cell instance sky130_fd_sc_hd__fill_8_1894 r0 *1 0,0
Xsky130_fd_sc_hd__fill_8_1894 VGND VPWR VPWR sky130_fd_sc_hd__fill_8
* cell instance sky130_fd_sc_hd__fill_8_1895 r0 *1 0,0
Xsky130_fd_sc_hd__fill_8_1895 VGND VPWR VPWR sky130_fd_sc_hd__fill_8
* cell instance sky130_fd_sc_hd__fill_8_1896 r0 *1 0,0
Xsky130_fd_sc_hd__fill_8_1896 VGND VPWR VPWR sky130_fd_sc_hd__fill_8
* cell instance sky130_fd_sc_hd__fill_8_1897 r0 *1 0,0
Xsky130_fd_sc_hd__fill_8_1897 VGND VPWR VPWR sky130_fd_sc_hd__fill_8
* cell instance sky130_fd_sc_hd__fill_8_1898 r0 *1 0,0
Xsky130_fd_sc_hd__fill_8_1898 VGND VPWR VPWR sky130_fd_sc_hd__fill_8
* cell instance sky130_fd_sc_hd__fill_8_1899 r0 *1 0,0
Xsky130_fd_sc_hd__fill_8_1899 VGND VPWR VPWR sky130_fd_sc_hd__fill_8
* cell instance sky130_fd_sc_hd__fill_8_1900 r0 *1 0,0
Xsky130_fd_sc_hd__fill_8_1900 VGND VPWR VPWR sky130_fd_sc_hd__fill_8
* cell instance sky130_fd_sc_hd__fill_8_1901 r0 *1 0,0
Xsky130_fd_sc_hd__fill_8_1901 VGND VPWR VPWR sky130_fd_sc_hd__fill_8
* cell instance sky130_fd_sc_hd__fill_8_1902 r0 *1 0,0
Xsky130_fd_sc_hd__fill_8_1902 VGND VPWR VPWR sky130_fd_sc_hd__fill_8
* cell instance sky130_fd_sc_hd__fill_8_1903 r0 *1 0,0
Xsky130_fd_sc_hd__fill_8_1903 VGND VPWR VPWR sky130_fd_sc_hd__fill_8
* cell instance sky130_fd_sc_hd__fill_8_1904 r0 *1 0,0
Xsky130_fd_sc_hd__fill_8_1904 VGND VPWR VPWR sky130_fd_sc_hd__fill_8
* cell instance sky130_fd_sc_hd__fill_8_1905 r0 *1 0,0
Xsky130_fd_sc_hd__fill_8_1905 VGND VPWR VPWR sky130_fd_sc_hd__fill_8
* cell instance sky130_fd_sc_hd__fill_8_1906 r0 *1 0,0
Xsky130_fd_sc_hd__fill_8_1906 VGND VPWR VPWR sky130_fd_sc_hd__fill_8
* cell instance sky130_fd_sc_hd__fill_8_1907 r0 *1 0,0
Xsky130_fd_sc_hd__fill_8_1907 VGND VPWR VPWR sky130_fd_sc_hd__fill_8
* cell instance sky130_fd_sc_hd__fill_8_1908 r0 *1 0,0
Xsky130_fd_sc_hd__fill_8_1908 VGND VPWR VPWR sky130_fd_sc_hd__fill_8
* cell instance sky130_fd_sc_hd__fill_8_1909 r0 *1 0,0
Xsky130_fd_sc_hd__fill_8_1909 VGND VPWR VPWR sky130_fd_sc_hd__fill_8
* cell instance sky130_fd_sc_hd__fill_8_1910 r0 *1 0,0
Xsky130_fd_sc_hd__fill_8_1910 VGND VPWR VPWR sky130_fd_sc_hd__fill_8
* cell instance sky130_fd_sc_hd__fill_8_1911 r0 *1 0,0
Xsky130_fd_sc_hd__fill_8_1911 VGND VPWR VPWR sky130_fd_sc_hd__fill_8
* cell instance sky130_fd_sc_hd__fill_8_1912 r0 *1 0,0
Xsky130_fd_sc_hd__fill_8_1912 VGND VPWR VPWR sky130_fd_sc_hd__fill_8
* cell instance sky130_fd_sc_hd__fill_8_1913 r0 *1 0,0
Xsky130_fd_sc_hd__fill_8_1913 VGND VPWR VPWR sky130_fd_sc_hd__fill_8
* cell instance sky130_fd_sc_hd__fill_8_1914 r0 *1 0,0
Xsky130_fd_sc_hd__fill_8_1914 VGND VPWR VPWR sky130_fd_sc_hd__fill_8
* cell instance sky130_fd_sc_hd__fill_8_1915 r0 *1 0,0
Xsky130_fd_sc_hd__fill_8_1915 VGND VPWR VPWR sky130_fd_sc_hd__fill_8
* cell instance sky130_fd_sc_hd__fill_8_1916 r0 *1 0,0
Xsky130_fd_sc_hd__fill_8_1916 VGND VPWR VPWR sky130_fd_sc_hd__fill_8
* cell instance sky130_fd_sc_hd__fill_8_1917 r0 *1 0,0
Xsky130_fd_sc_hd__fill_8_1917 VGND VPWR VPWR sky130_fd_sc_hd__fill_8
* cell instance sky130_fd_sc_hd__fill_8_1918 r0 *1 0,0
Xsky130_fd_sc_hd__fill_8_1918 VGND VPWR VPWR sky130_fd_sc_hd__fill_8
* cell instance sky130_fd_sc_hd__fill_8_1919 r0 *1 0,0
Xsky130_fd_sc_hd__fill_8_1919 VGND VPWR VPWR sky130_fd_sc_hd__fill_8
* cell instance sky130_fd_sc_hd__fill_8_1920 r0 *1 0,0
Xsky130_fd_sc_hd__fill_8_1920 VGND VPWR VPWR sky130_fd_sc_hd__fill_8
* cell instance sky130_fd_sc_hd__fill_8_1921 r0 *1 0,0
Xsky130_fd_sc_hd__fill_8_1921 VGND VPWR VPWR sky130_fd_sc_hd__fill_8
* cell instance sky130_fd_sc_hd__fill_8_1922 r0 *1 0,0
Xsky130_fd_sc_hd__fill_8_1922 VGND VPWR VPWR sky130_fd_sc_hd__fill_8
* cell instance sky130_fd_sc_hd__fill_8_1923 r0 *1 0,0
Xsky130_fd_sc_hd__fill_8_1923 VGND VPWR VPWR sky130_fd_sc_hd__fill_8
* cell instance sky130_fd_sc_hd__fill_8_1924 r0 *1 0,0
Xsky130_fd_sc_hd__fill_8_1924 VGND VPWR VPWR sky130_fd_sc_hd__fill_8
* cell instance sky130_fd_sc_hd__fill_8_1925 r0 *1 0,0
Xsky130_fd_sc_hd__fill_8_1925 VGND VPWR VPWR sky130_fd_sc_hd__fill_8
* cell instance sky130_fd_sc_hd__fill_8_1926 r0 *1 0,0
Xsky130_fd_sc_hd__fill_8_1926 VGND VPWR VPWR sky130_fd_sc_hd__fill_8
* cell instance sky130_fd_sc_hd__fill_8_1927 r0 *1 0,0
Xsky130_fd_sc_hd__fill_8_1927 VGND VPWR VPWR sky130_fd_sc_hd__fill_8
* cell instance sky130_fd_sc_hd__fill_8_1928 r0 *1 0,0
Xsky130_fd_sc_hd__fill_8_1928 VGND VPWR VPWR sky130_fd_sc_hd__fill_8
* cell instance sky130_fd_sc_hd__fill_8_1929 r0 *1 0,0
Xsky130_fd_sc_hd__fill_8_1929 VGND VPWR VPWR sky130_fd_sc_hd__fill_8
* cell instance sky130_fd_sc_hd__fill_8_1930 r0 *1 0,0
Xsky130_fd_sc_hd__fill_8_1930 VGND VPWR VPWR sky130_fd_sc_hd__fill_8
* cell instance sky130_fd_sc_hd__fill_8_1931 r0 *1 0,0
Xsky130_fd_sc_hd__fill_8_1931 VGND VPWR VPWR sky130_fd_sc_hd__fill_8
* cell instance sky130_fd_sc_hd__fill_8_1932 r0 *1 0,0
Xsky130_fd_sc_hd__fill_8_1932 VGND VPWR VPWR sky130_fd_sc_hd__fill_8
* cell instance sky130_fd_sc_hd__fill_8_1933 r0 *1 0,0
Xsky130_fd_sc_hd__fill_8_1933 VGND VPWR VPWR sky130_fd_sc_hd__fill_8
* cell instance sky130_fd_sc_hd__fill_8_1934 r0 *1 0,0
Xsky130_fd_sc_hd__fill_8_1934 VGND VPWR VPWR sky130_fd_sc_hd__fill_8
* cell instance sky130_fd_sc_hd__fill_8_1935 r0 *1 0,0
Xsky130_fd_sc_hd__fill_8_1935 VGND VPWR VPWR sky130_fd_sc_hd__fill_8
* cell instance sky130_fd_sc_hd__fill_8_1936 r0 *1 0,0
Xsky130_fd_sc_hd__fill_8_1936 VGND VPWR VPWR sky130_fd_sc_hd__fill_8
* cell instance sky130_fd_sc_hd__fill_8_1937 r0 *1 0,0
Xsky130_fd_sc_hd__fill_8_1937 VGND VPWR VPWR sky130_fd_sc_hd__fill_8
* cell instance sky130_fd_sc_hd__fill_8_1938 r0 *1 0,0
Xsky130_fd_sc_hd__fill_8_1938 VGND VPWR VPWR sky130_fd_sc_hd__fill_8
* cell instance sky130_fd_sc_hd__fill_8_1939 r0 *1 0,0
Xsky130_fd_sc_hd__fill_8_1939 VGND VPWR VPWR sky130_fd_sc_hd__fill_8
* cell instance sky130_fd_sc_hd__fill_8_1940 r0 *1 0,0
Xsky130_fd_sc_hd__fill_8_1940 VGND VPWR VPWR sky130_fd_sc_hd__fill_8
* cell instance sky130_fd_sc_hd__fill_8_1941 r0 *1 0,0
Xsky130_fd_sc_hd__fill_8_1941 VGND VPWR VPWR sky130_fd_sc_hd__fill_8
* cell instance sky130_fd_sc_hd__fill_8_1942 r0 *1 0,0
Xsky130_fd_sc_hd__fill_8_1942 VGND VPWR VPWR sky130_fd_sc_hd__fill_8
* cell instance sky130_fd_sc_hd__fill_8_1943 r0 *1 0,0
Xsky130_fd_sc_hd__fill_8_1943 VGND VPWR VPWR sky130_fd_sc_hd__fill_8
* cell instance sky130_fd_sc_hd__fill_8_1944 r0 *1 0,0
Xsky130_fd_sc_hd__fill_8_1944 VGND VPWR VPWR sky130_fd_sc_hd__fill_8
* cell instance sky130_fd_sc_hd__fill_8_1945 r0 *1 0,0
Xsky130_fd_sc_hd__fill_8_1945 VGND VPWR VPWR sky130_fd_sc_hd__fill_8
* cell instance sky130_fd_sc_hd__fill_8_1946 r0 *1 0,0
Xsky130_fd_sc_hd__fill_8_1946 VGND VPWR VPWR sky130_fd_sc_hd__fill_8
* cell instance sky130_fd_sc_hd__fill_8_1947 r0 *1 0,0
Xsky130_fd_sc_hd__fill_8_1947 VGND VPWR VPWR sky130_fd_sc_hd__fill_8
* cell instance sky130_fd_sc_hd__fill_8_1948 r0 *1 0,0
Xsky130_fd_sc_hd__fill_8_1948 VGND VPWR VPWR sky130_fd_sc_hd__fill_8
* cell instance sky130_fd_sc_hd__fill_8_1949 r0 *1 0,0
Xsky130_fd_sc_hd__fill_8_1949 VGND VPWR VPWR sky130_fd_sc_hd__fill_8
* cell instance sky130_fd_sc_hd__fill_8_1950 r0 *1 0,0
Xsky130_fd_sc_hd__fill_8_1950 VGND VPWR VPWR sky130_fd_sc_hd__fill_8
* cell instance sky130_fd_sc_hd__fill_8_1951 r0 *1 0,0
Xsky130_fd_sc_hd__fill_8_1951 VGND VPWR VPWR sky130_fd_sc_hd__fill_8
* cell instance sky130_fd_sc_hd__fill_8_1952 r0 *1 0,0
Xsky130_fd_sc_hd__fill_8_1952 VGND VPWR VPWR sky130_fd_sc_hd__fill_8
* cell instance sky130_fd_sc_hd__fill_8_1953 r0 *1 0,0
Xsky130_fd_sc_hd__fill_8_1953 VGND VPWR VPWR sky130_fd_sc_hd__fill_8
* cell instance sky130_fd_sc_hd__fill_8_1954 r0 *1 0,0
Xsky130_fd_sc_hd__fill_8_1954 VGND VPWR VPWR sky130_fd_sc_hd__fill_8
* cell instance sky130_fd_sc_hd__fill_8_1955 r0 *1 0,0
Xsky130_fd_sc_hd__fill_8_1955 VGND VPWR VPWR sky130_fd_sc_hd__fill_8
* cell instance sky130_fd_sc_hd__fill_8_1956 r0 *1 0,0
Xsky130_fd_sc_hd__fill_8_1956 VGND VPWR VPWR sky130_fd_sc_hd__fill_8
* cell instance sky130_fd_sc_hd__fill_8_1957 r0 *1 0,0
Xsky130_fd_sc_hd__fill_8_1957 VGND VPWR VPWR sky130_fd_sc_hd__fill_8
* cell instance sky130_fd_sc_hd__fill_8_1958 r0 *1 0,0
Xsky130_fd_sc_hd__fill_8_1958 VGND VPWR VPWR sky130_fd_sc_hd__fill_8
* cell instance sky130_fd_sc_hd__fill_8_1959 r0 *1 0,0
Xsky130_fd_sc_hd__fill_8_1959 VGND VPWR VPWR sky130_fd_sc_hd__fill_8
* cell instance sky130_fd_sc_hd__fill_8_1960 r0 *1 0,0
Xsky130_fd_sc_hd__fill_8_1960 VGND VPWR VPWR sky130_fd_sc_hd__fill_8
* cell instance sky130_fd_sc_hd__fill_8_1961 r0 *1 0,0
Xsky130_fd_sc_hd__fill_8_1961 VGND VPWR VPWR sky130_fd_sc_hd__fill_8
* cell instance sky130_fd_sc_hd__fill_8_1962 r0 *1 0,0
Xsky130_fd_sc_hd__fill_8_1962 VGND VPWR VPWR sky130_fd_sc_hd__fill_8
* cell instance sky130_fd_sc_hd__fill_8_1963 r0 *1 0,0
Xsky130_fd_sc_hd__fill_8_1963 VGND VPWR VPWR sky130_fd_sc_hd__fill_8
* cell instance sky130_fd_sc_hd__fill_8_1964 r0 *1 0,0
Xsky130_fd_sc_hd__fill_8_1964 VGND VPWR VPWR sky130_fd_sc_hd__fill_8
* cell instance sky130_fd_sc_hd__fill_8_1965 r0 *1 0,0
Xsky130_fd_sc_hd__fill_8_1965 VGND VPWR VPWR sky130_fd_sc_hd__fill_8
* cell instance sky130_fd_sc_hd__fill_8_1966 r0 *1 0,0
Xsky130_fd_sc_hd__fill_8_1966 VGND VPWR VPWR sky130_fd_sc_hd__fill_8
* cell instance sky130_fd_sc_hd__fill_8_1967 r0 *1 0,0
Xsky130_fd_sc_hd__fill_8_1967 VGND VPWR VPWR sky130_fd_sc_hd__fill_8
* cell instance sky130_fd_sc_hd__fill_8_1968 r0 *1 0,0
Xsky130_fd_sc_hd__fill_8_1968 VGND VPWR VPWR sky130_fd_sc_hd__fill_8
* cell instance sky130_fd_sc_hd__fill_8_1969 r0 *1 0,0
Xsky130_fd_sc_hd__fill_8_1969 VGND VPWR VPWR sky130_fd_sc_hd__fill_8
* cell instance sky130_fd_sc_hd__fill_8_1970 r0 *1 0,0
Xsky130_fd_sc_hd__fill_8_1970 VGND VPWR VPWR sky130_fd_sc_hd__fill_8
* cell instance sky130_fd_sc_hd__fill_8_1971 r0 *1 0,0
Xsky130_fd_sc_hd__fill_8_1971 VGND VPWR VPWR sky130_fd_sc_hd__fill_8
* cell instance sky130_fd_sc_hd__fill_8_1972 r0 *1 0,0
Xsky130_fd_sc_hd__fill_8_1972 VGND VPWR VPWR sky130_fd_sc_hd__fill_8
* cell instance sky130_fd_sc_hd__fill_8_1973 r0 *1 0,0
Xsky130_fd_sc_hd__fill_8_1973 VGND VPWR VPWR sky130_fd_sc_hd__fill_8
* cell instance sky130_fd_sc_hd__fill_8_1974 r0 *1 0,0
Xsky130_fd_sc_hd__fill_8_1974 VGND VPWR VPWR sky130_fd_sc_hd__fill_8
* cell instance sky130_fd_sc_hd__fill_8_1975 r0 *1 0,0
Xsky130_fd_sc_hd__fill_8_1975 VGND VPWR VPWR sky130_fd_sc_hd__fill_8
* cell instance sky130_fd_sc_hd__fill_8_1976 r0 *1 0,0
Xsky130_fd_sc_hd__fill_8_1976 VGND VPWR VPWR sky130_fd_sc_hd__fill_8
* cell instance sky130_fd_sc_hd__fill_8_1977 r0 *1 0,0
Xsky130_fd_sc_hd__fill_8_1977 VGND VPWR VPWR sky130_fd_sc_hd__fill_8
* cell instance sky130_fd_sc_hd__fill_8_1978 r0 *1 0,0
Xsky130_fd_sc_hd__fill_8_1978 VGND VPWR VPWR sky130_fd_sc_hd__fill_8
* cell instance sky130_fd_sc_hd__fill_8_1979 r0 *1 0,0
Xsky130_fd_sc_hd__fill_8_1979 VGND VPWR VPWR sky130_fd_sc_hd__fill_8
* cell instance sky130_fd_sc_hd__fill_8_1980 r0 *1 0,0
Xsky130_fd_sc_hd__fill_8_1980 VGND VPWR VPWR sky130_fd_sc_hd__fill_8
* cell instance sky130_fd_sc_hd__fill_8_1981 r0 *1 0,0
Xsky130_fd_sc_hd__fill_8_1981 VGND VPWR VPWR sky130_fd_sc_hd__fill_8
* cell instance sky130_fd_sc_hd__fill_8_1982 r0 *1 0,0
Xsky130_fd_sc_hd__fill_8_1982 VGND VPWR VPWR sky130_fd_sc_hd__fill_8
* cell instance sky130_fd_sc_hd__fill_8_1983 r0 *1 0,0
Xsky130_fd_sc_hd__fill_8_1983 VGND VPWR VPWR sky130_fd_sc_hd__fill_8
* cell instance sky130_fd_sc_hd__fill_8_1984 r0 *1 0,0
Xsky130_fd_sc_hd__fill_8_1984 VGND VPWR VPWR sky130_fd_sc_hd__fill_8
* cell instance sky130_fd_sc_hd__fill_8_1985 r0 *1 0,0
Xsky130_fd_sc_hd__fill_8_1985 VGND VPWR VPWR sky130_fd_sc_hd__fill_8
* cell instance sky130_fd_sc_hd__fill_8_1986 r0 *1 0,0
Xsky130_fd_sc_hd__fill_8_1986 VGND VPWR VPWR sky130_fd_sc_hd__fill_8
* cell instance sky130_fd_sc_hd__fill_8_1987 r0 *1 0,0
Xsky130_fd_sc_hd__fill_8_1987 VGND VPWR VPWR sky130_fd_sc_hd__fill_8
* cell instance sky130_fd_sc_hd__fill_8_1988 r0 *1 0,0
Xsky130_fd_sc_hd__fill_8_1988 VGND VPWR VPWR sky130_fd_sc_hd__fill_8
* cell instance sky130_fd_sc_hd__fill_8_1989 r0 *1 0,0
Xsky130_fd_sc_hd__fill_8_1989 VGND VPWR VPWR sky130_fd_sc_hd__fill_8
* cell instance sky130_fd_sc_hd__fill_8_1990 r0 *1 0,0
Xsky130_fd_sc_hd__fill_8_1990 VGND VPWR VPWR sky130_fd_sc_hd__fill_8
* cell instance sky130_fd_sc_hd__fill_8_1991 r0 *1 0,0
Xsky130_fd_sc_hd__fill_8_1991 VGND VPWR VPWR sky130_fd_sc_hd__fill_8
* cell instance sky130_fd_sc_hd__fill_8_1992 r0 *1 0,0
Xsky130_fd_sc_hd__fill_8_1992 VGND VPWR VPWR sky130_fd_sc_hd__fill_8
* cell instance sky130_fd_sc_hd__fill_8_1993 r0 *1 0,0
Xsky130_fd_sc_hd__fill_8_1993 VGND VPWR VPWR sky130_fd_sc_hd__fill_8
* cell instance sky130_fd_sc_hd__fill_8_1994 r0 *1 0,0
Xsky130_fd_sc_hd__fill_8_1994 VGND VPWR VPWR sky130_fd_sc_hd__fill_8
* cell instance sky130_fd_sc_hd__fill_8_1995 r0 *1 0,0
Xsky130_fd_sc_hd__fill_8_1995 VGND VPWR VPWR sky130_fd_sc_hd__fill_8
* cell instance sky130_fd_sc_hd__fill_8_1996 r0 *1 0,0
Xsky130_fd_sc_hd__fill_8_1996 VGND VPWR VPWR sky130_fd_sc_hd__fill_8
* cell instance sky130_fd_sc_hd__fill_8_1997 r0 *1 0,0
Xsky130_fd_sc_hd__fill_8_1997 VGND VPWR VPWR sky130_fd_sc_hd__fill_8
* cell instance sky130_fd_sc_hd__fill_8_1998 r0 *1 0,0
Xsky130_fd_sc_hd__fill_8_1998 VGND VPWR VPWR sky130_fd_sc_hd__fill_8
* cell instance sky130_fd_sc_hd__fill_8_1999 r0 *1 0,0
Xsky130_fd_sc_hd__fill_8_1999 VGND VPWR VPWR sky130_fd_sc_hd__fill_8
* cell instance sky130_fd_sc_hd__fill_8_2000 r0 *1 0,0
Xsky130_fd_sc_hd__fill_8_2000 VGND VPWR VPWR sky130_fd_sc_hd__fill_8
* cell instance sky130_fd_sc_hd__fill_8_2001 r0 *1 0,0
Xsky130_fd_sc_hd__fill_8_2001 VGND VPWR VPWR sky130_fd_sc_hd__fill_8
* cell instance sky130_fd_sc_hd__fill_8_2002 r0 *1 0,0
Xsky130_fd_sc_hd__fill_8_2002 VGND VPWR VPWR sky130_fd_sc_hd__fill_8
* cell instance sky130_fd_sc_hd__fill_8_2003 r0 *1 0,0
Xsky130_fd_sc_hd__fill_8_2003 VGND VPWR VPWR sky130_fd_sc_hd__fill_8
* cell instance sky130_fd_sc_hd__fill_8_2004 r0 *1 0,0
Xsky130_fd_sc_hd__fill_8_2004 VGND VPWR VPWR sky130_fd_sc_hd__fill_8
* cell instance sky130_fd_sc_hd__fill_8_2005 r0 *1 0,0
Xsky130_fd_sc_hd__fill_8_2005 VGND VPWR VPWR sky130_fd_sc_hd__fill_8
* cell instance sky130_fd_sc_hd__fill_8_2006 r0 *1 0,0
Xsky130_fd_sc_hd__fill_8_2006 VGND VPWR VPWR sky130_fd_sc_hd__fill_8
* cell instance sky130_fd_sc_hd__fill_8_2007 r0 *1 0,0
Xsky130_fd_sc_hd__fill_8_2007 VGND VPWR VPWR sky130_fd_sc_hd__fill_8
* cell instance sky130_fd_sc_hd__fill_8_2008 r0 *1 0,0
Xsky130_fd_sc_hd__fill_8_2008 VGND VPWR VPWR sky130_fd_sc_hd__fill_8
* cell instance sky130_fd_sc_hd__fill_8_2009 r0 *1 0,0
Xsky130_fd_sc_hd__fill_8_2009 VGND VPWR VPWR sky130_fd_sc_hd__fill_8
* cell instance sky130_fd_sc_hd__fill_8_2010 r0 *1 0,0
Xsky130_fd_sc_hd__fill_8_2010 VGND VPWR VPWR sky130_fd_sc_hd__fill_8
* cell instance sky130_fd_sc_hd__fill_8_2011 r0 *1 0,0
Xsky130_fd_sc_hd__fill_8_2011 VGND VPWR VPWR sky130_fd_sc_hd__fill_8
* cell instance sky130_fd_sc_hd__fill_8_2012 r0 *1 0,0
Xsky130_fd_sc_hd__fill_8_2012 VGND VPWR VPWR sky130_fd_sc_hd__fill_8
* cell instance sky130_fd_sc_hd__fill_8_2013 r0 *1 0,0
Xsky130_fd_sc_hd__fill_8_2013 VGND VPWR VPWR sky130_fd_sc_hd__fill_8
* cell instance sky130_fd_sc_hd__fill_8_2014 r0 *1 0,0
Xsky130_fd_sc_hd__fill_8_2014 VGND VPWR VPWR sky130_fd_sc_hd__fill_8
* cell instance sky130_fd_sc_hd__fill_8_2015 r0 *1 0,0
Xsky130_fd_sc_hd__fill_8_2015 VGND VPWR VPWR sky130_fd_sc_hd__fill_8
* cell instance sky130_fd_sc_hd__fill_8_2016 r0 *1 0,0
Xsky130_fd_sc_hd__fill_8_2016 VGND VPWR VPWR sky130_fd_sc_hd__fill_8
* cell instance sky130_fd_sc_hd__fill_8_2017 r0 *1 0,0
Xsky130_fd_sc_hd__fill_8_2017 VGND VPWR VPWR sky130_fd_sc_hd__fill_8
* cell instance sky130_fd_sc_hd__fill_8_2018 r0 *1 0,0
Xsky130_fd_sc_hd__fill_8_2018 VGND VPWR VPWR sky130_fd_sc_hd__fill_8
* cell instance sky130_fd_sc_hd__fill_8_2019 r0 *1 0,0
Xsky130_fd_sc_hd__fill_8_2019 VGND VPWR VPWR sky130_fd_sc_hd__fill_8
* cell instance sky130_fd_sc_hd__fill_8_2020 r0 *1 0,0
Xsky130_fd_sc_hd__fill_8_2020 VGND VPWR VPWR sky130_fd_sc_hd__fill_8
* cell instance sky130_fd_sc_hd__fill_8_2021 r0 *1 0,0
Xsky130_fd_sc_hd__fill_8_2021 VGND VPWR VPWR sky130_fd_sc_hd__fill_8
* cell instance sky130_fd_sc_hd__fill_8_2022 r0 *1 0,0
Xsky130_fd_sc_hd__fill_8_2022 VGND VPWR VPWR sky130_fd_sc_hd__fill_8
* cell instance sky130_fd_sc_hd__fill_8_2023 r0 *1 0,0
Xsky130_fd_sc_hd__fill_8_2023 VGND VPWR VPWR sky130_fd_sc_hd__fill_8
* cell instance sky130_fd_sc_hd__fill_8_2024 r0 *1 0,0
Xsky130_fd_sc_hd__fill_8_2024 VGND VPWR VPWR sky130_fd_sc_hd__fill_8
* cell instance sky130_fd_sc_hd__fill_8_2025 r0 *1 0,0
Xsky130_fd_sc_hd__fill_8_2025 VGND VPWR VPWR sky130_fd_sc_hd__fill_8
* cell instance sky130_fd_sc_hd__fill_8_2026 r0 *1 0,0
Xsky130_fd_sc_hd__fill_8_2026 VGND VPWR VPWR sky130_fd_sc_hd__fill_8
* cell instance sky130_fd_sc_hd__fill_8_2027 r0 *1 0,0
Xsky130_fd_sc_hd__fill_8_2027 VGND VPWR VPWR sky130_fd_sc_hd__fill_8
* cell instance sky130_fd_sc_hd__fill_8_2028 r0 *1 0,0
Xsky130_fd_sc_hd__fill_8_2028 VGND VPWR VPWR sky130_fd_sc_hd__fill_8
* cell instance sky130_fd_sc_hd__fill_8_2029 r0 *1 0,0
Xsky130_fd_sc_hd__fill_8_2029 VGND VPWR VPWR sky130_fd_sc_hd__fill_8
* cell instance sky130_fd_sc_hd__fill_8_2030 r0 *1 0,0
Xsky130_fd_sc_hd__fill_8_2030 VGND VPWR VPWR sky130_fd_sc_hd__fill_8
* cell instance sky130_fd_sc_hd__fill_8_2031 r0 *1 0,0
Xsky130_fd_sc_hd__fill_8_2031 VGND VPWR VPWR sky130_fd_sc_hd__fill_8
* cell instance sky130_fd_sc_hd__fill_8_2032 r0 *1 0,0
Xsky130_fd_sc_hd__fill_8_2032 VGND VPWR VPWR sky130_fd_sc_hd__fill_8
* cell instance sky130_fd_sc_hd__fill_8_2033 r0 *1 0,0
Xsky130_fd_sc_hd__fill_8_2033 VGND VPWR VPWR sky130_fd_sc_hd__fill_8
* cell instance sky130_fd_sc_hd__fill_8_2034 r0 *1 0,0
Xsky130_fd_sc_hd__fill_8_2034 VGND VPWR VPWR sky130_fd_sc_hd__fill_8
* cell instance sky130_fd_sc_hd__fill_8_2035 r0 *1 0,0
Xsky130_fd_sc_hd__fill_8_2035 VGND VPWR VPWR sky130_fd_sc_hd__fill_8
* cell instance sky130_fd_sc_hd__fill_8_2036 r0 *1 0,0
Xsky130_fd_sc_hd__fill_8_2036 VGND VPWR VPWR sky130_fd_sc_hd__fill_8
* cell instance sky130_fd_sc_hd__fill_8_2037 r0 *1 0,0
Xsky130_fd_sc_hd__fill_8_2037 VGND VPWR VPWR sky130_fd_sc_hd__fill_8
* cell instance sky130_fd_sc_hd__fill_8_2038 r0 *1 0,0
Xsky130_fd_sc_hd__fill_8_2038 VGND VPWR VPWR sky130_fd_sc_hd__fill_8
* cell instance sky130_fd_sc_hd__fill_8_2039 r0 *1 0,0
Xsky130_fd_sc_hd__fill_8_2039 VGND VPWR VPWR sky130_fd_sc_hd__fill_8
* cell instance sky130_fd_sc_hd__fill_8_2040 r0 *1 0,0
Xsky130_fd_sc_hd__fill_8_2040 VGND VPWR VPWR sky130_fd_sc_hd__fill_8
* cell instance sky130_fd_sc_hd__fill_8_2041 r0 *1 0,0
Xsky130_fd_sc_hd__fill_8_2041 VGND VPWR VPWR sky130_fd_sc_hd__fill_8
* cell instance sky130_fd_sc_hd__fill_8_2042 r0 *1 0,0
Xsky130_fd_sc_hd__fill_8_2042 VGND VPWR VPWR sky130_fd_sc_hd__fill_8
* cell instance sky130_fd_sc_hd__fill_8_2043 r0 *1 0,0
Xsky130_fd_sc_hd__fill_8_2043 VGND VPWR VPWR sky130_fd_sc_hd__fill_8
* cell instance sky130_fd_sc_hd__fill_8_2044 r0 *1 0,0
Xsky130_fd_sc_hd__fill_8_2044 VGND VPWR VPWR sky130_fd_sc_hd__fill_8
* cell instance sky130_fd_sc_hd__fill_8_2045 r0 *1 0,0
Xsky130_fd_sc_hd__fill_8_2045 VGND VPWR VPWR sky130_fd_sc_hd__fill_8
* cell instance sky130_fd_sc_hd__fill_8_2046 r0 *1 0,0
Xsky130_fd_sc_hd__fill_8_2046 VGND VPWR VPWR sky130_fd_sc_hd__fill_8
* cell instance sky130_fd_sc_hd__fill_8_2047 r0 *1 0,0
Xsky130_fd_sc_hd__fill_8_2047 VGND VPWR VPWR sky130_fd_sc_hd__fill_8
* cell instance sky130_fd_sc_hd__fill_8_2048 r0 *1 0,0
Xsky130_fd_sc_hd__fill_8_2048 VGND VPWR VPWR sky130_fd_sc_hd__fill_8
* cell instance sky130_fd_sc_hd__fill_8_2049 r0 *1 0,0
Xsky130_fd_sc_hd__fill_8_2049 VGND VPWR VPWR sky130_fd_sc_hd__fill_8
* cell instance sky130_fd_sc_hd__fill_8_2050 r0 *1 0,0
Xsky130_fd_sc_hd__fill_8_2050 VGND VPWR VPWR sky130_fd_sc_hd__fill_8
* cell instance sky130_fd_sc_hd__fill_8_2051 r0 *1 0,0
Xsky130_fd_sc_hd__fill_8_2051 VGND VPWR VPWR sky130_fd_sc_hd__fill_8
* cell instance sky130_fd_sc_hd__fill_8_2052 r0 *1 0,0
Xsky130_fd_sc_hd__fill_8_2052 VGND VPWR VPWR sky130_fd_sc_hd__fill_8
* cell instance sky130_fd_sc_hd__fill_8_2053 r0 *1 0,0
Xsky130_fd_sc_hd__fill_8_2053 VGND VPWR VPWR sky130_fd_sc_hd__fill_8
* cell instance sky130_fd_sc_hd__fill_8_2054 r0 *1 0,0
Xsky130_fd_sc_hd__fill_8_2054 VGND VPWR VPWR sky130_fd_sc_hd__fill_8
* cell instance sky130_fd_sc_hd__fill_8_2055 r0 *1 0,0
Xsky130_fd_sc_hd__fill_8_2055 VGND VPWR VPWR sky130_fd_sc_hd__fill_8
* cell instance sky130_fd_sc_hd__fill_8_2056 r0 *1 0,0
Xsky130_fd_sc_hd__fill_8_2056 VGND VPWR VPWR sky130_fd_sc_hd__fill_8
* cell instance sky130_fd_sc_hd__fill_8_2057 r0 *1 0,0
Xsky130_fd_sc_hd__fill_8_2057 VGND VPWR VPWR sky130_fd_sc_hd__fill_8
* cell instance sky130_fd_sc_hd__fill_8_2058 r0 *1 0,0
Xsky130_fd_sc_hd__fill_8_2058 VGND VPWR VPWR sky130_fd_sc_hd__fill_8
* cell instance sky130_fd_sc_hd__fill_8_2059 r0 *1 0,0
Xsky130_fd_sc_hd__fill_8_2059 VGND VPWR VPWR sky130_fd_sc_hd__fill_8
* cell instance sky130_fd_sc_hd__fill_8_2060 r0 *1 0,0
Xsky130_fd_sc_hd__fill_8_2060 VGND VPWR VPWR sky130_fd_sc_hd__fill_8
* cell instance sky130_fd_sc_hd__fill_8_2061 r0 *1 0,0
Xsky130_fd_sc_hd__fill_8_2061 VGND VPWR VPWR sky130_fd_sc_hd__fill_8
* cell instance sky130_fd_sc_hd__fill_8_2062 r0 *1 0,0
Xsky130_fd_sc_hd__fill_8_2062 VGND VPWR VPWR sky130_fd_sc_hd__fill_8
* cell instance sky130_fd_sc_hd__fill_8_2063 r0 *1 0,0
Xsky130_fd_sc_hd__fill_8_2063 VGND VPWR VPWR sky130_fd_sc_hd__fill_8
* cell instance sky130_fd_sc_hd__fill_8_2064 r0 *1 0,0
Xsky130_fd_sc_hd__fill_8_2064 VGND VPWR VPWR sky130_fd_sc_hd__fill_8
* cell instance sky130_fd_sc_hd__fill_8_2065 r0 *1 0,0
Xsky130_fd_sc_hd__fill_8_2065 VGND VPWR VPWR sky130_fd_sc_hd__fill_8
* cell instance sky130_fd_sc_hd__fill_8_2066 r0 *1 0,0
Xsky130_fd_sc_hd__fill_8_2066 VGND VPWR VPWR sky130_fd_sc_hd__fill_8
* cell instance sky130_fd_sc_hd__fill_8_2067 r0 *1 0,0
Xsky130_fd_sc_hd__fill_8_2067 VGND VPWR VPWR sky130_fd_sc_hd__fill_8
* cell instance sky130_fd_sc_hd__fill_8_2068 r0 *1 0,0
Xsky130_fd_sc_hd__fill_8_2068 VGND VPWR VPWR sky130_fd_sc_hd__fill_8
* cell instance sky130_fd_sc_hd__fill_8_2069 r0 *1 0,0
Xsky130_fd_sc_hd__fill_8_2069 VGND VPWR VPWR sky130_fd_sc_hd__fill_8
* cell instance sky130_fd_sc_hd__fill_8_2070 r0 *1 0,0
Xsky130_fd_sc_hd__fill_8_2070 VGND VPWR VPWR sky130_fd_sc_hd__fill_8
* cell instance sky130_fd_sc_hd__fill_8_2071 r0 *1 0,0
Xsky130_fd_sc_hd__fill_8_2071 VGND VPWR VPWR sky130_fd_sc_hd__fill_8
* cell instance sky130_fd_sc_hd__fill_8_2072 r0 *1 0,0
Xsky130_fd_sc_hd__fill_8_2072 VGND VPWR VPWR sky130_fd_sc_hd__fill_8
* cell instance sky130_fd_sc_hd__fill_8_2073 r0 *1 0,0
Xsky130_fd_sc_hd__fill_8_2073 VGND VPWR VPWR sky130_fd_sc_hd__fill_8
* cell instance sky130_fd_sc_hd__fill_8_2074 r0 *1 0,0
Xsky130_fd_sc_hd__fill_8_2074 VGND VPWR VPWR sky130_fd_sc_hd__fill_8
* cell instance sky130_fd_sc_hd__fill_8_2075 r0 *1 0,0
Xsky130_fd_sc_hd__fill_8_2075 VGND VPWR VPWR sky130_fd_sc_hd__fill_8
* cell instance sky130_fd_sc_hd__fill_8_2076 r0 *1 0,0
Xsky130_fd_sc_hd__fill_8_2076 VGND VPWR VPWR sky130_fd_sc_hd__fill_8
* cell instance sky130_fd_sc_hd__fill_8_2077 r0 *1 0,0
Xsky130_fd_sc_hd__fill_8_2077 VGND VPWR VPWR sky130_fd_sc_hd__fill_8
* cell instance sky130_fd_sc_hd__fill_8_2078 r0 *1 0,0
Xsky130_fd_sc_hd__fill_8_2078 VGND VPWR VPWR sky130_fd_sc_hd__fill_8
* cell instance sky130_fd_sc_hd__fill_8_2079 r0 *1 0,0
Xsky130_fd_sc_hd__fill_8_2079 VGND VPWR VPWR sky130_fd_sc_hd__fill_8
* cell instance sky130_fd_sc_hd__fill_8_2080 r0 *1 0,0
Xsky130_fd_sc_hd__fill_8_2080 VGND VPWR VPWR sky130_fd_sc_hd__fill_8
* cell instance sky130_fd_sc_hd__fill_8_2081 r0 *1 0,0
Xsky130_fd_sc_hd__fill_8_2081 VGND VPWR VPWR sky130_fd_sc_hd__fill_8
* cell instance sky130_fd_sc_hd__fill_8_2082 r0 *1 0,0
Xsky130_fd_sc_hd__fill_8_2082 VGND VPWR VPWR sky130_fd_sc_hd__fill_8
* cell instance sky130_fd_sc_hd__fill_8_2083 r0 *1 0,0
Xsky130_fd_sc_hd__fill_8_2083 VGND VPWR VPWR sky130_fd_sc_hd__fill_8
* cell instance sky130_fd_sc_hd__fill_8_2084 r0 *1 0,0
Xsky130_fd_sc_hd__fill_8_2084 VGND VPWR VPWR sky130_fd_sc_hd__fill_8
* cell instance sky130_fd_sc_hd__fill_8_2085 r0 *1 0,0
Xsky130_fd_sc_hd__fill_8_2085 VGND VPWR VPWR sky130_fd_sc_hd__fill_8
* cell instance sky130_fd_sc_hd__fill_8_2086 r0 *1 0,0
Xsky130_fd_sc_hd__fill_8_2086 VGND VPWR VPWR sky130_fd_sc_hd__fill_8
* cell instance sky130_fd_sc_hd__fill_8_2087 r0 *1 0,0
Xsky130_fd_sc_hd__fill_8_2087 VGND VPWR VPWR sky130_fd_sc_hd__fill_8
* cell instance sky130_fd_sc_hd__fill_8_2088 r0 *1 0,0
Xsky130_fd_sc_hd__fill_8_2088 VGND VPWR VPWR sky130_fd_sc_hd__fill_8
* cell instance sky130_fd_sc_hd__fill_8_2089 r0 *1 0,0
Xsky130_fd_sc_hd__fill_8_2089 VGND VPWR VPWR sky130_fd_sc_hd__fill_8
* cell instance sky130_fd_sc_hd__fill_8_2090 r0 *1 0,0
Xsky130_fd_sc_hd__fill_8_2090 VGND VPWR VPWR sky130_fd_sc_hd__fill_8
* cell instance sky130_fd_sc_hd__fill_8_2091 r0 *1 0,0
Xsky130_fd_sc_hd__fill_8_2091 VGND VPWR VPWR sky130_fd_sc_hd__fill_8
* cell instance sky130_fd_sc_hd__fill_8_2092 r0 *1 0,0
Xsky130_fd_sc_hd__fill_8_2092 VGND VPWR VPWR sky130_fd_sc_hd__fill_8
* cell instance sky130_fd_sc_hd__fill_8_2093 r0 *1 0,0
Xsky130_fd_sc_hd__fill_8_2093 VGND VPWR VPWR sky130_fd_sc_hd__fill_8
* cell instance sky130_fd_sc_hd__fill_8_2094 r0 *1 0,0
Xsky130_fd_sc_hd__fill_8_2094 VGND VPWR VPWR sky130_fd_sc_hd__fill_8
* cell instance sky130_fd_sc_hd__fill_8_2095 r0 *1 0,0
Xsky130_fd_sc_hd__fill_8_2095 VGND VPWR VPWR sky130_fd_sc_hd__fill_8
* cell instance sky130_fd_sc_hd__fill_8_2096 r0 *1 0,0
Xsky130_fd_sc_hd__fill_8_2096 VGND VPWR VPWR sky130_fd_sc_hd__fill_8
* cell instance sky130_fd_sc_hd__fill_8_2097 r0 *1 0,0
Xsky130_fd_sc_hd__fill_8_2097 VGND VPWR VPWR sky130_fd_sc_hd__fill_8
* cell instance sky130_fd_sc_hd__fill_8_2098 r0 *1 0,0
Xsky130_fd_sc_hd__fill_8_2098 VGND VPWR VPWR sky130_fd_sc_hd__fill_8
* cell instance sky130_fd_sc_hd__fill_8_2099 r0 *1 0,0
Xsky130_fd_sc_hd__fill_8_2099 VGND VPWR VPWR sky130_fd_sc_hd__fill_8
* cell instance sky130_fd_sc_hd__fill_8_2100 r0 *1 0,0
Xsky130_fd_sc_hd__fill_8_2100 VGND VPWR VPWR sky130_fd_sc_hd__fill_8
* cell instance sky130_fd_sc_hd__fill_8_2101 r0 *1 0,0
Xsky130_fd_sc_hd__fill_8_2101 VGND VPWR VPWR sky130_fd_sc_hd__fill_8
* cell instance sky130_fd_sc_hd__fill_8_2102 r0 *1 0,0
Xsky130_fd_sc_hd__fill_8_2102 VGND VPWR VPWR sky130_fd_sc_hd__fill_8
* cell instance sky130_fd_sc_hd__fill_8_2103 r0 *1 0,0
Xsky130_fd_sc_hd__fill_8_2103 VGND VPWR VPWR sky130_fd_sc_hd__fill_8
* cell instance sky130_fd_sc_hd__fill_8_2104 r0 *1 0,0
Xsky130_fd_sc_hd__fill_8_2104 VGND VPWR VPWR sky130_fd_sc_hd__fill_8
* cell instance sky130_fd_sc_hd__fill_8_2105 r0 *1 0,0
Xsky130_fd_sc_hd__fill_8_2105 VGND VPWR VPWR sky130_fd_sc_hd__fill_8
* cell instance sky130_fd_sc_hd__fill_8_2106 r0 *1 0,0
Xsky130_fd_sc_hd__fill_8_2106 VGND VPWR VPWR sky130_fd_sc_hd__fill_8
* cell instance sky130_fd_sc_hd__fill_8_2107 r0 *1 0,0
Xsky130_fd_sc_hd__fill_8_2107 VGND VPWR VPWR sky130_fd_sc_hd__fill_8
* cell instance sky130_fd_sc_hd__fill_8_2108 r0 *1 0,0
Xsky130_fd_sc_hd__fill_8_2108 VGND VPWR VPWR sky130_fd_sc_hd__fill_8
* cell instance sky130_fd_sc_hd__fill_8_2109 r0 *1 0,0
Xsky130_fd_sc_hd__fill_8_2109 VGND VPWR VPWR sky130_fd_sc_hd__fill_8
* cell instance sky130_fd_sc_hd__fill_8_2110 r0 *1 0,0
Xsky130_fd_sc_hd__fill_8_2110 VGND VPWR VPWR sky130_fd_sc_hd__fill_8
* cell instance sky130_fd_sc_hd__fill_8_2111 r0 *1 0,0
Xsky130_fd_sc_hd__fill_8_2111 VGND VPWR VPWR sky130_fd_sc_hd__fill_8
* cell instance sky130_fd_sc_hd__fill_8_2112 r0 *1 0,0
Xsky130_fd_sc_hd__fill_8_2112 VGND VPWR VPWR sky130_fd_sc_hd__fill_8
* cell instance sky130_fd_sc_hd__fill_8_2113 r0 *1 0,0
Xsky130_fd_sc_hd__fill_8_2113 VGND VPWR VPWR sky130_fd_sc_hd__fill_8
* cell instance sky130_fd_sc_hd__fill_8_2114 r0 *1 0,0
Xsky130_fd_sc_hd__fill_8_2114 VGND VPWR VPWR sky130_fd_sc_hd__fill_8
* cell instance sky130_fd_sc_hd__fill_8_2115 r0 *1 0,0
Xsky130_fd_sc_hd__fill_8_2115 VGND VPWR VPWR sky130_fd_sc_hd__fill_8
* cell instance sky130_fd_sc_hd__fill_8_2116 r0 *1 0,0
Xsky130_fd_sc_hd__fill_8_2116 VGND VPWR VPWR sky130_fd_sc_hd__fill_8
* cell instance sky130_fd_sc_hd__fill_8_2117 r0 *1 0,0
Xsky130_fd_sc_hd__fill_8_2117 VGND VPWR VPWR sky130_fd_sc_hd__fill_8
* cell instance sky130_fd_sc_hd__fill_8_2118 r0 *1 0,0
Xsky130_fd_sc_hd__fill_8_2118 VGND VPWR VPWR sky130_fd_sc_hd__fill_8
* cell instance sky130_fd_sc_hd__fill_8_2119 r0 *1 0,0
Xsky130_fd_sc_hd__fill_8_2119 VGND VPWR VPWR sky130_fd_sc_hd__fill_8
* cell instance sky130_fd_sc_hd__fill_8_2120 r0 *1 0,0
Xsky130_fd_sc_hd__fill_8_2120 VGND VPWR VPWR sky130_fd_sc_hd__fill_8
* cell instance sky130_fd_sc_hd__fill_8_2121 r0 *1 0,0
Xsky130_fd_sc_hd__fill_8_2121 VGND VPWR VPWR sky130_fd_sc_hd__fill_8
* cell instance sky130_fd_sc_hd__fill_8_2122 r0 *1 0,0
Xsky130_fd_sc_hd__fill_8_2122 VGND VPWR VPWR sky130_fd_sc_hd__fill_8
* cell instance sky130_fd_sc_hd__fill_8_2123 r0 *1 0,0
Xsky130_fd_sc_hd__fill_8_2123 VGND VPWR VPWR sky130_fd_sc_hd__fill_8
* cell instance sky130_fd_sc_hd__fill_8_2124 r0 *1 0,0
Xsky130_fd_sc_hd__fill_8_2124 VGND VPWR VPWR sky130_fd_sc_hd__fill_8
* cell instance sky130_fd_sc_hd__fill_8_2125 r0 *1 0,0
Xsky130_fd_sc_hd__fill_8_2125 VGND VPWR VPWR sky130_fd_sc_hd__fill_8
* cell instance sky130_fd_sc_hd__fill_8_2126 r0 *1 0,0
Xsky130_fd_sc_hd__fill_8_2126 VGND VPWR VPWR sky130_fd_sc_hd__fill_8
* cell instance sky130_fd_sc_hd__fill_8_2127 r0 *1 0,0
Xsky130_fd_sc_hd__fill_8_2127 VGND VPWR VPWR sky130_fd_sc_hd__fill_8
* cell instance sky130_fd_sc_hd__fill_8_2128 r0 *1 0,0
Xsky130_fd_sc_hd__fill_8_2128 VGND VPWR VPWR sky130_fd_sc_hd__fill_8
* cell instance sky130_fd_sc_hd__fill_8_2129 r0 *1 0,0
Xsky130_fd_sc_hd__fill_8_2129 VGND VPWR VPWR sky130_fd_sc_hd__fill_8
* cell instance sky130_fd_sc_hd__fill_8_2130 r0 *1 0,0
Xsky130_fd_sc_hd__fill_8_2130 VGND VPWR VPWR sky130_fd_sc_hd__fill_8
* cell instance sky130_fd_sc_hd__fill_8_2131 r0 *1 0,0
Xsky130_fd_sc_hd__fill_8_2131 VGND VPWR VPWR sky130_fd_sc_hd__fill_8
* cell instance sky130_fd_sc_hd__fill_8_2132 r0 *1 0,0
Xsky130_fd_sc_hd__fill_8_2132 VGND VPWR VPWR sky130_fd_sc_hd__fill_8
* cell instance sky130_fd_sc_hd__fill_8_2133 r0 *1 0,0
Xsky130_fd_sc_hd__fill_8_2133 VGND VPWR VPWR sky130_fd_sc_hd__fill_8
* cell instance sky130_fd_sc_hd__fill_8_2134 r0 *1 0,0
Xsky130_fd_sc_hd__fill_8_2134 VGND VPWR VPWR sky130_fd_sc_hd__fill_8
* cell instance sky130_fd_sc_hd__fill_8_2135 r0 *1 0,0
Xsky130_fd_sc_hd__fill_8_2135 VGND VPWR VPWR sky130_fd_sc_hd__fill_8
* cell instance sky130_fd_sc_hd__fill_8_2136 r0 *1 0,0
Xsky130_fd_sc_hd__fill_8_2136 VGND VPWR VPWR sky130_fd_sc_hd__fill_8
* cell instance sky130_fd_sc_hd__fill_8_2137 r0 *1 0,0
Xsky130_fd_sc_hd__fill_8_2137 VGND VPWR VPWR sky130_fd_sc_hd__fill_8
* cell instance sky130_fd_sc_hd__fill_8_2138 r0 *1 0,0
Xsky130_fd_sc_hd__fill_8_2138 VGND VPWR VPWR sky130_fd_sc_hd__fill_8
* cell instance sky130_fd_sc_hd__fill_8_2139 r0 *1 0,0
Xsky130_fd_sc_hd__fill_8_2139 VGND VPWR VPWR sky130_fd_sc_hd__fill_8
* cell instance sky130_fd_sc_hd__fill_8_2140 r0 *1 0,0
Xsky130_fd_sc_hd__fill_8_2140 VGND VPWR VPWR sky130_fd_sc_hd__fill_8
* cell instance sky130_fd_sc_hd__fill_8_2141 r0 *1 0,0
Xsky130_fd_sc_hd__fill_8_2141 VGND VPWR VPWR sky130_fd_sc_hd__fill_8
* cell instance sky130_fd_sc_hd__fill_8_2142 r0 *1 0,0
Xsky130_fd_sc_hd__fill_8_2142 VGND VPWR VPWR sky130_fd_sc_hd__fill_8
* cell instance sky130_fd_sc_hd__fill_8_2143 r0 *1 0,0
Xsky130_fd_sc_hd__fill_8_2143 VGND VPWR VPWR sky130_fd_sc_hd__fill_8
* cell instance sky130_fd_sc_hd__fill_8_2144 r0 *1 0,0
Xsky130_fd_sc_hd__fill_8_2144 VGND VPWR VPWR sky130_fd_sc_hd__fill_8
* cell instance sky130_fd_sc_hd__fill_8_2145 r0 *1 0,0
Xsky130_fd_sc_hd__fill_8_2145 VGND VPWR VPWR sky130_fd_sc_hd__fill_8
* cell instance sky130_fd_sc_hd__fill_8_2146 r0 *1 0,0
Xsky130_fd_sc_hd__fill_8_2146 VGND VPWR VPWR sky130_fd_sc_hd__fill_8
* cell instance sky130_fd_sc_hd__fill_8_2147 r0 *1 0,0
Xsky130_fd_sc_hd__fill_8_2147 VGND VPWR VPWR sky130_fd_sc_hd__fill_8
* cell instance sky130_fd_sc_hd__fill_8_2148 r0 *1 0,0
Xsky130_fd_sc_hd__fill_8_2148 VGND VPWR VPWR sky130_fd_sc_hd__fill_8
* cell instance sky130_fd_sc_hd__fill_8_2149 r0 *1 0,0
Xsky130_fd_sc_hd__fill_8_2149 VGND VPWR VPWR sky130_fd_sc_hd__fill_8
* cell instance sky130_fd_sc_hd__fill_8_2150 r0 *1 0,0
Xsky130_fd_sc_hd__fill_8_2150 VGND VPWR VPWR sky130_fd_sc_hd__fill_8
* cell instance sky130_fd_sc_hd__fill_8_2151 r0 *1 0,0
Xsky130_fd_sc_hd__fill_8_2151 VGND VPWR VPWR sky130_fd_sc_hd__fill_8
* cell instance sky130_fd_sc_hd__fill_8_2152 r0 *1 0,0
Xsky130_fd_sc_hd__fill_8_2152 VGND VPWR VPWR sky130_fd_sc_hd__fill_8
* cell instance sky130_fd_sc_hd__fill_8_2153 r0 *1 0,0
Xsky130_fd_sc_hd__fill_8_2153 VGND VPWR VPWR sky130_fd_sc_hd__fill_8
* cell instance sky130_fd_sc_hd__fill_8_2154 r0 *1 0,0
Xsky130_fd_sc_hd__fill_8_2154 VGND VPWR VPWR sky130_fd_sc_hd__fill_8
* cell instance sky130_fd_sc_hd__fill_8_2155 r0 *1 0,0
Xsky130_fd_sc_hd__fill_8_2155 VGND VPWR VPWR sky130_fd_sc_hd__fill_8
* cell instance sky130_fd_sc_hd__fill_8_2156 r0 *1 0,0
Xsky130_fd_sc_hd__fill_8_2156 VGND VPWR VPWR sky130_fd_sc_hd__fill_8
* cell instance sky130_fd_sc_hd__fill_8_2157 r0 *1 0,0
Xsky130_fd_sc_hd__fill_8_2157 VGND VPWR VPWR sky130_fd_sc_hd__fill_8
* cell instance sky130_fd_sc_hd__fill_8_2158 r0 *1 0,0
Xsky130_fd_sc_hd__fill_8_2158 VGND VPWR VPWR sky130_fd_sc_hd__fill_8
* cell instance sky130_fd_sc_hd__fill_8_2159 r0 *1 0,0
Xsky130_fd_sc_hd__fill_8_2159 VGND VPWR VPWR sky130_fd_sc_hd__fill_8
* cell instance sky130_fd_sc_hd__fill_8_2160 r0 *1 0,0
Xsky130_fd_sc_hd__fill_8_2160 VGND VPWR VPWR sky130_fd_sc_hd__fill_8
* cell instance sky130_fd_sc_hd__fill_8_2161 r0 *1 0,0
Xsky130_fd_sc_hd__fill_8_2161 VGND VPWR VPWR sky130_fd_sc_hd__fill_8
* cell instance sky130_fd_sc_hd__fill_8_2162 r0 *1 0,0
Xsky130_fd_sc_hd__fill_8_2162 VGND VPWR VPWR sky130_fd_sc_hd__fill_8
* cell instance sky130_fd_sc_hd__fill_8_2163 r0 *1 0,0
Xsky130_fd_sc_hd__fill_8_2163 VGND VPWR VPWR sky130_fd_sc_hd__fill_8
* cell instance sky130_fd_sc_hd__fill_8_2164 r0 *1 0,0
Xsky130_fd_sc_hd__fill_8_2164 VGND VPWR VPWR sky130_fd_sc_hd__fill_8
* cell instance sky130_fd_sc_hd__fill_8_2165 r0 *1 0,0
Xsky130_fd_sc_hd__fill_8_2165 VGND VPWR VPWR sky130_fd_sc_hd__fill_8
* cell instance sky130_fd_sc_hd__fill_8_2166 r0 *1 0,0
Xsky130_fd_sc_hd__fill_8_2166 VGND VPWR VPWR sky130_fd_sc_hd__fill_8
* cell instance sky130_fd_sc_hd__fill_8_2167 r0 *1 0,0
Xsky130_fd_sc_hd__fill_8_2167 VGND VPWR VPWR sky130_fd_sc_hd__fill_8
* cell instance sky130_fd_sc_hd__fill_8_2168 r0 *1 0,0
Xsky130_fd_sc_hd__fill_8_2168 VGND VPWR VPWR sky130_fd_sc_hd__fill_8
* cell instance sky130_fd_sc_hd__fill_8_2169 r0 *1 0,0
Xsky130_fd_sc_hd__fill_8_2169 VGND VPWR VPWR sky130_fd_sc_hd__fill_8
* cell instance sky130_fd_sc_hd__fill_8_2170 r0 *1 0,0
Xsky130_fd_sc_hd__fill_8_2170 VGND VPWR VPWR sky130_fd_sc_hd__fill_8
* cell instance sky130_fd_sc_hd__fill_8_2171 r0 *1 0,0
Xsky130_fd_sc_hd__fill_8_2171 VGND VPWR VPWR sky130_fd_sc_hd__fill_8
* cell instance sky130_fd_sc_hd__fill_8_2172 r0 *1 0,0
Xsky130_fd_sc_hd__fill_8_2172 VGND VPWR VPWR sky130_fd_sc_hd__fill_8
* cell instance sky130_fd_sc_hd__fill_8_2173 r0 *1 0,0
Xsky130_fd_sc_hd__fill_8_2173 VGND VPWR VPWR sky130_fd_sc_hd__fill_8
* cell instance sky130_fd_sc_hd__fill_8_2174 r0 *1 0,0
Xsky130_fd_sc_hd__fill_8_2174 VGND VPWR VPWR sky130_fd_sc_hd__fill_8
* cell instance sky130_fd_sc_hd__fill_8_2175 r0 *1 0,0
Xsky130_fd_sc_hd__fill_8_2175 VGND VPWR VPWR sky130_fd_sc_hd__fill_8
* cell instance sky130_fd_sc_hd__fill_8_2176 r0 *1 0,0
Xsky130_fd_sc_hd__fill_8_2176 VGND VPWR VPWR sky130_fd_sc_hd__fill_8
* cell instance sky130_fd_sc_hd__fill_8_2177 r0 *1 0,0
Xsky130_fd_sc_hd__fill_8_2177 VGND VPWR VPWR sky130_fd_sc_hd__fill_8
* cell instance sky130_fd_sc_hd__fill_8_2178 r0 *1 0,0
Xsky130_fd_sc_hd__fill_8_2178 VGND VPWR VPWR sky130_fd_sc_hd__fill_8
* cell instance sky130_fd_sc_hd__fill_8_2179 r0 *1 0,0
Xsky130_fd_sc_hd__fill_8_2179 VGND VPWR VPWR sky130_fd_sc_hd__fill_8
* cell instance sky130_fd_sc_hd__fill_8_2180 r0 *1 0,0
Xsky130_fd_sc_hd__fill_8_2180 VGND VPWR VPWR sky130_fd_sc_hd__fill_8
* cell instance sky130_fd_sc_hd__fill_8_2181 r0 *1 0,0
Xsky130_fd_sc_hd__fill_8_2181 VGND VPWR VPWR sky130_fd_sc_hd__fill_8
* cell instance sky130_fd_sc_hd__fill_8_2182 r0 *1 0,0
Xsky130_fd_sc_hd__fill_8_2182 VGND VPWR VPWR sky130_fd_sc_hd__fill_8
* cell instance sky130_fd_sc_hd__fill_8_2183 r0 *1 0,0
Xsky130_fd_sc_hd__fill_8_2183 VGND VPWR VPWR sky130_fd_sc_hd__fill_8
* cell instance sky130_fd_sc_hd__fill_8_2184 r0 *1 0,0
Xsky130_fd_sc_hd__fill_8_2184 VGND VPWR VPWR sky130_fd_sc_hd__fill_8
* cell instance sky130_fd_sc_hd__fill_8_2185 r0 *1 0,0
Xsky130_fd_sc_hd__fill_8_2185 VGND VPWR VPWR sky130_fd_sc_hd__fill_8
* cell instance sky130_fd_sc_hd__fill_8_2186 r0 *1 0,0
Xsky130_fd_sc_hd__fill_8_2186 VGND VPWR VPWR sky130_fd_sc_hd__fill_8
* cell instance sky130_fd_sc_hd__fill_8_2187 r0 *1 0,0
Xsky130_fd_sc_hd__fill_8_2187 VGND VPWR VPWR sky130_fd_sc_hd__fill_8
* cell instance sky130_fd_sc_hd__fill_8_2188 r0 *1 0,0
Xsky130_fd_sc_hd__fill_8_2188 VGND VPWR VPWR sky130_fd_sc_hd__fill_8
* cell instance sky130_fd_sc_hd__fill_8_2189 r0 *1 0,0
Xsky130_fd_sc_hd__fill_8_2189 VGND VPWR VPWR sky130_fd_sc_hd__fill_8
* cell instance sky130_fd_sc_hd__fill_8_2190 r0 *1 0,0
Xsky130_fd_sc_hd__fill_8_2190 VGND VPWR VPWR sky130_fd_sc_hd__fill_8
* cell instance sky130_fd_sc_hd__fill_8_2191 r0 *1 0,0
Xsky130_fd_sc_hd__fill_8_2191 VGND VPWR VPWR sky130_fd_sc_hd__fill_8
* cell instance sky130_fd_sc_hd__fill_8_2192 r0 *1 0,0
Xsky130_fd_sc_hd__fill_8_2192 VGND VPWR VPWR sky130_fd_sc_hd__fill_8
* cell instance sky130_fd_sc_hd__fill_8_2193 r0 *1 0,0
Xsky130_fd_sc_hd__fill_8_2193 VGND VPWR VPWR sky130_fd_sc_hd__fill_8
* cell instance sky130_fd_sc_hd__fill_8_2194 r0 *1 0,0
Xsky130_fd_sc_hd__fill_8_2194 VGND VPWR VPWR sky130_fd_sc_hd__fill_8
* cell instance sky130_fd_sc_hd__fill_8_2195 r0 *1 0,0
Xsky130_fd_sc_hd__fill_8_2195 VGND VPWR VPWR sky130_fd_sc_hd__fill_8
* cell instance sky130_fd_sc_hd__fill_8_2196 r0 *1 0,0
Xsky130_fd_sc_hd__fill_8_2196 VGND VPWR VPWR sky130_fd_sc_hd__fill_8
* cell instance sky130_fd_sc_hd__fill_8_2197 r0 *1 0,0
Xsky130_fd_sc_hd__fill_8_2197 VGND VPWR VPWR sky130_fd_sc_hd__fill_8
* cell instance sky130_fd_sc_hd__fill_8_2198 r0 *1 0,0
Xsky130_fd_sc_hd__fill_8_2198 VGND VPWR VPWR sky130_fd_sc_hd__fill_8
* cell instance sky130_fd_sc_hd__fill_8_2199 r0 *1 0,0
Xsky130_fd_sc_hd__fill_8_2199 VGND VPWR VPWR sky130_fd_sc_hd__fill_8
* cell instance sky130_fd_sc_hd__fill_8_2200 r0 *1 0,0
Xsky130_fd_sc_hd__fill_8_2200 VGND VPWR VPWR sky130_fd_sc_hd__fill_8
* cell instance sky130_fd_sc_hd__fill_8_2201 r0 *1 0,0
Xsky130_fd_sc_hd__fill_8_2201 VGND VPWR VPWR sky130_fd_sc_hd__fill_8
* cell instance sky130_fd_sc_hd__fill_8_2202 r0 *1 0,0
Xsky130_fd_sc_hd__fill_8_2202 VGND VPWR VPWR sky130_fd_sc_hd__fill_8
* cell instance sky130_fd_sc_hd__fill_8_2203 r0 *1 0,0
Xsky130_fd_sc_hd__fill_8_2203 VGND VPWR VPWR sky130_fd_sc_hd__fill_8
* cell instance sky130_fd_sc_hd__fill_8_2204 r0 *1 0,0
Xsky130_fd_sc_hd__fill_8_2204 VGND VPWR VPWR sky130_fd_sc_hd__fill_8
* cell instance sky130_fd_sc_hd__fill_8_2205 r0 *1 0,0
Xsky130_fd_sc_hd__fill_8_2205 VGND VPWR VPWR sky130_fd_sc_hd__fill_8
* cell instance sky130_fd_sc_hd__fill_8_2206 r0 *1 0,0
Xsky130_fd_sc_hd__fill_8_2206 VGND VPWR VPWR sky130_fd_sc_hd__fill_8
* cell instance sky130_fd_sc_hd__fill_8_2207 r0 *1 0,0
Xsky130_fd_sc_hd__fill_8_2207 VGND VPWR VPWR sky130_fd_sc_hd__fill_8
* cell instance sky130_fd_sc_hd__fill_8_2208 r0 *1 0,0
Xsky130_fd_sc_hd__fill_8_2208 VGND VPWR VPWR sky130_fd_sc_hd__fill_8
* cell instance sky130_fd_sc_hd__fill_8_2209 r0 *1 0,0
Xsky130_fd_sc_hd__fill_8_2209 VGND VPWR VPWR sky130_fd_sc_hd__fill_8
* cell instance sky130_fd_sc_hd__fill_8_2210 r0 *1 0,0
Xsky130_fd_sc_hd__fill_8_2210 VGND VPWR VPWR sky130_fd_sc_hd__fill_8
* cell instance sky130_fd_sc_hd__fill_8_2211 r0 *1 0,0
Xsky130_fd_sc_hd__fill_8_2211 VGND VPWR VPWR sky130_fd_sc_hd__fill_8
* cell instance sky130_fd_sc_hd__fill_8_2212 r0 *1 0,0
Xsky130_fd_sc_hd__fill_8_2212 VGND VPWR VPWR sky130_fd_sc_hd__fill_8
* cell instance sky130_fd_sc_hd__fill_8_2213 r0 *1 0,0
Xsky130_fd_sc_hd__fill_8_2213 VGND VPWR VPWR sky130_fd_sc_hd__fill_8
* cell instance sky130_fd_sc_hd__fill_8_2214 r0 *1 0,0
Xsky130_fd_sc_hd__fill_8_2214 VGND VPWR VPWR sky130_fd_sc_hd__fill_8
* cell instance sky130_fd_sc_hd__fill_8_2215 r0 *1 0,0
Xsky130_fd_sc_hd__fill_8_2215 VGND VPWR VPWR sky130_fd_sc_hd__fill_8
* cell instance sky130_fd_sc_hd__fill_8_2216 r0 *1 0,0
Xsky130_fd_sc_hd__fill_8_2216 VGND VPWR VPWR sky130_fd_sc_hd__fill_8
* cell instance sky130_fd_sc_hd__fill_8_2217 r0 *1 0,0
Xsky130_fd_sc_hd__fill_8_2217 VGND VPWR VPWR sky130_fd_sc_hd__fill_8
* cell instance sky130_fd_sc_hd__fill_8_2218 r0 *1 0,0
Xsky130_fd_sc_hd__fill_8_2218 VGND VPWR VPWR sky130_fd_sc_hd__fill_8
* cell instance sky130_fd_sc_hd__fill_8_2219 r0 *1 0,0
Xsky130_fd_sc_hd__fill_8_2219 VGND VPWR VPWR sky130_fd_sc_hd__fill_8
* cell instance sky130_fd_sc_hd__fill_8_2220 r0 *1 0,0
Xsky130_fd_sc_hd__fill_8_2220 VGND VPWR VPWR sky130_fd_sc_hd__fill_8
* cell instance sky130_fd_sc_hd__fill_8_2221 r0 *1 0,0
Xsky130_fd_sc_hd__fill_8_2221 VGND VPWR VPWR sky130_fd_sc_hd__fill_8
* cell instance sky130_fd_sc_hd__fill_8_2222 r0 *1 0,0
Xsky130_fd_sc_hd__fill_8_2222 VGND VPWR VPWR sky130_fd_sc_hd__fill_8
* cell instance sky130_fd_sc_hd__fill_8_2223 r0 *1 0,0
Xsky130_fd_sc_hd__fill_8_2223 VGND VPWR VPWR sky130_fd_sc_hd__fill_8
* cell instance sky130_fd_sc_hd__fill_8_2224 r0 *1 0,0
Xsky130_fd_sc_hd__fill_8_2224 VGND VPWR VPWR sky130_fd_sc_hd__fill_8
* cell instance sky130_fd_sc_hd__fill_8_2225 r0 *1 0,0
Xsky130_fd_sc_hd__fill_8_2225 VGND VPWR VPWR sky130_fd_sc_hd__fill_8
* cell instance sky130_fd_sc_hd__fill_8_2226 r0 *1 0,0
Xsky130_fd_sc_hd__fill_8_2226 VGND VPWR VPWR sky130_fd_sc_hd__fill_8
* cell instance sky130_fd_sc_hd__fill_8_2227 r0 *1 0,0
Xsky130_fd_sc_hd__fill_8_2227 VGND VPWR VPWR sky130_fd_sc_hd__fill_8
* cell instance sky130_fd_sc_hd__fill_8_2228 r0 *1 0,0
Xsky130_fd_sc_hd__fill_8_2228 VGND VPWR VPWR sky130_fd_sc_hd__fill_8
* cell instance sky130_fd_sc_hd__fill_8_2229 r0 *1 0,0
Xsky130_fd_sc_hd__fill_8_2229 VGND VPWR VPWR sky130_fd_sc_hd__fill_8
* cell instance sky130_fd_sc_hd__fill_8_2230 r0 *1 0,0
Xsky130_fd_sc_hd__fill_8_2230 VGND VPWR VPWR sky130_fd_sc_hd__fill_8
* cell instance sky130_fd_sc_hd__fill_8_2231 r0 *1 0,0
Xsky130_fd_sc_hd__fill_8_2231 VGND VPWR VPWR sky130_fd_sc_hd__fill_8
* cell instance sky130_fd_sc_hd__fill_8_2232 r0 *1 0,0
Xsky130_fd_sc_hd__fill_8_2232 VGND VPWR VPWR sky130_fd_sc_hd__fill_8
* cell instance sky130_fd_sc_hd__fill_8_2233 r0 *1 0,0
Xsky130_fd_sc_hd__fill_8_2233 VGND VPWR VPWR sky130_fd_sc_hd__fill_8
* cell instance sky130_fd_sc_hd__fill_8_2234 r0 *1 0,0
Xsky130_fd_sc_hd__fill_8_2234 VGND VPWR VPWR sky130_fd_sc_hd__fill_8
* cell instance sky130_fd_sc_hd__fill_8_2235 r0 *1 0,0
Xsky130_fd_sc_hd__fill_8_2235 VGND VPWR VPWR sky130_fd_sc_hd__fill_8
* cell instance sky130_fd_sc_hd__fill_8_2236 r0 *1 0,0
Xsky130_fd_sc_hd__fill_8_2236 VGND VPWR VPWR sky130_fd_sc_hd__fill_8
* cell instance sky130_fd_sc_hd__fill_8_2237 r0 *1 0,0
Xsky130_fd_sc_hd__fill_8_2237 VGND VPWR VPWR sky130_fd_sc_hd__fill_8
* cell instance sky130_fd_sc_hd__fill_8_2238 r0 *1 0,0
Xsky130_fd_sc_hd__fill_8_2238 VGND VPWR VPWR sky130_fd_sc_hd__fill_8
* cell instance sky130_fd_sc_hd__fill_8_2239 r0 *1 0,0
Xsky130_fd_sc_hd__fill_8_2239 VGND VPWR VPWR sky130_fd_sc_hd__fill_8
* cell instance sky130_fd_sc_hd__fill_8_2240 r0 *1 0,0
Xsky130_fd_sc_hd__fill_8_2240 VGND VPWR VPWR sky130_fd_sc_hd__fill_8
* cell instance sky130_fd_sc_hd__fill_8_2241 r0 *1 0,0
Xsky130_fd_sc_hd__fill_8_2241 VGND VPWR VPWR sky130_fd_sc_hd__fill_8
* cell instance sky130_fd_sc_hd__fill_8_2242 r0 *1 0,0
Xsky130_fd_sc_hd__fill_8_2242 VGND VPWR VPWR sky130_fd_sc_hd__fill_8
* cell instance sky130_fd_sc_hd__fill_8_2243 r0 *1 0,0
Xsky130_fd_sc_hd__fill_8_2243 VGND VPWR VPWR sky130_fd_sc_hd__fill_8
* cell instance sky130_fd_sc_hd__fill_8_2244 r0 *1 0,0
Xsky130_fd_sc_hd__fill_8_2244 VGND VPWR VPWR sky130_fd_sc_hd__fill_8
* cell instance sky130_fd_sc_hd__fill_8_2245 r0 *1 0,0
Xsky130_fd_sc_hd__fill_8_2245 VGND VPWR VPWR sky130_fd_sc_hd__fill_8
* cell instance sky130_fd_sc_hd__fill_8_2246 r0 *1 0,0
Xsky130_fd_sc_hd__fill_8_2246 VGND VPWR VPWR sky130_fd_sc_hd__fill_8
* cell instance sky130_fd_sc_hd__fill_8_2247 r0 *1 0,0
Xsky130_fd_sc_hd__fill_8_2247 VGND VPWR VPWR sky130_fd_sc_hd__fill_8
* cell instance sky130_fd_sc_hd__fill_8_2248 r0 *1 0,0
Xsky130_fd_sc_hd__fill_8_2248 VGND VPWR VPWR sky130_fd_sc_hd__fill_8
* cell instance sky130_fd_sc_hd__fill_8_2249 r0 *1 0,0
Xsky130_fd_sc_hd__fill_8_2249 VGND VPWR VPWR sky130_fd_sc_hd__fill_8
* cell instance sky130_fd_sc_hd__fill_8_2250 r0 *1 0,0
Xsky130_fd_sc_hd__fill_8_2250 VGND VPWR VPWR sky130_fd_sc_hd__fill_8
* cell instance sky130_fd_sc_hd__fill_8_2251 r0 *1 0,0
Xsky130_fd_sc_hd__fill_8_2251 VGND VPWR VPWR sky130_fd_sc_hd__fill_8
* cell instance sky130_fd_sc_hd__fill_8_2252 r0 *1 0,0
Xsky130_fd_sc_hd__fill_8_2252 VGND VPWR VPWR sky130_fd_sc_hd__fill_8
* cell instance sky130_fd_sc_hd__fill_8_2253 r0 *1 0,0
Xsky130_fd_sc_hd__fill_8_2253 VGND VPWR VPWR sky130_fd_sc_hd__fill_8
* cell instance sky130_fd_sc_hd__fill_8_2254 r0 *1 0,0
Xsky130_fd_sc_hd__fill_8_2254 VGND VPWR VPWR sky130_fd_sc_hd__fill_8
* cell instance sky130_fd_sc_hd__fill_8_2255 r0 *1 0,0
Xsky130_fd_sc_hd__fill_8_2255 VGND VPWR VPWR sky130_fd_sc_hd__fill_8
* cell instance sky130_fd_sc_hd__fill_8_2256 r0 *1 0,0
Xsky130_fd_sc_hd__fill_8_2256 VGND VPWR VPWR sky130_fd_sc_hd__fill_8
* cell instance sky130_fd_sc_hd__fill_8_2257 r0 *1 0,0
Xsky130_fd_sc_hd__fill_8_2257 VGND VPWR VPWR sky130_fd_sc_hd__fill_8
* cell instance sky130_fd_sc_hd__fill_8_2258 r0 *1 0,0
Xsky130_fd_sc_hd__fill_8_2258 VGND VPWR VPWR sky130_fd_sc_hd__fill_8
* cell instance sky130_fd_sc_hd__fill_8_2259 r0 *1 0,0
Xsky130_fd_sc_hd__fill_8_2259 VGND VPWR VPWR sky130_fd_sc_hd__fill_8
* cell instance sky130_fd_sc_hd__fill_8_2260 r0 *1 0,0
Xsky130_fd_sc_hd__fill_8_2260 VGND VPWR VPWR sky130_fd_sc_hd__fill_8
* cell instance sky130_fd_sc_hd__fill_8_2261 r0 *1 0,0
Xsky130_fd_sc_hd__fill_8_2261 VGND VPWR VPWR sky130_fd_sc_hd__fill_8
* cell instance sky130_fd_sc_hd__fill_8_2262 r0 *1 0,0
Xsky130_fd_sc_hd__fill_8_2262 VGND VPWR VPWR sky130_fd_sc_hd__fill_8
* cell instance sky130_fd_sc_hd__fill_8_2263 r0 *1 0,0
Xsky130_fd_sc_hd__fill_8_2263 VGND VPWR VPWR sky130_fd_sc_hd__fill_8
* cell instance sky130_fd_sc_hd__fill_8_2264 r0 *1 0,0
Xsky130_fd_sc_hd__fill_8_2264 VGND VPWR VPWR sky130_fd_sc_hd__fill_8
* cell instance sky130_fd_sc_hd__fill_8_2265 r0 *1 0,0
Xsky130_fd_sc_hd__fill_8_2265 VGND VPWR VPWR sky130_fd_sc_hd__fill_8
* cell instance sky130_fd_sc_hd__fill_8_2266 r0 *1 0,0
Xsky130_fd_sc_hd__fill_8_2266 VGND VPWR VPWR sky130_fd_sc_hd__fill_8
* cell instance sky130_fd_sc_hd__fill_8_2267 r0 *1 0,0
Xsky130_fd_sc_hd__fill_8_2267 VGND VPWR VPWR sky130_fd_sc_hd__fill_8
* cell instance sky130_fd_sc_hd__inv_1_0 r0 *1 0,0
Xsky130_fd_sc_hd__inv_1_0 \_0247_ VGND VPWR VPWR \_0011_[19]
+ sky130_fd_sc_hd__inv_1
* cell instance sky130_fd_sc_hd__inv_1_1 r0 *1 0,0
Xsky130_fd_sc_hd__inv_1_1 \_0199_ VGND VPWR VPWR alarm sky130_fd_sc_hd__inv_1
* cell instance sky130_fd_sc_hd__inv_1_2 r0 *1 0,0
Xsky130_fd_sc_hd__inv_1_2 \_1234_ VGND VPWR VPWR out_valid
+ sky130_fd_sc_hd__inv_1
* cell instance sky130_fd_sc_hd__inv_1_3 r0 *1 0,0
Xsky130_fd_sc_hd__inv_1_3 \_1291_ VGND VPWR VPWR \_0011_[31]
+ sky130_fd_sc_hd__inv_1
* cell instance sky130_fd_sc_hd__inv_1_4 r0 *1 0,0
Xsky130_fd_sc_hd__inv_1_4 \_0236_ VGND VPWR VPWR \_0011_[25]
+ sky130_fd_sc_hd__inv_1
* cell instance sky130_fd_sc_hd__inv_1_5 r0 *1 0,0
Xsky130_fd_sc_hd__inv_1_5 clknet_leaf_3_clk VGND VPWR VPWR \$3156
+ sky130_fd_sc_hd__inv_1
* cell instance sky130_fd_sc_hd__inv_1_6 r0 *1 0,0
Xsky130_fd_sc_hd__inv_1_6 clknet_leaf_64_clk VGND VPWR VPWR \$1069
+ sky130_fd_sc_hd__inv_1
* cell instance sky130_fd_sc_hd__inv_1_7 r0 *1 0,0
Xsky130_fd_sc_hd__inv_1_7 \_0227_ VGND VPWR VPWR \_0011_[29]
+ sky130_fd_sc_hd__inv_1
* cell instance sky130_fd_sc_hd__inv_1_8 r0 *1 0,0
Xsky130_fd_sc_hd__inv_1_8 clknet_leaf_13_clk VGND VPWR VPWR \$4943
+ sky130_fd_sc_hd__inv_1
* cell instance sky130_fd_sc_hd__inv_1_9 r0 *1 0,0
Xsky130_fd_sc_hd__inv_1_9 clknet_leaf_2_clk VGND VPWR VPWR \$1828
+ sky130_fd_sc_hd__inv_1
* cell instance sky130_fd_sc_hd__inv_1_10 r0 *1 0,0
Xsky130_fd_sc_hd__inv_1_10 clknet_leaf_62_clk VGND VPWR VPWR \$442
+ sky130_fd_sc_hd__inv_1
* cell instance sky130_fd_sc_hd__inv_1_11 r0 *1 0,0
Xsky130_fd_sc_hd__inv_1_11 \_0268_ VGND VPWR VPWR \_0011_[8]
+ sky130_fd_sc_hd__inv_1
* cell instance sky130_fd_sc_hd__inv_1_12 r0 *1 0,0
Xsky130_fd_sc_hd__inv_1_12 \_0235_ VGND VPWR VPWR \_0011_[26]
+ sky130_fd_sc_hd__inv_1
* cell instance sky130_fd_sc_hd__inv_1_13 r0 *1 0,0
Xsky130_fd_sc_hd__inv_1_13 \_0258_ VGND VPWR VPWR \_0011_[12]
+ sky130_fd_sc_hd__inv_1
* cell instance sky130_fd_sc_hd__inv_1_14 r0 *1 0,0
Xsky130_fd_sc_hd__inv_1_14 \_0237_ VGND VPWR VPWR \_0011_[24]
+ sky130_fd_sc_hd__inv_1
* cell instance sky130_fd_sc_hd__inv_1_15 r0 *1 0,0
Xsky130_fd_sc_hd__inv_1_15 \_0230_ VGND VPWR VPWR \_0011_[27]
+ sky130_fd_sc_hd__inv_1
* cell instance sky130_fd_sc_hd__inv_1_16 r0 *1 0,0
Xsky130_fd_sc_hd__inv_1_16 \_0256_ VGND VPWR VPWR \_1132_ sky130_fd_sc_hd__inv_1
* cell instance sky130_fd_sc_hd__inv_1_17 r0 *1 0,0
Xsky130_fd_sc_hd__inv_1_17 \_0266_ VGND VPWR VPWR \_1148_ sky130_fd_sc_hd__inv_1
* cell instance sky130_fd_sc_hd__inv_1_18 r0 *1 0,0
Xsky130_fd_sc_hd__inv_1_18 \_0288_ VGND VPWR VPWR \_0011_[0]
+ sky130_fd_sc_hd__inv_1
* cell instance sky130_fd_sc_hd__inv_1_19 r0 *1 0,0
Xsky130_fd_sc_hd__inv_1_19 clknet_leaf_11_clk VGND VPWR VPWR \$4384
+ sky130_fd_sc_hd__inv_1
* cell instance sky130_fd_sc_hd__inv_1_20 r0 *1 0,0
Xsky130_fd_sc_hd__inv_1_20 clknet_leaf_15_clk VGND VPWR VPWR \$6107
+ sky130_fd_sc_hd__inv_1
* cell instance sky130_fd_sc_hd__inv_1_21 r0 *1 0,0
Xsky130_fd_sc_hd__inv_1_21 \_0272_ VGND VPWR VPWR \_0011_[6]
+ sky130_fd_sc_hd__inv_1
* cell instance sky130_fd_sc_hd__inv_1_22 r0 *1 0,0
Xsky130_fd_sc_hd__inv_1_22 \_0275_ VGND VPWR VPWR \_0011_[5]
+ sky130_fd_sc_hd__inv_1
* cell instance sky130_fd_sc_hd__inv_1_23 r0 *1 0,0
Xsky130_fd_sc_hd__inv_1_23 \_0273_ VGND VPWR VPWR \_1158_ sky130_fd_sc_hd__inv_1
* cell instance sky130_fd_sc_hd__inv_1_24 r0 *1 0,0
Xsky130_fd_sc_hd__inv_1_24 \_0255_ VGND VPWR VPWR \_0011_[13]
+ sky130_fd_sc_hd__inv_1
* cell instance sky130_fd_sc_hd__inv_1_25 r0 *1 0,0
Xsky130_fd_sc_hd__inv_1_25 \_0276_ VGND VPWR VPWR \_1162_ sky130_fd_sc_hd__inv_1
* cell instance sky130_fd_sc_hd__inv_1_26 r0 *1 0,0
Xsky130_fd_sc_hd__inv_1_26 \_0734_ VGND VPWR VPWR \_0001_ sky130_fd_sc_hd__inv_1
* cell instance sky130_fd_sc_hd__inv_1_27 r0 *1 0,0
Xsky130_fd_sc_hd__inv_1_27 clknet_leaf_60_clk VGND VPWR VPWR \$1027
+ sky130_fd_sc_hd__inv_1
* cell instance sky130_fd_sc_hd__inv_1_28 r0 *1 0,0
Xsky130_fd_sc_hd__inv_1_28 clknet_leaf_10_clk VGND VPWR VPWR \$4849
+ sky130_fd_sc_hd__inv_1
* cell instance sky130_fd_sc_hd__inv_1_29 r0 *1 0,0
Xsky130_fd_sc_hd__inv_1_29 \_0729_ VGND VPWR VPWR \_0002_ sky130_fd_sc_hd__inv_1
* cell instance sky130_fd_sc_hd__inv_1_30 r0 *1 0,0
Xsky130_fd_sc_hd__inv_1_30 clknet_leaf_61_clk VGND VPWR VPWR \$122
+ sky130_fd_sc_hd__inv_1
* cell instance sky130_fd_sc_hd__inv_1_31 r0 *1 0,0
Xsky130_fd_sc_hd__inv_1_31 clknet_leaf_20_clk VGND VPWR VPWR \$7046
+ sky130_fd_sc_hd__inv_1
* cell instance sky130_fd_sc_hd__inv_1_32 r0 *1 0,0
Xsky130_fd_sc_hd__inv_1_32 \_0736_ VGND VPWR VPWR \_0000_ sky130_fd_sc_hd__inv_1
* cell instance sky130_fd_sc_hd__inv_1_33 r0 *1 0,0
Xsky130_fd_sc_hd__inv_1_33 \_0265_ VGND VPWR VPWR \_0011_[9]
+ sky130_fd_sc_hd__inv_1
* cell instance sky130_fd_sc_hd__inv_1_34 r0 *1 0,0
Xsky130_fd_sc_hd__inv_1_34 \_0252_ VGND VPWR VPWR \_0011_[16]
+ sky130_fd_sc_hd__inv_1
* cell instance sky130_fd_sc_hd__inv_1_35 r0 *1 0,0
Xsky130_fd_sc_hd__inv_1_35 \_0250_ VGND VPWR VPWR \_1122_ sky130_fd_sc_hd__inv_1
* cell instance sky130_fd_sc_hd__inv_1_36 r0 *1 0,0
Xsky130_fd_sc_hd__inv_1_36 \_0248_ VGND VPWR VPWR \_0011_[18]
+ sky130_fd_sc_hd__inv_1
* cell instance sky130_fd_sc_hd__inv_1_37 r0 *1 0,0
Xsky130_fd_sc_hd__inv_1_37 \_0278_ VGND VPWR VPWR \_0011_[4]
+ sky130_fd_sc_hd__inv_1
* cell instance sky130_fd_sc_hd__inv_1_38 r0 *1 0,0
Xsky130_fd_sc_hd__inv_1_38 clknet_leaf_9_clk VGND VPWR VPWR \$5663
+ sky130_fd_sc_hd__inv_1
* cell instance sky130_fd_sc_hd__inv_1_39 r0 *1 0,0
Xsky130_fd_sc_hd__inv_1_39 clknet_leaf_21_clk VGND VPWR VPWR \$6786
+ sky130_fd_sc_hd__inv_1
* cell instance sky130_fd_sc_hd__inv_1_40 r0 *1 0,0
Xsky130_fd_sc_hd__inv_1_40 \_0229_ VGND VPWR VPWR \_0011_[28]
+ sky130_fd_sc_hd__inv_1
* cell instance sky130_fd_sc_hd__inv_1_41 r0 *1 0,0
Xsky130_fd_sc_hd__inv_1_41 clknet_leaf_22_clk VGND VPWR VPWR \$7720
+ sky130_fd_sc_hd__inv_1
* cell instance sky130_fd_sc_hd__inv_1_42 r0 *1 0,0
Xsky130_fd_sc_hd__inv_1_42 \_0292_ VGND VPWR VPWR \_0014_[1]
+ sky130_fd_sc_hd__inv_1
* cell instance sky130_fd_sc_hd__inv_1_43 r0 *1 0,0
Xsky130_fd_sc_hd__inv_1_43 clknet_leaf_58_clk VGND VPWR VPWR \$593
+ sky130_fd_sc_hd__inv_1
* cell instance sky130_fd_sc_hd__inv_1_44 r0 *1 0,0
Xsky130_fd_sc_hd__inv_1_44 \_0249_ VGND VPWR VPWR \_0011_[17]
+ sky130_fd_sc_hd__inv_1
* cell instance sky130_fd_sc_hd__inv_1_45 r0 *1 0,0
Xsky130_fd_sc_hd__inv_1_45 clknet_leaf_55_clk VGND VPWR VPWR \$1676
+ sky130_fd_sc_hd__inv_1
* cell instance sky130_fd_sc_hd__inv_1_46 r0 *1 0,0
Xsky130_fd_sc_hd__inv_1_46 \_0225_ VGND VPWR VPWR \_0011_[30]
+ sky130_fd_sc_hd__inv_1
* cell instance sky130_fd_sc_hd__inv_1_47 r0 *1 0,0
Xsky130_fd_sc_hd__inv_1_47 clknet_leaf_6_clk VGND VPWR VPWR \$3300
+ sky130_fd_sc_hd__inv_1
* cell instance sky130_fd_sc_hd__inv_1_48 r0 *1 0,0
Xsky130_fd_sc_hd__inv_1_48 \_0271_ VGND VPWR VPWR \_0011_[7]
+ sky130_fd_sc_hd__inv_1
* cell instance sky130_fd_sc_hd__inv_1_49 r0 *1 0,0
Xsky130_fd_sc_hd__inv_1_49 \_0269_ VGND VPWR VPWR \_1152_ sky130_fd_sc_hd__inv_1
* cell instance sky130_fd_sc_hd__inv_1_50 r0 *1 0,0
Xsky130_fd_sc_hd__inv_1_50 \_0259_ VGND VPWR VPWR \_1136_ sky130_fd_sc_hd__inv_1
* cell instance sky130_fd_sc_hd__inv_1_51 r0 *1 0,0
Xsky130_fd_sc_hd__inv_1_51 clknet_leaf_25_clk VGND VPWR VPWR \$6798
+ sky130_fd_sc_hd__inv_1
* cell instance sky130_fd_sc_hd__inv_1_52 r0 *1 0,0
Xsky130_fd_sc_hd__inv_1_52 \_0261_ VGND VPWR VPWR \_0011_[11]
+ sky130_fd_sc_hd__inv_1
* cell instance sky130_fd_sc_hd__inv_1_53 r0 *1 0,0
Xsky130_fd_sc_hd__inv_1_53 \_0264_ VGND VPWR VPWR \_0011_[10]
+ sky130_fd_sc_hd__inv_1
* cell instance sky130_fd_sc_hd__inv_1_54 r0 *1 0,0
Xsky130_fd_sc_hd__inv_1_54 clknet_leaf_23_clk VGND VPWR VPWR \$7810
+ sky130_fd_sc_hd__inv_1
* cell instance sky130_fd_sc_hd__inv_1_55 r0 *1 0,0
Xsky130_fd_sc_hd__inv_1_55 clknet_leaf_57_clk VGND VPWR VPWR \$349
+ sky130_fd_sc_hd__inv_1
* cell instance sky130_fd_sc_hd__inv_1_56 r0 *1 0,0
Xsky130_fd_sc_hd__inv_1_56 \_0262_ VGND VPWR VPWR \_1142_ sky130_fd_sc_hd__inv_1
* cell instance sky130_fd_sc_hd__inv_1_57 r0 *1 0,0
Xsky130_fd_sc_hd__inv_1_57 clknet_leaf_24_clk VGND VPWR VPWR \$7266
+ sky130_fd_sc_hd__inv_1
* cell instance sky130_fd_sc_hd__inv_1_58 r0 *1 0,0
Xsky130_fd_sc_hd__inv_1_58 \_0254_ VGND VPWR VPWR \_0011_[14]
+ sky130_fd_sc_hd__inv_1
* cell instance sky130_fd_sc_hd__inv_1_59 r0 *1 0,0
Xsky130_fd_sc_hd__inv_1_59 clknet_leaf_27_clk VGND VPWR VPWR \$5794
+ sky130_fd_sc_hd__inv_1
* cell instance sky130_fd_sc_hd__inv_1_60 r0 *1 0,0
Xsky130_fd_sc_hd__inv_1_60 \_0246_ VGND VPWR VPWR \_0011_[20]
+ sky130_fd_sc_hd__inv_1
* cell instance sky130_fd_sc_hd__inv_1_61 r0 *1 0,0
Xsky130_fd_sc_hd__inv_1_61 \_0279_ VGND VPWR VPWR \_0011_[3]
+ sky130_fd_sc_hd__inv_1
* cell instance sky130_fd_sc_hd__inv_1_62 r0 *1 0,0
Xsky130_fd_sc_hd__inv_1_62 clknet_leaf_53_clk VGND VPWR VPWR \$3104
+ sky130_fd_sc_hd__inv_1
* cell instance sky130_fd_sc_hd__inv_1_63 r0 *1 0,0
Xsky130_fd_sc_hd__inv_1_63 clknet_leaf_32_clk VGND VPWR VPWR \$7506
+ sky130_fd_sc_hd__inv_1
* cell instance sky130_fd_sc_hd__inv_1_64 r0 *1 0,0
Xsky130_fd_sc_hd__inv_1_64 \_0253_ VGND VPWR VPWR \_0011_[15]
+ sky130_fd_sc_hd__inv_1
* cell instance sky130_fd_sc_hd__inv_1_65 r0 *1 0,0
Xsky130_fd_sc_hd__inv_1_65 \_0245_ VGND VPWR VPWR \_0011_[21]
+ sky130_fd_sc_hd__inv_1
* cell instance sky130_fd_sc_hd__inv_1_66 r0 *1 0,0
Xsky130_fd_sc_hd__inv_1_66 clknet_leaf_31_clk VGND VPWR VPWR \$6458
+ sky130_fd_sc_hd__inv_1
* cell instance sky130_fd_sc_hd__inv_1_67 r0 *1 0,0
Xsky130_fd_sc_hd__inv_1_67 \_0280_ VGND VPWR VPWR \_1168_ sky130_fd_sc_hd__inv_1
* cell instance sky130_fd_sc_hd__inv_1_68 r0 *1 0,0
Xsky130_fd_sc_hd__inv_1_68 clknet_leaf_41_clk VGND VPWR VPWR \$3836
+ sky130_fd_sc_hd__inv_1
* cell instance sky130_fd_sc_hd__inv_1_69 r0 *1 0,0
Xsky130_fd_sc_hd__inv_1_69 clknet_leaf_29_clk VGND VPWR VPWR \$5594
+ sky130_fd_sc_hd__inv_1
* cell instance sky130_fd_sc_hd__inv_1_70 r0 *1 0,0
Xsky130_fd_sc_hd__inv_1_70 \_0285_ VGND VPWR VPWR \_0011_[1]
+ sky130_fd_sc_hd__inv_1
* cell instance sky130_fd_sc_hd__inv_1_71 r0 *1 0,0
Xsky130_fd_sc_hd__inv_1_71 clknet_leaf_33_clk VGND VPWR VPWR \$7513
+ sky130_fd_sc_hd__inv_1
* cell instance sky130_fd_sc_hd__inv_1_72 r0 *1 0,0
Xsky130_fd_sc_hd__inv_1_72 clknet_leaf_50_clk VGND VPWR VPWR \$1275
+ sky130_fd_sc_hd__inv_1
* cell instance sky130_fd_sc_hd__inv_1_73 r0 *1 0,0
Xsky130_fd_sc_hd__inv_1_73 \_0239_ VGND VPWR VPWR \_1103_ sky130_fd_sc_hd__inv_1
* cell instance sky130_fd_sc_hd__inv_1_74 r0 *1 0,0
Xsky130_fd_sc_hd__inv_1_74 \_0282_ VGND VPWR VPWR \_0011_[2]
+ sky130_fd_sc_hd__inv_1
* cell instance sky130_fd_sc_hd__inv_1_75 r0 *1 0,0
Xsky130_fd_sc_hd__inv_1_75 \_0283_ VGND VPWR VPWR \_1172_ sky130_fd_sc_hd__inv_1
* cell instance sky130_fd_sc_hd__inv_1_76 r0 *1 0,0
Xsky130_fd_sc_hd__inv_1_76 \_0242_ VGND VPWR VPWR \_1107_ sky130_fd_sc_hd__inv_1
* cell instance sky130_fd_sc_hd__inv_1_77 r0 *1 0,0
Xsky130_fd_sc_hd__inv_1_77 \_0244_ VGND VPWR VPWR \_0011_[22]
+ sky130_fd_sc_hd__inv_1
* cell instance sky130_fd_sc_hd__inv_1_78 r0 *1 0,0
Xsky130_fd_sc_hd__inv_1_78 \_0241_ VGND VPWR VPWR \_0011_[23]
+ sky130_fd_sc_hd__inv_1
* cell instance sky130_fd_sc_hd__inv_1_79 r0 *1 0,0
Xsky130_fd_sc_hd__inv_1_79 clknet_leaf_40_clk VGND VPWR VPWR \$4434
+ sky130_fd_sc_hd__inv_1
* cell instance sky130_fd_sc_hd__inv_1_80 r0 *1 0,0
Xsky130_fd_sc_hd__inv_1_80 clknet_leaf_51_clk VGND VPWR VPWR \$1887
+ sky130_fd_sc_hd__inv_1
* cell instance sky130_fd_sc_hd__inv_1_81 r0 *1 0,0
Xsky130_fd_sc_hd__inv_1_81 cond_count[8] VGND VPWR VPWR \_0203_
+ sky130_fd_sc_hd__inv_1
* cell instance sky130_fd_sc_hd__inv_1_82 r0 *1 0,0
Xsky130_fd_sc_hd__inv_1_82 clknet_leaf_43_clk VGND VPWR VPWR \$2590
+ sky130_fd_sc_hd__inv_1
* cell instance sky130_fd_sc_hd__inv_1_83 r0 *1 0,0
Xsky130_fd_sc_hd__inv_1_83 cond_count[7] VGND VPWR VPWR \_0202_
+ sky130_fd_sc_hd__inv_1
* cell instance sky130_fd_sc_hd__inv_1_84 r0 *1 0,0
Xsky130_fd_sc_hd__inv_1_84 clknet_leaf_39_clk VGND VPWR VPWR \$5392
+ sky130_fd_sc_hd__inv_1
* cell instance sky130_fd_sc_hd__inv_1_85 r0 *1 0,0
Xsky130_fd_sc_hd__inv_1_85 \_0743_ VGND VPWR VPWR \_0027_ sky130_fd_sc_hd__inv_1
* cell instance sky130_fd_sc_hd__inv_1_86 r0 *1 0,0
Xsky130_fd_sc_hd__inv_1_86 startup_count[10] VGND VPWR VPWR \_0478_
+ sky130_fd_sc_hd__inv_1
* cell instance sky130_fd_sc_hd__inv_1_87 r0 *1 0,0
Xsky130_fd_sc_hd__inv_1_87 startup_count[12] VGND VPWR VPWR \_0490_
+ sky130_fd_sc_hd__inv_1
* cell instance sky130_fd_sc_hd__inv_1_88 r0 *1 0,0
Xsky130_fd_sc_hd__inv_1_88 startup_count[15] VGND VPWR VPWR \_0737_
+ sky130_fd_sc_hd__inv_1
* cell instance sky130_fd_sc_hd__inv_1_89 r0 *1 0,0
Xsky130_fd_sc_hd__inv_1_89 startup_count[14] VGND VPWR VPWR \_0477_
+ sky130_fd_sc_hd__inv_1
* cell instance sky130_fd_sc_hd__inv_1_90 r0 *1 0,0
Xsky130_fd_sc_hd__inv_1_90 apt_index[13] VGND VPWR VPWR \_0368_
+ sky130_fd_sc_hd__inv_1
* cell instance sky130_fd_sc_hd__inv_1_91 r0 *1 0,0
Xsky130_fd_sc_hd__inv_1_91 clknet_leaf_35_clk VGND VPWR VPWR \$6081
+ sky130_fd_sc_hd__inv_1
* cell instance sky130_fd_sc_hd__inv_1_92 r0 *1 0,0
Xsky130_fd_sc_hd__inv_1_92 clknet_leaf_45_clk VGND VPWR VPWR \$3336
+ sky130_fd_sc_hd__inv_1
* cell instance sky130_fd_sc_hd__inv_1_93 r0 *1 0,0
Xsky130_fd_sc_hd__inv_1_93 apt_index[4] VGND VPWR VPWR \_0369_
+ sky130_fd_sc_hd__inv_1
* cell instance sky130_fd_sc_hd__inv_1_94 r0 *1 0,0
Xsky130_fd_sc_hd__inv_1_94 clknet_leaf_36_clk VGND VPWR VPWR \$5527
+ sky130_fd_sc_hd__inv_1
* cell instance sky130_fd_sc_hd__inv_1_95 r0 *1 0,0
Xsky130_fd_sc_hd__inv_1_95 clknet_leaf_46_clk VGND VPWR VPWR \$3344
+ sky130_fd_sc_hd__inv_1
* cell instance sky130_fd_sc_hd__inv_4_0 r0 *1 0,0
Xsky130_fd_sc_hd__inv_4_0 clknet_3_2__leaf_clk VGND VPWR VPWR \$1617
+ sky130_fd_sc_hd__inv_4
* cell instance sky130_fd_sc_hd__mux2_2_0 r0 *1 0,0
Xsky130_fd_sc_hd__mux2_2_0 \_1019_ \_0020_[8] net23 VGND VPWR VPWR \_0019_[8]
+ sky130_fd_sc_hd__mux2_2
* cell instance sky130_fd_sc_hd__mux2_2_1 r0 *1 0,0
Xsky130_fd_sc_hd__mux2_2_1 \_1009_ \_0020_[12] net23 VGND VPWR VPWR \_0019_[12]
+ sky130_fd_sc_hd__mux2_2
* cell instance sky130_fd_sc_hd__mux2_2_2 r0 *1 0,0
Xsky130_fd_sc_hd__mux2_2_2 \_1029_ \_0020_[5] net23 VGND VPWR VPWR \_0019_[5]
+ sky130_fd_sc_hd__mux2_2
* cell instance sky130_fd_sc_hd__mux2_2_3 r0 *1 0,0
Xsky130_fd_sc_hd__mux2_2_3 \_1026_ \_0020_[6] net23 VGND VPWR VPWR \_0019_[6]
+ sky130_fd_sc_hd__mux2_2
* cell instance sky130_fd_sc_hd__mux2_2_4 r0 *1 0,0
Xsky130_fd_sc_hd__mux2_2_4 \_1006_ \_0020_[13] net23 VGND VPWR VPWR \_0019_[13]
+ sky130_fd_sc_hd__mux2_2
* cell instance sky130_fd_sc_hd__mux2_2_5 r0 *1 0,0
Xsky130_fd_sc_hd__mux2_2_5 \_1044_ \_0020_[0] net23 VGND VPWR VPWR \_0019_[0]
+ sky130_fd_sc_hd__mux2_2
* cell instance sky130_fd_sc_hd__mux2_2_6 r0 *1 0,0
Xsky130_fd_sc_hd__mux2_2_6 \_1032_ \_0020_[4] net23 VGND VPWR VPWR \_0019_[4]
+ sky130_fd_sc_hd__mux2_2
* cell instance sky130_fd_sc_hd__mux2_2_7 r0 *1 0,0
Xsky130_fd_sc_hd__mux2_2_7 \_1038_ \_0020_[2] net23 VGND VPWR VPWR \_0019_[2]
+ sky130_fd_sc_hd__mux2_2
* cell instance sky130_fd_sc_hd__mux2_2_8 r0 *1 0,0
Xsky130_fd_sc_hd__mux2_2_8 \_1016_ \_0020_[9] net23 VGND VPWR VPWR \_0019_[9]
+ sky130_fd_sc_hd__mux2_2
* cell instance sky130_fd_sc_hd__mux2_2_9 r0 *1 0,0
Xsky130_fd_sc_hd__mux2_2_9 bus_wdata[0] ctrl[0] \_0291_ VGND VPWR VPWR
+ \_0014_[0] sky130_fd_sc_hd__mux2_2
* cell instance sky130_fd_sc_hd__mux2_2_10 r0 *1 0,0
Xsky130_fd_sc_hd__mux2_2_10 \_0754_ \_0762_ \_0764_ VGND VPWR VPWR \_0016_[0]
+ sky130_fd_sc_hd__mux2_2
* cell instance sky130_fd_sc_hd__mux2_2_11 r0 *1 0,0
Xsky130_fd_sc_hd__mux2_2_11 \_0796_ \_1070_ ctrl[1] VGND VPWR VPWR \_1234_
+ sky130_fd_sc_hd__mux2_2
* cell instance sky130_fd_sc_hd__mux2_2_12 r0 *1 0,0
Xsky130_fd_sc_hd__mux2_2_12 \_0795_ \_0779_ \_0794_ VGND VPWR VPWR \_0007_[0]
+ sky130_fd_sc_hd__mux2_2
* cell instance sky130_fd_sc_hd__mux2_2_13 r0 *1 0,0
Xsky130_fd_sc_hd__mux2_2_13 \_0789_ \_0790_ \_0794_ VGND VPWR VPWR \_0007_[1]
+ sky130_fd_sc_hd__mux2_2
* cell instance sky130_fd_sc_hd__mux2i_1_0 r0 *1 0,0
Xsky130_fd_sc_hd__mux2i_1_0 \_0839_ \_0841_ net23 VGND VPWR VPWR \_0017_[25]
+ sky130_fd_sc_hd__mux2i_1
* cell instance sky130_fd_sc_hd__mux2i_1_1 r0 *1 0,0
Xsky130_fd_sc_hd__mux2i_1_1 \_0841_ \_0980_ net23 VGND VPWR VPWR \_0018_[25]
+ sky130_fd_sc_hd__mux2i_1
* cell instance sky130_fd_sc_hd__mux2i_1_2 r0 *1 0,0
Xsky130_fd_sc_hd__mux2i_1_2 \_0866_ \_0868_ net23 VGND VPWR VPWR \_0017_[19]
+ sky130_fd_sc_hd__mux2i_1
* cell instance sky130_fd_sc_hd__mux2i_1_3 r0 *1 0,0
Xsky130_fd_sc_hd__mux2i_1_3 \_0868_ \_0992_ net23 VGND VPWR VPWR \_0018_[19]
+ sky130_fd_sc_hd__mux2i_1
* cell instance sky130_fd_sc_hd__mux2i_1_4 r0 *1 0,0
Xsky130_fd_sc_hd__mux2i_1_4 \_1114_ \_1115_ net21 VGND VPWR VPWR \_0008_[19]
+ sky130_fd_sc_hd__mux2i_1
* cell instance sky130_fd_sc_hd__mux2i_1_5 r0 *1 0,0
Xsky130_fd_sc_hd__mux2i_1_5 \_1115_ \_1199_ net21 VGND VPWR VPWR \_0009_[19]
+ sky130_fd_sc_hd__mux2i_1
* cell instance sky130_fd_sc_hd__mux2i_1_6 r0 *1 0,0
Xsky130_fd_sc_hd__mux2i_1_6 \_0916_ \_0918_ net23 VGND VPWR VPWR \_0017_[8]
+ sky130_fd_sc_hd__mux2i_1
* cell instance sky130_fd_sc_hd__mux2i_1_7 r0 *1 0,0
Xsky130_fd_sc_hd__mux2i_1_7 \_1304_ \_1305_ net21 VGND VPWR VPWR \_0009_[31]
+ sky130_fd_sc_hd__mux2i_1
* cell instance sky130_fd_sc_hd__mux2i_1_8 r0 *1 0,0
Xsky130_fd_sc_hd__mux2i_1_8 \_1095_ \_1096_ net21 VGND VPWR VPWR \_0008_[25]
+ sky130_fd_sc_hd__mux2i_1
* cell instance sky130_fd_sc_hd__mux2i_1_9 r0 *1 0,0
Xsky130_fd_sc_hd__mux2i_1_9 \_1096_ \_1189_ net21 VGND VPWR VPWR \_0009_[25]
+ sky130_fd_sc_hd__mux2i_1
* cell instance sky130_fd_sc_hd__mux2i_1_10 r0 *1 0,0
Xsky130_fd_sc_hd__mux2i_1_10 \_1189_ \_0236_ net21 VGND VPWR VPWR \_0010_[25]
+ sky130_fd_sc_hd__mux2i_1
* cell instance sky130_fd_sc_hd__mux2i_1_11 r0 *1 0,0
Xsky130_fd_sc_hd__mux2i_1_11 \_1199_ \_0247_ net21 VGND VPWR VPWR \_0010_[19]
+ sky130_fd_sc_hd__mux2i_1
* cell instance sky130_fd_sc_hd__mux2i_1_12 r0 *1 0,0
Xsky130_fd_sc_hd__mux2i_1_12 \_1082_ \_1084_ net21 VGND VPWR VPWR \_0008_[29]
+ sky130_fd_sc_hd__mux2i_1
* cell instance sky130_fd_sc_hd__mux2i_1_13 r0 *1 0,0
Xsky130_fd_sc_hd__mux2i_1_13 \_1303_ \_1304_ net21 VGND VPWR VPWR \_0008_[31]
+ sky130_fd_sc_hd__mux2i_1
* cell instance sky130_fd_sc_hd__mux2i_1_14 r0 *1 0,0
Xsky130_fd_sc_hd__mux2i_1_14 \_1305_ \_1291_ net21 VGND VPWR VPWR \_0010_[31]
+ sky130_fd_sc_hd__mux2i_1
* cell instance sky130_fd_sc_hd__mux2i_1_15 r0 *1 0,0
Xsky130_fd_sc_hd__mux2i_1_15 \_0818_ \_0821_ net23 VGND VPWR VPWR \_0017_[29]
+ sky130_fd_sc_hd__mux2i_1
* cell instance sky130_fd_sc_hd__mux2i_1_16 r0 *1 0,0
Xsky130_fd_sc_hd__mux2i_1_16 raw_mem[0][25] cond_mem[0][25] net41 VGND VPWR
+ VPWR \_1242_ sky130_fd_sc_hd__mux2i_1
* cell instance sky130_fd_sc_hd__mux2i_1_17 r0 *1 0,0
Xsky130_fd_sc_hd__mux2i_1_17 \_1084_ \_1182_ net21 VGND VPWR VPWR \_0009_[29]
+ sky130_fd_sc_hd__mux2i_1
* cell instance sky130_fd_sc_hd__mux2i_1_18 r0 *1 0,0
Xsky130_fd_sc_hd__mux2i_1_18 crc_state[18] cond_mem[0][19] net28 VGND VPWR VPWR
+ \_1114_ sky130_fd_sc_hd__mux2i_1
* cell instance sky130_fd_sc_hd__mux2i_1_19 r0 *1 0,0
Xsky130_fd_sc_hd__mux2i_1_19 \_0844_ \_0847_ net23 VGND VPWR VPWR \_0017_[24]
+ sky130_fd_sc_hd__mux2i_1
* cell instance sky130_fd_sc_hd__mux2i_1_20 r0 *1 0,0
Xsky130_fd_sc_hd__mux2i_1_20 raw_mem[0][19] cond_mem[0][19] net41 VGND VPWR
+ VPWR \_1250_ sky130_fd_sc_hd__mux2i_1
* cell instance sky130_fd_sc_hd__mux2i_1_21 r0 *1 0,0
Xsky130_fd_sc_hd__mux2i_1_21 cond_mem[1][19] crc_state[18] net27 VGND VPWR VPWR
+ \_1115_ sky130_fd_sc_hd__mux2i_1
* cell instance sky130_fd_sc_hd__mux2i_1_22 r0 *1 0,0
Xsky130_fd_sc_hd__mux2i_1_22 raw_mem[0][29] cond_mem[0][29] net41 VGND VPWR
+ VPWR \_1238_ sky130_fd_sc_hd__mux2i_1
* cell instance sky130_fd_sc_hd__mux2i_1_23 r0 *1 0,0
Xsky130_fd_sc_hd__mux2i_1_23 raw_mem[0][24] cond_mem[0][24] net41 VGND VPWR
+ VPWR \_1243_ sky130_fd_sc_hd__mux2i_1
* cell instance sky130_fd_sc_hd__mux2i_1_24 r0 *1 0,0
Xsky130_fd_sc_hd__mux2i_1_24 cond_mem[1][31] crc_state[30] net27 VGND VPWR VPWR
+ \_1304_ sky130_fd_sc_hd__mux2i_1
* cell instance sky130_fd_sc_hd__mux2i_1_25 r0 *1 0,0
Xsky130_fd_sc_hd__mux2i_1_25 crc_state[24] cond_mem[0][25] net28 VGND VPWR VPWR
+ \_1095_ sky130_fd_sc_hd__mux2i_1
* cell instance sky130_fd_sc_hd__mux2i_1_26 r0 *1 0,0
Xsky130_fd_sc_hd__mux2i_1_26 cond_mem[1][25] crc_state[24] net27 VGND VPWR VPWR
+ \_1096_ sky130_fd_sc_hd__mux2i_1
* cell instance sky130_fd_sc_hd__mux2i_1_27 r0 *1 0,0
Xsky130_fd_sc_hd__mux2i_1_27 crc_state[24] cond_mem[2][25] net26 VGND VPWR VPWR
+ \_1189_ sky130_fd_sc_hd__mux2i_1
* cell instance sky130_fd_sc_hd__mux2i_1_28 r0 *1 0,0
Xsky130_fd_sc_hd__mux2i_1_28 crc_state[18] cond_mem[3][19] net29 VGND VPWR VPWR
+ \_0247_ sky130_fd_sc_hd__mux2i_1
* cell instance sky130_fd_sc_hd__mux2i_1_29 r0 *1 0,0
Xsky130_fd_sc_hd__mux2i_1_29 crc_state[28] cond_mem[0][29] net28 VGND VPWR VPWR
+ \_1082_ sky130_fd_sc_hd__mux2i_1
* cell instance sky130_fd_sc_hd__mux2i_1_30 r0 *1 0,0
Xsky130_fd_sc_hd__mux2i_1_30 raw_mem[0][31] cond_mem[0][31] net41 VGND VPWR
+ VPWR \_1306_ sky130_fd_sc_hd__mux2i_1
* cell instance sky130_fd_sc_hd__mux2i_1_31 r0 *1 0,0
Xsky130_fd_sc_hd__mux2i_1_31 raw_mem[0][8] cond_mem[0][8] net41 VGND VPWR VPWR
+ \_1263_ sky130_fd_sc_hd__mux2i_1
* cell instance sky130_fd_sc_hd__mux2i_1_32 r0 *1 0,0
Xsky130_fd_sc_hd__mux2i_1_32 crc_state[30] cond_mem[0][31] net28 VGND VPWR VPWR
+ \_1303_ sky130_fd_sc_hd__mux2i_1
* cell instance sky130_fd_sc_hd__mux2i_1_33 r0 *1 0,0
Xsky130_fd_sc_hd__mux2i_1_33 crc_state[30] cond_mem[2][31] net26 VGND VPWR VPWR
+ \_1305_ sky130_fd_sc_hd__mux2i_1
* cell instance sky130_fd_sc_hd__mux2i_1_34 r0 *1 0,0
Xsky130_fd_sc_hd__mux2i_1_34 crc_state[30] cond_mem[3][31] net29 VGND VPWR VPWR
+ \_1291_ sky130_fd_sc_hd__mux2i_1
* cell instance sky130_fd_sc_hd__mux2i_1_35 r0 *1 0,0
Xsky130_fd_sc_hd__mux2i_1_35 crc_state[24] cond_mem[3][25] net29 VGND VPWR VPWR
+ \_0236_ sky130_fd_sc_hd__mux2i_1
* cell instance sky130_fd_sc_hd__mux2i_1_36 r0 *1 0,0
Xsky130_fd_sc_hd__mux2i_1_36 crc_state[18] cond_mem[2][19] net26 VGND VPWR VPWR
+ \_1199_ sky130_fd_sc_hd__mux2i_1
* cell instance sky130_fd_sc_hd__mux2i_1_37 r0 *1 0,0
Xsky130_fd_sc_hd__mux2i_1_37 cond_mem[1][29] crc_state[28] net27 VGND VPWR VPWR
+ \_1084_ sky130_fd_sc_hd__mux2i_1
* cell instance sky130_fd_sc_hd__mux2i_1_38 r0 *1 0,0
Xsky130_fd_sc_hd__mux2i_1_38 \_1182_ \_0227_ net21 VGND VPWR VPWR \_0010_[29]
+ sky130_fd_sc_hd__mux2i_1
* cell instance sky130_fd_sc_hd__mux2i_1_39 r0 *1 0,0
Xsky130_fd_sc_hd__mux2i_1_39 \_1097_ \_1098_ net21 VGND VPWR VPWR \_0008_[24]
+ sky130_fd_sc_hd__mux2i_1
* cell instance sky130_fd_sc_hd__mux2i_1_40 r0 *1 0,0
Xsky130_fd_sc_hd__mux2i_1_40 \_0821_ \_0970_ net23 VGND VPWR VPWR \_0018_[29]
+ sky130_fd_sc_hd__mux2i_1
* cell instance sky130_fd_sc_hd__mux2i_1_41 r0 *1 0,0
Xsky130_fd_sc_hd__mux2i_1_41 crc_state[23] cond_mem[0][24] net28 VGND VPWR VPWR
+ \_1097_ sky130_fd_sc_hd__mux2i_1
* cell instance sky130_fd_sc_hd__mux2i_1_42 r0 *1 0,0
Xsky130_fd_sc_hd__mux2i_1_42 \_1297_ \_1299_ net23 VGND VPWR VPWR \_0017_[31]
+ sky130_fd_sc_hd__mux2i_1
* cell instance sky130_fd_sc_hd__mux2i_1_43 r0 *1 0,0
Xsky130_fd_sc_hd__mux2i_1_43 \_0847_ \_0982_ net23 VGND VPWR VPWR \_0018_[24]
+ sky130_fd_sc_hd__mux2i_1
* cell instance sky130_fd_sc_hd__mux2i_1_44 r0 *1 0,0
Xsky130_fd_sc_hd__mux2i_1_44 crc_state[28] cond_mem[2][29] net26 VGND VPWR VPWR
+ \_1182_ sky130_fd_sc_hd__mux2i_1
* cell instance sky130_fd_sc_hd__mux2i_1_45 r0 *1 0,0
Xsky130_fd_sc_hd__mux2i_1_45 crc_state[28] cond_mem[3][29] net29 VGND VPWR VPWR
+ \_0227_ sky130_fd_sc_hd__mux2i_1
* cell instance sky130_fd_sc_hd__mux2i_1_46 r0 *1 0,0
Xsky130_fd_sc_hd__mux2i_1_46 \_1098_ \_1190_ net21 VGND VPWR VPWR \_0009_[24]
+ sky130_fd_sc_hd__mux2i_1
* cell instance sky130_fd_sc_hd__mux2i_1_47 r0 *1 0,0
Xsky130_fd_sc_hd__mux2i_1_47 cond_mem[1][24] crc_state[23] net27 VGND VPWR VPWR
+ \_1098_ sky130_fd_sc_hd__mux2i_1
* cell instance sky130_fd_sc_hd__mux2i_1_48 r0 *1 0,0
Xsky130_fd_sc_hd__mux2i_1_48 \_1147_ \_1149_ net21 VGND VPWR VPWR \_0008_[8]
+ sky130_fd_sc_hd__mux2i_1
* cell instance sky130_fd_sc_hd__mux2i_1_49 r0 *1 0,0
Xsky130_fd_sc_hd__mux2i_1_49 \_1299_ \_1301_ net23 VGND VPWR VPWR \_0018_[31]
+ sky130_fd_sc_hd__mux2i_1
* cell instance sky130_fd_sc_hd__mux2i_1_50 r0 *1 0,0
Xsky130_fd_sc_hd__mux2i_1_50 \_1088_ \_1089_ net21 VGND VPWR VPWR \_0008_[27]
+ sky130_fd_sc_hd__mux2i_1
* cell instance sky130_fd_sc_hd__mux2i_1_51 r0 *1 0,0
Xsky130_fd_sc_hd__mux2i_1_51 \_1131_ \_1133_ net21 VGND VPWR VPWR \_0008_[12]
+ sky130_fd_sc_hd__mux2i_1
* cell instance sky130_fd_sc_hd__mux2i_1_52 r0 *1 0,0
Xsky130_fd_sc_hd__mux2i_1_52 \_1089_ \_1185_ net21 VGND VPWR VPWR \_0009_[27]
+ sky130_fd_sc_hd__mux2i_1
* cell instance sky130_fd_sc_hd__mux2i_1_53 r0 *1 0,0
Xsky130_fd_sc_hd__mux2i_1_53 \_1208_ \_0258_ net21 VGND VPWR VPWR \_0010_[12]
+ sky130_fd_sc_hd__mux2i_1
* cell instance sky130_fd_sc_hd__mux2i_1_54 r0 *1 0,0
Xsky130_fd_sc_hd__mux2i_1_54 \_1149_ \_1216_ net21 VGND VPWR VPWR \_0009_[8]
+ sky130_fd_sc_hd__mux2i_1
* cell instance sky130_fd_sc_hd__mux2i_1_55 r0 *1 0,0
Xsky130_fd_sc_hd__mux2i_1_55 \_1216_ \_0268_ net21 VGND VPWR VPWR \_0010_[8]
+ sky130_fd_sc_hd__mux2i_1
* cell instance sky130_fd_sc_hd__mux2i_1_56 r0 *1 0,0
Xsky130_fd_sc_hd__mux2i_1_56 \_1133_ \_1208_ net21 VGND VPWR VPWR \_0009_[12]
+ sky130_fd_sc_hd__mux2i_1
* cell instance sky130_fd_sc_hd__mux2i_1_57 r0 *1 0,0
Xsky130_fd_sc_hd__mux2i_1_57 raw_mem[0][12] cond_mem[0][12] net41 VGND VPWR
+ VPWR \_1258_ sky130_fd_sc_hd__mux2i_1
* cell instance sky130_fd_sc_hd__mux2i_1_58 r0 *1 0,0
Xsky130_fd_sc_hd__mux2i_1_58 \_1190_ \_0237_ net21 VGND VPWR VPWR \_0010_[24]
+ sky130_fd_sc_hd__mux2i_1
* cell instance sky130_fd_sc_hd__mux2i_1_59 r0 *1 0,0
Xsky130_fd_sc_hd__mux2i_1_59 raw_mem[0][27] cond_mem[0][27] net41 VGND VPWR
+ VPWR \_1240_ sky130_fd_sc_hd__mux2i_1
* cell instance sky130_fd_sc_hd__mux2i_1_60 r0 *1 0,0
Xsky130_fd_sc_hd__mux2i_1_60 \_1188_ \_0235_ net21 VGND VPWR VPWR \_0010_[26]
+ sky130_fd_sc_hd__mux2i_1
* cell instance sky130_fd_sc_hd__mux2i_1_61 r0 *1 0,0
Xsky130_fd_sc_hd__mux2i_1_61 crc_state[26] cond_mem[0][27] net28 VGND VPWR VPWR
+ \_1088_ sky130_fd_sc_hd__mux2i_1
* cell instance sky130_fd_sc_hd__mux2i_1_62 r0 *1 0,0
Xsky130_fd_sc_hd__mux2i_1_62 \_1185_ \_0230_ net21 VGND VPWR VPWR \_0010_[27]
+ sky130_fd_sc_hd__mux2i_1
* cell instance sky130_fd_sc_hd__mux2i_1_63 r0 *1 0,0
Xsky130_fd_sc_hd__mux2i_1_63 \_1094_ \_1188_ net21 VGND VPWR VPWR \_0009_[26]
+ sky130_fd_sc_hd__mux2i_1
* cell instance sky130_fd_sc_hd__mux2i_1_64 r0 *1 0,0
Xsky130_fd_sc_hd__mux2i_1_64 crc_state[23] cond_mem[2][24] net26 VGND VPWR VPWR
+ \_1190_ sky130_fd_sc_hd__mux2i_1
* cell instance sky130_fd_sc_hd__mux2i_1_65 r0 *1 0,0
Xsky130_fd_sc_hd__mux2i_1_65 cond_mem[1][27] crc_state[26] net27 VGND VPWR VPWR
+ \_1089_ sky130_fd_sc_hd__mux2i_1
* cell instance sky130_fd_sc_hd__mux2i_1_66 r0 *1 0,0
Xsky130_fd_sc_hd__mux2i_1_66 cond_mem[1][12] \_1132_ net27 VGND VPWR VPWR
+ \_1133_ sky130_fd_sc_hd__mux2i_1
* cell instance sky130_fd_sc_hd__mux2i_1_67 r0 *1 0,0
Xsky130_fd_sc_hd__mux2i_1_67 \_1092_ \_1094_ net21 VGND VPWR VPWR \_0008_[26]
+ sky130_fd_sc_hd__mux2i_1
* cell instance sky130_fd_sc_hd__mux2i_1_68 r0 *1 0,0
Xsky130_fd_sc_hd__mux2i_1_68 cond_mem[1][8] \_1148_ net27 VGND VPWR VPWR
+ \_1149_ sky130_fd_sc_hd__mux2i_1
* cell instance sky130_fd_sc_hd__mux2i_1_69 r0 *1 0,0
Xsky130_fd_sc_hd__mux2i_1_69 \_0837_ \_0978_ net23 VGND VPWR VPWR \_0018_[26]
+ sky130_fd_sc_hd__mux2i_1
* cell instance sky130_fd_sc_hd__mux2i_1_70 r0 *1 0,0
Xsky130_fd_sc_hd__mux2i_1_70 raw_mem[0][26] cond_mem[0][26] net41 VGND VPWR
+ VPWR \_1241_ sky130_fd_sc_hd__mux2i_1
* cell instance sky130_fd_sc_hd__mux2i_1_71 r0 *1 0,0
Xsky130_fd_sc_hd__mux2i_1_71 crc_state[23] cond_mem[3][24] net29 VGND VPWR VPWR
+ \_0237_ sky130_fd_sc_hd__mux2i_1
* cell instance sky130_fd_sc_hd__mux2i_1_72 r0 *1 0,0
Xsky130_fd_sc_hd__mux2i_1_72 \_0834_ \_0837_ net23 VGND VPWR VPWR \_0017_[26]
+ sky130_fd_sc_hd__mux2i_1
* cell instance sky130_fd_sc_hd__mux2i_1_73 r0 *1 0,0
Xsky130_fd_sc_hd__mux2i_1_73 crc_state[26] cond_mem[2][27] net26 VGND VPWR VPWR
+ \_1185_ sky130_fd_sc_hd__mux2i_1
* cell instance sky130_fd_sc_hd__mux2i_1_74 r0 *1 0,0
Xsky130_fd_sc_hd__mux2i_1_74 crc_state[26] cond_mem[3][27] net29 VGND VPWR VPWR
+ \_0230_ sky130_fd_sc_hd__mux2i_1
* cell instance sky130_fd_sc_hd__mux2i_1_75 r0 *1 0,0
Xsky130_fd_sc_hd__mux2i_1_75 raw_mem[0][5] cond_mem[0][5] net41 VGND VPWR VPWR
+ \_1266_ sky130_fd_sc_hd__mux2i_1
* cell instance sky130_fd_sc_hd__mux2i_1_76 r0 *1 0,0
Xsky130_fd_sc_hd__mux2i_1_76 \_1157_ \_1159_ net21 VGND VPWR VPWR \_0008_[5]
+ sky130_fd_sc_hd__mux2i_1
* cell instance sky130_fd_sc_hd__mux2i_1_77 r0 *1 0,0
Xsky130_fd_sc_hd__mux2i_1_77 \_1161_ \_1163_ net21 VGND VPWR VPWR \_0008_[4]
+ sky130_fd_sc_hd__mux2i_1
* cell instance sky130_fd_sc_hd__mux2i_1_78 r0 *1 0,0
Xsky130_fd_sc_hd__mux2i_1_78 \_1128_ \_1129_ net21 VGND VPWR VPWR \_0008_[13]
+ sky130_fd_sc_hd__mux2i_1
* cell instance sky130_fd_sc_hd__mux2i_1_79 r0 *1 0,0
Xsky130_fd_sc_hd__mux2i_1_79 \_1159_ \_1221_ net21 VGND VPWR VPWR \_0009_[5]
+ sky130_fd_sc_hd__mux2i_1
* cell instance sky130_fd_sc_hd__mux2i_1_80 r0 *1 0,0
Xsky130_fd_sc_hd__mux2i_1_80 \_1231_ \_0288_ net21 VGND VPWR VPWR \_0010_[0]
+ sky130_fd_sc_hd__mux2i_1
* cell instance sky130_fd_sc_hd__mux2i_1_81 r0 *1 0,0
Xsky130_fd_sc_hd__mux2i_1_81 \_1129_ \_1206_ net21 VGND VPWR VPWR \_0009_[13]
+ sky130_fd_sc_hd__mux2i_1
* cell instance sky130_fd_sc_hd__mux2i_1_82 r0 *1 0,0
Xsky130_fd_sc_hd__mux2i_1_82 raw_mem[0][6] cond_mem[0][6] net41 VGND VPWR VPWR
+ \_1265_ sky130_fd_sc_hd__mux2i_1
* cell instance sky130_fd_sc_hd__mux2i_1_83 r0 *1 0,0
Xsky130_fd_sc_hd__mux2i_1_83 \_1221_ \_0275_ net21 VGND VPWR VPWR \_0010_[5]
+ sky130_fd_sc_hd__mux2i_1
* cell instance sky130_fd_sc_hd__mux2i_1_84 r0 *1 0,0
Xsky130_fd_sc_hd__mux2i_1_84 raw_mem[0][13] cond_mem[0][13] net41 VGND VPWR
+ VPWR \_1257_ sky130_fd_sc_hd__mux2i_1
* cell instance sky130_fd_sc_hd__mux2i_1_85 r0 *1 0,0
Xsky130_fd_sc_hd__mux2i_1_85 \_1154_ \_1155_ net21 VGND VPWR VPWR \_0008_[6]
+ sky130_fd_sc_hd__mux2i_1
* cell instance sky130_fd_sc_hd__mux2i_1_86 r0 *1 0,0
Xsky130_fd_sc_hd__mux2i_1_86 \_1177_ \_1231_ net21 VGND VPWR VPWR \_0009_[0]
+ sky130_fd_sc_hd__mux2i_1
* cell instance sky130_fd_sc_hd__mux2i_1_87 r0 *1 0,0
Xsky130_fd_sc_hd__mux2i_1_87 raw_mem[0][4] cond_mem[0][4] net41 VGND VPWR VPWR
+ \_1267_ sky130_fd_sc_hd__mux2i_1
* cell instance sky130_fd_sc_hd__mux2i_1_88 r0 *1 0,0
Xsky130_fd_sc_hd__mux2i_1_88 \_1163_ \_1223_ net21 VGND VPWR VPWR \_0009_[4]
+ sky130_fd_sc_hd__mux2i_1
* cell instance sky130_fd_sc_hd__mux2i_1_89 r0 *1 0,0
Xsky130_fd_sc_hd__mux2i_1_89 crc_state[12] cond_mem[0][13] net28 VGND VPWR VPWR
+ \_1128_ sky130_fd_sc_hd__mux2i_1
* cell instance sky130_fd_sc_hd__mux2i_1_90 r0 *1 0,0
Xsky130_fd_sc_hd__mux2i_1_90 \_1176_ \_1177_ net21 VGND VPWR VPWR \_0008_[0]
+ sky130_fd_sc_hd__mux2i_1
* cell instance sky130_fd_sc_hd__mux2i_1_91 r0 *1 0,0
Xsky130_fd_sc_hd__mux2i_1_91 cond_mem[1][5] \_1158_ net27 VGND VPWR VPWR
+ \_1159_ sky130_fd_sc_hd__mux2i_1
* cell instance sky130_fd_sc_hd__mux2i_1_92 r0 *1 0,0
Xsky130_fd_sc_hd__mux2i_1_92 \_1155_ \_1219_ net21 VGND VPWR VPWR \_0009_[6]
+ sky130_fd_sc_hd__mux2i_1
* cell instance sky130_fd_sc_hd__mux2i_1_93 r0 *1 0,0
Xsky130_fd_sc_hd__mux2i_1_93 crc_state[5] cond_mem[0][6] net28 VGND VPWR VPWR
+ \_1154_ sky130_fd_sc_hd__mux2i_1
* cell instance sky130_fd_sc_hd__mux2i_1_94 r0 *1 0,0
Xsky130_fd_sc_hd__mux2i_1_94 \_1219_ \_0272_ net21 VGND VPWR VPWR \_0010_[6]
+ sky130_fd_sc_hd__mux2i_1
* cell instance sky130_fd_sc_hd__mux2i_1_95 r0 *1 0,0
Xsky130_fd_sc_hd__mux2i_1_95 cond_mem[1][4] \_1162_ net27 VGND VPWR VPWR
+ \_1163_ sky130_fd_sc_hd__mux2i_1
* cell instance sky130_fd_sc_hd__mux2i_1_96 r0 *1 0,0
Xsky130_fd_sc_hd__mux2i_1_96 cond_mem[1][13] crc_state[12] net27 VGND VPWR VPWR
+ \_1129_ sky130_fd_sc_hd__mux2i_1
* cell instance sky130_fd_sc_hd__mux2i_1_97 r0 *1 0,0
Xsky130_fd_sc_hd__mux2i_1_97 \_1206_ \_0255_ net21 VGND VPWR VPWR \_0010_[13]
+ sky130_fd_sc_hd__mux2i_1
* cell instance sky130_fd_sc_hd__mux2i_1_98 r0 *1 0,0
Xsky130_fd_sc_hd__mux2i_1_98 raw_mem[0][0] cond_mem[0][0] net41 VGND VPWR VPWR
+ \_1271_ sky130_fd_sc_hd__mux2i_1
* cell instance sky130_fd_sc_hd__mux2i_1_99 r0 *1 0,0
Xsky130_fd_sc_hd__mux2i_1_99 cond_mem[1][6] crc_state[5] net27 VGND VPWR VPWR
+ \_1155_ sky130_fd_sc_hd__mux2i_1
* cell instance sky130_fd_sc_hd__mux2i_1_100 r0 *1 0,0
Xsky130_fd_sc_hd__mux2i_1_100 crc_state[12] cond_mem[2][13] net26 VGND VPWR
+ VPWR \_1206_ sky130_fd_sc_hd__mux2i_1
* cell instance sky130_fd_sc_hd__mux2i_1_101 r0 *1 0,0
Xsky130_fd_sc_hd__mux2i_1_101 crc_state[5] cond_mem[3][6] net29 VGND VPWR VPWR
+ \_0272_ sky130_fd_sc_hd__mux2i_1
* cell instance sky130_fd_sc_hd__mux2i_1_102 r0 *1 0,0
Xsky130_fd_sc_hd__mux2i_1_102 crc_state[12] cond_mem[3][13] net29 VGND VPWR
+ VPWR \_0255_ sky130_fd_sc_hd__mux2i_1
* cell instance sky130_fd_sc_hd__mux2i_1_103 r0 *1 0,0
Xsky130_fd_sc_hd__mux2i_1_103 cond_mem[1][0] \_0232_ net27 VGND VPWR VPWR
+ \_1177_ sky130_fd_sc_hd__mux2i_1
* cell instance sky130_fd_sc_hd__mux2i_1_104 r0 *1 0,0
Xsky130_fd_sc_hd__mux2i_1_104 crc_state[5] cond_mem[2][6] net26 VGND VPWR VPWR
+ \_1219_ sky130_fd_sc_hd__mux2i_1
* cell instance sky130_fd_sc_hd__mux2i_1_105 r0 *1 0,0
Xsky130_fd_sc_hd__mux2i_1_105 \_0878_ \_0880_ net23 VGND VPWR VPWR \_0017_[16]
+ sky130_fd_sc_hd__mux2i_1
* cell instance sky130_fd_sc_hd__mux2i_1_106 r0 *1 0,0
Xsky130_fd_sc_hd__mux2i_1_106 \_0880_ \_0998_ net23 VGND VPWR VPWR \_0018_[16]
+ sky130_fd_sc_hd__mux2i_1
* cell instance sky130_fd_sc_hd__mux2i_1_107 r0 *1 0,0
Xsky130_fd_sc_hd__mux2i_1_107 \_1121_ \_1123_ net21 VGND VPWR VPWR \_0008_[16]
+ sky130_fd_sc_hd__mux2i_1
* cell instance sky130_fd_sc_hd__mux2i_1_108 r0 *1 0,0
Xsky130_fd_sc_hd__mux2i_1_108 raw_mem[0][16] cond_mem[0][16] net41 VGND VPWR
+ VPWR \_1253_ sky130_fd_sc_hd__mux2i_1
* cell instance sky130_fd_sc_hd__mux2i_1_109 r0 *1 0,0
Xsky130_fd_sc_hd__mux2i_1_109 \_1123_ \_1203_ net21 VGND VPWR VPWR \_0009_[16]
+ sky130_fd_sc_hd__mux2i_1
* cell instance sky130_fd_sc_hd__mux2i_1_110 r0 *1 0,0
Xsky130_fd_sc_hd__mux2i_1_110 \_1145_ \_1214_ net21 VGND VPWR VPWR \_0009_[9]
+ sky130_fd_sc_hd__mux2i_1
* cell instance sky130_fd_sc_hd__mux2i_1_111 r0 *1 0,0
Xsky130_fd_sc_hd__mux2i_1_111 \_1214_ \_0265_ net21 VGND VPWR VPWR \_0010_[9]
+ sky130_fd_sc_hd__mux2i_1
* cell instance sky130_fd_sc_hd__mux2i_1_112 r0 *1 0,0
Xsky130_fd_sc_hd__mux2i_1_112 raw_mem[0][2] cond_mem[0][2] net41 VGND VPWR VPWR
+ \_1269_ sky130_fd_sc_hd__mux2i_1
* cell instance sky130_fd_sc_hd__mux2i_1_113 r0 *1 0,0
Xsky130_fd_sc_hd__mux2i_1_113 \_1203_ \_0252_ net21 VGND VPWR VPWR \_0010_[16]
+ sky130_fd_sc_hd__mux2i_1
* cell instance sky130_fd_sc_hd__mux2i_1_114 r0 *1 0,0
Xsky130_fd_sc_hd__mux2i_1_114 \_1144_ \_1145_ net21 VGND VPWR VPWR \_0008_[9]
+ sky130_fd_sc_hd__mux2i_1
* cell instance sky130_fd_sc_hd__mux2i_1_115 r0 *1 0,0
Xsky130_fd_sc_hd__mux2i_1_115 cond_mem[1][9] crc_state[8] net27 VGND VPWR VPWR
+ \_1145_ sky130_fd_sc_hd__mux2i_1
* cell instance sky130_fd_sc_hd__mux2i_1_116 r0 *1 0,0
Xsky130_fd_sc_hd__mux2i_1_116 crc_state[8] cond_mem[2][9] net26 VGND VPWR VPWR
+ \_1214_ sky130_fd_sc_hd__mux2i_1
* cell instance sky130_fd_sc_hd__mux2i_1_117 r0 *1 0,0
Xsky130_fd_sc_hd__mux2i_1_117 \_1223_ \_0278_ net21 VGND VPWR VPWR \_0010_[4]
+ sky130_fd_sc_hd__mux2i_1
* cell instance sky130_fd_sc_hd__mux2i_1_118 r0 *1 0,0
Xsky130_fd_sc_hd__mux2i_1_118 crc_state[8] cond_mem[0][9] net28 VGND VPWR VPWR
+ \_1144_ sky130_fd_sc_hd__mux2i_1
* cell instance sky130_fd_sc_hd__mux2i_1_119 r0 *1 0,0
Xsky130_fd_sc_hd__mux2i_1_119 raw_mem[0][9] cond_mem[0][9] net41 VGND VPWR VPWR
+ \_1262_ sky130_fd_sc_hd__mux2i_1
* cell instance sky130_fd_sc_hd__mux2i_1_120 r0 *1 0,0
Xsky130_fd_sc_hd__mux2i_1_120 crc_state[8] cond_mem[3][9] net29 VGND VPWR VPWR
+ \_0265_ sky130_fd_sc_hd__mux2i_1
* cell instance sky130_fd_sc_hd__mux2i_1_121 r0 *1 0,0
Xsky130_fd_sc_hd__mux2i_1_121 cond_mem[1][16] \_1122_ net27 VGND VPWR VPWR
+ \_1123_ sky130_fd_sc_hd__mux2i_1
* cell instance sky130_fd_sc_hd__mux2i_1_122 r0 *1 0,0
Xsky130_fd_sc_hd__mux2i_1_122 \_1200_ \_0248_ net21 VGND VPWR VPWR \_0010_[18]
+ sky130_fd_sc_hd__mux2i_1
* cell instance sky130_fd_sc_hd__mux2i_1_123 r0 *1 0,0
Xsky130_fd_sc_hd__mux2i_1_123 \_1117_ \_1200_ net21 VGND VPWR VPWR \_0009_[18]
+ sky130_fd_sc_hd__mux2i_1
* cell instance sky130_fd_sc_hd__mux2i_1_124 r0 *1 0,0
Xsky130_fd_sc_hd__mux2i_1_124 \_1116_ \_1117_ net21 VGND VPWR VPWR \_0008_[18]
+ sky130_fd_sc_hd__mux2i_1
* cell instance sky130_fd_sc_hd__mux2i_1_125 r0 *1 0,0
Xsky130_fd_sc_hd__mux2i_1_125 crc_state[17] cond_mem[3][18] net29 VGND VPWR
+ VPWR \_0248_ sky130_fd_sc_hd__mux2i_1
* cell instance sky130_fd_sc_hd__mux2i_1_126 r0 *1 0,0
Xsky130_fd_sc_hd__mux2i_1_126 crc_state[17] cond_mem[2][18] net26 VGND VPWR
+ VPWR \_1200_ sky130_fd_sc_hd__mux2i_1
* cell instance sky130_fd_sc_hd__mux2i_1_127 r0 *1 0,0
Xsky130_fd_sc_hd__mux2i_1_127 cond_mem[1][18] crc_state[17] net27 VGND VPWR
+ VPWR \_1117_ sky130_fd_sc_hd__mux2i_1
* cell instance sky130_fd_sc_hd__mux2i_1_128 r0 *1 0,0
Xsky130_fd_sc_hd__mux2i_1_128 crc_state[17] cond_mem[0][18] net28 VGND VPWR
+ VPWR \_1116_ sky130_fd_sc_hd__mux2i_1
* cell instance sky130_fd_sc_hd__mux2i_1_129 r0 *1 0,0
Xsky130_fd_sc_hd__mux2i_1_129 \_1183_ \_0229_ net21 VGND VPWR VPWR \_0010_[28]
+ sky130_fd_sc_hd__mux2i_1
* cell instance sky130_fd_sc_hd__mux2i_1_130 r0 *1 0,0
Xsky130_fd_sc_hd__mux2i_1_130 bus_wdata[1] net41 \_0291_ VGND VPWR VPWR \_0292_
+ sky130_fd_sc_hd__mux2i_1
* cell instance sky130_fd_sc_hd__mux2i_1_131 r0 *1 0,0
Xsky130_fd_sc_hd__mux2i_1_131 raw_mem[0][18] cond_mem[0][18] net41 VGND VPWR
+ VPWR \_1251_ sky130_fd_sc_hd__mux2i_1
* cell instance sky130_fd_sc_hd__mux2i_1_132 r0 *1 0,0
Xsky130_fd_sc_hd__mux2i_1_132 \_1087_ \_1183_ net21 VGND VPWR VPWR \_0009_[28]
+ sky130_fd_sc_hd__mux2i_1
* cell instance sky130_fd_sc_hd__mux2i_1_133 r0 *1 0,0
Xsky130_fd_sc_hd__mux2i_1_133 \_1086_ \_1087_ net22 VGND VPWR VPWR \_0008_[28]
+ sky130_fd_sc_hd__mux2i_1
* cell instance sky130_fd_sc_hd__mux2i_1_134 r0 *1 0,0
Xsky130_fd_sc_hd__mux2i_1_134 crc_state[27] cond_mem[3][28] net29 VGND VPWR
+ VPWR \_0229_ sky130_fd_sc_hd__mux2i_1
* cell instance sky130_fd_sc_hd__mux2i_1_135 r0 *1 0,0
Xsky130_fd_sc_hd__mux2i_1_135 crc_state[27] cond_mem[2][28] net26 VGND VPWR
+ VPWR \_1183_ sky130_fd_sc_hd__mux2i_1
* cell instance sky130_fd_sc_hd__mux2i_1_136 r0 *1 0,0
Xsky130_fd_sc_hd__mux2i_1_136 crc_state[27] cond_mem[0][28] net28 VGND VPWR
+ VPWR \_1086_ sky130_fd_sc_hd__mux2i_1
* cell instance sky130_fd_sc_hd__mux2i_1_137 r0 *1 0,0
Xsky130_fd_sc_hd__mux2i_1_137 \_1180_ \_0225_ net22 VGND VPWR VPWR \_0010_[30]
+ sky130_fd_sc_hd__mux2i_1
* cell instance sky130_fd_sc_hd__mux2i_1_138 r0 *1 0,0
Xsky130_fd_sc_hd__mux2i_1_138 cond_mem[1][28] crc_state[27] net27 VGND VPWR
+ VPWR \_1087_ sky130_fd_sc_hd__mux2i_1
* cell instance sky130_fd_sc_hd__mux2i_1_139 r0 *1 0,0
Xsky130_fd_sc_hd__mux2i_1_139 \_1076_ \_1180_ net22 VGND VPWR VPWR \_0009_[30]
+ sky130_fd_sc_hd__mux2i_1
* cell instance sky130_fd_sc_hd__mux2i_1_140 r0 *1 0,0
Xsky130_fd_sc_hd__mux2i_1_140 crc_state[16] cond_mem[3][17] net29 VGND VPWR
+ VPWR \_0249_ sky130_fd_sc_hd__mux2i_1
* cell instance sky130_fd_sc_hd__mux2i_1_141 r0 *1 0,0
Xsky130_fd_sc_hd__mux2i_1_141 \_1201_ \_0249_ net22 VGND VPWR VPWR \_0010_[17]
+ sky130_fd_sc_hd__mux2i_1
* cell instance sky130_fd_sc_hd__mux2i_1_142 r0 *1 0,0
Xsky130_fd_sc_hd__mux2i_1_142 crc_state[29] cond_mem[3][30] net29 VGND VPWR
+ VPWR \_0225_ sky130_fd_sc_hd__mux2i_1
* cell instance sky130_fd_sc_hd__mux2i_1_143 r0 *1 0,0
Xsky130_fd_sc_hd__mux2i_1_143 raw_mem[0][1] cond_mem[0][1] net41 VGND VPWR VPWR
+ \_1270_ sky130_fd_sc_hd__mux2i_1
* cell instance sky130_fd_sc_hd__mux2i_1_144 r0 *1 0,0
Xsky130_fd_sc_hd__mux2i_1_144 raw_mem[0][28] cond_mem[0][28] net41 VGND VPWR
+ VPWR \_1239_ sky130_fd_sc_hd__mux2i_1
* cell instance sky130_fd_sc_hd__mux2i_1_145 r0 *1 0,0
Xsky130_fd_sc_hd__mux2i_1_145 \_1073_ \_1076_ net22 VGND VPWR VPWR \_0008_[30]
+ sky130_fd_sc_hd__mux2i_1
* cell instance sky130_fd_sc_hd__mux2i_1_146 r0 *1 0,0
Xsky130_fd_sc_hd__mux2i_1_146 crc_state[29] cond_mem[2][30] net26 VGND VPWR
+ VPWR \_1180_ sky130_fd_sc_hd__mux2i_1
* cell instance sky130_fd_sc_hd__mux2i_1_147 r0 *1 0,0
Xsky130_fd_sc_hd__mux2i_1_147 raw_mem[0][3] cond_mem[0][3] net41 VGND VPWR VPWR
+ \_1268_ sky130_fd_sc_hd__mux2i_1
* cell instance sky130_fd_sc_hd__mux2i_1_148 r0 *1 0,0
Xsky130_fd_sc_hd__mux2i_1_148 cond_mem[1][30] crc_state[29] net27 VGND VPWR
+ VPWR \_1076_ sky130_fd_sc_hd__mux2i_1
* cell instance sky130_fd_sc_hd__mux2i_1_149 r0 *1 0,0
Xsky130_fd_sc_hd__mux2i_1_149 net43 raw_sr[16] \_0138_ VGND VPWR VPWR \_0139_
+ sky130_fd_sc_hd__mux2i_1
* cell instance sky130_fd_sc_hd__mux2i_1_150 r0 *1 0,0
Xsky130_fd_sc_hd__mux2i_1_150 crc_state[29] cond_mem[0][30] net28 VGND VPWR
+ VPWR \_1073_ sky130_fd_sc_hd__mux2i_1
* cell instance sky130_fd_sc_hd__mux2i_1_151 r0 *1 0,0
Xsky130_fd_sc_hd__mux2i_1_151 raw_sr[0] net43 \_1413_ VGND VPWR VPWR \_0197_
+ sky130_fd_sc_hd__mux2i_1
* cell instance sky130_fd_sc_hd__mux2i_1_152 r0 *1 0,0
Xsky130_fd_sc_hd__mux2i_1_152 raw_mem[0][7] cond_mem[0][7] net41 VGND VPWR VPWR
+ \_1264_ sky130_fd_sc_hd__mux2i_1
* cell instance sky130_fd_sc_hd__mux2i_1_153 r0 *1 0,0
Xsky130_fd_sc_hd__mux2i_1_153 \_1119_ \_1201_ net22 VGND VPWR VPWR \_0009_[17]
+ sky130_fd_sc_hd__mux2i_1
* cell instance sky130_fd_sc_hd__mux2i_1_154 r0 *1 0,0
Xsky130_fd_sc_hd__mux2i_1_154 \_1151_ \_1153_ net22 VGND VPWR VPWR \_0008_[7]
+ sky130_fd_sc_hd__mux2i_1
* cell instance sky130_fd_sc_hd__mux2i_1_155 r0 *1 0,0
Xsky130_fd_sc_hd__mux2i_1_155 \_1218_ \_0271_ net22 VGND VPWR VPWR \_0010_[7]
+ sky130_fd_sc_hd__mux2i_1
* cell instance sky130_fd_sc_hd__mux2i_1_156 r0 *1 0,0
Xsky130_fd_sc_hd__mux2i_1_156 raw_mem[0][30] cond_mem[0][30] net41 VGND VPWR
+ VPWR \_1237_ sky130_fd_sc_hd__mux2i_1
* cell instance sky130_fd_sc_hd__mux2i_1_157 r0 *1 0,0
Xsky130_fd_sc_hd__mux2i_1_157 \_1135_ \_1138_ net22 VGND VPWR VPWR \_0008_[11]
+ sky130_fd_sc_hd__mux2i_1
* cell instance sky130_fd_sc_hd__mux2i_1_158 r0 *1 0,0
Xsky130_fd_sc_hd__mux2i_1_158 \_1138_ \_1211_ net22 VGND VPWR VPWR \_0009_[11]
+ sky130_fd_sc_hd__mux2i_1
* cell instance sky130_fd_sc_hd__mux2i_1_159 r0 *1 0,0
Xsky130_fd_sc_hd__mux2i_1_159 crc_state[16] cond_mem[2][17] net26 VGND VPWR
+ VPWR \_1201_ sky130_fd_sc_hd__mux2i_1
* cell instance sky130_fd_sc_hd__mux2i_1_160 r0 *1 0,0
Xsky130_fd_sc_hd__mux2i_1_160 \_1153_ \_1218_ net22 VGND VPWR VPWR \_0009_[7]
+ sky130_fd_sc_hd__mux2i_1
* cell instance sky130_fd_sc_hd__mux2i_1_161 r0 *1 0,0
Xsky130_fd_sc_hd__mux2i_1_161 \_1118_ \_1119_ net22 VGND VPWR VPWR \_0008_[17]
+ sky130_fd_sc_hd__mux2i_1
* cell instance sky130_fd_sc_hd__mux2i_1_162 r0 *1 0,0
Xsky130_fd_sc_hd__mux2i_1_162 cond_mem[1][11] \_1136_ net27 VGND VPWR VPWR
+ \_1138_ sky130_fd_sc_hd__mux2i_1
* cell instance sky130_fd_sc_hd__mux2i_1_163 r0 *1 0,0
Xsky130_fd_sc_hd__mux2i_1_163 crc_state[16] cond_mem[0][17] net28 VGND VPWR
+ VPWR \_1118_ sky130_fd_sc_hd__mux2i_1
* cell instance sky130_fd_sc_hd__mux2i_1_164 r0 *1 0,0
Xsky130_fd_sc_hd__mux2i_1_164 cond_mem[1][17] crc_state[16] net27 VGND VPWR
+ VPWR \_1119_ sky130_fd_sc_hd__mux2i_1
* cell instance sky130_fd_sc_hd__mux2i_1_165 r0 *1 0,0
Xsky130_fd_sc_hd__mux2i_1_165 \_0907_ \_0909_ net24 VGND VPWR VPWR \_0017_[10]
+ sky130_fd_sc_hd__mux2i_1
* cell instance sky130_fd_sc_hd__mux2i_1_166 r0 *1 0,0
Xsky130_fd_sc_hd__mux2i_1_166 \_1211_ \_0261_ net22 VGND VPWR VPWR \_0010_[11]
+ sky130_fd_sc_hd__mux2i_1
* cell instance sky130_fd_sc_hd__mux2i_1_167 r0 *1 0,0
Xsky130_fd_sc_hd__mux2i_1_167 cond_mem[1][7] \_1152_ net27 VGND VPWR VPWR
+ \_1153_ sky130_fd_sc_hd__mux2i_1
* cell instance sky130_fd_sc_hd__mux2i_1_168 r0 *1 0,0
Xsky130_fd_sc_hd__mux2i_1_168 \_1141_ \_1143_ net22 VGND VPWR VPWR \_0008_[10]
+ sky130_fd_sc_hd__mux2i_1
* cell instance sky130_fd_sc_hd__mux2i_1_169 r0 *1 0,0
Xsky130_fd_sc_hd__mux2i_1_169 \_0902_ \_0904_ net24 VGND VPWR VPWR \_0017_[11]
+ sky130_fd_sc_hd__mux2i_1
* cell instance sky130_fd_sc_hd__mux2i_1_170 r0 *1 0,0
Xsky130_fd_sc_hd__mux2i_1_170 \_0909_ \_1014_ net24 VGND VPWR VPWR \_0018_[10]
+ sky130_fd_sc_hd__mux2i_1
* cell instance sky130_fd_sc_hd__mux2i_1_171 r0 *1 0,0
Xsky130_fd_sc_hd__mux2i_1_171 raw_mem[0][10] cond_mem[0][10] net41 VGND VPWR
+ VPWR \_1261_ sky130_fd_sc_hd__mux2i_1
* cell instance sky130_fd_sc_hd__mux2i_1_172 r0 *1 0,0
Xsky130_fd_sc_hd__mux2i_1_172 raw_mem[0][11] cond_mem[0][11] net41 VGND VPWR
+ VPWR \_1260_ sky130_fd_sc_hd__mux2i_1
* cell instance sky130_fd_sc_hd__mux2i_1_173 r0 *1 0,0
Xsky130_fd_sc_hd__mux2i_1_173 raw_mem[0][17] cond_mem[0][17] net41 VGND VPWR
+ VPWR \_1252_ sky130_fd_sc_hd__mux2i_1
* cell instance sky130_fd_sc_hd__mux2i_1_174 r0 *1 0,0
Xsky130_fd_sc_hd__mux2i_1_174 \_1167_ \_1169_ net22 VGND VPWR VPWR \_0008_[2]
+ sky130_fd_sc_hd__mux2i_1
* cell instance sky130_fd_sc_hd__mux2i_1_175 r0 *1 0,0
Xsky130_fd_sc_hd__mux2i_1_175 \_1143_ \_1213_ net22 VGND VPWR VPWR \_0009_[10]
+ sky130_fd_sc_hd__mux2i_1
* cell instance sky130_fd_sc_hd__mux2i_1_176 r0 *1 0,0
Xsky130_fd_sc_hd__mux2i_1_176 \_0904_ \_1012_ net24 VGND VPWR VPWR \_0018_[11]
+ sky130_fd_sc_hd__mux2i_1
* cell instance sky130_fd_sc_hd__mux2i_1_177 r0 *1 0,0
Xsky130_fd_sc_hd__mux2i_1_177 \_0108_ raw_sr[8] \_0168_ VGND VPWR VPWR \_0169_
+ sky130_fd_sc_hd__mux2i_1
* cell instance sky130_fd_sc_hd__mux2i_1_178 r0 *1 0,0
Xsky130_fd_sc_hd__mux2i_1_178 \_1213_ \_0264_ net22 VGND VPWR VPWR \_0010_[10]
+ sky130_fd_sc_hd__mux2i_1
* cell instance sky130_fd_sc_hd__mux2i_1_179 r0 *1 0,0
Xsky130_fd_sc_hd__mux2i_1_179 \_1126_ \_1127_ net22 VGND VPWR VPWR \_0008_[14]
+ sky130_fd_sc_hd__mux2i_1
* cell instance sky130_fd_sc_hd__mux2i_1_180 r0 *1 0,0
Xsky130_fd_sc_hd__mux2i_1_180 cond_mem[1][10] \_1142_ net27 VGND VPWR VPWR
+ \_1143_ sky130_fd_sc_hd__mux2i_1
* cell instance sky130_fd_sc_hd__mux2i_1_181 r0 *1 0,0
Xsky130_fd_sc_hd__mux2i_1_181 \_1127_ \_1205_ net22 VGND VPWR VPWR \_0009_[14]
+ sky130_fd_sc_hd__mux2i_1
* cell instance sky130_fd_sc_hd__mux2i_1_182 r0 *1 0,0
Xsky130_fd_sc_hd__mux2i_1_182 crc_state[13] cond_mem[0][14] net28 VGND VPWR
+ VPWR \_1126_ sky130_fd_sc_hd__mux2i_1
* cell instance sky130_fd_sc_hd__mux2i_1_183 r0 *1 0,0
Xsky130_fd_sc_hd__mux2i_1_183 \_1164_ \_1165_ net22 VGND VPWR VPWR \_0008_[3]
+ sky130_fd_sc_hd__mux2i_1
* cell instance sky130_fd_sc_hd__mux2i_1_184 r0 *1 0,0
Xsky130_fd_sc_hd__mux2i_1_184 cond_mem[1][14] crc_state[13] net27 VGND VPWR
+ VPWR \_1127_ sky130_fd_sc_hd__mux2i_1
* cell instance sky130_fd_sc_hd__mux2i_1_185 r0 *1 0,0
Xsky130_fd_sc_hd__mux2i_1_185 crc_state[2] cond_mem[0][3] net28 VGND VPWR VPWR
+ \_1164_ sky130_fd_sc_hd__mux2i_1
* cell instance sky130_fd_sc_hd__mux2i_1_186 r0 *1 0,0
Xsky130_fd_sc_hd__mux2i_1_186 raw_mem[0][14] cond_mem[0][14] net41 VGND VPWR
+ VPWR \_1255_ sky130_fd_sc_hd__mux2i_1
* cell instance sky130_fd_sc_hd__mux2i_1_187 r0 *1 0,0
Xsky130_fd_sc_hd__mux2i_1_187 \_1205_ \_0254_ net22 VGND VPWR VPWR \_0010_[14]
+ sky130_fd_sc_hd__mux2i_1
* cell instance sky130_fd_sc_hd__mux2i_1_188 r0 *1 0,0
Xsky130_fd_sc_hd__mux2i_1_188 raw_sr[12] \_0108_ \_0156_ VGND VPWR VPWR \_0157_
+ sky130_fd_sc_hd__mux2i_1
* cell instance sky130_fd_sc_hd__mux2i_1_189 r0 *1 0,0
Xsky130_fd_sc_hd__mux2i_1_189 crc_state[13] cond_mem[2][14] net26 VGND VPWR
+ VPWR \_1205_ sky130_fd_sc_hd__mux2i_1
* cell instance sky130_fd_sc_hd__mux2i_1_190 r0 *1 0,0
Xsky130_fd_sc_hd__mux2i_1_190 \_0830_ \_0832_ net24 VGND VPWR VPWR \_0017_[27]
+ sky130_fd_sc_hd__mux2i_1
* cell instance sky130_fd_sc_hd__mux2i_1_191 r0 *1 0,0
Xsky130_fd_sc_hd__mux2i_1_191 \_1112_ \_1113_ net22 VGND VPWR VPWR \_0008_[20]
+ sky130_fd_sc_hd__mux2i_1
* cell instance sky130_fd_sc_hd__mux2i_1_192 r0 *1 0,0
Xsky130_fd_sc_hd__mux2i_1_192 \_1113_ \_1198_ net22 VGND VPWR VPWR \_0009_[20]
+ sky130_fd_sc_hd__mux2i_1
* cell instance sky130_fd_sc_hd__mux2i_1_193 r0 *1 0,0
Xsky130_fd_sc_hd__mux2i_1_193 \_0882_ \_0884_ net24 VGND VPWR VPWR \_0017_[15]
+ sky130_fd_sc_hd__mux2i_1
* cell instance sky130_fd_sc_hd__mux2i_1_194 r0 *1 0,0
Xsky130_fd_sc_hd__mux2i_1_194 \_1165_ \_1224_ net22 VGND VPWR VPWR \_0009_[3]
+ sky130_fd_sc_hd__mux2i_1
* cell instance sky130_fd_sc_hd__mux2i_1_195 r0 *1 0,0
Xsky130_fd_sc_hd__mux2i_1_195 crc_state[13] cond_mem[3][14] net29 VGND VPWR
+ VPWR \_0254_ sky130_fd_sc_hd__mux2i_1
* cell instance sky130_fd_sc_hd__mux2i_1_196 r0 *1 0,0
Xsky130_fd_sc_hd__mux2i_1_196 \_0884_ \_1000_ net24 VGND VPWR VPWR \_0018_[15]
+ sky130_fd_sc_hd__mux2i_1
* cell instance sky130_fd_sc_hd__mux2i_1_197 r0 *1 0,0
Xsky130_fd_sc_hd__mux2i_1_197 crc_state[19] cond_mem[0][20] net28 VGND VPWR
+ VPWR \_1112_ sky130_fd_sc_hd__mux2i_1
* cell instance sky130_fd_sc_hd__mux2i_1_198 r0 *1 0,0
Xsky130_fd_sc_hd__mux2i_1_198 \_1198_ \_0246_ net22 VGND VPWR VPWR \_0010_[20]
+ sky130_fd_sc_hd__mux2i_1
* cell instance sky130_fd_sc_hd__mux2i_1_199 r0 *1 0,0
Xsky130_fd_sc_hd__mux2i_1_199 \_1224_ \_0279_ net22 VGND VPWR VPWR \_0010_[3]
+ sky130_fd_sc_hd__mux2i_1
* cell instance sky130_fd_sc_hd__mux2i_1_200 r0 *1 0,0
Xsky130_fd_sc_hd__mux2i_1_200 cond_mem[1][20] crc_state[19] net27 VGND VPWR
+ VPWR \_1113_ sky130_fd_sc_hd__mux2i_1
* cell instance sky130_fd_sc_hd__mux2i_1_201 r0 *1 0,0
Xsky130_fd_sc_hd__mux2i_1_201 raw_mem[0][15] cond_mem[0][15] net41 VGND VPWR
+ VPWR \_1254_ sky130_fd_sc_hd__mux2i_1
* cell instance sky130_fd_sc_hd__mux2i_1_202 r0 *1 0,0
Xsky130_fd_sc_hd__mux2i_1_202 cond_mem[1][3] crc_state[2] net27 VGND VPWR VPWR
+ \_1165_ sky130_fd_sc_hd__mux2i_1
* cell instance sky130_fd_sc_hd__mux2i_1_203 r0 *1 0,0
Xsky130_fd_sc_hd__mux2i_1_203 raw_mem[0][20] cond_mem[0][20] net41 VGND VPWR
+ VPWR \_1249_ sky130_fd_sc_hd__mux2i_1
* cell instance sky130_fd_sc_hd__mux2i_1_204 r0 *1 0,0
Xsky130_fd_sc_hd__mux2i_1_204 crc_state[19] cond_mem[3][20] net29 VGND VPWR
+ VPWR \_0246_ sky130_fd_sc_hd__mux2i_1
* cell instance sky130_fd_sc_hd__mux2i_1_205 r0 *1 0,0
Xsky130_fd_sc_hd__mux2i_1_205 crc_state[19] cond_mem[2][20] net26 VGND VPWR
+ VPWR \_1198_ sky130_fd_sc_hd__mux2i_1
* cell instance sky130_fd_sc_hd__mux2i_1_206 r0 *1 0,0
Xsky130_fd_sc_hd__mux2i_1_206 \_0832_ \_0974_ net24 VGND VPWR VPWR \_0018_[27]
+ sky130_fd_sc_hd__mux2i_1
* cell instance sky130_fd_sc_hd__mux2i_1_207 r0 *1 0,0
Xsky130_fd_sc_hd__mux2i_1_207 \_0870_ \_0872_ net24 VGND VPWR VPWR \_0017_[18]
+ sky130_fd_sc_hd__mux2i_1
* cell instance sky130_fd_sc_hd__mux2i_1_208 r0 *1 0,0
Xsky130_fd_sc_hd__mux2i_1_208 crc_state[2] cond_mem[2][3] net26 VGND VPWR VPWR
+ \_1224_ sky130_fd_sc_hd__mux2i_1
* cell instance sky130_fd_sc_hd__mux2i_1_209 r0 *1 0,0
Xsky130_fd_sc_hd__mux2i_1_209 crc_state[2] cond_mem[3][3] net29 VGND VPWR VPWR
+ \_0279_ sky130_fd_sc_hd__mux2i_1
* cell instance sky130_fd_sc_hd__mux2i_1_210 r0 *1 0,0
Xsky130_fd_sc_hd__mux2i_1_210 crc_state[14] cond_mem[0][15] net28 VGND VPWR
+ VPWR \_1124_ sky130_fd_sc_hd__mux2i_1
* cell instance sky130_fd_sc_hd__mux2i_1_211 r0 *1 0,0
Xsky130_fd_sc_hd__mux2i_1_211 \_1124_ \_1125_ net22 VGND VPWR VPWR \_0008_[15]
+ sky130_fd_sc_hd__mux2i_1
* cell instance sky130_fd_sc_hd__mux2i_1_212 r0 *1 0,0
Xsky130_fd_sc_hd__mux2i_1_212 \_0872_ \_0994_ net24 VGND VPWR VPWR \_0018_[18]
+ sky130_fd_sc_hd__mux2i_1
* cell instance sky130_fd_sc_hd__mux2i_1_213 r0 *1 0,0
Xsky130_fd_sc_hd__mux2i_1_213 \_1109_ \_1110_ net22 VGND VPWR VPWR \_0008_[21]
+ sky130_fd_sc_hd__mux2i_1
* cell instance sky130_fd_sc_hd__mux2i_1_214 r0 *1 0,0
Xsky130_fd_sc_hd__mux2i_1_214 \_1110_ \_1197_ net22 VGND VPWR VPWR \_0009_[21]
+ sky130_fd_sc_hd__mux2i_1
* cell instance sky130_fd_sc_hd__mux2i_1_215 r0 *1 0,0
Xsky130_fd_sc_hd__mux2i_1_215 \_1204_ \_0253_ net22 VGND VPWR VPWR \_0010_[15]
+ sky130_fd_sc_hd__mux2i_1
* cell instance sky130_fd_sc_hd__mux2i_1_216 r0 *1 0,0
Xsky130_fd_sc_hd__mux2i_1_216 \_1125_ \_1204_ net22 VGND VPWR VPWR \_0009_[15]
+ sky130_fd_sc_hd__mux2i_1
* cell instance sky130_fd_sc_hd__mux2i_1_217 r0 *1 0,0
Xsky130_fd_sc_hd__mux2i_1_217 \_1197_ \_0245_ net22 VGND VPWR VPWR \_0010_[21]
+ sky130_fd_sc_hd__mux2i_1
* cell instance sky130_fd_sc_hd__mux2i_1_218 r0 *1 0,0
Xsky130_fd_sc_hd__mux2i_1_218 cond_mem[1][15] crc_state[14] net27 VGND VPWR
+ VPWR \_1125_ sky130_fd_sc_hd__mux2i_1
* cell instance sky130_fd_sc_hd__mux2i_1_219 r0 *1 0,0
Xsky130_fd_sc_hd__mux2i_1_219 cond_mem[1][21] crc_state[20] net27 VGND VPWR
+ VPWR \_1110_ sky130_fd_sc_hd__mux2i_1
* cell instance sky130_fd_sc_hd__mux2i_1_220 r0 *1 0,0
Xsky130_fd_sc_hd__mux2i_1_220 crc_state[14] cond_mem[3][15] net29 VGND VPWR
+ VPWR \_0253_ sky130_fd_sc_hd__mux2i_1
* cell instance sky130_fd_sc_hd__mux2i_1_221 r0 *1 0,0
Xsky130_fd_sc_hd__mux2i_1_221 crc_state[20] cond_mem[0][21] net28 VGND VPWR
+ VPWR \_1109_ sky130_fd_sc_hd__mux2i_1
* cell instance sky130_fd_sc_hd__mux2i_1_222 r0 *1 0,0
Xsky130_fd_sc_hd__mux2i_1_222 crc_state[14] cond_mem[2][15] net26 VGND VPWR
+ VPWR \_1204_ sky130_fd_sc_hd__mux2i_1
* cell instance sky130_fd_sc_hd__mux2i_1_223 r0 *1 0,0
Xsky130_fd_sc_hd__mux2i_1_223 crc_state[20] cond_mem[3][21] net29 VGND VPWR
+ VPWR \_0245_ sky130_fd_sc_hd__mux2i_1
* cell instance sky130_fd_sc_hd__mux2i_1_224 r0 *1 0,0
Xsky130_fd_sc_hd__mux2i_1_224 crc_state[20] cond_mem[2][21] net26 VGND VPWR
+ VPWR \_1197_ sky130_fd_sc_hd__mux2i_1
* cell instance sky130_fd_sc_hd__mux2i_1_225 r0 *1 0,0
Xsky130_fd_sc_hd__mux2i_1_225 \_0874_ \_0876_ net24 VGND VPWR VPWR \_0017_[17]
+ sky130_fd_sc_hd__mux2i_1
* cell instance sky130_fd_sc_hd__mux2i_1_226 r0 *1 0,0
Xsky130_fd_sc_hd__mux2i_1_226 \_1169_ \_1226_ net22 VGND VPWR VPWR \_0009_[2]
+ sky130_fd_sc_hd__mux2i_1
* cell instance sky130_fd_sc_hd__mux2i_1_227 r0 *1 0,0
Xsky130_fd_sc_hd__mux2i_1_227 raw_mem[0][21] cond_mem[0][21] net41 VGND VPWR
+ VPWR \_1248_ sky130_fd_sc_hd__mux2i_1
* cell instance sky130_fd_sc_hd__mux2i_1_228 r0 *1 0,0
Xsky130_fd_sc_hd__mux2i_1_228 cond_mem[1][2] \_1168_ net27 VGND VPWR VPWR
+ \_1169_ sky130_fd_sc_hd__mux2i_1
* cell instance sky130_fd_sc_hd__mux2i_1_229 r0 *1 0,0
Xsky130_fd_sc_hd__mux2i_1_229 \_1102_ \_1104_ net22 VGND VPWR VPWR \_0008_[23]
+ sky130_fd_sc_hd__mux2i_1
* cell instance sky130_fd_sc_hd__mux2i_1_230 r0 *1 0,0
Xsky130_fd_sc_hd__mux2i_1_230 \_0886_ \_0888_ net24 VGND VPWR VPWR \_0017_[14]
+ sky130_fd_sc_hd__mux2i_1
* cell instance sky130_fd_sc_hd__mux2i_1_231 r0 *1 0,0
Xsky130_fd_sc_hd__mux2i_1_231 \_0876_ \_0996_ net24 VGND VPWR VPWR \_0018_[17]
+ sky130_fd_sc_hd__mux2i_1
* cell instance sky130_fd_sc_hd__mux2i_1_232 r0 *1 0,0
Xsky130_fd_sc_hd__mux2i_1_232 \_1171_ \_1173_ net22 VGND VPWR VPWR \_0008_[1]
+ sky130_fd_sc_hd__mux2i_1
* cell instance sky130_fd_sc_hd__mux2i_1_233 r0 *1 0,0
Xsky130_fd_sc_hd__mux2i_1_233 raw_mem[0][23] cond_mem[0][23] net41 VGND VPWR
+ VPWR \_1245_ sky130_fd_sc_hd__mux2i_1
* cell instance sky130_fd_sc_hd__mux2i_1_234 r0 *1 0,0
Xsky130_fd_sc_hd__mux2i_1_234 \_1106_ \_1108_ net22 VGND VPWR VPWR \_0008_[22]
+ sky130_fd_sc_hd__mux2i_1
* cell instance sky130_fd_sc_hd__mux2i_1_235 r0 *1 0,0
Xsky130_fd_sc_hd__mux2i_1_235 \_1226_ \_0282_ net22 VGND VPWR VPWR \_0010_[2]
+ sky130_fd_sc_hd__mux2i_1
* cell instance sky130_fd_sc_hd__mux2i_1_236 r0 *1 0,0
Xsky130_fd_sc_hd__mux2i_1_236 raw_mem[0][22] cond_mem[0][22] net41 VGND VPWR
+ VPWR \_1247_ sky130_fd_sc_hd__mux2i_1
* cell instance sky130_fd_sc_hd__mux2i_1_237 r0 *1 0,0
Xsky130_fd_sc_hd__mux2i_1_237 \_1104_ \_1192_ net22 VGND VPWR VPWR \_0009_[23]
+ sky130_fd_sc_hd__mux2i_1
* cell instance sky130_fd_sc_hd__mux2i_1_238 r0 *1 0,0
Xsky130_fd_sc_hd__mux2i_1_238 \_0888_ \_1002_ net24 VGND VPWR VPWR \_0018_[14]
+ sky130_fd_sc_hd__mux2i_1
* cell instance sky130_fd_sc_hd__mux2i_1_239 r0 *1 0,0
Xsky130_fd_sc_hd__mux2i_1_239 \_1173_ \_1229_ net22 VGND VPWR VPWR \_0009_[1]
+ sky130_fd_sc_hd__mux2i_1
* cell instance sky130_fd_sc_hd__mux2i_1_240 r0 *1 0,0
Xsky130_fd_sc_hd__mux2i_1_240 \_0825_ \_0827_ net24 VGND VPWR VPWR \_0017_[28]
+ sky130_fd_sc_hd__mux2i_1
* cell instance sky130_fd_sc_hd__mux2i_1_241 r0 *1 0,0
Xsky130_fd_sc_hd__mux2i_1_241 \_1229_ \_0285_ net22 VGND VPWR VPWR \_0010_[1]
+ sky130_fd_sc_hd__mux2i_1
* cell instance sky130_fd_sc_hd__mux2i_1_242 r0 *1 0,0
Xsky130_fd_sc_hd__mux2i_1_242 \_1195_ \_0244_ net22 VGND VPWR VPWR \_0010_[22]
+ sky130_fd_sc_hd__mux2i_1
* cell instance sky130_fd_sc_hd__mux2i_1_243 r0 *1 0,0
Xsky130_fd_sc_hd__mux2i_1_243 cond_mem[1][23] \_1103_ net27 VGND VPWR VPWR
+ \_1104_ sky130_fd_sc_hd__mux2i_1
* cell instance sky130_fd_sc_hd__mux2i_1_244 r0 *1 0,0
Xsky130_fd_sc_hd__mux2i_1_244 \_1108_ \_1195_ net22 VGND VPWR VPWR \_0009_[22]
+ sky130_fd_sc_hd__mux2i_1
* cell instance sky130_fd_sc_hd__mux2i_1_245 r0 *1 0,0
Xsky130_fd_sc_hd__mux2i_1_245 \_1192_ \_0241_ net22 VGND VPWR VPWR \_0010_[23]
+ sky130_fd_sc_hd__mux2i_1
* cell instance sky130_fd_sc_hd__mux2i_1_246 r0 *1 0,0
Xsky130_fd_sc_hd__mux2i_1_246 cond_mem[1][22] \_1107_ net27 VGND VPWR VPWR
+ \_1108_ sky130_fd_sc_hd__mux2i_1
* cell instance sky130_fd_sc_hd__mux2i_1_247 r0 *1 0,0
Xsky130_fd_sc_hd__mux2i_1_247 \_0853_ \_0855_ net24 VGND VPWR VPWR \_0017_[22]
+ sky130_fd_sc_hd__mux2i_1
* cell instance sky130_fd_sc_hd__mux2i_1_248 r0 *1 0,0
Xsky130_fd_sc_hd__mux2i_1_248 cond_mem[1][1] \_1172_ net27 VGND VPWR VPWR
+ \_1173_ sky130_fd_sc_hd__mux2i_1
* cell instance sky130_fd_sc_hd__mux2i_1_249 r0 *1 0,0
Xsky130_fd_sc_hd__mux2i_1_249 \_0849_ \_0851_ net24 VGND VPWR VPWR \_0017_[23]
+ sky130_fd_sc_hd__mux2i_1
* cell instance sky130_fd_sc_hd__mux2i_1_250 r0 *1 0,0
Xsky130_fd_sc_hd__mux2i_1_250 \_0801_ \_0808_ net24 VGND VPWR VPWR \_0017_[30]
+ sky130_fd_sc_hd__mux2i_1
* cell instance sky130_fd_sc_hd__mux2i_1_251 r0 *1 0,0
Xsky130_fd_sc_hd__mux2i_1_251 \_0858_ \_0860_ net24 VGND VPWR VPWR \_0017_[21]
+ sky130_fd_sc_hd__mux2i_1
* cell instance sky130_fd_sc_hd__mux2i_1_252 r0 *1 0,0
Xsky130_fd_sc_hd__mux2i_1_252 \_0862_ \_0864_ net24 VGND VPWR VPWR \_0017_[20]
+ sky130_fd_sc_hd__mux2i_1
* cell instance sky130_fd_sc_hd__mux2i_1_253 r0 *1 0,0
Xsky130_fd_sc_hd__mux2i_1_253 raw_sr[20] \_0108_ \_0120_ VGND VPWR VPWR \_0121_
+ sky130_fd_sc_hd__mux2i_1
* cell instance sky130_fd_sc_hd__mux2i_1_254 r0 *1 0,0
Xsky130_fd_sc_hd__mux2i_1_254 \_0827_ \_0972_ net24 VGND VPWR VPWR \_0018_[28]
+ sky130_fd_sc_hd__mux2i_1
* cell instance sky130_fd_sc_hd__mux2i_1_255 r0 *1 0,0
Xsky130_fd_sc_hd__mux2i_1_255 \_0860_ \_0988_ net24 VGND VPWR VPWR \_0018_[21]
+ sky130_fd_sc_hd__mux2i_1
* cell instance sky130_fd_sc_hd__mux2i_1_256 r0 *1 0,0
Xsky130_fd_sc_hd__mux2i_1_256 \_0864_ \_0990_ net24 VGND VPWR VPWR \_0018_[20]
+ sky130_fd_sc_hd__mux2i_1
* cell instance sky130_fd_sc_hd__mux2i_1_257 r0 *1 0,0
Xsky130_fd_sc_hd__mux2i_1_257 \_0855_ \_0986_ net24 VGND VPWR VPWR \_0018_[22]
+ sky130_fd_sc_hd__mux2i_1
* cell instance sky130_fd_sc_hd__mux2i_1_258 r0 *1 0,0
Xsky130_fd_sc_hd__mux2i_1_258 \_0808_ \_0967_ net24 VGND VPWR VPWR \_0018_[30]
+ sky130_fd_sc_hd__mux2i_1
* cell instance sky130_fd_sc_hd__mux2i_1_259 r0 *1 0,0
Xsky130_fd_sc_hd__mux2i_1_259 \_0851_ \_0984_ net24 VGND VPWR VPWR \_0018_[23]
+ sky130_fd_sc_hd__mux2i_1
* cell instance sky130_fd_sc_hd__nand2_1_0 r0 *1 0,0
Xsky130_fd_sc_hd__nand2_1_0 bus_rdata_r[24] net36 VGND VPWR VPWR \_1328_
+ sky130_fd_sc_hd__nand2_1
* cell instance sky130_fd_sc_hd__nand2_1_1 r0 *1 0,0
Xsky130_fd_sc_hd__nand2_1_1 bus_rdata_r[25] net36 VGND VPWR VPWR \_1327_
+ sky130_fd_sc_hd__nand2_1
* cell instance sky130_fd_sc_hd__nand2_1_2 r0 *1 0,0
Xsky130_fd_sc_hd__nand2_1_2 bus_rdata_r[19] net36 VGND VPWR VPWR \_1333_
+ sky130_fd_sc_hd__nand2_1
* cell instance sky130_fd_sc_hd__nand2_1_3 r0 *1 0,0
Xsky130_fd_sc_hd__nand2_1_3 bus_rdata_r[29] net36 VGND VPWR VPWR \_1322_
+ sky130_fd_sc_hd__nand2_1
* cell instance sky130_fd_sc_hd__nand2_1_4 r0 *1 0,0
Xsky130_fd_sc_hd__nand2_1_4 net23 \_1019_ VGND VPWR VPWR \_1020_
+ sky130_fd_sc_hd__nand2_1
* cell instance sky130_fd_sc_hd__nand2_1_5 r0 *1 0,0
Xsky130_fd_sc_hd__nand2_1_5 \_0020_[25] net23 VGND VPWR VPWR \_1052_
+ sky130_fd_sc_hd__nand2_1
* cell instance sky130_fd_sc_hd__nand2_1_6 r0 *1 0,0
Xsky130_fd_sc_hd__nand2_1_6 bus_rdata_r[31] net36 VGND VPWR VPWR \_1311_
+ sky130_fd_sc_hd__nand2_1
* cell instance sky130_fd_sc_hd__nand2_1_7 r0 *1 0,0
Xsky130_fd_sc_hd__nand2_1_7 raw_mem[2][8] net33 VGND VPWR VPWR \_1018_
+ sky130_fd_sc_hd__nand2_1
* cell instance sky130_fd_sc_hd__nand2_1_8 r0 *1 0,0
Xsky130_fd_sc_hd__nand2_1_8 \_0020_[19] net23 VGND VPWR VPWR \_1059_
+ sky130_fd_sc_hd__nand2_1
* cell instance sky130_fd_sc_hd__nand2_1_9 r0 *1 0,0
Xsky130_fd_sc_hd__nand2_1_9 raw_mem[3][8] net32 VGND VPWR VPWR \_0170_
+ sky130_fd_sc_hd__nand2_1
* cell instance sky130_fd_sc_hd__nand2_1_10 r0 *1 0,0
Xsky130_fd_sc_hd__nand2_1_10 raw_mem[3][25] net32 VGND VPWR VPWR \_0091_
+ sky130_fd_sc_hd__nand2_1
* cell instance sky130_fd_sc_hd__nand2_1_11 r0 *1 0,0
Xsky130_fd_sc_hd__nand2_1_11 \_0020_[29] net23 VGND VPWR VPWR \_1048_
+ sky130_fd_sc_hd__nand2_1
* cell instance sky130_fd_sc_hd__nand2_1_12 r0 *1 0,0
Xsky130_fd_sc_hd__nand2_1_12 raw_mem[3][29] net32 VGND VPWR VPWR \_0066_
+ sky130_fd_sc_hd__nand2_1
* cell instance sky130_fd_sc_hd__nand2_1_13 r0 *1 0,0
Xsky130_fd_sc_hd__nand2_1_13 net23 \_1009_ VGND VPWR VPWR \_1010_
+ sky130_fd_sc_hd__nand2_1
* cell instance sky130_fd_sc_hd__nand2_1_14 r0 *1 0,0
Xsky130_fd_sc_hd__nand2_1_14 bus_rdata_r[27] net36 VGND VPWR VPWR \_1325_
+ sky130_fd_sc_hd__nand2_1
* cell instance sky130_fd_sc_hd__nand2_1_15 r0 *1 0,0
Xsky130_fd_sc_hd__nand2_1_15 raw_mem[3][19] net32 VGND VPWR VPWR \_0127_
+ sky130_fd_sc_hd__nand2_1
* cell instance sky130_fd_sc_hd__nand2_1_16 r0 *1 0,0
Xsky130_fd_sc_hd__nand2_1_16 net42 \_1362_ VGND VPWR VPWR \_1363_
+ sky130_fd_sc_hd__nand2_1
* cell instance sky130_fd_sc_hd__nand2_1_17 r0 *1 0,0
Xsky130_fd_sc_hd__nand2_1_17 raw_mem[2][12] net33 VGND VPWR VPWR \_1008_
+ sky130_fd_sc_hd__nand2_1
* cell instance sky130_fd_sc_hd__nand2_1_18 r0 *1 0,0
Xsky130_fd_sc_hd__nand2_1_18 \_0020_[24] net23 VGND VPWR VPWR \_1054_
+ sky130_fd_sc_hd__nand2_1
* cell instance sky130_fd_sc_hd__nand2_1_19 r0 *1 0,0
Xsky130_fd_sc_hd__nand2_1_19 raw_mem[3][12] net32 VGND VPWR VPWR \_0158_
+ sky130_fd_sc_hd__nand2_1
* cell instance sky130_fd_sc_hd__nand2_1_20 r0 *1 0,0
Xsky130_fd_sc_hd__nand2_1_20 raw_mem[0][12] \_0797_ VGND VPWR VPWR \_0898_
+ sky130_fd_sc_hd__nand2_1
* cell instance sky130_fd_sc_hd__nand2_1_21 r0 *1 0,0
Xsky130_fd_sc_hd__nand2_1_21 cond_mem[3][8] net29 VGND VPWR VPWR \_0267_
+ sky130_fd_sc_hd__nand2_1
* cell instance sky130_fd_sc_hd__nand2_1_22 r0 *1 0,0
Xsky130_fd_sc_hd__nand2_1_22 cond_mem[3][26] net29 VGND VPWR VPWR \_0234_
+ sky130_fd_sc_hd__nand2_1
* cell instance sky130_fd_sc_hd__nand2_1_23 r0 *1 0,0
Xsky130_fd_sc_hd__nand2_1_23 cond_mem[3][12] net29 VGND VPWR VPWR \_0257_
+ sky130_fd_sc_hd__nand2_1
* cell instance sky130_fd_sc_hd__nand2_1_24 r0 *1 0,0
Xsky130_fd_sc_hd__nand2_1_24 raw_mem[3][24] net32 VGND VPWR VPWR \_0096_
+ sky130_fd_sc_hd__nand2_1
* cell instance sky130_fd_sc_hd__nand2_1_25 r0 *1 0,0
Xsky130_fd_sc_hd__nand2_1_25 net23 \_1029_ VGND VPWR VPWR \_1030_
+ sky130_fd_sc_hd__nand2_1
* cell instance sky130_fd_sc_hd__nand2_1_26 r0 *1 0,0
Xsky130_fd_sc_hd__nand2_1_26 \_0233_ net27 VGND VPWR VPWR \_1093_
+ sky130_fd_sc_hd__nand2_1
* cell instance sky130_fd_sc_hd__nand2_1_27 r0 *1 0,0
Xsky130_fd_sc_hd__nand2_1_27 raw_mem[2][5] net33 VGND VPWR VPWR \_1028_
+ sky130_fd_sc_hd__nand2_1
* cell instance sky130_fd_sc_hd__nand2_1_28 r0 *1 0,0
Xsky130_fd_sc_hd__nand2_1_28 net23 \_1026_ VGND VPWR VPWR \_1027_
+ sky130_fd_sc_hd__nand2_1
* cell instance sky130_fd_sc_hd__nand2_1_29 r0 *1 0,0
Xsky130_fd_sc_hd__nand2_1_29 raw_mem[0][5] \_0797_ VGND VPWR VPWR \_0934_
+ sky130_fd_sc_hd__nand2_1
* cell instance sky130_fd_sc_hd__nand2_1_30 r0 *1 0,0
Xsky130_fd_sc_hd__nand2_1_30 raw_mem[3][5] net32 VGND VPWR VPWR \_0182_
+ sky130_fd_sc_hd__nand2_1
* cell instance sky130_fd_sc_hd__nand2_1_31 r0 *1 0,0
Xsky130_fd_sc_hd__nand2_1_31 \_0020_[26] net23 VGND VPWR VPWR \_1051_
+ sky130_fd_sc_hd__nand2_1
* cell instance sky130_fd_sc_hd__nand2_1_32 r0 *1 0,0
Xsky130_fd_sc_hd__nand2_1_32 \_1374_ \_1376_ VGND VPWR VPWR \_1377_
+ sky130_fd_sc_hd__nand2_1
* cell instance sky130_fd_sc_hd__nand2_1_33 r0 *1 0,0
Xsky130_fd_sc_hd__nand2_1_33 \_0810_ \_0935_ VGND VPWR VPWR \_1371_
+ sky130_fd_sc_hd__nand2_1
* cell instance sky130_fd_sc_hd__nand2_1_34 r0 *1 0,0
Xsky130_fd_sc_hd__nand2_1_34 raw_mem[2][6] net33 VGND VPWR VPWR \_1025_
+ sky130_fd_sc_hd__nand2_1
* cell instance sky130_fd_sc_hd__nand2_1_35 r0 *1 0,0
Xsky130_fd_sc_hd__nand2_1_35 raw_mem[3][6] net32 VGND VPWR VPWR \_0178_
+ sky130_fd_sc_hd__nand2_1
* cell instance sky130_fd_sc_hd__nand2_1_36 r0 *1 0,0
Xsky130_fd_sc_hd__nand2_1_36 raw_mem[0][6] \_0797_ VGND VPWR VPWR \_0929_
+ sky130_fd_sc_hd__nand2_1
* cell instance sky130_fd_sc_hd__nand2_1_37 r0 *1 0,0
Xsky130_fd_sc_hd__nand2_1_37 bus_addr[0] bus_addr[1] VGND VPWR VPWR \_0785_
+ sky130_fd_sc_hd__nand2_1
* cell instance sky130_fd_sc_hd__nand2_1_38 r0 *1 0,0
Xsky130_fd_sc_hd__nand2_1_38 net42 \_0810_ VGND VPWR VPWR \_0811_
+ sky130_fd_sc_hd__nand2_1
* cell instance sky130_fd_sc_hd__nand2_1_39 r0 *1 0,0
Xsky130_fd_sc_hd__nand2_1_39 net23 \_1006_ VGND VPWR VPWR \_1007_
+ sky130_fd_sc_hd__nand2_1
* cell instance sky130_fd_sc_hd__nand2_1_40 r0 *1 0,0
Xsky130_fd_sc_hd__nand2_1_40 raw_mem[0][13] \_0797_ VGND VPWR VPWR \_0893_
+ sky130_fd_sc_hd__nand2_1
* cell instance sky130_fd_sc_hd__nand2_1_41 r0 *1 0,0
Xsky130_fd_sc_hd__nand2_1_41 cond_mem[3][0] net29 VGND VPWR VPWR \_0287_
+ sky130_fd_sc_hd__nand2_1
* cell instance sky130_fd_sc_hd__nand2_1_42 r0 *1 0,0
Xsky130_fd_sc_hd__nand2_1_42 raw_mem[3][26] net32 VGND VPWR VPWR \_0085_
+ sky130_fd_sc_hd__nand2_1
* cell instance sky130_fd_sc_hd__nand2_1_43 r0 *1 0,0
Xsky130_fd_sc_hd__nand2_1_43 raw_mem[0][4] \_0797_ VGND VPWR VPWR \_0939_
+ sky130_fd_sc_hd__nand2_1
* cell instance sky130_fd_sc_hd__nand2_1_44 r0 *1 0,0
Xsky130_fd_sc_hd__nand2_1_44 raw_mem[2][13] net33 VGND VPWR VPWR \_1005_
+ sky130_fd_sc_hd__nand2_1
* cell instance sky130_fd_sc_hd__nand2_1_45 r0 *1 0,0
Xsky130_fd_sc_hd__nand2_1_45 raw_mem[3][13] net32 VGND VPWR VPWR \_0153_
+ sky130_fd_sc_hd__nand2_1
* cell instance sky130_fd_sc_hd__nand2_1_46 r0 *1 0,0
Xsky130_fd_sc_hd__nand2_1_46 net23 \_0961_ VGND VPWR VPWR \_0962_
+ sky130_fd_sc_hd__nand2_1
* cell instance sky130_fd_sc_hd__nand2_1_47 r0 *1 0,0
Xsky130_fd_sc_hd__nand2_1_47 raw_mem[0][0] \_0797_ VGND VPWR VPWR \_0958_
+ sky130_fd_sc_hd__nand2_1
* cell instance sky130_fd_sc_hd__nand2_1_48 r0 *1 0,0
Xsky130_fd_sc_hd__nand2_1_48 cond_mem[3][5] net29 VGND VPWR VPWR \_0274_
+ sky130_fd_sc_hd__nand2_1
* cell instance sky130_fd_sc_hd__nand2_1_49 r0 *1 0,0
Xsky130_fd_sc_hd__nand2_1_49 net23 \_1044_ VGND VPWR VPWR \_1045_
+ sky130_fd_sc_hd__nand2_1
* cell instance sky130_fd_sc_hd__nand2_1_50 r0 *1 0,0
Xsky130_fd_sc_hd__nand2_1_50 bus_wdata[2] \_0298_ VGND VPWR VPWR \_0299_
+ sky130_fd_sc_hd__nand2_1
* cell instance sky130_fd_sc_hd__nand2_1_51 r0 *1 0,0
Xsky130_fd_sc_hd__nand2_1_51 \_0734_ \_0736_ VGND VPWR VPWR \_0784_
+ sky130_fd_sc_hd__nand2_1
* cell instance sky130_fd_sc_hd__nand2_1_52 r0 *1 0,0
Xsky130_fd_sc_hd__nand2_1_52 net23 \_1032_ VGND VPWR VPWR \_1033_
+ sky130_fd_sc_hd__nand2_1
* cell instance sky130_fd_sc_hd__nand2_1_53 r0 *1 0,0
Xsky130_fd_sc_hd__nand2_1_53 raw_mem[2][0] net33 VGND VPWR VPWR \_1043_
+ sky130_fd_sc_hd__nand2_1
* cell instance sky130_fd_sc_hd__nand2_1_54 r0 *1 0,0
Xsky130_fd_sc_hd__nand2_1_54 net35 \_0273_ VGND VPWR VPWR \_0604_
+ sky130_fd_sc_hd__nand2_1
* cell instance sky130_fd_sc_hd__nand2_1_55 r0 *1 0,0
Xsky130_fd_sc_hd__nand2_1_55 net25 \_0605_ VGND VPWR VPWR \_0013_[5]
+ sky130_fd_sc_hd__nand2_1
* cell instance sky130_fd_sc_hd__nand2_1_56 r0 *1 0,0
Xsky130_fd_sc_hd__nand2_1_56 raw_mem[3][0] net32 VGND VPWR VPWR \_0198_
+ sky130_fd_sc_hd__nand2_1
* cell instance sky130_fd_sc_hd__nand2_1_57 r0 *1 0,0
Xsky130_fd_sc_hd__nand2_1_57 net25 \_0607_ VGND VPWR VPWR \_0013_[4]
+ sky130_fd_sc_hd__nand2_1
* cell instance sky130_fd_sc_hd__nand2_1_58 r0 *1 0,0
Xsky130_fd_sc_hd__nand2_1_58 net35 \_0276_ VGND VPWR VPWR \_0606_
+ sky130_fd_sc_hd__nand2_1
* cell instance sky130_fd_sc_hd__nand2_1_59 r0 *1 0,0
Xsky130_fd_sc_hd__nand2_1_59 \_0020_[16] net23 VGND VPWR VPWR \_1062_
+ sky130_fd_sc_hd__nand2_1
* cell instance sky130_fd_sc_hd__nand2_1_60 r0 *1 0,0
Xsky130_fd_sc_hd__nand2_1_60 \_0757_ \_0809_ VGND VPWR VPWR \_1313_
+ sky130_fd_sc_hd__nand2_1
* cell instance sky130_fd_sc_hd__nand2_1_61 r0 *1 0,0
Xsky130_fd_sc_hd__nand2_1_61 net35 \_0233_ VGND VPWR VPWR \_0559_
+ sky130_fd_sc_hd__nand2_1
* cell instance sky130_fd_sc_hd__nand2_1_62 r0 *1 0,0
Xsky130_fd_sc_hd__nand2_1_62 raw_mem[2][4] net33 VGND VPWR VPWR \_1031_
+ sky130_fd_sc_hd__nand2_1
* cell instance sky130_fd_sc_hd__nand2_1_63 r0 *1 0,0
Xsky130_fd_sc_hd__nand2_1_63 net25 \_0561_ VGND VPWR VPWR \_0013_[26]
+ sky130_fd_sc_hd__nand2_1
* cell instance sky130_fd_sc_hd__nand2_1_64 r0 *1 0,0
Xsky130_fd_sc_hd__nand2_1_64 net23 \_1038_ VGND VPWR VPWR \_1039_
+ sky130_fd_sc_hd__nand2_1
* cell instance sky130_fd_sc_hd__nand2_1_65 r0 *1 0,0
Xsky130_fd_sc_hd__nand2_1_65 raw_mem[0][2] \_0797_ VGND VPWR VPWR \_0950_
+ sky130_fd_sc_hd__nand2_1
* cell instance sky130_fd_sc_hd__nand2_1_66 r0 *1 0,0
Xsky130_fd_sc_hd__nand2_1_66 net42 \_0757_ VGND VPWR VPWR \_0758_
+ sky130_fd_sc_hd__nand2_1
* cell instance sky130_fd_sc_hd__nand2_1_67 r0 *1 0,0
Xsky130_fd_sc_hd__nand2_1_67 net42 \_1343_ VGND VPWR VPWR \_1344_
+ sky130_fd_sc_hd__nand2_1
* cell instance sky130_fd_sc_hd__nand2_1_68 r0 *1 0,0
Xsky130_fd_sc_hd__nand2_1_68 raw_mem[3][4] net32 VGND VPWR VPWR \_0186_
+ sky130_fd_sc_hd__nand2_1
* cell instance sky130_fd_sc_hd__nand2_1_69 r0 *1 0,0
Xsky130_fd_sc_hd__nand2_1_69 raw_mem[3][16] net32 VGND VPWR VPWR \_0140_
+ sky130_fd_sc_hd__nand2_1
* cell instance sky130_fd_sc_hd__nand2_1_70 r0 *1 0,0
Xsky130_fd_sc_hd__nand2_1_70 raw_mem[2][2] net33 VGND VPWR VPWR \_1037_
+ sky130_fd_sc_hd__nand2_1
* cell instance sky130_fd_sc_hd__nand2_1_71 r0 *1 0,0
Xsky130_fd_sc_hd__nand2_1_71 raw_mem[3][2] net32 VGND VPWR VPWR \_0193_
+ sky130_fd_sc_hd__nand2_1
* cell instance sky130_fd_sc_hd__nand2_1_72 r0 *1 0,0
Xsky130_fd_sc_hd__nand2_1_72 raw_mem[3][31] net32 VGND VPWR VPWR \_1293_
+ sky130_fd_sc_hd__nand2_1
* cell instance sky130_fd_sc_hd__nand2_1_73 r0 *1 0,0
Xsky130_fd_sc_hd__nand2_1_73 net24 \_0020_[31] VGND VPWR VPWR \_1302_
+ sky130_fd_sc_hd__nand2_1
* cell instance sky130_fd_sc_hd__nand2_1_74 r0 *1 0,0
Xsky130_fd_sc_hd__nand2_1_74 \_0783_ \_1343_ VGND VPWR VPWR \_1374_
+ sky130_fd_sc_hd__nand2_1
* cell instance sky130_fd_sc_hd__nand2_1_75 r0 *1 0,0
Xsky130_fd_sc_hd__nand2_1_75 bus_rdata_r[18] net36 VGND VPWR VPWR \_1335_
+ sky130_fd_sc_hd__nand2_1
* cell instance sky130_fd_sc_hd__nand2_1_76 r0 *1 0,0
Xsky130_fd_sc_hd__nand2_1_76 net23 \_1016_ VGND VPWR VPWR \_1017_
+ sky130_fd_sc_hd__nand2_1
* cell instance sky130_fd_sc_hd__nand2_1_77 r0 *1 0,0
Xsky130_fd_sc_hd__nand2_1_77 \_0020_[7] net23 VGND VPWR VPWR \_1067_
+ sky130_fd_sc_hd__nand2_1
* cell instance sky130_fd_sc_hd__nand2_1_78 r0 *1 0,0
Xsky130_fd_sc_hd__nand2_1_78 \_0752_ \_1343_ VGND VPWR VPWR \_1357_
+ sky130_fd_sc_hd__nand2_1
* cell instance sky130_fd_sc_hd__nand2_1_79 r0 *1 0,0
Xsky130_fd_sc_hd__nand2_1_79 net25 \_0601_ VGND VPWR VPWR \_0013_[7]
+ sky130_fd_sc_hd__nand2_1
* cell instance sky130_fd_sc_hd__nand2_1_80 r0 *1 0,0
Xsky130_fd_sc_hd__nand2_1_80 cond_mem[3][16] net29 VGND VPWR VPWR \_0251_
+ sky130_fd_sc_hd__nand2_1
* cell instance sky130_fd_sc_hd__nand2_1_81 r0 *1 0,0
Xsky130_fd_sc_hd__nand2_1_81 raw_mem[2][9] net33 VGND VPWR VPWR \_1015_
+ sky130_fd_sc_hd__nand2_1
* cell instance sky130_fd_sc_hd__nand2_1_82 r0 *1 0,0
Xsky130_fd_sc_hd__nand2_1_82 bus_we \_0290_ VGND VPWR VPWR \_0291_
+ sky130_fd_sc_hd__nand2_1
* cell instance sky130_fd_sc_hd__nand2_1_83 r0 *1 0,0
Xsky130_fd_sc_hd__nand2_1_83 raw_mem[0][9] \_0797_ VGND VPWR VPWR \_0912_
+ sky130_fd_sc_hd__nand2_1
* cell instance sky130_fd_sc_hd__nand2_1_84 r0 *1 0,0
Xsky130_fd_sc_hd__nand2_1_84 \_0754_ \_0761_ VGND VPWR VPWR \_0765_
+ sky130_fd_sc_hd__nand2_1
* cell instance sky130_fd_sc_hd__nand2_1_85 r0 *1 0,0
Xsky130_fd_sc_hd__nand2_1_85 raw_mem[3][9] net32 VGND VPWR VPWR \_0167_
+ sky130_fd_sc_hd__nand2_1
* cell instance sky130_fd_sc_hd__nand2_1_86 r0 *1 0,0
Xsky130_fd_sc_hd__nand2_1_86 net35 \_0269_ VGND VPWR VPWR \_0600_
+ sky130_fd_sc_hd__nand2_1
* cell instance sky130_fd_sc_hd__nand2_1_87 r0 *1 0,0
Xsky130_fd_sc_hd__nand2_1_87 net35 \_0266_ VGND VPWR VPWR \_0598_
+ sky130_fd_sc_hd__nand2_1
* cell instance sky130_fd_sc_hd__nand2_1_88 r0 *1 0,0
Xsky130_fd_sc_hd__nand2_1_88 \_0020_[1] net23 VGND VPWR VPWR \_1069_
+ sky130_fd_sc_hd__nand2_1
* cell instance sky130_fd_sc_hd__nand2_1_89 r0 *1 0,0
Xsky130_fd_sc_hd__nand2_1_89 \_0783_ \_0787_ VGND VPWR VPWR \_1315_
+ sky130_fd_sc_hd__nand2_1
* cell instance sky130_fd_sc_hd__nand2_1_90 r0 *1 0,0
Xsky130_fd_sc_hd__nand2_1_90 cond_mem[3][4] net29 VGND VPWR VPWR \_0277_
+ sky130_fd_sc_hd__nand2_1
* cell instance sky130_fd_sc_hd__nand2_1_91 r0 *1 0,0
Xsky130_fd_sc_hd__nand2_1_91 raw_mem[3][7] net32 VGND VPWR VPWR \_0174_
+ sky130_fd_sc_hd__nand2_1
* cell instance sky130_fd_sc_hd__nand2_1_92 r0 *1 0,0
Xsky130_fd_sc_hd__nand2_1_92 net25 \_0599_ VGND VPWR VPWR \_0013_[8]
+ sky130_fd_sc_hd__nand2_1
* cell instance sky130_fd_sc_hd__nand2_1_93 r0 *1 0,0
Xsky130_fd_sc_hd__nand2_1_93 \_0811_ \_0764_ VGND VPWR VPWR \_0812_
+ sky130_fd_sc_hd__nand2_1
* cell instance sky130_fd_sc_hd__nand2_1_94 r0 *1 0,0
Xsky130_fd_sc_hd__nand2_1_94 net35 \_0250_ VGND VPWR VPWR \_0582_
+ sky130_fd_sc_hd__nand2_1
* cell instance sky130_fd_sc_hd__nand2_1_95 r0 *1 0,0
Xsky130_fd_sc_hd__nand2_1_95 \_0545_ \_0583_ VGND VPWR VPWR \_0013_[16]
+ sky130_fd_sc_hd__nand2_1
* cell instance sky130_fd_sc_hd__nand2_1_96 r0 *1 0,0
Xsky130_fd_sc_hd__nand2_1_96 raw_mem[3][1] net32 VGND VPWR VPWR \_0196_
+ sky130_fd_sc_hd__nand2_1
* cell instance sky130_fd_sc_hd__nand2_1_97 r0 *1 0,0
Xsky130_fd_sc_hd__nand2_1_97 \_0014_[1] \_0781_ VGND VPWR VPWR \_0792_
+ sky130_fd_sc_hd__nand2_1
* cell instance sky130_fd_sc_hd__nand2_1_98 r0 *1 0,0
Xsky130_fd_sc_hd__nand2_1_98 \_0195_ \_0923_ VGND VPWR VPWR \_0955_
+ sky130_fd_sc_hd__nand2_1
* cell instance sky130_fd_sc_hd__nand2_1_99 r0 *1 0,0
Xsky130_fd_sc_hd__nand2_1_99 \_0173_ \_0923_ VGND VPWR VPWR \_0924_
+ sky130_fd_sc_hd__nand2_1
* cell instance sky130_fd_sc_hd__nand2_1_100 r0 *1 0,0
Xsky130_fd_sc_hd__nand2_1_100 raw_level[0] \_1401_ VGND VPWR VPWR \_0750_
+ sky130_fd_sc_hd__nand2_1
* cell instance sky130_fd_sc_hd__nand2_1_101 r0 *1 0,0
Xsky130_fd_sc_hd__nand2_1_101 ctrl[0] raw_valid VGND VPWR VPWR \_1395_
+ sky130_fd_sc_hd__nand2_1
* cell instance sky130_fd_sc_hd__nand2_1_102 r0 *1 0,0
Xsky130_fd_sc_hd__nand2_1_102 \_0781_ \_0782_ VGND VPWR VPWR \_0783_
+ sky130_fd_sc_hd__nand2_1
* cell instance sky130_fd_sc_hd__nand2_1_103 r0 *1 0,0
Xsky130_fd_sc_hd__nand2_1_103 \_0189_ \_0923_ VGND VPWR VPWR \_0945_
+ sky130_fd_sc_hd__nand2_1
* cell instance sky130_fd_sc_hd__nand2_1_104 r0 *1 0,0
Xsky130_fd_sc_hd__nand2_1_104 \_1401_ \_0796_ VGND VPWR VPWR \_0797_
+ sky130_fd_sc_hd__nand2_1
* cell instance sky130_fd_sc_hd__nand2_1_105 r0 *1 0,0
Xsky130_fd_sc_hd__nand2_1_105 \_0545_ \_0593_ VGND VPWR VPWR \_0013_[11]
+ sky130_fd_sc_hd__nand2_1
* cell instance sky130_fd_sc_hd__nand2_1_106 r0 *1 0,0
Xsky130_fd_sc_hd__nand2_1_106 net35 \_0256_ VGND VPWR VPWR \_0590_
+ sky130_fd_sc_hd__nand2_1
* cell instance sky130_fd_sc_hd__nand2_1_107 r0 *1 0,0
Xsky130_fd_sc_hd__nand2_1_107 bus_rdata_r[7] \_1309_ VGND VPWR VPWR \_1366_
+ sky130_fd_sc_hd__nand2_1
* cell instance sky130_fd_sc_hd__nand2_1_108 r0 *1 0,0
Xsky130_fd_sc_hd__nand2_1_108 \_0020_[3] net23 VGND VPWR VPWR \_1068_
+ sky130_fd_sc_hd__nand2_1
* cell instance sky130_fd_sc_hd__nand2_1_109 r0 *1 0,0
Xsky130_fd_sc_hd__nand2_1_109 net35 \_0259_ VGND VPWR VPWR \_0592_
+ sky130_fd_sc_hd__nand2_1
* cell instance sky130_fd_sc_hd__nand2_1_110 r0 *1 0,0
Xsky130_fd_sc_hd__nand2_1_110 \_0545_ \_0591_ VGND VPWR VPWR \_0013_[12]
+ sky130_fd_sc_hd__nand2_1
* cell instance sky130_fd_sc_hd__nand2_1_111 r0 *1 0,0
Xsky130_fd_sc_hd__nand2_1_111 \_0705_ \_0778_ VGND VPWR VPWR \_0779_
+ sky130_fd_sc_hd__nand2_1
* cell instance sky130_fd_sc_hd__nand2_1_112 r0 *1 0,0
Xsky130_fd_sc_hd__nand2_1_112 raw_sr[31] \_0705_ VGND VPWR VPWR \_1290_
+ sky130_fd_sc_hd__nand2_1
* cell instance sky130_fd_sc_hd__nand2_1_113 r0 *1 0,0
Xsky130_fd_sc_hd__nand2_1_113 cond_mem[3][7] net29 VGND VPWR VPWR \_0270_
+ sky130_fd_sc_hd__nand2_1
* cell instance sky130_fd_sc_hd__nand2_1_114 r0 *1 0,0
Xsky130_fd_sc_hd__nand2_1_114 \_0092_ \_1416_ VGND VPWR VPWR \_0138_
+ sky130_fd_sc_hd__nand2_1
* cell instance sky130_fd_sc_hd__nand2_1_115 r0 *1 0,0
Xsky130_fd_sc_hd__nand2_1_115 bus_rdata_r[17] \_1309_ VGND VPWR VPWR \_1341_
+ sky130_fd_sc_hd__nand2_1
* cell instance sky130_fd_sc_hd__nand2_1_116 r0 *1 0,0
Xsky130_fd_sc_hd__nand2_1_116 raw_mem[3][3] net32 VGND VPWR VPWR \_0190_
+ sky130_fd_sc_hd__nand2_1
* cell instance sky130_fd_sc_hd__nand2_1_117 r0 *1 0,0
Xsky130_fd_sc_hd__nand2_1_117 \_0311_ \_1400_ VGND VPWR VPWR \_0651_
+ sky130_fd_sc_hd__nand2_1
* cell instance sky130_fd_sc_hd__nand2_1_118 r0 *1 0,0
Xsky130_fd_sc_hd__nand2_1_118 net25 \_0595_ VGND VPWR VPWR \_0013_[10]
+ sky130_fd_sc_hd__nand2_1
* cell instance sky130_fd_sc_hd__nand2_1_119 r0 *1 0,0
Xsky130_fd_sc_hd__nand2_1_119 net35 \_0262_ VGND VPWR VPWR \_0594_
+ sky130_fd_sc_hd__nand2_1
* cell instance sky130_fd_sc_hd__nand2_1_120 r0 *1 0,0
Xsky130_fd_sc_hd__nand2_1_120 \_0020_[10] net24 VGND VPWR VPWR \_1066_
+ sky130_fd_sc_hd__nand2_1
* cell instance sky130_fd_sc_hd__nand2_1_121 r0 *1 0,0
Xsky130_fd_sc_hd__nand2_1_121 cond_mem[3][11] net29 VGND VPWR VPWR \_0260_
+ sky130_fd_sc_hd__nand2_1
* cell instance sky130_fd_sc_hd__nand2_1_122 r0 *1 0,0
Xsky130_fd_sc_hd__nand2_1_122 \_0020_[11] net24 VGND VPWR VPWR \_1065_
+ sky130_fd_sc_hd__nand2_1
* cell instance sky130_fd_sc_hd__nand2_1_123 r0 *1 0,0
Xsky130_fd_sc_hd__nand2_1_123 cond_mem[3][10] net29 VGND VPWR VPWR \_0263_
+ sky130_fd_sc_hd__nand2_1
* cell instance sky130_fd_sc_hd__nand2_1_124 r0 *1 0,0
Xsky130_fd_sc_hd__nand2_1_124 bus_rdata_r[21] \_1309_ VGND VPWR VPWR \_1331_
+ sky130_fd_sc_hd__nand2_1
* cell instance sky130_fd_sc_hd__nand2_1_125 r0 *1 0,0
Xsky130_fd_sc_hd__nand2_1_125 bus_rdata_r[23] \_1309_ VGND VPWR VPWR \_1329_
+ sky130_fd_sc_hd__nand2_1
* cell instance sky130_fd_sc_hd__nand2_1_126 r0 *1 0,0
Xsky130_fd_sc_hd__nand2_1_126 net35 \_0280_ VGND VPWR VPWR \_0610_
+ sky130_fd_sc_hd__nand2_1
* cell instance sky130_fd_sc_hd__nand2_1_127 r0 *1 0,0
Xsky130_fd_sc_hd__nand2_1_127 bus_rdata_r[15] \_1309_ VGND VPWR VPWR \_1346_
+ sky130_fd_sc_hd__nand2_1
* cell instance sky130_fd_sc_hd__nand2_1_128 r0 *1 0,0
Xsky130_fd_sc_hd__nand2_1_128 raw_mem[3][10] net32 VGND VPWR VPWR \_0164_
+ sky130_fd_sc_hd__nand2_1
* cell instance sky130_fd_sc_hd__nand2_1_129 r0 *1 0,0
Xsky130_fd_sc_hd__nand2_1_129 net25 \_0611_ VGND VPWR VPWR \_0013_[2]
+ sky130_fd_sc_hd__nand2_1
* cell instance sky130_fd_sc_hd__nand2_1_130 r0 *1 0,0
Xsky130_fd_sc_hd__nand2_1_130 raw_mem[3][11] net32 VGND VPWR VPWR \_0161_
+ sky130_fd_sc_hd__nand2_1
* cell instance sky130_fd_sc_hd__nand2_1_131 r0 *1 0,0
Xsky130_fd_sc_hd__nand2_1_131 \_0020_[15] net24 VGND VPWR VPWR \_1063_
+ sky130_fd_sc_hd__nand2_1
* cell instance sky130_fd_sc_hd__nand2_1_132 r0 *1 0,0
Xsky130_fd_sc_hd__nand2_1_132 raw_mem[3][15] net32 VGND VPWR VPWR \_0146_
+ sky130_fd_sc_hd__nand2_1
* cell instance sky130_fd_sc_hd__nand2_1_133 r0 *1 0,0
Xsky130_fd_sc_hd__nand2_1_133 \_0020_[27] net24 VGND VPWR VPWR \_1050_
+ sky130_fd_sc_hd__nand2_1
* cell instance sky130_fd_sc_hd__nand2_1_134 r0 *1 0,0
Xsky130_fd_sc_hd__nand2_1_134 \_0020_[18] net24 VGND VPWR VPWR \_1060_
+ sky130_fd_sc_hd__nand2_1
* cell instance sky130_fd_sc_hd__nand2_1_135 r0 *1 0,0
Xsky130_fd_sc_hd__nand2_1_135 raw_count[1] raw_count[0] VGND VPWR VPWR \_0074_
+ sky130_fd_sc_hd__nand2_1
* cell instance sky130_fd_sc_hd__nand2_1_136 r0 *1 0,0
Xsky130_fd_sc_hd__nand2_1_136 cond_level[0] net40 VGND VPWR VPWR \_0777_
+ sky130_fd_sc_hd__nand2_1
* cell instance sky130_fd_sc_hd__nand2_1_137 r0 *1 0,0
Xsky130_fd_sc_hd__nand2_1_137 cond_level[1] net40 VGND VPWR VPWR \_0772_
+ sky130_fd_sc_hd__nand2_1
* cell instance sky130_fd_sc_hd__nand2_1_138 r0 *1 0,0
Xsky130_fd_sc_hd__nand2_1_138 raw_count[2] \_0067_ VGND VPWR VPWR \_0119_
+ sky130_fd_sc_hd__nand2_1
* cell instance sky130_fd_sc_hd__nand2_1_139 r0 *1 0,0
Xsky130_fd_sc_hd__nand2_1_139 raw_mem[3][27] net32 VGND VPWR VPWR \_0079_
+ sky130_fd_sc_hd__nand2_1
* cell instance sky130_fd_sc_hd__nand2_1_140 r0 *1 0,0
Xsky130_fd_sc_hd__nand2_1_140 raw_mem[3][18] net32 VGND VPWR VPWR \_0132_
+ sky130_fd_sc_hd__nand2_1
* cell instance sky130_fd_sc_hd__nand2_1_141 r0 *1 0,0
Xsky130_fd_sc_hd__nand2_1_141 \_1422_ \_0183_ VGND VPWR VPWR \_0184_
+ sky130_fd_sc_hd__nand2_1
* cell instance sky130_fd_sc_hd__nand2_1_142 r0 *1 0,0
Xsky130_fd_sc_hd__nand2_1_142 \_0545_ \_0568_ VGND VPWR VPWR \_0013_[23]
+ sky130_fd_sc_hd__nand2_1
* cell instance sky130_fd_sc_hd__nand2_1_143 r0 *1 0,0
Xsky130_fd_sc_hd__nand2_1_143 \_0020_[17] net24 VGND VPWR VPWR \_1061_
+ sky130_fd_sc_hd__nand2_1
* cell instance sky130_fd_sc_hd__nand2_1_144 r0 *1 0,0
Xsky130_fd_sc_hd__nand2_1_144 net35 \_0239_ VGND VPWR VPWR \_0567_
+ sky130_fd_sc_hd__nand2_1
* cell instance sky130_fd_sc_hd__nand2_1_145 r0 *1 0,0
Xsky130_fd_sc_hd__nand2_1_145 \_0020_[14] net24 VGND VPWR VPWR \_1064_
+ sky130_fd_sc_hd__nand2_1
* cell instance sky130_fd_sc_hd__nand2_1_146 r0 *1 0,0
Xsky130_fd_sc_hd__nand2_1_146 \_1424_ \_0102_ VGND VPWR VPWR \_0103_
+ sky130_fd_sc_hd__nand2_1
* cell instance sky130_fd_sc_hd__nand2_1_147 r0 *1 0,0
Xsky130_fd_sc_hd__nand2_1_147 raw_mem[3][17] net32 VGND VPWR VPWR \_0137_
+ sky130_fd_sc_hd__nand2_1
* cell instance sky130_fd_sc_hd__nand2_1_148 r0 *1 0,0
Xsky130_fd_sc_hd__nand2_1_148 cond_mem[3][1] net29 VGND VPWR VPWR \_0284_
+ sky130_fd_sc_hd__nand2_1
* cell instance sky130_fd_sc_hd__nand2_1_149 r0 *1 0,0
Xsky130_fd_sc_hd__nand2_1_149 net25 \_0613_ VGND VPWR VPWR \_0013_[1]
+ sky130_fd_sc_hd__nand2_1
* cell instance sky130_fd_sc_hd__nand2_1_150 r0 *1 0,0
Xsky130_fd_sc_hd__nand2_1_150 raw_mem[3][14] net32 VGND VPWR VPWR \_0149_
+ sky130_fd_sc_hd__nand2_1
* cell instance sky130_fd_sc_hd__nand2_1_151 r0 *1 0,0
Xsky130_fd_sc_hd__nand2_1_151 net35 \_0283_ VGND VPWR VPWR \_0612_
+ sky130_fd_sc_hd__nand2_1
* cell instance sky130_fd_sc_hd__nand2_1_152 r0 *1 0,0
Xsky130_fd_sc_hd__nand2_1_152 net35 \_0242_ VGND VPWR VPWR \_0569_
+ sky130_fd_sc_hd__nand2_1
* cell instance sky130_fd_sc_hd__nand2_1_153 r0 *1 0,0
Xsky130_fd_sc_hd__nand2_1_153 \_0545_ \_0570_ VGND VPWR VPWR \_0013_[22]
+ sky130_fd_sc_hd__nand2_1
* cell instance sky130_fd_sc_hd__nand2_1_154 r0 *1 0,0
Xsky130_fd_sc_hd__nand2_1_154 cond_mem[3][2] net29 VGND VPWR VPWR \_0281_
+ sky130_fd_sc_hd__nand2_1
* cell instance sky130_fd_sc_hd__nand2_1_155 r0 *1 0,0
Xsky130_fd_sc_hd__nand2_1_155 cond_mem[3][22] net29 VGND VPWR VPWR \_0243_
+ sky130_fd_sc_hd__nand2_1
* cell instance sky130_fd_sc_hd__nand2_1_156 r0 *1 0,0
Xsky130_fd_sc_hd__nand2_1_156 cond_mem[3][23] net29 VGND VPWR VPWR \_0240_
+ sky130_fd_sc_hd__nand2_1
* cell instance sky130_fd_sc_hd__nand2_1_157 r0 *1 0,0
Xsky130_fd_sc_hd__nand2_1_157 \_0311_ \_0200_ VGND VPWR VPWR \_0537_
+ sky130_fd_sc_hd__nand2_1
* cell instance sky130_fd_sc_hd__nand2_1_158 r0 *1 0,0
Xsky130_fd_sc_hd__nand2_1_158 \_0020_[21] net24 VGND VPWR VPWR \_1057_
+ sky130_fd_sc_hd__nand2_1
* cell instance sky130_fd_sc_hd__nand2_1_159 r0 *1 0,0
Xsky130_fd_sc_hd__nand2_1_159 cond_count[11] gated VGND VPWR VPWR \_0627_
+ sky130_fd_sc_hd__nand2_1
* cell instance sky130_fd_sc_hd__nand2_1_160 r0 *1 0,0
Xsky130_fd_sc_hd__nand2_1_160 \_0020_[28] net24 VGND VPWR VPWR \_1049_
+ sky130_fd_sc_hd__nand2_1
* cell instance sky130_fd_sc_hd__nand2_1_161 r0 *1 0,0
Xsky130_fd_sc_hd__nand2_1_161 \_0200_ net30 VGND VPWR VPWR \_0634_
+ sky130_fd_sc_hd__nand2_1
* cell instance sky130_fd_sc_hd__nand2_1_162 r0 *1 0,0
Xsky130_fd_sc_hd__nand2_1_162 \_0020_[22] net24 VGND VPWR VPWR \_1056_
+ sky130_fd_sc_hd__nand2_1
* cell instance sky130_fd_sc_hd__nand2_1_163 r0 *1 0,0
Xsky130_fd_sc_hd__nand2_1_163 raw_mem[3][21] net32 VGND VPWR VPWR \_0118_
+ sky130_fd_sc_hd__nand2_1
* cell instance sky130_fd_sc_hd__nand2_1_164 r0 *1 0,0
Xsky130_fd_sc_hd__nand2_1_164 \_0020_[30] net24 VGND VPWR VPWR \_1047_
+ sky130_fd_sc_hd__nand2_1
* cell instance sky130_fd_sc_hd__nand2_1_165 r0 *1 0,0
Xsky130_fd_sc_hd__nand2_1_165 \_0020_[20] net24 VGND VPWR VPWR \_1058_
+ sky130_fd_sc_hd__nand2_1
* cell instance sky130_fd_sc_hd__nand2_1_166 r0 *1 0,0
Xsky130_fd_sc_hd__nand2_1_166 \_0203_ \_0216_ VGND VPWR VPWR \_0217_
+ sky130_fd_sc_hd__nand2_1
* cell instance sky130_fd_sc_hd__nand2_1_167 r0 *1 0,0
Xsky130_fd_sc_hd__nand2_1_167 raw_mem[3][28] net32 VGND VPWR VPWR \_0072_
+ sky130_fd_sc_hd__nand2_1
* cell instance sky130_fd_sc_hd__nand2_1_168 r0 *1 0,0
Xsky130_fd_sc_hd__nand2_1_168 \_0020_[23] net24 VGND VPWR VPWR \_1055_
+ sky130_fd_sc_hd__nand2_1
* cell instance sky130_fd_sc_hd__nand2_1_169 r0 *1 0,0
Xsky130_fd_sc_hd__nand2_1_169 \_0212_ \_0214_ VGND VPWR VPWR \_0215_
+ sky130_fd_sc_hd__nand2_1
* cell instance sky130_fd_sc_hd__nand2_1_170 r0 *1 0,0
Xsky130_fd_sc_hd__nand2_1_170 raw_mem[3][22] net32 VGND VPWR VPWR \_0113_
+ sky130_fd_sc_hd__nand2_1
* cell instance sky130_fd_sc_hd__nand2_1_171 r0 *1 0,0
Xsky130_fd_sc_hd__nand2_1_171 raw_mem[3][30] net32 VGND VPWR VPWR \_1430_
+ sky130_fd_sc_hd__nand2_1
* cell instance sky130_fd_sc_hd__nand2_1_172 r0 *1 0,0
Xsky130_fd_sc_hd__nand2_1_172 raw_mem[3][20] net32 VGND VPWR VPWR \_0122_
+ sky130_fd_sc_hd__nand2_1
* cell instance sky130_fd_sc_hd__nand2_1_173 r0 *1 0,0
Xsky130_fd_sc_hd__nand2_1_173 raw_mem[3][23] net32 VGND VPWR VPWR \_0106_
+ sky130_fd_sc_hd__nand2_1
* cell instance sky130_fd_sc_hd__nand2_1_174 r0 *1 0,0
Xsky130_fd_sc_hd__nand2_1_174 cond_count[15] gated VGND VPWR VPWR \_1287_
+ sky130_fd_sc_hd__nand2_1
* cell instance sky130_fd_sc_hd__nand2_1_175 r0 *1 0,0
Xsky130_fd_sc_hd__nand2_1_175 cond_count[12] gated VGND VPWR VPWR \_0624_
+ sky130_fd_sc_hd__nand2_1
* cell instance sky130_fd_sc_hd__nand2_1_176 r0 *1 0,0
Xsky130_fd_sc_hd__nand2_1_176 startup_count[6] startup_count[4] VGND VPWR VPWR
+ \_0481_ sky130_fd_sc_hd__nand2_1
* cell instance sky130_fd_sc_hd__nand2_1_177 r0 *1 0,0
Xsky130_fd_sc_hd__nand2_1_177 startup_done_r startup_count[13] VGND VPWR VPWR
+ \_0494_ sky130_fd_sc_hd__nand2_1
* cell instance sky130_fd_sc_hd__nand2_1_178 r0 *1 0,0
Xsky130_fd_sc_hd__nand2_1_178 \_0311_ \_0326_ VGND VPWR VPWR \_0327_
+ sky130_fd_sc_hd__nand2_1
* cell instance sky130_fd_sc_hd__nand2_1_179 r0 *1 0,0
Xsky130_fd_sc_hd__nand2_1_179 startup_done_r \_0478_ VGND VPWR VPWR \_0505_
+ sky130_fd_sc_hd__nand2_1
* cell instance sky130_fd_sc_hd__nand2_1_180 r0 *1 0,0
Xsky130_fd_sc_hd__nand2_1_180 startup_count[8] startup_count[7] VGND VPWR VPWR
+ \_0480_ sky130_fd_sc_hd__nand2_1
* cell instance sky130_fd_sc_hd__nand2_1_181 r0 *1 0,0
Xsky130_fd_sc_hd__nand2_1_181 startup_count[11] \_0484_ VGND VPWR VPWR \_0491_
+ sky130_fd_sc_hd__nand2_1
* cell instance sky130_fd_sc_hd__nand2_1_182 r0 *1 0,0
Xsky130_fd_sc_hd__nand2_1_182 \_0485_ \_0492_ VGND VPWR VPWR \_0493_
+ sky130_fd_sc_hd__nand2_1
* cell instance sky130_fd_sc_hd__nand2_1_183 r0 *1 0,0
Xsky130_fd_sc_hd__nand2_1_183 apt_index[13] net40 VGND VPWR VPWR \_0404_
+ sky130_fd_sc_hd__nand2_1
* cell instance sky130_fd_sc_hd__nand2_1_184 r0 *1 0,0
Xsky130_fd_sc_hd__nand2_1_184 startup_done_r startup_count[14] VGND VPWR VPWR
+ \_0487_ sky130_fd_sc_hd__nand2_1
* cell instance sky130_fd_sc_hd__nand2_1_185 r0 *1 0,0
Xsky130_fd_sc_hd__nand2_1_185 startup_done_r startup_count[11] VGND VPWR VPWR
+ \_0502_ sky130_fd_sc_hd__nand2_1
* cell instance sky130_fd_sc_hd__nand2_1_186 r0 *1 0,0
Xsky130_fd_sc_hd__nand2_1_186 apt_index[14] \_0375_ VGND VPWR VPWR \_0377_
+ sky130_fd_sc_hd__nand2_1
* cell instance sky130_fd_sc_hd__nand2_1_187 r0 *1 0,0
Xsky130_fd_sc_hd__nand2_1_187 \_0311_ net37 VGND VPWR VPWR \_1276_
+ sky130_fd_sc_hd__nand2_1
* cell instance sky130_fd_sc_hd__nand2_1_188 r0 *1 0,0
Xsky130_fd_sc_hd__nand2_1_188 net43 \_0311_ VGND VPWR VPWR \_1273_
+ sky130_fd_sc_hd__nand2_1
* cell instance sky130_fd_sc_hd__nand2_1_189 r0 *1 0,0
Xsky130_fd_sc_hd__nand2_1_189 rct_ref net40 VGND VPWR VPWR \_1272_
+ sky130_fd_sc_hd__nand2_1
* cell instance sky130_fd_sc_hd__nand2_1_190 r0 *1 0,0
Xsky130_fd_sc_hd__nand2_1_190 rct_count[0] \_0313_ VGND VPWR VPWR \_0400_
+ sky130_fd_sc_hd__nand2_1
* cell instance sky130_fd_sc_hd__nand2_1_191 r0 *1 0,0
Xsky130_fd_sc_hd__nand2_1_191 apt_matches[0] \_0328_ VGND VPWR VPWR \_0469_
+ sky130_fd_sc_hd__nand2_1
* cell instance sky130_fd_sc_hd__nand2_1_192 r0 *1 0,0
Xsky130_fd_sc_hd__nand2_1_192 apt_matches[2] net40 VGND VPWR VPWR \_0467_
+ sky130_fd_sc_hd__nand2_1
* cell instance sky130_fd_sc_hd__nand2_1_193 r0 *1 0,0
Xsky130_fd_sc_hd__nand2_1_193 rct_armed \_0308_ VGND VPWR VPWR \_0309_
+ sky130_fd_sc_hd__nand2_1
* cell instance sky130_fd_sc_hd__nand2_1_194 r0 *1 0,0
Xsky130_fd_sc_hd__nand2_1_194 apt_matches[6] net40 VGND VPWR VPWR \_0457_
+ sky130_fd_sc_hd__nand2_1
* cell instance sky130_fd_sc_hd__nand2_1_195 r0 *1 0,0
Xsky130_fd_sc_hd__nand2_1_195 \_0351_ \_0366_ VGND VPWR VPWR \_0367_
+ sky130_fd_sc_hd__nand2_1
* cell instance sky130_fd_sc_hd__nand2_1_196 r0 *1 0,0
Xsky130_fd_sc_hd__nand2_1_196 \_0314_ \_0316_ VGND VPWR VPWR \_0317_
+ sky130_fd_sc_hd__nand2_1
* cell instance sky130_fd_sc_hd__nand2_1_197 r0 *1 0,0
Xsky130_fd_sc_hd__nand2_1_197 apt_index[0] \_0311_ VGND VPWR VPWR \_0420_
+ sky130_fd_sc_hd__nand2_1
* cell instance sky130_fd_sc_hd__nand2_1_198 r0 *1 0,0
Xsky130_fd_sc_hd__nand2_1_198 \_0322_ \_0324_ VGND VPWR VPWR \_0325_
+ sky130_fd_sc_hd__nand2_1
* cell instance sky130_fd_sc_hd__nand2_1_199 r0 *1 0,0
Xsky130_fd_sc_hd__nand2_1_199 rct_count[3] net40 VGND VPWR VPWR \_0393_
+ sky130_fd_sc_hd__nand2_1
* cell instance sky130_fd_sc_hd__nand2_1_200 r0 *1 0,0
Xsky130_fd_sc_hd__nand2_1_200 rct_count[4] \_0323_ VGND VPWR VPWR \_0324_
+ sky130_fd_sc_hd__nand2_1
* cell instance sky130_fd_sc_hd__nand2_1_201 r0 *1 0,0
Xsky130_fd_sc_hd__nand2_1_201 apt_index[6] apt_index[0] VGND VPWR VPWR \_0370_
+ sky130_fd_sc_hd__nand2_1
* cell instance sky130_fd_sc_hd__nand2_1_202 r0 *1 0,0
Xsky130_fd_sc_hd__nand2_1_202 rct_count[14] rct_count[13] VGND VPWR VPWR
+ \_0318_ sky130_fd_sc_hd__nand2_1
* cell instance sky130_fd_sc_hd__nand2_1_203 r0 *1 0,0
Xsky130_fd_sc_hd__nand2_1_203 apt_index[1] apt_index[2] VGND VPWR VPWR \_0431_
+ sky130_fd_sc_hd__nand2_1
* cell instance sky130_fd_sc_hd__nand2b_1_0 r0 *1 0,0
Xsky130_fd_sc_hd__nand2b_1_0 bus_addr[2] bus_addr[3] VGND VPWR VPWR \_1316_
+ sky130_fd_sc_hd__nand2b_1
* cell instance sky130_fd_sc_hd__nand2b_1_1 r0 *1 0,0
Xsky130_fd_sc_hd__nand2b_1_1 bus_addr[1] bus_addr[0] VGND VPWR VPWR \_1336_
+ sky130_fd_sc_hd__nand2b_1
* cell instance sky130_fd_sc_hd__nand2b_1_2 r0 *1 0,0
Xsky130_fd_sc_hd__nand2b_1_2 bus_addr[0] bus_addr[1] VGND VPWR VPWR \_0756_
+ sky130_fd_sc_hd__nand2b_1
* cell instance sky130_fd_sc_hd__nand2b_1_3 r0 *1 0,0
Xsky130_fd_sc_hd__nand2b_1_3 bus_addr[3] bus_addr[2] VGND VPWR VPWR \_0730_
+ sky130_fd_sc_hd__nand2b_1
* cell instance sky130_fd_sc_hd__nand2b_1_4 r0 *1 0,0
Xsky130_fd_sc_hd__nand2b_1_4 raw_mem[1][7] \_0802_ VGND VPWR VPWR \_0925_
+ sky130_fd_sc_hd__nand2b_1
* cell instance sky130_fd_sc_hd__nand2b_1_5 r0 *1 0,0
Xsky130_fd_sc_hd__nand2b_1_5 raw_mem[1][1] \_0802_ VGND VPWR VPWR \_0956_
+ sky130_fd_sc_hd__nand2b_1
* cell instance sky130_fd_sc_hd__nand2b_1_6 r0 *1 0,0
Xsky130_fd_sc_hd__nand2b_1_6 raw_mem[1][3] \_0802_ VGND VPWR VPWR \_0946_
+ sky130_fd_sc_hd__nand2b_1
* cell instance sky130_fd_sc_hd__nand2b_1_7 r0 *1 0,0
Xsky130_fd_sc_hd__nand2b_1_7 \_1413_ net43 VGND VPWR VPWR \_1422_
+ sky130_fd_sc_hd__nand2b_1
* cell instance sky130_fd_sc_hd__nand2b_1_8 r0 *1 0,0
Xsky130_fd_sc_hd__nand2b_1_8 raw_count[3] \_1411_ VGND VPWR VPWR \_1412_
+ sky130_fd_sc_hd__nand2b_1
* cell instance sky130_fd_sc_hd__nand2b_1_9 r0 *1 0,0
Xsky130_fd_sc_hd__nand2b_1_9 \_1413_ \_1414_ VGND VPWR VPWR \_1415_
+ sky130_fd_sc_hd__nand2b_1
* cell instance sky130_fd_sc_hd__nand2b_1_10 r0 *1 0,0
Xsky130_fd_sc_hd__nand2b_1_10 raw_count[5] \_1417_ VGND VPWR VPWR \_0154_
+ sky130_fd_sc_hd__nand2b_1
* cell instance sky130_fd_sc_hd__nand2b_1_11 r0 *1 0,0
Xsky130_fd_sc_hd__nand2b_1_11 \_1415_ \_0098_ VGND VPWR VPWR \_0099_
+ sky130_fd_sc_hd__nand2b_1
* cell instance sky130_fd_sc_hd__nand3_1_0 r0 *1 0,0
Xsky130_fd_sc_hd__nand3_1_0 \_1358_ \_1370_ \_1371_ VGND VPWR VPWR \_1372_
+ sky130_fd_sc_hd__nand3_1
* cell instance sky130_fd_sc_hd__nand3_1_1 r0 *1 0,0
Xsky130_fd_sc_hd__nand3_1_1 \_1317_ \_1357_ \_1358_ VGND VPWR VPWR \_1359_
+ sky130_fd_sc_hd__nand3_1
* cell instance sky130_fd_sc_hd__nand3_1_2 r0 *1 0,0
Xsky130_fd_sc_hd__nand3_1_2 bus_we bus_wdata[2] \_0290_ VGND VPWR VPWR \_0295_
+ sky130_fd_sc_hd__nand3_1
* cell instance sky130_fd_sc_hd__nand3_1_3 r0 *1 0,0
Xsky130_fd_sc_hd__nand3_1_3 net42 \_0783_ \_0787_ VGND VPWR VPWR \_1077_
+ sky130_fd_sc_hd__nand3_1
* cell instance sky130_fd_sc_hd__nand3_1_4 r0 *1 0,0
Xsky130_fd_sc_hd__nand3_1_4 out_ready \_0292_ \_0763_ VGND VPWR VPWR \_0764_
+ sky130_fd_sc_hd__nand3_1
* cell instance sky130_fd_sc_hd__nand3_1_5 r0 *1 0,0
Xsky130_fd_sc_hd__nand3_1_5 net23 \_0955_ \_0956_ VGND VPWR VPWR \_0957_
+ sky130_fd_sc_hd__nand3_1
* cell instance sky130_fd_sc_hd__nand3_1_6 r0 *1 0,0
Xsky130_fd_sc_hd__nand3_1_6 net23 \_0924_ \_0925_ VGND VPWR VPWR \_0926_
+ sky130_fd_sc_hd__nand3_1
* cell instance sky130_fd_sc_hd__nand3_1_7 r0 *1 0,0
Xsky130_fd_sc_hd__nand3_1_7 net23 \_0945_ \_0946_ VGND VPWR VPWR \_0947_
+ sky130_fd_sc_hd__nand3_1
* cell instance sky130_fd_sc_hd__nand3_1_8 r0 *1 0,0
Xsky130_fd_sc_hd__nand3_1_8 raw_level[0] raw_level[1] \_1401_ VGND VPWR VPWR
+ \_1402_ sky130_fd_sc_hd__nand3_1
* cell instance sky130_fd_sc_hd__nand3_1_9 r0 *1 0,0
Xsky130_fd_sc_hd__nand3_1_9 raw_count[3] \_0092_ \_1411_ VGND VPWR VPWR \_0093_
+ sky130_fd_sc_hd__nand3_1
* cell instance sky130_fd_sc_hd__nand3_1_10 r0 *1 0,0
Xsky130_fd_sc_hd__nand3_1_10 raw_count[3] \_1418_ \_0086_ VGND VPWR VPWR
+ \_0087_ sky130_fd_sc_hd__nand3_1
* cell instance sky130_fd_sc_hd__nand3_1_11 r0 *1 0,0
Xsky130_fd_sc_hd__nand3_1_11 raw_count[3] \_0086_ \_0141_ VGND VPWR VPWR
+ \_0165_ sky130_fd_sc_hd__nand3_1
* cell instance sky130_fd_sc_hd__nand3_1_12 r0 *1 0,0
Xsky130_fd_sc_hd__nand3_1_12 raw_count[3] \_1411_ \_0141_ VGND VPWR VPWR
+ \_0168_ sky130_fd_sc_hd__nand3_1
* cell instance sky130_fd_sc_hd__nand3_1_13 r0 *1 0,0
Xsky130_fd_sc_hd__nand3_1_13 raw_count[3] \_0080_ \_0141_ VGND VPWR VPWR
+ \_0162_ sky130_fd_sc_hd__nand3_1
* cell instance sky130_fd_sc_hd__nand3_1_14 r0 *1 0,0
Xsky130_fd_sc_hd__nand3_1_14 raw_count[3] \_1418_ \_0080_ VGND VPWR VPWR
+ \_0081_ sky130_fd_sc_hd__nand3_1
* cell instance sky130_fd_sc_hd__nand3_1_15 r0 *1 0,0
Xsky130_fd_sc_hd__nand3_1_15 raw_count[3] \_0060_ \_0141_ VGND VPWR VPWR
+ \_0150_ sky130_fd_sc_hd__nand3_1
* cell instance sky130_fd_sc_hd__nand3_1_16 r0 *1 0,0
Xsky130_fd_sc_hd__nand3_1_16 raw_count[3] \_1418_ \_0060_ VGND VPWR VPWR
+ \_0061_ sky130_fd_sc_hd__nand3_1
* cell instance sky130_fd_sc_hd__nand3_1_17 r0 *1 0,0
Xsky130_fd_sc_hd__nand3_1_17 \_0108_ \_1424_ \_0080_ VGND VPWR VPWR \_0129_
+ sky130_fd_sc_hd__nand3_1
* cell instance sky130_fd_sc_hd__nand3_1_18 r0 *1 0,0
Xsky130_fd_sc_hd__nand3_1_18 \_0220_ net35 \_1070_ VGND VPWR VPWR \_1071_
+ sky130_fd_sc_hd__nand3_1
* cell instance sky130_fd_sc_hd__nand3_1_19 r0 *1 0,0
Xsky130_fd_sc_hd__nand3_1_19 \_0108_ \_1424_ \_0060_ VGND VPWR VPWR \_0115_
+ sky130_fd_sc_hd__nand3_1
* cell instance sky130_fd_sc_hd__nand3_1_20 r0 *1 0,0
Xsky130_fd_sc_hd__nand3_1_20 raw_count[2] raw_count[3] \_0067_ VGND VPWR VPWR
+ \_0068_ sky130_fd_sc_hd__nand3_1
* cell instance sky130_fd_sc_hd__nand3_1_21 r0 *1 0,0
Xsky130_fd_sc_hd__nand3_1_21 \_0108_ \_1424_ \_0075_ VGND VPWR VPWR \_0124_
+ sky130_fd_sc_hd__nand3_1
* cell instance sky130_fd_sc_hd__nand3_1_22 r0 *1 0,0
Xsky130_fd_sc_hd__nand3_1_22 raw_count[3] \_0075_ \_0141_ VGND VPWR VPWR
+ \_0159_ sky130_fd_sc_hd__nand3_1
* cell instance sky130_fd_sc_hd__nand3_1_23 r0 *1 0,0
Xsky130_fd_sc_hd__nand3_1_23 raw_count[3] \_1418_ \_0075_ VGND VPWR VPWR
+ \_0076_ sky130_fd_sc_hd__nand3_1
* cell instance sky130_fd_sc_hd__nand3_1_24 r0 *1 0,0
Xsky130_fd_sc_hd__nand3_1_24 raw_count[1] raw_count[0] raw_count[2] VGND VPWR
+ VPWR \_0097_ sky130_fd_sc_hd__nand3_1
* cell instance sky130_fd_sc_hd__nand3_1_25 r0 *1 0,0
Xsky130_fd_sc_hd__nand3_1_25 \_0108_ \_1424_ \_0086_ VGND VPWR VPWR \_0134_
+ sky130_fd_sc_hd__nand3_1
* cell instance sky130_fd_sc_hd__nand3_1_26 r0 *1 0,0
Xsky130_fd_sc_hd__nand3_1_26 raw_count[3] \_1410_ \_0141_ VGND VPWR VPWR
+ \_0147_ sky130_fd_sc_hd__nand3_1
* cell instance sky130_fd_sc_hd__nand3_1_27 r0 *1 0,0
Xsky130_fd_sc_hd__nand3_1_27 \_1410_ \_0108_ \_1424_ VGND VPWR VPWR \_0110_
+ sky130_fd_sc_hd__nand3_1
* cell instance sky130_fd_sc_hd__nand3_1_28 r0 *1 0,0
Xsky130_fd_sc_hd__nand3_1_28 raw_count[3] \_1410_ \_1418_ VGND VPWR VPWR
+ \_1419_ sky130_fd_sc_hd__nand3_1
* cell instance sky130_fd_sc_hd__nand3_1_29 r0 *1 0,0
Xsky130_fd_sc_hd__nand3_1_29 cond_count[12] cond_count[13] \_0207_ VGND VPWR
+ VPWR \_0212_ sky130_fd_sc_hd__nand3_1
* cell instance sky130_fd_sc_hd__nand3_1_30 r0 *1 0,0
Xsky130_fd_sc_hd__nand3_1_30 cond_count[5] cond_count[4] cond_count[3] VGND
+ VPWR VPWR \_0204_ sky130_fd_sc_hd__nand3_1
* cell instance sky130_fd_sc_hd__nand3_1_31 r0 *1 0,0
Xsky130_fd_sc_hd__nand3_1_31 cond_count[5] cond_count[4] \_0641_ VGND VPWR VPWR
+ \_0642_ sky130_fd_sc_hd__nand3_1
* cell instance sky130_fd_sc_hd__nand3_1_32 r0 *1 0,0
Xsky130_fd_sc_hd__nand3_1_32 startup_count[8] startup_count[7] \_0511_ VGND
+ VPWR VPWR \_0512_ sky130_fd_sc_hd__nand3_1
* cell instance sky130_fd_sc_hd__nand3_1_33 r0 *1 0,0
Xsky130_fd_sc_hd__nand3_1_33 \_0486_ \_0493_ \_0501_ VGND VPWR VPWR \_0740_
+ sky130_fd_sc_hd__nand3_1
* cell instance sky130_fd_sc_hd__nand3_1_34 r0 *1 0,0
Xsky130_fd_sc_hd__nand3_1_34 apt_matches[9] apt_matches[10] \_0332_ VGND VPWR
+ VPWR \_0360_ sky130_fd_sc_hd__nand3_1
* cell instance sky130_fd_sc_hd__nand3_1_35 r0 *1 0,0
Xsky130_fd_sc_hd__nand3_1_35 \_0311_ \_0326_ \_0379_ VGND VPWR VPWR \_0416_
+ sky130_fd_sc_hd__nand3_1
* cell instance sky130_fd_sc_hd__nand3_1_36 r0 *1 0,0
Xsky130_fd_sc_hd__nand3_1_36 apt_index[11] apt_index[10] \_0410_ VGND VPWR VPWR
+ \_0411_ sky130_fd_sc_hd__nand3_1
* cell instance sky130_fd_sc_hd__nand3_1_37 r0 *1 0,0
Xsky130_fd_sc_hd__nand3_1_37 apt_index[1] apt_index[3] apt_index[2] VGND VPWR
+ VPWR \_0364_ sky130_fd_sc_hd__nand3_1
* cell instance sky130_fd_sc_hd__nand3_1_38 r0 *1 0,0
Xsky130_fd_sc_hd__nand3_1_38 apt_index[8] apt_index[6] apt_index[5] VGND VPWR
+ VPWR \_0365_ sky130_fd_sc_hd__nand3_1
* cell instance sky130_fd_sc_hd__nand3b_1_0 r0 *1 0,0
Xsky130_fd_sc_hd__nand3b_1_0 \_0766_ \_0749_ \_0764_ VGND VPWR VPWR \_1295_
+ sky130_fd_sc_hd__nand3b_1
* cell instance sky130_fd_sc_hd__nand3b_1_1 r0 *1 0,0
Xsky130_fd_sc_hd__nand3b_1_1 raw_count[3] \_1418_ \_0075_ VGND VPWR VPWR
+ \_0123_ sky130_fd_sc_hd__nand3b_1
* cell instance sky130_fd_sc_hd__nand3b_1_2 r0 *1 0,0
Xsky130_fd_sc_hd__nand3b_1_2 raw_count[1] raw_count[0] raw_count[2] VGND VPWR
+ VPWR \_0062_ sky130_fd_sc_hd__nand3b_1
* cell instance sky130_fd_sc_hd__nand3b_1_3 r0 *1 0,0
Xsky130_fd_sc_hd__nand3b_1_3 raw_count[0] raw_count[2] raw_count[1] VGND VPWR
+ VPWR \_1420_ sky130_fd_sc_hd__nand3b_1
* cell instance sky130_fd_sc_hd__nand4_1_0 r0 *1 0,0
Xsky130_fd_sc_hd__nand4_1_0 raw_count[1] raw_count[0] raw_count[2] raw_count[3]
+ VGND VPWR VPWR \_1398_ sky130_fd_sc_hd__nand4_1
* cell instance sky130_fd_sc_hd__nand4_1_1 r0 *1 0,0
Xsky130_fd_sc_hd__nand4_1_1 cond_level[1] cond_level[0] \_0220_ net35 VGND VPWR
+ VPWR \_0222_ sky130_fd_sc_hd__nand4_1
* cell instance sky130_fd_sc_hd__nand4_1_2 r0 *1 0,0
Xsky130_fd_sc_hd__nand4_1_2 cond_level[0] \_0200_ \_0209_ \_0219_ VGND VPWR
+ VPWR \_0770_ sky130_fd_sc_hd__nand4_1
* cell instance sky130_fd_sc_hd__nand4_1_3 r0 *1 0,0
Xsky130_fd_sc_hd__nand4_1_3 cond_count[2] cond_count[1] cond_count[0]
+ cond_count[6] VGND VPWR VPWR \_0205_ sky130_fd_sc_hd__nand4_1
* cell instance sky130_fd_sc_hd__nand4_1_4 r0 *1 0,0
Xsky130_fd_sc_hd__nand4_1_4 \_0216_ \_0530_ \_0209_ \_0531_ VGND VPWR VPWR
+ \_0532_ sky130_fd_sc_hd__nand4_1
* cell instance sky130_fd_sc_hd__nand4_1_5 r0 *1 0,0
Xsky130_fd_sc_hd__nand4_1_5 cond_count[12] cond_count[13] cond_count[14]
+ \_0207_ VGND VPWR VPWR \_0210_ sky130_fd_sc_hd__nand4_1
* cell instance sky130_fd_sc_hd__nand4_1_6 r0 *1 0,0
Xsky130_fd_sc_hd__nand4_1_6 startup_count[5] startup_count[9] \_0479_ \_0482_
+ VGND VPWR VPWR \_0483_ sky130_fd_sc_hd__nand4_1
* cell instance sky130_fd_sc_hd__nand4_1_7 r0 *1 0,0
Xsky130_fd_sc_hd__nand4_1_7 apt_matches[12] apt_matches[13] apt_matches[14]
+ \_0334_ VGND VPWR VPWR \_0335_ sky130_fd_sc_hd__nand4_1
* cell instance sky130_fd_sc_hd__nand4_1_8 r0 *1 0,0
Xsky130_fd_sc_hd__nand4_1_8 startup_count[5] startup_count[7] \_0479_ \_0514_
+ VGND VPWR VPWR \_0515_ sky130_fd_sc_hd__nand4_1
* cell instance sky130_fd_sc_hd__nand4_1_9 r0 *1 0,0
Xsky130_fd_sc_hd__nand4_1_9 startup_count[11] startup_count[12]
+ startup_count[13] \_0484_ VGND VPWR VPWR \_0485_ sky130_fd_sc_hd__nand4_1
* cell instance sky130_fd_sc_hd__nand4_1_10 r0 *1 0,0
Xsky130_fd_sc_hd__nand4_1_10 apt_matches[9] apt_matches[10] apt_matches[11]
+ \_0332_ VGND VPWR VPWR \_0341_ sky130_fd_sc_hd__nand4_1
* cell instance sky130_fd_sc_hd__nand4_1_11 r0 *1 0,0
Xsky130_fd_sc_hd__nand4_1_11 apt_index[12] apt_index[11] apt_index[10] \_0372_
+ VGND VPWR VPWR \_0373_ sky130_fd_sc_hd__nand4_1
* cell instance sky130_fd_sc_hd__nand4_1_12 r0 *1 0,0
Xsky130_fd_sc_hd__nand4_1_12 \_0349_ \_0350_ \_0351_ \_0352_ VGND VPWR VPWR
+ \_0353_ sky130_fd_sc_hd__nand4_1
* cell instance sky130_fd_sc_hd__nand4_1_13 r0 *1 0,0
Xsky130_fd_sc_hd__nand4_1_13 rct_count[8] rct_count[7] rct_count[15] \_0306_
+ VGND VPWR VPWR \_0320_ sky130_fd_sc_hd__nand4_1
* cell instance sky130_fd_sc_hd__nand4_1_14 r0 *1 0,0
Xsky130_fd_sc_hd__nand4_1_14 rct_count[12] rct_count[11] rct_count[10]
+ rct_count[9] VGND VPWR VPWR \_0319_ sky130_fd_sc_hd__nand4_1
* cell instance sky130_fd_sc_hd__nand4_1_15 r0 *1 0,0
Xsky130_fd_sc_hd__nand4_1_15 apt_index[7] apt_index[9] apt_index[0]
+ apt_index[4] VGND VPWR VPWR \_0363_ sky130_fd_sc_hd__nand4_1
* cell instance sky130_fd_sc_hd__nand4_1_16 r0 *1 0,0
Xsky130_fd_sc_hd__nand4_1_16 apt_index[8] apt_index[7] apt_index[9]
+ apt_index[5] VGND VPWR VPWR \_0371_ sky130_fd_sc_hd__nand4_1
* cell instance sky130_fd_sc_hd__nand4b_1_0 r0 *1 0,0
Xsky130_fd_sc_hd__nand4b_1_0 raw_level[0] raw_level[1] \_0092_ \_0720_ VGND
+ VPWR VPWR \_0963_ sky130_fd_sc_hd__nand4b_1
* cell instance sky130_fd_sc_hd__nand4b_1_1 r0 *1 0,0
Xsky130_fd_sc_hd__nand4b_1_1 cond_level[0] \_0220_ net35 cond_level[1] VGND
+ VPWR VPWR \_1178_ sky130_fd_sc_hd__nand4b_1
* cell instance sky130_fd_sc_hd__nand4b_1_2 r0 *1 0,0
Xsky130_fd_sc_hd__nand4b_1_2 \_0367_ \_0374_ \_0376_ \_0378_ VGND VPWR VPWR
+ \_0379_ sky130_fd_sc_hd__nand4b_1
* cell instance sky130_fd_sc_hd__nor2_1_0 r0 *1 0,0
Xsky130_fd_sc_hd__nor2_1_0 \_1234_ \_1237_ VGND VPWR VPWR out_data[30]
+ sky130_fd_sc_hd__nor2_1
* cell instance sky130_fd_sc_hd__nor2_1_1 r0 *1 0,0
Xsky130_fd_sc_hd__nor2_1_1 \_1234_ \_1239_ VGND VPWR VPWR out_data[28]
+ sky130_fd_sc_hd__nor2_1
* cell instance sky130_fd_sc_hd__nor2_1_2 r0 *1 0,0
Xsky130_fd_sc_hd__nor2_1_2 \_1234_ \_1262_ VGND VPWR VPWR out_data[9]
+ sky130_fd_sc_hd__nor2_1
* cell instance sky130_fd_sc_hd__nor2_1_3 r0 *1 0,0
Xsky130_fd_sc_hd__nor2_1_3 \_1234_ \_1245_ VGND VPWR VPWR out_data[23]
+ sky130_fd_sc_hd__nor2_1
* cell instance sky130_fd_sc_hd__nor2_1_4 r0 *1 0,0
Xsky130_fd_sc_hd__nor2_1_4 \_1234_ \_1260_ VGND VPWR VPWR out_data[11]
+ sky130_fd_sc_hd__nor2_1
* cell instance sky130_fd_sc_hd__nor2_1_5 r0 *1 0,0
Xsky130_fd_sc_hd__nor2_1_5 \_1234_ \_1255_ VGND VPWR VPWR out_data[14]
+ sky130_fd_sc_hd__nor2_1
* cell instance sky130_fd_sc_hd__nor2_1_6 r0 *1 0,0
Xsky130_fd_sc_hd__nor2_1_6 \_1234_ \_1249_ VGND VPWR VPWR out_data[20]
+ sky130_fd_sc_hd__nor2_1
* cell instance sky130_fd_sc_hd__nor2_1_7 r0 *1 0,0
Xsky130_fd_sc_hd__nor2_1_7 \_1234_ \_1247_ VGND VPWR VPWR out_data[22]
+ sky130_fd_sc_hd__nor2_1
* cell instance sky130_fd_sc_hd__nor2_1_8 r0 *1 0,0
Xsky130_fd_sc_hd__nor2_1_8 \_1234_ \_1242_ VGND VPWR VPWR out_data[25]
+ sky130_fd_sc_hd__nor2_1
* cell instance sky130_fd_sc_hd__nor2_1_9 r0 *1 0,0
Xsky130_fd_sc_hd__nor2_1_9 \_1234_ \_1250_ VGND VPWR VPWR out_data[19]
+ sky130_fd_sc_hd__nor2_1
* cell instance sky130_fd_sc_hd__nor2_1_10 r0 *1 0,0
Xsky130_fd_sc_hd__nor2_1_10 \_1234_ \_1257_ VGND VPWR VPWR out_data[13]
+ sky130_fd_sc_hd__nor2_1
* cell instance sky130_fd_sc_hd__nor2_1_11 r0 *1 0,0
Xsky130_fd_sc_hd__nor2_1_11 \_1234_ \_1264_ VGND VPWR VPWR out_data[7]
+ sky130_fd_sc_hd__nor2_1
* cell instance sky130_fd_sc_hd__nor2_1_12 r0 *1 0,0
Xsky130_fd_sc_hd__nor2_1_12 \_1234_ \_1270_ VGND VPWR VPWR out_data[1]
+ sky130_fd_sc_hd__nor2_1
* cell instance sky130_fd_sc_hd__nor2_1_13 r0 *1 0,0
Xsky130_fd_sc_hd__nor2_1_13 \_1234_ \_1271_ VGND VPWR VPWR out_data[0]
+ sky130_fd_sc_hd__nor2_1
* cell instance sky130_fd_sc_hd__nor2_1_14 r0 *1 0,0
Xsky130_fd_sc_hd__nor2_1_14 \_1234_ \_1265_ VGND VPWR VPWR out_data[6]
+ sky130_fd_sc_hd__nor2_1
* cell instance sky130_fd_sc_hd__nor2_1_15 r0 *1 0,0
Xsky130_fd_sc_hd__nor2_1_15 \_1234_ \_1253_ VGND VPWR VPWR out_data[16]
+ sky130_fd_sc_hd__nor2_1
* cell instance sky130_fd_sc_hd__nor2_1_16 r0 *1 0,0
Xsky130_fd_sc_hd__nor2_1_16 \_1234_ \_1240_ VGND VPWR VPWR out_data[27]
+ sky130_fd_sc_hd__nor2_1
* cell instance sky130_fd_sc_hd__nor2_1_17 r0 *1 0,0
Xsky130_fd_sc_hd__nor2_1_17 \_1234_ \_1258_ VGND VPWR VPWR out_data[12]
+ sky130_fd_sc_hd__nor2_1
* cell instance sky130_fd_sc_hd__nor2_1_18 r0 *1 0,0
Xsky130_fd_sc_hd__nor2_1_18 \_1234_ \_1243_ VGND VPWR VPWR out_data[24]
+ sky130_fd_sc_hd__nor2_1
* cell instance sky130_fd_sc_hd__nor2_1_19 r0 *1 0,0
Xsky130_fd_sc_hd__nor2_1_19 \_1234_ \_1254_ VGND VPWR VPWR out_data[15]
+ sky130_fd_sc_hd__nor2_1
* cell instance sky130_fd_sc_hd__nor2_1_20 r0 *1 0,0
Xsky130_fd_sc_hd__nor2_1_20 \_1234_ \_1261_ VGND VPWR VPWR out_data[10]
+ sky130_fd_sc_hd__nor2_1
* cell instance sky130_fd_sc_hd__nor2_1_21 r0 *1 0,0
Xsky130_fd_sc_hd__nor2_1_21 \_1234_ \_1238_ VGND VPWR VPWR out_data[29]
+ sky130_fd_sc_hd__nor2_1
* cell instance sky130_fd_sc_hd__nor2_1_22 r0 *1 0,0
Xsky130_fd_sc_hd__nor2_1_22 \_1234_ \_1269_ VGND VPWR VPWR out_data[2]
+ sky130_fd_sc_hd__nor2_1
* cell instance sky130_fd_sc_hd__nor2_1_23 r0 *1 0,0
Xsky130_fd_sc_hd__nor2_1_23 \_1234_ \_1268_ VGND VPWR VPWR out_data[3]
+ sky130_fd_sc_hd__nor2_1
* cell instance sky130_fd_sc_hd__nor2_1_24 r0 *1 0,0
Xsky130_fd_sc_hd__nor2_1_24 \_1234_ \_1251_ VGND VPWR VPWR out_data[18]
+ sky130_fd_sc_hd__nor2_1
* cell instance sky130_fd_sc_hd__nor2_1_25 r0 *1 0,0
Xsky130_fd_sc_hd__nor2_1_25 \_1234_ \_1252_ VGND VPWR VPWR out_data[17]
+ sky130_fd_sc_hd__nor2_1
* cell instance sky130_fd_sc_hd__nor2_1_26 r0 *1 0,0
Xsky130_fd_sc_hd__nor2_1_26 \_1234_ \_1248_ VGND VPWR VPWR out_data[21]
+ sky130_fd_sc_hd__nor2_1
* cell instance sky130_fd_sc_hd__nor2_1_27 r0 *1 0,0
Xsky130_fd_sc_hd__nor2_1_27 \_1234_ \_1306_ VGND VPWR VPWR out_data[31]
+ sky130_fd_sc_hd__nor2_1
* cell instance sky130_fd_sc_hd__nor2_1_28 r0 *1 0,0
Xsky130_fd_sc_hd__nor2_1_28 \_1234_ \_1263_ VGND VPWR VPWR out_data[8]
+ sky130_fd_sc_hd__nor2_1
* cell instance sky130_fd_sc_hd__nor2_1_29 r0 *1 0,0
Xsky130_fd_sc_hd__nor2_1_29 \_1234_ \_1267_ VGND VPWR VPWR out_data[4]
+ sky130_fd_sc_hd__nor2_1
* cell instance sky130_fd_sc_hd__nor2_1_30 r0 *1 0,0
Xsky130_fd_sc_hd__nor2_1_30 \_0169_ \_0802_ VGND VPWR VPWR \_0917_
+ sky130_fd_sc_hd__nor2_1
* cell instance sky130_fd_sc_hd__nor2_1_31 r0 *1 0,0
Xsky130_fd_sc_hd__nor2_1_31 \_0090_ \_0797_ VGND VPWR VPWR \_0838_
+ sky130_fd_sc_hd__nor2_1
* cell instance sky130_fd_sc_hd__nor2_1_32 r0 *1 0,0
Xsky130_fd_sc_hd__nor2_1_32 \_0169_ \_0797_ VGND VPWR VPWR \_0915_
+ sky130_fd_sc_hd__nor2_1
* cell instance sky130_fd_sc_hd__nor2_1_33 r0 *1 0,0
Xsky130_fd_sc_hd__nor2_1_33 \_0090_ \_0802_ VGND VPWR VPWR \_0840_
+ sky130_fd_sc_hd__nor2_1
* cell instance sky130_fd_sc_hd__nor2_1_34 r0 *1 0,0
Xsky130_fd_sc_hd__nor2_1_34 \_0090_ net33 VGND VPWR VPWR \_0979_
+ sky130_fd_sc_hd__nor2_1
* cell instance sky130_fd_sc_hd__nor2_1_35 r0 *1 0,0
Xsky130_fd_sc_hd__nor2_1_35 \_0126_ \_0797_ VGND VPWR VPWR \_0865_
+ sky130_fd_sc_hd__nor2_1
* cell instance sky130_fd_sc_hd__nor2_1_36 r0 *1 0,0
Xsky130_fd_sc_hd__nor2_1_36 \_0126_ \_0802_ VGND VPWR VPWR \_0867_
+ sky130_fd_sc_hd__nor2_1
* cell instance sky130_fd_sc_hd__nor2_1_37 r0 *1 0,0
Xsky130_fd_sc_hd__nor2_1_37 \_0064_ \_0797_ VGND VPWR VPWR \_0817_
+ sky130_fd_sc_hd__nor2_1
* cell instance sky130_fd_sc_hd__nor2_1_38 r0 *1 0,0
Xsky130_fd_sc_hd__nor2_1_38 \_0126_ net33 VGND VPWR VPWR \_0991_
+ sky130_fd_sc_hd__nor2_1
* cell instance sky130_fd_sc_hd__nor2_1_39 r0 *1 0,0
Xsky130_fd_sc_hd__nor2_1_39 \_0095_ \_0797_ VGND VPWR VPWR \_0843_
+ sky130_fd_sc_hd__nor2_1
* cell instance sky130_fd_sc_hd__nor2_1_40 r0 *1 0,0
Xsky130_fd_sc_hd__nor2_1_40 \_0064_ \_0802_ VGND VPWR VPWR \_0820_
+ sky130_fd_sc_hd__nor2_1
* cell instance sky130_fd_sc_hd__nor2_1_41 r0 *1 0,0
Xsky130_fd_sc_hd__nor2_1_41 \_0095_ \_0802_ VGND VPWR VPWR \_0846_
+ sky130_fd_sc_hd__nor2_1
* cell instance sky130_fd_sc_hd__nor2_1_42 r0 *1 0,0
Xsky130_fd_sc_hd__nor2_1_42 \_0064_ net33 VGND VPWR VPWR \_0969_
+ sky130_fd_sc_hd__nor2_1
* cell instance sky130_fd_sc_hd__nor2_1_43 r0 *1 0,0
Xsky130_fd_sc_hd__nor2_1_43 \_0797_ \_1292_ VGND VPWR VPWR \_1296_
+ sky130_fd_sc_hd__nor2_1
* cell instance sky130_fd_sc_hd__nor2_1_44 r0 *1 0,0
Xsky130_fd_sc_hd__nor2_1_44 \_0095_ net33 VGND VPWR VPWR \_0981_
+ sky130_fd_sc_hd__nor2_1
* cell instance sky130_fd_sc_hd__nor2_1_45 r0 *1 0,0
Xsky130_fd_sc_hd__nor2_1_45 \_0157_ \_0802_ VGND VPWR VPWR \_0896_
+ sky130_fd_sc_hd__nor2_1
* cell instance sky130_fd_sc_hd__nor2_1_46 r0 *1 0,0
Xsky130_fd_sc_hd__nor2_1_46 \_0802_ \_1292_ VGND VPWR VPWR \_1298_
+ sky130_fd_sc_hd__nor2_1
* cell instance sky130_fd_sc_hd__nor2_1_47 r0 *1 0,0
Xsky130_fd_sc_hd__nor2_1_47 \_1234_ \_1241_ VGND VPWR VPWR out_data[26]
+ sky130_fd_sc_hd__nor2_1
* cell instance sky130_fd_sc_hd__nor2_1_48 r0 *1 0,0
Xsky130_fd_sc_hd__nor2_1_48 net23 \_0899_ VGND VPWR VPWR \_0900_
+ sky130_fd_sc_hd__nor2_1
* cell instance sky130_fd_sc_hd__nor2_1_49 r0 *1 0,0
Xsky130_fd_sc_hd__nor2_1_49 \_0266_ net28 VGND VPWR VPWR \_1146_
+ sky130_fd_sc_hd__nor2_1
* cell instance sky130_fd_sc_hd__nor2_1_50 r0 *1 0,0
Xsky130_fd_sc_hd__nor2_1_50 \_0266_ net26 VGND VPWR VPWR \_1215_
+ sky130_fd_sc_hd__nor2_1
* cell instance sky130_fd_sc_hd__nor2_1_51 r0 *1 0,0
Xsky130_fd_sc_hd__nor2_1_51 \_0256_ net28 VGND VPWR VPWR \_1130_
+ sky130_fd_sc_hd__nor2_1
* cell instance sky130_fd_sc_hd__nor2_1_52 r0 *1 0,0
Xsky130_fd_sc_hd__nor2_1_52 \_0256_ net26 VGND VPWR VPWR \_1207_
+ sky130_fd_sc_hd__nor2_1
* cell instance sky130_fd_sc_hd__nor2_1_53 r0 *1 0,0
Xsky130_fd_sc_hd__nor2_1_53 \_1234_ \_1266_ VGND VPWR VPWR out_data[5]
+ sky130_fd_sc_hd__nor2_1
* cell instance sky130_fd_sc_hd__nor2_1_54 r0 *1 0,0
Xsky130_fd_sc_hd__nor2_1_54 \_0233_ net28 VGND VPWR VPWR \_1091_
+ sky130_fd_sc_hd__nor2_1
* cell instance sky130_fd_sc_hd__nor2_1_55 r0 *1 0,0
Xsky130_fd_sc_hd__nor2_1_55 \_0233_ net26 VGND VPWR VPWR \_1187_
+ sky130_fd_sc_hd__nor2_1
* cell instance sky130_fd_sc_hd__nor2_1_56 r0 *1 0,0
Xsky130_fd_sc_hd__nor2_1_56 net23 \_0935_ VGND VPWR VPWR \_0936_
+ sky130_fd_sc_hd__nor2_1
* cell instance sky130_fd_sc_hd__nor2_1_57 r0 *1 0,0
Xsky130_fd_sc_hd__nor2_1_57 \_0181_ \_0802_ VGND VPWR VPWR \_0932_
+ sky130_fd_sc_hd__nor2_1
* cell instance sky130_fd_sc_hd__nor2_1_58 r0 *1 0,0
Xsky130_fd_sc_hd__nor2_1_58 \_0084_ \_0797_ VGND VPWR VPWR \_0833_
+ sky130_fd_sc_hd__nor2_1
* cell instance sky130_fd_sc_hd__nor2_1_59 r0 *1 0,0
Xsky130_fd_sc_hd__nor2_1_59 \_0177_ \_0802_ VGND VPWR VPWR \_0927_
+ sky130_fd_sc_hd__nor2_1
* cell instance sky130_fd_sc_hd__nor2_1_60 r0 *1 0,0
Xsky130_fd_sc_hd__nor2_1_60 \_0084_ \_0802_ VGND VPWR VPWR \_0836_
+ sky130_fd_sc_hd__nor2_1
* cell instance sky130_fd_sc_hd__nor2_1_61 r0 *1 0,0
Xsky130_fd_sc_hd__nor2_1_61 net23 \_0930_ VGND VPWR VPWR \_0931_
+ sky130_fd_sc_hd__nor2_1
* cell instance sky130_fd_sc_hd__nor2_1_62 r0 *1 0,0
Xsky130_fd_sc_hd__nor2_1_62 \_0084_ net33 VGND VPWR VPWR \_0977_
+ sky130_fd_sc_hd__nor2_1
* cell instance sky130_fd_sc_hd__nor2_1_63 r0 *1 0,0
Xsky130_fd_sc_hd__nor2_1_63 net23 \_0894_ VGND VPWR VPWR \_0895_
+ sky130_fd_sc_hd__nor2_1
* cell instance sky130_fd_sc_hd__nor2_1_64 r0 *1 0,0
Xsky130_fd_sc_hd__nor2_1_64 \_0273_ net28 VGND VPWR VPWR \_1156_
+ sky130_fd_sc_hd__nor2_1
* cell instance sky130_fd_sc_hd__nor2_1_65 r0 *1 0,0
Xsky130_fd_sc_hd__nor2_1_65 net23 \_0940_ VGND VPWR VPWR \_0941_
+ sky130_fd_sc_hd__nor2_1
* cell instance sky130_fd_sc_hd__nor2_1_66 r0 *1 0,0
Xsky130_fd_sc_hd__nor2_1_66 \_0276_ net28 VGND VPWR VPWR \_1160_
+ sky130_fd_sc_hd__nor2_1
* cell instance sky130_fd_sc_hd__nor2_1_67 r0 *1 0,0
Xsky130_fd_sc_hd__nor2_1_67 \_0273_ net26 VGND VPWR VPWR \_1220_
+ sky130_fd_sc_hd__nor2_1
* cell instance sky130_fd_sc_hd__nor2_1_68 r0 *1 0,0
Xsky130_fd_sc_hd__nor2_1_68 \_0151_ \_0802_ VGND VPWR VPWR \_0891_
+ sky130_fd_sc_hd__nor2_1
* cell instance sky130_fd_sc_hd__nor2_1_69 r0 *1 0,0
Xsky130_fd_sc_hd__nor2_1_69 \_0286_ net28 VGND VPWR VPWR \_1175_
+ sky130_fd_sc_hd__nor2_1
* cell instance sky130_fd_sc_hd__nor2_1_70 r0 *1 0,0
Xsky130_fd_sc_hd__nor2_1_70 \_0286_ net26 VGND VPWR VPWR \_1230_
+ sky130_fd_sc_hd__nor2_1
* cell instance sky130_fd_sc_hd__nor2_1_71 r0 *1 0,0
Xsky130_fd_sc_hd__nor2_1_71 \_0185_ \_0802_ VGND VPWR VPWR \_0937_
+ sky130_fd_sc_hd__nor2_1
* cell instance sky130_fd_sc_hd__nor2_1_72 r0 *1 0,0
Xsky130_fd_sc_hd__nor2_1_72 \_0197_ \_0802_ VGND VPWR VPWR \_0960_
+ sky130_fd_sc_hd__nor2_1
* cell instance sky130_fd_sc_hd__nor2_1_73 r0 *1 0,0
Xsky130_fd_sc_hd__nor2_1_73 bus_addr[2] \_0299_ VGND VPWR VPWR \_0300_
+ sky130_fd_sc_hd__nor2_1
* cell instance sky130_fd_sc_hd__nor2_1_74 r0 *1 0,0
Xsky130_fd_sc_hd__nor2_1_74 bus_wdata[0] \_0731_ VGND VPWR VPWR \_0732_
+ sky130_fd_sc_hd__nor2_1
* cell instance sky130_fd_sc_hd__nor2_1_75 r0 *1 0,0
Xsky130_fd_sc_hd__nor2_1_75 crc_state[30] net35 VGND VPWR VPWR \_0529_
+ sky130_fd_sc_hd__nor2_1
* cell instance sky130_fd_sc_hd__nor2_1_76 r0 *1 0,0
Xsky130_fd_sc_hd__nor2_1_76 bus_wdata[1] \_0731_ VGND VPWR VPWR \_0735_
+ sky130_fd_sc_hd__nor2_1
* cell instance sky130_fd_sc_hd__nor2_1_77 r0 *1 0,0
Xsky130_fd_sc_hd__nor2_1_77 crc_state[31] net35 VGND VPWR VPWR \_1285_
+ sky130_fd_sc_hd__nor2_1
* cell instance sky130_fd_sc_hd__nor2_1_78 r0 *1 0,0
Xsky130_fd_sc_hd__nor2_1_78 net23 \_0951_ VGND VPWR VPWR \_0952_
+ sky130_fd_sc_hd__nor2_1
* cell instance sky130_fd_sc_hd__nor2_1_79 r0 *1 0,0
Xsky130_fd_sc_hd__nor2_1_79 crc_state[24] net35 VGND VPWR VPWR \_0564_
+ sky130_fd_sc_hd__nor2_1
* cell instance sky130_fd_sc_hd__nor2_1_80 r0 *1 0,0
Xsky130_fd_sc_hd__nor2_1_80 crc_state[25] net35 VGND VPWR VPWR \_0562_
+ sky130_fd_sc_hd__nor2_1
* cell instance sky130_fd_sc_hd__nor2_1_81 r0 *1 0,0
Xsky130_fd_sc_hd__nor2_1_81 \_0139_ \_0802_ VGND VPWR VPWR \_0879_
+ sky130_fd_sc_hd__nor2_1
* cell instance sky130_fd_sc_hd__nor2_1_82 r0 *1 0,0
Xsky130_fd_sc_hd__nor2_1_82 \_0139_ \_0797_ VGND VPWR VPWR \_0877_
+ sky130_fd_sc_hd__nor2_1
* cell instance sky130_fd_sc_hd__nor2_1_83 r0 *1 0,0
Xsky130_fd_sc_hd__nor2_1_83 \_0139_ net33 VGND VPWR VPWR \_0997_
+ sky130_fd_sc_hd__nor2_1
* cell instance sky130_fd_sc_hd__nor2_1_84 r0 *1 0,0
Xsky130_fd_sc_hd__nor2_1_84 \_0192_ \_0802_ VGND VPWR VPWR \_0948_
+ sky130_fd_sc_hd__nor2_1
* cell instance sky130_fd_sc_hd__nor2_1_85 r0 *1 0,0
Xsky130_fd_sc_hd__nor2_1_85 \_0779_ \_1344_ VGND VPWR VPWR \_1351_
+ sky130_fd_sc_hd__nor2_1
* cell instance sky130_fd_sc_hd__nor2_1_86 r0 *1 0,0
Xsky130_fd_sc_hd__nor2_1_86 \_0250_ net28 VGND VPWR VPWR \_1120_
+ sky130_fd_sc_hd__nor2_1
* cell instance sky130_fd_sc_hd__nor2_1_87 r0 *1 0,0
Xsky130_fd_sc_hd__nor2_1_87 \_0758_ \_0760_ VGND VPWR VPWR \_0761_
+ sky130_fd_sc_hd__nor2_1
* cell instance sky130_fd_sc_hd__nor2_1_88 r0 *1 0,0
Xsky130_fd_sc_hd__nor2_1_88 \_0749_ \_0759_ VGND VPWR VPWR \_0760_
+ sky130_fd_sc_hd__nor2_1
* cell instance sky130_fd_sc_hd__nor2_1_89 r0 *1 0,0
Xsky130_fd_sc_hd__nor2_1_89 crc_state[28] net35 VGND VPWR VPWR \_0552_
+ sky130_fd_sc_hd__nor2_1
* cell instance sky130_fd_sc_hd__nor2_1_90 r0 *1 0,0
Xsky130_fd_sc_hd__nor2_1_90 \_0276_ net26 VGND VPWR VPWR \_1222_
+ sky130_fd_sc_hd__nor2_1
* cell instance sky130_fd_sc_hd__nor2_1_91 r0 *1 0,0
Xsky130_fd_sc_hd__nor2_1_91 net38 \_0747_ VGND VPWR VPWR \_0021_
+ sky130_fd_sc_hd__nor2_1
* cell instance sky130_fd_sc_hd__nor2_1_92 r0 *1 0,0
Xsky130_fd_sc_hd__nor2_1_92 \_0250_ net26 VGND VPWR VPWR \_1202_
+ sky130_fd_sc_hd__nor2_1
* cell instance sky130_fd_sc_hd__nor2_1_93 r0 *1 0,0
Xsky130_fd_sc_hd__nor2_1_93 \_0758_ \_0759_ VGND VPWR VPWR \_0766_
+ sky130_fd_sc_hd__nor2_1
* cell instance sky130_fd_sc_hd__nor2_1_94 r0 *1 0,0
Xsky130_fd_sc_hd__nor2_1_94 crc_state[6] net35 VGND VPWR VPWR \_0602_
+ sky130_fd_sc_hd__nor2_1
* cell instance sky130_fd_sc_hd__nor2_1_95 r0 *1 0,0
Xsky130_fd_sc_hd__nor2_1_95 crc_state[29] net35 VGND VPWR VPWR \_0547_
+ sky130_fd_sc_hd__nor2_1
* cell instance sky130_fd_sc_hd__nor2_1_96 r0 *1 0,0
Xsky130_fd_sc_hd__nor2_1_96 net23 \_0913_ VGND VPWR VPWR \_0914_
+ sky130_fd_sc_hd__nor2_1
* cell instance sky130_fd_sc_hd__nor2_1_97 r0 *1 0,0
Xsky130_fd_sc_hd__nor2_1_97 net42 net38 VGND VPWR VPWR \_1309_
+ sky130_fd_sc_hd__nor2_1
* cell instance sky130_fd_sc_hd__nor2_1_98 r0 *1 0,0
Xsky130_fd_sc_hd__nor2_1_98 net33 \_1292_ VGND VPWR VPWR \_1300_
+ sky130_fd_sc_hd__nor2_1
* cell instance sky130_fd_sc_hd__nor2_1_99 r0 *1 0,0
Xsky130_fd_sc_hd__nor2_1_99 \_0166_ \_0802_ VGND VPWR VPWR \_0910_
+ sky130_fd_sc_hd__nor2_1
* cell instance sky130_fd_sc_hd__nor2_1_100 r0 *1 0,0
Xsky130_fd_sc_hd__nor2_1_100 crc_state[27] net35 VGND VPWR VPWR \_0554_
+ sky130_fd_sc_hd__nor2_1
* cell instance sky130_fd_sc_hd__nor2_1_101 r0 *1 0,0
Xsky130_fd_sc_hd__nor2_1_101 \_0173_ net33 VGND VPWR VPWR \_1021_
+ sky130_fd_sc_hd__nor2_1
* cell instance sky130_fd_sc_hd__nor2_1_102 r0 *1 0,0
Xsky130_fd_sc_hd__nor2_1_102 \_0764_ \_0768_ VGND VPWR VPWR \_0769_
+ sky130_fd_sc_hd__nor2_1
* cell instance sky130_fd_sc_hd__nor2_1_103 r0 *1 0,0
Xsky130_fd_sc_hd__nor2_1_103 net34 \_0751_ VGND VPWR VPWR \_0752_
+ sky130_fd_sc_hd__nor2_1
* cell instance sky130_fd_sc_hd__nor2_1_104 r0 *1 0,0
Xsky130_fd_sc_hd__nor2_1_104 bus_wdata[2] \_0542_ VGND VPWR VPWR \_0543_
+ sky130_fd_sc_hd__nor2_1
* cell instance sky130_fd_sc_hd__nor2_1_105 r0 *1 0,0
Xsky130_fd_sc_hd__nor2_1_105 \_0195_ net33 VGND VPWR VPWR \_1040_
+ sky130_fd_sc_hd__nor2_1
* cell instance sky130_fd_sc_hd__nor2_1_106 r0 *1 0,0
Xsky130_fd_sc_hd__nor2_1_106 \_1313_ \_0954_ VGND VPWR VPWR \_1386_
+ sky130_fd_sc_hd__nor2_1
* cell instance sky130_fd_sc_hd__nor2_1_107 r0 *1 0,0
Xsky130_fd_sc_hd__nor2_1_107 crc_state[17] net35 VGND VPWR VPWR \_0580_
+ sky130_fd_sc_hd__nor2_1
* cell instance sky130_fd_sc_hd__nor2_1_108 r0 *1 0,0
Xsky130_fd_sc_hd__nor2_1_108 \_0292_ \_0793_ VGND VPWR VPWR \_0794_
+ sky130_fd_sc_hd__nor2_1
* cell instance sky130_fd_sc_hd__nor2_1_109 r0 *1 0,0
Xsky130_fd_sc_hd__nor2_1_109 \_0291_ \_0543_ VGND VPWR VPWR \_0544_
+ sky130_fd_sc_hd__nor2_1
* cell instance sky130_fd_sc_hd__nor2_1_110 r0 *1 0,0
Xsky130_fd_sc_hd__nor2_1_110 \_0195_ net31 VGND VPWR VPWR \_0953_
+ sky130_fd_sc_hd__nor2_1
* cell instance sky130_fd_sc_hd__nor2_1_111 r0 *1 0,0
Xsky130_fd_sc_hd__nor2_1_111 raw_level[1] \_0750_ VGND VPWR VPWR \_0923_
+ sky130_fd_sc_hd__nor2_1
* cell instance sky130_fd_sc_hd__nor2_1_112 r0 *1 0,0
Xsky130_fd_sc_hd__nor2_1_112 net34 \_0748_ VGND VPWR VPWR \_0749_
+ sky130_fd_sc_hd__nor2_1
* cell instance sky130_fd_sc_hd__nor2_1_113 r0 *1 0,0
Xsky130_fd_sc_hd__nor2_1_113 net34 \_0719_ VGND VPWR VPWR \_0022_[0]
+ sky130_fd_sc_hd__nor2_1
* cell instance sky130_fd_sc_hd__nor2_1_114 r0 *1 0,0
Xsky130_fd_sc_hd__nor2_1_114 net34 \_0686_ VGND VPWR VPWR \_0022_[16]
+ sky130_fd_sc_hd__nor2_1
* cell instance sky130_fd_sc_hd__nor2_1_115 r0 *1 0,0
Xsky130_fd_sc_hd__nor2_1_115 raw_level[0] raw_level[1] VGND VPWR VPWR \_0746_
+ sky130_fd_sc_hd__nor2_1
* cell instance sky130_fd_sc_hd__nor2_1_116 r0 *1 0,0
Xsky130_fd_sc_hd__nor2_1_116 \_0189_ net31 VGND VPWR VPWR \_0943_
+ sky130_fd_sc_hd__nor2_1
* cell instance sky130_fd_sc_hd__nor2_1_117 r0 *1 0,0
Xsky130_fd_sc_hd__nor2_1_117 \_0139_ \_0651_ VGND VPWR VPWR \_0685_
+ sky130_fd_sc_hd__nor2_1
* cell instance sky130_fd_sc_hd__nor2_1_118 r0 *1 0,0
Xsky130_fd_sc_hd__nor2_1_118 \_0173_ net31 VGND VPWR VPWR \_0920_
+ sky130_fd_sc_hd__nor2_1
* cell instance sky130_fd_sc_hd__nor2_1_119 r0 *1 0,0
Xsky130_fd_sc_hd__nor2_1_119 \_0197_ \_0651_ VGND VPWR VPWR \_0718_
+ sky130_fd_sc_hd__nor2_1
* cell instance sky130_fd_sc_hd__nor2_1_120 r0 *1 0,0
Xsky130_fd_sc_hd__nor2_1_120 crc_state[9] net35 VGND VPWR VPWR \_0596_
+ sky130_fd_sc_hd__nor2_1
* cell instance sky130_fd_sc_hd__nor2_1_121 r0 *1 0,0
Xsky130_fd_sc_hd__nor2_1_121 \_1401_ \_1290_ VGND VPWR VPWR \_0022_[31]
+ sky130_fd_sc_hd__nor2_1
* cell instance sky130_fd_sc_hd__nor2_1_122 r0 *1 0,0
Xsky130_fd_sc_hd__nor2_1_122 crc_state[18] net35 VGND VPWR VPWR \_0578_
+ sky130_fd_sc_hd__nor2_1
* cell instance sky130_fd_sc_hd__nor2_1_123 r0 *1 0,0
Xsky130_fd_sc_hd__nor2_1_123 \_0189_ net33 VGND VPWR VPWR \_1034_
+ sky130_fd_sc_hd__nor2_1
* cell instance sky130_fd_sc_hd__nor2_1_124 r0 *1 0,0
Xsky130_fd_sc_hd__nor2_1_124 net34 \_0668_ VGND VPWR VPWR \_0022_[24]
+ sky130_fd_sc_hd__nor2_1
* cell instance sky130_fd_sc_hd__nor2_1_125 r0 *1 0,0
Xsky130_fd_sc_hd__nor2_1_125 \_0269_ net28 VGND VPWR VPWR \_1150_
+ sky130_fd_sc_hd__nor2_1
* cell instance sky130_fd_sc_hd__nor2_1_126 r0 *1 0,0
Xsky130_fd_sc_hd__nor2_1_126 \_0095_ \_0651_ VGND VPWR VPWR \_0667_
+ sky130_fd_sc_hd__nor2_1
* cell instance sky130_fd_sc_hd__nor2_1_127 r0 *1 0,0
Xsky130_fd_sc_hd__nor2_1_127 net40 \_1400_ VGND VPWR VPWR \_1401_
+ sky130_fd_sc_hd__nor2_1
* cell instance sky130_fd_sc_hd__nor2_1_128 r0 *1 0,0
Xsky130_fd_sc_hd__nor2_1_128 \_0269_ net26 VGND VPWR VPWR \_1217_
+ sky130_fd_sc_hd__nor2_1
* cell instance sky130_fd_sc_hd__nor2_1_129 r0 *1 0,0
Xsky130_fd_sc_hd__nor2_1_129 net34 \_0666_ VGND VPWR VPWR \_0022_[25]
+ sky130_fd_sc_hd__nor2_1
* cell instance sky130_fd_sc_hd__nor2_1_130 r0 *1 0,0
Xsky130_fd_sc_hd__nor2_1_130 \_0259_ net28 VGND VPWR VPWR \_1134_
+ sky130_fd_sc_hd__nor2_1
* cell instance sky130_fd_sc_hd__nor2_1_131 r0 *1 0,0
Xsky130_fd_sc_hd__nor2_1_131 \_0090_ \_0651_ VGND VPWR VPWR \_0665_
+ sky130_fd_sc_hd__nor2_1
* cell instance sky130_fd_sc_hd__nor2_1_132 r0 *1 0,0
Xsky130_fd_sc_hd__nor2_1_132 net34 \_0700_ VGND VPWR VPWR \_0022_[9]
+ sky130_fd_sc_hd__nor2_1
* cell instance sky130_fd_sc_hd__nor2_1_133 r0 *1 0,0
Xsky130_fd_sc_hd__nor2_1_133 \_0259_ net26 VGND VPWR VPWR \_1210_
+ sky130_fd_sc_hd__nor2_1
* cell instance sky130_fd_sc_hd__nor2_1_134 r0 *1 0,0
Xsky130_fd_sc_hd__nor2_1_134 \_0166_ \_0651_ VGND VPWR VPWR \_0699_
+ sky130_fd_sc_hd__nor2_1
* cell instance sky130_fd_sc_hd__nor2_1_135 r0 *1 0,0
Xsky130_fd_sc_hd__nor2_1_135 net34 \_0702_ VGND VPWR VPWR \_0022_[8]
+ sky130_fd_sc_hd__nor2_1
* cell instance sky130_fd_sc_hd__nor2_1_136 r0 *1 0,0
Xsky130_fd_sc_hd__nor2_1_136 \_0169_ \_0651_ VGND VPWR VPWR \_0701_
+ sky130_fd_sc_hd__nor2_1
* cell instance sky130_fd_sc_hd__nor2_1_137 r0 *1 0,0
Xsky130_fd_sc_hd__nor2_1_137 \_0262_ net28 VGND VPWR VPWR \_1140_
+ sky130_fd_sc_hd__nor2_1
* cell instance sky130_fd_sc_hd__nor2_1_138 r0 *1 0,0
Xsky130_fd_sc_hd__nor2_1_138 \_0163_ net31 VGND VPWR VPWR \_0906_
+ sky130_fd_sc_hd__nor2_1
* cell instance sky130_fd_sc_hd__nor2_1_139 r0 *1 0,0
Xsky130_fd_sc_hd__nor2_1_139 net34 \_0657_ VGND VPWR VPWR \_0022_[29]
+ sky130_fd_sc_hd__nor2_1
* cell instance sky130_fd_sc_hd__nor2_1_140 r0 *1 0,0
Xsky130_fd_sc_hd__nor2_1_140 \_1422_ \_0093_ VGND VPWR VPWR \_0094_
+ sky130_fd_sc_hd__nor2_1
* cell instance sky130_fd_sc_hd__nor2_1_141 r0 *1 0,0
Xsky130_fd_sc_hd__nor2_1_141 net34 \_0698_ VGND VPWR VPWR \_0022_[10]
+ sky130_fd_sc_hd__nor2_1
* cell instance sky130_fd_sc_hd__nor2_1_142 r0 *1 0,0
Xsky130_fd_sc_hd__nor2_1_142 net34 \_0664_ VGND VPWR VPWR \_0022_[26]
+ sky130_fd_sc_hd__nor2_1
* cell instance sky130_fd_sc_hd__nor2_1_143 r0 *1 0,0
Xsky130_fd_sc_hd__nor2_1_143 \_0064_ \_0651_ VGND VPWR VPWR \_0656_
+ sky130_fd_sc_hd__nor2_1
* cell instance sky130_fd_sc_hd__nor2_1_144 r0 *1 0,0
Xsky130_fd_sc_hd__nor2_1_144 \_0163_ \_0802_ VGND VPWR VPWR \_0908_
+ sky130_fd_sc_hd__nor2_1
* cell instance sky130_fd_sc_hd__nor2_1_145 r0 *1 0,0
Xsky130_fd_sc_hd__nor2_1_145 \_0163_ \_0651_ VGND VPWR VPWR \_0697_
+ sky130_fd_sc_hd__nor2_1
* cell instance sky130_fd_sc_hd__nor2_1_146 r0 *1 0,0
Xsky130_fd_sc_hd__nor2_1_146 \_0084_ \_0651_ VGND VPWR VPWR \_0663_
+ sky130_fd_sc_hd__nor2_1
* cell instance sky130_fd_sc_hd__nor2_1_147 r0 *1 0,0
Xsky130_fd_sc_hd__nor2_1_147 \_0160_ net31 VGND VPWR VPWR \_0901_
+ sky130_fd_sc_hd__nor2_1
* cell instance sky130_fd_sc_hd__nor2_1_148 r0 *1 0,0
Xsky130_fd_sc_hd__nor2_1_148 \_0163_ net33 VGND VPWR VPWR \_1013_
+ sky130_fd_sc_hd__nor2_1
* cell instance sky130_fd_sc_hd__nor2_1_149 r0 *1 0,0
Xsky130_fd_sc_hd__nor2_1_149 \_0262_ net26 VGND VPWR VPWR \_1212_
+ sky130_fd_sc_hd__nor2_1
* cell instance sky130_fd_sc_hd__nor2_1_150 r0 *1 0,0
Xsky130_fd_sc_hd__nor2_1_150 crc_state[13] net35 VGND VPWR VPWR \_0588_
+ sky130_fd_sc_hd__nor2_1
* cell instance sky130_fd_sc_hd__nor2_1_151 r0 *1 0,0
Xsky130_fd_sc_hd__nor2_1_151 net34 \_0692_ VGND VPWR VPWR \_0022_[13]
+ sky130_fd_sc_hd__nor2_1
* cell instance sky130_fd_sc_hd__nor2_1_152 r0 *1 0,0
Xsky130_fd_sc_hd__nor2_1_152 net34 \_0694_ VGND VPWR VPWR \_0022_[12]
+ sky130_fd_sc_hd__nor2_1
* cell instance sky130_fd_sc_hd__nor2_1_153 r0 *1 0,0
Xsky130_fd_sc_hd__nor2_1_153 \_0157_ \_0651_ VGND VPWR VPWR \_0693_
+ sky130_fd_sc_hd__nor2_1
* cell instance sky130_fd_sc_hd__nor2_1_154 r0 *1 0,0
Xsky130_fd_sc_hd__nor2_1_154 \_0160_ \_0802_ VGND VPWR VPWR \_0903_
+ sky130_fd_sc_hd__nor2_1
* cell instance sky130_fd_sc_hd__nor2_1_155 r0 *1 0,0
Xsky130_fd_sc_hd__nor2_1_155 \_0280_ net28 VGND VPWR VPWR \_1166_
+ sky130_fd_sc_hd__nor2_1
* cell instance sky130_fd_sc_hd__nor2_1_156 r0 *1 0,0
Xsky130_fd_sc_hd__nor2_1_156 \_0151_ \_0651_ VGND VPWR VPWR \_0691_
+ sky130_fd_sc_hd__nor2_1
* cell instance sky130_fd_sc_hd__nor2_1_157 r0 *1 0,0
Xsky130_fd_sc_hd__nor2_1_157 \_0160_ net33 VGND VPWR VPWR \_1011_
+ sky130_fd_sc_hd__nor2_1
* cell instance sky130_fd_sc_hd__nor2_1_158 r0 *1 0,0
Xsky130_fd_sc_hd__nor2_1_158 net38 \_0745_ VGND VPWR VPWR \_0012_
+ sky130_fd_sc_hd__nor2_1
* cell instance sky130_fd_sc_hd__nor2_1_159 r0 *1 0,0
Xsky130_fd_sc_hd__nor2_1_159 net40 \_1398_ VGND VPWR VPWR \_0720_
+ sky130_fd_sc_hd__nor2_1
* cell instance sky130_fd_sc_hd__nor2_1_160 r0 *1 0,0
Xsky130_fd_sc_hd__nor2_1_160 crc_state[19] net35 VGND VPWR VPWR \_0576_
+ sky130_fd_sc_hd__nor2_1
* cell instance sky130_fd_sc_hd__nor2_1_161 r0 *1 0,0
Xsky130_fd_sc_hd__nor2_1_161 \_0192_ \_0651_ VGND VPWR VPWR \_0714_
+ sky130_fd_sc_hd__nor2_1
* cell instance sky130_fd_sc_hd__nor2_1_162 r0 *1 0,0
Xsky130_fd_sc_hd__nor2_1_162 net34 \_0679_ VGND VPWR VPWR \_0022_[19]
+ sky130_fd_sc_hd__nor2_1
* cell instance sky130_fd_sc_hd__nor2_1_163 r0 *1 0,0
Xsky130_fd_sc_hd__nor2_1_163 crc_state[15] net35 VGND VPWR VPWR \_0584_
+ sky130_fd_sc_hd__nor2_1
* cell instance sky130_fd_sc_hd__nor2_1_164 r0 *1 0,0
Xsky130_fd_sc_hd__nor2_1_164 net34 \_0715_ VGND VPWR VPWR \_0022_[2]
+ sky130_fd_sc_hd__nor2_1
* cell instance sky130_fd_sc_hd__nor2_1_165 r0 *1 0,0
Xsky130_fd_sc_hd__nor2_1_165 raw_count[5] \_0098_ VGND VPWR VPWR \_0141_
+ sky130_fd_sc_hd__nor2_1
* cell instance sky130_fd_sc_hd__nor2_1_166 r0 *1 0,0
Xsky130_fd_sc_hd__nor2_1_166 net34 \_0688_ VGND VPWR VPWR \_0022_[15]
+ sky130_fd_sc_hd__nor2_1
* cell instance sky130_fd_sc_hd__nor2_1_167 r0 *1 0,0
Xsky130_fd_sc_hd__nor2_1_167 \_0126_ \_0651_ VGND VPWR VPWR \_0678_
+ sky130_fd_sc_hd__nor2_1
* cell instance sky130_fd_sc_hd__nor2_1_168 r0 *1 0,0
Xsky130_fd_sc_hd__nor2_1_168 \_1415_ \_1417_ VGND VPWR VPWR \_1418_
+ sky130_fd_sc_hd__nor2_1
* cell instance sky130_fd_sc_hd__nor2_1_169 r0 *1 0,0
Xsky130_fd_sc_hd__nor2_1_169 \_0145_ net31 VGND VPWR VPWR \_0881_
+ sky130_fd_sc_hd__nor2_1
* cell instance sky130_fd_sc_hd__nor2_1_170 r0 *1 0,0
Xsky130_fd_sc_hd__nor2_1_170 \_0068_ \_0154_ VGND VPWR VPWR \_0156_
+ sky130_fd_sc_hd__nor2_1
* cell instance sky130_fd_sc_hd__nor2_1_171 r0 *1 0,0
Xsky130_fd_sc_hd__nor2_1_171 \_0145_ \_0651_ VGND VPWR VPWR \_0687_
+ sky130_fd_sc_hd__nor2_1
* cell instance sky130_fd_sc_hd__nor2_1_172 r0 *1 0,0
Xsky130_fd_sc_hd__nor2_1_172 crc_state[3] net35 VGND VPWR VPWR \_0608_
+ sky130_fd_sc_hd__nor2_1
* cell instance sky130_fd_sc_hd__nor2_1_173 r0 *1 0,0
Xsky130_fd_sc_hd__nor2_1_173 \_0145_ \_0802_ VGND VPWR VPWR \_0883_
+ sky130_fd_sc_hd__nor2_1
* cell instance sky130_fd_sc_hd__nor2_1_174 r0 *1 0,0
Xsky130_fd_sc_hd__nor2_1_174 crc_state[14] net35 VGND VPWR VPWR \_0586_
+ sky130_fd_sc_hd__nor2_1
* cell instance sky130_fd_sc_hd__nor2_1_175 r0 *1 0,0
Xsky130_fd_sc_hd__nor2_1_175 net34 \_0713_ VGND VPWR VPWR \_0022_[3]
+ sky130_fd_sc_hd__nor2_1
* cell instance sky130_fd_sc_hd__nor2_1_176 r0 *1 0,0
Xsky130_fd_sc_hd__nor2_1_176 \_0145_ net33 VGND VPWR VPWR \_0999_
+ sky130_fd_sc_hd__nor2_1
* cell instance sky130_fd_sc_hd__nor2_1_177 r0 *1 0,0
Xsky130_fd_sc_hd__nor2_1_177 net34 \_0696_ VGND VPWR VPWR \_0022_[11]
+ sky130_fd_sc_hd__nor2_1
* cell instance sky130_fd_sc_hd__nor2_1_178 r0 *1 0,0
Xsky130_fd_sc_hd__nor2_1_178 \_0078_ net31 VGND VPWR VPWR \_0829_
+ sky130_fd_sc_hd__nor2_1
* cell instance sky130_fd_sc_hd__nor2_1_179 r0 *1 0,0
Xsky130_fd_sc_hd__nor2_1_179 \_0189_ \_0651_ VGND VPWR VPWR \_0712_
+ sky130_fd_sc_hd__nor2_1
* cell instance sky130_fd_sc_hd__nor2_1_180 r0 *1 0,0
Xsky130_fd_sc_hd__nor2_1_180 net34 \_0709_ VGND VPWR VPWR \_0022_[5]
+ sky130_fd_sc_hd__nor2_1
* cell instance sky130_fd_sc_hd__nor2_1_181 r0 *1 0,0
Xsky130_fd_sc_hd__nor2_1_181 \_0099_ \_0129_ VGND VPWR VPWR \_0130_
+ sky130_fd_sc_hd__nor2_1
* cell instance sky130_fd_sc_hd__nor2_1_182 r0 *1 0,0
Xsky130_fd_sc_hd__nor2_1_182 net34 \_0681_ VGND VPWR VPWR \_0022_[18]
+ sky130_fd_sc_hd__nor2_1
* cell instance sky130_fd_sc_hd__nor2_1_183 r0 *1 0,0
Xsky130_fd_sc_hd__nor2_1_183 \_0160_ \_0651_ VGND VPWR VPWR \_0695_
+ sky130_fd_sc_hd__nor2_1
* cell instance sky130_fd_sc_hd__nor2_1_184 r0 *1 0,0
Xsky130_fd_sc_hd__nor2_1_184 \_0181_ \_0651_ VGND VPWR VPWR \_0708_
+ sky130_fd_sc_hd__nor2_1
* cell instance sky130_fd_sc_hd__nor2_1_185 r0 *1 0,0
Xsky130_fd_sc_hd__nor2_1_185 \_0131_ net31 VGND VPWR VPWR \_0869_
+ sky130_fd_sc_hd__nor2_1
* cell instance sky130_fd_sc_hd__nor2_1_186 r0 *1 0,0
Xsky130_fd_sc_hd__nor2_1_186 \_0099_ \_0124_ VGND VPWR VPWR \_0125_
+ sky130_fd_sc_hd__nor2_1
* cell instance sky130_fd_sc_hd__nor2_1_187 r0 *1 0,0
Xsky130_fd_sc_hd__nor2_1_187 \_0124_ \_0154_ VGND VPWR VPWR \_0188_
+ sky130_fd_sc_hd__nor2_1
* cell instance sky130_fd_sc_hd__nor2_1_188 r0 *1 0,0
Xsky130_fd_sc_hd__nor2_1_188 \_0131_ \_0651_ VGND VPWR VPWR \_0680_
+ sky130_fd_sc_hd__nor2_1
* cell instance sky130_fd_sc_hd__nor2_1_189 r0 *1 0,0
Xsky130_fd_sc_hd__nor2_1_189 \_0078_ \_0802_ VGND VPWR VPWR \_0831_
+ sky130_fd_sc_hd__nor2_1
* cell instance sky130_fd_sc_hd__nor2_1_190 r0 *1 0,0
Xsky130_fd_sc_hd__nor2_1_190 \_0115_ \_0154_ VGND VPWR VPWR \_0180_
+ sky130_fd_sc_hd__nor2_1
* cell instance sky130_fd_sc_hd__nor2_1_191 r0 *1 0,0
Xsky130_fd_sc_hd__nor2_1_191 \_0131_ \_0802_ VGND VPWR VPWR \_0871_
+ sky130_fd_sc_hd__nor2_1
* cell instance sky130_fd_sc_hd__nor2_1_192 r0 *1 0,0
Xsky130_fd_sc_hd__nor2_1_192 raw_count[2] \_0074_ VGND VPWR VPWR \_0075_
+ sky130_fd_sc_hd__nor2_1
* cell instance sky130_fd_sc_hd__nor2_1_193 r0 *1 0,0
Xsky130_fd_sc_hd__nor2_1_193 \_0078_ net33 VGND VPWR VPWR \_0973_
+ sky130_fd_sc_hd__nor2_1
* cell instance sky130_fd_sc_hd__nor2_1_194 r0 *1 0,0
Xsky130_fd_sc_hd__nor2_1_194 net34 \_0711_ VGND VPWR VPWR \_0022_[4]
+ sky130_fd_sc_hd__nor2_1
* cell instance sky130_fd_sc_hd__nor2_1_195 r0 *1 0,0
Xsky130_fd_sc_hd__nor2_1_195 \_0078_ \_0651_ VGND VPWR VPWR \_0661_
+ sky130_fd_sc_hd__nor2_1
* cell instance sky130_fd_sc_hd__nor2_1_196 r0 *1 0,0
Xsky130_fd_sc_hd__nor2_1_196 net34 \_0662_ VGND VPWR VPWR \_0022_[27]
+ sky130_fd_sc_hd__nor2_1
* cell instance sky130_fd_sc_hd__nor2_1_197 r0 *1 0,0
Xsky130_fd_sc_hd__nor2_1_197 crc_state[20] net35 VGND VPWR VPWR \_0573_
+ sky130_fd_sc_hd__nor2_1
* cell instance sky130_fd_sc_hd__nor2_1_198 r0 *1 0,0
Xsky130_fd_sc_hd__nor2_1_198 raw_count[1] raw_count[0] VGND VPWR VPWR \_0067_
+ sky130_fd_sc_hd__nor2_1
* cell instance sky130_fd_sc_hd__nor2_1_199 r0 *1 0,0
Xsky130_fd_sc_hd__nor2_1_199 \_0131_ net33 VGND VPWR VPWR \_0993_
+ sky130_fd_sc_hd__nor2_1
* cell instance sky130_fd_sc_hd__nor2_1_200 r0 *1 0,0
Xsky130_fd_sc_hd__nor2_1_200 \_0185_ \_0651_ VGND VPWR VPWR \_0710_
+ sky130_fd_sc_hd__nor2_1
* cell instance sky130_fd_sc_hd__nor2_1_201 r0 *1 0,0
Xsky130_fd_sc_hd__nor2_1_201 net40 \_0074_ VGND VPWR VPWR \_0724_
+ sky130_fd_sc_hd__nor2_1
* cell instance sky130_fd_sc_hd__nor2_1_202 r0 *1 0,0
Xsky130_fd_sc_hd__nor2_1_202 raw_count[2] \_0724_ VGND VPWR VPWR \_0725_
+ sky130_fd_sc_hd__nor2_1
* cell instance sky130_fd_sc_hd__nor2_1_203 r0 *1 0,0
Xsky130_fd_sc_hd__nor2_1_203 raw_count[3] \_0722_ VGND VPWR VPWR \_0723_
+ sky130_fd_sc_hd__nor2_1
* cell instance sky130_fd_sc_hd__nor2_1_204 r0 *1 0,0
Xsky130_fd_sc_hd__nor2_1_204 net40 \_0097_ VGND VPWR VPWR \_0722_
+ sky130_fd_sc_hd__nor2_1
* cell instance sky130_fd_sc_hd__nor2_1_205 r0 *1 0,0
Xsky130_fd_sc_hd__nor2_1_205 crc_state[21] net35 VGND VPWR VPWR \_0571_
+ sky130_fd_sc_hd__nor2_1
* cell instance sky130_fd_sc_hd__nor2_1_206 r0 *1 0,0
Xsky130_fd_sc_hd__nor2_1_206 \_0136_ net31 VGND VPWR VPWR \_0873_
+ sky130_fd_sc_hd__nor2_1
* cell instance sky130_fd_sc_hd__nor2_1_207 r0 *1 0,0
Xsky130_fd_sc_hd__nor2_1_207 \_0195_ \_0651_ VGND VPWR VPWR \_0716_
+ sky130_fd_sc_hd__nor2_1
* cell instance sky130_fd_sc_hd__nor2_1_208 r0 *1 0,0
Xsky130_fd_sc_hd__nor2_1_208 \_0173_ \_0651_ VGND VPWR VPWR \_0704_
+ sky130_fd_sc_hd__nor2_1
* cell instance sky130_fd_sc_hd__nor2_1_209 r0 *1 0,0
Xsky130_fd_sc_hd__nor2_1_209 net34 \_0717_ VGND VPWR VPWR \_0022_[1]
+ sky130_fd_sc_hd__nor2_1
* cell instance sky130_fd_sc_hd__nor2_1_210 r0 *1 0,0
Xsky130_fd_sc_hd__nor2_1_210 \_0239_ net28 VGND VPWR VPWR \_1101_
+ sky130_fd_sc_hd__nor2_1
* cell instance sky130_fd_sc_hd__nor2_1_211 r0 *1 0,0
Xsky130_fd_sc_hd__nor2_1_211 \_0136_ \_0802_ VGND VPWR VPWR \_0875_
+ sky130_fd_sc_hd__nor2_1
* cell instance sky130_fd_sc_hd__nor2_1_212 r0 *1 0,0
Xsky130_fd_sc_hd__nor2_1_212 \_0148_ net31 VGND VPWR VPWR \_0885_
+ sky130_fd_sc_hd__nor2_1
* cell instance sky130_fd_sc_hd__nor2_1_213 r0 *1 0,0
Xsky130_fd_sc_hd__nor2_1_213 \_0283_ net28 VGND VPWR VPWR \_1170_
+ sky130_fd_sc_hd__nor2_1
* cell instance sky130_fd_sc_hd__nor2_1_214 r0 *1 0,0
Xsky130_fd_sc_hd__nor2_1_214 \_0280_ net26 VGND VPWR VPWR \_1225_
+ sky130_fd_sc_hd__nor2_1
* cell instance sky130_fd_sc_hd__nor2_1_215 r0 *1 0,0
Xsky130_fd_sc_hd__nor2_1_215 \_0242_ net28 VGND VPWR VPWR \_1105_
+ sky130_fd_sc_hd__nor2_1
* cell instance sky130_fd_sc_hd__nor2_1_216 r0 *1 0,0
Xsky130_fd_sc_hd__nor2_1_216 \_0148_ \_0802_ VGND VPWR VPWR \_0887_
+ sky130_fd_sc_hd__nor2_1
* cell instance sky130_fd_sc_hd__nor2_1_217 r0 *1 0,0
Xsky130_fd_sc_hd__nor2_1_217 \_0136_ net33 VGND VPWR VPWR \_0995_
+ sky130_fd_sc_hd__nor2_1
* cell instance sky130_fd_sc_hd__nor2_1_218 r0 *1 0,0
Xsky130_fd_sc_hd__nor2_1_218 \_0099_ \_0134_ VGND VPWR VPWR \_0135_
+ sky130_fd_sc_hd__nor2_1
* cell instance sky130_fd_sc_hd__nor2_1_219 r0 *1 0,0
Xsky130_fd_sc_hd__nor2_1_219 \_0103_ \_0154_ VGND VPWR VPWR \_0172_
+ sky130_fd_sc_hd__nor2_1
* cell instance sky130_fd_sc_hd__nor2_1_220 r0 *1 0,0
Xsky130_fd_sc_hd__nor2_1_220 \_0283_ net26 VGND VPWR VPWR \_1228_
+ sky130_fd_sc_hd__nor2_1
* cell instance sky130_fd_sc_hd__nor2_1_221 r0 *1 0,0
Xsky130_fd_sc_hd__nor2_1_221 \_0242_ net26 VGND VPWR VPWR \_1194_
+ sky130_fd_sc_hd__nor2_1
* cell instance sky130_fd_sc_hd__nor2_1_222 r0 *1 0,0
Xsky130_fd_sc_hd__nor2_1_222 \_0136_ \_0651_ VGND VPWR VPWR \_0683_
+ sky130_fd_sc_hd__nor2_1
* cell instance sky130_fd_sc_hd__nor2_1_223 r0 *1 0,0
Xsky130_fd_sc_hd__nor2_1_223 net34 \_0690_ VGND VPWR VPWR \_0022_[14]
+ sky130_fd_sc_hd__nor2_1
* cell instance sky130_fd_sc_hd__nor2_1_224 r0 *1 0,0
Xsky130_fd_sc_hd__nor2_1_224 \_0097_ \_1422_ VGND VPWR VPWR \_0102_
+ sky130_fd_sc_hd__nor2_1
* cell instance sky130_fd_sc_hd__nor2_1_225 r0 *1 0,0
Xsky130_fd_sc_hd__nor2_1_225 \_0148_ net33 VGND VPWR VPWR \_1001_
+ sky130_fd_sc_hd__nor2_1
* cell instance sky130_fd_sc_hd__nor2_1_226 r0 *1 0,0
Xsky130_fd_sc_hd__nor2_1_226 \_0239_ net26 VGND VPWR VPWR \_1191_
+ sky130_fd_sc_hd__nor2_1
* cell instance sky130_fd_sc_hd__nor2_1_227 r0 *1 0,0
Xsky130_fd_sc_hd__nor2_1_227 net34 \_0684_ VGND VPWR VPWR \_0022_[17]
+ sky130_fd_sc_hd__nor2_1
* cell instance sky130_fd_sc_hd__nor2_1_228 r0 *1 0,0
Xsky130_fd_sc_hd__nor2_1_228 \_0148_ \_0651_ VGND VPWR VPWR \_0689_
+ sky130_fd_sc_hd__nor2_1
* cell instance sky130_fd_sc_hd__nor2_1_229 r0 *1 0,0
Xsky130_fd_sc_hd__nor2_1_229 \_0110_ \_0154_ VGND VPWR VPWR \_0176_
+ sky130_fd_sc_hd__nor2_1
* cell instance sky130_fd_sc_hd__nor2_1_230 r0 *1 0,0
Xsky130_fd_sc_hd__nor2_1_230 \_0177_ \_0651_ VGND VPWR VPWR \_0706_
+ sky130_fd_sc_hd__nor2_1
* cell instance sky130_fd_sc_hd__nor2_1_231 r0 *1 0,0
Xsky130_fd_sc_hd__nor2_1_231 \_0071_ net31 VGND VPWR VPWR \_0824_
+ sky130_fd_sc_hd__nor2_1
* cell instance sky130_fd_sc_hd__nor2_1_232 r0 *1 0,0
Xsky130_fd_sc_hd__nor2_1_232 \_1422_ \_0069_ VGND VPWR VPWR \_0070_
+ sky130_fd_sc_hd__nor2_1
* cell instance sky130_fd_sc_hd__nor2_1_233 r0 *1 0,0
Xsky130_fd_sc_hd__nor2_1_233 net34 \_0707_ VGND VPWR VPWR \_0022_[6]
+ sky130_fd_sc_hd__nor2_1
* cell instance sky130_fd_sc_hd__nor2_1_234 r0 *1 0,0
Xsky130_fd_sc_hd__nor2_1_234 \_0099_ \_0115_ VGND VPWR VPWR \_0116_
+ sky130_fd_sc_hd__nor2_1
* cell instance sky130_fd_sc_hd__nor2_1_235 r0 *1 0,0
Xsky130_fd_sc_hd__nor2_1_235 \_0099_ \_0103_ VGND VPWR VPWR \_0104_
+ sky130_fd_sc_hd__nor2_1
* cell instance sky130_fd_sc_hd__nor2_1_236 r0 *1 0,0
Xsky130_fd_sc_hd__nor2_1_236 crc_state[0] net35 VGND VPWR VPWR \_0614_
+ sky130_fd_sc_hd__nor2_1
* cell instance sky130_fd_sc_hd__nor2_1_237 r0 *1 0,0
Xsky130_fd_sc_hd__nor2_1_237 \_1428_ net31 VGND VPWR VPWR \_0800_
+ sky130_fd_sc_hd__nor2_1
* cell instance sky130_fd_sc_hd__nor2_1_238 r0 *1 0,0
Xsky130_fd_sc_hd__nor2_1_238 \_0099_ \_0110_ VGND VPWR VPWR \_0111_
+ sky130_fd_sc_hd__nor2_1
* cell instance sky130_fd_sc_hd__nor2_1_239 r0 *1 0,0
Xsky130_fd_sc_hd__nor2_1_239 \_0112_ net31 VGND VPWR VPWR \_0852_
+ sky130_fd_sc_hd__nor2_1
* cell instance sky130_fd_sc_hd__nor2_1_240 r0 *1 0,0
Xsky130_fd_sc_hd__nor2_1_240 \_0121_ net31 VGND VPWR VPWR \_0861_
+ sky130_fd_sc_hd__nor2_1
* cell instance sky130_fd_sc_hd__nor2_1_241 r0 *1 0,0
Xsky130_fd_sc_hd__nor2_1_241 \_0105_ net31 VGND VPWR VPWR \_0848_
+ sky130_fd_sc_hd__nor2_1
* cell instance sky130_fd_sc_hd__nor2_1_242 r0 *1 0,0
Xsky130_fd_sc_hd__nor2_1_242 \_0117_ net31 VGND VPWR VPWR \_0857_
+ sky130_fd_sc_hd__nor2_1
* cell instance sky130_fd_sc_hd__nor2_1_243 r0 *1 0,0
Xsky130_fd_sc_hd__nor2_1_243 net40 gated VGND VPWR VPWR \_0221_
+ sky130_fd_sc_hd__nor2_1
* cell instance sky130_fd_sc_hd__nor2_1_244 r0 *1 0,0
Xsky130_fd_sc_hd__nor2_1_244 \_0540_ net34 VGND VPWR VPWR \_0545_
+ sky130_fd_sc_hd__nor2_1
* cell instance sky130_fd_sc_hd__nor2_1_245 r0 *1 0,0
Xsky130_fd_sc_hd__nor2_1_245 net34 \_0675_ VGND VPWR VPWR \_0022_[21]
+ sky130_fd_sc_hd__nor2_1
* cell instance sky130_fd_sc_hd__nor2_1_246 r0 *1 0,0
Xsky130_fd_sc_hd__nor2_1_246 net34 \_0670_ VGND VPWR VPWR \_0022_[23]
+ sky130_fd_sc_hd__nor2_1
* cell instance sky130_fd_sc_hd__nor2_1_247 r0 *1 0,0
Xsky130_fd_sc_hd__nor2_1_247 \_0071_ \_0802_ VGND VPWR VPWR \_0826_
+ sky130_fd_sc_hd__nor2_1
* cell instance sky130_fd_sc_hd__nor2_1_248 r0 *1 0,0
Xsky130_fd_sc_hd__nor2_1_248 net34 \_0629_ VGND VPWR VPWR \_0006_[11]
+ sky130_fd_sc_hd__nor2_1
* cell instance sky130_fd_sc_hd__nor2_1_249 r0 *1 0,0
Xsky130_fd_sc_hd__nor2_1_249 \_0117_ \_0651_ VGND VPWR VPWR \_0674_
+ sky130_fd_sc_hd__nor2_1
* cell instance sky130_fd_sc_hd__nor2_1_250 r0 *1 0,0
Xsky130_fd_sc_hd__nor2_1_250 \_0105_ \_0651_ VGND VPWR VPWR \_0669_
+ sky130_fd_sc_hd__nor2_1
* cell instance sky130_fd_sc_hd__nor2_1_251 r0 *1 0,0
Xsky130_fd_sc_hd__nor2_1_251 \_0121_ \_0802_ VGND VPWR VPWR \_0863_
+ sky130_fd_sc_hd__nor2_1
* cell instance sky130_fd_sc_hd__nor2_1_252 r0 *1 0,0
Xsky130_fd_sc_hd__nor2_1_252 net34 \_0620_ VGND VPWR VPWR \_0006_[14]
+ sky130_fd_sc_hd__nor2_1
* cell instance sky130_fd_sc_hd__nor2_1_253 r0 *1 0,0
Xsky130_fd_sc_hd__nor2_1_253 \_0117_ \_0802_ VGND VPWR VPWR \_0859_
+ sky130_fd_sc_hd__nor2_1
* cell instance sky130_fd_sc_hd__nor2_1_254 r0 *1 0,0
Xsky130_fd_sc_hd__nor2_1_254 net34 \_0677_ VGND VPWR VPWR \_0022_[20]
+ sky130_fd_sc_hd__nor2_1
* cell instance sky130_fd_sc_hd__nor2_1_255 r0 *1 0,0
Xsky130_fd_sc_hd__nor2_1_255 \_0117_ net33 VGND VPWR VPWR \_0987_
+ sky130_fd_sc_hd__nor2_1
* cell instance sky130_fd_sc_hd__nor2_1_256 r0 *1 0,0
Xsky130_fd_sc_hd__nor2_1_256 \_0121_ \_0651_ VGND VPWR VPWR \_0676_
+ sky130_fd_sc_hd__nor2_1
* cell instance sky130_fd_sc_hd__nor2_1_257 r0 *1 0,0
Xsky130_fd_sc_hd__nor2_1_257 \_0112_ \_0651_ VGND VPWR VPWR \_0672_
+ sky130_fd_sc_hd__nor2_1
* cell instance sky130_fd_sc_hd__nor2_1_258 r0 *1 0,0
Xsky130_fd_sc_hd__nor2_1_258 \_1428_ \_0651_ VGND VPWR VPWR \_0653_
+ sky130_fd_sc_hd__nor2_1
* cell instance sky130_fd_sc_hd__nor2_1_259 r0 *1 0,0
Xsky130_fd_sc_hd__nor2_1_259 \_0071_ \_0651_ VGND VPWR VPWR \_0659_
+ sky130_fd_sc_hd__nor2_1
* cell instance sky130_fd_sc_hd__nor2_1_260 r0 *1 0,0
Xsky130_fd_sc_hd__nor2_1_260 \_0071_ net33 VGND VPWR VPWR \_0971_
+ sky130_fd_sc_hd__nor2_1
* cell instance sky130_fd_sc_hd__nor2_1_261 r0 *1 0,0
Xsky130_fd_sc_hd__nor2_1_261 \_0112_ \_0802_ VGND VPWR VPWR \_0854_
+ sky130_fd_sc_hd__nor2_1
* cell instance sky130_fd_sc_hd__nor2_1_262 r0 *1 0,0
Xsky130_fd_sc_hd__nor2_1_262 net34 \_0637_ VGND VPWR VPWR \_0006_[8]
+ sky130_fd_sc_hd__nor2_1
* cell instance sky130_fd_sc_hd__nor2_1_263 r0 *1 0,0
Xsky130_fd_sc_hd__nor2_1_263 cond_count[14] \_0200_ VGND VPWR VPWR \_0618_
+ sky130_fd_sc_hd__nor2_1
* cell instance sky130_fd_sc_hd__nor2_1_264 r0 *1 0,0
Xsky130_fd_sc_hd__nor2_1_264 net34 \_0654_ VGND VPWR VPWR \_0022_[30]
+ sky130_fd_sc_hd__nor2_1
* cell instance sky130_fd_sc_hd__nor2_1_265 r0 *1 0,0
Xsky130_fd_sc_hd__nor2_1_265 net34 \_0660_ VGND VPWR VPWR \_0022_[28]
+ sky130_fd_sc_hd__nor2_1
* cell instance sky130_fd_sc_hd__nor2_1_266 r0 *1 0,0
Xsky130_fd_sc_hd__nor2_1_266 net34 \_0673_ VGND VPWR VPWR \_0022_[22]
+ sky130_fd_sc_hd__nor2_1
* cell instance sky130_fd_sc_hd__nor2_1_267 r0 *1 0,0
Xsky130_fd_sc_hd__nor2_1_267 \_0112_ net33 VGND VPWR VPWR \_0985_
+ sky130_fd_sc_hd__nor2_1
* cell instance sky130_fd_sc_hd__nor2_1_268 r0 *1 0,0
Xsky130_fd_sc_hd__nor2_1_268 \_1428_ \_0802_ VGND VPWR VPWR \_0807_
+ sky130_fd_sc_hd__nor2_1
* cell instance sky130_fd_sc_hd__nor2_1_269 r0 *1 0,0
Xsky130_fd_sc_hd__nor2_1_269 \_0121_ net33 VGND VPWR VPWR \_0989_
+ sky130_fd_sc_hd__nor2_1
* cell instance sky130_fd_sc_hd__nor2_1_270 r0 *1 0,0
Xsky130_fd_sc_hd__nor2_1_270 net34 \_0623_ VGND VPWR VPWR \_0006_[13]
+ sky130_fd_sc_hd__nor2_1
* cell instance sky130_fd_sc_hd__nor2_1_271 r0 *1 0,0
Xsky130_fd_sc_hd__nor2_1_271 \_0105_ \_0802_ VGND VPWR VPWR \_0850_
+ sky130_fd_sc_hd__nor2_1
* cell instance sky130_fd_sc_hd__nor2_1_272 r0 *1 0,0
Xsky130_fd_sc_hd__nor2_1_272 \_1428_ net33 VGND VPWR VPWR \_0966_
+ sky130_fd_sc_hd__nor2_1
* cell instance sky130_fd_sc_hd__nor2_1_273 r0 *1 0,0
Xsky130_fd_sc_hd__nor2_1_273 \_0105_ net33 VGND VPWR VPWR \_0983_
+ sky130_fd_sc_hd__nor2_1
* cell instance sky130_fd_sc_hd__nor2_1_274 r0 *1 0,0
Xsky130_fd_sc_hd__nor2_1_274 net34 \_0626_ VGND VPWR VPWR \_0006_[12]
+ sky130_fd_sc_hd__nor2_1
* cell instance sky130_fd_sc_hd__nor2_1_275 r0 *1 0,0
Xsky130_fd_sc_hd__nor2_1_275 net34 \_1289_ VGND VPWR VPWR \_0006_[15]
+ sky130_fd_sc_hd__nor2_1
* cell instance sky130_fd_sc_hd__nor2_1_276 r0 *1 0,0
Xsky130_fd_sc_hd__nor2_1_276 net38 \_0496_ VGND VPWR VPWR \_0026_[13]
+ sky130_fd_sc_hd__nor2_1
* cell instance sky130_fd_sc_hd__nor2_1_277 r0 *1 0,0
Xsky130_fd_sc_hd__nor2_1_277 \_0408_ \_0518_ VGND VPWR VPWR \_0026_[7]
+ sky130_fd_sc_hd__nor2_1
* cell instance sky130_fd_sc_hd__nor2_1_278 r0 *1 0,0
Xsky130_fd_sc_hd__nor2_1_278 net38 \_0500_ VGND VPWR VPWR \_0026_[12]
+ sky130_fd_sc_hd__nor2_1
* cell instance sky130_fd_sc_hd__nor2_1_279 r0 *1 0,0
Xsky130_fd_sc_hd__nor2_1_279 startup_done_r \_0311_ VGND VPWR VPWR \_0742_
+ sky130_fd_sc_hd__nor2_1
* cell instance sky130_fd_sc_hd__nor2_1_280 r0 *1 0,0
Xsky130_fd_sc_hd__nor2_1_280 \_0408_ \_0513_ VGND VPWR VPWR \_0026_[9]
+ sky130_fd_sc_hd__nor2_1
* cell instance sky130_fd_sc_hd__nor2_1_281 r0 *1 0,0
Xsky130_fd_sc_hd__nor2_1_281 net38 \_0508_ VGND VPWR VPWR \_0026_[10]
+ sky130_fd_sc_hd__nor2_1
* cell instance sky130_fd_sc_hd__nor2_1_282 r0 *1 0,0
Xsky130_fd_sc_hd__nor2_1_282 net40 \_0326_ VGND VPWR VPWR \_0406_
+ sky130_fd_sc_hd__nor2_1
* cell instance sky130_fd_sc_hd__nor2_1_283 r0 *1 0,0
Xsky130_fd_sc_hd__nor2_1_283 net38 \_0446_ VGND VPWR VPWR \_0004_[12]
+ sky130_fd_sc_hd__nor2_1
* cell instance sky130_fd_sc_hd__nor2_1_284 r0 *1 0,0
Xsky130_fd_sc_hd__nor2_1_284 net38 \_0448_ VGND VPWR VPWR \_0004_[10]
+ sky130_fd_sc_hd__nor2_1
* cell instance sky130_fd_sc_hd__nor2_1_285 r0 *1 0,0
Xsky130_fd_sc_hd__nor2_1_285 \_0408_ \_0520_ VGND VPWR VPWR \_0026_[5]
+ sky130_fd_sc_hd__nor2_1
* cell instance sky130_fd_sc_hd__nor2_1_286 r0 *1 0,0
Xsky130_fd_sc_hd__nor2_1_286 \_0327_ \_0380_ VGND VPWR VPWR \_0381_
+ sky130_fd_sc_hd__nor2_1
* cell instance sky130_fd_sc_hd__nor2_1_287 r0 *1 0,0
Xsky130_fd_sc_hd__nor2_1_287 net38 \_0444_ VGND VPWR VPWR \_0004_[13]
+ sky130_fd_sc_hd__nor2_1
* cell instance sky130_fd_sc_hd__nor2_1_288 r0 *1 0,0
Xsky130_fd_sc_hd__nor2_1_288 net38 \_0441_ VGND VPWR VPWR \_0004_[14]
+ sky130_fd_sc_hd__nor2_1
* cell instance sky130_fd_sc_hd__nor2_1_289 r0 *1 0,0
Xsky130_fd_sc_hd__nor2_1_289 startup_done_r \_0481_ VGND VPWR VPWR \_0514_
+ sky130_fd_sc_hd__nor2_1
* cell instance sky130_fd_sc_hd__nor2_1_290 r0 *1 0,0
Xsky130_fd_sc_hd__nor2_1_290 net38 \_0447_ VGND VPWR VPWR \_0004_[11]
+ sky130_fd_sc_hd__nor2_1
* cell instance sky130_fd_sc_hd__nor2_1_291 r0 *1 0,0
Xsky130_fd_sc_hd__nor2_1_291 net38 \_1281_ VGND VPWR VPWR \_0004_[15]
+ sky130_fd_sc_hd__nor2_1
* cell instance sky130_fd_sc_hd__nor2_1_292 r0 *1 0,0
Xsky130_fd_sc_hd__nor2_1_292 net38 \_1284_ VGND VPWR VPWR \_0026_[15]
+ sky130_fd_sc_hd__nor2_1
* cell instance sky130_fd_sc_hd__nor2_1_293 r0 *1 0,0
Xsky130_fd_sc_hd__nor2_1_293 \_0478_ \_0483_ VGND VPWR VPWR \_0484_
+ sky130_fd_sc_hd__nor2_1
* cell instance sky130_fd_sc_hd__nor2_1_294 r0 *1 0,0
Xsky130_fd_sc_hd__nor2_1_294 \_0480_ \_0481_ VGND VPWR VPWR \_0482_
+ sky130_fd_sc_hd__nor2_1
* cell instance sky130_fd_sc_hd__nor2_1_295 r0 *1 0,0
Xsky130_fd_sc_hd__nor2_1_295 net38 \_0403_ VGND VPWR VPWR \_0003_[14]
+ sky130_fd_sc_hd__nor2_1
* cell instance sky130_fd_sc_hd__nor2_1_296 r0 *1 0,0
Xsky130_fd_sc_hd__nor2_1_296 \_0337_ \_0339_ VGND VPWR VPWR \_0442_
+ sky130_fd_sc_hd__nor2_1
* cell instance sky130_fd_sc_hd__nor2_1_297 r0 *1 0,0
Xsky130_fd_sc_hd__nor2_1_297 startup_done_r net40 VGND VPWR VPWR \_0509_
+ sky130_fd_sc_hd__nor2_1
* cell instance sky130_fd_sc_hd__nor2_1_298 r0 *1 0,0
Xsky130_fd_sc_hd__nor2_1_298 net38 \_0517_ VGND VPWR VPWR \_0026_[8]
+ sky130_fd_sc_hd__nor2_1
* cell instance sky130_fd_sc_hd__nor2_1_299 r0 *1 0,0
Xsky130_fd_sc_hd__nor2_1_299 net38 \_0504_ VGND VPWR VPWR \_0026_[11]
+ sky130_fd_sc_hd__nor2_1
* cell instance sky130_fd_sc_hd__nor2_1_300 r0 *1 0,0
Xsky130_fd_sc_hd__nor2_1_300 \_0477_ \_0485_ VGND VPWR VPWR \_0738_
+ sky130_fd_sc_hd__nor2_1
* cell instance sky130_fd_sc_hd__nor2_1_301 r0 *1 0,0
Xsky130_fd_sc_hd__nor2_1_301 \_0327_ \_0376_ VGND VPWR VPWR \_0402_
+ sky130_fd_sc_hd__nor2_1
* cell instance sky130_fd_sc_hd__nor2_1_302 r0 *1 0,0
Xsky130_fd_sc_hd__nor2_1_302 net38 \_0452_ VGND VPWR VPWR \_0004_[9]
+ sky130_fd_sc_hd__nor2_1
* cell instance sky130_fd_sc_hd__nor2_1_303 r0 *1 0,0
Xsky130_fd_sc_hd__nor2_1_303 net38 \_0489_ VGND VPWR VPWR \_0026_[14]
+ sky130_fd_sc_hd__nor2_1
* cell instance sky130_fd_sc_hd__nor2_1_304 r0 *1 0,0
Xsky130_fd_sc_hd__nor2_1_304 net37 \_0416_ VGND VPWR VPWR \_0443_
+ sky130_fd_sc_hd__nor2_1
* cell instance sky130_fd_sc_hd__nor2_1_305 r0 *1 0,0
Xsky130_fd_sc_hd__nor2_1_305 \_0408_ \_0526_ VGND VPWR VPWR \_0026_[1]
+ sky130_fd_sc_hd__nor2_1
* cell instance sky130_fd_sc_hd__nor2_1_306 r0 *1 0,0
Xsky130_fd_sc_hd__nor2_1_306 \_0327_ \_0378_ VGND VPWR VPWR \_1278_
+ sky130_fd_sc_hd__nor2_1
* cell instance sky130_fd_sc_hd__nor2_1_307 r0 *1 0,0
Xsky130_fd_sc_hd__nor2_1_307 startup_count[0] \_0509_ VGND VPWR VPWR \_0527_
+ sky130_fd_sc_hd__nor2_1
* cell instance sky130_fd_sc_hd__nor2_1_308 r0 *1 0,0
Xsky130_fd_sc_hd__nor2_1_308 \_0368_ \_0373_ VGND VPWR VPWR \_0375_
+ sky130_fd_sc_hd__nor2_1
* cell instance sky130_fd_sc_hd__nor2_1_309 r0 *1 0,0
Xsky130_fd_sc_hd__nor2_1_309 apt_index[14] apt_index[13] VGND VPWR VPWR \_0349_
+ sky130_fd_sc_hd__nor2_1
* cell instance sky130_fd_sc_hd__nor2_1_310 r0 *1 0,0
Xsky130_fd_sc_hd__nor2_1_310 \_1275_ \_1277_ VGND VPWR VPWR \_0005_
+ sky130_fd_sc_hd__nor2_1
* cell instance sky130_fd_sc_hd__nor2_1_311 r0 *1 0,0
Xsky130_fd_sc_hd__nor2_1_311 net38 \_1279_ VGND VPWR VPWR \_0003_[15]
+ sky130_fd_sc_hd__nor2_1
* cell instance sky130_fd_sc_hd__nor2_1_312 r0 *1 0,0
Xsky130_fd_sc_hd__nor2_1_312 startup_count[3] \_0523_ VGND VPWR VPWR \_0524_
+ sky130_fd_sc_hd__nor2_1
* cell instance sky130_fd_sc_hd__nor2_1_313 r0 *1 0,0
Xsky130_fd_sc_hd__nor2_1_313 net38 \_0471_ VGND VPWR VPWR \_0004_[1]
+ sky130_fd_sc_hd__nor2_1
* cell instance sky130_fd_sc_hd__nor2_1_314 r0 *1 0,0
Xsky130_fd_sc_hd__nor2_1_314 net38 \_0401_ VGND VPWR VPWR \_0024_[0]
+ sky130_fd_sc_hd__nor2_1
* cell instance sky130_fd_sc_hd__nor2_1_315 r0 *1 0,0
Xsky130_fd_sc_hd__nor2_1_315 \_0408_ \_1274_ VGND VPWR VPWR \_0023_
+ sky130_fd_sc_hd__nor2_1
* cell instance sky130_fd_sc_hd__nor2_1_316 r0 *1 0,0
Xsky130_fd_sc_hd__nor2_1_316 net38 \_0468_ VGND VPWR VPWR \_0004_[2]
+ sky130_fd_sc_hd__nor2_1
* cell instance sky130_fd_sc_hd__nor2_1_317 r0 *1 0,0
Xsky130_fd_sc_hd__nor2_1_317 net38 \_0399_ VGND VPWR VPWR \_0024_[1]
+ sky130_fd_sc_hd__nor2_1
* cell instance sky130_fd_sc_hd__nor2_1_318 r0 *1 0,0
Xsky130_fd_sc_hd__nor2_1_318 net38 \_0419_ VGND VPWR VPWR \_0003_[10]
+ sky130_fd_sc_hd__nor2_1
* cell instance sky130_fd_sc_hd__nor2_1_319 r0 *1 0,0
Xsky130_fd_sc_hd__nor2_1_319 net38 \_0475_ VGND VPWR VPWR \_0004_[0]
+ sky130_fd_sc_hd__nor2_1
* cell instance sky130_fd_sc_hd__nor2_1_320 r0 *1 0,0
Xsky130_fd_sc_hd__nor2_1_320 rct_armed \_0311_ VGND VPWR VPWR \_1274_
+ sky130_fd_sc_hd__nor2_1
* cell instance sky130_fd_sc_hd__nor2_1_321 r0 *1 0,0
Xsky130_fd_sc_hd__nor2_1_321 \_0408_ \_0412_ VGND VPWR VPWR \_0003_[12]
+ sky130_fd_sc_hd__nor2_1
* cell instance sky130_fd_sc_hd__nor2_1_322 r0 *1 0,0
Xsky130_fd_sc_hd__nor2_1_322 net38 \_0458_ VGND VPWR VPWR \_0004_[6]
+ sky130_fd_sc_hd__nor2_1
* cell instance sky130_fd_sc_hd__nor2_1_323 r0 *1 0,0
Xsky130_fd_sc_hd__nor2_1_323 net38 \_0454_ VGND VPWR VPWR \_0004_[8]
+ sky130_fd_sc_hd__nor2_1
* cell instance sky130_fd_sc_hd__nor2_1_324 r0 *1 0,0
Xsky130_fd_sc_hd__nor2_1_324 \_0416_ \_0473_ VGND VPWR VPWR \_0474_
+ sky130_fd_sc_hd__nor2_1
* cell instance sky130_fd_sc_hd__nor2_1_325 r0 *1 0,0
Xsky130_fd_sc_hd__nor2_1_325 \_0332_ \_0357_ VGND VPWR VPWR \_0453_
+ sky130_fd_sc_hd__nor2_1
* cell instance sky130_fd_sc_hd__nor2_1_326 r0 *1 0,0
Xsky130_fd_sc_hd__nor2_1_326 \_0416_ \_0417_ VGND VPWR VPWR \_0418_
+ sky130_fd_sc_hd__nor2_1
* cell instance sky130_fd_sc_hd__nor2_1_327 r0 *1 0,0
Xsky130_fd_sc_hd__nor2_1_327 net38 \_0397_ VGND VPWR VPWR \_0024_[2]
+ sky130_fd_sc_hd__nor2_1
* cell instance sky130_fd_sc_hd__nor2_1_328 r0 *1 0,0
Xsky130_fd_sc_hd__nor2_1_328 net38 \_0383_ VGND VPWR VPWR \_0024_[6]
+ sky130_fd_sc_hd__nor2_1
* cell instance sky130_fd_sc_hd__nor2_1_329 r0 *1 0,0
Xsky130_fd_sc_hd__nor2_1_329 \_0343_ \_0344_ VGND VPWR VPWR \_0455_
+ sky130_fd_sc_hd__nor2_1
* cell instance sky130_fd_sc_hd__nor2_1_330 r0 *1 0,0
Xsky130_fd_sc_hd__nor2_1_330 net38 \_0456_ VGND VPWR VPWR \_0004_[7]
+ sky130_fd_sc_hd__nor2_1
* cell instance sky130_fd_sc_hd__nor2_1_331 r0 *1 0,0
Xsky130_fd_sc_hd__nor2_1_331 apt_matches[3] \_0329_ VGND VPWR VPWR \_0347_
+ sky130_fd_sc_hd__nor2_1
* cell instance sky130_fd_sc_hd__nor2_1_332 r0 *1 0,0
Xsky130_fd_sc_hd__nor2_1_332 \_0346_ \_0347_ VGND VPWR VPWR \_0464_
+ sky130_fd_sc_hd__nor2_1
* cell instance sky130_fd_sc_hd__nor2_1_333 r0 *1 0,0
Xsky130_fd_sc_hd__nor2_1_333 apt_index[9] \_0424_ VGND VPWR VPWR \_0425_
+ sky130_fd_sc_hd__nor2_1
* cell instance sky130_fd_sc_hd__nor2_1_334 r0 *1 0,0
Xsky130_fd_sc_hd__nor2_1_334 net38 \_0463_ VGND VPWR VPWR \_0004_[4]
+ sky130_fd_sc_hd__nor2_1
* cell instance sky130_fd_sc_hd__nor2_1_335 r0 *1 0,0
Xsky130_fd_sc_hd__nor2_1_335 \_0309_ \_0322_ VGND VPWR VPWR \_0386_
+ sky130_fd_sc_hd__nor2_1
* cell instance sky130_fd_sc_hd__nor2_1_336 r0 *1 0,0
Xsky130_fd_sc_hd__nor2_1_336 \_0330_ \_0459_ VGND VPWR VPWR \_0460_
+ sky130_fd_sc_hd__nor2_1
* cell instance sky130_fd_sc_hd__nor2_1_337 r0 *1 0,0
Xsky130_fd_sc_hd__nor2_1_337 \_0431_ \_0420_ VGND VPWR VPWR \_0432_
+ sky130_fd_sc_hd__nor2_1
* cell instance sky130_fd_sc_hd__nor2_1_338 r0 *1 0,0
Xsky130_fd_sc_hd__nor2_1_338 net38 \_0391_ VGND VPWR VPWR \_0024_[4]
+ sky130_fd_sc_hd__nor2_1
* cell instance sky130_fd_sc_hd__nor2_1_339 r0 *1 0,0
Xsky130_fd_sc_hd__nor2_1_339 net38 \_0387_ VGND VPWR VPWR \_0024_[5]
+ sky130_fd_sc_hd__nor2_1
* cell instance sky130_fd_sc_hd__nor2_1_340 r0 *1 0,0
Xsky130_fd_sc_hd__nor2_1_340 net38 \_0465_ VGND VPWR VPWR \_0004_[3]
+ sky130_fd_sc_hd__nor2_1
* cell instance sky130_fd_sc_hd__nor2_1_341 r0 *1 0,0
Xsky130_fd_sc_hd__nor2_1_341 \_0364_ \_0420_ VGND VPWR VPWR \_0421_
+ sky130_fd_sc_hd__nor2_1
* cell instance sky130_fd_sc_hd__nor2_1_342 r0 *1 0,0
Xsky130_fd_sc_hd__nor2_1_342 net38 \_0461_ VGND VPWR VPWR \_0004_[5]
+ sky130_fd_sc_hd__nor2_1
* cell instance sky130_fd_sc_hd__nor2_1_343 r0 *1 0,0
Xsky130_fd_sc_hd__nor2_1_343 apt_index[3] \_0432_ VGND VPWR VPWR \_0433_
+ sky130_fd_sc_hd__nor2_1
* cell instance sky130_fd_sc_hd__nor2_1_344 r0 *1 0,0
Xsky130_fd_sc_hd__nor2_1_344 \_0408_ \_0436_ VGND VPWR VPWR \_0003_[1]
+ sky130_fd_sc_hd__nor2_1
* cell instance sky130_fd_sc_hd__nor2_1_345 r0 *1 0,0
Xsky130_fd_sc_hd__nor2_1_345 \_0408_ \_0427_ VGND VPWR VPWR \_0003_[7]
+ sky130_fd_sc_hd__nor2_1
* cell instance sky130_fd_sc_hd__nor2_1_346 r0 *1 0,0
Xsky130_fd_sc_hd__nor2_1_346 \_0408_ \_0430_ VGND VPWR VPWR \_0003_[4]
+ sky130_fd_sc_hd__nor2_1
* cell instance sky130_fd_sc_hd__nor2_1_347 r0 *1 0,0
Xsky130_fd_sc_hd__nor2_1_347 apt_index[6] \_0422_ VGND VPWR VPWR \_0428_
+ sky130_fd_sc_hd__nor2_1
* cell instance sky130_fd_sc_hd__nor2b_1_0 r0 *1 0,0
Xsky130_fd_sc_hd__nor2b_1_0 raw_count[5] raw_count[4] VGND VPWR VPWR \_0092_
+ sky130_fd_sc_hd__nor2b_1
* cell instance sky130_fd_sc_hd__nor2b_1_1 r0 *1 0,0
Xsky130_fd_sc_hd__nor2b_1_1 \_1413_ net43 VGND VPWR VPWR \_0108_
+ sky130_fd_sc_hd__nor2b_1
* cell instance sky130_fd_sc_hd__nor3_1_0 r0 *1 0,0
Xsky130_fd_sc_hd__nor3_1_0 bus_addr[3] bus_addr[2] \_1336_ VGND VPWR VPWR
+ \_1343_ sky130_fd_sc_hd__nor3_1
* cell instance sky130_fd_sc_hd__nor3_1_1 r0 *1 0,0
Xsky130_fd_sc_hd__nor3_1_1 bus_addr[3] bus_addr[2] \_0785_ VGND VPWR VPWR
+ \_0786_ sky130_fd_sc_hd__nor3_1
* cell instance sky130_fd_sc_hd__nor3_1_2 r0 *1 0,0
Xsky130_fd_sc_hd__nor3_1_2 bus_addr[3] bus_addr[2] \_0756_ VGND VPWR VPWR
+ \_0757_ sky130_fd_sc_hd__nor3_1
* cell instance sky130_fd_sc_hd__nor3_1_3 r0 *1 0,0
Xsky130_fd_sc_hd__nor3_1_3 \_0002_ \_0743_ \_0784_ VGND VPWR VPWR \_1385_
+ sky130_fd_sc_hd__nor3_1
* cell instance sky130_fd_sc_hd__nor3_1_4 r0 *1 0,0
Xsky130_fd_sc_hd__nor3_1_4 al_apt al_rct al_startup VGND VPWR VPWR \_0199_
+ sky130_fd_sc_hd__nor3_1
* cell instance sky130_fd_sc_hd__nor3_1_5 r0 *1 0,0
Xsky130_fd_sc_hd__nor3_1_5 crc_state[30] net30 \_0537_ VGND VPWR VPWR \_1286_
+ sky130_fd_sc_hd__nor3_1
* cell instance sky130_fd_sc_hd__nor3_1_6 r0 *1 0,0
Xsky130_fd_sc_hd__nor3_1_6 crc_state[24] net30 \_0537_ VGND VPWR VPWR \_0563_
+ sky130_fd_sc_hd__nor3_1
* cell instance sky130_fd_sc_hd__nor3_1_7 r0 *1 0,0
Xsky130_fd_sc_hd__nor3_1_7 crc_state[23] net30 \_0537_ VGND VPWR VPWR \_0565_
+ sky130_fd_sc_hd__nor3_1
* cell instance sky130_fd_sc_hd__nor3_1_8 r0 *1 0,0
Xsky130_fd_sc_hd__nor3_1_8 net38 \_0747_ \_1344_ VGND VPWR VPWR \_1345_
+ sky130_fd_sc_hd__nor3_1
* cell instance sky130_fd_sc_hd__nor3_1_9 r0 *1 0,0
Xsky130_fd_sc_hd__nor3_1_9 crc_state[5] net30 \_0537_ VGND VPWR VPWR \_0603_
+ sky130_fd_sc_hd__nor3_1
* cell instance sky130_fd_sc_hd__nor3_1_10 r0 *1 0,0
Xsky130_fd_sc_hd__nor3_1_10 crc_state[29] net30 \_0537_ VGND VPWR VPWR \_0539_
+ sky130_fd_sc_hd__nor3_1
* cell instance sky130_fd_sc_hd__nor3_1_11 r0 *1 0,0
Xsky130_fd_sc_hd__nor3_1_11 crc_state[28] net30 \_0537_ VGND VPWR VPWR \_0550_
+ sky130_fd_sc_hd__nor3_1
* cell instance sky130_fd_sc_hd__nor3_1_12 r0 *1 0,0
Xsky130_fd_sc_hd__nor3_1_12 crc_state[26] net30 \_0537_ VGND VPWR VPWR \_0555_
+ sky130_fd_sc_hd__nor3_1
* cell instance sky130_fd_sc_hd__nor3_1_13 r0 *1 0,0
Xsky130_fd_sc_hd__nor3_1_13 crc_state[27] net30 \_0537_ VGND VPWR VPWR \_0553_
+ sky130_fd_sc_hd__nor3_1
* cell instance sky130_fd_sc_hd__nor3_1_14 r0 *1 0,0
Xsky130_fd_sc_hd__nor3_1_14 crc_state[8] net30 \_0537_ VGND VPWR VPWR \_0597_
+ sky130_fd_sc_hd__nor3_1
* cell instance sky130_fd_sc_hd__nor3_1_15 r0 *1 0,0
Xsky130_fd_sc_hd__nor3_1_15 crc_state[16] net30 \_0537_ VGND VPWR VPWR \_0581_
+ sky130_fd_sc_hd__nor3_1
* cell instance sky130_fd_sc_hd__nor3_1_16 r0 *1 0,0
Xsky130_fd_sc_hd__nor3_1_16 raw_level[0] raw_level[1] raw_level[2] VGND VPWR
+ VPWR \_0796_ sky130_fd_sc_hd__nor3_1
* cell instance sky130_fd_sc_hd__nor3_1_17 r0 *1 0,0
Xsky130_fd_sc_hd__nor3_1_17 crc_state[17] net30 \_0537_ VGND VPWR VPWR \_0579_
+ sky130_fd_sc_hd__nor3_1
* cell instance sky130_fd_sc_hd__nor3_1_18 r0 *1 0,0
Xsky130_fd_sc_hd__nor3_1_18 crc_state[12] net30 \_0537_ VGND VPWR VPWR \_0589_
+ sky130_fd_sc_hd__nor3_1
* cell instance sky130_fd_sc_hd__nor3_1_19 r0 *1 0,0
Xsky130_fd_sc_hd__nor3_1_19 net38 \_0745_ \_1337_ VGND VPWR VPWR \_1338_
+ sky130_fd_sc_hd__nor3_1
* cell instance sky130_fd_sc_hd__nor3_1_20 r0 *1 0,0
Xsky130_fd_sc_hd__nor3_1_20 crc_state[18] net30 \_0537_ VGND VPWR VPWR \_0577_
+ sky130_fd_sc_hd__nor3_1
* cell instance sky130_fd_sc_hd__nor3_1_21 r0 *1 0,0
Xsky130_fd_sc_hd__nor3_1_21 raw_count[4] raw_count[5] \_1412_ VGND VPWR VPWR
+ \_1413_ sky130_fd_sc_hd__nor3_1
* cell instance sky130_fd_sc_hd__nor3_1_22 r0 *1 0,0
Xsky130_fd_sc_hd__nor3_1_22 raw_count[1] raw_count[0] raw_count[2] VGND VPWR
+ VPWR \_1411_ sky130_fd_sc_hd__nor3_1
* cell instance sky130_fd_sc_hd__nor3_1_23 r0 *1 0,0
Xsky130_fd_sc_hd__nor3_1_23 \_1422_ \_1424_ \_0082_ VGND VPWR VPWR \_0083_
+ sky130_fd_sc_hd__nor3_1
* cell instance sky130_fd_sc_hd__nor3_1_24 r0 *1 0,0
Xsky130_fd_sc_hd__nor3_1_24 \_1422_ \_1424_ \_0062_ VGND VPWR VPWR \_0063_
+ sky130_fd_sc_hd__nor3_1
* cell instance sky130_fd_sc_hd__nor3_1_25 r0 *1 0,0
Xsky130_fd_sc_hd__nor3_1_25 crc_state[13] net30 \_0537_ VGND VPWR VPWR \_0587_
+ sky130_fd_sc_hd__nor3_1
* cell instance sky130_fd_sc_hd__nor3_1_26 r0 *1 0,0
Xsky130_fd_sc_hd__nor3_1_26 crc_state[14] net30 \_0537_ VGND VPWR VPWR \_0585_
+ sky130_fd_sc_hd__nor3_1
* cell instance sky130_fd_sc_hd__nor3_1_27 r0 *1 0,0
Xsky130_fd_sc_hd__nor3_1_27 crc_state[2] \_0220_ \_0537_ VGND VPWR VPWR \_0609_
+ sky130_fd_sc_hd__nor3_1
* cell instance sky130_fd_sc_hd__nor3_1_28 r0 *1 0,0
Xsky130_fd_sc_hd__nor3_1_28 cond_level[1] cond_level[0] cond_level[2] VGND VPWR
+ VPWR \_1070_ sky130_fd_sc_hd__nor3_1
* cell instance sky130_fd_sc_hd__nor3_1_29 r0 *1 0,0
Xsky130_fd_sc_hd__nor3_1_29 crc_state[19] net30 \_0537_ VGND VPWR VPWR \_0574_
+ sky130_fd_sc_hd__nor3_1
* cell instance sky130_fd_sc_hd__nor3_1_30 r0 *1 0,0
Xsky130_fd_sc_hd__nor3_1_30 \_0724_ net34 \_0726_ VGND VPWR VPWR \_0015_[1]
+ sky130_fd_sc_hd__nor3_1
* cell instance sky130_fd_sc_hd__nor3_1_31 r0 *1 0,0
Xsky130_fd_sc_hd__nor3_1_31 \_0097_ \_1422_ \_1424_ VGND VPWR VPWR \_0143_
+ sky130_fd_sc_hd__nor3_1
* cell instance sky130_fd_sc_hd__nor3_1_32 r0 *1 0,0
Xsky130_fd_sc_hd__nor3_1_32 cond_level[1] net40 \_0770_ VGND VPWR VPWR \_1074_
+ sky130_fd_sc_hd__nor3_1
* cell instance sky130_fd_sc_hd__nor3_1_33 r0 *1 0,0
Xsky130_fd_sc_hd__nor3_1_33 \_0722_ net34 \_0725_ VGND VPWR VPWR \_0015_[2]
+ sky130_fd_sc_hd__nor3_1
* cell instance sky130_fd_sc_hd__nor3_1_34 r0 *1 0,0
Xsky130_fd_sc_hd__nor3_1_34 \_0720_ net34 \_0723_ VGND VPWR VPWR \_0015_[3]
+ sky130_fd_sc_hd__nor3_1
* cell instance sky130_fd_sc_hd__nor3_1_35 r0 *1 0,0
Xsky130_fd_sc_hd__nor3_1_35 crc_state[20] net30 \_0537_ VGND VPWR VPWR \_0572_
+ sky130_fd_sc_hd__nor3_1
* cell instance sky130_fd_sc_hd__nor3_1_36 r0 *1 0,0
Xsky130_fd_sc_hd__nor3_1_36 raw_count[3] \_0119_ \_0154_ VGND VPWR VPWR \_0183_
+ sky130_fd_sc_hd__nor3_1
* cell instance sky130_fd_sc_hd__nor3_1_37 r0 *1 0,0
Xsky130_fd_sc_hd__nor3_1_37 \_1422_ \_1424_ \_0088_ VGND VPWR VPWR \_0089_
+ sky130_fd_sc_hd__nor3_1
* cell instance sky130_fd_sc_hd__nor3_1_38 r0 *1 0,0
Xsky130_fd_sc_hd__nor3_1_38 \_1420_ \_1422_ \_1424_ VGND VPWR VPWR \_1426_
+ sky130_fd_sc_hd__nor3_1
* cell instance sky130_fd_sc_hd__nor3_1_39 r0 *1 0,0
Xsky130_fd_sc_hd__nor3_1_39 net30 \_0537_ net39 VGND VPWR VPWR \_0615_
+ sky130_fd_sc_hd__nor3_1
* cell instance sky130_fd_sc_hd__nor3_1_40 r0 *1 0,0
Xsky130_fd_sc_hd__nor3_1_40 raw_count[3] \_0099_ \_0119_ VGND VPWR VPWR \_0120_
+ sky130_fd_sc_hd__nor3_1
* cell instance sky130_fd_sc_hd__nor3_1_41 r0 *1 0,0
Xsky130_fd_sc_hd__nor3_1_41 \_0540_ net34 \_0643_ VGND VPWR VPWR \_0006_[6]
+ sky130_fd_sc_hd__nor3_1
* cell instance sky130_fd_sc_hd__nor3_1_42 r0 *1 0,0
Xsky130_fd_sc_hd__nor3_1_42 \_0540_ net34 \_0632_ VGND VPWR VPWR \_0006_[10]
+ sky130_fd_sc_hd__nor3_1
* cell instance sky130_fd_sc_hd__nor3_1_43 r0 *1 0,0
Xsky130_fd_sc_hd__nor3_1_43 cond_count[8] cond_count[9] cond_count[10] VGND
+ VPWR VPWR \_0531_ sky130_fd_sc_hd__nor3_1
* cell instance sky130_fd_sc_hd__nor3_1_44 r0 *1 0,0
Xsky130_fd_sc_hd__nor3_1_44 \_0540_ net34 \_0639_ VGND VPWR VPWR \_0006_[7]
+ sky130_fd_sc_hd__nor3_1
* cell instance sky130_fd_sc_hd__nor3_1_45 r0 *1 0,0
Xsky130_fd_sc_hd__nor3_1_45 \_0202_ \_0204_ \_0205_ VGND VPWR VPWR \_0216_
+ sky130_fd_sc_hd__nor3_1
* cell instance sky130_fd_sc_hd__nor3_1_46 r0 *1 0,0
Xsky130_fd_sc_hd__nor3_1_46 \_0408_ \_0511_ \_0519_ VGND VPWR VPWR \_0026_[6]
+ sky130_fd_sc_hd__nor3_1
* cell instance sky130_fd_sc_hd__nor3_1_47 r0 *1 0,0
Xsky130_fd_sc_hd__nor3_1_47 \_0408_ \_0510_ \_0521_ VGND VPWR VPWR \_0026_[4]
+ sky130_fd_sc_hd__nor3_1
* cell instance sky130_fd_sc_hd__nor3_1_48 r0 *1 0,0
Xsky130_fd_sc_hd__nor3_1_48 \_0336_ net37 \_0416_ VGND VPWR VPWR \_1280_
+ sky130_fd_sc_hd__nor3_1
* cell instance sky130_fd_sc_hd__nor3_1_49 r0 *1 0,0
Xsky130_fd_sc_hd__nor3_1_49 \_0338_ net37 \_0416_ VGND VPWR VPWR \_0440_
+ sky130_fd_sc_hd__nor3_1
* cell instance sky130_fd_sc_hd__nor3_1_50 r0 *1 0,0
Xsky130_fd_sc_hd__nor3_1_50 \_0340_ net37 \_0416_ VGND VPWR VPWR \_0445_
+ sky130_fd_sc_hd__nor3_1
* cell instance sky130_fd_sc_hd__nor3_1_51 r0 *1 0,0
Xsky130_fd_sc_hd__nor3_1_51 \_0408_ \_0522_ \_0527_ VGND VPWR VPWR \_0026_[0]
+ sky130_fd_sc_hd__nor3_1
* cell instance sky130_fd_sc_hd__nor3_1_52 r0 *1 0,0
Xsky130_fd_sc_hd__nor3_1_52 \_0408_ \_0523_ \_0525_ VGND VPWR VPWR \_0026_[2]
+ sky130_fd_sc_hd__nor3_1
* cell instance sky130_fd_sc_hd__nor3_1_53 r0 *1 0,0
Xsky130_fd_sc_hd__nor3_1_53 apt_index[12] apt_index[11] apt_index[10] VGND VPWR
+ VPWR \_0351_ sky130_fd_sc_hd__nor3_1
* cell instance sky130_fd_sc_hd__nor3_1_54 r0 *1 0,0
Xsky130_fd_sc_hd__nor3_1_54 \_0304_ \_0309_ \_0395_ VGND VPWR VPWR \_0396_
+ sky130_fd_sc_hd__nor3_1
* cell instance sky130_fd_sc_hd__nor3_1_55 r0 *1 0,0
Xsky130_fd_sc_hd__nor3_1_55 \_0408_ \_0410_ \_0425_ VGND VPWR VPWR \_0003_[9]
+ sky130_fd_sc_hd__nor3_1
* cell instance sky130_fd_sc_hd__nor3_1_56 r0 *1 0,0
Xsky130_fd_sc_hd__nor3_1_56 \_0306_ \_0307_ \_0309_ VGND VPWR VPWR \_0310_
+ sky130_fd_sc_hd__nor3_1
* cell instance sky130_fd_sc_hd__nor3_1_57 r0 *1 0,0
Xsky130_fd_sc_hd__nor3_1_57 \_0408_ \_0432_ \_0435_ VGND VPWR VPWR \_0003_[2]
+ sky130_fd_sc_hd__nor3_1
* cell instance sky130_fd_sc_hd__nor3_1_58 r0 *1 0,0
Xsky130_fd_sc_hd__nor3_1_58 \_0305_ \_0309_ \_0389_ VGND VPWR VPWR \_0390_
+ sky130_fd_sc_hd__nor3_1
* cell instance sky130_fd_sc_hd__nor3_1_59 r0 *1 0,0
Xsky130_fd_sc_hd__nor3_1_59 \_0363_ \_0364_ \_0365_ VGND VPWR VPWR \_0366_
+ sky130_fd_sc_hd__nor3_1
* cell instance sky130_fd_sc_hd__nor3_1_60 r0 *1 0,0
Xsky130_fd_sc_hd__nor3_1_60 \_0408_ \_0424_ \_0426_ VGND VPWR VPWR \_0003_[8]
+ sky130_fd_sc_hd__nor3_1
* cell instance sky130_fd_sc_hd__nor3_1_61 r0 *1 0,0
Xsky130_fd_sc_hd__nor3_1_61 \_0408_ \_0421_ \_0433_ VGND VPWR VPWR \_0003_[3]
+ sky130_fd_sc_hd__nor3_1
* cell instance sky130_fd_sc_hd__nor3_1_62 r0 *1 0,0
Xsky130_fd_sc_hd__nor3_1_62 \_0408_ \_0423_ \_0428_ VGND VPWR VPWR \_0003_[6]
+ sky130_fd_sc_hd__nor3_1
* cell instance sky130_fd_sc_hd__nor3_1_63 r0 *1 0,0
Xsky130_fd_sc_hd__nor3_1_63 \_0408_ \_0422_ \_0429_ VGND VPWR VPWR \_0003_[5]
+ sky130_fd_sc_hd__nor3_1
* cell instance sky130_fd_sc_hd__nor3b_1_0 r0 *1 0,0
Xsky130_fd_sc_hd__nor3b_1_0 raw_count[0] raw_count[2] raw_count[1] VGND VPWR
+ VPWR \_0080_ sky130_fd_sc_hd__nor3b_1
* cell instance sky130_fd_sc_hd__nor3b_1_1 r0 *1 0,0
Xsky130_fd_sc_hd__nor3b_1_1 cond_level[1] cond_level[0] cond_level[2] VGND VPWR
+ VPWR \_0744_ sky130_fd_sc_hd__nor3b_1
* cell instance sky130_fd_sc_hd__nor3b_1_2 r0 *1 0,0
Xsky130_fd_sc_hd__nor3b_1_2 raw_count[1] raw_count[2] raw_count[0] VGND VPWR
+ VPWR \_0086_ sky130_fd_sc_hd__nor3b_1
* cell instance sky130_fd_sc_hd__nor3b_1_3 r0 *1 0,0
Xsky130_fd_sc_hd__nor3b_1_3 \_0332_ \_0357_ apt_matches[9] VGND VPWR VPWR
+ \_0358_ sky130_fd_sc_hd__nor3b_1
* cell instance sky130_fd_sc_hd__nor3b_1_4 r0 *1 0,0
Xsky130_fd_sc_hd__nor3b_1_4 \_0413_ \_0408_ \_0411_ VGND VPWR VPWR \_0003_[11]
+ sky130_fd_sc_hd__nor3b_1
* cell instance sky130_fd_sc_hd__nor4_1_0 r0 *1 0,0
Xsky130_fd_sc_hd__nor4_1_0 bus_addr[0] bus_addr[1] bus_addr[3] bus_addr[2] VGND
+ VPWR VPWR \_0290_ sky130_fd_sc_hd__nor4_1
* cell instance sky130_fd_sc_hd__nor4_1_1 r0 *1 0,0
Xsky130_fd_sc_hd__nor4_1_1 raw_count[1] raw_count[0] raw_count[2] raw_count[3]
+ VGND VPWR VPWR \_1416_ sky130_fd_sc_hd__nor4_1
* cell instance sky130_fd_sc_hd__nor4_1_2 r0 *1 0,0
Xsky130_fd_sc_hd__nor4_1_2 raw_count[2] \_0074_ \_1422_ \_1424_ VGND VPWR VPWR
+ \_0077_ sky130_fd_sc_hd__nor4_1
* cell instance sky130_fd_sc_hd__nor4_1_3 r0 *1 0,0
Xsky130_fd_sc_hd__nor4_1_3 \_0540_ net34 \_0640_ \_0648_ VGND VPWR VPWR
+ \_0006_[1] sky130_fd_sc_hd__nor4_1
* cell instance sky130_fd_sc_hd__nor4_1_4 r0 *1 0,0
Xsky130_fd_sc_hd__nor4_1_4 \_0540_ net34 \_0631_ \_0633_ VGND VPWR VPWR
+ \_0006_[9] sky130_fd_sc_hd__nor4_1
* cell instance sky130_fd_sc_hd__nor4_1_5 r0 *1 0,0
Xsky130_fd_sc_hd__nor4_1_5 \_0540_ net34 \_0641_ \_0646_ VGND VPWR VPWR
+ \_0006_[3] sky130_fd_sc_hd__nor4_1
* cell instance sky130_fd_sc_hd__nor4_1_6 r0 *1 0,0
Xsky130_fd_sc_hd__nor4_1_6 \_0202_ \_0203_ \_0204_ \_0205_ VGND VPWR VPWR
+ \_0206_ sky130_fd_sc_hd__nor4_1
* cell instance sky130_fd_sc_hd__nor4_1_7 r0 *1 0,0
Xsky130_fd_sc_hd__nor4_1_7 cond_count[9] cond_count[10] cond_count[12] \_0217_
+ VGND VPWR VPWR \_0218_ sky130_fd_sc_hd__nor4_1
* cell instance sky130_fd_sc_hd__nor4_1_8 r0 *1 0,0
Xsky130_fd_sc_hd__nor4_1_8 \_0497_ \_0507_ \_0739_ \_0740_ VGND VPWR VPWR
+ \_0741_ sky130_fd_sc_hd__nor4_1
* cell instance sky130_fd_sc_hd__nor4_1_9 r0 *1 0,0
Xsky130_fd_sc_hd__nor4_1_9 rct_count[11] rct_count[10] rct_count[7]
+ rct_count[15] VGND VPWR VPWR \_0314_ sky130_fd_sc_hd__nor4_1
* cell instance sky130_fd_sc_hd__nor4_1_10 r0 *1 0,0
Xsky130_fd_sc_hd__nor4_1_10 apt_index[0] apt_index[15] apt_index[3] \_0353_
+ VGND VPWR VPWR \_0439_ sky130_fd_sc_hd__nor4_1
* cell instance sky130_fd_sc_hd__nor4_1_11 r0 *1 0,0
Xsky130_fd_sc_hd__nor4_1_11 apt_index[1] apt_index[5] apt_index[4] apt_index[2]
+ VGND VPWR VPWR \_0352_ sky130_fd_sc_hd__nor4_1
* cell instance sky130_fd_sc_hd__nor4_1_12 r0 *1 0,0
Xsky130_fd_sc_hd__nor4_1_12 \_0369_ \_0364_ \_0370_ \_0371_ VGND VPWR VPWR
+ \_0372_ sky130_fd_sc_hd__nor4_1
* cell instance sky130_fd_sc_hd__nor4_1_13 r0 *1 0,0
Xsky130_fd_sc_hd__nor4_1_13 apt_index[8] apt_index[7] apt_index[9] apt_index[6]
+ VGND VPWR VPWR \_0350_ sky130_fd_sc_hd__nor4_1
* cell instance sky130_fd_sc_hd__nor4_1_14 r0 *1 0,0
Xsky130_fd_sc_hd__nor4_1_14 rct_count[14] rct_count[12] \_0306_ \_0315_ VGND
+ VPWR VPWR \_0316_ sky130_fd_sc_hd__nor4_1
* cell instance sky130_fd_sc_hd__nor4b_1_0 r0 *1 0,0
Xsky130_fd_sc_hd__nor4b_1_0 \_0002_ \_0743_ \_0784_ \_0786_ VGND VPWR VPWR
+ \_0787_ sky130_fd_sc_hd__nor4b_1
* cell instance sky130_fd_sc_hd__nor4b_1_1 r0 *1 0,0
Xsky130_fd_sc_hd__nor4b_1_1 bus_addr[0] bus_addr[1] bus_addr[3] bus_we VGND
+ VPWR VPWR \_0298_ sky130_fd_sc_hd__nor4b_1
* cell instance sky130_fd_sc_hd__o211a_1_0 r0 *1 0,0
Xsky130_fd_sc_hd__o211a_1_0 \_0337_ \_0339_ \_0340_ \_0361_ VGND VPWR VPWR
+ \_0362_ sky130_fd_sc_hd__o211a_1
* cell instance sky130_fd_sc_hd__o211ai_1_0 r0 *1 0,0
Xsky130_fd_sc_hd__o211ai_1_0 \_0729_ \_0731_ \_1317_ \_1382_ VGND VPWR VPWR
+ \_1383_ sky130_fd_sc_hd__o211ai_1
* cell instance sky130_fd_sc_hd__o211ai_1_1 r0 *1 0,0
Xsky130_fd_sc_hd__o211ai_1_1 \_0731_ \_0736_ \_1317_ \_1387_ VGND VPWR VPWR
+ \_1388_ sky130_fd_sc_hd__o211ai_1
* cell instance sky130_fd_sc_hd__o211ai_1_2 r0 *1 0,0
Xsky130_fd_sc_hd__o211ai_1_2 \_1077_ \_1118_ \_1340_ \_1341_ VGND VPWR VPWR
+ \_0042_ sky130_fd_sc_hd__o211ai_1
* cell instance sky130_fd_sc_hd__o211ai_1_3 r0 *1 0,0
Xsky130_fd_sc_hd__o211ai_1_3 \_0343_ \_0344_ \_0345_ \_0355_ VGND VPWR VPWR
+ \_0356_ sky130_fd_sc_hd__o211ai_1
* cell instance sky130_fd_sc_hd__o211ai_1_4 r0 *1 0,0
Xsky130_fd_sc_hd__o211ai_1_4 rct_count[3] \_0304_ \_0323_ \_0381_ VGND VPWR
+ VPWR \_0394_ sky130_fd_sc_hd__o211ai_1
* cell instance sky130_fd_sc_hd__o21a_1_0 r0 *1 0,0
Xsky130_fd_sc_hd__o21a_1_0 net29 \_0266_ \_0267_ VGND VPWR VPWR \_0268_
+ sky130_fd_sc_hd__o21a_1
* cell instance sky130_fd_sc_hd__o21a_1_1 r0 *1 0,0
Xsky130_fd_sc_hd__o21a_1_1 net29 \_0256_ \_0257_ VGND VPWR VPWR \_0258_
+ sky130_fd_sc_hd__o21a_1
* cell instance sky130_fd_sc_hd__o21a_1_2 r0 *1 0,0
Xsky130_fd_sc_hd__o21a_1_2 net29 \_0233_ \_0234_ VGND VPWR VPWR \_0235_
+ sky130_fd_sc_hd__o21a_1
* cell instance sky130_fd_sc_hd__o21a_1_3 r0 *1 0,0
Xsky130_fd_sc_hd__o21a_1_3 net29 \_0286_ \_0287_ VGND VPWR VPWR \_0288_
+ sky130_fd_sc_hd__o21a_1
* cell instance sky130_fd_sc_hd__o21a_1_4 r0 *1 0,0
Xsky130_fd_sc_hd__o21a_1_4 net23 \_0959_ \_0962_ VGND VPWR VPWR \_0017_[0]
+ sky130_fd_sc_hd__o21a_1
* cell instance sky130_fd_sc_hd__o21a_1_5 r0 *1 0,0
Xsky130_fd_sc_hd__o21a_1_5 net29 \_0273_ \_0274_ VGND VPWR VPWR \_0275_
+ sky130_fd_sc_hd__o21a_1
* cell instance sky130_fd_sc_hd__o21a_1_6 r0 *1 0,0
Xsky130_fd_sc_hd__o21a_1_6 net29 \_0250_ \_0251_ VGND VPWR VPWR \_0252_
+ sky130_fd_sc_hd__o21a_1
* cell instance sky130_fd_sc_hd__o21a_1_7 r0 *1 0,0
Xsky130_fd_sc_hd__o21a_1_7 net29 \_0276_ \_0277_ VGND VPWR VPWR \_0278_
+ sky130_fd_sc_hd__o21a_1
* cell instance sky130_fd_sc_hd__o21a_1_8 r0 *1 0,0
Xsky130_fd_sc_hd__o21a_1_8 net29 \_0269_ \_0270_ VGND VPWR VPWR \_0271_
+ sky130_fd_sc_hd__o21a_1
* cell instance sky130_fd_sc_hd__o21a_1_9 r0 *1 0,0
Xsky130_fd_sc_hd__o21a_1_9 raw_count[4] \_0720_ \_0721_ VGND VPWR VPWR
+ \_0015_[4] sky130_fd_sc_hd__o21a_1
* cell instance sky130_fd_sc_hd__o21a_1_10 r0 *1 0,0
Xsky130_fd_sc_hd__o21a_1_10 net29 \_0259_ \_0260_ VGND VPWR VPWR \_0261_
+ sky130_fd_sc_hd__o21a_1
* cell instance sky130_fd_sc_hd__o21a_1_11 r0 *1 0,0
Xsky130_fd_sc_hd__o21a_1_11 net29 \_0262_ \_0263_ VGND VPWR VPWR \_0264_
+ sky130_fd_sc_hd__o21a_1
* cell instance sky130_fd_sc_hd__o21a_1_12 r0 *1 0,0
Xsky130_fd_sc_hd__o21a_1_12 \_0129_ \_0154_ \_0191_ VGND VPWR VPWR \_0192_
+ sky130_fd_sc_hd__o21a_1
* cell instance sky130_fd_sc_hd__o21a_1_13 r0 *1 0,0
Xsky130_fd_sc_hd__o21a_1_13 \_0703_ \_0704_ \_0705_ VGND VPWR VPWR \_0022_[7]
+ sky130_fd_sc_hd__o21a_1
* cell instance sky130_fd_sc_hd__o21a_1_14 r0 *1 0,0
Xsky130_fd_sc_hd__o21a_1_14 \_0134_ \_0154_ \_0194_ VGND VPWR VPWR \_0195_
+ sky130_fd_sc_hd__o21a_1
* cell instance sky130_fd_sc_hd__o21a_1_15 r0 *1 0,0
Xsky130_fd_sc_hd__o21a_1_15 net29 \_0283_ \_0284_ VGND VPWR VPWR \_0285_
+ sky130_fd_sc_hd__o21a_1
* cell instance sky130_fd_sc_hd__o21a_1_16 r0 *1 0,0
Xsky130_fd_sc_hd__o21a_1_16 net29 \_0242_ \_0243_ VGND VPWR VPWR \_0244_
+ sky130_fd_sc_hd__o21a_1
* cell instance sky130_fd_sc_hd__o21a_1_17 r0 *1 0,0
Xsky130_fd_sc_hd__o21a_1_17 net29 \_0280_ \_0281_ VGND VPWR VPWR \_0282_
+ sky130_fd_sc_hd__o21a_1
* cell instance sky130_fd_sc_hd__o21a_1_18 r0 *1 0,0
Xsky130_fd_sc_hd__o21a_1_18 net29 \_0239_ \_0240_ VGND VPWR VPWR \_0241_
+ sky130_fd_sc_hd__o21a_1
* cell instance sky130_fd_sc_hd__o21ai_0_0 r0 *1 0,0
Xsky130_fd_sc_hd__o21ai_0_0 net23 \_0918_ \_1020_ VGND VPWR VPWR \_0018_[8]
+ sky130_fd_sc_hd__o21ai_0
* cell instance sky130_fd_sc_hd__o21ai_0_1 r0 *1 0,0
Xsky130_fd_sc_hd__o21ai_0_1 net23 \_0980_ \_1052_ VGND VPWR VPWR \_0019_[25]
+ sky130_fd_sc_hd__o21ai_0
* cell instance sky130_fd_sc_hd__o21ai_0_2 r0 *1 0,0
Xsky130_fd_sc_hd__o21ai_0_2 \_0169_ net33 \_1018_ VGND VPWR VPWR \_1019_
+ sky130_fd_sc_hd__o21ai_0
* cell instance sky130_fd_sc_hd__o21ai_0_3 r0 *1 0,0
Xsky130_fd_sc_hd__o21ai_0_3 net23 \_0992_ \_1059_ VGND VPWR VPWR \_0019_[19]
+ sky130_fd_sc_hd__o21ai_0
* cell instance sky130_fd_sc_hd__o21ai_0_4 r0 *1 0,0
Xsky130_fd_sc_hd__o21ai_0_4 net32 \_0169_ \_0170_ VGND VPWR VPWR \_0020_[8]
+ sky130_fd_sc_hd__o21ai_0
* cell instance sky130_fd_sc_hd__o21ai_0_5 r0 *1 0,0
Xsky130_fd_sc_hd__o21ai_0_5 net32 \_0090_ \_0091_ VGND VPWR VPWR \_0020_[25]
+ sky130_fd_sc_hd__o21ai_0
* cell instance sky130_fd_sc_hd__o21ai_0_6 r0 *1 0,0
Xsky130_fd_sc_hd__o21ai_0_6 net23 \_0970_ \_1048_ VGND VPWR VPWR \_0019_[29]
+ sky130_fd_sc_hd__o21ai_0
* cell instance sky130_fd_sc_hd__o21ai_0_7 r0 *1 0,0
Xsky130_fd_sc_hd__o21ai_0_7 \_0811_ \_0916_ \_1363_ VGND VPWR VPWR \_1364_
+ sky130_fd_sc_hd__o21ai_0
* cell instance sky130_fd_sc_hd__o21ai_0_8 r0 *1 0,0
Xsky130_fd_sc_hd__o21ai_0_8 \_1077_ \_1147_ \_1365_ VGND VPWR VPWR \_0051_
+ sky130_fd_sc_hd__o21ai_0
* cell instance sky130_fd_sc_hd__o21ai_0_9 r0 *1 0,0
Xsky130_fd_sc_hd__o21ai_0_9 net32 \_0064_ \_0066_ VGND VPWR VPWR \_0020_[29]
+ sky130_fd_sc_hd__o21ai_0
* cell instance sky130_fd_sc_hd__o21ai_0_10 r0 *1 0,0
Xsky130_fd_sc_hd__o21ai_0_10 net23 \_0897_ \_1010_ VGND VPWR VPWR \_0018_[12]
+ sky130_fd_sc_hd__o21ai_0
* cell instance sky130_fd_sc_hd__o21ai_0_11 r0 *1 0,0
Xsky130_fd_sc_hd__o21ai_0_11 net32 \_0126_ \_0127_ VGND VPWR VPWR \_0020_[19]
+ sky130_fd_sc_hd__o21ai_0
* cell instance sky130_fd_sc_hd__o21ai_0_12 r0 *1 0,0
Xsky130_fd_sc_hd__o21ai_0_12 net23 \_0982_ \_1054_ VGND VPWR VPWR \_0019_[24]
+ sky130_fd_sc_hd__o21ai_0
* cell instance sky130_fd_sc_hd__o21ai_0_13 r0 *1 0,0
Xsky130_fd_sc_hd__o21ai_0_13 net32 \_0157_ \_0158_ VGND VPWR VPWR \_0020_[12]
+ sky130_fd_sc_hd__o21ai_0
* cell instance sky130_fd_sc_hd__o21ai_0_14 r0 *1 0,0
Xsky130_fd_sc_hd__o21ai_0_14 \_0157_ net33 \_1008_ VGND VPWR VPWR \_1009_
+ sky130_fd_sc_hd__o21ai_0
* cell instance sky130_fd_sc_hd__o21ai_0_15 r0 *1 0,0
Xsky130_fd_sc_hd__o21ai_0_15 \_1077_ \_1131_ \_1352_ VGND VPWR VPWR \_0047_
+ sky130_fd_sc_hd__o21ai_0
* cell instance sky130_fd_sc_hd__o21ai_0_16 r0 *1 0,0
Xsky130_fd_sc_hd__o21ai_0_16 \_0157_ \_0797_ \_0898_ VGND VPWR VPWR \_0899_
+ sky130_fd_sc_hd__o21ai_0
* cell instance sky130_fd_sc_hd__o21ai_0_17 r0 *1 0,0
Xsky130_fd_sc_hd__o21ai_0_17 net32 \_0095_ \_0096_ VGND VPWR VPWR \_0020_[24]
+ sky130_fd_sc_hd__o21ai_0
* cell instance sky130_fd_sc_hd__o21ai_0_18 r0 *1 0,0
Xsky130_fd_sc_hd__o21ai_0_18 \_1077_ \_1161_ \_1378_ VGND VPWR VPWR \_0055_
+ sky130_fd_sc_hd__o21ai_0
* cell instance sky130_fd_sc_hd__o21ai_0_19 r0 *1 0,0
Xsky130_fd_sc_hd__o21ai_0_19 net23 \_0933_ \_1030_ VGND VPWR VPWR \_0018_[5]
+ sky130_fd_sc_hd__o21ai_0
* cell instance sky130_fd_sc_hd__o21ai_0_20 r0 *1 0,0
Xsky130_fd_sc_hd__o21ai_0_20 cond_mem[1][26] net27 \_1093_ VGND VPWR VPWR
+ \_1094_ sky130_fd_sc_hd__o21ai_0
* cell instance sky130_fd_sc_hd__o21ai_0_21 r0 *1 0,0
Xsky130_fd_sc_hd__o21ai_0_21 \_0181_ net33 \_1028_ VGND VPWR VPWR \_1029_
+ sky130_fd_sc_hd__o21ai_0
* cell instance sky130_fd_sc_hd__o21ai_0_22 r0 *1 0,0
Xsky130_fd_sc_hd__o21ai_0_22 net23 \_0928_ \_1027_ VGND VPWR VPWR \_0018_[6]
+ sky130_fd_sc_hd__o21ai_0
* cell instance sky130_fd_sc_hd__o21ai_0_23 r0 *1 0,0
Xsky130_fd_sc_hd__o21ai_0_23 net23 \_0978_ \_1051_ VGND VPWR VPWR \_0019_[26]
+ sky130_fd_sc_hd__o21ai_0
* cell instance sky130_fd_sc_hd__o21ai_0_24 r0 *1 0,0
Xsky130_fd_sc_hd__o21ai_0_24 net32 \_0181_ \_0182_ VGND VPWR VPWR \_0020_[5]
+ sky130_fd_sc_hd__o21ai_0
* cell instance sky130_fd_sc_hd__o21ai_0_25 r0 *1 0,0
Xsky130_fd_sc_hd__o21ai_0_25 \_0181_ \_0797_ \_0934_ VGND VPWR VPWR \_0935_
+ sky130_fd_sc_hd__o21ai_0
* cell instance sky130_fd_sc_hd__o21ai_0_26 r0 *1 0,0
Xsky130_fd_sc_hd__o21ai_0_26 net32 \_0177_ \_0178_ VGND VPWR VPWR \_0020_[6]
+ sky130_fd_sc_hd__o21ai_0
* cell instance sky130_fd_sc_hd__o21ai_0_27 r0 *1 0,0
Xsky130_fd_sc_hd__o21ai_0_27 \_0177_ net33 \_1025_ VGND VPWR VPWR \_1026_
+ sky130_fd_sc_hd__o21ai_0
* cell instance sky130_fd_sc_hd__o21ai_0_28 r0 *1 0,0
Xsky130_fd_sc_hd__o21ai_0_28 \_1077_ \_1128_ \_1350_ VGND VPWR VPWR \_0046_
+ sky130_fd_sc_hd__o21ai_0
* cell instance sky130_fd_sc_hd__o21ai_0_29 r0 *1 0,0
Xsky130_fd_sc_hd__o21ai_0_29 \_1077_ \_1157_ \_1373_ VGND VPWR VPWR \_0054_
+ sky130_fd_sc_hd__o21ai_0
* cell instance sky130_fd_sc_hd__o21ai_0_30 r0 *1 0,0
Xsky130_fd_sc_hd__o21ai_0_30 \_0177_ \_0797_ \_0929_ VGND VPWR VPWR \_0930_
+ sky130_fd_sc_hd__o21ai_0
* cell instance sky130_fd_sc_hd__o21ai_0_31 r0 *1 0,0
Xsky130_fd_sc_hd__o21ai_0_31 \_1077_ \_1154_ \_1369_ VGND VPWR VPWR \_0053_
+ sky130_fd_sc_hd__o21ai_0
* cell instance sky130_fd_sc_hd__o21ai_0_32 r0 *1 0,0
Xsky130_fd_sc_hd__o21ai_0_32 net32 \_0084_ \_0085_ VGND VPWR VPWR \_0020_[26]
+ sky130_fd_sc_hd__o21ai_0
* cell instance sky130_fd_sc_hd__o21ai_0_33 r0 *1 0,0
Xsky130_fd_sc_hd__o21ai_0_33 \_0730_ \_1336_ \_1317_ VGND VPWR VPWR \_1367_
+ sky130_fd_sc_hd__o21ai_0
* cell instance sky130_fd_sc_hd__o21ai_0_34 r0 *1 0,0
Xsky130_fd_sc_hd__o21ai_0_34 net23 \_0892_ \_1007_ VGND VPWR VPWR \_0018_[13]
+ sky130_fd_sc_hd__o21ai_0
* cell instance sky130_fd_sc_hd__o21ai_0_35 r0 *1 0,0
Xsky130_fd_sc_hd__o21ai_0_35 \_0002_ \_0784_ \_1343_ VGND VPWR VPWR \_1370_
+ sky130_fd_sc_hd__o21ai_0
* cell instance sky130_fd_sc_hd__o21ai_0_36 r0 *1 0,0
Xsky130_fd_sc_hd__o21ai_0_36 \_0151_ \_0797_ \_0893_ VGND VPWR VPWR \_0894_
+ sky130_fd_sc_hd__o21ai_0
* cell instance sky130_fd_sc_hd__o21ai_0_37 r0 *1 0,0
Xsky130_fd_sc_hd__o21ai_0_37 \_0151_ net33 \_1005_ VGND VPWR VPWR \_1006_
+ sky130_fd_sc_hd__o21ai_0
* cell instance sky130_fd_sc_hd__o21ai_0_38 r0 *1 0,0
Xsky130_fd_sc_hd__o21ai_0_38 net32 \_0151_ \_0153_ VGND VPWR VPWR \_0020_[13]
+ sky130_fd_sc_hd__o21ai_0
* cell instance sky130_fd_sc_hd__o21ai_0_39 r0 *1 0,0
Xsky130_fd_sc_hd__o21ai_0_39 \_0185_ \_0797_ \_0939_ VGND VPWR VPWR \_0940_
+ sky130_fd_sc_hd__o21ai_0
* cell instance sky130_fd_sc_hd__o21ai_0_40 r0 *1 0,0
Xsky130_fd_sc_hd__o21ai_0_40 \_1077_ \_1167_ \_1384_ VGND VPWR VPWR \_0057_
+ sky130_fd_sc_hd__o21ai_0
* cell instance sky130_fd_sc_hd__o21ai_0_41 r0 *1 0,0
Xsky130_fd_sc_hd__o21ai_0_41 net23 \_0961_ \_1045_ VGND VPWR VPWR \_0018_[0]
+ sky130_fd_sc_hd__o21ai_0
* cell instance sky130_fd_sc_hd__o21ai_0_42 r0 *1 0,0
Xsky130_fd_sc_hd__o21ai_0_42 \_0197_ \_0797_ \_0958_ VGND VPWR VPWR \_0959_
+ sky130_fd_sc_hd__o21ai_0
* cell instance sky130_fd_sc_hd__o21ai_0_43 r0 *1 0,0
Xsky130_fd_sc_hd__o21ai_0_43 net23 \_0938_ \_1033_ VGND VPWR VPWR \_0018_[4]
+ sky130_fd_sc_hd__o21ai_0
* cell instance sky130_fd_sc_hd__o21ai_0_44 r0 *1 0,0
Xsky130_fd_sc_hd__o21ai_0_44 \_0731_ \_0734_ \_1390_ VGND VPWR VPWR \_1391_
+ sky130_fd_sc_hd__o21ai_0
* cell instance sky130_fd_sc_hd__o21ai_0_45 r0 *1 0,0
Xsky130_fd_sc_hd__o21ai_0_45 bus_addr[2] bus_wdata[2] \_0298_ VGND VPWR VPWR
+ \_0733_ sky130_fd_sc_hd__o21ai_0
* cell instance sky130_fd_sc_hd__o21ai_0_46 r0 *1 0,0
Xsky130_fd_sc_hd__o21ai_0_46 \_0197_ net33 \_1043_ VGND VPWR VPWR \_1044_
+ sky130_fd_sc_hd__o21ai_0
* cell instance sky130_fd_sc_hd__o21ai_0_47 r0 *1 0,0
Xsky130_fd_sc_hd__o21ai_0_47 net32 \_0197_ \_0198_ VGND VPWR VPWR \_0020_[0]
+ sky130_fd_sc_hd__o21ai_0
* cell instance sky130_fd_sc_hd__o21ai_0_48 r0 *1 0,0
Xsky130_fd_sc_hd__o21ai_0_48 al_startup \_0728_ \_0299_ VGND VPWR VPWR \_0729_
+ sky130_fd_sc_hd__o21ai_0
* cell instance sky130_fd_sc_hd__o21ai_0_49 r0 *1 0,0
Xsky130_fd_sc_hd__o21ai_0_49 net23 \_0998_ \_1062_ VGND VPWR VPWR \_0019_[16]
+ sky130_fd_sc_hd__o21ai_0
* cell instance sky130_fd_sc_hd__o21ai_0_50 r0 *1 0,0
Xsky130_fd_sc_hd__o21ai_0_50 \_1285_ \_1286_ net25 VGND VPWR VPWR \_0013_[31]
+ sky130_fd_sc_hd__o21ai_0
* cell instance sky130_fd_sc_hd__o21ai_0_51 r0 *1 0,0
Xsky130_fd_sc_hd__o21ai_0_51 \_0529_ \_0539_ net25 VGND VPWR VPWR \_0013_[30]
+ sky130_fd_sc_hd__o21ai_0
* cell instance sky130_fd_sc_hd__o21ai_0_52 r0 *1 0,0
Xsky130_fd_sc_hd__o21ai_0_52 \_0562_ \_0563_ net25 VGND VPWR VPWR \_0013_[25]
+ sky130_fd_sc_hd__o21ai_0
* cell instance sky130_fd_sc_hd__o21ai_0_53 r0 *1 0,0
Xsky130_fd_sc_hd__o21ai_0_53 \_0564_ \_0565_ net25 VGND VPWR VPWR \_0013_[24]
+ sky130_fd_sc_hd__o21ai_0
* cell instance sky130_fd_sc_hd__o21ai_0_54 r0 *1 0,0
Xsky130_fd_sc_hd__o21ai_0_54 \_0185_ net33 \_1031_ VGND VPWR VPWR \_1032_
+ sky130_fd_sc_hd__o21ai_0
* cell instance sky130_fd_sc_hd__o21ai_0_55 r0 *1 0,0
Xsky130_fd_sc_hd__o21ai_0_55 net23 \_0949_ \_1039_ VGND VPWR VPWR \_0018_[2]
+ sky130_fd_sc_hd__o21ai_0
* cell instance sky130_fd_sc_hd__o21ai_0_56 r0 *1 0,0
Xsky130_fd_sc_hd__o21ai_0_56 net32 \_0185_ \_0186_ VGND VPWR VPWR \_0020_[4]
+ sky130_fd_sc_hd__o21ai_0
* cell instance sky130_fd_sc_hd__o21ai_0_57 r0 *1 0,0
Xsky130_fd_sc_hd__o21ai_0_57 \_0192_ \_0797_ \_0950_ VGND VPWR VPWR \_0951_
+ sky130_fd_sc_hd__o21ai_0
* cell instance sky130_fd_sc_hd__o21ai_0_58 r0 *1 0,0
Xsky130_fd_sc_hd__o21ai_0_58 net32 \_0139_ \_0140_ VGND VPWR VPWR \_0020_[16]
+ sky130_fd_sc_hd__o21ai_0
* cell instance sky130_fd_sc_hd__o21ai_0_59 r0 *1 0,0
Xsky130_fd_sc_hd__o21ai_0_59 \_0760_ \_1344_ \_1380_ VGND VPWR VPWR \_0056_
+ sky130_fd_sc_hd__o21ai_0
* cell instance sky130_fd_sc_hd__o21ai_0_60 r0 *1 0,0
Xsky130_fd_sc_hd__o21ai_0_60 \_0192_ net33 \_1037_ VGND VPWR VPWR \_1038_
+ sky130_fd_sc_hd__o21ai_0
* cell instance sky130_fd_sc_hd__o21ai_0_61 r0 *1 0,0
Xsky130_fd_sc_hd__o21ai_0_61 \_0602_ \_0603_ net25 VGND VPWR VPWR \_0013_[6]
+ sky130_fd_sc_hd__o21ai_0
* cell instance sky130_fd_sc_hd__o21ai_0_62 r0 *1 0,0
Xsky130_fd_sc_hd__o21ai_0_62 net32 \_0192_ \_0193_ VGND VPWR VPWR \_0020_[2]
+ sky130_fd_sc_hd__o21ai_0
* cell instance sky130_fd_sc_hd__o21ai_0_63 r0 *1 0,0
Xsky130_fd_sc_hd__o21ai_0_63 \_1077_ \_1144_ \_1361_ VGND VPWR VPWR \_0050_
+ sky130_fd_sc_hd__o21ai_0
* cell instance sky130_fd_sc_hd__o21ai_0_64 r0 *1 0,0
Xsky130_fd_sc_hd__o21ai_0_64 net32 \_1292_ \_1293_ VGND VPWR VPWR \_0020_[31]
+ sky130_fd_sc_hd__o21ai_0
* cell instance sky130_fd_sc_hd__o21ai_0_65 r0 *1 0,0
Xsky130_fd_sc_hd__o21ai_0_65 \_0552_ \_0553_ net25 VGND VPWR VPWR \_0013_[28]
+ sky130_fd_sc_hd__o21ai_0
* cell instance sky130_fd_sc_hd__o21ai_0_66 r0 *1 0,0
Xsky130_fd_sc_hd__o21ai_0_66 \_0166_ net33 \_1015_ VGND VPWR VPWR \_1016_
+ sky130_fd_sc_hd__o21ai_0
* cell instance sky130_fd_sc_hd__o21ai_0_67 r0 *1 0,0
Xsky130_fd_sc_hd__o21ai_0_67 net24 \_1301_ \_1302_ VGND VPWR VPWR \_0019_[31]
+ sky130_fd_sc_hd__o21ai_0
* cell instance sky130_fd_sc_hd__o21ai_0_68 r0 *1 0,0
Xsky130_fd_sc_hd__o21ai_0_68 net32 \_0166_ \_0167_ VGND VPWR VPWR \_0020_[9]
+ sky130_fd_sc_hd__o21ai_0
* cell instance sky130_fd_sc_hd__o21ai_0_69 r0 *1 0,0
Xsky130_fd_sc_hd__o21ai_0_69 net23 \_0911_ \_1017_ VGND VPWR VPWR \_0018_[9]
+ sky130_fd_sc_hd__o21ai_0
* cell instance sky130_fd_sc_hd__o21ai_0_70 r0 *1 0,0
Xsky130_fd_sc_hd__o21ai_0_70 net23 \_1022_ \_1067_ VGND VPWR VPWR \_0019_[7]
+ sky130_fd_sc_hd__o21ai_0
* cell instance sky130_fd_sc_hd__o21ai_0_71 r0 *1 0,0
Xsky130_fd_sc_hd__o21ai_0_71 \_0547_ \_0550_ net25 VGND VPWR VPWR \_0013_[29]
+ sky130_fd_sc_hd__o21ai_0
* cell instance sky130_fd_sc_hd__o21ai_0_72 r0 *1 0,0
Xsky130_fd_sc_hd__o21ai_0_72 \_0166_ \_0797_ \_0912_ VGND VPWR VPWR \_0913_
+ sky130_fd_sc_hd__o21ai_0
* cell instance sky130_fd_sc_hd__o21ai_0_73 r0 *1 0,0
Xsky130_fd_sc_hd__o21ai_0_73 net32 \_0173_ \_0174_ VGND VPWR VPWR \_0020_[7]
+ sky130_fd_sc_hd__o21ai_0
* cell instance sky130_fd_sc_hd__o21ai_0_74 r0 *1 0,0
Xsky130_fd_sc_hd__o21ai_0_74 \_0554_ \_0555_ net25 VGND VPWR VPWR \_0013_[27]
+ sky130_fd_sc_hd__o21ai_0
* cell instance sky130_fd_sc_hd__o21ai_0_75 r0 *1 0,0
Xsky130_fd_sc_hd__o21ai_0_75 net23 \_1041_ \_1069_ VGND VPWR VPWR \_0019_[1]
+ sky130_fd_sc_hd__o21ai_0
* cell instance sky130_fd_sc_hd__o21ai_0_76 r0 *1 0,0
Xsky130_fd_sc_hd__o21ai_0_76 \_0764_ \_1294_ \_1295_ VGND VPWR VPWR \_0016_[2]
+ sky130_fd_sc_hd__o21ai_0
* cell instance sky130_fd_sc_hd__o21ai_0_77 r0 *1 0,0
Xsky130_fd_sc_hd__o21ai_0_77 \_0751_ \_0754_ \_0759_ VGND VPWR VPWR \_0768_
+ sky130_fd_sc_hd__o21ai_0
* cell instance sky130_fd_sc_hd__o21ai_0_78 r0 *1 0,0
Xsky130_fd_sc_hd__o21ai_0_78 net32 \_0195_ \_0196_ VGND VPWR VPWR \_0020_[1]
+ sky130_fd_sc_hd__o21ai_0
* cell instance sky130_fd_sc_hd__o21ai_0_79 r0 *1 0,0
Xsky130_fd_sc_hd__o21ai_0_79 net34 \_0751_ \_0754_ VGND VPWR VPWR \_0759_
+ sky130_fd_sc_hd__o21ai_0
* cell instance sky130_fd_sc_hd__o21ai_0_80 r0 *1 0,0
Xsky130_fd_sc_hd__o21ai_0_80 net23 \_0954_ \_0957_ VGND VPWR VPWR \_0017_[1]
+ sky130_fd_sc_hd__o21ai_0
* cell instance sky130_fd_sc_hd__o21ai_0_81 r0 *1 0,0
Xsky130_fd_sc_hd__o21ai_0_81 \_0292_ \_0793_ \_1077_ VGND VPWR VPWR \_1078_
+ sky130_fd_sc_hd__o21ai_0
* cell instance sky130_fd_sc_hd__o21ai_0_82 r0 *1 0,0
Xsky130_fd_sc_hd__o21ai_0_82 net23 \_0944_ \_0947_ VGND VPWR VPWR \_0017_[3]
+ sky130_fd_sc_hd__o21ai_0
* cell instance sky130_fd_sc_hd__o21ai_0_83 r0 *1 0,0
Xsky130_fd_sc_hd__o21ai_0_83 \_0580_ \_0581_ \_0545_ VGND VPWR VPWR \_0013_[17]
+ sky130_fd_sc_hd__o21ai_0
* cell instance sky130_fd_sc_hd__o21ai_0_84 r0 *1 0,0
Xsky130_fd_sc_hd__o21ai_0_84 raw_level[0] \_1401_ \_0753_ VGND VPWR VPWR
+ \_0754_ sky130_fd_sc_hd__o21ai_0
* cell instance sky130_fd_sc_hd__o21ai_0_85 r0 *1 0,0
Xsky130_fd_sc_hd__o21ai_0_85 net24 \_0921_ \_0926_ VGND VPWR VPWR \_0017_[7]
+ sky130_fd_sc_hd__o21ai_0
* cell instance sky130_fd_sc_hd__o21ai_0_86 r0 *1 0,0
Xsky130_fd_sc_hd__o21ai_0_86 \_0596_ \_0597_ net25 VGND VPWR VPWR \_0013_[9]
+ sky130_fd_sc_hd__o21ai_0
* cell instance sky130_fd_sc_hd__o21ai_0_87 r0 *1 0,0
Xsky130_fd_sc_hd__o21ai_0_87 net23 \_1035_ \_1068_ VGND VPWR VPWR \_0019_[3]
+ sky130_fd_sc_hd__o21ai_0
* cell instance sky130_fd_sc_hd__o21ai_0_88 r0 *1 0,0
Xsky130_fd_sc_hd__o21ai_0_88 \_0578_ \_0579_ \_0545_ VGND VPWR VPWR \_0013_[18]
+ sky130_fd_sc_hd__o21ai_0
* cell instance sky130_fd_sc_hd__o21ai_0_89 r0 *1 0,0
Xsky130_fd_sc_hd__o21ai_0_89 net32 \_0189_ \_0190_ VGND VPWR VPWR \_0020_[3]
+ sky130_fd_sc_hd__o21ai_0
* cell instance sky130_fd_sc_hd__o21ai_0_90 r0 *1 0,0
Xsky130_fd_sc_hd__o21ai_0_90 \_0773_ \_0778_ \_0705_ VGND VPWR VPWR \_0782_
+ sky130_fd_sc_hd__o21ai_0
* cell instance sky130_fd_sc_hd__o21ai_0_91 r0 *1 0,0
Xsky130_fd_sc_hd__o21ai_0_91 \_1338_ \_1339_ net42 VGND VPWR VPWR \_1340_
+ sky130_fd_sc_hd__o21ai_0
* cell instance sky130_fd_sc_hd__o21ai_0_92 r0 *1 0,0
Xsky130_fd_sc_hd__o21ai_0_92 \_1077_ \_1126_ \_1348_ VGND VPWR VPWR \_0045_
+ sky130_fd_sc_hd__o21ai_0
* cell instance sky130_fd_sc_hd__o21ai_0_93 r0 *1 0,0
Xsky130_fd_sc_hd__o21ai_0_93 \_1313_ \_0874_ \_1317_ VGND VPWR VPWR \_1339_
+ sky130_fd_sc_hd__o21ai_0
* cell instance sky130_fd_sc_hd__o21ai_0_94 r0 *1 0,0
Xsky130_fd_sc_hd__o21ai_0_94 \_0588_ \_0589_ \_0545_ VGND VPWR VPWR \_0013_[13]
+ sky130_fd_sc_hd__o21ai_0
* cell instance sky130_fd_sc_hd__o21ai_0_95 r0 *1 0,0
Xsky130_fd_sc_hd__o21ai_0_95 net24 \_1014_ \_1066_ VGND VPWR VPWR \_0019_[10]
+ sky130_fd_sc_hd__o21ai_0
* cell instance sky130_fd_sc_hd__o21ai_0_96 r0 *1 0,0
Xsky130_fd_sc_hd__o21ai_0_96 net24 \_1012_ \_1065_ VGND VPWR VPWR \_0019_[11]
+ sky130_fd_sc_hd__o21ai_0
* cell instance sky130_fd_sc_hd__o21ai_0_97 r0 *1 0,0
Xsky130_fd_sc_hd__o21ai_0_97 raw_count[4] \_1412_ raw_count[5] VGND VPWR VPWR
+ \_1414_ sky130_fd_sc_hd__o21ai_0
* cell instance sky130_fd_sc_hd__o21ai_0_98 r0 *1 0,0
Xsky130_fd_sc_hd__o21ai_0_98 net32 \_0163_ \_0164_ VGND VPWR VPWR \_0020_[10]
+ sky130_fd_sc_hd__o21ai_0
* cell instance sky130_fd_sc_hd__o21ai_0_99 r0 *1 0,0
Xsky130_fd_sc_hd__o21ai_0_99 \_0576_ \_0577_ \_0545_ VGND VPWR VPWR \_0013_[19]
+ sky130_fd_sc_hd__o21ai_0
* cell instance sky130_fd_sc_hd__o21ai_0_100 r0 *1 0,0
Xsky130_fd_sc_hd__o21ai_0_100 net32 \_0160_ \_0161_ VGND VPWR VPWR \_0020_[11]
+ sky130_fd_sc_hd__o21ai_0
* cell instance sky130_fd_sc_hd__o21ai_0_101 r0 *1 0,0
Xsky130_fd_sc_hd__o21ai_0_101 \_0584_ \_0585_ \_0545_ VGND VPWR VPWR
+ \_0013_[15] sky130_fd_sc_hd__o21ai_0
* cell instance sky130_fd_sc_hd__o21ai_0_102 r0 *1 0,0
Xsky130_fd_sc_hd__o21ai_0_102 \_0608_ \_0609_ net25 VGND VPWR VPWR \_0013_[3]
+ sky130_fd_sc_hd__o21ai_0
* cell instance sky130_fd_sc_hd__o21ai_0_103 r0 *1 0,0
Xsky130_fd_sc_hd__o21ai_0_103 net24 \_1000_ \_1063_ VGND VPWR VPWR \_0019_[15]
+ sky130_fd_sc_hd__o21ai_0
* cell instance sky130_fd_sc_hd__o21ai_0_104 r0 *1 0,0
Xsky130_fd_sc_hd__o21ai_0_104 \_0586_ \_0587_ \_0545_ VGND VPWR VPWR
+ \_0013_[14] sky130_fd_sc_hd__o21ai_0
* cell instance sky130_fd_sc_hd__o21ai_0_105 r0 *1 0,0
Xsky130_fd_sc_hd__o21ai_0_105 net32 \_0145_ \_0146_ VGND VPWR VPWR \_0020_[15]
+ sky130_fd_sc_hd__o21ai_0
* cell instance sky130_fd_sc_hd__o21ai_0_106 r0 *1 0,0
Xsky130_fd_sc_hd__o21ai_0_106 net24 \_0974_ \_1050_ VGND VPWR VPWR \_0019_[27]
+ sky130_fd_sc_hd__o21ai_0
* cell instance sky130_fd_sc_hd__o21ai_0_107 r0 *1 0,0
Xsky130_fd_sc_hd__o21ai_0_107 \_0573_ \_0574_ \_0545_ VGND VPWR VPWR
+ \_0013_[20] sky130_fd_sc_hd__o21ai_0
* cell instance sky130_fd_sc_hd__o21ai_0_108 r0 *1 0,0
Xsky130_fd_sc_hd__o21ai_0_108 net24 \_0994_ \_1060_ VGND VPWR VPWR \_0019_[18]
+ sky130_fd_sc_hd__o21ai_0
* cell instance sky130_fd_sc_hd__o21ai_0_109 r0 *1 0,0
Xsky130_fd_sc_hd__o21ai_0_109 net32 \_0078_ \_0079_ VGND VPWR VPWR \_0020_[27]
+ sky130_fd_sc_hd__o21ai_0
* cell instance sky130_fd_sc_hd__o21ai_0_110 r0 *1 0,0
Xsky130_fd_sc_hd__o21ai_0_110 net32 \_0131_ \_0132_ VGND VPWR VPWR \_0020_[18]
+ sky130_fd_sc_hd__o21ai_0
* cell instance sky130_fd_sc_hd__o21ai_0_111 r0 *1 0,0
Xsky130_fd_sc_hd__o21ai_0_111 raw_sr[4] \_0183_ \_0184_ VGND VPWR VPWR \_0185_
+ sky130_fd_sc_hd__o21ai_0
* cell instance sky130_fd_sc_hd__o21ai_0_112 r0 *1 0,0
Xsky130_fd_sc_hd__o21ai_0_112 \_0571_ \_0572_ \_0545_ VGND VPWR VPWR
+ \_0013_[21] sky130_fd_sc_hd__o21ai_0
* cell instance sky130_fd_sc_hd__o21ai_0_113 r0 *1 0,0
Xsky130_fd_sc_hd__o21ai_0_113 raw_count[0] \_0311_ \_0705_ VGND VPWR VPWR
+ \_0727_ sky130_fd_sc_hd__o21ai_0
* cell instance sky130_fd_sc_hd__o21ai_0_114 r0 *1 0,0
Xsky130_fd_sc_hd__o21ai_0_114 net24 \_0996_ \_1061_ VGND VPWR VPWR \_0019_[17]
+ sky130_fd_sc_hd__o21ai_0
* cell instance sky130_fd_sc_hd__o21ai_0_115 r0 *1 0,0
Xsky130_fd_sc_hd__o21ai_0_115 net24 \_1002_ \_1064_ VGND VPWR VPWR \_0019_[14]
+ sky130_fd_sc_hd__o21ai_0
* cell instance sky130_fd_sc_hd__o21ai_0_116 r0 *1 0,0
Xsky130_fd_sc_hd__o21ai_0_116 net32 \_0136_ \_0137_ VGND VPWR VPWR \_0020_[17]
+ sky130_fd_sc_hd__o21ai_0
* cell instance sky130_fd_sc_hd__o21ai_0_117 r0 *1 0,0
Xsky130_fd_sc_hd__o21ai_0_117 net32 \_0148_ \_0149_ VGND VPWR VPWR \_0020_[14]
+ sky130_fd_sc_hd__o21ai_0
* cell instance sky130_fd_sc_hd__o21ai_0_118 r0 *1 0,0
Xsky130_fd_sc_hd__o21ai_0_118 \_0614_ \_0615_ net25 VGND VPWR VPWR \_0013_[0]
+ sky130_fd_sc_hd__o21ai_0
* cell instance sky130_fd_sc_hd__o21ai_0_119 r0 *1 0,0
Xsky130_fd_sc_hd__o21ai_0_119 net24 \_0988_ \_1057_ VGND VPWR VPWR \_0019_[21]
+ sky130_fd_sc_hd__o21ai_0
* cell instance sky130_fd_sc_hd__o21ai_0_120 r0 *1 0,0
Xsky130_fd_sc_hd__o21ai_0_120 gated \_0209_ \_0627_ VGND VPWR VPWR \_0628_
+ sky130_fd_sc_hd__o21ai_0
* cell instance sky130_fd_sc_hd__o21ai_0_121 r0 *1 0,0
Xsky130_fd_sc_hd__o21ai_0_121 net24 \_0972_ \_1049_ VGND VPWR VPWR \_0019_[28]
+ sky130_fd_sc_hd__o21ai_0
* cell instance sky130_fd_sc_hd__o21ai_0_122 r0 *1 0,0
Xsky130_fd_sc_hd__o21ai_0_122 net32 \_0117_ \_0118_ VGND VPWR VPWR \_0020_[21]
+ sky130_fd_sc_hd__o21ai_0
* cell instance sky130_fd_sc_hd__o21ai_0_123 r0 *1 0,0
Xsky130_fd_sc_hd__o21ai_0_123 cond_count[0] net35 \_0545_ VGND VPWR VPWR
+ \_0649_ sky130_fd_sc_hd__o21ai_0
* cell instance sky130_fd_sc_hd__o21ai_0_124 r0 *1 0,0
Xsky130_fd_sc_hd__o21ai_0_124 net24 \_0986_ \_1056_ VGND VPWR VPWR \_0019_[22]
+ sky130_fd_sc_hd__o21ai_0
* cell instance sky130_fd_sc_hd__o21ai_0_125 r0 *1 0,0
Xsky130_fd_sc_hd__o21ai_0_125 net32 \_0071_ \_0072_ VGND VPWR VPWR \_0020_[28]
+ sky130_fd_sc_hd__o21ai_0
* cell instance sky130_fd_sc_hd__o21ai_0_126 r0 *1 0,0
Xsky130_fd_sc_hd__o21ai_0_126 cond_count[2] \_0640_ \_0545_ VGND VPWR VPWR
+ \_0647_ sky130_fd_sc_hd__o21ai_0
* cell instance sky130_fd_sc_hd__o21ai_0_127 r0 *1 0,0
Xsky130_fd_sc_hd__o21ai_0_127 net24 \_0990_ \_1058_ VGND VPWR VPWR \_0019_[20]
+ sky130_fd_sc_hd__o21ai_0
* cell instance sky130_fd_sc_hd__o21ai_0_128 r0 *1 0,0
Xsky130_fd_sc_hd__o21ai_0_128 cond_count[13] \_0200_ \_0381_ VGND VPWR VPWR
+ \_0621_ sky130_fd_sc_hd__o21ai_0
* cell instance sky130_fd_sc_hd__o21ai_0_129 r0 *1 0,0
Xsky130_fd_sc_hd__o21ai_0_129 net24 \_0967_ \_1047_ VGND VPWR VPWR \_0019_[30]
+ sky130_fd_sc_hd__o21ai_0
* cell instance sky130_fd_sc_hd__o21ai_0_130 r0 *1 0,0
Xsky130_fd_sc_hd__o21ai_0_130 net32 \_0112_ \_0113_ VGND VPWR VPWR \_0020_[22]
+ sky130_fd_sc_hd__o21ai_0
* cell instance sky130_fd_sc_hd__o21ai_0_131 r0 *1 0,0
Xsky130_fd_sc_hd__o21ai_0_131 net24 \_0984_ \_1055_ VGND VPWR VPWR \_0019_[23]
+ sky130_fd_sc_hd__o21ai_0
* cell instance sky130_fd_sc_hd__o21ai_0_132 r0 *1 0,0
Xsky130_fd_sc_hd__o21ai_0_132 net32 \_0121_ \_0122_ VGND VPWR VPWR \_0020_[20]
+ sky130_fd_sc_hd__o21ai_0
* cell instance sky130_fd_sc_hd__o21ai_0_133 r0 *1 0,0
Xsky130_fd_sc_hd__o21ai_0_133 net32 \_1428_ \_1430_ VGND VPWR VPWR \_0020_[30]
+ sky130_fd_sc_hd__o21ai_0
* cell instance sky130_fd_sc_hd__o21ai_0_134 r0 *1 0,0
Xsky130_fd_sc_hd__o21ai_0_134 net32 \_0105_ \_0106_ VGND VPWR VPWR \_0020_[23]
+ sky130_fd_sc_hd__o21ai_0
* cell instance sky130_fd_sc_hd__o21ai_0_135 r0 *1 0,0
Xsky130_fd_sc_hd__o21ai_0_135 gated \_0530_ \_0624_ VGND VPWR VPWR \_0625_
+ sky130_fd_sc_hd__o21ai_0
* cell instance sky130_fd_sc_hd__o21ai_0_136 r0 *1 0,0
Xsky130_fd_sc_hd__o21ai_0_136 gated \_0211_ \_1287_ VGND VPWR VPWR \_1288_
+ sky130_fd_sc_hd__o21ai_0
* cell instance sky130_fd_sc_hd__o21ai_0_137 r0 *1 0,0
Xsky130_fd_sc_hd__o21ai_0_137 cond_count[4] \_0641_ \_0545_ VGND VPWR VPWR
+ \_0645_ sky130_fd_sc_hd__o21ai_0
* cell instance sky130_fd_sc_hd__o21ai_0_138 r0 *1 0,0
Xsky130_fd_sc_hd__o21ai_0_138 startup_done_r \_0493_ \_0494_ VGND VPWR VPWR
+ \_0495_ sky130_fd_sc_hd__o21ai_0
* cell instance sky130_fd_sc_hd__o21ai_0_139 r0 *1 0,0
Xsky130_fd_sc_hd__o21ai_0_139 startup_done_r \_0497_ \_0381_ VGND VPWR VPWR
+ \_0498_ sky130_fd_sc_hd__o21ai_0
* cell instance sky130_fd_sc_hd__o21ai_0_140 r0 *1 0,0
Xsky130_fd_sc_hd__o21ai_0_140 startup_done_r \_0739_ \_0381_ VGND VPWR VPWR
+ \_1282_ sky130_fd_sc_hd__o21ai_0
* cell instance sky130_fd_sc_hd__o21ai_0_141 r0 *1 0,0
Xsky130_fd_sc_hd__o21ai_0_141 startup_done_r \_0501_ \_0502_ VGND VPWR VPWR
+ \_0503_ sky130_fd_sc_hd__o21ai_0
* cell instance sky130_fd_sc_hd__o21ai_0_142 r0 *1 0,0
Xsky130_fd_sc_hd__o21ai_0_142 startup_done_r \_0486_ \_0487_ VGND VPWR VPWR
+ \_0488_ sky130_fd_sc_hd__o21ai_0
* cell instance sky130_fd_sc_hd__o21ai_0_143 r0 *1 0,0
Xsky130_fd_sc_hd__o21ai_0_143 apt_matches[9] \_0332_ \_0443_ VGND VPWR VPWR
+ \_0450_ sky130_fd_sc_hd__o21ai_0
* cell instance sky130_fd_sc_hd__o21ai_0_144 r0 *1 0,0
Xsky130_fd_sc_hd__o21ai_0_144 net43 \_1276_ \_0295_ VGND VPWR VPWR \_1277_
+ sky130_fd_sc_hd__o21ai_0
* cell instance sky130_fd_sc_hd__o21ai_0_145 r0 *1 0,0
Xsky130_fd_sc_hd__o21ai_0_145 apt_index[0] \_0381_ \_0295_ VGND VPWR VPWR
+ \_0437_ sky130_fd_sc_hd__o21ai_0
* cell instance sky130_fd_sc_hd__o21ba_2_0 r0 *1 0,0
Xsky130_fd_sc_hd__o21ba_2_0 \_0406_ \_0407_ startup_done_r VGND VPWR VPWR
+ \_0728_ sky130_fd_sc_hd__o21ba_2
* cell instance sky130_fd_sc_hd__o21bai_1_0 r0 *1 0,0
Xsky130_fd_sc_hd__o21bai_1_0 \_0484_ \_0506_ startup_done_r VGND VPWR VPWR
+ \_0507_ sky130_fd_sc_hd__o21bai_1
* cell instance sky130_fd_sc_hd__o21bai_1_1 r0 *1 0,0
Xsky130_fd_sc_hd__o21bai_1_1 \_0490_ \_0491_ startup_count[13] VGND VPWR VPWR
+ \_0492_ sky130_fd_sc_hd__o21bai_1
* cell instance sky130_fd_sc_hd__o221ai_1_0 r0 *1 0,0
Xsky130_fd_sc_hd__o221ai_1_0 \_0811_ \_0839_ \_1095_ \_1077_ \_1327_ VGND VPWR
+ VPWR \_0034_ sky130_fd_sc_hd__o221ai_1
* cell instance sky130_fd_sc_hd__o221ai_1_1 r0 *1 0,0
Xsky130_fd_sc_hd__o221ai_1_1 \_0811_ \_0866_ \_1114_ \_1077_ \_1333_ VGND VPWR
+ VPWR \_0040_ sky130_fd_sc_hd__o221ai_1
* cell instance sky130_fd_sc_hd__o221ai_1_2 r0 *1 0,0
Xsky130_fd_sc_hd__o221ai_1_2 \_0811_ \_0818_ \_1082_ \_1077_ \_1322_ VGND VPWR
+ VPWR \_0030_ sky130_fd_sc_hd__o221ai_1
* cell instance sky130_fd_sc_hd__o221ai_1_3 r0 *1 0,0
Xsky130_fd_sc_hd__o221ai_1_3 \_0811_ \_0844_ \_1097_ \_1077_ \_1328_ VGND VPWR
+ VPWR \_0035_ sky130_fd_sc_hd__o221ai_1
* cell instance sky130_fd_sc_hd__o221ai_1_4 r0 *1 0,0
Xsky130_fd_sc_hd__o221ai_1_4 \_0811_ \_1297_ \_1303_ \_1077_ \_1311_ VGND VPWR
+ VPWR \_0028_ sky130_fd_sc_hd__o221ai_1
* cell instance sky130_fd_sc_hd__o221ai_1_5 r0 *1 0,0
Xsky130_fd_sc_hd__o221ai_1_5 \_0811_ \_0830_ \_1088_ \_1077_ \_1325_ VGND VPWR
+ VPWR \_0032_ sky130_fd_sc_hd__o221ai_1
* cell instance sky130_fd_sc_hd__o221ai_1_6 r0 *1 0,0
Xsky130_fd_sc_hd__o221ai_1_6 \_1313_ \_0834_ \_1092_ \_1315_ \_1317_ VGND VPWR
+ VPWR \_1326_ sky130_fd_sc_hd__o221ai_1
* cell instance sky130_fd_sc_hd__o221ai_1_7 r0 *1 0,0
Xsky130_fd_sc_hd__o221ai_1_7 \_1316_ \_1336_ \_1337_ \_0754_ \_1358_ VGND VPWR
+ VPWR \_1362_ sky130_fd_sc_hd__o221ai_1
* cell instance sky130_fd_sc_hd__o221ai_1_8 r0 *1 0,0
Xsky130_fd_sc_hd__o221ai_1_8 \_1315_ \_1176_ \_1337_ \_0743_ \_1392_ VGND VPWR
+ VPWR \_1393_ sky130_fd_sc_hd__o221ai_1
* cell instance sky130_fd_sc_hd__o221ai_1_9 r0 *1 0,0
Xsky130_fd_sc_hd__o221ai_1_9 \_1077_ \_1171_ \_1344_ \_1385_ \_1389_ VGND VPWR
+ VPWR \_0058_ sky130_fd_sc_hd__o221ai_1
* cell instance sky130_fd_sc_hd__o221ai_1_10 r0 *1 0,0
Xsky130_fd_sc_hd__o221ai_1_10 \_0811_ \_0870_ \_1116_ \_1077_ \_1335_ VGND VPWR
+ VPWR \_0041_ sky130_fd_sc_hd__o221ai_1
* cell instance sky130_fd_sc_hd__o221ai_1_11 r0 *1 0,0
Xsky130_fd_sc_hd__o221ai_1_11 \_1313_ \_0944_ \_1164_ \_1315_ \_1358_ VGND VPWR
+ VPWR \_1379_ sky130_fd_sc_hd__o221ai_1
* cell instance sky130_fd_sc_hd__o221ai_1_12 r0 *1 0,0
Xsky130_fd_sc_hd__o221ai_1_12 \_1313_ \_0825_ \_1086_ \_1315_ \_1317_ VGND VPWR
+ VPWR \_1324_ sky130_fd_sc_hd__o221ai_1
* cell instance sky130_fd_sc_hd__o221ai_1_13 r0 *1 0,0
Xsky130_fd_sc_hd__o221ai_1_13 \_0811_ \_0921_ \_1151_ \_1077_ \_1366_ VGND VPWR
+ VPWR \_0052_ sky130_fd_sc_hd__o221ai_1
* cell instance sky130_fd_sc_hd__o221ai_1_14 r0 *1 0,0
Xsky130_fd_sc_hd__o221ai_1_14 \_1313_ \_0801_ \_1073_ \_1315_ \_1317_ VGND VPWR
+ VPWR \_1319_ sky130_fd_sc_hd__o221ai_1
* cell instance sky130_fd_sc_hd__o221ai_1_15 r0 *1 0,0
Xsky130_fd_sc_hd__o221ai_1_15 \_1313_ \_0907_ \_1141_ \_1315_ \_1355_ VGND VPWR
+ VPWR \_1356_ sky130_fd_sc_hd__o221ai_1
* cell instance sky130_fd_sc_hd__o221ai_1_16 r0 *1 0,0
Xsky130_fd_sc_hd__o221ai_1_16 \_1313_ \_0902_ \_1135_ \_1315_ \_1317_ VGND VPWR
+ VPWR \_1353_ sky130_fd_sc_hd__o221ai_1
* cell instance sky130_fd_sc_hd__o221ai_1_17 r0 *1 0,0
Xsky130_fd_sc_hd__o221ai_1_17 \_1313_ \_0886_ \_1337_ \_0781_ \_1317_ VGND VPWR
+ VPWR \_1347_ sky130_fd_sc_hd__o221ai_1
* cell instance sky130_fd_sc_hd__o221ai_1_18 r0 *1 0,0
Xsky130_fd_sc_hd__o221ai_1_18 \_1313_ \_0862_ \_1112_ \_1315_ \_1317_ VGND VPWR
+ VPWR \_1332_ sky130_fd_sc_hd__o221ai_1
* cell instance sky130_fd_sc_hd__o221ai_1_19 r0 *1 0,0
Xsky130_fd_sc_hd__o221ai_1_19 \_1313_ \_0853_ \_1106_ \_1315_ \_1317_ VGND VPWR
+ VPWR \_1330_ sky130_fd_sc_hd__o221ai_1
* cell instance sky130_fd_sc_hd__o221ai_1_20 r0 *1 0,0
Xsky130_fd_sc_hd__o221ai_1_20 \_0811_ \_0858_ \_1109_ \_1077_ \_1331_ VGND VPWR
+ VPWR \_0038_ sky130_fd_sc_hd__o221ai_1
* cell instance sky130_fd_sc_hd__o221ai_1_21 r0 *1 0,0
Xsky130_fd_sc_hd__o221ai_1_21 \_0811_ \_0849_ \_1102_ \_1077_ \_1329_ VGND VPWR
+ VPWR \_0036_ sky130_fd_sc_hd__o221ai_1
* cell instance sky130_fd_sc_hd__o221ai_1_22 r0 *1 0,0
Xsky130_fd_sc_hd__o221ai_1_22 \_0811_ \_0882_ \_1124_ \_1077_ \_1346_ VGND VPWR
+ VPWR \_0044_ sky130_fd_sc_hd__o221ai_1
* cell instance sky130_fd_sc_hd__o22ai_1_0 r0 *1 0,0
Xsky130_fd_sc_hd__o22ai_1_0 \_0730_ \_0785_ \_1316_ bus_addr[0] VGND VPWR VPWR
+ \_1354_ sky130_fd_sc_hd__o22ai_1
* cell instance sky130_fd_sc_hd__o22ai_1_1 r0 *1 0,0
Xsky130_fd_sc_hd__o22ai_1_1 crc_state[5] net35 \_0604_ net30 VGND VPWR VPWR
+ \_0605_ sky130_fd_sc_hd__o22ai_1
* cell instance sky130_fd_sc_hd__o22ai_1_2 r0 *1 0,0
Xsky130_fd_sc_hd__o22ai_1_2 al_rct \_0406_ \_0732_ \_0733_ VGND VPWR VPWR
+ \_0734_ sky130_fd_sc_hd__o22ai_1
* cell instance sky130_fd_sc_hd__o22ai_1_3 r0 *1 0,0
Xsky130_fd_sc_hd__o22ai_1_3 al_apt \_0407_ \_0733_ \_0735_ VGND VPWR VPWR
+ \_0736_ sky130_fd_sc_hd__o22ai_1
* cell instance sky130_fd_sc_hd__o22ai_1_4 r0 *1 0,0
Xsky130_fd_sc_hd__o22ai_1_4 \_1313_ \_0878_ \_1121_ \_1315_ VGND VPWR VPWR
+ \_1342_ sky130_fd_sc_hd__o22ai_1
* cell instance sky130_fd_sc_hd__o22ai_1_5 r0 *1 0,0
Xsky130_fd_sc_hd__o22ai_1_5 crc_state[4] net35 \_0606_ net30 VGND VPWR VPWR
+ \_0607_ sky130_fd_sc_hd__o22ai_1
* cell instance sky130_fd_sc_hd__o22ai_1_6 r0 *1 0,0
Xsky130_fd_sc_hd__o22ai_1_6 crc_state[26] net35 \_0559_ net30 VGND VPWR VPWR
+ \_0561_ sky130_fd_sc_hd__o22ai_1
* cell instance sky130_fd_sc_hd__o22ai_1_7 r0 *1 0,0
Xsky130_fd_sc_hd__o22ai_1_7 crc_state[7] net35 \_0600_ net30 VGND VPWR VPWR
+ \_0601_ sky130_fd_sc_hd__o22ai_1
* cell instance sky130_fd_sc_hd__o22ai_1_8 r0 *1 0,0
Xsky130_fd_sc_hd__o22ai_1_8 crc_state[8] net35 \_0598_ net30 VGND VPWR VPWR
+ \_0599_ sky130_fd_sc_hd__o22ai_1
* cell instance sky130_fd_sc_hd__o22ai_1_9 r0 *1 0,0
Xsky130_fd_sc_hd__o22ai_1_9 crc_state[16] net35 \_0582_ net30 VGND VPWR VPWR
+ \_0583_ sky130_fd_sc_hd__o22ai_1
* cell instance sky130_fd_sc_hd__o22ai_1_10 r0 *1 0,0
Xsky130_fd_sc_hd__o22ai_1_10 crc_state[11] net35 \_0592_ net30 VGND VPWR VPWR
+ \_0593_ sky130_fd_sc_hd__o22ai_1
* cell instance sky130_fd_sc_hd__o22ai_1_11 r0 *1 0,0
Xsky130_fd_sc_hd__o22ai_1_11 crc_state[12] net35 \_0590_ net30 VGND VPWR VPWR
+ \_0591_ sky130_fd_sc_hd__o22ai_1
* cell instance sky130_fd_sc_hd__o22ai_1_12 r0 *1 0,0
Xsky130_fd_sc_hd__o22ai_1_12 crc_state[10] net35 \_0594_ net30 VGND VPWR VPWR
+ \_0595_ sky130_fd_sc_hd__o22ai_1
* cell instance sky130_fd_sc_hd__o22ai_1_13 r0 *1 0,0
Xsky130_fd_sc_hd__o22ai_1_13 crc_state[2] net35 \_0610_ net30 VGND VPWR VPWR
+ \_0611_ sky130_fd_sc_hd__o22ai_1
* cell instance sky130_fd_sc_hd__o22ai_1_14 r0 *1 0,0
Xsky130_fd_sc_hd__o22ai_1_14 crc_state[23] net35 \_0567_ net30 VGND VPWR VPWR
+ \_0568_ sky130_fd_sc_hd__o22ai_1
* cell instance sky130_fd_sc_hd__o22ai_1_15 r0 *1 0,0
Xsky130_fd_sc_hd__o22ai_1_15 crc_state[1] net35 \_0612_ net30 VGND VPWR VPWR
+ \_0613_ sky130_fd_sc_hd__o22ai_1
* cell instance sky130_fd_sc_hd__o22ai_1_16 r0 *1 0,0
Xsky130_fd_sc_hd__o22ai_1_16 crc_state[22] net35 \_0569_ net30 VGND VPWR VPWR
+ \_0570_ sky130_fd_sc_hd__o22ai_1
* cell instance sky130_fd_sc_hd__o31a_1_0 r0 *1 0,0
Xsky130_fd_sc_hd__o31a_1_0 \_0345_ net37 \_0416_ \_0457_ VGND VPWR VPWR \_0458_
+ sky130_fd_sc_hd__o31a_1
* cell instance sky130_fd_sc_hd__o31ai_1_0 r0 *1 0,0
Xsky130_fd_sc_hd__o31ai_1_0 raw_count[3] \_0082_ \_0154_ raw_sr[2] VGND VPWR
+ VPWR \_0191_ sky130_fd_sc_hd__o31ai_1
* cell instance sky130_fd_sc_hd__o31ai_1_1 r0 *1 0,0
Xsky130_fd_sc_hd__o31ai_1_1 \_0327_ \_0380_ \_0776_ \_0777_ VGND VPWR VPWR
+ \_0778_ sky130_fd_sc_hd__o31ai_1
* cell instance sky130_fd_sc_hd__o31ai_1_2 r0 *1 0,0
Xsky130_fd_sc_hd__o31ai_1_2 \_0327_ \_0380_ \_0771_ \_0772_ VGND VPWR VPWR
+ \_0773_ sky130_fd_sc_hd__o31ai_1
* cell instance sky130_fd_sc_hd__o31ai_1_3 r0 *1 0,0
Xsky130_fd_sc_hd__o31ai_1_3 raw_count[3] \_0088_ \_0154_ raw_sr[1] VGND VPWR
+ VPWR \_0194_ sky130_fd_sc_hd__o31ai_1
* cell instance sky130_fd_sc_hd__o41a_1_0 r0 *1 0,0
Xsky130_fd_sc_hd__o41a_1_0 \_0329_ net37 \_0416_ \_0466_ \_0467_ VGND VPWR VPWR
+ \_0468_ sky130_fd_sc_hd__o41a_1
* cell instance sky130_fd_sc_hd__o41ai_1_0 r0 *1 0,0
Xsky130_fd_sc_hd__o41ai_1_0 \_0774_ \_0788_ \_0791_ \_0792_ out_ready VGND VPWR
+ VPWR \_0793_ sky130_fd_sc_hd__o41ai_1
* cell instance sky130_fd_sc_hd__o41ai_1_1 r0 *1 0,0
Xsky130_fd_sc_hd__o41ai_1_1 apt_index[0] apt_index[15] apt_index[3] \_0353_
+ apt_matches[4] VGND VPWR VPWR \_0354_ sky130_fd_sc_hd__o41ai_1
* cell instance sky130_fd_sc_hd__or2_2_0 r0 *1 0,0
Xsky130_fd_sc_hd__or2_2_0 \_0756_ \_1316_ VGND VPWR VPWR \_1317_
+ sky130_fd_sc_hd__or2_2
* cell instance sky130_fd_sc_hd__or2_2_1 r0 *1 0,0
Xsky130_fd_sc_hd__or2_2_1 \_0730_ \_0756_ VGND VPWR VPWR \_1358_
+ sky130_fd_sc_hd__or2_2
* cell instance sky130_fd_sc_hd__or2_2_2 r0 *1 0,0
Xsky130_fd_sc_hd__or2_2_2 \_0749_ \_0759_ VGND VPWR VPWR \_0809_
+ sky130_fd_sc_hd__or2_2
* cell instance sky130_fd_sc_hd__or2_2_3 r0 *1 0,0
Xsky130_fd_sc_hd__or2_2_3 \_0788_ \_0791_ VGND VPWR VPWR \_0795_
+ sky130_fd_sc_hd__or2_2
* cell instance sky130_fd_sc_hd__or2_2_4 r0 *1 0,0
Xsky130_fd_sc_hd__or2_2_4 raw_level[1] \_0750_ VGND VPWR VPWR \_0802_
+ sky130_fd_sc_hd__or2_2
* cell instance sky130_fd_sc_hd__or2_2_5 r0 *1 0,0
Xsky130_fd_sc_hd__or2_2_5 \_0291_ \_0543_ VGND VPWR VPWR \_0705_
+ sky130_fd_sc_hd__or2_2
* cell instance sky130_fd_sc_hd__or2_2_6 r0 *1 0,0
Xsky130_fd_sc_hd__or2_2_6 \_0406_ \_0407_ VGND VPWR VPWR \_0540_
+ sky130_fd_sc_hd__or2_2
* cell instance sky130_fd_sc_hd__or2_2_7 r0 *1 0,0
Xsky130_fd_sc_hd__or2_2_7 \_0207_ \_0208_ VGND VPWR VPWR \_0209_
+ sky130_fd_sc_hd__or2_2
* cell instance sky130_fd_sc_hd__or2_2_8 r0 *1 0,0
Xsky130_fd_sc_hd__or2_2_8 apt_matches[0] \_0328_ VGND VPWR VPWR \_0472_
+ sky130_fd_sc_hd__or2_2
* cell instance sky130_fd_sc_hd__or3_1_0 r0 *1 0,0
Xsky130_fd_sc_hd__or3_1_0 bus_addr[3] bus_addr[2] \_1336_ VGND VPWR VPWR
+ \_1337_ sky130_fd_sc_hd__or3_1
* cell instance sky130_fd_sc_hd__or3_1_1 r0 *1 0,0
Xsky130_fd_sc_hd__or3_1_1 bus_addr[0] bus_addr[1] \_0730_ VGND VPWR VPWR
+ \_0731_ sky130_fd_sc_hd__or3_1
* cell instance sky130_fd_sc_hd__or3_1_2 r0 *1 0,0
Xsky130_fd_sc_hd__or3_1_2 \_0749_ \_0752_ \_0762_ VGND VPWR VPWR \_0763_
+ sky130_fd_sc_hd__or3_1
* cell instance sky130_fd_sc_hd__or3_1_3 r0 *1 0,0
Xsky130_fd_sc_hd__or3_1_3 raw_count[4] \_1398_ \_1415_ VGND VPWR VPWR \_0144_
+ sky130_fd_sc_hd__or3_1
* cell instance sky130_fd_sc_hd__or3_1_4 r0 *1 0,0
Xsky130_fd_sc_hd__or3_1_4 \_1415_ \_1417_ \_0068_ VGND VPWR VPWR \_0069_
+ sky130_fd_sc_hd__or3_1
* cell instance sky130_fd_sc_hd__or3_1_5 r0 *1 0,0
Xsky130_fd_sc_hd__or3_1_5 raw_count[3] \_0099_ \_0082_ VGND VPWR VPWR \_0128_
+ sky130_fd_sc_hd__or3_1
* cell instance sky130_fd_sc_hd__or3_1_6 r0 *1 0,0
Xsky130_fd_sc_hd__or3_1_6 raw_count[3] \_0062_ \_0154_ VGND VPWR VPWR \_0179_
+ sky130_fd_sc_hd__or3_1
* cell instance sky130_fd_sc_hd__or3_1_7 r0 *1 0,0
Xsky130_fd_sc_hd__or3_1_7 \_0540_ net34 \_0780_ VGND VPWR VPWR \_0781_
+ sky130_fd_sc_hd__or3_1
* cell instance sky130_fd_sc_hd__or3_1_8 r0 *1 0,0
Xsky130_fd_sc_hd__or3_1_8 raw_count[3] \_0097_ \_0154_ VGND VPWR VPWR \_0171_
+ sky130_fd_sc_hd__or3_1
* cell instance sky130_fd_sc_hd__or3_1_9 r0 *1 0,0
Xsky130_fd_sc_hd__or3_1_9 raw_count[3] \_0099_ \_0088_ VGND VPWR VPWR \_0133_
+ sky130_fd_sc_hd__or3_1
* cell instance sky130_fd_sc_hd__or3_1_10 r0 *1 0,0
Xsky130_fd_sc_hd__or3_1_10 raw_count[3] \_1420_ \_0154_ VGND VPWR VPWR \_0175_
+ sky130_fd_sc_hd__or3_1
* cell instance sky130_fd_sc_hd__or3_1_11 r0 *1 0,0
Xsky130_fd_sc_hd__or3_1_11 raw_count[3] \_0099_ \_0062_ VGND VPWR VPWR \_0114_
+ sky130_fd_sc_hd__or3_1
* cell instance sky130_fd_sc_hd__or3_1_12 r0 *1 0,0
Xsky130_fd_sc_hd__or3_1_12 raw_count[3] \_0097_ \_0099_ VGND VPWR VPWR \_0101_
+ sky130_fd_sc_hd__or3_1
* cell instance sky130_fd_sc_hd__or3_1_13 r0 *1 0,0
Xsky130_fd_sc_hd__or3_1_13 raw_count[3] \_1420_ \_0099_ VGND VPWR VPWR \_0107_
+ sky130_fd_sc_hd__or3_1
* cell instance sky130_fd_sc_hd__or3_1_14 r0 *1 0,0
Xsky130_fd_sc_hd__or3_1_14 \_0204_ \_0205_ \_0537_ VGND VPWR VPWR \_0638_
+ sky130_fd_sc_hd__or3_1
* cell instance sky130_fd_sc_hd__or3_1_15 r0 *1 0,0
Xsky130_fd_sc_hd__or3_1_15 net38 \_0406_ \_0407_ VGND VPWR VPWR \_0408_
+ sky130_fd_sc_hd__or3_1
* cell instance sky130_fd_sc_hd__or3_1_16 r0 *1 0,0
Xsky130_fd_sc_hd__or3_1_16 \_0408_ \_0741_ \_0742_ VGND VPWR VPWR \_0743_
+ sky130_fd_sc_hd__or3_1
* cell instance sky130_fd_sc_hd__or3_1_17 r0 *1 0,0
Xsky130_fd_sc_hd__or3_1_17 \_0327_ \_0374_ \_0380_ VGND VPWR VPWR \_0405_
+ sky130_fd_sc_hd__or3_1
* cell instance sky130_fd_sc_hd__or3_1_18 r0 *1 0,0
Xsky130_fd_sc_hd__or3_1_18 \_0318_ \_0319_ \_0320_ VGND VPWR VPWR \_0321_
+ sky130_fd_sc_hd__or3_1
* cell instance sky130_fd_sc_hd__or3_1_19 r0 *1 0,0
Xsky130_fd_sc_hd__or3_1_19 rct_count[13] rct_count[9] rct_count[8] VGND VPWR
+ VPWR \_0315_ sky130_fd_sc_hd__or3_1
* cell instance sky130_fd_sc_hd__or3b_2_0 r0 *1 0,0
Xsky130_fd_sc_hd__or3b_2_0 raw_count[5] \_1398_ raw_count[4] VGND VPWR VPWR
+ \_1400_ sky130_fd_sc_hd__or3b_2
* cell instance sky130_fd_sc_hd__or3b_2_1 r0 *1 0,0
Xsky130_fd_sc_hd__or3b_2_1 raw_count[0] raw_count[2] raw_count[1] VGND VPWR
+ VPWR \_0082_ sky130_fd_sc_hd__or3b_2
* cell instance sky130_fd_sc_hd__or3b_2_2 r0 *1 0,0
Xsky130_fd_sc_hd__or3b_2_2 raw_count[1] raw_count[2] raw_count[0] VGND VPWR
+ VPWR \_0088_ sky130_fd_sc_hd__or3b_2
* cell instance sky130_fd_sc_hd__or4_1_0 r0 *1 0,0
Xsky130_fd_sc_hd__or4_1_0 raw_count[2] raw_count[3] \_0074_ \_0154_ VGND VPWR
+ VPWR \_0187_ sky130_fd_sc_hd__or4_1
* cell instance sky130_fd_sc_hd__or4b_2_0 r0 *1 0,0
Xsky130_fd_sc_hd__or4b_2_0 \_0346_ \_0347_ \_0354_ apt_matches[5] VGND VPWR
+ VPWR \_0355_ sky130_fd_sc_hd__or4b_2
* cell instance sky130_fd_sc_hd__tapvpwrvgnd_1_0 r0 *1 0,0
Xsky130_fd_sc_hd__tapvpwrvgnd_1_0 VGND VPWR sky130_fd_sc_hd__tapvpwrvgnd_1
* cell instance sky130_fd_sc_hd__tapvpwrvgnd_1_1 r0 *1 0,0
Xsky130_fd_sc_hd__tapvpwrvgnd_1_1 VGND VPWR sky130_fd_sc_hd__tapvpwrvgnd_1
* cell instance sky130_fd_sc_hd__tapvpwrvgnd_1_2 r0 *1 0,0
Xsky130_fd_sc_hd__tapvpwrvgnd_1_2 VGND VPWR sky130_fd_sc_hd__tapvpwrvgnd_1
* cell instance sky130_fd_sc_hd__tapvpwrvgnd_1_3 r0 *1 0,0
Xsky130_fd_sc_hd__tapvpwrvgnd_1_3 VGND VPWR sky130_fd_sc_hd__tapvpwrvgnd_1
* cell instance sky130_fd_sc_hd__tapvpwrvgnd_1_4 r0 *1 0,0
Xsky130_fd_sc_hd__tapvpwrvgnd_1_4 VGND VPWR sky130_fd_sc_hd__tapvpwrvgnd_1
* cell instance sky130_fd_sc_hd__tapvpwrvgnd_1_5 r0 *1 0,0
Xsky130_fd_sc_hd__tapvpwrvgnd_1_5 VGND VPWR sky130_fd_sc_hd__tapvpwrvgnd_1
* cell instance sky130_fd_sc_hd__tapvpwrvgnd_1_6 r0 *1 0,0
Xsky130_fd_sc_hd__tapvpwrvgnd_1_6 VGND VPWR sky130_fd_sc_hd__tapvpwrvgnd_1
* cell instance sky130_fd_sc_hd__tapvpwrvgnd_1_7 r0 *1 0,0
Xsky130_fd_sc_hd__tapvpwrvgnd_1_7 VGND VPWR sky130_fd_sc_hd__tapvpwrvgnd_1
* cell instance sky130_fd_sc_hd__tapvpwrvgnd_1_8 r0 *1 0,0
Xsky130_fd_sc_hd__tapvpwrvgnd_1_8 VGND VPWR sky130_fd_sc_hd__tapvpwrvgnd_1
* cell instance sky130_fd_sc_hd__tapvpwrvgnd_1_9 r0 *1 0,0
Xsky130_fd_sc_hd__tapvpwrvgnd_1_9 VGND VPWR sky130_fd_sc_hd__tapvpwrvgnd_1
* cell instance sky130_fd_sc_hd__tapvpwrvgnd_1_10 r0 *1 0,0
Xsky130_fd_sc_hd__tapvpwrvgnd_1_10 VGND VPWR sky130_fd_sc_hd__tapvpwrvgnd_1
* cell instance sky130_fd_sc_hd__tapvpwrvgnd_1_11 r0 *1 0,0
Xsky130_fd_sc_hd__tapvpwrvgnd_1_11 VGND VPWR sky130_fd_sc_hd__tapvpwrvgnd_1
* cell instance sky130_fd_sc_hd__tapvpwrvgnd_1_12 r0 *1 0,0
Xsky130_fd_sc_hd__tapvpwrvgnd_1_12 VGND VPWR sky130_fd_sc_hd__tapvpwrvgnd_1
* cell instance sky130_fd_sc_hd__tapvpwrvgnd_1_13 r0 *1 0,0
Xsky130_fd_sc_hd__tapvpwrvgnd_1_13 VGND VPWR sky130_fd_sc_hd__tapvpwrvgnd_1
* cell instance sky130_fd_sc_hd__tapvpwrvgnd_1_14 r0 *1 0,0
Xsky130_fd_sc_hd__tapvpwrvgnd_1_14 VGND VPWR sky130_fd_sc_hd__tapvpwrvgnd_1
* cell instance sky130_fd_sc_hd__tapvpwrvgnd_1_15 r0 *1 0,0
Xsky130_fd_sc_hd__tapvpwrvgnd_1_15 VGND VPWR sky130_fd_sc_hd__tapvpwrvgnd_1
* cell instance sky130_fd_sc_hd__tapvpwrvgnd_1_16 r0 *1 0,0
Xsky130_fd_sc_hd__tapvpwrvgnd_1_16 VGND VPWR sky130_fd_sc_hd__tapvpwrvgnd_1
* cell instance sky130_fd_sc_hd__tapvpwrvgnd_1_17 r0 *1 0,0
Xsky130_fd_sc_hd__tapvpwrvgnd_1_17 VGND VPWR sky130_fd_sc_hd__tapvpwrvgnd_1
* cell instance sky130_fd_sc_hd__tapvpwrvgnd_1_18 r0 *1 0,0
Xsky130_fd_sc_hd__tapvpwrvgnd_1_18 VGND VPWR sky130_fd_sc_hd__tapvpwrvgnd_1
* cell instance sky130_fd_sc_hd__tapvpwrvgnd_1_19 r0 *1 0,0
Xsky130_fd_sc_hd__tapvpwrvgnd_1_19 VGND VPWR sky130_fd_sc_hd__tapvpwrvgnd_1
* cell instance sky130_fd_sc_hd__tapvpwrvgnd_1_20 r0 *1 0,0
Xsky130_fd_sc_hd__tapvpwrvgnd_1_20 VGND VPWR sky130_fd_sc_hd__tapvpwrvgnd_1
* cell instance sky130_fd_sc_hd__tapvpwrvgnd_1_21 r0 *1 0,0
Xsky130_fd_sc_hd__tapvpwrvgnd_1_21 VGND VPWR sky130_fd_sc_hd__tapvpwrvgnd_1
* cell instance sky130_fd_sc_hd__tapvpwrvgnd_1_22 r0 *1 0,0
Xsky130_fd_sc_hd__tapvpwrvgnd_1_22 VGND VPWR sky130_fd_sc_hd__tapvpwrvgnd_1
* cell instance sky130_fd_sc_hd__tapvpwrvgnd_1_23 r0 *1 0,0
Xsky130_fd_sc_hd__tapvpwrvgnd_1_23 VGND VPWR sky130_fd_sc_hd__tapvpwrvgnd_1
* cell instance sky130_fd_sc_hd__tapvpwrvgnd_1_24 r0 *1 0,0
Xsky130_fd_sc_hd__tapvpwrvgnd_1_24 VGND VPWR sky130_fd_sc_hd__tapvpwrvgnd_1
* cell instance sky130_fd_sc_hd__tapvpwrvgnd_1_25 r0 *1 0,0
Xsky130_fd_sc_hd__tapvpwrvgnd_1_25 VGND VPWR sky130_fd_sc_hd__tapvpwrvgnd_1
* cell instance sky130_fd_sc_hd__tapvpwrvgnd_1_26 r0 *1 0,0
Xsky130_fd_sc_hd__tapvpwrvgnd_1_26 VGND VPWR sky130_fd_sc_hd__tapvpwrvgnd_1
* cell instance sky130_fd_sc_hd__tapvpwrvgnd_1_27 r0 *1 0,0
Xsky130_fd_sc_hd__tapvpwrvgnd_1_27 VGND VPWR sky130_fd_sc_hd__tapvpwrvgnd_1
* cell instance sky130_fd_sc_hd__tapvpwrvgnd_1_28 r0 *1 0,0
Xsky130_fd_sc_hd__tapvpwrvgnd_1_28 VGND VPWR sky130_fd_sc_hd__tapvpwrvgnd_1
* cell instance sky130_fd_sc_hd__tapvpwrvgnd_1_29 r0 *1 0,0
Xsky130_fd_sc_hd__tapvpwrvgnd_1_29 VGND VPWR sky130_fd_sc_hd__tapvpwrvgnd_1
* cell instance sky130_fd_sc_hd__tapvpwrvgnd_1_30 r0 *1 0,0
Xsky130_fd_sc_hd__tapvpwrvgnd_1_30 VGND VPWR sky130_fd_sc_hd__tapvpwrvgnd_1
* cell instance sky130_fd_sc_hd__tapvpwrvgnd_1_31 r0 *1 0,0
Xsky130_fd_sc_hd__tapvpwrvgnd_1_31 VGND VPWR sky130_fd_sc_hd__tapvpwrvgnd_1
* cell instance sky130_fd_sc_hd__tapvpwrvgnd_1_32 r0 *1 0,0
Xsky130_fd_sc_hd__tapvpwrvgnd_1_32 VGND VPWR sky130_fd_sc_hd__tapvpwrvgnd_1
* cell instance sky130_fd_sc_hd__tapvpwrvgnd_1_33 r0 *1 0,0
Xsky130_fd_sc_hd__tapvpwrvgnd_1_33 VGND VPWR sky130_fd_sc_hd__tapvpwrvgnd_1
* cell instance sky130_fd_sc_hd__tapvpwrvgnd_1_34 r0 *1 0,0
Xsky130_fd_sc_hd__tapvpwrvgnd_1_34 VGND VPWR sky130_fd_sc_hd__tapvpwrvgnd_1
* cell instance sky130_fd_sc_hd__tapvpwrvgnd_1_35 r0 *1 0,0
Xsky130_fd_sc_hd__tapvpwrvgnd_1_35 VGND VPWR sky130_fd_sc_hd__tapvpwrvgnd_1
* cell instance sky130_fd_sc_hd__tapvpwrvgnd_1_36 r0 *1 0,0
Xsky130_fd_sc_hd__tapvpwrvgnd_1_36 VGND VPWR sky130_fd_sc_hd__tapvpwrvgnd_1
* cell instance sky130_fd_sc_hd__tapvpwrvgnd_1_37 r0 *1 0,0
Xsky130_fd_sc_hd__tapvpwrvgnd_1_37 VGND VPWR sky130_fd_sc_hd__tapvpwrvgnd_1
* cell instance sky130_fd_sc_hd__tapvpwrvgnd_1_38 r0 *1 0,0
Xsky130_fd_sc_hd__tapvpwrvgnd_1_38 VGND VPWR sky130_fd_sc_hd__tapvpwrvgnd_1
* cell instance sky130_fd_sc_hd__tapvpwrvgnd_1_39 r0 *1 0,0
Xsky130_fd_sc_hd__tapvpwrvgnd_1_39 VGND VPWR sky130_fd_sc_hd__tapvpwrvgnd_1
* cell instance sky130_fd_sc_hd__tapvpwrvgnd_1_40 r0 *1 0,0
Xsky130_fd_sc_hd__tapvpwrvgnd_1_40 VGND VPWR sky130_fd_sc_hd__tapvpwrvgnd_1
* cell instance sky130_fd_sc_hd__tapvpwrvgnd_1_41 r0 *1 0,0
Xsky130_fd_sc_hd__tapvpwrvgnd_1_41 VGND VPWR sky130_fd_sc_hd__tapvpwrvgnd_1
* cell instance sky130_fd_sc_hd__tapvpwrvgnd_1_42 r0 *1 0,0
Xsky130_fd_sc_hd__tapvpwrvgnd_1_42 VGND VPWR sky130_fd_sc_hd__tapvpwrvgnd_1
* cell instance sky130_fd_sc_hd__tapvpwrvgnd_1_43 r0 *1 0,0
Xsky130_fd_sc_hd__tapvpwrvgnd_1_43 VGND VPWR sky130_fd_sc_hd__tapvpwrvgnd_1
* cell instance sky130_fd_sc_hd__tapvpwrvgnd_1_44 r0 *1 0,0
Xsky130_fd_sc_hd__tapvpwrvgnd_1_44 VGND VPWR sky130_fd_sc_hd__tapvpwrvgnd_1
* cell instance sky130_fd_sc_hd__tapvpwrvgnd_1_45 r0 *1 0,0
Xsky130_fd_sc_hd__tapvpwrvgnd_1_45 VGND VPWR sky130_fd_sc_hd__tapvpwrvgnd_1
* cell instance sky130_fd_sc_hd__tapvpwrvgnd_1_46 r0 *1 0,0
Xsky130_fd_sc_hd__tapvpwrvgnd_1_46 VGND VPWR sky130_fd_sc_hd__tapvpwrvgnd_1
* cell instance sky130_fd_sc_hd__tapvpwrvgnd_1_47 r0 *1 0,0
Xsky130_fd_sc_hd__tapvpwrvgnd_1_47 VGND VPWR sky130_fd_sc_hd__tapvpwrvgnd_1
* cell instance sky130_fd_sc_hd__tapvpwrvgnd_1_48 r0 *1 0,0
Xsky130_fd_sc_hd__tapvpwrvgnd_1_48 VGND VPWR sky130_fd_sc_hd__tapvpwrvgnd_1
* cell instance sky130_fd_sc_hd__tapvpwrvgnd_1_49 r0 *1 0,0
Xsky130_fd_sc_hd__tapvpwrvgnd_1_49 VGND VPWR sky130_fd_sc_hd__tapvpwrvgnd_1
* cell instance sky130_fd_sc_hd__tapvpwrvgnd_1_50 r0 *1 0,0
Xsky130_fd_sc_hd__tapvpwrvgnd_1_50 VGND VPWR sky130_fd_sc_hd__tapvpwrvgnd_1
* cell instance sky130_fd_sc_hd__tapvpwrvgnd_1_51 r0 *1 0,0
Xsky130_fd_sc_hd__tapvpwrvgnd_1_51 VGND VPWR sky130_fd_sc_hd__tapvpwrvgnd_1
* cell instance sky130_fd_sc_hd__tapvpwrvgnd_1_52 r0 *1 0,0
Xsky130_fd_sc_hd__tapvpwrvgnd_1_52 VGND VPWR sky130_fd_sc_hd__tapvpwrvgnd_1
* cell instance sky130_fd_sc_hd__tapvpwrvgnd_1_53 r0 *1 0,0
Xsky130_fd_sc_hd__tapvpwrvgnd_1_53 VGND VPWR sky130_fd_sc_hd__tapvpwrvgnd_1
* cell instance sky130_fd_sc_hd__tapvpwrvgnd_1_54 r0 *1 0,0
Xsky130_fd_sc_hd__tapvpwrvgnd_1_54 VGND VPWR sky130_fd_sc_hd__tapvpwrvgnd_1
* cell instance sky130_fd_sc_hd__tapvpwrvgnd_1_55 r0 *1 0,0
Xsky130_fd_sc_hd__tapvpwrvgnd_1_55 VGND VPWR sky130_fd_sc_hd__tapvpwrvgnd_1
* cell instance sky130_fd_sc_hd__tapvpwrvgnd_1_56 r0 *1 0,0
Xsky130_fd_sc_hd__tapvpwrvgnd_1_56 VGND VPWR sky130_fd_sc_hd__tapvpwrvgnd_1
* cell instance sky130_fd_sc_hd__tapvpwrvgnd_1_57 r0 *1 0,0
Xsky130_fd_sc_hd__tapvpwrvgnd_1_57 VGND VPWR sky130_fd_sc_hd__tapvpwrvgnd_1
* cell instance sky130_fd_sc_hd__tapvpwrvgnd_1_58 r0 *1 0,0
Xsky130_fd_sc_hd__tapvpwrvgnd_1_58 VGND VPWR sky130_fd_sc_hd__tapvpwrvgnd_1
* cell instance sky130_fd_sc_hd__tapvpwrvgnd_1_59 r0 *1 0,0
Xsky130_fd_sc_hd__tapvpwrvgnd_1_59 VGND VPWR sky130_fd_sc_hd__tapvpwrvgnd_1
* cell instance sky130_fd_sc_hd__tapvpwrvgnd_1_60 r0 *1 0,0
Xsky130_fd_sc_hd__tapvpwrvgnd_1_60 VGND VPWR sky130_fd_sc_hd__tapvpwrvgnd_1
* cell instance sky130_fd_sc_hd__tapvpwrvgnd_1_61 r0 *1 0,0
Xsky130_fd_sc_hd__tapvpwrvgnd_1_61 VGND VPWR sky130_fd_sc_hd__tapvpwrvgnd_1
* cell instance sky130_fd_sc_hd__tapvpwrvgnd_1_62 r0 *1 0,0
Xsky130_fd_sc_hd__tapvpwrvgnd_1_62 VGND VPWR sky130_fd_sc_hd__tapvpwrvgnd_1
* cell instance sky130_fd_sc_hd__tapvpwrvgnd_1_63 r0 *1 0,0
Xsky130_fd_sc_hd__tapvpwrvgnd_1_63 VGND VPWR sky130_fd_sc_hd__tapvpwrvgnd_1
* cell instance sky130_fd_sc_hd__tapvpwrvgnd_1_64 r0 *1 0,0
Xsky130_fd_sc_hd__tapvpwrvgnd_1_64 VGND VPWR sky130_fd_sc_hd__tapvpwrvgnd_1
* cell instance sky130_fd_sc_hd__tapvpwrvgnd_1_65 r0 *1 0,0
Xsky130_fd_sc_hd__tapvpwrvgnd_1_65 VGND VPWR sky130_fd_sc_hd__tapvpwrvgnd_1
* cell instance sky130_fd_sc_hd__tapvpwrvgnd_1_66 r0 *1 0,0
Xsky130_fd_sc_hd__tapvpwrvgnd_1_66 VGND VPWR sky130_fd_sc_hd__tapvpwrvgnd_1
* cell instance sky130_fd_sc_hd__tapvpwrvgnd_1_67 r0 *1 0,0
Xsky130_fd_sc_hd__tapvpwrvgnd_1_67 VGND VPWR sky130_fd_sc_hd__tapvpwrvgnd_1
* cell instance sky130_fd_sc_hd__tapvpwrvgnd_1_68 r0 *1 0,0
Xsky130_fd_sc_hd__tapvpwrvgnd_1_68 VGND VPWR sky130_fd_sc_hd__tapvpwrvgnd_1
* cell instance sky130_fd_sc_hd__tapvpwrvgnd_1_69 r0 *1 0,0
Xsky130_fd_sc_hd__tapvpwrvgnd_1_69 VGND VPWR sky130_fd_sc_hd__tapvpwrvgnd_1
* cell instance sky130_fd_sc_hd__tapvpwrvgnd_1_70 r0 *1 0,0
Xsky130_fd_sc_hd__tapvpwrvgnd_1_70 VGND VPWR sky130_fd_sc_hd__tapvpwrvgnd_1
* cell instance sky130_fd_sc_hd__tapvpwrvgnd_1_71 r0 *1 0,0
Xsky130_fd_sc_hd__tapvpwrvgnd_1_71 VGND VPWR sky130_fd_sc_hd__tapvpwrvgnd_1
* cell instance sky130_fd_sc_hd__tapvpwrvgnd_1_72 r0 *1 0,0
Xsky130_fd_sc_hd__tapvpwrvgnd_1_72 VGND VPWR sky130_fd_sc_hd__tapvpwrvgnd_1
* cell instance sky130_fd_sc_hd__tapvpwrvgnd_1_73 r0 *1 0,0
Xsky130_fd_sc_hd__tapvpwrvgnd_1_73 VGND VPWR sky130_fd_sc_hd__tapvpwrvgnd_1
* cell instance sky130_fd_sc_hd__tapvpwrvgnd_1_74 r0 *1 0,0
Xsky130_fd_sc_hd__tapvpwrvgnd_1_74 VGND VPWR sky130_fd_sc_hd__tapvpwrvgnd_1
* cell instance sky130_fd_sc_hd__tapvpwrvgnd_1_75 r0 *1 0,0
Xsky130_fd_sc_hd__tapvpwrvgnd_1_75 VGND VPWR sky130_fd_sc_hd__tapvpwrvgnd_1
* cell instance sky130_fd_sc_hd__tapvpwrvgnd_1_76 r0 *1 0,0
Xsky130_fd_sc_hd__tapvpwrvgnd_1_76 VGND VPWR sky130_fd_sc_hd__tapvpwrvgnd_1
* cell instance sky130_fd_sc_hd__tapvpwrvgnd_1_77 r0 *1 0,0
Xsky130_fd_sc_hd__tapvpwrvgnd_1_77 VGND VPWR sky130_fd_sc_hd__tapvpwrvgnd_1
* cell instance sky130_fd_sc_hd__tapvpwrvgnd_1_78 r0 *1 0,0
Xsky130_fd_sc_hd__tapvpwrvgnd_1_78 VGND VPWR sky130_fd_sc_hd__tapvpwrvgnd_1
* cell instance sky130_fd_sc_hd__tapvpwrvgnd_1_79 r0 *1 0,0
Xsky130_fd_sc_hd__tapvpwrvgnd_1_79 VGND VPWR sky130_fd_sc_hd__tapvpwrvgnd_1
* cell instance sky130_fd_sc_hd__tapvpwrvgnd_1_80 r0 *1 0,0
Xsky130_fd_sc_hd__tapvpwrvgnd_1_80 VGND VPWR sky130_fd_sc_hd__tapvpwrvgnd_1
* cell instance sky130_fd_sc_hd__tapvpwrvgnd_1_81 r0 *1 0,0
Xsky130_fd_sc_hd__tapvpwrvgnd_1_81 VGND VPWR sky130_fd_sc_hd__tapvpwrvgnd_1
* cell instance sky130_fd_sc_hd__tapvpwrvgnd_1_82 r0 *1 0,0
Xsky130_fd_sc_hd__tapvpwrvgnd_1_82 VGND VPWR sky130_fd_sc_hd__tapvpwrvgnd_1
* cell instance sky130_fd_sc_hd__tapvpwrvgnd_1_83 r0 *1 0,0
Xsky130_fd_sc_hd__tapvpwrvgnd_1_83 VGND VPWR sky130_fd_sc_hd__tapvpwrvgnd_1
* cell instance sky130_fd_sc_hd__tapvpwrvgnd_1_84 r0 *1 0,0
Xsky130_fd_sc_hd__tapvpwrvgnd_1_84 VGND VPWR sky130_fd_sc_hd__tapvpwrvgnd_1
* cell instance sky130_fd_sc_hd__tapvpwrvgnd_1_85 r0 *1 0,0
Xsky130_fd_sc_hd__tapvpwrvgnd_1_85 VGND VPWR sky130_fd_sc_hd__tapvpwrvgnd_1
* cell instance sky130_fd_sc_hd__tapvpwrvgnd_1_86 r0 *1 0,0
Xsky130_fd_sc_hd__tapvpwrvgnd_1_86 VGND VPWR sky130_fd_sc_hd__tapvpwrvgnd_1
* cell instance sky130_fd_sc_hd__tapvpwrvgnd_1_87 r0 *1 0,0
Xsky130_fd_sc_hd__tapvpwrvgnd_1_87 VGND VPWR sky130_fd_sc_hd__tapvpwrvgnd_1
* cell instance sky130_fd_sc_hd__tapvpwrvgnd_1_88 r0 *1 0,0
Xsky130_fd_sc_hd__tapvpwrvgnd_1_88 VGND VPWR sky130_fd_sc_hd__tapvpwrvgnd_1
* cell instance sky130_fd_sc_hd__tapvpwrvgnd_1_89 r0 *1 0,0
Xsky130_fd_sc_hd__tapvpwrvgnd_1_89 VGND VPWR sky130_fd_sc_hd__tapvpwrvgnd_1
* cell instance sky130_fd_sc_hd__tapvpwrvgnd_1_90 r0 *1 0,0
Xsky130_fd_sc_hd__tapvpwrvgnd_1_90 VGND VPWR sky130_fd_sc_hd__tapvpwrvgnd_1
* cell instance sky130_fd_sc_hd__tapvpwrvgnd_1_91 r0 *1 0,0
Xsky130_fd_sc_hd__tapvpwrvgnd_1_91 VGND VPWR sky130_fd_sc_hd__tapvpwrvgnd_1
* cell instance sky130_fd_sc_hd__tapvpwrvgnd_1_92 r0 *1 0,0
Xsky130_fd_sc_hd__tapvpwrvgnd_1_92 VGND VPWR sky130_fd_sc_hd__tapvpwrvgnd_1
* cell instance sky130_fd_sc_hd__tapvpwrvgnd_1_93 r0 *1 0,0
Xsky130_fd_sc_hd__tapvpwrvgnd_1_93 VGND VPWR sky130_fd_sc_hd__tapvpwrvgnd_1
* cell instance sky130_fd_sc_hd__tapvpwrvgnd_1_94 r0 *1 0,0
Xsky130_fd_sc_hd__tapvpwrvgnd_1_94 VGND VPWR sky130_fd_sc_hd__tapvpwrvgnd_1
* cell instance sky130_fd_sc_hd__tapvpwrvgnd_1_95 r0 *1 0,0
Xsky130_fd_sc_hd__tapvpwrvgnd_1_95 VGND VPWR sky130_fd_sc_hd__tapvpwrvgnd_1
* cell instance sky130_fd_sc_hd__tapvpwrvgnd_1_96 r0 *1 0,0
Xsky130_fd_sc_hd__tapvpwrvgnd_1_96 VGND VPWR sky130_fd_sc_hd__tapvpwrvgnd_1
* cell instance sky130_fd_sc_hd__tapvpwrvgnd_1_97 r0 *1 0,0
Xsky130_fd_sc_hd__tapvpwrvgnd_1_97 VGND VPWR sky130_fd_sc_hd__tapvpwrvgnd_1
* cell instance sky130_fd_sc_hd__tapvpwrvgnd_1_98 r0 *1 0,0
Xsky130_fd_sc_hd__tapvpwrvgnd_1_98 VGND VPWR sky130_fd_sc_hd__tapvpwrvgnd_1
* cell instance sky130_fd_sc_hd__tapvpwrvgnd_1_99 r0 *1 0,0
Xsky130_fd_sc_hd__tapvpwrvgnd_1_99 VGND VPWR sky130_fd_sc_hd__tapvpwrvgnd_1
* cell instance sky130_fd_sc_hd__tapvpwrvgnd_1_100 r0 *1 0,0
Xsky130_fd_sc_hd__tapvpwrvgnd_1_100 VGND VPWR sky130_fd_sc_hd__tapvpwrvgnd_1
* cell instance sky130_fd_sc_hd__tapvpwrvgnd_1_101 r0 *1 0,0
Xsky130_fd_sc_hd__tapvpwrvgnd_1_101 VGND VPWR sky130_fd_sc_hd__tapvpwrvgnd_1
* cell instance sky130_fd_sc_hd__tapvpwrvgnd_1_102 r0 *1 0,0
Xsky130_fd_sc_hd__tapvpwrvgnd_1_102 VGND VPWR sky130_fd_sc_hd__tapvpwrvgnd_1
* cell instance sky130_fd_sc_hd__tapvpwrvgnd_1_103 r0 *1 0,0
Xsky130_fd_sc_hd__tapvpwrvgnd_1_103 VGND VPWR sky130_fd_sc_hd__tapvpwrvgnd_1
* cell instance sky130_fd_sc_hd__tapvpwrvgnd_1_104 r0 *1 0,0
Xsky130_fd_sc_hd__tapvpwrvgnd_1_104 VGND VPWR sky130_fd_sc_hd__tapvpwrvgnd_1
* cell instance sky130_fd_sc_hd__tapvpwrvgnd_1_105 r0 *1 0,0
Xsky130_fd_sc_hd__tapvpwrvgnd_1_105 VGND VPWR sky130_fd_sc_hd__tapvpwrvgnd_1
* cell instance sky130_fd_sc_hd__tapvpwrvgnd_1_106 r0 *1 0,0
Xsky130_fd_sc_hd__tapvpwrvgnd_1_106 VGND VPWR sky130_fd_sc_hd__tapvpwrvgnd_1
* cell instance sky130_fd_sc_hd__tapvpwrvgnd_1_107 r0 *1 0,0
Xsky130_fd_sc_hd__tapvpwrvgnd_1_107 VGND VPWR sky130_fd_sc_hd__tapvpwrvgnd_1
* cell instance sky130_fd_sc_hd__tapvpwrvgnd_1_108 r0 *1 0,0
Xsky130_fd_sc_hd__tapvpwrvgnd_1_108 VGND VPWR sky130_fd_sc_hd__tapvpwrvgnd_1
* cell instance sky130_fd_sc_hd__tapvpwrvgnd_1_109 r0 *1 0,0
Xsky130_fd_sc_hd__tapvpwrvgnd_1_109 VGND VPWR sky130_fd_sc_hd__tapvpwrvgnd_1
* cell instance sky130_fd_sc_hd__tapvpwrvgnd_1_110 r0 *1 0,0
Xsky130_fd_sc_hd__tapvpwrvgnd_1_110 VGND VPWR sky130_fd_sc_hd__tapvpwrvgnd_1
* cell instance sky130_fd_sc_hd__tapvpwrvgnd_1_111 r0 *1 0,0
Xsky130_fd_sc_hd__tapvpwrvgnd_1_111 VGND VPWR sky130_fd_sc_hd__tapvpwrvgnd_1
* cell instance sky130_fd_sc_hd__tapvpwrvgnd_1_112 r0 *1 0,0
Xsky130_fd_sc_hd__tapvpwrvgnd_1_112 VGND VPWR sky130_fd_sc_hd__tapvpwrvgnd_1
* cell instance sky130_fd_sc_hd__tapvpwrvgnd_1_113 r0 *1 0,0
Xsky130_fd_sc_hd__tapvpwrvgnd_1_113 VGND VPWR sky130_fd_sc_hd__tapvpwrvgnd_1
* cell instance sky130_fd_sc_hd__tapvpwrvgnd_1_114 r0 *1 0,0
Xsky130_fd_sc_hd__tapvpwrvgnd_1_114 VGND VPWR sky130_fd_sc_hd__tapvpwrvgnd_1
* cell instance sky130_fd_sc_hd__tapvpwrvgnd_1_115 r0 *1 0,0
Xsky130_fd_sc_hd__tapvpwrvgnd_1_115 VGND VPWR sky130_fd_sc_hd__tapvpwrvgnd_1
* cell instance sky130_fd_sc_hd__tapvpwrvgnd_1_116 r0 *1 0,0
Xsky130_fd_sc_hd__tapvpwrvgnd_1_116 VGND VPWR sky130_fd_sc_hd__tapvpwrvgnd_1
* cell instance sky130_fd_sc_hd__tapvpwrvgnd_1_117 r0 *1 0,0
Xsky130_fd_sc_hd__tapvpwrvgnd_1_117 VGND VPWR sky130_fd_sc_hd__tapvpwrvgnd_1
* cell instance sky130_fd_sc_hd__tapvpwrvgnd_1_118 r0 *1 0,0
Xsky130_fd_sc_hd__tapvpwrvgnd_1_118 VGND VPWR sky130_fd_sc_hd__tapvpwrvgnd_1
* cell instance sky130_fd_sc_hd__tapvpwrvgnd_1_119 r0 *1 0,0
Xsky130_fd_sc_hd__tapvpwrvgnd_1_119 VGND VPWR sky130_fd_sc_hd__tapvpwrvgnd_1
* cell instance sky130_fd_sc_hd__tapvpwrvgnd_1_120 r0 *1 0,0
Xsky130_fd_sc_hd__tapvpwrvgnd_1_120 VGND VPWR sky130_fd_sc_hd__tapvpwrvgnd_1
* cell instance sky130_fd_sc_hd__tapvpwrvgnd_1_121 r0 *1 0,0
Xsky130_fd_sc_hd__tapvpwrvgnd_1_121 VGND VPWR sky130_fd_sc_hd__tapvpwrvgnd_1
* cell instance sky130_fd_sc_hd__tapvpwrvgnd_1_122 r0 *1 0,0
Xsky130_fd_sc_hd__tapvpwrvgnd_1_122 VGND VPWR sky130_fd_sc_hd__tapvpwrvgnd_1
* cell instance sky130_fd_sc_hd__tapvpwrvgnd_1_123 r0 *1 0,0
Xsky130_fd_sc_hd__tapvpwrvgnd_1_123 VGND VPWR sky130_fd_sc_hd__tapvpwrvgnd_1
* cell instance sky130_fd_sc_hd__tapvpwrvgnd_1_124 r0 *1 0,0
Xsky130_fd_sc_hd__tapvpwrvgnd_1_124 VGND VPWR sky130_fd_sc_hd__tapvpwrvgnd_1
* cell instance sky130_fd_sc_hd__tapvpwrvgnd_1_125 r0 *1 0,0
Xsky130_fd_sc_hd__tapvpwrvgnd_1_125 VGND VPWR sky130_fd_sc_hd__tapvpwrvgnd_1
* cell instance sky130_fd_sc_hd__tapvpwrvgnd_1_126 r0 *1 0,0
Xsky130_fd_sc_hd__tapvpwrvgnd_1_126 VGND VPWR sky130_fd_sc_hd__tapvpwrvgnd_1
* cell instance sky130_fd_sc_hd__tapvpwrvgnd_1_127 r0 *1 0,0
Xsky130_fd_sc_hd__tapvpwrvgnd_1_127 VGND VPWR sky130_fd_sc_hd__tapvpwrvgnd_1
* cell instance sky130_fd_sc_hd__tapvpwrvgnd_1_128 r0 *1 0,0
Xsky130_fd_sc_hd__tapvpwrvgnd_1_128 VGND VPWR sky130_fd_sc_hd__tapvpwrvgnd_1
* cell instance sky130_fd_sc_hd__tapvpwrvgnd_1_129 r0 *1 0,0
Xsky130_fd_sc_hd__tapvpwrvgnd_1_129 VGND VPWR sky130_fd_sc_hd__tapvpwrvgnd_1
* cell instance sky130_fd_sc_hd__tapvpwrvgnd_1_130 r0 *1 0,0
Xsky130_fd_sc_hd__tapvpwrvgnd_1_130 VGND VPWR sky130_fd_sc_hd__tapvpwrvgnd_1
* cell instance sky130_fd_sc_hd__tapvpwrvgnd_1_131 r0 *1 0,0
Xsky130_fd_sc_hd__tapvpwrvgnd_1_131 VGND VPWR sky130_fd_sc_hd__tapvpwrvgnd_1
* cell instance sky130_fd_sc_hd__tapvpwrvgnd_1_132 r0 *1 0,0
Xsky130_fd_sc_hd__tapvpwrvgnd_1_132 VGND VPWR sky130_fd_sc_hd__tapvpwrvgnd_1
* cell instance sky130_fd_sc_hd__tapvpwrvgnd_1_133 r0 *1 0,0
Xsky130_fd_sc_hd__tapvpwrvgnd_1_133 VGND VPWR sky130_fd_sc_hd__tapvpwrvgnd_1
* cell instance sky130_fd_sc_hd__tapvpwrvgnd_1_134 r0 *1 0,0
Xsky130_fd_sc_hd__tapvpwrvgnd_1_134 VGND VPWR sky130_fd_sc_hd__tapvpwrvgnd_1
* cell instance sky130_fd_sc_hd__tapvpwrvgnd_1_135 r0 *1 0,0
Xsky130_fd_sc_hd__tapvpwrvgnd_1_135 VGND VPWR sky130_fd_sc_hd__tapvpwrvgnd_1
* cell instance sky130_fd_sc_hd__tapvpwrvgnd_1_136 r0 *1 0,0
Xsky130_fd_sc_hd__tapvpwrvgnd_1_136 VGND VPWR sky130_fd_sc_hd__tapvpwrvgnd_1
* cell instance sky130_fd_sc_hd__tapvpwrvgnd_1_137 r0 *1 0,0
Xsky130_fd_sc_hd__tapvpwrvgnd_1_137 VGND VPWR sky130_fd_sc_hd__tapvpwrvgnd_1
* cell instance sky130_fd_sc_hd__tapvpwrvgnd_1_138 r0 *1 0,0
Xsky130_fd_sc_hd__tapvpwrvgnd_1_138 VGND VPWR sky130_fd_sc_hd__tapvpwrvgnd_1
* cell instance sky130_fd_sc_hd__tapvpwrvgnd_1_139 r0 *1 0,0
Xsky130_fd_sc_hd__tapvpwrvgnd_1_139 VGND VPWR sky130_fd_sc_hd__tapvpwrvgnd_1
* cell instance sky130_fd_sc_hd__tapvpwrvgnd_1_140 r0 *1 0,0
Xsky130_fd_sc_hd__tapvpwrvgnd_1_140 VGND VPWR sky130_fd_sc_hd__tapvpwrvgnd_1
* cell instance sky130_fd_sc_hd__tapvpwrvgnd_1_141 r0 *1 0,0
Xsky130_fd_sc_hd__tapvpwrvgnd_1_141 VGND VPWR sky130_fd_sc_hd__tapvpwrvgnd_1
* cell instance sky130_fd_sc_hd__tapvpwrvgnd_1_142 r0 *1 0,0
Xsky130_fd_sc_hd__tapvpwrvgnd_1_142 VGND VPWR sky130_fd_sc_hd__tapvpwrvgnd_1
* cell instance sky130_fd_sc_hd__tapvpwrvgnd_1_143 r0 *1 0,0
Xsky130_fd_sc_hd__tapvpwrvgnd_1_143 VGND VPWR sky130_fd_sc_hd__tapvpwrvgnd_1
* cell instance sky130_fd_sc_hd__tapvpwrvgnd_1_144 r0 *1 0,0
Xsky130_fd_sc_hd__tapvpwrvgnd_1_144 VGND VPWR sky130_fd_sc_hd__tapvpwrvgnd_1
* cell instance sky130_fd_sc_hd__tapvpwrvgnd_1_145 r0 *1 0,0
Xsky130_fd_sc_hd__tapvpwrvgnd_1_145 VGND VPWR sky130_fd_sc_hd__tapvpwrvgnd_1
* cell instance sky130_fd_sc_hd__tapvpwrvgnd_1_146 r0 *1 0,0
Xsky130_fd_sc_hd__tapvpwrvgnd_1_146 VGND VPWR sky130_fd_sc_hd__tapvpwrvgnd_1
* cell instance sky130_fd_sc_hd__tapvpwrvgnd_1_147 r0 *1 0,0
Xsky130_fd_sc_hd__tapvpwrvgnd_1_147 VGND VPWR sky130_fd_sc_hd__tapvpwrvgnd_1
* cell instance sky130_fd_sc_hd__tapvpwrvgnd_1_148 r0 *1 0,0
Xsky130_fd_sc_hd__tapvpwrvgnd_1_148 VGND VPWR sky130_fd_sc_hd__tapvpwrvgnd_1
* cell instance sky130_fd_sc_hd__tapvpwrvgnd_1_149 r0 *1 0,0
Xsky130_fd_sc_hd__tapvpwrvgnd_1_149 VGND VPWR sky130_fd_sc_hd__tapvpwrvgnd_1
* cell instance sky130_fd_sc_hd__tapvpwrvgnd_1_150 r0 *1 0,0
Xsky130_fd_sc_hd__tapvpwrvgnd_1_150 VGND VPWR sky130_fd_sc_hd__tapvpwrvgnd_1
* cell instance sky130_fd_sc_hd__tapvpwrvgnd_1_151 r0 *1 0,0
Xsky130_fd_sc_hd__tapvpwrvgnd_1_151 VGND VPWR sky130_fd_sc_hd__tapvpwrvgnd_1
* cell instance sky130_fd_sc_hd__tapvpwrvgnd_1_152 r0 *1 0,0
Xsky130_fd_sc_hd__tapvpwrvgnd_1_152 VGND VPWR sky130_fd_sc_hd__tapvpwrvgnd_1
* cell instance sky130_fd_sc_hd__tapvpwrvgnd_1_153 r0 *1 0,0
Xsky130_fd_sc_hd__tapvpwrvgnd_1_153 VGND VPWR sky130_fd_sc_hd__tapvpwrvgnd_1
* cell instance sky130_fd_sc_hd__tapvpwrvgnd_1_154 r0 *1 0,0
Xsky130_fd_sc_hd__tapvpwrvgnd_1_154 VGND VPWR sky130_fd_sc_hd__tapvpwrvgnd_1
* cell instance sky130_fd_sc_hd__tapvpwrvgnd_1_155 r0 *1 0,0
Xsky130_fd_sc_hd__tapvpwrvgnd_1_155 VGND VPWR sky130_fd_sc_hd__tapvpwrvgnd_1
* cell instance sky130_fd_sc_hd__tapvpwrvgnd_1_156 r0 *1 0,0
Xsky130_fd_sc_hd__tapvpwrvgnd_1_156 VGND VPWR sky130_fd_sc_hd__tapvpwrvgnd_1
* cell instance sky130_fd_sc_hd__tapvpwrvgnd_1_157 r0 *1 0,0
Xsky130_fd_sc_hd__tapvpwrvgnd_1_157 VGND VPWR sky130_fd_sc_hd__tapvpwrvgnd_1
* cell instance sky130_fd_sc_hd__tapvpwrvgnd_1_158 r0 *1 0,0
Xsky130_fd_sc_hd__tapvpwrvgnd_1_158 VGND VPWR sky130_fd_sc_hd__tapvpwrvgnd_1
* cell instance sky130_fd_sc_hd__tapvpwrvgnd_1_159 r0 *1 0,0
Xsky130_fd_sc_hd__tapvpwrvgnd_1_159 VGND VPWR sky130_fd_sc_hd__tapvpwrvgnd_1
* cell instance sky130_fd_sc_hd__tapvpwrvgnd_1_160 r0 *1 0,0
Xsky130_fd_sc_hd__tapvpwrvgnd_1_160 VGND VPWR sky130_fd_sc_hd__tapvpwrvgnd_1
* cell instance sky130_fd_sc_hd__tapvpwrvgnd_1_161 r0 *1 0,0
Xsky130_fd_sc_hd__tapvpwrvgnd_1_161 VGND VPWR sky130_fd_sc_hd__tapvpwrvgnd_1
* cell instance sky130_fd_sc_hd__tapvpwrvgnd_1_162 r0 *1 0,0
Xsky130_fd_sc_hd__tapvpwrvgnd_1_162 VGND VPWR sky130_fd_sc_hd__tapvpwrvgnd_1
* cell instance sky130_fd_sc_hd__tapvpwrvgnd_1_163 r0 *1 0,0
Xsky130_fd_sc_hd__tapvpwrvgnd_1_163 VGND VPWR sky130_fd_sc_hd__tapvpwrvgnd_1
* cell instance sky130_fd_sc_hd__tapvpwrvgnd_1_164 r0 *1 0,0
Xsky130_fd_sc_hd__tapvpwrvgnd_1_164 VGND VPWR sky130_fd_sc_hd__tapvpwrvgnd_1
* cell instance sky130_fd_sc_hd__tapvpwrvgnd_1_165 r0 *1 0,0
Xsky130_fd_sc_hd__tapvpwrvgnd_1_165 VGND VPWR sky130_fd_sc_hd__tapvpwrvgnd_1
* cell instance sky130_fd_sc_hd__tapvpwrvgnd_1_166 r0 *1 0,0
Xsky130_fd_sc_hd__tapvpwrvgnd_1_166 VGND VPWR sky130_fd_sc_hd__tapvpwrvgnd_1
* cell instance sky130_fd_sc_hd__tapvpwrvgnd_1_167 r0 *1 0,0
Xsky130_fd_sc_hd__tapvpwrvgnd_1_167 VGND VPWR sky130_fd_sc_hd__tapvpwrvgnd_1
* cell instance sky130_fd_sc_hd__tapvpwrvgnd_1_168 r0 *1 0,0
Xsky130_fd_sc_hd__tapvpwrvgnd_1_168 VGND VPWR sky130_fd_sc_hd__tapvpwrvgnd_1
* cell instance sky130_fd_sc_hd__tapvpwrvgnd_1_169 r0 *1 0,0
Xsky130_fd_sc_hd__tapvpwrvgnd_1_169 VGND VPWR sky130_fd_sc_hd__tapvpwrvgnd_1
* cell instance sky130_fd_sc_hd__tapvpwrvgnd_1_170 r0 *1 0,0
Xsky130_fd_sc_hd__tapvpwrvgnd_1_170 VGND VPWR sky130_fd_sc_hd__tapvpwrvgnd_1
* cell instance sky130_fd_sc_hd__tapvpwrvgnd_1_171 r0 *1 0,0
Xsky130_fd_sc_hd__tapvpwrvgnd_1_171 VGND VPWR sky130_fd_sc_hd__tapvpwrvgnd_1
* cell instance sky130_fd_sc_hd__tapvpwrvgnd_1_172 r0 *1 0,0
Xsky130_fd_sc_hd__tapvpwrvgnd_1_172 VGND VPWR sky130_fd_sc_hd__tapvpwrvgnd_1
* cell instance sky130_fd_sc_hd__tapvpwrvgnd_1_173 r0 *1 0,0
Xsky130_fd_sc_hd__tapvpwrvgnd_1_173 VGND VPWR sky130_fd_sc_hd__tapvpwrvgnd_1
* cell instance sky130_fd_sc_hd__tapvpwrvgnd_1_174 r0 *1 0,0
Xsky130_fd_sc_hd__tapvpwrvgnd_1_174 VGND VPWR sky130_fd_sc_hd__tapvpwrvgnd_1
* cell instance sky130_fd_sc_hd__tapvpwrvgnd_1_175 r0 *1 0,0
Xsky130_fd_sc_hd__tapvpwrvgnd_1_175 VGND VPWR sky130_fd_sc_hd__tapvpwrvgnd_1
* cell instance sky130_fd_sc_hd__tapvpwrvgnd_1_176 r0 *1 0,0
Xsky130_fd_sc_hd__tapvpwrvgnd_1_176 VGND VPWR sky130_fd_sc_hd__tapvpwrvgnd_1
* cell instance sky130_fd_sc_hd__tapvpwrvgnd_1_177 r0 *1 0,0
Xsky130_fd_sc_hd__tapvpwrvgnd_1_177 VGND VPWR sky130_fd_sc_hd__tapvpwrvgnd_1
* cell instance sky130_fd_sc_hd__tapvpwrvgnd_1_178 r0 *1 0,0
Xsky130_fd_sc_hd__tapvpwrvgnd_1_178 VGND VPWR sky130_fd_sc_hd__tapvpwrvgnd_1
* cell instance sky130_fd_sc_hd__tapvpwrvgnd_1_179 r0 *1 0,0
Xsky130_fd_sc_hd__tapvpwrvgnd_1_179 VGND VPWR sky130_fd_sc_hd__tapvpwrvgnd_1
* cell instance sky130_fd_sc_hd__tapvpwrvgnd_1_180 r0 *1 0,0
Xsky130_fd_sc_hd__tapvpwrvgnd_1_180 VGND VPWR sky130_fd_sc_hd__tapvpwrvgnd_1
* cell instance sky130_fd_sc_hd__tapvpwrvgnd_1_181 r0 *1 0,0
Xsky130_fd_sc_hd__tapvpwrvgnd_1_181 VGND VPWR sky130_fd_sc_hd__tapvpwrvgnd_1
* cell instance sky130_fd_sc_hd__tapvpwrvgnd_1_182 r0 *1 0,0
Xsky130_fd_sc_hd__tapvpwrvgnd_1_182 VGND VPWR sky130_fd_sc_hd__tapvpwrvgnd_1
* cell instance sky130_fd_sc_hd__tapvpwrvgnd_1_183 r0 *1 0,0
Xsky130_fd_sc_hd__tapvpwrvgnd_1_183 VGND VPWR sky130_fd_sc_hd__tapvpwrvgnd_1
* cell instance sky130_fd_sc_hd__tapvpwrvgnd_1_184 r0 *1 0,0
Xsky130_fd_sc_hd__tapvpwrvgnd_1_184 VGND VPWR sky130_fd_sc_hd__tapvpwrvgnd_1
* cell instance sky130_fd_sc_hd__tapvpwrvgnd_1_185 r0 *1 0,0
Xsky130_fd_sc_hd__tapvpwrvgnd_1_185 VGND VPWR sky130_fd_sc_hd__tapvpwrvgnd_1
* cell instance sky130_fd_sc_hd__tapvpwrvgnd_1_186 r0 *1 0,0
Xsky130_fd_sc_hd__tapvpwrvgnd_1_186 VGND VPWR sky130_fd_sc_hd__tapvpwrvgnd_1
* cell instance sky130_fd_sc_hd__tapvpwrvgnd_1_187 r0 *1 0,0
Xsky130_fd_sc_hd__tapvpwrvgnd_1_187 VGND VPWR sky130_fd_sc_hd__tapvpwrvgnd_1
* cell instance sky130_fd_sc_hd__tapvpwrvgnd_1_188 r0 *1 0,0
Xsky130_fd_sc_hd__tapvpwrvgnd_1_188 VGND VPWR sky130_fd_sc_hd__tapvpwrvgnd_1
* cell instance sky130_fd_sc_hd__tapvpwrvgnd_1_189 r0 *1 0,0
Xsky130_fd_sc_hd__tapvpwrvgnd_1_189 VGND VPWR sky130_fd_sc_hd__tapvpwrvgnd_1
* cell instance sky130_fd_sc_hd__tapvpwrvgnd_1_190 r0 *1 0,0
Xsky130_fd_sc_hd__tapvpwrvgnd_1_190 VGND VPWR sky130_fd_sc_hd__tapvpwrvgnd_1
* cell instance sky130_fd_sc_hd__tapvpwrvgnd_1_191 r0 *1 0,0
Xsky130_fd_sc_hd__tapvpwrvgnd_1_191 VGND VPWR sky130_fd_sc_hd__tapvpwrvgnd_1
* cell instance sky130_fd_sc_hd__tapvpwrvgnd_1_192 r0 *1 0,0
Xsky130_fd_sc_hd__tapvpwrvgnd_1_192 VGND VPWR sky130_fd_sc_hd__tapvpwrvgnd_1
* cell instance sky130_fd_sc_hd__tapvpwrvgnd_1_193 r0 *1 0,0
Xsky130_fd_sc_hd__tapvpwrvgnd_1_193 VGND VPWR sky130_fd_sc_hd__tapvpwrvgnd_1
* cell instance sky130_fd_sc_hd__tapvpwrvgnd_1_194 r0 *1 0,0
Xsky130_fd_sc_hd__tapvpwrvgnd_1_194 VGND VPWR sky130_fd_sc_hd__tapvpwrvgnd_1
* cell instance sky130_fd_sc_hd__tapvpwrvgnd_1_195 r0 *1 0,0
Xsky130_fd_sc_hd__tapvpwrvgnd_1_195 VGND VPWR sky130_fd_sc_hd__tapvpwrvgnd_1
* cell instance sky130_fd_sc_hd__tapvpwrvgnd_1_196 r0 *1 0,0
Xsky130_fd_sc_hd__tapvpwrvgnd_1_196 VGND VPWR sky130_fd_sc_hd__tapvpwrvgnd_1
* cell instance sky130_fd_sc_hd__tapvpwrvgnd_1_197 r0 *1 0,0
Xsky130_fd_sc_hd__tapvpwrvgnd_1_197 VGND VPWR sky130_fd_sc_hd__tapvpwrvgnd_1
* cell instance sky130_fd_sc_hd__tapvpwrvgnd_1_198 r0 *1 0,0
Xsky130_fd_sc_hd__tapvpwrvgnd_1_198 VGND VPWR sky130_fd_sc_hd__tapvpwrvgnd_1
* cell instance sky130_fd_sc_hd__tapvpwrvgnd_1_199 r0 *1 0,0
Xsky130_fd_sc_hd__tapvpwrvgnd_1_199 VGND VPWR sky130_fd_sc_hd__tapvpwrvgnd_1
* cell instance sky130_fd_sc_hd__tapvpwrvgnd_1_200 r0 *1 0,0
Xsky130_fd_sc_hd__tapvpwrvgnd_1_200 VGND VPWR sky130_fd_sc_hd__tapvpwrvgnd_1
* cell instance sky130_fd_sc_hd__tapvpwrvgnd_1_201 r0 *1 0,0
Xsky130_fd_sc_hd__tapvpwrvgnd_1_201 VGND VPWR sky130_fd_sc_hd__tapvpwrvgnd_1
* cell instance sky130_fd_sc_hd__tapvpwrvgnd_1_202 r0 *1 0,0
Xsky130_fd_sc_hd__tapvpwrvgnd_1_202 VGND VPWR sky130_fd_sc_hd__tapvpwrvgnd_1
* cell instance sky130_fd_sc_hd__tapvpwrvgnd_1_203 r0 *1 0,0
Xsky130_fd_sc_hd__tapvpwrvgnd_1_203 VGND VPWR sky130_fd_sc_hd__tapvpwrvgnd_1
* cell instance sky130_fd_sc_hd__tapvpwrvgnd_1_204 r0 *1 0,0
Xsky130_fd_sc_hd__tapvpwrvgnd_1_204 VGND VPWR sky130_fd_sc_hd__tapvpwrvgnd_1
* cell instance sky130_fd_sc_hd__tapvpwrvgnd_1_205 r0 *1 0,0
Xsky130_fd_sc_hd__tapvpwrvgnd_1_205 VGND VPWR sky130_fd_sc_hd__tapvpwrvgnd_1
* cell instance sky130_fd_sc_hd__tapvpwrvgnd_1_206 r0 *1 0,0
Xsky130_fd_sc_hd__tapvpwrvgnd_1_206 VGND VPWR sky130_fd_sc_hd__tapvpwrvgnd_1
* cell instance sky130_fd_sc_hd__tapvpwrvgnd_1_207 r0 *1 0,0
Xsky130_fd_sc_hd__tapvpwrvgnd_1_207 VGND VPWR sky130_fd_sc_hd__tapvpwrvgnd_1
* cell instance sky130_fd_sc_hd__tapvpwrvgnd_1_208 r0 *1 0,0
Xsky130_fd_sc_hd__tapvpwrvgnd_1_208 VGND VPWR sky130_fd_sc_hd__tapvpwrvgnd_1
* cell instance sky130_fd_sc_hd__tapvpwrvgnd_1_209 r0 *1 0,0
Xsky130_fd_sc_hd__tapvpwrvgnd_1_209 VGND VPWR sky130_fd_sc_hd__tapvpwrvgnd_1
* cell instance sky130_fd_sc_hd__tapvpwrvgnd_1_210 r0 *1 0,0
Xsky130_fd_sc_hd__tapvpwrvgnd_1_210 VGND VPWR sky130_fd_sc_hd__tapvpwrvgnd_1
* cell instance sky130_fd_sc_hd__tapvpwrvgnd_1_211 r0 *1 0,0
Xsky130_fd_sc_hd__tapvpwrvgnd_1_211 VGND VPWR sky130_fd_sc_hd__tapvpwrvgnd_1
* cell instance sky130_fd_sc_hd__tapvpwrvgnd_1_212 r0 *1 0,0
Xsky130_fd_sc_hd__tapvpwrvgnd_1_212 VGND VPWR sky130_fd_sc_hd__tapvpwrvgnd_1
* cell instance sky130_fd_sc_hd__tapvpwrvgnd_1_213 r0 *1 0,0
Xsky130_fd_sc_hd__tapvpwrvgnd_1_213 VGND VPWR sky130_fd_sc_hd__tapvpwrvgnd_1
* cell instance sky130_fd_sc_hd__tapvpwrvgnd_1_214 r0 *1 0,0
Xsky130_fd_sc_hd__tapvpwrvgnd_1_214 VGND VPWR sky130_fd_sc_hd__tapvpwrvgnd_1
* cell instance sky130_fd_sc_hd__tapvpwrvgnd_1_215 r0 *1 0,0
Xsky130_fd_sc_hd__tapvpwrvgnd_1_215 VGND VPWR sky130_fd_sc_hd__tapvpwrvgnd_1
* cell instance sky130_fd_sc_hd__tapvpwrvgnd_1_216 r0 *1 0,0
Xsky130_fd_sc_hd__tapvpwrvgnd_1_216 VGND VPWR sky130_fd_sc_hd__tapvpwrvgnd_1
* cell instance sky130_fd_sc_hd__tapvpwrvgnd_1_217 r0 *1 0,0
Xsky130_fd_sc_hd__tapvpwrvgnd_1_217 VGND VPWR sky130_fd_sc_hd__tapvpwrvgnd_1
* cell instance sky130_fd_sc_hd__tapvpwrvgnd_1_218 r0 *1 0,0
Xsky130_fd_sc_hd__tapvpwrvgnd_1_218 VGND VPWR sky130_fd_sc_hd__tapvpwrvgnd_1
* cell instance sky130_fd_sc_hd__tapvpwrvgnd_1_219 r0 *1 0,0
Xsky130_fd_sc_hd__tapvpwrvgnd_1_219 VGND VPWR sky130_fd_sc_hd__tapvpwrvgnd_1
* cell instance sky130_fd_sc_hd__tapvpwrvgnd_1_220 r0 *1 0,0
Xsky130_fd_sc_hd__tapvpwrvgnd_1_220 VGND VPWR sky130_fd_sc_hd__tapvpwrvgnd_1
* cell instance sky130_fd_sc_hd__tapvpwrvgnd_1_221 r0 *1 0,0
Xsky130_fd_sc_hd__tapvpwrvgnd_1_221 VGND VPWR sky130_fd_sc_hd__tapvpwrvgnd_1
* cell instance sky130_fd_sc_hd__tapvpwrvgnd_1_222 r0 *1 0,0
Xsky130_fd_sc_hd__tapvpwrvgnd_1_222 VGND VPWR sky130_fd_sc_hd__tapvpwrvgnd_1
* cell instance sky130_fd_sc_hd__tapvpwrvgnd_1_223 r0 *1 0,0
Xsky130_fd_sc_hd__tapvpwrvgnd_1_223 VGND VPWR sky130_fd_sc_hd__tapvpwrvgnd_1
* cell instance sky130_fd_sc_hd__tapvpwrvgnd_1_224 r0 *1 0,0
Xsky130_fd_sc_hd__tapvpwrvgnd_1_224 VGND VPWR sky130_fd_sc_hd__tapvpwrvgnd_1
* cell instance sky130_fd_sc_hd__tapvpwrvgnd_1_225 r0 *1 0,0
Xsky130_fd_sc_hd__tapvpwrvgnd_1_225 VGND VPWR sky130_fd_sc_hd__tapvpwrvgnd_1
* cell instance sky130_fd_sc_hd__tapvpwrvgnd_1_226 r0 *1 0,0
Xsky130_fd_sc_hd__tapvpwrvgnd_1_226 VGND VPWR sky130_fd_sc_hd__tapvpwrvgnd_1
* cell instance sky130_fd_sc_hd__tapvpwrvgnd_1_227 r0 *1 0,0
Xsky130_fd_sc_hd__tapvpwrvgnd_1_227 VGND VPWR sky130_fd_sc_hd__tapvpwrvgnd_1
* cell instance sky130_fd_sc_hd__tapvpwrvgnd_1_228 r0 *1 0,0
Xsky130_fd_sc_hd__tapvpwrvgnd_1_228 VGND VPWR sky130_fd_sc_hd__tapvpwrvgnd_1
* cell instance sky130_fd_sc_hd__tapvpwrvgnd_1_229 r0 *1 0,0
Xsky130_fd_sc_hd__tapvpwrvgnd_1_229 VGND VPWR sky130_fd_sc_hd__tapvpwrvgnd_1
* cell instance sky130_fd_sc_hd__tapvpwrvgnd_1_230 r0 *1 0,0
Xsky130_fd_sc_hd__tapvpwrvgnd_1_230 VGND VPWR sky130_fd_sc_hd__tapvpwrvgnd_1
* cell instance sky130_fd_sc_hd__tapvpwrvgnd_1_231 r0 *1 0,0
Xsky130_fd_sc_hd__tapvpwrvgnd_1_231 VGND VPWR sky130_fd_sc_hd__tapvpwrvgnd_1
* cell instance sky130_fd_sc_hd__tapvpwrvgnd_1_232 r0 *1 0,0
Xsky130_fd_sc_hd__tapvpwrvgnd_1_232 VGND VPWR sky130_fd_sc_hd__tapvpwrvgnd_1
* cell instance sky130_fd_sc_hd__tapvpwrvgnd_1_233 r0 *1 0,0
Xsky130_fd_sc_hd__tapvpwrvgnd_1_233 VGND VPWR sky130_fd_sc_hd__tapvpwrvgnd_1
* cell instance sky130_fd_sc_hd__tapvpwrvgnd_1_234 r0 *1 0,0
Xsky130_fd_sc_hd__tapvpwrvgnd_1_234 VGND VPWR sky130_fd_sc_hd__tapvpwrvgnd_1
* cell instance sky130_fd_sc_hd__tapvpwrvgnd_1_235 r0 *1 0,0
Xsky130_fd_sc_hd__tapvpwrvgnd_1_235 VGND VPWR sky130_fd_sc_hd__tapvpwrvgnd_1
* cell instance sky130_fd_sc_hd__tapvpwrvgnd_1_236 r0 *1 0,0
Xsky130_fd_sc_hd__tapvpwrvgnd_1_236 VGND VPWR sky130_fd_sc_hd__tapvpwrvgnd_1
* cell instance sky130_fd_sc_hd__tapvpwrvgnd_1_237 r0 *1 0,0
Xsky130_fd_sc_hd__tapvpwrvgnd_1_237 VGND VPWR sky130_fd_sc_hd__tapvpwrvgnd_1
* cell instance sky130_fd_sc_hd__tapvpwrvgnd_1_238 r0 *1 0,0
Xsky130_fd_sc_hd__tapvpwrvgnd_1_238 VGND VPWR sky130_fd_sc_hd__tapvpwrvgnd_1
* cell instance sky130_fd_sc_hd__tapvpwrvgnd_1_239 r0 *1 0,0
Xsky130_fd_sc_hd__tapvpwrvgnd_1_239 VGND VPWR sky130_fd_sc_hd__tapvpwrvgnd_1
* cell instance sky130_fd_sc_hd__tapvpwrvgnd_1_240 r0 *1 0,0
Xsky130_fd_sc_hd__tapvpwrvgnd_1_240 VGND VPWR sky130_fd_sc_hd__tapvpwrvgnd_1
* cell instance sky130_fd_sc_hd__tapvpwrvgnd_1_241 r0 *1 0,0
Xsky130_fd_sc_hd__tapvpwrvgnd_1_241 VGND VPWR sky130_fd_sc_hd__tapvpwrvgnd_1
* cell instance sky130_fd_sc_hd__tapvpwrvgnd_1_242 r0 *1 0,0
Xsky130_fd_sc_hd__tapvpwrvgnd_1_242 VGND VPWR sky130_fd_sc_hd__tapvpwrvgnd_1
* cell instance sky130_fd_sc_hd__tapvpwrvgnd_1_243 r0 *1 0,0
Xsky130_fd_sc_hd__tapvpwrvgnd_1_243 VGND VPWR sky130_fd_sc_hd__tapvpwrvgnd_1
* cell instance sky130_fd_sc_hd__tapvpwrvgnd_1_244 r0 *1 0,0
Xsky130_fd_sc_hd__tapvpwrvgnd_1_244 VGND VPWR sky130_fd_sc_hd__tapvpwrvgnd_1
* cell instance sky130_fd_sc_hd__tapvpwrvgnd_1_245 r0 *1 0,0
Xsky130_fd_sc_hd__tapvpwrvgnd_1_245 VGND VPWR sky130_fd_sc_hd__tapvpwrvgnd_1
* cell instance sky130_fd_sc_hd__tapvpwrvgnd_1_246 r0 *1 0,0
Xsky130_fd_sc_hd__tapvpwrvgnd_1_246 VGND VPWR sky130_fd_sc_hd__tapvpwrvgnd_1
* cell instance sky130_fd_sc_hd__tapvpwrvgnd_1_247 r0 *1 0,0
Xsky130_fd_sc_hd__tapvpwrvgnd_1_247 VGND VPWR sky130_fd_sc_hd__tapvpwrvgnd_1
* cell instance sky130_fd_sc_hd__tapvpwrvgnd_1_248 r0 *1 0,0
Xsky130_fd_sc_hd__tapvpwrvgnd_1_248 VGND VPWR sky130_fd_sc_hd__tapvpwrvgnd_1
* cell instance sky130_fd_sc_hd__tapvpwrvgnd_1_249 r0 *1 0,0
Xsky130_fd_sc_hd__tapvpwrvgnd_1_249 VGND VPWR sky130_fd_sc_hd__tapvpwrvgnd_1
* cell instance sky130_fd_sc_hd__tapvpwrvgnd_1_250 r0 *1 0,0
Xsky130_fd_sc_hd__tapvpwrvgnd_1_250 VGND VPWR sky130_fd_sc_hd__tapvpwrvgnd_1
* cell instance sky130_fd_sc_hd__tapvpwrvgnd_1_251 r0 *1 0,0
Xsky130_fd_sc_hd__tapvpwrvgnd_1_251 VGND VPWR sky130_fd_sc_hd__tapvpwrvgnd_1
* cell instance sky130_fd_sc_hd__tapvpwrvgnd_1_252 r0 *1 0,0
Xsky130_fd_sc_hd__tapvpwrvgnd_1_252 VGND VPWR sky130_fd_sc_hd__tapvpwrvgnd_1
* cell instance sky130_fd_sc_hd__tapvpwrvgnd_1_253 r0 *1 0,0
Xsky130_fd_sc_hd__tapvpwrvgnd_1_253 VGND VPWR sky130_fd_sc_hd__tapvpwrvgnd_1
* cell instance sky130_fd_sc_hd__tapvpwrvgnd_1_254 r0 *1 0,0
Xsky130_fd_sc_hd__tapvpwrvgnd_1_254 VGND VPWR sky130_fd_sc_hd__tapvpwrvgnd_1
* cell instance sky130_fd_sc_hd__tapvpwrvgnd_1_255 r0 *1 0,0
Xsky130_fd_sc_hd__tapvpwrvgnd_1_255 VGND VPWR sky130_fd_sc_hd__tapvpwrvgnd_1
* cell instance sky130_fd_sc_hd__tapvpwrvgnd_1_256 r0 *1 0,0
Xsky130_fd_sc_hd__tapvpwrvgnd_1_256 VGND VPWR sky130_fd_sc_hd__tapvpwrvgnd_1
* cell instance sky130_fd_sc_hd__tapvpwrvgnd_1_257 r0 *1 0,0
Xsky130_fd_sc_hd__tapvpwrvgnd_1_257 VGND VPWR sky130_fd_sc_hd__tapvpwrvgnd_1
* cell instance sky130_fd_sc_hd__tapvpwrvgnd_1_258 r0 *1 0,0
Xsky130_fd_sc_hd__tapvpwrvgnd_1_258 VGND VPWR sky130_fd_sc_hd__tapvpwrvgnd_1
* cell instance sky130_fd_sc_hd__tapvpwrvgnd_1_259 r0 *1 0,0
Xsky130_fd_sc_hd__tapvpwrvgnd_1_259 VGND VPWR sky130_fd_sc_hd__tapvpwrvgnd_1
* cell instance sky130_fd_sc_hd__tapvpwrvgnd_1_260 r0 *1 0,0
Xsky130_fd_sc_hd__tapvpwrvgnd_1_260 VGND VPWR sky130_fd_sc_hd__tapvpwrvgnd_1
* cell instance sky130_fd_sc_hd__tapvpwrvgnd_1_261 r0 *1 0,0
Xsky130_fd_sc_hd__tapvpwrvgnd_1_261 VGND VPWR sky130_fd_sc_hd__tapvpwrvgnd_1
* cell instance sky130_fd_sc_hd__tapvpwrvgnd_1_262 r0 *1 0,0
Xsky130_fd_sc_hd__tapvpwrvgnd_1_262 VGND VPWR sky130_fd_sc_hd__tapvpwrvgnd_1
* cell instance sky130_fd_sc_hd__tapvpwrvgnd_1_263 r0 *1 0,0
Xsky130_fd_sc_hd__tapvpwrvgnd_1_263 VGND VPWR sky130_fd_sc_hd__tapvpwrvgnd_1
* cell instance sky130_fd_sc_hd__tapvpwrvgnd_1_264 r0 *1 0,0
Xsky130_fd_sc_hd__tapvpwrvgnd_1_264 VGND VPWR sky130_fd_sc_hd__tapvpwrvgnd_1
* cell instance sky130_fd_sc_hd__tapvpwrvgnd_1_265 r0 *1 0,0
Xsky130_fd_sc_hd__tapvpwrvgnd_1_265 VGND VPWR sky130_fd_sc_hd__tapvpwrvgnd_1
* cell instance sky130_fd_sc_hd__tapvpwrvgnd_1_266 r0 *1 0,0
Xsky130_fd_sc_hd__tapvpwrvgnd_1_266 VGND VPWR sky130_fd_sc_hd__tapvpwrvgnd_1
* cell instance sky130_fd_sc_hd__tapvpwrvgnd_1_267 r0 *1 0,0
Xsky130_fd_sc_hd__tapvpwrvgnd_1_267 VGND VPWR sky130_fd_sc_hd__tapvpwrvgnd_1
* cell instance sky130_fd_sc_hd__tapvpwrvgnd_1_268 r0 *1 0,0
Xsky130_fd_sc_hd__tapvpwrvgnd_1_268 VGND VPWR sky130_fd_sc_hd__tapvpwrvgnd_1
* cell instance sky130_fd_sc_hd__tapvpwrvgnd_1_269 r0 *1 0,0
Xsky130_fd_sc_hd__tapvpwrvgnd_1_269 VGND VPWR sky130_fd_sc_hd__tapvpwrvgnd_1
* cell instance sky130_fd_sc_hd__tapvpwrvgnd_1_270 r0 *1 0,0
Xsky130_fd_sc_hd__tapvpwrvgnd_1_270 VGND VPWR sky130_fd_sc_hd__tapvpwrvgnd_1
* cell instance sky130_fd_sc_hd__tapvpwrvgnd_1_271 r0 *1 0,0
Xsky130_fd_sc_hd__tapvpwrvgnd_1_271 VGND VPWR sky130_fd_sc_hd__tapvpwrvgnd_1
* cell instance sky130_fd_sc_hd__tapvpwrvgnd_1_272 r0 *1 0,0
Xsky130_fd_sc_hd__tapvpwrvgnd_1_272 VGND VPWR sky130_fd_sc_hd__tapvpwrvgnd_1
* cell instance sky130_fd_sc_hd__tapvpwrvgnd_1_273 r0 *1 0,0
Xsky130_fd_sc_hd__tapvpwrvgnd_1_273 VGND VPWR sky130_fd_sc_hd__tapvpwrvgnd_1
* cell instance sky130_fd_sc_hd__tapvpwrvgnd_1_274 r0 *1 0,0
Xsky130_fd_sc_hd__tapvpwrvgnd_1_274 VGND VPWR sky130_fd_sc_hd__tapvpwrvgnd_1
* cell instance sky130_fd_sc_hd__tapvpwrvgnd_1_275 r0 *1 0,0
Xsky130_fd_sc_hd__tapvpwrvgnd_1_275 VGND VPWR sky130_fd_sc_hd__tapvpwrvgnd_1
* cell instance sky130_fd_sc_hd__tapvpwrvgnd_1_276 r0 *1 0,0
Xsky130_fd_sc_hd__tapvpwrvgnd_1_276 VGND VPWR sky130_fd_sc_hd__tapvpwrvgnd_1
* cell instance sky130_fd_sc_hd__tapvpwrvgnd_1_277 r0 *1 0,0
Xsky130_fd_sc_hd__tapvpwrvgnd_1_277 VGND VPWR sky130_fd_sc_hd__tapvpwrvgnd_1
* cell instance sky130_fd_sc_hd__tapvpwrvgnd_1_278 r0 *1 0,0
Xsky130_fd_sc_hd__tapvpwrvgnd_1_278 VGND VPWR sky130_fd_sc_hd__tapvpwrvgnd_1
* cell instance sky130_fd_sc_hd__tapvpwrvgnd_1_279 r0 *1 0,0
Xsky130_fd_sc_hd__tapvpwrvgnd_1_279 VGND VPWR sky130_fd_sc_hd__tapvpwrvgnd_1
* cell instance sky130_fd_sc_hd__tapvpwrvgnd_1_280 r0 *1 0,0
Xsky130_fd_sc_hd__tapvpwrvgnd_1_280 VGND VPWR sky130_fd_sc_hd__tapvpwrvgnd_1
* cell instance sky130_fd_sc_hd__tapvpwrvgnd_1_281 r0 *1 0,0
Xsky130_fd_sc_hd__tapvpwrvgnd_1_281 VGND VPWR sky130_fd_sc_hd__tapvpwrvgnd_1
* cell instance sky130_fd_sc_hd__tapvpwrvgnd_1_282 r0 *1 0,0
Xsky130_fd_sc_hd__tapvpwrvgnd_1_282 VGND VPWR sky130_fd_sc_hd__tapvpwrvgnd_1
* cell instance sky130_fd_sc_hd__tapvpwrvgnd_1_283 r0 *1 0,0
Xsky130_fd_sc_hd__tapvpwrvgnd_1_283 VGND VPWR sky130_fd_sc_hd__tapvpwrvgnd_1
* cell instance sky130_fd_sc_hd__tapvpwrvgnd_1_284 r0 *1 0,0
Xsky130_fd_sc_hd__tapvpwrvgnd_1_284 VGND VPWR sky130_fd_sc_hd__tapvpwrvgnd_1
* cell instance sky130_fd_sc_hd__tapvpwrvgnd_1_285 r0 *1 0,0
Xsky130_fd_sc_hd__tapvpwrvgnd_1_285 VGND VPWR sky130_fd_sc_hd__tapvpwrvgnd_1
* cell instance sky130_fd_sc_hd__tapvpwrvgnd_1_286 r0 *1 0,0
Xsky130_fd_sc_hd__tapvpwrvgnd_1_286 VGND VPWR sky130_fd_sc_hd__tapvpwrvgnd_1
* cell instance sky130_fd_sc_hd__tapvpwrvgnd_1_287 r0 *1 0,0
Xsky130_fd_sc_hd__tapvpwrvgnd_1_287 VGND VPWR sky130_fd_sc_hd__tapvpwrvgnd_1
* cell instance sky130_fd_sc_hd__tapvpwrvgnd_1_288 r0 *1 0,0
Xsky130_fd_sc_hd__tapvpwrvgnd_1_288 VGND VPWR sky130_fd_sc_hd__tapvpwrvgnd_1
* cell instance sky130_fd_sc_hd__tapvpwrvgnd_1_289 r0 *1 0,0
Xsky130_fd_sc_hd__tapvpwrvgnd_1_289 VGND VPWR sky130_fd_sc_hd__tapvpwrvgnd_1
* cell instance sky130_fd_sc_hd__tapvpwrvgnd_1_290 r0 *1 0,0
Xsky130_fd_sc_hd__tapvpwrvgnd_1_290 VGND VPWR sky130_fd_sc_hd__tapvpwrvgnd_1
* cell instance sky130_fd_sc_hd__tapvpwrvgnd_1_291 r0 *1 0,0
Xsky130_fd_sc_hd__tapvpwrvgnd_1_291 VGND VPWR sky130_fd_sc_hd__tapvpwrvgnd_1
* cell instance sky130_fd_sc_hd__tapvpwrvgnd_1_292 r0 *1 0,0
Xsky130_fd_sc_hd__tapvpwrvgnd_1_292 VGND VPWR sky130_fd_sc_hd__tapvpwrvgnd_1
* cell instance sky130_fd_sc_hd__tapvpwrvgnd_1_293 r0 *1 0,0
Xsky130_fd_sc_hd__tapvpwrvgnd_1_293 VGND VPWR sky130_fd_sc_hd__tapvpwrvgnd_1
* cell instance sky130_fd_sc_hd__tapvpwrvgnd_1_294 r0 *1 0,0
Xsky130_fd_sc_hd__tapvpwrvgnd_1_294 VGND VPWR sky130_fd_sc_hd__tapvpwrvgnd_1
* cell instance sky130_fd_sc_hd__tapvpwrvgnd_1_295 r0 *1 0,0
Xsky130_fd_sc_hd__tapvpwrvgnd_1_295 VGND VPWR sky130_fd_sc_hd__tapvpwrvgnd_1
* cell instance sky130_fd_sc_hd__tapvpwrvgnd_1_296 r0 *1 0,0
Xsky130_fd_sc_hd__tapvpwrvgnd_1_296 VGND VPWR sky130_fd_sc_hd__tapvpwrvgnd_1
* cell instance sky130_fd_sc_hd__tapvpwrvgnd_1_297 r0 *1 0,0
Xsky130_fd_sc_hd__tapvpwrvgnd_1_297 VGND VPWR sky130_fd_sc_hd__tapvpwrvgnd_1
* cell instance sky130_fd_sc_hd__tapvpwrvgnd_1_298 r0 *1 0,0
Xsky130_fd_sc_hd__tapvpwrvgnd_1_298 VGND VPWR sky130_fd_sc_hd__tapvpwrvgnd_1
* cell instance sky130_fd_sc_hd__tapvpwrvgnd_1_299 r0 *1 0,0
Xsky130_fd_sc_hd__tapvpwrvgnd_1_299 VGND VPWR sky130_fd_sc_hd__tapvpwrvgnd_1
* cell instance sky130_fd_sc_hd__tapvpwrvgnd_1_300 r0 *1 0,0
Xsky130_fd_sc_hd__tapvpwrvgnd_1_300 VGND VPWR sky130_fd_sc_hd__tapvpwrvgnd_1
* cell instance sky130_fd_sc_hd__tapvpwrvgnd_1_301 r0 *1 0,0
Xsky130_fd_sc_hd__tapvpwrvgnd_1_301 VGND VPWR sky130_fd_sc_hd__tapvpwrvgnd_1
* cell instance sky130_fd_sc_hd__tapvpwrvgnd_1_302 r0 *1 0,0
Xsky130_fd_sc_hd__tapvpwrvgnd_1_302 VGND VPWR sky130_fd_sc_hd__tapvpwrvgnd_1
* cell instance sky130_fd_sc_hd__tapvpwrvgnd_1_303 r0 *1 0,0
Xsky130_fd_sc_hd__tapvpwrvgnd_1_303 VGND VPWR sky130_fd_sc_hd__tapvpwrvgnd_1
* cell instance sky130_fd_sc_hd__tapvpwrvgnd_1_304 r0 *1 0,0
Xsky130_fd_sc_hd__tapvpwrvgnd_1_304 VGND VPWR sky130_fd_sc_hd__tapvpwrvgnd_1
* cell instance sky130_fd_sc_hd__tapvpwrvgnd_1_305 r0 *1 0,0
Xsky130_fd_sc_hd__tapvpwrvgnd_1_305 VGND VPWR sky130_fd_sc_hd__tapvpwrvgnd_1
* cell instance sky130_fd_sc_hd__tapvpwrvgnd_1_306 r0 *1 0,0
Xsky130_fd_sc_hd__tapvpwrvgnd_1_306 VGND VPWR sky130_fd_sc_hd__tapvpwrvgnd_1
* cell instance sky130_fd_sc_hd__tapvpwrvgnd_1_307 r0 *1 0,0
Xsky130_fd_sc_hd__tapvpwrvgnd_1_307 VGND VPWR sky130_fd_sc_hd__tapvpwrvgnd_1
* cell instance sky130_fd_sc_hd__tapvpwrvgnd_1_308 r0 *1 0,0
Xsky130_fd_sc_hd__tapvpwrvgnd_1_308 VGND VPWR sky130_fd_sc_hd__tapvpwrvgnd_1
* cell instance sky130_fd_sc_hd__tapvpwrvgnd_1_309 r0 *1 0,0
Xsky130_fd_sc_hd__tapvpwrvgnd_1_309 VGND VPWR sky130_fd_sc_hd__tapvpwrvgnd_1
* cell instance sky130_fd_sc_hd__tapvpwrvgnd_1_310 r0 *1 0,0
Xsky130_fd_sc_hd__tapvpwrvgnd_1_310 VGND VPWR sky130_fd_sc_hd__tapvpwrvgnd_1
* cell instance sky130_fd_sc_hd__tapvpwrvgnd_1_311 r0 *1 0,0
Xsky130_fd_sc_hd__tapvpwrvgnd_1_311 VGND VPWR sky130_fd_sc_hd__tapvpwrvgnd_1
* cell instance sky130_fd_sc_hd__tapvpwrvgnd_1_312 r0 *1 0,0
Xsky130_fd_sc_hd__tapvpwrvgnd_1_312 VGND VPWR sky130_fd_sc_hd__tapvpwrvgnd_1
* cell instance sky130_fd_sc_hd__tapvpwrvgnd_1_313 r0 *1 0,0
Xsky130_fd_sc_hd__tapvpwrvgnd_1_313 VGND VPWR sky130_fd_sc_hd__tapvpwrvgnd_1
* cell instance sky130_fd_sc_hd__tapvpwrvgnd_1_314 r0 *1 0,0
Xsky130_fd_sc_hd__tapvpwrvgnd_1_314 VGND VPWR sky130_fd_sc_hd__tapvpwrvgnd_1
* cell instance sky130_fd_sc_hd__tapvpwrvgnd_1_315 r0 *1 0,0
Xsky130_fd_sc_hd__tapvpwrvgnd_1_315 VGND VPWR sky130_fd_sc_hd__tapvpwrvgnd_1
* cell instance sky130_fd_sc_hd__tapvpwrvgnd_1_316 r0 *1 0,0
Xsky130_fd_sc_hd__tapvpwrvgnd_1_316 VGND VPWR sky130_fd_sc_hd__tapvpwrvgnd_1
* cell instance sky130_fd_sc_hd__tapvpwrvgnd_1_317 r0 *1 0,0
Xsky130_fd_sc_hd__tapvpwrvgnd_1_317 VGND VPWR sky130_fd_sc_hd__tapvpwrvgnd_1
* cell instance sky130_fd_sc_hd__tapvpwrvgnd_1_318 r0 *1 0,0
Xsky130_fd_sc_hd__tapvpwrvgnd_1_318 VGND VPWR sky130_fd_sc_hd__tapvpwrvgnd_1
* cell instance sky130_fd_sc_hd__tapvpwrvgnd_1_319 r0 *1 0,0
Xsky130_fd_sc_hd__tapvpwrvgnd_1_319 VGND VPWR sky130_fd_sc_hd__tapvpwrvgnd_1
* cell instance sky130_fd_sc_hd__tapvpwrvgnd_1_320 r0 *1 0,0
Xsky130_fd_sc_hd__tapvpwrvgnd_1_320 VGND VPWR sky130_fd_sc_hd__tapvpwrvgnd_1
* cell instance sky130_fd_sc_hd__tapvpwrvgnd_1_321 r0 *1 0,0
Xsky130_fd_sc_hd__tapvpwrvgnd_1_321 VGND VPWR sky130_fd_sc_hd__tapvpwrvgnd_1
* cell instance sky130_fd_sc_hd__tapvpwrvgnd_1_322 r0 *1 0,0
Xsky130_fd_sc_hd__tapvpwrvgnd_1_322 VGND VPWR sky130_fd_sc_hd__tapvpwrvgnd_1
* cell instance sky130_fd_sc_hd__tapvpwrvgnd_1_323 r0 *1 0,0
Xsky130_fd_sc_hd__tapvpwrvgnd_1_323 VGND VPWR sky130_fd_sc_hd__tapvpwrvgnd_1
* cell instance sky130_fd_sc_hd__tapvpwrvgnd_1_324 r0 *1 0,0
Xsky130_fd_sc_hd__tapvpwrvgnd_1_324 VGND VPWR sky130_fd_sc_hd__tapvpwrvgnd_1
* cell instance sky130_fd_sc_hd__tapvpwrvgnd_1_325 r0 *1 0,0
Xsky130_fd_sc_hd__tapvpwrvgnd_1_325 VGND VPWR sky130_fd_sc_hd__tapvpwrvgnd_1
* cell instance sky130_fd_sc_hd__tapvpwrvgnd_1_326 r0 *1 0,0
Xsky130_fd_sc_hd__tapvpwrvgnd_1_326 VGND VPWR sky130_fd_sc_hd__tapvpwrvgnd_1
* cell instance sky130_fd_sc_hd__tapvpwrvgnd_1_327 r0 *1 0,0
Xsky130_fd_sc_hd__tapvpwrvgnd_1_327 VGND VPWR sky130_fd_sc_hd__tapvpwrvgnd_1
* cell instance sky130_fd_sc_hd__tapvpwrvgnd_1_328 r0 *1 0,0
Xsky130_fd_sc_hd__tapvpwrvgnd_1_328 VGND VPWR sky130_fd_sc_hd__tapvpwrvgnd_1
* cell instance sky130_fd_sc_hd__tapvpwrvgnd_1_329 r0 *1 0,0
Xsky130_fd_sc_hd__tapvpwrvgnd_1_329 VGND VPWR sky130_fd_sc_hd__tapvpwrvgnd_1
* cell instance sky130_fd_sc_hd__tapvpwrvgnd_1_330 r0 *1 0,0
Xsky130_fd_sc_hd__tapvpwrvgnd_1_330 VGND VPWR sky130_fd_sc_hd__tapvpwrvgnd_1
* cell instance sky130_fd_sc_hd__tapvpwrvgnd_1_331 r0 *1 0,0
Xsky130_fd_sc_hd__tapvpwrvgnd_1_331 VGND VPWR sky130_fd_sc_hd__tapvpwrvgnd_1
* cell instance sky130_fd_sc_hd__tapvpwrvgnd_1_332 r0 *1 0,0
Xsky130_fd_sc_hd__tapvpwrvgnd_1_332 VGND VPWR sky130_fd_sc_hd__tapvpwrvgnd_1
* cell instance sky130_fd_sc_hd__tapvpwrvgnd_1_333 r0 *1 0,0
Xsky130_fd_sc_hd__tapvpwrvgnd_1_333 VGND VPWR sky130_fd_sc_hd__tapvpwrvgnd_1
* cell instance sky130_fd_sc_hd__tapvpwrvgnd_1_334 r0 *1 0,0
Xsky130_fd_sc_hd__tapvpwrvgnd_1_334 VGND VPWR sky130_fd_sc_hd__tapvpwrvgnd_1
* cell instance sky130_fd_sc_hd__tapvpwrvgnd_1_335 r0 *1 0,0
Xsky130_fd_sc_hd__tapvpwrvgnd_1_335 VGND VPWR sky130_fd_sc_hd__tapvpwrvgnd_1
* cell instance sky130_fd_sc_hd__tapvpwrvgnd_1_336 r0 *1 0,0
Xsky130_fd_sc_hd__tapvpwrvgnd_1_336 VGND VPWR sky130_fd_sc_hd__tapvpwrvgnd_1
* cell instance sky130_fd_sc_hd__tapvpwrvgnd_1_337 r0 *1 0,0
Xsky130_fd_sc_hd__tapvpwrvgnd_1_337 VGND VPWR sky130_fd_sc_hd__tapvpwrvgnd_1
* cell instance sky130_fd_sc_hd__tapvpwrvgnd_1_338 r0 *1 0,0
Xsky130_fd_sc_hd__tapvpwrvgnd_1_338 VGND VPWR sky130_fd_sc_hd__tapvpwrvgnd_1
* cell instance sky130_fd_sc_hd__tapvpwrvgnd_1_339 r0 *1 0,0
Xsky130_fd_sc_hd__tapvpwrvgnd_1_339 VGND VPWR sky130_fd_sc_hd__tapvpwrvgnd_1
* cell instance sky130_fd_sc_hd__tapvpwrvgnd_1_340 r0 *1 0,0
Xsky130_fd_sc_hd__tapvpwrvgnd_1_340 VGND VPWR sky130_fd_sc_hd__tapvpwrvgnd_1
* cell instance sky130_fd_sc_hd__tapvpwrvgnd_1_341 r0 *1 0,0
Xsky130_fd_sc_hd__tapvpwrvgnd_1_341 VGND VPWR sky130_fd_sc_hd__tapvpwrvgnd_1
* cell instance sky130_fd_sc_hd__tapvpwrvgnd_1_342 r0 *1 0,0
Xsky130_fd_sc_hd__tapvpwrvgnd_1_342 VGND VPWR sky130_fd_sc_hd__tapvpwrvgnd_1
* cell instance sky130_fd_sc_hd__tapvpwrvgnd_1_343 r0 *1 0,0
Xsky130_fd_sc_hd__tapvpwrvgnd_1_343 VGND VPWR sky130_fd_sc_hd__tapvpwrvgnd_1
* cell instance sky130_fd_sc_hd__tapvpwrvgnd_1_344 r0 *1 0,0
Xsky130_fd_sc_hd__tapvpwrvgnd_1_344 VGND VPWR sky130_fd_sc_hd__tapvpwrvgnd_1
* cell instance sky130_fd_sc_hd__tapvpwrvgnd_1_345 r0 *1 0,0
Xsky130_fd_sc_hd__tapvpwrvgnd_1_345 VGND VPWR sky130_fd_sc_hd__tapvpwrvgnd_1
* cell instance sky130_fd_sc_hd__tapvpwrvgnd_1_346 r0 *1 0,0
Xsky130_fd_sc_hd__tapvpwrvgnd_1_346 VGND VPWR sky130_fd_sc_hd__tapvpwrvgnd_1
* cell instance sky130_fd_sc_hd__tapvpwrvgnd_1_347 r0 *1 0,0
Xsky130_fd_sc_hd__tapvpwrvgnd_1_347 VGND VPWR sky130_fd_sc_hd__tapvpwrvgnd_1
* cell instance sky130_fd_sc_hd__tapvpwrvgnd_1_348 r0 *1 0,0
Xsky130_fd_sc_hd__tapvpwrvgnd_1_348 VGND VPWR sky130_fd_sc_hd__tapvpwrvgnd_1
* cell instance sky130_fd_sc_hd__tapvpwrvgnd_1_349 r0 *1 0,0
Xsky130_fd_sc_hd__tapvpwrvgnd_1_349 VGND VPWR sky130_fd_sc_hd__tapvpwrvgnd_1
* cell instance sky130_fd_sc_hd__tapvpwrvgnd_1_350 r0 *1 0,0
Xsky130_fd_sc_hd__tapvpwrvgnd_1_350 VGND VPWR sky130_fd_sc_hd__tapvpwrvgnd_1
* cell instance sky130_fd_sc_hd__tapvpwrvgnd_1_351 r0 *1 0,0
Xsky130_fd_sc_hd__tapvpwrvgnd_1_351 VGND VPWR sky130_fd_sc_hd__tapvpwrvgnd_1
* cell instance sky130_fd_sc_hd__tapvpwrvgnd_1_352 r0 *1 0,0
Xsky130_fd_sc_hd__tapvpwrvgnd_1_352 VGND VPWR sky130_fd_sc_hd__tapvpwrvgnd_1
* cell instance sky130_fd_sc_hd__tapvpwrvgnd_1_353 r0 *1 0,0
Xsky130_fd_sc_hd__tapvpwrvgnd_1_353 VGND VPWR sky130_fd_sc_hd__tapvpwrvgnd_1
* cell instance sky130_fd_sc_hd__tapvpwrvgnd_1_354 r0 *1 0,0
Xsky130_fd_sc_hd__tapvpwrvgnd_1_354 VGND VPWR sky130_fd_sc_hd__tapvpwrvgnd_1
* cell instance sky130_fd_sc_hd__tapvpwrvgnd_1_355 r0 *1 0,0
Xsky130_fd_sc_hd__tapvpwrvgnd_1_355 VGND VPWR sky130_fd_sc_hd__tapvpwrvgnd_1
* cell instance sky130_fd_sc_hd__tapvpwrvgnd_1_356 r0 *1 0,0
Xsky130_fd_sc_hd__tapvpwrvgnd_1_356 VGND VPWR sky130_fd_sc_hd__tapvpwrvgnd_1
* cell instance sky130_fd_sc_hd__tapvpwrvgnd_1_357 r0 *1 0,0
Xsky130_fd_sc_hd__tapvpwrvgnd_1_357 VGND VPWR sky130_fd_sc_hd__tapvpwrvgnd_1
* cell instance sky130_fd_sc_hd__tapvpwrvgnd_1_358 r0 *1 0,0
Xsky130_fd_sc_hd__tapvpwrvgnd_1_358 VGND VPWR sky130_fd_sc_hd__tapvpwrvgnd_1
* cell instance sky130_fd_sc_hd__tapvpwrvgnd_1_359 r0 *1 0,0
Xsky130_fd_sc_hd__tapvpwrvgnd_1_359 VGND VPWR sky130_fd_sc_hd__tapvpwrvgnd_1
* cell instance sky130_fd_sc_hd__tapvpwrvgnd_1_360 r0 *1 0,0
Xsky130_fd_sc_hd__tapvpwrvgnd_1_360 VGND VPWR sky130_fd_sc_hd__tapvpwrvgnd_1
* cell instance sky130_fd_sc_hd__tapvpwrvgnd_1_361 r0 *1 0,0
Xsky130_fd_sc_hd__tapvpwrvgnd_1_361 VGND VPWR sky130_fd_sc_hd__tapvpwrvgnd_1
* cell instance sky130_fd_sc_hd__tapvpwrvgnd_1_362 r0 *1 0,0
Xsky130_fd_sc_hd__tapvpwrvgnd_1_362 VGND VPWR sky130_fd_sc_hd__tapvpwrvgnd_1
* cell instance sky130_fd_sc_hd__tapvpwrvgnd_1_363 r0 *1 0,0
Xsky130_fd_sc_hd__tapvpwrvgnd_1_363 VGND VPWR sky130_fd_sc_hd__tapvpwrvgnd_1
* cell instance sky130_fd_sc_hd__tapvpwrvgnd_1_364 r0 *1 0,0
Xsky130_fd_sc_hd__tapvpwrvgnd_1_364 VGND VPWR sky130_fd_sc_hd__tapvpwrvgnd_1
* cell instance sky130_fd_sc_hd__tapvpwrvgnd_1_365 r0 *1 0,0
Xsky130_fd_sc_hd__tapvpwrvgnd_1_365 VGND VPWR sky130_fd_sc_hd__tapvpwrvgnd_1
* cell instance sky130_fd_sc_hd__tapvpwrvgnd_1_366 r0 *1 0,0
Xsky130_fd_sc_hd__tapvpwrvgnd_1_366 VGND VPWR sky130_fd_sc_hd__tapvpwrvgnd_1
* cell instance sky130_fd_sc_hd__tapvpwrvgnd_1_367 r0 *1 0,0
Xsky130_fd_sc_hd__tapvpwrvgnd_1_367 VGND VPWR sky130_fd_sc_hd__tapvpwrvgnd_1
* cell instance sky130_fd_sc_hd__tapvpwrvgnd_1_368 r0 *1 0,0
Xsky130_fd_sc_hd__tapvpwrvgnd_1_368 VGND VPWR sky130_fd_sc_hd__tapvpwrvgnd_1
* cell instance sky130_fd_sc_hd__tapvpwrvgnd_1_369 r0 *1 0,0
Xsky130_fd_sc_hd__tapvpwrvgnd_1_369 VGND VPWR sky130_fd_sc_hd__tapvpwrvgnd_1
* cell instance sky130_fd_sc_hd__tapvpwrvgnd_1_370 r0 *1 0,0
Xsky130_fd_sc_hd__tapvpwrvgnd_1_370 VGND VPWR sky130_fd_sc_hd__tapvpwrvgnd_1
* cell instance sky130_fd_sc_hd__tapvpwrvgnd_1_371 r0 *1 0,0
Xsky130_fd_sc_hd__tapvpwrvgnd_1_371 VGND VPWR sky130_fd_sc_hd__tapvpwrvgnd_1
* cell instance sky130_fd_sc_hd__tapvpwrvgnd_1_372 r0 *1 0,0
Xsky130_fd_sc_hd__tapvpwrvgnd_1_372 VGND VPWR sky130_fd_sc_hd__tapvpwrvgnd_1
* cell instance sky130_fd_sc_hd__tapvpwrvgnd_1_373 r0 *1 0,0
Xsky130_fd_sc_hd__tapvpwrvgnd_1_373 VGND VPWR sky130_fd_sc_hd__tapvpwrvgnd_1
* cell instance sky130_fd_sc_hd__tapvpwrvgnd_1_374 r0 *1 0,0
Xsky130_fd_sc_hd__tapvpwrvgnd_1_374 VGND VPWR sky130_fd_sc_hd__tapvpwrvgnd_1
* cell instance sky130_fd_sc_hd__tapvpwrvgnd_1_375 r0 *1 0,0
Xsky130_fd_sc_hd__tapvpwrvgnd_1_375 VGND VPWR sky130_fd_sc_hd__tapvpwrvgnd_1
* cell instance sky130_fd_sc_hd__tapvpwrvgnd_1_376 r0 *1 0,0
Xsky130_fd_sc_hd__tapvpwrvgnd_1_376 VGND VPWR sky130_fd_sc_hd__tapvpwrvgnd_1
* cell instance sky130_fd_sc_hd__tapvpwrvgnd_1_377 r0 *1 0,0
Xsky130_fd_sc_hd__tapvpwrvgnd_1_377 VGND VPWR sky130_fd_sc_hd__tapvpwrvgnd_1
* cell instance sky130_fd_sc_hd__tapvpwrvgnd_1_378 r0 *1 0,0
Xsky130_fd_sc_hd__tapvpwrvgnd_1_378 VGND VPWR sky130_fd_sc_hd__tapvpwrvgnd_1
* cell instance sky130_fd_sc_hd__tapvpwrvgnd_1_379 r0 *1 0,0
Xsky130_fd_sc_hd__tapvpwrvgnd_1_379 VGND VPWR sky130_fd_sc_hd__tapvpwrvgnd_1
* cell instance sky130_fd_sc_hd__tapvpwrvgnd_1_380 r0 *1 0,0
Xsky130_fd_sc_hd__tapvpwrvgnd_1_380 VGND VPWR sky130_fd_sc_hd__tapvpwrvgnd_1
* cell instance sky130_fd_sc_hd__tapvpwrvgnd_1_381 r0 *1 0,0
Xsky130_fd_sc_hd__tapvpwrvgnd_1_381 VGND VPWR sky130_fd_sc_hd__tapvpwrvgnd_1
* cell instance sky130_fd_sc_hd__tapvpwrvgnd_1_382 r0 *1 0,0
Xsky130_fd_sc_hd__tapvpwrvgnd_1_382 VGND VPWR sky130_fd_sc_hd__tapvpwrvgnd_1
* cell instance sky130_fd_sc_hd__tapvpwrvgnd_1_383 r0 *1 0,0
Xsky130_fd_sc_hd__tapvpwrvgnd_1_383 VGND VPWR sky130_fd_sc_hd__tapvpwrvgnd_1
* cell instance sky130_fd_sc_hd__tapvpwrvgnd_1_384 r0 *1 0,0
Xsky130_fd_sc_hd__tapvpwrvgnd_1_384 VGND VPWR sky130_fd_sc_hd__tapvpwrvgnd_1
* cell instance sky130_fd_sc_hd__tapvpwrvgnd_1_385 r0 *1 0,0
Xsky130_fd_sc_hd__tapvpwrvgnd_1_385 VGND VPWR sky130_fd_sc_hd__tapvpwrvgnd_1
* cell instance sky130_fd_sc_hd__tapvpwrvgnd_1_386 r0 *1 0,0
Xsky130_fd_sc_hd__tapvpwrvgnd_1_386 VGND VPWR sky130_fd_sc_hd__tapvpwrvgnd_1
* cell instance sky130_fd_sc_hd__tapvpwrvgnd_1_387 r0 *1 0,0
Xsky130_fd_sc_hd__tapvpwrvgnd_1_387 VGND VPWR sky130_fd_sc_hd__tapvpwrvgnd_1
* cell instance sky130_fd_sc_hd__tapvpwrvgnd_1_388 r0 *1 0,0
Xsky130_fd_sc_hd__tapvpwrvgnd_1_388 VGND VPWR sky130_fd_sc_hd__tapvpwrvgnd_1
* cell instance sky130_fd_sc_hd__tapvpwrvgnd_1_389 r0 *1 0,0
Xsky130_fd_sc_hd__tapvpwrvgnd_1_389 VGND VPWR sky130_fd_sc_hd__tapvpwrvgnd_1
* cell instance sky130_fd_sc_hd__tapvpwrvgnd_1_390 r0 *1 0,0
Xsky130_fd_sc_hd__tapvpwrvgnd_1_390 VGND VPWR sky130_fd_sc_hd__tapvpwrvgnd_1
* cell instance sky130_fd_sc_hd__tapvpwrvgnd_1_391 r0 *1 0,0
Xsky130_fd_sc_hd__tapvpwrvgnd_1_391 VGND VPWR sky130_fd_sc_hd__tapvpwrvgnd_1
* cell instance sky130_fd_sc_hd__tapvpwrvgnd_1_392 r0 *1 0,0
Xsky130_fd_sc_hd__tapvpwrvgnd_1_392 VGND VPWR sky130_fd_sc_hd__tapvpwrvgnd_1
* cell instance sky130_fd_sc_hd__tapvpwrvgnd_1_393 r0 *1 0,0
Xsky130_fd_sc_hd__tapvpwrvgnd_1_393 VGND VPWR sky130_fd_sc_hd__tapvpwrvgnd_1
* cell instance sky130_fd_sc_hd__tapvpwrvgnd_1_394 r0 *1 0,0
Xsky130_fd_sc_hd__tapvpwrvgnd_1_394 VGND VPWR sky130_fd_sc_hd__tapvpwrvgnd_1
* cell instance sky130_fd_sc_hd__tapvpwrvgnd_1_395 r0 *1 0,0
Xsky130_fd_sc_hd__tapvpwrvgnd_1_395 VGND VPWR sky130_fd_sc_hd__tapvpwrvgnd_1
* cell instance sky130_fd_sc_hd__tapvpwrvgnd_1_396 r0 *1 0,0
Xsky130_fd_sc_hd__tapvpwrvgnd_1_396 VGND VPWR sky130_fd_sc_hd__tapvpwrvgnd_1
* cell instance sky130_fd_sc_hd__tapvpwrvgnd_1_397 r0 *1 0,0
Xsky130_fd_sc_hd__tapvpwrvgnd_1_397 VGND VPWR sky130_fd_sc_hd__tapvpwrvgnd_1
* cell instance sky130_fd_sc_hd__tapvpwrvgnd_1_398 r0 *1 0,0
Xsky130_fd_sc_hd__tapvpwrvgnd_1_398 VGND VPWR sky130_fd_sc_hd__tapvpwrvgnd_1
* cell instance sky130_fd_sc_hd__tapvpwrvgnd_1_399 r0 *1 0,0
Xsky130_fd_sc_hd__tapvpwrvgnd_1_399 VGND VPWR sky130_fd_sc_hd__tapvpwrvgnd_1
* cell instance sky130_fd_sc_hd__tapvpwrvgnd_1_400 r0 *1 0,0
Xsky130_fd_sc_hd__tapvpwrvgnd_1_400 VGND VPWR sky130_fd_sc_hd__tapvpwrvgnd_1
* cell instance sky130_fd_sc_hd__tapvpwrvgnd_1_401 r0 *1 0,0
Xsky130_fd_sc_hd__tapvpwrvgnd_1_401 VGND VPWR sky130_fd_sc_hd__tapvpwrvgnd_1
* cell instance sky130_fd_sc_hd__tapvpwrvgnd_1_402 r0 *1 0,0
Xsky130_fd_sc_hd__tapvpwrvgnd_1_402 VGND VPWR sky130_fd_sc_hd__tapvpwrvgnd_1
* cell instance sky130_fd_sc_hd__tapvpwrvgnd_1_403 r0 *1 0,0
Xsky130_fd_sc_hd__tapvpwrvgnd_1_403 VGND VPWR sky130_fd_sc_hd__tapvpwrvgnd_1
* cell instance sky130_fd_sc_hd__tapvpwrvgnd_1_404 r0 *1 0,0
Xsky130_fd_sc_hd__tapvpwrvgnd_1_404 VGND VPWR sky130_fd_sc_hd__tapvpwrvgnd_1
* cell instance sky130_fd_sc_hd__tapvpwrvgnd_1_405 r0 *1 0,0
Xsky130_fd_sc_hd__tapvpwrvgnd_1_405 VGND VPWR sky130_fd_sc_hd__tapvpwrvgnd_1
* cell instance sky130_fd_sc_hd__tapvpwrvgnd_1_406 r0 *1 0,0
Xsky130_fd_sc_hd__tapvpwrvgnd_1_406 VGND VPWR sky130_fd_sc_hd__tapvpwrvgnd_1
* cell instance sky130_fd_sc_hd__tapvpwrvgnd_1_407 r0 *1 0,0
Xsky130_fd_sc_hd__tapvpwrvgnd_1_407 VGND VPWR sky130_fd_sc_hd__tapvpwrvgnd_1
* cell instance sky130_fd_sc_hd__tapvpwrvgnd_1_408 r0 *1 0,0
Xsky130_fd_sc_hd__tapvpwrvgnd_1_408 VGND VPWR sky130_fd_sc_hd__tapvpwrvgnd_1
* cell instance sky130_fd_sc_hd__tapvpwrvgnd_1_409 r0 *1 0,0
Xsky130_fd_sc_hd__tapvpwrvgnd_1_409 VGND VPWR sky130_fd_sc_hd__tapvpwrvgnd_1
* cell instance sky130_fd_sc_hd__tapvpwrvgnd_1_410 r0 *1 0,0
Xsky130_fd_sc_hd__tapvpwrvgnd_1_410 VGND VPWR sky130_fd_sc_hd__tapvpwrvgnd_1
* cell instance sky130_fd_sc_hd__tapvpwrvgnd_1_411 r0 *1 0,0
Xsky130_fd_sc_hd__tapvpwrvgnd_1_411 VGND VPWR sky130_fd_sc_hd__tapvpwrvgnd_1
* cell instance sky130_fd_sc_hd__tapvpwrvgnd_1_412 r0 *1 0,0
Xsky130_fd_sc_hd__tapvpwrvgnd_1_412 VGND VPWR sky130_fd_sc_hd__tapvpwrvgnd_1
* cell instance sky130_fd_sc_hd__tapvpwrvgnd_1_413 r0 *1 0,0
Xsky130_fd_sc_hd__tapvpwrvgnd_1_413 VGND VPWR sky130_fd_sc_hd__tapvpwrvgnd_1
* cell instance sky130_fd_sc_hd__tapvpwrvgnd_1_414 r0 *1 0,0
Xsky130_fd_sc_hd__tapvpwrvgnd_1_414 VGND VPWR sky130_fd_sc_hd__tapvpwrvgnd_1
* cell instance sky130_fd_sc_hd__tapvpwrvgnd_1_415 r0 *1 0,0
Xsky130_fd_sc_hd__tapvpwrvgnd_1_415 VGND VPWR sky130_fd_sc_hd__tapvpwrvgnd_1
* cell instance sky130_fd_sc_hd__tapvpwrvgnd_1_416 r0 *1 0,0
Xsky130_fd_sc_hd__tapvpwrvgnd_1_416 VGND VPWR sky130_fd_sc_hd__tapvpwrvgnd_1
* cell instance sky130_fd_sc_hd__tapvpwrvgnd_1_417 r0 *1 0,0
Xsky130_fd_sc_hd__tapvpwrvgnd_1_417 VGND VPWR sky130_fd_sc_hd__tapvpwrvgnd_1
* cell instance sky130_fd_sc_hd__tapvpwrvgnd_1_418 r0 *1 0,0
Xsky130_fd_sc_hd__tapvpwrvgnd_1_418 VGND VPWR sky130_fd_sc_hd__tapvpwrvgnd_1
* cell instance sky130_fd_sc_hd__tapvpwrvgnd_1_419 r0 *1 0,0
Xsky130_fd_sc_hd__tapvpwrvgnd_1_419 VGND VPWR sky130_fd_sc_hd__tapvpwrvgnd_1
* cell instance sky130_fd_sc_hd__tapvpwrvgnd_1_420 r0 *1 0,0
Xsky130_fd_sc_hd__tapvpwrvgnd_1_420 VGND VPWR sky130_fd_sc_hd__tapvpwrvgnd_1
* cell instance sky130_fd_sc_hd__tapvpwrvgnd_1_421 r0 *1 0,0
Xsky130_fd_sc_hd__tapvpwrvgnd_1_421 VGND VPWR sky130_fd_sc_hd__tapvpwrvgnd_1
* cell instance sky130_fd_sc_hd__tapvpwrvgnd_1_422 r0 *1 0,0
Xsky130_fd_sc_hd__tapvpwrvgnd_1_422 VGND VPWR sky130_fd_sc_hd__tapvpwrvgnd_1
* cell instance sky130_fd_sc_hd__tapvpwrvgnd_1_423 r0 *1 0,0
Xsky130_fd_sc_hd__tapvpwrvgnd_1_423 VGND VPWR sky130_fd_sc_hd__tapvpwrvgnd_1
* cell instance sky130_fd_sc_hd__tapvpwrvgnd_1_424 r0 *1 0,0
Xsky130_fd_sc_hd__tapvpwrvgnd_1_424 VGND VPWR sky130_fd_sc_hd__tapvpwrvgnd_1
* cell instance sky130_fd_sc_hd__tapvpwrvgnd_1_425 r0 *1 0,0
Xsky130_fd_sc_hd__tapvpwrvgnd_1_425 VGND VPWR sky130_fd_sc_hd__tapvpwrvgnd_1
* cell instance sky130_fd_sc_hd__tapvpwrvgnd_1_426 r0 *1 0,0
Xsky130_fd_sc_hd__tapvpwrvgnd_1_426 VGND VPWR sky130_fd_sc_hd__tapvpwrvgnd_1
* cell instance sky130_fd_sc_hd__tapvpwrvgnd_1_427 r0 *1 0,0
Xsky130_fd_sc_hd__tapvpwrvgnd_1_427 VGND VPWR sky130_fd_sc_hd__tapvpwrvgnd_1
* cell instance sky130_fd_sc_hd__tapvpwrvgnd_1_428 r0 *1 0,0
Xsky130_fd_sc_hd__tapvpwrvgnd_1_428 VGND VPWR sky130_fd_sc_hd__tapvpwrvgnd_1
* cell instance sky130_fd_sc_hd__tapvpwrvgnd_1_429 r0 *1 0,0
Xsky130_fd_sc_hd__tapvpwrvgnd_1_429 VGND VPWR sky130_fd_sc_hd__tapvpwrvgnd_1
* cell instance sky130_fd_sc_hd__tapvpwrvgnd_1_430 r0 *1 0,0
Xsky130_fd_sc_hd__tapvpwrvgnd_1_430 VGND VPWR sky130_fd_sc_hd__tapvpwrvgnd_1
* cell instance sky130_fd_sc_hd__tapvpwrvgnd_1_431 r0 *1 0,0
Xsky130_fd_sc_hd__tapvpwrvgnd_1_431 VGND VPWR sky130_fd_sc_hd__tapvpwrvgnd_1
* cell instance sky130_fd_sc_hd__tapvpwrvgnd_1_432 r0 *1 0,0
Xsky130_fd_sc_hd__tapvpwrvgnd_1_432 VGND VPWR sky130_fd_sc_hd__tapvpwrvgnd_1
* cell instance sky130_fd_sc_hd__tapvpwrvgnd_1_433 r0 *1 0,0
Xsky130_fd_sc_hd__tapvpwrvgnd_1_433 VGND VPWR sky130_fd_sc_hd__tapvpwrvgnd_1
* cell instance sky130_fd_sc_hd__tapvpwrvgnd_1_434 r0 *1 0,0
Xsky130_fd_sc_hd__tapvpwrvgnd_1_434 VGND VPWR sky130_fd_sc_hd__tapvpwrvgnd_1
* cell instance sky130_fd_sc_hd__tapvpwrvgnd_1_435 r0 *1 0,0
Xsky130_fd_sc_hd__tapvpwrvgnd_1_435 VGND VPWR sky130_fd_sc_hd__tapvpwrvgnd_1
* cell instance sky130_fd_sc_hd__tapvpwrvgnd_1_436 r0 *1 0,0
Xsky130_fd_sc_hd__tapvpwrvgnd_1_436 VGND VPWR sky130_fd_sc_hd__tapvpwrvgnd_1
* cell instance sky130_fd_sc_hd__tapvpwrvgnd_1_437 r0 *1 0,0
Xsky130_fd_sc_hd__tapvpwrvgnd_1_437 VGND VPWR sky130_fd_sc_hd__tapvpwrvgnd_1
* cell instance sky130_fd_sc_hd__tapvpwrvgnd_1_438 r0 *1 0,0
Xsky130_fd_sc_hd__tapvpwrvgnd_1_438 VGND VPWR sky130_fd_sc_hd__tapvpwrvgnd_1
* cell instance sky130_fd_sc_hd__tapvpwrvgnd_1_439 r0 *1 0,0
Xsky130_fd_sc_hd__tapvpwrvgnd_1_439 VGND VPWR sky130_fd_sc_hd__tapvpwrvgnd_1
* cell instance sky130_fd_sc_hd__tapvpwrvgnd_1_440 r0 *1 0,0
Xsky130_fd_sc_hd__tapvpwrvgnd_1_440 VGND VPWR sky130_fd_sc_hd__tapvpwrvgnd_1
* cell instance sky130_fd_sc_hd__tapvpwrvgnd_1_441 r0 *1 0,0
Xsky130_fd_sc_hd__tapvpwrvgnd_1_441 VGND VPWR sky130_fd_sc_hd__tapvpwrvgnd_1
* cell instance sky130_fd_sc_hd__tapvpwrvgnd_1_442 r0 *1 0,0
Xsky130_fd_sc_hd__tapvpwrvgnd_1_442 VGND VPWR sky130_fd_sc_hd__tapvpwrvgnd_1
* cell instance sky130_fd_sc_hd__tapvpwrvgnd_1_443 r0 *1 0,0
Xsky130_fd_sc_hd__tapvpwrvgnd_1_443 VGND VPWR sky130_fd_sc_hd__tapvpwrvgnd_1
* cell instance sky130_fd_sc_hd__tapvpwrvgnd_1_444 r0 *1 0,0
Xsky130_fd_sc_hd__tapvpwrvgnd_1_444 VGND VPWR sky130_fd_sc_hd__tapvpwrvgnd_1
* cell instance sky130_fd_sc_hd__tapvpwrvgnd_1_445 r0 *1 0,0
Xsky130_fd_sc_hd__tapvpwrvgnd_1_445 VGND VPWR sky130_fd_sc_hd__tapvpwrvgnd_1
* cell instance sky130_fd_sc_hd__tapvpwrvgnd_1_446 r0 *1 0,0
Xsky130_fd_sc_hd__tapvpwrvgnd_1_446 VGND VPWR sky130_fd_sc_hd__tapvpwrvgnd_1
* cell instance sky130_fd_sc_hd__tapvpwrvgnd_1_447 r0 *1 0,0
Xsky130_fd_sc_hd__tapvpwrvgnd_1_447 VGND VPWR sky130_fd_sc_hd__tapvpwrvgnd_1
* cell instance sky130_fd_sc_hd__tapvpwrvgnd_1_448 r0 *1 0,0
Xsky130_fd_sc_hd__tapvpwrvgnd_1_448 VGND VPWR sky130_fd_sc_hd__tapvpwrvgnd_1
* cell instance sky130_fd_sc_hd__tapvpwrvgnd_1_449 r0 *1 0,0
Xsky130_fd_sc_hd__tapvpwrvgnd_1_449 VGND VPWR sky130_fd_sc_hd__tapvpwrvgnd_1
* cell instance sky130_fd_sc_hd__tapvpwrvgnd_1_450 r0 *1 0,0
Xsky130_fd_sc_hd__tapvpwrvgnd_1_450 VGND VPWR sky130_fd_sc_hd__tapvpwrvgnd_1
* cell instance sky130_fd_sc_hd__tapvpwrvgnd_1_451 r0 *1 0,0
Xsky130_fd_sc_hd__tapvpwrvgnd_1_451 VGND VPWR sky130_fd_sc_hd__tapvpwrvgnd_1
* cell instance sky130_fd_sc_hd__tapvpwrvgnd_1_452 r0 *1 0,0
Xsky130_fd_sc_hd__tapvpwrvgnd_1_452 VGND VPWR sky130_fd_sc_hd__tapvpwrvgnd_1
* cell instance sky130_fd_sc_hd__tapvpwrvgnd_1_453 r0 *1 0,0
Xsky130_fd_sc_hd__tapvpwrvgnd_1_453 VGND VPWR sky130_fd_sc_hd__tapvpwrvgnd_1
* cell instance sky130_fd_sc_hd__tapvpwrvgnd_1_454 r0 *1 0,0
Xsky130_fd_sc_hd__tapvpwrvgnd_1_454 VGND VPWR sky130_fd_sc_hd__tapvpwrvgnd_1
* cell instance sky130_fd_sc_hd__tapvpwrvgnd_1_455 r0 *1 0,0
Xsky130_fd_sc_hd__tapvpwrvgnd_1_455 VGND VPWR sky130_fd_sc_hd__tapvpwrvgnd_1
* cell instance sky130_fd_sc_hd__tapvpwrvgnd_1_456 r0 *1 0,0
Xsky130_fd_sc_hd__tapvpwrvgnd_1_456 VGND VPWR sky130_fd_sc_hd__tapvpwrvgnd_1
* cell instance sky130_fd_sc_hd__tapvpwrvgnd_1_457 r0 *1 0,0
Xsky130_fd_sc_hd__tapvpwrvgnd_1_457 VGND VPWR sky130_fd_sc_hd__tapvpwrvgnd_1
* cell instance sky130_fd_sc_hd__tapvpwrvgnd_1_458 r0 *1 0,0
Xsky130_fd_sc_hd__tapvpwrvgnd_1_458 VGND VPWR sky130_fd_sc_hd__tapvpwrvgnd_1
* cell instance sky130_fd_sc_hd__tapvpwrvgnd_1_459 r0 *1 0,0
Xsky130_fd_sc_hd__tapvpwrvgnd_1_459 VGND VPWR sky130_fd_sc_hd__tapvpwrvgnd_1
* cell instance sky130_fd_sc_hd__tapvpwrvgnd_1_460 r0 *1 0,0
Xsky130_fd_sc_hd__tapvpwrvgnd_1_460 VGND VPWR sky130_fd_sc_hd__tapvpwrvgnd_1
* cell instance sky130_fd_sc_hd__tapvpwrvgnd_1_461 r0 *1 0,0
Xsky130_fd_sc_hd__tapvpwrvgnd_1_461 VGND VPWR sky130_fd_sc_hd__tapvpwrvgnd_1
* cell instance sky130_fd_sc_hd__tapvpwrvgnd_1_462 r0 *1 0,0
Xsky130_fd_sc_hd__tapvpwrvgnd_1_462 VGND VPWR sky130_fd_sc_hd__tapvpwrvgnd_1
* cell instance sky130_fd_sc_hd__tapvpwrvgnd_1_463 r0 *1 0,0
Xsky130_fd_sc_hd__tapvpwrvgnd_1_463 VGND VPWR sky130_fd_sc_hd__tapvpwrvgnd_1
* cell instance sky130_fd_sc_hd__tapvpwrvgnd_1_464 r0 *1 0,0
Xsky130_fd_sc_hd__tapvpwrvgnd_1_464 VGND VPWR sky130_fd_sc_hd__tapvpwrvgnd_1
* cell instance sky130_fd_sc_hd__tapvpwrvgnd_1_465 r0 *1 0,0
Xsky130_fd_sc_hd__tapvpwrvgnd_1_465 VGND VPWR sky130_fd_sc_hd__tapvpwrvgnd_1
* cell instance sky130_fd_sc_hd__tapvpwrvgnd_1_466 r0 *1 0,0
Xsky130_fd_sc_hd__tapvpwrvgnd_1_466 VGND VPWR sky130_fd_sc_hd__tapvpwrvgnd_1
* cell instance sky130_fd_sc_hd__tapvpwrvgnd_1_467 r0 *1 0,0
Xsky130_fd_sc_hd__tapvpwrvgnd_1_467 VGND VPWR sky130_fd_sc_hd__tapvpwrvgnd_1
* cell instance sky130_fd_sc_hd__tapvpwrvgnd_1_468 r0 *1 0,0
Xsky130_fd_sc_hd__tapvpwrvgnd_1_468 VGND VPWR sky130_fd_sc_hd__tapvpwrvgnd_1
* cell instance sky130_fd_sc_hd__tapvpwrvgnd_1_469 r0 *1 0,0
Xsky130_fd_sc_hd__tapvpwrvgnd_1_469 VGND VPWR sky130_fd_sc_hd__tapvpwrvgnd_1
* cell instance sky130_fd_sc_hd__tapvpwrvgnd_1_470 r0 *1 0,0
Xsky130_fd_sc_hd__tapvpwrvgnd_1_470 VGND VPWR sky130_fd_sc_hd__tapvpwrvgnd_1
* cell instance sky130_fd_sc_hd__tapvpwrvgnd_1_471 r0 *1 0,0
Xsky130_fd_sc_hd__tapvpwrvgnd_1_471 VGND VPWR sky130_fd_sc_hd__tapvpwrvgnd_1
* cell instance sky130_fd_sc_hd__tapvpwrvgnd_1_472 r0 *1 0,0
Xsky130_fd_sc_hd__tapvpwrvgnd_1_472 VGND VPWR sky130_fd_sc_hd__tapvpwrvgnd_1
* cell instance sky130_fd_sc_hd__tapvpwrvgnd_1_473 r0 *1 0,0
Xsky130_fd_sc_hd__tapvpwrvgnd_1_473 VGND VPWR sky130_fd_sc_hd__tapvpwrvgnd_1
* cell instance sky130_fd_sc_hd__tapvpwrvgnd_1_474 r0 *1 0,0
Xsky130_fd_sc_hd__tapvpwrvgnd_1_474 VGND VPWR sky130_fd_sc_hd__tapvpwrvgnd_1
* cell instance sky130_fd_sc_hd__tapvpwrvgnd_1_475 r0 *1 0,0
Xsky130_fd_sc_hd__tapvpwrvgnd_1_475 VGND VPWR sky130_fd_sc_hd__tapvpwrvgnd_1
* cell instance sky130_fd_sc_hd__tapvpwrvgnd_1_476 r0 *1 0,0
Xsky130_fd_sc_hd__tapvpwrvgnd_1_476 VGND VPWR sky130_fd_sc_hd__tapvpwrvgnd_1
* cell instance sky130_fd_sc_hd__tapvpwrvgnd_1_477 r0 *1 0,0
Xsky130_fd_sc_hd__tapvpwrvgnd_1_477 VGND VPWR sky130_fd_sc_hd__tapvpwrvgnd_1
* cell instance sky130_fd_sc_hd__tapvpwrvgnd_1_478 r0 *1 0,0
Xsky130_fd_sc_hd__tapvpwrvgnd_1_478 VGND VPWR sky130_fd_sc_hd__tapvpwrvgnd_1
* cell instance sky130_fd_sc_hd__tapvpwrvgnd_1_479 r0 *1 0,0
Xsky130_fd_sc_hd__tapvpwrvgnd_1_479 VGND VPWR sky130_fd_sc_hd__tapvpwrvgnd_1
* cell instance sky130_fd_sc_hd__tapvpwrvgnd_1_480 r0 *1 0,0
Xsky130_fd_sc_hd__tapvpwrvgnd_1_480 VGND VPWR sky130_fd_sc_hd__tapvpwrvgnd_1
* cell instance sky130_fd_sc_hd__tapvpwrvgnd_1_481 r0 *1 0,0
Xsky130_fd_sc_hd__tapvpwrvgnd_1_481 VGND VPWR sky130_fd_sc_hd__tapvpwrvgnd_1
* cell instance sky130_fd_sc_hd__tapvpwrvgnd_1_482 r0 *1 0,0
Xsky130_fd_sc_hd__tapvpwrvgnd_1_482 VGND VPWR sky130_fd_sc_hd__tapvpwrvgnd_1
* cell instance sky130_fd_sc_hd__tapvpwrvgnd_1_483 r0 *1 0,0
Xsky130_fd_sc_hd__tapvpwrvgnd_1_483 VGND VPWR sky130_fd_sc_hd__tapvpwrvgnd_1
* cell instance sky130_fd_sc_hd__tapvpwrvgnd_1_484 r0 *1 0,0
Xsky130_fd_sc_hd__tapvpwrvgnd_1_484 VGND VPWR sky130_fd_sc_hd__tapvpwrvgnd_1
* cell instance sky130_fd_sc_hd__tapvpwrvgnd_1_485 r0 *1 0,0
Xsky130_fd_sc_hd__tapvpwrvgnd_1_485 VGND VPWR sky130_fd_sc_hd__tapvpwrvgnd_1
* cell instance sky130_fd_sc_hd__tapvpwrvgnd_1_486 r0 *1 0,0
Xsky130_fd_sc_hd__tapvpwrvgnd_1_486 VGND VPWR sky130_fd_sc_hd__tapvpwrvgnd_1
* cell instance sky130_fd_sc_hd__tapvpwrvgnd_1_487 r0 *1 0,0
Xsky130_fd_sc_hd__tapvpwrvgnd_1_487 VGND VPWR sky130_fd_sc_hd__tapvpwrvgnd_1
* cell instance sky130_fd_sc_hd__tapvpwrvgnd_1_488 r0 *1 0,0
Xsky130_fd_sc_hd__tapvpwrvgnd_1_488 VGND VPWR sky130_fd_sc_hd__tapvpwrvgnd_1
* cell instance sky130_fd_sc_hd__tapvpwrvgnd_1_489 r0 *1 0,0
Xsky130_fd_sc_hd__tapvpwrvgnd_1_489 VGND VPWR sky130_fd_sc_hd__tapvpwrvgnd_1
* cell instance sky130_fd_sc_hd__tapvpwrvgnd_1_490 r0 *1 0,0
Xsky130_fd_sc_hd__tapvpwrvgnd_1_490 VGND VPWR sky130_fd_sc_hd__tapvpwrvgnd_1
* cell instance sky130_fd_sc_hd__tapvpwrvgnd_1_491 r0 *1 0,0
Xsky130_fd_sc_hd__tapvpwrvgnd_1_491 VGND VPWR sky130_fd_sc_hd__tapvpwrvgnd_1
* cell instance sky130_fd_sc_hd__tapvpwrvgnd_1_492 r0 *1 0,0
Xsky130_fd_sc_hd__tapvpwrvgnd_1_492 VGND VPWR sky130_fd_sc_hd__tapvpwrvgnd_1
* cell instance sky130_fd_sc_hd__tapvpwrvgnd_1_493 r0 *1 0,0
Xsky130_fd_sc_hd__tapvpwrvgnd_1_493 VGND VPWR sky130_fd_sc_hd__tapvpwrvgnd_1
* cell instance sky130_fd_sc_hd__tapvpwrvgnd_1_494 r0 *1 0,0
Xsky130_fd_sc_hd__tapvpwrvgnd_1_494 VGND VPWR sky130_fd_sc_hd__tapvpwrvgnd_1
* cell instance sky130_fd_sc_hd__tapvpwrvgnd_1_495 r0 *1 0,0
Xsky130_fd_sc_hd__tapvpwrvgnd_1_495 VGND VPWR sky130_fd_sc_hd__tapvpwrvgnd_1
* cell instance sky130_fd_sc_hd__tapvpwrvgnd_1_496 r0 *1 0,0
Xsky130_fd_sc_hd__tapvpwrvgnd_1_496 VGND VPWR sky130_fd_sc_hd__tapvpwrvgnd_1
* cell instance sky130_fd_sc_hd__tapvpwrvgnd_1_497 r0 *1 0,0
Xsky130_fd_sc_hd__tapvpwrvgnd_1_497 VGND VPWR sky130_fd_sc_hd__tapvpwrvgnd_1
* cell instance sky130_fd_sc_hd__tapvpwrvgnd_1_498 r0 *1 0,0
Xsky130_fd_sc_hd__tapvpwrvgnd_1_498 VGND VPWR sky130_fd_sc_hd__tapvpwrvgnd_1
* cell instance sky130_fd_sc_hd__tapvpwrvgnd_1_499 r0 *1 0,0
Xsky130_fd_sc_hd__tapvpwrvgnd_1_499 VGND VPWR sky130_fd_sc_hd__tapvpwrvgnd_1
* cell instance sky130_fd_sc_hd__tapvpwrvgnd_1_500 r0 *1 0,0
Xsky130_fd_sc_hd__tapvpwrvgnd_1_500 VGND VPWR sky130_fd_sc_hd__tapvpwrvgnd_1
* cell instance sky130_fd_sc_hd__tapvpwrvgnd_1_501 r0 *1 0,0
Xsky130_fd_sc_hd__tapvpwrvgnd_1_501 VGND VPWR sky130_fd_sc_hd__tapvpwrvgnd_1
* cell instance sky130_fd_sc_hd__tapvpwrvgnd_1_502 r0 *1 0,0
Xsky130_fd_sc_hd__tapvpwrvgnd_1_502 VGND VPWR sky130_fd_sc_hd__tapvpwrvgnd_1
* cell instance sky130_fd_sc_hd__tapvpwrvgnd_1_503 r0 *1 0,0
Xsky130_fd_sc_hd__tapvpwrvgnd_1_503 VGND VPWR sky130_fd_sc_hd__tapvpwrvgnd_1
* cell instance sky130_fd_sc_hd__tapvpwrvgnd_1_504 r0 *1 0,0
Xsky130_fd_sc_hd__tapvpwrvgnd_1_504 VGND VPWR sky130_fd_sc_hd__tapvpwrvgnd_1
* cell instance sky130_fd_sc_hd__tapvpwrvgnd_1_505 r0 *1 0,0
Xsky130_fd_sc_hd__tapvpwrvgnd_1_505 VGND VPWR sky130_fd_sc_hd__tapvpwrvgnd_1
* cell instance sky130_fd_sc_hd__tapvpwrvgnd_1_506 r0 *1 0,0
Xsky130_fd_sc_hd__tapvpwrvgnd_1_506 VGND VPWR sky130_fd_sc_hd__tapvpwrvgnd_1
* cell instance sky130_fd_sc_hd__tapvpwrvgnd_1_507 r0 *1 0,0
Xsky130_fd_sc_hd__tapvpwrvgnd_1_507 VGND VPWR sky130_fd_sc_hd__tapvpwrvgnd_1
* cell instance sky130_fd_sc_hd__tapvpwrvgnd_1_508 r0 *1 0,0
Xsky130_fd_sc_hd__tapvpwrvgnd_1_508 VGND VPWR sky130_fd_sc_hd__tapvpwrvgnd_1
* cell instance sky130_fd_sc_hd__tapvpwrvgnd_1_509 r0 *1 0,0
Xsky130_fd_sc_hd__tapvpwrvgnd_1_509 VGND VPWR sky130_fd_sc_hd__tapvpwrvgnd_1
* cell instance sky130_fd_sc_hd__tapvpwrvgnd_1_510 r0 *1 0,0
Xsky130_fd_sc_hd__tapvpwrvgnd_1_510 VGND VPWR sky130_fd_sc_hd__tapvpwrvgnd_1
* cell instance sky130_fd_sc_hd__tapvpwrvgnd_1_511 r0 *1 0,0
Xsky130_fd_sc_hd__tapvpwrvgnd_1_511 VGND VPWR sky130_fd_sc_hd__tapvpwrvgnd_1
* cell instance sky130_fd_sc_hd__tapvpwrvgnd_1_512 r0 *1 0,0
Xsky130_fd_sc_hd__tapvpwrvgnd_1_512 VGND VPWR sky130_fd_sc_hd__tapvpwrvgnd_1
* cell instance sky130_fd_sc_hd__tapvpwrvgnd_1_513 r0 *1 0,0
Xsky130_fd_sc_hd__tapvpwrvgnd_1_513 VGND VPWR sky130_fd_sc_hd__tapvpwrvgnd_1
* cell instance sky130_fd_sc_hd__tapvpwrvgnd_1_514 r0 *1 0,0
Xsky130_fd_sc_hd__tapvpwrvgnd_1_514 VGND VPWR sky130_fd_sc_hd__tapvpwrvgnd_1
* cell instance sky130_fd_sc_hd__tapvpwrvgnd_1_515 r0 *1 0,0
Xsky130_fd_sc_hd__tapvpwrvgnd_1_515 VGND VPWR sky130_fd_sc_hd__tapvpwrvgnd_1
* cell instance sky130_fd_sc_hd__tapvpwrvgnd_1_516 r0 *1 0,0
Xsky130_fd_sc_hd__tapvpwrvgnd_1_516 VGND VPWR sky130_fd_sc_hd__tapvpwrvgnd_1
* cell instance sky130_fd_sc_hd__tapvpwrvgnd_1_517 r0 *1 0,0
Xsky130_fd_sc_hd__tapvpwrvgnd_1_517 VGND VPWR sky130_fd_sc_hd__tapvpwrvgnd_1
* cell instance sky130_fd_sc_hd__tapvpwrvgnd_1_518 r0 *1 0,0
Xsky130_fd_sc_hd__tapvpwrvgnd_1_518 VGND VPWR sky130_fd_sc_hd__tapvpwrvgnd_1
* cell instance sky130_fd_sc_hd__tapvpwrvgnd_1_519 r0 *1 0,0
Xsky130_fd_sc_hd__tapvpwrvgnd_1_519 VGND VPWR sky130_fd_sc_hd__tapvpwrvgnd_1
* cell instance sky130_fd_sc_hd__tapvpwrvgnd_1_520 r0 *1 0,0
Xsky130_fd_sc_hd__tapvpwrvgnd_1_520 VGND VPWR sky130_fd_sc_hd__tapvpwrvgnd_1
* cell instance sky130_fd_sc_hd__tapvpwrvgnd_1_521 r0 *1 0,0
Xsky130_fd_sc_hd__tapvpwrvgnd_1_521 VGND VPWR sky130_fd_sc_hd__tapvpwrvgnd_1
* cell instance sky130_fd_sc_hd__tapvpwrvgnd_1_522 r0 *1 0,0
Xsky130_fd_sc_hd__tapvpwrvgnd_1_522 VGND VPWR sky130_fd_sc_hd__tapvpwrvgnd_1
* cell instance sky130_fd_sc_hd__tapvpwrvgnd_1_523 r0 *1 0,0
Xsky130_fd_sc_hd__tapvpwrvgnd_1_523 VGND VPWR sky130_fd_sc_hd__tapvpwrvgnd_1
* cell instance sky130_fd_sc_hd__tapvpwrvgnd_1_524 r0 *1 0,0
Xsky130_fd_sc_hd__tapvpwrvgnd_1_524 VGND VPWR sky130_fd_sc_hd__tapvpwrvgnd_1
* cell instance sky130_fd_sc_hd__tapvpwrvgnd_1_525 r0 *1 0,0
Xsky130_fd_sc_hd__tapvpwrvgnd_1_525 VGND VPWR sky130_fd_sc_hd__tapvpwrvgnd_1
* cell instance sky130_fd_sc_hd__tapvpwrvgnd_1_526 r0 *1 0,0
Xsky130_fd_sc_hd__tapvpwrvgnd_1_526 VGND VPWR sky130_fd_sc_hd__tapvpwrvgnd_1
* cell instance sky130_fd_sc_hd__tapvpwrvgnd_1_527 r0 *1 0,0
Xsky130_fd_sc_hd__tapvpwrvgnd_1_527 VGND VPWR sky130_fd_sc_hd__tapvpwrvgnd_1
* cell instance sky130_fd_sc_hd__tapvpwrvgnd_1_528 r0 *1 0,0
Xsky130_fd_sc_hd__tapvpwrvgnd_1_528 VGND VPWR sky130_fd_sc_hd__tapvpwrvgnd_1
* cell instance sky130_fd_sc_hd__tapvpwrvgnd_1_529 r0 *1 0,0
Xsky130_fd_sc_hd__tapvpwrvgnd_1_529 VGND VPWR sky130_fd_sc_hd__tapvpwrvgnd_1
* cell instance sky130_fd_sc_hd__tapvpwrvgnd_1_530 r0 *1 0,0
Xsky130_fd_sc_hd__tapvpwrvgnd_1_530 VGND VPWR sky130_fd_sc_hd__tapvpwrvgnd_1
* cell instance sky130_fd_sc_hd__tapvpwrvgnd_1_531 r0 *1 0,0
Xsky130_fd_sc_hd__tapvpwrvgnd_1_531 VGND VPWR sky130_fd_sc_hd__tapvpwrvgnd_1
* cell instance sky130_fd_sc_hd__tapvpwrvgnd_1_532 r0 *1 0,0
Xsky130_fd_sc_hd__tapvpwrvgnd_1_532 VGND VPWR sky130_fd_sc_hd__tapvpwrvgnd_1
* cell instance sky130_fd_sc_hd__tapvpwrvgnd_1_533 r0 *1 0,0
Xsky130_fd_sc_hd__tapvpwrvgnd_1_533 VGND VPWR sky130_fd_sc_hd__tapvpwrvgnd_1
* cell instance sky130_fd_sc_hd__tapvpwrvgnd_1_534 r0 *1 0,0
Xsky130_fd_sc_hd__tapvpwrvgnd_1_534 VGND VPWR sky130_fd_sc_hd__tapvpwrvgnd_1
* cell instance sky130_fd_sc_hd__tapvpwrvgnd_1_535 r0 *1 0,0
Xsky130_fd_sc_hd__tapvpwrvgnd_1_535 VGND VPWR sky130_fd_sc_hd__tapvpwrvgnd_1
* cell instance sky130_fd_sc_hd__tapvpwrvgnd_1_536 r0 *1 0,0
Xsky130_fd_sc_hd__tapvpwrvgnd_1_536 VGND VPWR sky130_fd_sc_hd__tapvpwrvgnd_1
* cell instance sky130_fd_sc_hd__tapvpwrvgnd_1_537 r0 *1 0,0
Xsky130_fd_sc_hd__tapvpwrvgnd_1_537 VGND VPWR sky130_fd_sc_hd__tapvpwrvgnd_1
* cell instance sky130_fd_sc_hd__tapvpwrvgnd_1_538 r0 *1 0,0
Xsky130_fd_sc_hd__tapvpwrvgnd_1_538 VGND VPWR sky130_fd_sc_hd__tapvpwrvgnd_1
* cell instance sky130_fd_sc_hd__tapvpwrvgnd_1_539 r0 *1 0,0
Xsky130_fd_sc_hd__tapvpwrvgnd_1_539 VGND VPWR sky130_fd_sc_hd__tapvpwrvgnd_1
* cell instance sky130_fd_sc_hd__tapvpwrvgnd_1_540 r0 *1 0,0
Xsky130_fd_sc_hd__tapvpwrvgnd_1_540 VGND VPWR sky130_fd_sc_hd__tapvpwrvgnd_1
* cell instance sky130_fd_sc_hd__tapvpwrvgnd_1_541 r0 *1 0,0
Xsky130_fd_sc_hd__tapvpwrvgnd_1_541 VGND VPWR sky130_fd_sc_hd__tapvpwrvgnd_1
* cell instance sky130_fd_sc_hd__tapvpwrvgnd_1_542 r0 *1 0,0
Xsky130_fd_sc_hd__tapvpwrvgnd_1_542 VGND VPWR sky130_fd_sc_hd__tapvpwrvgnd_1
* cell instance sky130_fd_sc_hd__tapvpwrvgnd_1_543 r0 *1 0,0
Xsky130_fd_sc_hd__tapvpwrvgnd_1_543 VGND VPWR sky130_fd_sc_hd__tapvpwrvgnd_1
* cell instance sky130_fd_sc_hd__tapvpwrvgnd_1_544 r0 *1 0,0
Xsky130_fd_sc_hd__tapvpwrvgnd_1_544 VGND VPWR sky130_fd_sc_hd__tapvpwrvgnd_1
* cell instance sky130_fd_sc_hd__tapvpwrvgnd_1_545 r0 *1 0,0
Xsky130_fd_sc_hd__tapvpwrvgnd_1_545 VGND VPWR sky130_fd_sc_hd__tapvpwrvgnd_1
* cell instance sky130_fd_sc_hd__tapvpwrvgnd_1_546 r0 *1 0,0
Xsky130_fd_sc_hd__tapvpwrvgnd_1_546 VGND VPWR sky130_fd_sc_hd__tapvpwrvgnd_1
* cell instance sky130_fd_sc_hd__tapvpwrvgnd_1_547 r0 *1 0,0
Xsky130_fd_sc_hd__tapvpwrvgnd_1_547 VGND VPWR sky130_fd_sc_hd__tapvpwrvgnd_1
* cell instance sky130_fd_sc_hd__tapvpwrvgnd_1_548 r0 *1 0,0
Xsky130_fd_sc_hd__tapvpwrvgnd_1_548 VGND VPWR sky130_fd_sc_hd__tapvpwrvgnd_1
* cell instance sky130_fd_sc_hd__tapvpwrvgnd_1_549 r0 *1 0,0
Xsky130_fd_sc_hd__tapvpwrvgnd_1_549 VGND VPWR sky130_fd_sc_hd__tapvpwrvgnd_1
* cell instance sky130_fd_sc_hd__tapvpwrvgnd_1_550 r0 *1 0,0
Xsky130_fd_sc_hd__tapvpwrvgnd_1_550 VGND VPWR sky130_fd_sc_hd__tapvpwrvgnd_1
* cell instance sky130_fd_sc_hd__tapvpwrvgnd_1_551 r0 *1 0,0
Xsky130_fd_sc_hd__tapvpwrvgnd_1_551 VGND VPWR sky130_fd_sc_hd__tapvpwrvgnd_1
* cell instance sky130_fd_sc_hd__tapvpwrvgnd_1_552 r0 *1 0,0
Xsky130_fd_sc_hd__tapvpwrvgnd_1_552 VGND VPWR sky130_fd_sc_hd__tapvpwrvgnd_1
* cell instance sky130_fd_sc_hd__tapvpwrvgnd_1_553 r0 *1 0,0
Xsky130_fd_sc_hd__tapvpwrvgnd_1_553 VGND VPWR sky130_fd_sc_hd__tapvpwrvgnd_1
* cell instance sky130_fd_sc_hd__tapvpwrvgnd_1_554 r0 *1 0,0
Xsky130_fd_sc_hd__tapvpwrvgnd_1_554 VGND VPWR sky130_fd_sc_hd__tapvpwrvgnd_1
* cell instance sky130_fd_sc_hd__tapvpwrvgnd_1_555 r0 *1 0,0
Xsky130_fd_sc_hd__tapvpwrvgnd_1_555 VGND VPWR sky130_fd_sc_hd__tapvpwrvgnd_1
* cell instance sky130_fd_sc_hd__tapvpwrvgnd_1_556 r0 *1 0,0
Xsky130_fd_sc_hd__tapvpwrvgnd_1_556 VGND VPWR sky130_fd_sc_hd__tapvpwrvgnd_1
* cell instance sky130_fd_sc_hd__tapvpwrvgnd_1_557 r0 *1 0,0
Xsky130_fd_sc_hd__tapvpwrvgnd_1_557 VGND VPWR sky130_fd_sc_hd__tapvpwrvgnd_1
* cell instance sky130_fd_sc_hd__tapvpwrvgnd_1_558 r0 *1 0,0
Xsky130_fd_sc_hd__tapvpwrvgnd_1_558 VGND VPWR sky130_fd_sc_hd__tapvpwrvgnd_1
* cell instance sky130_fd_sc_hd__tapvpwrvgnd_1_559 r0 *1 0,0
Xsky130_fd_sc_hd__tapvpwrvgnd_1_559 VGND VPWR sky130_fd_sc_hd__tapvpwrvgnd_1
* cell instance sky130_fd_sc_hd__tapvpwrvgnd_1_560 r0 *1 0,0
Xsky130_fd_sc_hd__tapvpwrvgnd_1_560 VGND VPWR sky130_fd_sc_hd__tapvpwrvgnd_1
* cell instance sky130_fd_sc_hd__tapvpwrvgnd_1_561 r0 *1 0,0
Xsky130_fd_sc_hd__tapvpwrvgnd_1_561 VGND VPWR sky130_fd_sc_hd__tapvpwrvgnd_1
* cell instance sky130_fd_sc_hd__tapvpwrvgnd_1_562 r0 *1 0,0
Xsky130_fd_sc_hd__tapvpwrvgnd_1_562 VGND VPWR sky130_fd_sc_hd__tapvpwrvgnd_1
* cell instance sky130_fd_sc_hd__tapvpwrvgnd_1_563 r0 *1 0,0
Xsky130_fd_sc_hd__tapvpwrvgnd_1_563 VGND VPWR sky130_fd_sc_hd__tapvpwrvgnd_1
* cell instance sky130_fd_sc_hd__tapvpwrvgnd_1_564 r0 *1 0,0
Xsky130_fd_sc_hd__tapvpwrvgnd_1_564 VGND VPWR sky130_fd_sc_hd__tapvpwrvgnd_1
* cell instance sky130_fd_sc_hd__tapvpwrvgnd_1_565 r0 *1 0,0
Xsky130_fd_sc_hd__tapvpwrvgnd_1_565 VGND VPWR sky130_fd_sc_hd__tapvpwrvgnd_1
* cell instance sky130_fd_sc_hd__tapvpwrvgnd_1_566 r0 *1 0,0
Xsky130_fd_sc_hd__tapvpwrvgnd_1_566 VGND VPWR sky130_fd_sc_hd__tapvpwrvgnd_1
* cell instance sky130_fd_sc_hd__tapvpwrvgnd_1_567 r0 *1 0,0
Xsky130_fd_sc_hd__tapvpwrvgnd_1_567 VGND VPWR sky130_fd_sc_hd__tapvpwrvgnd_1
* cell instance sky130_fd_sc_hd__tapvpwrvgnd_1_568 r0 *1 0,0
Xsky130_fd_sc_hd__tapvpwrvgnd_1_568 VGND VPWR sky130_fd_sc_hd__tapvpwrvgnd_1
* cell instance sky130_fd_sc_hd__tapvpwrvgnd_1_569 r0 *1 0,0
Xsky130_fd_sc_hd__tapvpwrvgnd_1_569 VGND VPWR sky130_fd_sc_hd__tapvpwrvgnd_1
* cell instance sky130_fd_sc_hd__tapvpwrvgnd_1_570 r0 *1 0,0
Xsky130_fd_sc_hd__tapvpwrvgnd_1_570 VGND VPWR sky130_fd_sc_hd__tapvpwrvgnd_1
* cell instance sky130_fd_sc_hd__tapvpwrvgnd_1_571 r0 *1 0,0
Xsky130_fd_sc_hd__tapvpwrvgnd_1_571 VGND VPWR sky130_fd_sc_hd__tapvpwrvgnd_1
* cell instance sky130_fd_sc_hd__tapvpwrvgnd_1_572 r0 *1 0,0
Xsky130_fd_sc_hd__tapvpwrvgnd_1_572 VGND VPWR sky130_fd_sc_hd__tapvpwrvgnd_1
* cell instance sky130_fd_sc_hd__tapvpwrvgnd_1_573 r0 *1 0,0
Xsky130_fd_sc_hd__tapvpwrvgnd_1_573 VGND VPWR sky130_fd_sc_hd__tapvpwrvgnd_1
* cell instance sky130_fd_sc_hd__tapvpwrvgnd_1_574 r0 *1 0,0
Xsky130_fd_sc_hd__tapvpwrvgnd_1_574 VGND VPWR sky130_fd_sc_hd__tapvpwrvgnd_1
* cell instance sky130_fd_sc_hd__tapvpwrvgnd_1_575 r0 *1 0,0
Xsky130_fd_sc_hd__tapvpwrvgnd_1_575 VGND VPWR sky130_fd_sc_hd__tapvpwrvgnd_1
* cell instance sky130_fd_sc_hd__tapvpwrvgnd_1_576 r0 *1 0,0
Xsky130_fd_sc_hd__tapvpwrvgnd_1_576 VGND VPWR sky130_fd_sc_hd__tapvpwrvgnd_1
* cell instance sky130_fd_sc_hd__tapvpwrvgnd_1_577 r0 *1 0,0
Xsky130_fd_sc_hd__tapvpwrvgnd_1_577 VGND VPWR sky130_fd_sc_hd__tapvpwrvgnd_1
* cell instance sky130_fd_sc_hd__tapvpwrvgnd_1_578 r0 *1 0,0
Xsky130_fd_sc_hd__tapvpwrvgnd_1_578 VGND VPWR sky130_fd_sc_hd__tapvpwrvgnd_1
* cell instance sky130_fd_sc_hd__tapvpwrvgnd_1_579 r0 *1 0,0
Xsky130_fd_sc_hd__tapvpwrvgnd_1_579 VGND VPWR sky130_fd_sc_hd__tapvpwrvgnd_1
* cell instance sky130_fd_sc_hd__tapvpwrvgnd_1_580 r0 *1 0,0
Xsky130_fd_sc_hd__tapvpwrvgnd_1_580 VGND VPWR sky130_fd_sc_hd__tapvpwrvgnd_1
* cell instance sky130_fd_sc_hd__tapvpwrvgnd_1_581 r0 *1 0,0
Xsky130_fd_sc_hd__tapvpwrvgnd_1_581 VGND VPWR sky130_fd_sc_hd__tapvpwrvgnd_1
* cell instance sky130_fd_sc_hd__tapvpwrvgnd_1_582 r0 *1 0,0
Xsky130_fd_sc_hd__tapvpwrvgnd_1_582 VGND VPWR sky130_fd_sc_hd__tapvpwrvgnd_1
* cell instance sky130_fd_sc_hd__tapvpwrvgnd_1_583 r0 *1 0,0
Xsky130_fd_sc_hd__tapvpwrvgnd_1_583 VGND VPWR sky130_fd_sc_hd__tapvpwrvgnd_1
* cell instance sky130_fd_sc_hd__tapvpwrvgnd_1_584 r0 *1 0,0
Xsky130_fd_sc_hd__tapvpwrvgnd_1_584 VGND VPWR sky130_fd_sc_hd__tapvpwrvgnd_1
* cell instance sky130_fd_sc_hd__tapvpwrvgnd_1_585 r0 *1 0,0
Xsky130_fd_sc_hd__tapvpwrvgnd_1_585 VGND VPWR sky130_fd_sc_hd__tapvpwrvgnd_1
* cell instance sky130_fd_sc_hd__tapvpwrvgnd_1_586 r0 *1 0,0
Xsky130_fd_sc_hd__tapvpwrvgnd_1_586 VGND VPWR sky130_fd_sc_hd__tapvpwrvgnd_1
* cell instance sky130_fd_sc_hd__tapvpwrvgnd_1_587 r0 *1 0,0
Xsky130_fd_sc_hd__tapvpwrvgnd_1_587 VGND VPWR sky130_fd_sc_hd__tapvpwrvgnd_1
* cell instance sky130_fd_sc_hd__tapvpwrvgnd_1_588 r0 *1 0,0
Xsky130_fd_sc_hd__tapvpwrvgnd_1_588 VGND VPWR sky130_fd_sc_hd__tapvpwrvgnd_1
* cell instance sky130_fd_sc_hd__tapvpwrvgnd_1_589 r0 *1 0,0
Xsky130_fd_sc_hd__tapvpwrvgnd_1_589 VGND VPWR sky130_fd_sc_hd__tapvpwrvgnd_1
* cell instance sky130_fd_sc_hd__tapvpwrvgnd_1_590 r0 *1 0,0
Xsky130_fd_sc_hd__tapvpwrvgnd_1_590 VGND VPWR sky130_fd_sc_hd__tapvpwrvgnd_1
* cell instance sky130_fd_sc_hd__tapvpwrvgnd_1_591 r0 *1 0,0
Xsky130_fd_sc_hd__tapvpwrvgnd_1_591 VGND VPWR sky130_fd_sc_hd__tapvpwrvgnd_1
* cell instance sky130_fd_sc_hd__tapvpwrvgnd_1_592 r0 *1 0,0
Xsky130_fd_sc_hd__tapvpwrvgnd_1_592 VGND VPWR sky130_fd_sc_hd__tapvpwrvgnd_1
* cell instance sky130_fd_sc_hd__tapvpwrvgnd_1_593 r0 *1 0,0
Xsky130_fd_sc_hd__tapvpwrvgnd_1_593 VGND VPWR sky130_fd_sc_hd__tapvpwrvgnd_1
* cell instance sky130_fd_sc_hd__tapvpwrvgnd_1_594 r0 *1 0,0
Xsky130_fd_sc_hd__tapvpwrvgnd_1_594 VGND VPWR sky130_fd_sc_hd__tapvpwrvgnd_1
* cell instance sky130_fd_sc_hd__tapvpwrvgnd_1_595 r0 *1 0,0
Xsky130_fd_sc_hd__tapvpwrvgnd_1_595 VGND VPWR sky130_fd_sc_hd__tapvpwrvgnd_1
* cell instance sky130_fd_sc_hd__tapvpwrvgnd_1_596 r0 *1 0,0
Xsky130_fd_sc_hd__tapvpwrvgnd_1_596 VGND VPWR sky130_fd_sc_hd__tapvpwrvgnd_1
* cell instance sky130_fd_sc_hd__tapvpwrvgnd_1_597 r0 *1 0,0
Xsky130_fd_sc_hd__tapvpwrvgnd_1_597 VGND VPWR sky130_fd_sc_hd__tapvpwrvgnd_1
* cell instance sky130_fd_sc_hd__tapvpwrvgnd_1_598 r0 *1 0,0
Xsky130_fd_sc_hd__tapvpwrvgnd_1_598 VGND VPWR sky130_fd_sc_hd__tapvpwrvgnd_1
* cell instance sky130_fd_sc_hd__tapvpwrvgnd_1_599 r0 *1 0,0
Xsky130_fd_sc_hd__tapvpwrvgnd_1_599 VGND VPWR sky130_fd_sc_hd__tapvpwrvgnd_1
* cell instance sky130_fd_sc_hd__tapvpwrvgnd_1_600 r0 *1 0,0
Xsky130_fd_sc_hd__tapvpwrvgnd_1_600 VGND VPWR sky130_fd_sc_hd__tapvpwrvgnd_1
* cell instance sky130_fd_sc_hd__tapvpwrvgnd_1_601 r0 *1 0,0
Xsky130_fd_sc_hd__tapvpwrvgnd_1_601 VGND VPWR sky130_fd_sc_hd__tapvpwrvgnd_1
* cell instance sky130_fd_sc_hd__tapvpwrvgnd_1_602 r0 *1 0,0
Xsky130_fd_sc_hd__tapvpwrvgnd_1_602 VGND VPWR sky130_fd_sc_hd__tapvpwrvgnd_1
* cell instance sky130_fd_sc_hd__tapvpwrvgnd_1_603 r0 *1 0,0
Xsky130_fd_sc_hd__tapvpwrvgnd_1_603 VGND VPWR sky130_fd_sc_hd__tapvpwrvgnd_1
* cell instance sky130_fd_sc_hd__tapvpwrvgnd_1_604 r0 *1 0,0
Xsky130_fd_sc_hd__tapvpwrvgnd_1_604 VGND VPWR sky130_fd_sc_hd__tapvpwrvgnd_1
* cell instance sky130_fd_sc_hd__tapvpwrvgnd_1_605 r0 *1 0,0
Xsky130_fd_sc_hd__tapvpwrvgnd_1_605 VGND VPWR sky130_fd_sc_hd__tapvpwrvgnd_1
* cell instance sky130_fd_sc_hd__tapvpwrvgnd_1_606 r0 *1 0,0
Xsky130_fd_sc_hd__tapvpwrvgnd_1_606 VGND VPWR sky130_fd_sc_hd__tapvpwrvgnd_1
* cell instance sky130_fd_sc_hd__tapvpwrvgnd_1_607 r0 *1 0,0
Xsky130_fd_sc_hd__tapvpwrvgnd_1_607 VGND VPWR sky130_fd_sc_hd__tapvpwrvgnd_1
* cell instance sky130_fd_sc_hd__tapvpwrvgnd_1_608 r0 *1 0,0
Xsky130_fd_sc_hd__tapvpwrvgnd_1_608 VGND VPWR sky130_fd_sc_hd__tapvpwrvgnd_1
* cell instance sky130_fd_sc_hd__tapvpwrvgnd_1_609 r0 *1 0,0
Xsky130_fd_sc_hd__tapvpwrvgnd_1_609 VGND VPWR sky130_fd_sc_hd__tapvpwrvgnd_1
* cell instance sky130_fd_sc_hd__tapvpwrvgnd_1_610 r0 *1 0,0
Xsky130_fd_sc_hd__tapvpwrvgnd_1_610 VGND VPWR sky130_fd_sc_hd__tapvpwrvgnd_1
* cell instance sky130_fd_sc_hd__tapvpwrvgnd_1_611 r0 *1 0,0
Xsky130_fd_sc_hd__tapvpwrvgnd_1_611 VGND VPWR sky130_fd_sc_hd__tapvpwrvgnd_1
* cell instance sky130_fd_sc_hd__tapvpwrvgnd_1_612 r0 *1 0,0
Xsky130_fd_sc_hd__tapvpwrvgnd_1_612 VGND VPWR sky130_fd_sc_hd__tapvpwrvgnd_1
* cell instance sky130_fd_sc_hd__tapvpwrvgnd_1_613 r0 *1 0,0
Xsky130_fd_sc_hd__tapvpwrvgnd_1_613 VGND VPWR sky130_fd_sc_hd__tapvpwrvgnd_1
* cell instance sky130_fd_sc_hd__tapvpwrvgnd_1_614 r0 *1 0,0
Xsky130_fd_sc_hd__tapvpwrvgnd_1_614 VGND VPWR sky130_fd_sc_hd__tapvpwrvgnd_1
* cell instance sky130_fd_sc_hd__tapvpwrvgnd_1_615 r0 *1 0,0
Xsky130_fd_sc_hd__tapvpwrvgnd_1_615 VGND VPWR sky130_fd_sc_hd__tapvpwrvgnd_1
* cell instance sky130_fd_sc_hd__tapvpwrvgnd_1_616 r0 *1 0,0
Xsky130_fd_sc_hd__tapvpwrvgnd_1_616 VGND VPWR sky130_fd_sc_hd__tapvpwrvgnd_1
* cell instance sky130_fd_sc_hd__tapvpwrvgnd_1_617 r0 *1 0,0
Xsky130_fd_sc_hd__tapvpwrvgnd_1_617 VGND VPWR sky130_fd_sc_hd__tapvpwrvgnd_1
* cell instance sky130_fd_sc_hd__tapvpwrvgnd_1_618 r0 *1 0,0
Xsky130_fd_sc_hd__tapvpwrvgnd_1_618 VGND VPWR sky130_fd_sc_hd__tapvpwrvgnd_1
* cell instance sky130_fd_sc_hd__tapvpwrvgnd_1_619 r0 *1 0,0
Xsky130_fd_sc_hd__tapvpwrvgnd_1_619 VGND VPWR sky130_fd_sc_hd__tapvpwrvgnd_1
* cell instance sky130_fd_sc_hd__tapvpwrvgnd_1_620 r0 *1 0,0
Xsky130_fd_sc_hd__tapvpwrvgnd_1_620 VGND VPWR sky130_fd_sc_hd__tapvpwrvgnd_1
* cell instance sky130_fd_sc_hd__tapvpwrvgnd_1_621 r0 *1 0,0
Xsky130_fd_sc_hd__tapvpwrvgnd_1_621 VGND VPWR sky130_fd_sc_hd__tapvpwrvgnd_1
* cell instance sky130_fd_sc_hd__tapvpwrvgnd_1_622 r0 *1 0,0
Xsky130_fd_sc_hd__tapvpwrvgnd_1_622 VGND VPWR sky130_fd_sc_hd__tapvpwrvgnd_1
* cell instance sky130_fd_sc_hd__tapvpwrvgnd_1_623 r0 *1 0,0
Xsky130_fd_sc_hd__tapvpwrvgnd_1_623 VGND VPWR sky130_fd_sc_hd__tapvpwrvgnd_1
* cell instance sky130_fd_sc_hd__tapvpwrvgnd_1_624 r0 *1 0,0
Xsky130_fd_sc_hd__tapvpwrvgnd_1_624 VGND VPWR sky130_fd_sc_hd__tapvpwrvgnd_1
* cell instance sky130_fd_sc_hd__tapvpwrvgnd_1_625 r0 *1 0,0
Xsky130_fd_sc_hd__tapvpwrvgnd_1_625 VGND VPWR sky130_fd_sc_hd__tapvpwrvgnd_1
* cell instance sky130_fd_sc_hd__tapvpwrvgnd_1_626 r0 *1 0,0
Xsky130_fd_sc_hd__tapvpwrvgnd_1_626 VGND VPWR sky130_fd_sc_hd__tapvpwrvgnd_1
* cell instance sky130_fd_sc_hd__tapvpwrvgnd_1_627 r0 *1 0,0
Xsky130_fd_sc_hd__tapvpwrvgnd_1_627 VGND VPWR sky130_fd_sc_hd__tapvpwrvgnd_1
* cell instance sky130_fd_sc_hd__tapvpwrvgnd_1_628 r0 *1 0,0
Xsky130_fd_sc_hd__tapvpwrvgnd_1_628 VGND VPWR sky130_fd_sc_hd__tapvpwrvgnd_1
* cell instance sky130_fd_sc_hd__tapvpwrvgnd_1_629 r0 *1 0,0
Xsky130_fd_sc_hd__tapvpwrvgnd_1_629 VGND VPWR sky130_fd_sc_hd__tapvpwrvgnd_1
* cell instance sky130_fd_sc_hd__tapvpwrvgnd_1_630 r0 *1 0,0
Xsky130_fd_sc_hd__tapvpwrvgnd_1_630 VGND VPWR sky130_fd_sc_hd__tapvpwrvgnd_1
* cell instance sky130_fd_sc_hd__tapvpwrvgnd_1_631 r0 *1 0,0
Xsky130_fd_sc_hd__tapvpwrvgnd_1_631 VGND VPWR sky130_fd_sc_hd__tapvpwrvgnd_1
* cell instance sky130_fd_sc_hd__tapvpwrvgnd_1_632 r0 *1 0,0
Xsky130_fd_sc_hd__tapvpwrvgnd_1_632 VGND VPWR sky130_fd_sc_hd__tapvpwrvgnd_1
* cell instance sky130_fd_sc_hd__tapvpwrvgnd_1_633 r0 *1 0,0
Xsky130_fd_sc_hd__tapvpwrvgnd_1_633 VGND VPWR sky130_fd_sc_hd__tapvpwrvgnd_1
* cell instance sky130_fd_sc_hd__tapvpwrvgnd_1_634 r0 *1 0,0
Xsky130_fd_sc_hd__tapvpwrvgnd_1_634 VGND VPWR sky130_fd_sc_hd__tapvpwrvgnd_1
* cell instance sky130_fd_sc_hd__tapvpwrvgnd_1_635 r0 *1 0,0
Xsky130_fd_sc_hd__tapvpwrvgnd_1_635 VGND VPWR sky130_fd_sc_hd__tapvpwrvgnd_1
* cell instance sky130_fd_sc_hd__tapvpwrvgnd_1_636 r0 *1 0,0
Xsky130_fd_sc_hd__tapvpwrvgnd_1_636 VGND VPWR sky130_fd_sc_hd__tapvpwrvgnd_1
* cell instance sky130_fd_sc_hd__tapvpwrvgnd_1_637 r0 *1 0,0
Xsky130_fd_sc_hd__tapvpwrvgnd_1_637 VGND VPWR sky130_fd_sc_hd__tapvpwrvgnd_1
* cell instance sky130_fd_sc_hd__tapvpwrvgnd_1_638 r0 *1 0,0
Xsky130_fd_sc_hd__tapvpwrvgnd_1_638 VGND VPWR sky130_fd_sc_hd__tapvpwrvgnd_1
* cell instance sky130_fd_sc_hd__tapvpwrvgnd_1_639 r0 *1 0,0
Xsky130_fd_sc_hd__tapvpwrvgnd_1_639 VGND VPWR sky130_fd_sc_hd__tapvpwrvgnd_1
* cell instance sky130_fd_sc_hd__tapvpwrvgnd_1_640 r0 *1 0,0
Xsky130_fd_sc_hd__tapvpwrvgnd_1_640 VGND VPWR sky130_fd_sc_hd__tapvpwrvgnd_1
* cell instance sky130_fd_sc_hd__tapvpwrvgnd_1_641 r0 *1 0,0
Xsky130_fd_sc_hd__tapvpwrvgnd_1_641 VGND VPWR sky130_fd_sc_hd__tapvpwrvgnd_1
* cell instance sky130_fd_sc_hd__tapvpwrvgnd_1_642 r0 *1 0,0
Xsky130_fd_sc_hd__tapvpwrvgnd_1_642 VGND VPWR sky130_fd_sc_hd__tapvpwrvgnd_1
* cell instance sky130_fd_sc_hd__tapvpwrvgnd_1_643 r0 *1 0,0
Xsky130_fd_sc_hd__tapvpwrvgnd_1_643 VGND VPWR sky130_fd_sc_hd__tapvpwrvgnd_1
* cell instance sky130_fd_sc_hd__tapvpwrvgnd_1_644 r0 *1 0,0
Xsky130_fd_sc_hd__tapvpwrvgnd_1_644 VGND VPWR sky130_fd_sc_hd__tapvpwrvgnd_1
* cell instance sky130_fd_sc_hd__tapvpwrvgnd_1_645 r0 *1 0,0
Xsky130_fd_sc_hd__tapvpwrvgnd_1_645 VGND VPWR sky130_fd_sc_hd__tapvpwrvgnd_1
* cell instance sky130_fd_sc_hd__tapvpwrvgnd_1_646 r0 *1 0,0
Xsky130_fd_sc_hd__tapvpwrvgnd_1_646 VGND VPWR sky130_fd_sc_hd__tapvpwrvgnd_1
* cell instance sky130_fd_sc_hd__tapvpwrvgnd_1_647 r0 *1 0,0
Xsky130_fd_sc_hd__tapvpwrvgnd_1_647 VGND VPWR sky130_fd_sc_hd__tapvpwrvgnd_1
* cell instance sky130_fd_sc_hd__tapvpwrvgnd_1_648 r0 *1 0,0
Xsky130_fd_sc_hd__tapvpwrvgnd_1_648 VGND VPWR sky130_fd_sc_hd__tapvpwrvgnd_1
* cell instance sky130_fd_sc_hd__tapvpwrvgnd_1_649 r0 *1 0,0
Xsky130_fd_sc_hd__tapvpwrvgnd_1_649 VGND VPWR sky130_fd_sc_hd__tapvpwrvgnd_1
* cell instance sky130_fd_sc_hd__tapvpwrvgnd_1_650 r0 *1 0,0
Xsky130_fd_sc_hd__tapvpwrvgnd_1_650 VGND VPWR sky130_fd_sc_hd__tapvpwrvgnd_1
* cell instance sky130_fd_sc_hd__tapvpwrvgnd_1_651 r0 *1 0,0
Xsky130_fd_sc_hd__tapvpwrvgnd_1_651 VGND VPWR sky130_fd_sc_hd__tapvpwrvgnd_1
* cell instance sky130_fd_sc_hd__tapvpwrvgnd_1_652 r0 *1 0,0
Xsky130_fd_sc_hd__tapvpwrvgnd_1_652 VGND VPWR sky130_fd_sc_hd__tapvpwrvgnd_1
* cell instance sky130_fd_sc_hd__tapvpwrvgnd_1_653 r0 *1 0,0
Xsky130_fd_sc_hd__tapvpwrvgnd_1_653 VGND VPWR sky130_fd_sc_hd__tapvpwrvgnd_1
* cell instance sky130_fd_sc_hd__tapvpwrvgnd_1_654 r0 *1 0,0
Xsky130_fd_sc_hd__tapvpwrvgnd_1_654 VGND VPWR sky130_fd_sc_hd__tapvpwrvgnd_1
* cell instance sky130_fd_sc_hd__tapvpwrvgnd_1_655 r0 *1 0,0
Xsky130_fd_sc_hd__tapvpwrvgnd_1_655 VGND VPWR sky130_fd_sc_hd__tapvpwrvgnd_1
* cell instance sky130_fd_sc_hd__tapvpwrvgnd_1_656 r0 *1 0,0
Xsky130_fd_sc_hd__tapvpwrvgnd_1_656 VGND VPWR sky130_fd_sc_hd__tapvpwrvgnd_1
* cell instance sky130_fd_sc_hd__tapvpwrvgnd_1_657 r0 *1 0,0
Xsky130_fd_sc_hd__tapvpwrvgnd_1_657 VGND VPWR sky130_fd_sc_hd__tapvpwrvgnd_1
* cell instance sky130_fd_sc_hd__tapvpwrvgnd_1_658 r0 *1 0,0
Xsky130_fd_sc_hd__tapvpwrvgnd_1_658 VGND VPWR sky130_fd_sc_hd__tapvpwrvgnd_1
* cell instance sky130_fd_sc_hd__tapvpwrvgnd_1_659 r0 *1 0,0
Xsky130_fd_sc_hd__tapvpwrvgnd_1_659 VGND VPWR sky130_fd_sc_hd__tapvpwrvgnd_1
* cell instance sky130_fd_sc_hd__tapvpwrvgnd_1_660 r0 *1 0,0
Xsky130_fd_sc_hd__tapvpwrvgnd_1_660 VGND VPWR sky130_fd_sc_hd__tapvpwrvgnd_1
* cell instance sky130_fd_sc_hd__tapvpwrvgnd_1_661 r0 *1 0,0
Xsky130_fd_sc_hd__tapvpwrvgnd_1_661 VGND VPWR sky130_fd_sc_hd__tapvpwrvgnd_1
* cell instance sky130_fd_sc_hd__tapvpwrvgnd_1_662 r0 *1 0,0
Xsky130_fd_sc_hd__tapvpwrvgnd_1_662 VGND VPWR sky130_fd_sc_hd__tapvpwrvgnd_1
* cell instance sky130_fd_sc_hd__tapvpwrvgnd_1_663 r0 *1 0,0
Xsky130_fd_sc_hd__tapvpwrvgnd_1_663 VGND VPWR sky130_fd_sc_hd__tapvpwrvgnd_1
* cell instance sky130_fd_sc_hd__tapvpwrvgnd_1_664 r0 *1 0,0
Xsky130_fd_sc_hd__tapvpwrvgnd_1_664 VGND VPWR sky130_fd_sc_hd__tapvpwrvgnd_1
* cell instance sky130_fd_sc_hd__tapvpwrvgnd_1_665 r0 *1 0,0
Xsky130_fd_sc_hd__tapvpwrvgnd_1_665 VGND VPWR sky130_fd_sc_hd__tapvpwrvgnd_1
* cell instance sky130_fd_sc_hd__tapvpwrvgnd_1_666 r0 *1 0,0
Xsky130_fd_sc_hd__tapvpwrvgnd_1_666 VGND VPWR sky130_fd_sc_hd__tapvpwrvgnd_1
* cell instance sky130_fd_sc_hd__tapvpwrvgnd_1_667 r0 *1 0,0
Xsky130_fd_sc_hd__tapvpwrvgnd_1_667 VGND VPWR sky130_fd_sc_hd__tapvpwrvgnd_1
* cell instance sky130_fd_sc_hd__tapvpwrvgnd_1_668 r0 *1 0,0
Xsky130_fd_sc_hd__tapvpwrvgnd_1_668 VGND VPWR sky130_fd_sc_hd__tapvpwrvgnd_1
* cell instance sky130_fd_sc_hd__tapvpwrvgnd_1_669 r0 *1 0,0
Xsky130_fd_sc_hd__tapvpwrvgnd_1_669 VGND VPWR sky130_fd_sc_hd__tapvpwrvgnd_1
* cell instance sky130_fd_sc_hd__tapvpwrvgnd_1_670 r0 *1 0,0
Xsky130_fd_sc_hd__tapvpwrvgnd_1_670 VGND VPWR sky130_fd_sc_hd__tapvpwrvgnd_1
* cell instance sky130_fd_sc_hd__tapvpwrvgnd_1_671 r0 *1 0,0
Xsky130_fd_sc_hd__tapvpwrvgnd_1_671 VGND VPWR sky130_fd_sc_hd__tapvpwrvgnd_1
* cell instance sky130_fd_sc_hd__tapvpwrvgnd_1_672 r0 *1 0,0
Xsky130_fd_sc_hd__tapvpwrvgnd_1_672 VGND VPWR sky130_fd_sc_hd__tapvpwrvgnd_1
* cell instance sky130_fd_sc_hd__tapvpwrvgnd_1_673 r0 *1 0,0
Xsky130_fd_sc_hd__tapvpwrvgnd_1_673 VGND VPWR sky130_fd_sc_hd__tapvpwrvgnd_1
* cell instance sky130_fd_sc_hd__tapvpwrvgnd_1_674 r0 *1 0,0
Xsky130_fd_sc_hd__tapvpwrvgnd_1_674 VGND VPWR sky130_fd_sc_hd__tapvpwrvgnd_1
* cell instance sky130_fd_sc_hd__tapvpwrvgnd_1_675 r0 *1 0,0
Xsky130_fd_sc_hd__tapvpwrvgnd_1_675 VGND VPWR sky130_fd_sc_hd__tapvpwrvgnd_1
* cell instance sky130_fd_sc_hd__tapvpwrvgnd_1_676 r0 *1 0,0
Xsky130_fd_sc_hd__tapvpwrvgnd_1_676 VGND VPWR sky130_fd_sc_hd__tapvpwrvgnd_1
* cell instance sky130_fd_sc_hd__tapvpwrvgnd_1_677 r0 *1 0,0
Xsky130_fd_sc_hd__tapvpwrvgnd_1_677 VGND VPWR sky130_fd_sc_hd__tapvpwrvgnd_1
* cell instance sky130_fd_sc_hd__tapvpwrvgnd_1_678 r0 *1 0,0
Xsky130_fd_sc_hd__tapvpwrvgnd_1_678 VGND VPWR sky130_fd_sc_hd__tapvpwrvgnd_1
* cell instance sky130_fd_sc_hd__tapvpwrvgnd_1_679 r0 *1 0,0
Xsky130_fd_sc_hd__tapvpwrvgnd_1_679 VGND VPWR sky130_fd_sc_hd__tapvpwrvgnd_1
* cell instance sky130_fd_sc_hd__tapvpwrvgnd_1_680 r0 *1 0,0
Xsky130_fd_sc_hd__tapvpwrvgnd_1_680 VGND VPWR sky130_fd_sc_hd__tapvpwrvgnd_1
* cell instance sky130_fd_sc_hd__tapvpwrvgnd_1_681 r0 *1 0,0
Xsky130_fd_sc_hd__tapvpwrvgnd_1_681 VGND VPWR sky130_fd_sc_hd__tapvpwrvgnd_1
* cell instance sky130_fd_sc_hd__tapvpwrvgnd_1_682 r0 *1 0,0
Xsky130_fd_sc_hd__tapvpwrvgnd_1_682 VGND VPWR sky130_fd_sc_hd__tapvpwrvgnd_1
* cell instance sky130_fd_sc_hd__tapvpwrvgnd_1_683 r0 *1 0,0
Xsky130_fd_sc_hd__tapvpwrvgnd_1_683 VGND VPWR sky130_fd_sc_hd__tapvpwrvgnd_1
* cell instance sky130_fd_sc_hd__tapvpwrvgnd_1_684 r0 *1 0,0
Xsky130_fd_sc_hd__tapvpwrvgnd_1_684 VGND VPWR sky130_fd_sc_hd__tapvpwrvgnd_1
* cell instance sky130_fd_sc_hd__tapvpwrvgnd_1_685 r0 *1 0,0
Xsky130_fd_sc_hd__tapvpwrvgnd_1_685 VGND VPWR sky130_fd_sc_hd__tapvpwrvgnd_1
* cell instance sky130_fd_sc_hd__tapvpwrvgnd_1_686 r0 *1 0,0
Xsky130_fd_sc_hd__tapvpwrvgnd_1_686 VGND VPWR sky130_fd_sc_hd__tapvpwrvgnd_1
* cell instance sky130_fd_sc_hd__tapvpwrvgnd_1_687 r0 *1 0,0
Xsky130_fd_sc_hd__tapvpwrvgnd_1_687 VGND VPWR sky130_fd_sc_hd__tapvpwrvgnd_1
* cell instance sky130_fd_sc_hd__tapvpwrvgnd_1_688 r0 *1 0,0
Xsky130_fd_sc_hd__tapvpwrvgnd_1_688 VGND VPWR sky130_fd_sc_hd__tapvpwrvgnd_1
* cell instance sky130_fd_sc_hd__tapvpwrvgnd_1_689 r0 *1 0,0
Xsky130_fd_sc_hd__tapvpwrvgnd_1_689 VGND VPWR sky130_fd_sc_hd__tapvpwrvgnd_1
* cell instance sky130_fd_sc_hd__tapvpwrvgnd_1_690 r0 *1 0,0
Xsky130_fd_sc_hd__tapvpwrvgnd_1_690 VGND VPWR sky130_fd_sc_hd__tapvpwrvgnd_1
* cell instance sky130_fd_sc_hd__tapvpwrvgnd_1_691 r0 *1 0,0
Xsky130_fd_sc_hd__tapvpwrvgnd_1_691 VGND VPWR sky130_fd_sc_hd__tapvpwrvgnd_1
* cell instance sky130_fd_sc_hd__tapvpwrvgnd_1_692 r0 *1 0,0
Xsky130_fd_sc_hd__tapvpwrvgnd_1_692 VGND VPWR sky130_fd_sc_hd__tapvpwrvgnd_1
* cell instance sky130_fd_sc_hd__tapvpwrvgnd_1_693 r0 *1 0,0
Xsky130_fd_sc_hd__tapvpwrvgnd_1_693 VGND VPWR sky130_fd_sc_hd__tapvpwrvgnd_1
* cell instance sky130_fd_sc_hd__tapvpwrvgnd_1_694 r0 *1 0,0
Xsky130_fd_sc_hd__tapvpwrvgnd_1_694 VGND VPWR sky130_fd_sc_hd__tapvpwrvgnd_1
* cell instance sky130_fd_sc_hd__tapvpwrvgnd_1_695 r0 *1 0,0
Xsky130_fd_sc_hd__tapvpwrvgnd_1_695 VGND VPWR sky130_fd_sc_hd__tapvpwrvgnd_1
* cell instance sky130_fd_sc_hd__tapvpwrvgnd_1_696 r0 *1 0,0
Xsky130_fd_sc_hd__tapvpwrvgnd_1_696 VGND VPWR sky130_fd_sc_hd__tapvpwrvgnd_1
* cell instance sky130_fd_sc_hd__tapvpwrvgnd_1_697 r0 *1 0,0
Xsky130_fd_sc_hd__tapvpwrvgnd_1_697 VGND VPWR sky130_fd_sc_hd__tapvpwrvgnd_1
* cell instance sky130_fd_sc_hd__tapvpwrvgnd_1_698 r0 *1 0,0
Xsky130_fd_sc_hd__tapvpwrvgnd_1_698 VGND VPWR sky130_fd_sc_hd__tapvpwrvgnd_1
* cell instance sky130_fd_sc_hd__tapvpwrvgnd_1_699 r0 *1 0,0
Xsky130_fd_sc_hd__tapvpwrvgnd_1_699 VGND VPWR sky130_fd_sc_hd__tapvpwrvgnd_1
* cell instance sky130_fd_sc_hd__tapvpwrvgnd_1_700 r0 *1 0,0
Xsky130_fd_sc_hd__tapvpwrvgnd_1_700 VGND VPWR sky130_fd_sc_hd__tapvpwrvgnd_1
* cell instance sky130_fd_sc_hd__tapvpwrvgnd_1_701 r0 *1 0,0
Xsky130_fd_sc_hd__tapvpwrvgnd_1_701 VGND VPWR sky130_fd_sc_hd__tapvpwrvgnd_1
* cell instance sky130_fd_sc_hd__tapvpwrvgnd_1_702 r0 *1 0,0
Xsky130_fd_sc_hd__tapvpwrvgnd_1_702 VGND VPWR sky130_fd_sc_hd__tapvpwrvgnd_1
* cell instance sky130_fd_sc_hd__tapvpwrvgnd_1_703 r0 *1 0,0
Xsky130_fd_sc_hd__tapvpwrvgnd_1_703 VGND VPWR sky130_fd_sc_hd__tapvpwrvgnd_1
* cell instance sky130_fd_sc_hd__xnor2_1_0 r0 *1 0,0
Xsky130_fd_sc_hd__xnor2_1_0 net43 crc_state[31] VGND VPWR VPWR \_0286_
+ sky130_fd_sc_hd__xnor2_1
* cell instance sky130_fd_sc_hd__xnor2_1_1 r0 *1 0,0
Xsky130_fd_sc_hd__xnor2_1_1 crc_state[25] net39 VGND VPWR VPWR \_0233_
+ sky130_fd_sc_hd__xnor2_1
* cell instance sky130_fd_sc_hd__xnor2_1_2 r0 *1 0,0
Xsky130_fd_sc_hd__xnor2_1_2 crc_state[4] net39 VGND VPWR VPWR \_0273_
+ sky130_fd_sc_hd__xnor2_1
* cell instance sky130_fd_sc_hd__xnor2_1_3 r0 *1 0,0
Xsky130_fd_sc_hd__xnor2_1_3 \_0754_ \_0761_ VGND VPWR VPWR \_0762_
+ sky130_fd_sc_hd__xnor2_1
* cell instance sky130_fd_sc_hd__xnor2_1_4 r0 *1 0,0
Xsky130_fd_sc_hd__xnor2_1_4 crc_state[6] net39 VGND VPWR VPWR \_0269_
+ sky130_fd_sc_hd__xnor2_1
* cell instance sky130_fd_sc_hd__xnor2_1_5 r0 *1 0,0
Xsky130_fd_sc_hd__xnor2_1_5 crc_state[7] net39 VGND VPWR VPWR \_0266_
+ sky130_fd_sc_hd__xnor2_1
* cell instance sky130_fd_sc_hd__xnor2_1_6 r0 *1 0,0
Xsky130_fd_sc_hd__xnor2_1_6 crc_state[11] net39 VGND VPWR VPWR \_0256_
+ sky130_fd_sc_hd__xnor2_1
* cell instance sky130_fd_sc_hd__xnor2_1_7 r0 *1 0,0
Xsky130_fd_sc_hd__xnor2_1_7 crc_state[9] net39 VGND VPWR VPWR \_0262_
+ sky130_fd_sc_hd__xnor2_1
* cell instance sky130_fd_sc_hd__xnor2_1_8 r0 *1 0,0
Xsky130_fd_sc_hd__xnor2_1_8 crc_state[10] net39 VGND VPWR VPWR \_0259_
+ sky130_fd_sc_hd__xnor2_1
* cell instance sky130_fd_sc_hd__xnor2_1_9 r0 *1 0,0
Xsky130_fd_sc_hd__xnor2_1_9 crc_state[15] net39 VGND VPWR VPWR \_0250_
+ sky130_fd_sc_hd__xnor2_1
* cell instance sky130_fd_sc_hd__xnor2_1_10 r0 *1 0,0
Xsky130_fd_sc_hd__xnor2_1_10 raw_count[3] \_1411_ VGND VPWR VPWR \_1424_
+ sky130_fd_sc_hd__xnor2_1
* cell instance sky130_fd_sc_hd__xnor2_1_11 r0 *1 0,0
Xsky130_fd_sc_hd__xnor2_1_11 raw_count[4] \_1416_ VGND VPWR VPWR \_1417_
+ sky130_fd_sc_hd__xnor2_1
* cell instance sky130_fd_sc_hd__xnor2_1_12 r0 *1 0,0
Xsky130_fd_sc_hd__xnor2_1_12 crc_state[3] net39 VGND VPWR VPWR \_0276_
+ sky130_fd_sc_hd__xnor2_1
* cell instance sky130_fd_sc_hd__xnor2_1_13 r0 *1 0,0
Xsky130_fd_sc_hd__xnor2_1_13 crc_state[21] net39 VGND VPWR VPWR \_0242_
+ sky130_fd_sc_hd__xnor2_1
* cell instance sky130_fd_sc_hd__xnor2_1_14 r0 *1 0,0
Xsky130_fd_sc_hd__xnor2_1_14 crc_state[1] net39 VGND VPWR VPWR \_0280_
+ sky130_fd_sc_hd__xnor2_1
* cell instance sky130_fd_sc_hd__xnor2_1_15 r0 *1 0,0
Xsky130_fd_sc_hd__xnor2_1_15 crc_state[0] net39 VGND VPWR VPWR \_0283_
+ sky130_fd_sc_hd__xnor2_1
* cell instance sky130_fd_sc_hd__xnor2_1_16 r0 *1 0,0
Xsky130_fd_sc_hd__xnor2_1_16 crc_state[22] net39 VGND VPWR VPWR \_0239_
+ sky130_fd_sc_hd__xnor2_1
* cell instance sky130_fd_sc_hd__xnor2_1_17 r0 *1 0,0
Xsky130_fd_sc_hd__xnor2_1_17 cond_count[10] \_0631_ VGND VPWR VPWR \_0632_
+ sky130_fd_sc_hd__xnor2_1
* cell instance sky130_fd_sc_hd__xnor2_1_18 r0 *1 0,0
Xsky130_fd_sc_hd__xnor2_1_18 \_0202_ \_0638_ VGND VPWR VPWR \_0639_
+ sky130_fd_sc_hd__xnor2_1
* cell instance sky130_fd_sc_hd__xnor2_1_19 r0 *1 0,0
Xsky130_fd_sc_hd__xnor2_1_19 cond_count[12] \_0207_ VGND VPWR VPWR \_0530_
+ sky130_fd_sc_hd__xnor2_1
* cell instance sky130_fd_sc_hd__xnor2_1_20 r0 *1 0,0
Xsky130_fd_sc_hd__xnor2_1_20 startup_count[7] \_0511_ VGND VPWR VPWR \_0518_
+ sky130_fd_sc_hd__xnor2_1
* cell instance sky130_fd_sc_hd__xnor2_1_21 r0 *1 0,0
Xsky130_fd_sc_hd__xnor2_1_21 startup_count[5] \_0510_ VGND VPWR VPWR \_0520_
+ sky130_fd_sc_hd__xnor2_1
* cell instance sky130_fd_sc_hd__xnor2_1_22 r0 *1 0,0
Xsky130_fd_sc_hd__xnor2_1_22 startup_count[12] \_0491_ VGND VPWR VPWR \_0497_
+ sky130_fd_sc_hd__xnor2_1
* cell instance sky130_fd_sc_hd__xnor2_1_23 r0 *1 0,0
Xsky130_fd_sc_hd__xnor2_1_23 \_0737_ \_0738_ VGND VPWR VPWR \_0739_
+ sky130_fd_sc_hd__xnor2_1
* cell instance sky130_fd_sc_hd__xnor2_1_24 r0 *1 0,0
Xsky130_fd_sc_hd__xnor2_1_24 startup_count[8] \_0515_ VGND VPWR VPWR \_0516_
+ sky130_fd_sc_hd__xnor2_1
* cell instance sky130_fd_sc_hd__xnor2_1_25 r0 *1 0,0
Xsky130_fd_sc_hd__xnor2_1_25 apt_matches[14] \_0337_ VGND VPWR VPWR \_0338_
+ sky130_fd_sc_hd__xnor2_1
* cell instance sky130_fd_sc_hd__xnor2_1_26 r0 *1 0,0
Xsky130_fd_sc_hd__xnor2_1_26 apt_matches[12] \_0334_ VGND VPWR VPWR \_0340_
+ sky130_fd_sc_hd__xnor2_1
* cell instance sky130_fd_sc_hd__xnor2_1_27 r0 *1 0,0
Xsky130_fd_sc_hd__xnor2_1_27 startup_count[11] \_0484_ VGND VPWR VPWR \_0501_
+ sky130_fd_sc_hd__xnor2_1
* cell instance sky130_fd_sc_hd__xnor2_1_28 r0 *1 0,0
Xsky130_fd_sc_hd__xnor2_1_28 \_0477_ \_0485_ VGND VPWR VPWR \_0486_
+ sky130_fd_sc_hd__xnor2_1
* cell instance sky130_fd_sc_hd__xnor2_1_29 r0 *1 0,0
Xsky130_fd_sc_hd__xnor2_1_29 apt_index[14] \_0375_ VGND VPWR VPWR \_0376_
+ sky130_fd_sc_hd__xnor2_1
* cell instance sky130_fd_sc_hd__xnor2_1_30 r0 *1 0,0
Xsky130_fd_sc_hd__xnor2_1_30 \_0368_ \_0373_ VGND VPWR VPWR \_0374_
+ sky130_fd_sc_hd__xnor2_1
* cell instance sky130_fd_sc_hd__xnor2_1_31 r0 *1 0,0
Xsky130_fd_sc_hd__xnor2_1_31 startup_count[1] \_0522_ VGND VPWR VPWR \_0526_
+ sky130_fd_sc_hd__xnor2_1
* cell instance sky130_fd_sc_hd__xnor2_1_32 r0 *1 0,0
Xsky130_fd_sc_hd__xnor2_1_32 net43 apt_ref VGND VPWR VPWR \_0328_
+ sky130_fd_sc_hd__xnor2_1
* cell instance sky130_fd_sc_hd__xnor2_1_33 r0 *1 0,0
Xsky130_fd_sc_hd__xnor2_1_33 net43 rct_ref VGND VPWR VPWR \_0308_
+ sky130_fd_sc_hd__xnor2_1
* cell instance sky130_fd_sc_hd__xnor2_1_34 r0 *1 0,0
Xsky130_fd_sc_hd__xnor2_1_34 apt_matches[1] \_0469_ VGND VPWR VPWR \_0470_
+ sky130_fd_sc_hd__xnor2_1
* cell instance sky130_fd_sc_hd__xnor2_1_35 r0 *1 0,0
Xsky130_fd_sc_hd__xnor2_1_35 apt_index[10] \_0372_ VGND VPWR VPWR \_0417_
+ sky130_fd_sc_hd__xnor2_1
* cell instance sky130_fd_sc_hd__xnor2_1_36 r0 *1 0,0
Xsky130_fd_sc_hd__xnor2_1_36 apt_matches[6] \_0330_ VGND VPWR VPWR \_0345_
+ sky130_fd_sc_hd__xnor2_1
* cell instance sky130_fd_sc_hd__xnor2_1_37 r0 *1 0,0
Xsky130_fd_sc_hd__xnor2_1_37 rct_count[5] \_0305_ VGND VPWR VPWR \_0322_
+ sky130_fd_sc_hd__xnor2_1
* cell instance sky130_fd_sc_hd__xnor2_1_38 r0 *1 0,0
Xsky130_fd_sc_hd__xnor2_1_38 apt_index[7] \_0423_ VGND VPWR VPWR \_0427_
+ sky130_fd_sc_hd__xnor2_1
* cell instance sky130_fd_sc_hd__xnor2_1_39 r0 *1 0,0
Xsky130_fd_sc_hd__xnor2_1_39 apt_index[4] \_0421_ VGND VPWR VPWR \_0430_
+ sky130_fd_sc_hd__xnor2_1
* cell instance sky130_fd_sc_hd__xor2_1_0 r0 *1 0,0
Xsky130_fd_sc_hd__xor2_1_0 net43 crc_state[31] VGND VPWR VPWR \_0232_
+ sky130_fd_sc_hd__xor2_1
* cell instance sky130_fd_sc_hd__xor2_1_1 r0 *1 0,0
Xsky130_fd_sc_hd__xor2_1_1 net41 bus_wdata[1] VGND VPWR VPWR \_0542_
+ sky130_fd_sc_hd__xor2_1
* cell instance sky130_fd_sc_hd__xor2_1_2 r0 *1 0,0
Xsky130_fd_sc_hd__xor2_1_2 \_0749_ \_0759_ VGND VPWR VPWR \_1294_
+ sky130_fd_sc_hd__xor2_1
* cell instance sky130_fd_sc_hd__xor2_1_3 r0 *1 0,0
Xsky130_fd_sc_hd__xor2_1_3 raw_level[1] \_0750_ VGND VPWR VPWR \_0751_
+ sky130_fd_sc_hd__xor2_1
* cell instance sky130_fd_sc_hd__xor2_1_4 r0 *1 0,0
Xsky130_fd_sc_hd__xor2_1_4 \_0774_ \_0788_ VGND VPWR VPWR \_0789_
+ sky130_fd_sc_hd__xor2_1
* cell instance sky130_fd_sc_hd__xor2_1_5 r0 *1 0,0
Xsky130_fd_sc_hd__xor2_1_5 raw_level[2] \_1402_ VGND VPWR VPWR \_0748_
+ sky130_fd_sc_hd__xor2_1
* cell instance sky130_fd_sc_hd__xor2_1_6 r0 *1 0,0
Xsky130_fd_sc_hd__xor2_1_6 raw_count[4] \_1416_ VGND VPWR VPWR \_0098_
+ sky130_fd_sc_hd__xor2_1
* cell instance sky130_fd_sc_hd__xor2_1_7 r0 *1 0,0
Xsky130_fd_sc_hd__xor2_1_7 cond_level[2] \_0222_ VGND VPWR VPWR \_0780_
+ sky130_fd_sc_hd__xor2_1
* cell instance sky130_fd_sc_hd__xor2_1_8 r0 *1 0,0
Xsky130_fd_sc_hd__xor2_1_8 cond_level[1] \_0770_ VGND VPWR VPWR \_0771_
+ sky130_fd_sc_hd__xor2_1
* cell instance sky130_fd_sc_hd__xor2_1_9 r0 *1 0,0
Xsky130_fd_sc_hd__xor2_1_9 cond_count[6] \_0642_ VGND VPWR VPWR \_0643_
+ sky130_fd_sc_hd__xor2_1
* cell instance sky130_fd_sc_hd__xor2_1_10 r0 *1 0,0
Xsky130_fd_sc_hd__xor2_1_10 cond_count[14] \_0212_ VGND VPWR VPWR \_0213_
+ sky130_fd_sc_hd__xor2_1
* cell instance sky130_fd_sc_hd__xor2_1_11 r0 *1 0,0
Xsky130_fd_sc_hd__xor2_1_11 cond_count[15] \_0210_ VGND VPWR VPWR \_0211_
+ sky130_fd_sc_hd__xor2_1
* cell instance sky130_fd_sc_hd__xor2_1_12 r0 *1 0,0
Xsky130_fd_sc_hd__xor2_1_12 startup_count[9] \_0512_ VGND VPWR VPWR \_0513_
+ sky130_fd_sc_hd__xor2_1
* cell instance sky130_fd_sc_hd__xor2_1_13 r0 *1 0,0
Xsky130_fd_sc_hd__xor2_1_13 apt_matches[15] \_0335_ VGND VPWR VPWR \_0336_
+ sky130_fd_sc_hd__xor2_1
* cell instance sky130_fd_sc_hd__xor2_1_14 r0 *1 0,0
Xsky130_fd_sc_hd__xor2_1_14 apt_index[15] \_0377_ VGND VPWR VPWR \_0378_
+ sky130_fd_sc_hd__xor2_1
* cell instance sky130_fd_sc_hd__xor2_1_15 r0 *1 0,0
Xsky130_fd_sc_hd__xor2_1_15 apt_index[12] \_0411_ VGND VPWR VPWR \_0412_
+ sky130_fd_sc_hd__xor2_1
* cell instance sky130_fd_sc_hd__xor2_1_16 r0 *1 0,0
Xsky130_fd_sc_hd__xor2_1_16 rct_count[1] rct_count[0] VGND VPWR VPWR \_0398_
+ sky130_fd_sc_hd__xor2_1
* cell instance sky130_fd_sc_hd__xor2_1_17 r0 *1 0,0
Xsky130_fd_sc_hd__xor2_1_17 apt_matches[4] \_0346_ VGND VPWR VPWR \_0462_
+ sky130_fd_sc_hd__xor2_1
* cell instance sky130_fd_sc_hd__xor2_1_18 r0 *1 0,0
Xsky130_fd_sc_hd__xor2_1_18 apt_index[1] \_0420_ VGND VPWR VPWR \_0436_
+ sky130_fd_sc_hd__xor2_1
.ENDS trng_digital

* cell sky130_fd_sc_hd__xor2_1
* pin A
* pin B
* pin VGND
* pin VPB
* pin VPWR
* pin X
.SUBCKT sky130_fd_sc_hd__xor2_1 A B VGND VPB VPWR X
.ENDS sky130_fd_sc_hd__xor2_1

* cell sky130_fd_sc_hd__xnor2_1
* pin A
* pin B
* pin VGND
* pin VPB
* pin VPWR
* pin Y
.SUBCKT sky130_fd_sc_hd__xnor2_1 A B VGND VPB VPWR Y
.ENDS sky130_fd_sc_hd__xnor2_1

* cell sky130_fd_sc_hd__tapvpwrvgnd_1
* pin VGND
* pin VPWR
.SUBCKT sky130_fd_sc_hd__tapvpwrvgnd_1 VGND VPWR
.ENDS sky130_fd_sc_hd__tapvpwrvgnd_1

* cell sky130_fd_sc_hd__or4b_2
* pin A
* pin B
* pin C
* pin D_N
* pin VGND
* pin VPB
* pin VPWR
* pin X
.SUBCKT sky130_fd_sc_hd__or4b_2 A B C D_N VGND VPB VPWR X
.ENDS sky130_fd_sc_hd__or4b_2

* cell sky130_fd_sc_hd__or4_1
* pin A
* pin B
* pin C
* pin D
* pin VGND
* pin VPB
* pin VPWR
* pin X
.SUBCKT sky130_fd_sc_hd__or4_1 A B C D VGND VPB VPWR X
.ENDS sky130_fd_sc_hd__or4_1

* cell sky130_fd_sc_hd__or3b_2
* pin A
* pin B
* pin C_N
* pin VGND
* pin VPB
* pin VPWR
* pin X
.SUBCKT sky130_fd_sc_hd__or3b_2 A B C_N VGND VPB VPWR X
.ENDS sky130_fd_sc_hd__or3b_2

* cell sky130_fd_sc_hd__or3_1
* pin A
* pin B
* pin C
* pin VGND
* pin VPB
* pin VPWR
* pin X
.SUBCKT sky130_fd_sc_hd__or3_1 A B C VGND VPB VPWR X
.ENDS sky130_fd_sc_hd__or3_1

* cell sky130_fd_sc_hd__or2_2
* pin A
* pin B
* pin VGND
* pin VPB
* pin VPWR
* pin X
.SUBCKT sky130_fd_sc_hd__or2_2 A B VGND VPB VPWR X
.ENDS sky130_fd_sc_hd__or2_2

* cell sky130_fd_sc_hd__o41ai_1
* pin A1
* pin A2
* pin A3
* pin A4
* pin B1
* pin VGND
* pin VPB
* pin VPWR
* pin Y
.SUBCKT sky130_fd_sc_hd__o41ai_1 A1 A2 A3 A4 B1 VGND VPB VPWR Y
.ENDS sky130_fd_sc_hd__o41ai_1

* cell sky130_fd_sc_hd__o41a_1
* pin A1
* pin A2
* pin A3
* pin A4
* pin B1
* pin VGND
* pin VPB
* pin VPWR
* pin X
.SUBCKT sky130_fd_sc_hd__o41a_1 A1 A2 A3 A4 B1 VGND VPB VPWR X
.ENDS sky130_fd_sc_hd__o41a_1

* cell sky130_fd_sc_hd__o31ai_1
* pin A1
* pin A2
* pin A3
* pin B1
* pin VGND
* pin VPB
* pin VPWR
* pin Y
.SUBCKT sky130_fd_sc_hd__o31ai_1 A1 A2 A3 B1 VGND VPB VPWR Y
.ENDS sky130_fd_sc_hd__o31ai_1

* cell sky130_fd_sc_hd__o31a_1
* pin A1
* pin A2
* pin A3
* pin B1
* pin VGND
* pin VPB
* pin VPWR
* pin X
.SUBCKT sky130_fd_sc_hd__o31a_1 A1 A2 A3 B1 VGND VPB VPWR X
.ENDS sky130_fd_sc_hd__o31a_1

* cell sky130_fd_sc_hd__o22ai_1
* pin A1
* pin A2
* pin B1
* pin B2
* pin VGND
* pin VPB
* pin VPWR
* pin Y
.SUBCKT sky130_fd_sc_hd__o22ai_1 A1 A2 B1 B2 VGND VPB VPWR Y
.ENDS sky130_fd_sc_hd__o22ai_1

* cell sky130_fd_sc_hd__o221ai_1
* pin A1
* pin A2
* pin B1
* pin B2
* pin C1
* pin VGND
* pin VPB
* pin VPWR
* pin Y
.SUBCKT sky130_fd_sc_hd__o221ai_1 A1 A2 B1 B2 C1 VGND VPB VPWR Y
.ENDS sky130_fd_sc_hd__o221ai_1

* cell sky130_fd_sc_hd__o21bai_1
* pin A1
* pin A2
* pin B1_N
* pin VGND
* pin VPB
* pin VPWR
* pin Y
.SUBCKT sky130_fd_sc_hd__o21bai_1 A1 A2 B1_N VGND VPB VPWR Y
.ENDS sky130_fd_sc_hd__o21bai_1

* cell sky130_fd_sc_hd__o21ba_2
* pin A1
* pin A2
* pin B1_N
* pin VGND
* pin VPB
* pin VPWR
* pin X
.SUBCKT sky130_fd_sc_hd__o21ba_2 A1 A2 B1_N VGND VPB VPWR X
.ENDS sky130_fd_sc_hd__o21ba_2

* cell sky130_fd_sc_hd__o21ai_0
* pin A1
* pin A2
* pin B1
* pin VGND
* pin VPB
* pin VPWR
* pin Y
.SUBCKT sky130_fd_sc_hd__o21ai_0 A1 A2 B1 VGND VPB VPWR Y
.ENDS sky130_fd_sc_hd__o21ai_0

* cell sky130_fd_sc_hd__o21a_1
* pin A1
* pin A2
* pin B1
* pin VGND
* pin VPB
* pin VPWR
* pin X
.SUBCKT sky130_fd_sc_hd__o21a_1 A1 A2 B1 VGND VPB VPWR X
.ENDS sky130_fd_sc_hd__o21a_1

* cell sky130_fd_sc_hd__o211ai_1
* pin A1
* pin A2
* pin B1
* pin C1
* pin VGND
* pin VPB
* pin VPWR
* pin Y
.SUBCKT sky130_fd_sc_hd__o211ai_1 A1 A2 B1 C1 VGND VPB VPWR Y
.ENDS sky130_fd_sc_hd__o211ai_1

* cell sky130_fd_sc_hd__o211a_1
* pin A1
* pin A2
* pin B1
* pin C1
* pin VGND
* pin VPB
* pin VPWR
* pin X
.SUBCKT sky130_fd_sc_hd__o211a_1 A1 A2 B1 C1 VGND VPB VPWR X
.ENDS sky130_fd_sc_hd__o211a_1

* cell sky130_fd_sc_hd__nor4b_1
* pin A
* pin B
* pin C
* pin D_N
* pin VGND
* pin VPB
* pin VPWR
* pin Y
.SUBCKT sky130_fd_sc_hd__nor4b_1 A B C D_N VGND VPB VPWR Y
.ENDS sky130_fd_sc_hd__nor4b_1

* cell sky130_fd_sc_hd__nor4_1
* pin A
* pin B
* pin C
* pin D
* pin VGND
* pin VPB
* pin VPWR
* pin Y
.SUBCKT sky130_fd_sc_hd__nor4_1 A B C D VGND VPB VPWR Y
.ENDS sky130_fd_sc_hd__nor4_1

* cell sky130_fd_sc_hd__nor3b_1
* pin A
* pin B
* pin C_N
* pin VGND
* pin VPB
* pin VPWR
* pin Y
.SUBCKT sky130_fd_sc_hd__nor3b_1 A B C_N VGND VPB VPWR Y
.ENDS sky130_fd_sc_hd__nor3b_1

* cell sky130_fd_sc_hd__nor3_1
* pin A
* pin B
* pin C
* pin VGND
* pin VPB
* pin VPWR
* pin Y
.SUBCKT sky130_fd_sc_hd__nor3_1 A B C VGND VPB VPWR Y
.ENDS sky130_fd_sc_hd__nor3_1

* cell sky130_fd_sc_hd__nor2b_1
* pin A
* pin B_N
* pin VGND
* pin VPB
* pin VPWR
* pin Y
.SUBCKT sky130_fd_sc_hd__nor2b_1 A B_N VGND VPB VPWR Y
.ENDS sky130_fd_sc_hd__nor2b_1

* cell sky130_fd_sc_hd__nor2_1
* pin A
* pin B
* pin VGND
* pin VPB
* pin VPWR
* pin Y
.SUBCKT sky130_fd_sc_hd__nor2_1 A B VGND VPB VPWR Y
.ENDS sky130_fd_sc_hd__nor2_1

* cell sky130_fd_sc_hd__nand4b_1
* pin A_N
* pin B
* pin C
* pin D
* pin VGND
* pin VPB
* pin VPWR
* pin Y
.SUBCKT sky130_fd_sc_hd__nand4b_1 A_N B C D VGND VPB VPWR Y
.ENDS sky130_fd_sc_hd__nand4b_1

* cell sky130_fd_sc_hd__nand4_1
* pin A
* pin B
* pin C
* pin D
* pin VGND
* pin VPB
* pin VPWR
* pin Y
.SUBCKT sky130_fd_sc_hd__nand4_1 A B C D VGND VPB VPWR Y
.ENDS sky130_fd_sc_hd__nand4_1

* cell sky130_fd_sc_hd__nand3b_1
* pin A_N
* pin B
* pin C
* pin VGND
* pin VPB
* pin VPWR
* pin Y
.SUBCKT sky130_fd_sc_hd__nand3b_1 A_N B C VGND VPB VPWR Y
.ENDS sky130_fd_sc_hd__nand3b_1

* cell sky130_fd_sc_hd__nand3_1
* pin A
* pin B
* pin C
* pin VGND
* pin VPB
* pin VPWR
* pin Y
.SUBCKT sky130_fd_sc_hd__nand3_1 A B C VGND VPB VPWR Y
.ENDS sky130_fd_sc_hd__nand3_1

* cell sky130_fd_sc_hd__nand2b_1
* pin A_N
* pin B
* pin VGND
* pin VPB
* pin VPWR
* pin Y
.SUBCKT sky130_fd_sc_hd__nand2b_1 A_N B VGND VPB VPWR Y
.ENDS sky130_fd_sc_hd__nand2b_1

* cell sky130_fd_sc_hd__nand2_1
* pin A
* pin B
* pin VGND
* pin VPB
* pin VPWR
* pin Y
.SUBCKT sky130_fd_sc_hd__nand2_1 A B VGND VPB VPWR Y
.ENDS sky130_fd_sc_hd__nand2_1

* cell sky130_fd_sc_hd__mux2i_1
* pin A0
* pin A1
* pin S
* pin VGND
* pin VPB
* pin VPWR
* pin Y
.SUBCKT sky130_fd_sc_hd__mux2i_1 A0 A1 S VGND VPB VPWR Y
.ENDS sky130_fd_sc_hd__mux2i_1

* cell sky130_fd_sc_hd__mux2_2
* pin A0
* pin A1
* pin S
* pin VGND
* pin VPB
* pin VPWR
* pin X
.SUBCKT sky130_fd_sc_hd__mux2_2 A0 A1 S VGND VPB VPWR X
.ENDS sky130_fd_sc_hd__mux2_2

* cell sky130_fd_sc_hd__inv_4
* pin A
* pin VGND
* pin VPB
* pin VPWR
* pin Y
.SUBCKT sky130_fd_sc_hd__inv_4 A VGND VPB VPWR Y
.ENDS sky130_fd_sc_hd__inv_4

* cell sky130_fd_sc_hd__inv_1
* pin A
* pin VGND
* pin VPB
* pin VPWR
* pin Y
.SUBCKT sky130_fd_sc_hd__inv_1 A VGND VPB VPWR Y
.ENDS sky130_fd_sc_hd__inv_1

* cell sky130_fd_sc_hd__fill_8
* pin VGND
* pin VPB
* pin VPWR
.SUBCKT sky130_fd_sc_hd__fill_8 VGND VPB VPWR
.ENDS sky130_fd_sc_hd__fill_8

* cell sky130_fd_sc_hd__fill_4
* pin VGND
* pin VPB
* pin VPWR
.SUBCKT sky130_fd_sc_hd__fill_4 VGND VPB VPWR
.ENDS sky130_fd_sc_hd__fill_4

* cell sky130_fd_sc_hd__fill_2
* pin VGND
* pin VPB
* pin VPWR
.SUBCKT sky130_fd_sc_hd__fill_2 VGND VPB VPWR
.ENDS sky130_fd_sc_hd__fill_2

* cell sky130_fd_sc_hd__fill_1
* pin VGND
* pin VPB
* pin VPWR
.SUBCKT sky130_fd_sc_hd__fill_1 VGND VPB VPWR
.ENDS sky130_fd_sc_hd__fill_1

* cell sky130_fd_sc_hd__diode_2
* pin DIODE
* pin VGND
* pin VPB
* pin VPWR
.SUBCKT sky130_fd_sc_hd__diode_2 DIODE VGND VPB VPWR
.ENDS sky130_fd_sc_hd__diode_2

* cell sky130_fd_sc_hd__dfstp_1
* pin CLK
* pin D
* pin Q
* pin SET_B
* pin VGND
* pin VPB
* pin VPWR
.SUBCKT sky130_fd_sc_hd__dfstp_1 CLK D Q SET_B VGND VPB VPWR
.ENDS sky130_fd_sc_hd__dfstp_1

* cell sky130_fd_sc_hd__dfrtp_1
* pin CLK
* pin D
* pin Q
* pin RESET_B
* pin VGND
* pin VPB
* pin VPWR
.SUBCKT sky130_fd_sc_hd__dfrtp_1 CLK D Q RESET_B VGND VPB VPWR
.ENDS sky130_fd_sc_hd__dfrtp_1

* cell sky130_fd_sc_hd__clkinvlp_2
* pin A
* pin VGND
* pin VPB
* pin VPWR
* pin Y
.SUBCKT sky130_fd_sc_hd__clkinvlp_2 A VGND VPB VPWR Y
.ENDS sky130_fd_sc_hd__clkinvlp_2

* cell sky130_fd_sc_hd__clkinv_4
* pin A
* pin VGND
* pin VPB
* pin VPWR
* pin Y
.SUBCKT sky130_fd_sc_hd__clkinv_4 A VGND VPB VPWR Y
.ENDS sky130_fd_sc_hd__clkinv_4

* cell sky130_fd_sc_hd__clkinv_2
* pin A
* pin VGND
* pin VPB
* pin VPWR
* pin Y
.SUBCKT sky130_fd_sc_hd__clkinv_2 A VGND VPB VPWR Y
.ENDS sky130_fd_sc_hd__clkinv_2

* cell sky130_fd_sc_hd__clkinv_1
* pin A
* pin VGND
* pin VPB
* pin VPWR
* pin Y
.SUBCKT sky130_fd_sc_hd__clkinv_1 A VGND VPB VPWR Y
.ENDS sky130_fd_sc_hd__clkinv_1

* cell sky130_fd_sc_hd__clkbuf_1
* pin A
* pin VGND
* pin VPB
* pin VPWR
* pin X
.SUBCKT sky130_fd_sc_hd__clkbuf_1 A VGND VPB VPWR X
.ENDS sky130_fd_sc_hd__clkbuf_1

* cell sky130_fd_sc_hd__bufinv_16
* pin A
* pin VGND
* pin VPB
* pin VPWR
* pin Y
.SUBCKT sky130_fd_sc_hd__bufinv_16 A VGND VPB VPWR Y
.ENDS sky130_fd_sc_hd__bufinv_16

* cell sky130_fd_sc_hd__buf_4
* pin A
* pin VGND
* pin VPB
* pin VPWR
* pin X
.SUBCKT sky130_fd_sc_hd__buf_4 A VGND VPB VPWR X
.ENDS sky130_fd_sc_hd__buf_4

* cell sky130_fd_sc_hd__and4b_1
* pin A_N
* pin B
* pin C
* pin D
* pin VGND
* pin VPB
* pin VPWR
* pin X
.SUBCKT sky130_fd_sc_hd__and4b_1 A_N B C D VGND VPB VPWR X
.ENDS sky130_fd_sc_hd__and4b_1

* cell sky130_fd_sc_hd__and4_1
* pin A
* pin B
* pin C
* pin D
* pin VGND
* pin VPB
* pin VPWR
* pin X
.SUBCKT sky130_fd_sc_hd__and4_1 A B C D VGND VPB VPWR X
.ENDS sky130_fd_sc_hd__and4_1

* cell sky130_fd_sc_hd__and3b_1
* pin A_N
* pin B
* pin C
* pin VGND
* pin VPB
* pin VPWR
* pin X
.SUBCKT sky130_fd_sc_hd__and3b_1 A_N B C VGND VPB VPWR X
.ENDS sky130_fd_sc_hd__and3b_1

* cell sky130_fd_sc_hd__and3_1
* pin A
* pin B
* pin C
* pin VGND
* pin VPB
* pin VPWR
* pin X
.SUBCKT sky130_fd_sc_hd__and3_1 A B C VGND VPB VPWR X
.ENDS sky130_fd_sc_hd__and3_1

* cell sky130_fd_sc_hd__and2_1
* pin A
* pin B
* pin VGND
* pin VPB
* pin VPWR
* pin X
.SUBCKT sky130_fd_sc_hd__and2_1 A B VGND VPB VPWR X
.ENDS sky130_fd_sc_hd__and2_1

* cell sky130_fd_sc_hd__a32oi_1
* pin A1
* pin A2
* pin A3
* pin B1
* pin B2
* pin VGND
* pin VPB
* pin VPWR
* pin Y
.SUBCKT sky130_fd_sc_hd__a32oi_1 A1 A2 A3 B1 B2 VGND VPB VPWR Y
.ENDS sky130_fd_sc_hd__a32oi_1

* cell sky130_fd_sc_hd__a32o_1
* pin A1
* pin A2
* pin A3
* pin B1
* pin B2
* pin VGND
* pin VPB
* pin VPWR
* pin X
.SUBCKT sky130_fd_sc_hd__a32o_1 A1 A2 A3 B1 B2 VGND VPB VPWR X
.ENDS sky130_fd_sc_hd__a32o_1

* cell sky130_fd_sc_hd__a31oi_1
* pin A1
* pin A2
* pin A3
* pin B1
* pin VGND
* pin VPB
* pin VPWR
* pin Y
.SUBCKT sky130_fd_sc_hd__a31oi_1 A1 A2 A3 B1 VGND VPB VPWR Y
.ENDS sky130_fd_sc_hd__a31oi_1

* cell sky130_fd_sc_hd__a31o_2
* pin A1
* pin A2
* pin A3
* pin B1
* pin VGND
* pin VPB
* pin VPWR
* pin X
.SUBCKT sky130_fd_sc_hd__a31o_2 A1 A2 A3 B1 VGND VPB VPWR X
.ENDS sky130_fd_sc_hd__a31o_2

* cell sky130_fd_sc_hd__a311oi_1
* pin A1
* pin A2
* pin A3
* pin B1
* pin C1
* pin VGND
* pin VPB
* pin VPWR
* pin Y
.SUBCKT sky130_fd_sc_hd__a311oi_1 A1 A2 A3 B1 C1 VGND VPB VPWR Y
.ENDS sky130_fd_sc_hd__a311oi_1

* cell sky130_fd_sc_hd__a311o_1
* pin A1
* pin A2
* pin A3
* pin B1
* pin C1
* pin VGND
* pin VPB
* pin VPWR
* pin X
.SUBCKT sky130_fd_sc_hd__a311o_1 A1 A2 A3 B1 C1 VGND VPB VPWR X
.ENDS sky130_fd_sc_hd__a311o_1

* cell sky130_fd_sc_hd__a22oi_1
* pin A1
* pin A2
* pin B1
* pin B2
* pin VGND
* pin VPB
* pin VPWR
* pin Y
.SUBCKT sky130_fd_sc_hd__a22oi_1 A1 A2 B1 B2 VGND VPB VPWR Y
.ENDS sky130_fd_sc_hd__a22oi_1

* cell sky130_fd_sc_hd__a22o_1
* pin A1
* pin A2
* pin B1
* pin B2
* pin VGND
* pin VPB
* pin VPWR
* pin X
.SUBCKT sky130_fd_sc_hd__a22o_1 A1 A2 B1 B2 VGND VPB VPWR X
.ENDS sky130_fd_sc_hd__a22o_1

* cell sky130_fd_sc_hd__a222oi_1
* pin A1
* pin A2
* pin B1
* pin B2
* pin C1
* pin C2
* pin VGND
* pin VPB
* pin VPWR
* pin Y
.SUBCKT sky130_fd_sc_hd__a222oi_1 A1 A2 B1 B2 C1 C2 VGND VPB VPWR Y
.ENDS sky130_fd_sc_hd__a222oi_1

* cell sky130_fd_sc_hd__a221oi_1
* pin A1
* pin A2
* pin B1
* pin B2
* pin C1
* pin VGND
* pin VPB
* pin VPWR
* pin Y
.SUBCKT sky130_fd_sc_hd__a221oi_1 A1 A2 B1 B2 C1 VGND VPB VPWR Y
.ENDS sky130_fd_sc_hd__a221oi_1

* cell sky130_fd_sc_hd__a221o_1
* pin A1
* pin A2
* pin B1
* pin B2
* pin C1
* pin VGND
* pin VPB
* pin VPWR
* pin X
.SUBCKT sky130_fd_sc_hd__a221o_1 A1 A2 B1 B2 C1 VGND VPB VPWR X
.ENDS sky130_fd_sc_hd__a221o_1

* cell sky130_fd_sc_hd__a21oi_1
* pin A1
* pin A2
* pin B1
* pin VGND
* pin VPB
* pin VPWR
* pin Y
.SUBCKT sky130_fd_sc_hd__a21oi_1 A1 A2 B1 VGND VPB VPWR Y
.ENDS sky130_fd_sc_hd__a21oi_1

* cell sky130_fd_sc_hd__a21o_1
* pin A1
* pin A2
* pin B1
* pin VGND
* pin VPB
* pin VPWR
* pin X
.SUBCKT sky130_fd_sc_hd__a21o_1 A1 A2 B1 VGND VPB VPWR X
.ENDS sky130_fd_sc_hd__a21o_1

* cell sky130_fd_sc_hd__a211oi_1
* pin A1
* pin A2
* pin B1
* pin C1
* pin VGND
* pin VPB
* pin VPWR
* pin Y
.SUBCKT sky130_fd_sc_hd__a211oi_1 A1 A2 B1 C1 VGND VPB VPWR Y
.ENDS sky130_fd_sc_hd__a211oi_1
