* Reference netlist for xor2 LVS -- GENERATED by layout/bin/compose-cell.py
* Source: design/ro_array_core.spice .subckt xor2
* Only unit spellings (and any substituted subckt parameter)
* differ from the source -- see compose-cell.py's docstring.
.subckt xor2 a b y vdd vss
*.ipin a
*.ipin b
*.opin y
*.iopin vdd
*.iopin vss
XMpiA an a vdd vdd sky130_fd_pr__pfet_01v8 L=0.15u W=0.84u nf=1 ad=0.2436 as=0.2436 pd=2.26 ps=2.26 nrd=0.345238095238095
+ nrs=0.345238095238095 sa=0 sb=0 sd=0 mult=1 m=1
XMniA an a vss vss sky130_fd_pr__nfet_01v8 L=0.15u W=0.42u nf=1 ad=0.1218 as=0.1218 pd=1.42 ps=1.42 nrd=0.69047619047619
+ nrs=0.69047619047619 sa=0 sb=0 sd=0 mult=1 m=1
XMpiB bn b vdd vdd sky130_fd_pr__pfet_01v8 L=0.15u W=0.84u nf=1 ad=0.2436 as=0.2436 pd=2.26 ps=2.26 nrd=0.345238095238095
+ nrs=0.345238095238095 sa=0 sb=0 sd=0 mult=1 m=1
XMniB bn b vss vss sky130_fd_pr__nfet_01v8 L=0.15u W=0.42u nf=1 ad=0.1218 as=0.1218 pd=1.42 ps=1.42 nrd=0.69047619047619
+ nrs=0.69047619047619 sa=0 sb=0 sd=0 mult=1 m=1
XMp1 mid a vdd vdd sky130_fd_pr__pfet_01v8 L=0.15u W=1.68u nf=1 ad=0.4872 as=0.4872 pd=3.94 ps=3.94 nrd=0.172619047619048
+ nrs=0.172619047619048 sa=0 sb=0 sd=0 mult=1 m=1
XMp2 mid b vdd vdd sky130_fd_pr__pfet_01v8 L=0.15u W=1.68u nf=1 ad=0.4872 as=0.4872 pd=3.94 ps=3.94 nrd=0.172619047619048
+ nrs=0.172619047619048 sa=0 sb=0 sd=0 mult=1 m=1
XMp3 y an mid vdd sky130_fd_pr__pfet_01v8 L=0.15u W=1.68u nf=1 ad=0.4872 as=0.4872 pd=3.94 ps=3.94 nrd=0.172619047619048
+ nrs=0.172619047619048 sa=0 sb=0 sd=0 mult=1 m=1
XMp4 y bn mid vdd sky130_fd_pr__pfet_01v8 L=0.15u W=1.68u nf=1 ad=0.4872 as=0.4872 pd=3.94 ps=3.94 nrd=0.172619047619048
+ nrs=0.172619047619048 sa=0 sb=0 sd=0 mult=1 m=1
XMn1 y a s1 vss sky130_fd_pr__nfet_01v8 L=0.15u W=0.84u nf=1 ad=0.2436 as=0.2436 pd=2.26 ps=2.26 nrd=0.345238095238095
+ nrs=0.345238095238095 sa=0 sb=0 sd=0 mult=1 m=1
XMn2 s1 b vss vss sky130_fd_pr__nfet_01v8 L=0.15u W=0.84u nf=1 ad=0.2436 as=0.2436 pd=2.26 ps=2.26 nrd=0.345238095238095
+ nrs=0.345238095238095 sa=0 sb=0 sd=0 mult=1 m=1
XMn3 y an s2 vss sky130_fd_pr__nfet_01v8 L=0.15u W=0.84u nf=1 ad=0.2436 as=0.2436 pd=2.26 ps=2.26 nrd=0.345238095238095
+ nrs=0.345238095238095 sa=0 sb=0 sd=0 mult=1 m=1
XMn4 s2 bn vss vss sky130_fd_pr__nfet_01v8 L=0.15u W=0.84u nf=1 ad=0.2436 as=0.2436 pd=2.26 ps=2.26 nrd=0.345238095238095
+ nrs=0.345238095238095 sa=0 sb=0 sd=0 mult=1 m=1
.ends
