* extracted by klt extract --deck sky130

* cell xor2
* pin a,b,invb_a,mn12_g1,mp24_g0
* pin a,inva_a,mn12_g0,mp13_g0
* pin an,inva_y,mn34_g0,mp13_g1,y
* pin bn,invb_y,mn34_g1,mp24_g1,y
* pin mid
* pin vdd
* pin vss
* pin y
.SUBCKT xor2 a|b|invb_a|mn12_g1|mp24_g0 a|inva_a|mn12_g0|mp13_g0
+ an|inva_y|mn34_g0|mp13_g1|y bn|invb_y|mn34_g1|mp24_g1|y mid vdd vss y
* device instance $1 r0 *1 0.895,3 nfet
M$1 \$3 an|inva_y|mn34_g0|mp13_g1|y y vss nfet L=0.15U W=0.84U AS=0.3948P
+ AD=0.2184P PS=2.62U PD=1.36U
* device instance $2 r0 *1 1.565,3 nfet
M$2 vss bn|invb_y|mn34_g1|mp24_g1|y \$3 vss nfet L=0.15U W=0.84U AS=0.2184P
+ AD=0.3948P PS=1.36U PD=2.62U
* device instance $3 r0 *1 7.895,3 nfet
M$3 \$6 a|inva_a|mn12_g0|mp13_g0 y vss nfet L=0.15U W=0.84U AS=0.3948P
+ AD=0.2184P PS=2.62U PD=1.36U
* device instance $4 r0 *1 8.565,3 nfet
M$4 vss a|b|invb_a|mn12_g1|mp24_g0 \$6 vss nfet L=0.15U W=0.84U AS=0.2184P
+ AD=0.3948P PS=1.36U PD=2.62U
* device instance $5 r0 *1 -3.44,5.32 nfet
M$5 an|inva_y|mn34_g0|mp13_g1|y a|inva_a|mn12_g0|mp13_g0 vss vss nfet L=0.15U
+ W=0.42U AS=0.1974P AD=0.1974P PS=1.78U PD=1.78U
* device instance $6 r0 *1 14.735,5.32 nfet
M$6 bn|invb_y|mn34_g1|mp24_g1|y a|b|invb_a|mn12_g1|mp24_g0 vss vss nfet L=0.15U
+ W=0.42U AS=0.1974P AD=0.1974P PS=1.78U PD=1.78U
* device instance $7 r0 *1 -3.44,8.64 pfet
M$7 an|inva_y|mn34_g0|mp13_g1|y a|inva_a|mn12_g0|mp13_g0 vdd vdd pfet L=0.15U
+ W=0.84U AS=0.3948P AD=0.3948P PS=2.62U PD=2.62U
* device instance $8 r0 *1 14.735,8.64 pfet
M$8 bn|invb_y|mn34_g1|mp24_g1|y a|b|invb_a|mn12_g1|mp24_g0 vdd vdd pfet L=0.15U
+ W=0.84U AS=0.3948P AD=0.3948P PS=2.62U PD=2.62U
* device instance $9 r0 *1 0.545,13 pfet
M$9 mid a|inva_a|mn12_g0|mp13_g0 vdd vdd pfet L=0.15U W=1.68U AS=0.7896P
+ AD=0.4368P PS=4.3U PD=2.2U
* device instance $10 r0 *1 1.215,13 pfet
M$10 y an|inva_y|mn34_g0|mp13_g1|y mid vdd pfet L=0.15U W=1.68U AS=0.4368P
+ AD=0.7896P PS=2.2U PD=4.3U
* device instance $11 r0 *1 7.695,13 pfet
M$11 mid bn|invb_y|mn34_g1|mp24_g1|y y vdd pfet L=0.15U W=1.68U AS=0.7896P
+ AD=0.4368P PS=4.3U PD=2.2U
* device instance $12 r0 *1 8.365,13 pfet
M$12 vdd a|b|invb_a|mn12_g1|mp24_g0 mid vdd pfet L=0.15U W=1.68U AS=0.4368P
+ AD=0.7896P PS=2.2U PD=4.3U
.ENDS xor2
