* extracted by klt extract --deck sky130

* cell core
* pin a,g_a,mnab_y,mpa_y,mpb_y,n1,n2,n3,n4,s4_y,y
* pin en
* pin g_vddr,mnt_g,vddr
* pin g_vss,mph_g,s1_vss,s2_vss,s3_vss,s4_vss,vss
* pin mnt_g,s1_vddr,vddr
* pin mnt_g,s2_vddr,vddr
* pin mnt_g,s3_vddr,vddr
* pin mnt_g,s4_vddr,vddr
* pin mpa_py,mpb_py,mph_py,py
* pin ny
* pin ny
* pin ny
* pin ny
* pin ny
* pin py
* pin py
* pin py
* pin py
.SUBCKT core a|g_a|mnab_y|mpa_y|mpb_y|n1|n2|n3|n4|s4_y|y en g_vddr|mnt_g|vddr
+ g_vss|mph_g|s1_vss|s2_vss|s3_vss|s4_vss|vss mnt_g|s1_vddr|vddr
+ mnt_g|s2_vddr|vddr mnt_g|s3_vddr|vddr mnt_g|s4_vddr|vddr
+ mpa_py|mpb_py|mph_py|py ny ny$1 ny$2 ny$3 ny$4 py py$1 py$2 py$3
* device instance $1 r0 *1 1.42,0.21 nfet
M$1 ny g_vddr|mnt_g|vddr g_vss|mph_g|s1_vss|s2_vss|s3_vss|s4_vss|vss
+ g_vss|mph_g|s1_vss|s2_vss|s3_vss|s4_vss|vss nfet L=2U W=0.42U AS=0.1764P
+ AD=0.1764P PS=1.68U PD=1.68U
* device instance $2 r0 *1 10.18,0.21 nfet
M$2 ny$1 mnt_g|s1_vddr|vddr g_vss|mph_g|s1_vss|s2_vss|s3_vss|s4_vss|vss
+ g_vss|mph_g|s1_vss|s2_vss|s3_vss|s4_vss|vss nfet L=2U W=0.42U AS=0.1764P
+ AD=0.1764P PS=1.68U PD=1.68U
* device instance $3 r0 *1 12.545,0.21 nfet
M$3 a|g_a|mnab_y|mpa_y|mpb_y|n1|n2|n3|n4|s4_y|y
+ a|g_a|mnab_y|mpa_y|mpb_y|n1|n2|n3|n4|s4_y|y ny$1
+ g_vss|mph_g|s1_vss|s2_vss|s3_vss|s4_vss|vss nfet L=0.15U W=0.42U AS=0.1974P
+ AD=0.1974P PS=1.78U PD=1.78U
* device instance $4 r0 *1 18.355,0.21 nfet
M$4 ny$2 mnt_g|s2_vddr|vddr g_vss|mph_g|s1_vss|s2_vss|s3_vss|s4_vss|vss
+ g_vss|mph_g|s1_vss|s2_vss|s3_vss|s4_vss|vss nfet L=2U W=0.42U AS=0.1764P
+ AD=0.1764P PS=1.68U PD=1.68U
* device instance $5 r0 *1 20.72,0.21 nfet
M$5 a|g_a|mnab_y|mpa_y|mpb_y|n1|n2|n3|n4|s4_y|y
+ a|g_a|mnab_y|mpa_y|mpb_y|n1|n2|n3|n4|s4_y|y ny$2
+ g_vss|mph_g|s1_vss|s2_vss|s3_vss|s4_vss|vss nfet L=0.15U W=0.42U AS=0.1974P
+ AD=0.1974P PS=1.78U PD=1.78U
* device instance $6 r0 *1 26.53,0.21 nfet
M$6 ny$3 mnt_g|s3_vddr|vddr g_vss|mph_g|s1_vss|s2_vss|s3_vss|s4_vss|vss
+ g_vss|mph_g|s1_vss|s2_vss|s3_vss|s4_vss|vss nfet L=2U W=0.42U AS=0.1764P
+ AD=0.1764P PS=1.68U PD=1.68U
* device instance $7 r0 *1 28.895,0.21 nfet
M$7 a|g_a|mnab_y|mpa_y|mpb_y|n1|n2|n3|n4|s4_y|y
+ a|g_a|mnab_y|mpa_y|mpb_y|n1|n2|n3|n4|s4_y|y ny$3
+ g_vss|mph_g|s1_vss|s2_vss|s3_vss|s4_vss|vss nfet L=0.15U W=0.42U AS=0.1974P
+ AD=0.1974P PS=1.78U PD=1.78U
* device instance $8 r0 *1 34.705,0.21 nfet
M$8 ny$4 mnt_g|s4_vddr|vddr g_vss|mph_g|s1_vss|s2_vss|s3_vss|s4_vss|vss
+ g_vss|mph_g|s1_vss|s2_vss|s3_vss|s4_vss|vss nfet L=2U W=0.42U AS=0.1764P
+ AD=0.1764P PS=1.68U PD=1.68U
* device instance $9 r0 *1 37.07,0.21 nfet
M$9 a|g_a|mnab_y|mpa_y|mpb_y|n1|n2|n3|n4|s4_y|y
+ a|g_a|mnab_y|mpa_y|mpb_y|n1|n2|n3|n4|s4_y|y ny$4
+ g_vss|mph_g|s1_vss|s2_vss|s3_vss|s4_vss|vss nfet L=0.15U W=0.42U AS=0.1974P
+ AD=0.1974P PS=1.78U PD=1.78U
* device instance $10 r0 *1 3.785,0.21 nfet
M$10 \$4 en ny g_vss|mph_g|s1_vss|s2_vss|s3_vss|s4_vss|vss nfet L=0.15U W=0.84U
+ AS=0.3948P AD=0.2184P PS=2.62U PD=1.36U
* device instance $11 r0 *1 4.455,0.21 nfet
M$11 a|g_a|mnab_y|mpa_y|mpb_y|n1|n2|n3|n4|s4_y|y
+ a|g_a|mnab_y|mpa_y|mpb_y|n1|n2|n3|n4|s4_y|y \$4
+ g_vss|mph_g|s1_vss|s2_vss|s3_vss|s4_vss|vss nfet L=0.15U W=0.84U AS=0.2184P
+ AD=0.3948P PS=1.36U PD=2.62U
* device instance $12 r0 *1 1.42,3.74 pfet
M$12 mpa_py|mpb_py|mph_py|py g_vss|mph_g|s1_vss|s2_vss|s3_vss|s4_vss|vss
+ g_vddr|mnt_g|vddr g_vddr|mnt_g|vddr pfet L=2U W=0.42U AS=0.1764P AD=0.1764P
+ PS=1.68U PD=1.68U
* device instance $13 r0 *1 10.18,3.74 pfet
M$13 py g_vss|mph_g|s1_vss|s2_vss|s3_vss|s4_vss|vss mnt_g|s1_vddr|vddr
+ mnt_g|s1_vddr|vddr pfet L=2U W=0.42U AS=0.1764P AD=0.1764P PS=1.68U PD=1.68U
* device instance $14 r0 *1 18.355,3.74 pfet
M$14 py$1 g_vss|mph_g|s1_vss|s2_vss|s3_vss|s4_vss|vss mnt_g|s2_vddr|vddr
+ mnt_g|s2_vddr|vddr pfet L=2U W=0.42U AS=0.1764P AD=0.1764P PS=1.68U PD=1.68U
* device instance $15 r0 *1 26.53,3.74 pfet
M$15 py$2 g_vss|mph_g|s1_vss|s2_vss|s3_vss|s4_vss|vss mnt_g|s3_vddr|vddr
+ mnt_g|s3_vddr|vddr pfet L=2U W=0.42U AS=0.1764P AD=0.1764P PS=1.68U PD=1.68U
* device instance $16 r0 *1 34.705,3.74 pfet
M$16 py$3 g_vss|mph_g|s1_vss|s2_vss|s3_vss|s4_vss|vss mnt_g|s4_vddr|vddr
+ mnt_g|s4_vddr|vddr pfet L=2U W=0.42U AS=0.1764P AD=0.1764P PS=1.68U PD=1.68U
* device instance $17 r0 *1 3.585,3.74 pfet
M$17 a|g_a|mnab_y|mpa_y|mpb_y|n1|n2|n3|n4|s4_y|y en mpa_py|mpb_py|mph_py|py
+ g_vddr|mnt_g|vddr pfet L=0.15U W=0.84U AS=0.3948P AD=0.3948P PS=2.62U PD=2.62U
* device instance $18 r0 *1 4.875,3.74 pfet
M$18 mpa_py|mpb_py|mph_py|py a|g_a|mnab_y|mpa_y|mpb_y|n1|n2|n3|n4|s4_y|y
+ a|g_a|mnab_y|mpa_y|mpb_y|n1|n2|n3|n4|s4_y|y g_vddr|mnt_g|vddr pfet L=0.15U
+ W=0.84U AS=0.3948P AD=0.3948P PS=2.62U PD=2.62U
* device instance $19 r0 *1 12.345,3.74 pfet
M$19 a|g_a|mnab_y|mpa_y|mpb_y|n1|n2|n3|n4|s4_y|y
+ a|g_a|mnab_y|mpa_y|mpb_y|n1|n2|n3|n4|s4_y|y py mnt_g|s1_vddr|vddr pfet
+ L=0.15U W=0.84U AS=0.3948P AD=0.3948P PS=2.62U PD=2.62U
* device instance $20 r0 *1 20.52,3.74 pfet
M$20 a|g_a|mnab_y|mpa_y|mpb_y|n1|n2|n3|n4|s4_y|y
+ a|g_a|mnab_y|mpa_y|mpb_y|n1|n2|n3|n4|s4_y|y py$1 mnt_g|s2_vddr|vddr pfet
+ L=0.15U W=0.84U AS=0.3948P AD=0.3948P PS=2.62U PD=2.62U
* device instance $21 r0 *1 28.695,3.74 pfet
M$21 a|g_a|mnab_y|mpa_y|mpb_y|n1|n2|n3|n4|s4_y|y
+ a|g_a|mnab_y|mpa_y|mpb_y|n1|n2|n3|n4|s4_y|y py$2 mnt_g|s3_vddr|vddr pfet
+ L=0.15U W=0.84U AS=0.3948P AD=0.3948P PS=2.62U PD=2.62U
* device instance $22 r0 *1 36.87,3.74 pfet
M$22 a|g_a|mnab_y|mpa_y|mpb_y|n1|n2|n3|n4|s4_y|y
+ a|g_a|mnab_y|mpa_y|mpb_y|n1|n2|n3|n4|s4_y|y py$3 mnt_g|s4_vddr|vddr pfet
+ L=0.15U W=0.84U AS=0.3948P AD=0.3948P PS=2.62U PD=2.62U
.ENDS core
