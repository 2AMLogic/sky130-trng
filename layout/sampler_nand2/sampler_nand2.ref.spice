* Reference netlist for sampler_nand2 LVS -- GENERATED by layout/bin/compose-cell.py
* Source: layout/sampler_nand2/sampler_nand2.source.spice .subckt sampler_nand2
* Only unit spellings (and any substituted subckt parameter)
* differ from the source -- see compose-cell.py's docstring.
.subckt sampler_nand2 a en y vdd vss
XMpa y a vdd vdd sky130_fd_pr__pfet_01v8 L=0.15u W=0.84u nf=1 ad=0.2436 as=0.2436 pd=2.26 ps=2.26
+ nrd=0.345238095238095 nrs=0.345238095238095 sa=0 sb=0 sd=0 mult=1 m=1
XMpb y en vdd vdd sky130_fd_pr__pfet_01v8 L=0.15u W=0.84u nf=1 ad=0.2436 as=0.2436 pd=2.26 ps=2.26
+ nrd=0.345238095238095 nrs=0.345238095238095 sa=0 sb=0 sd=0 mult=1 m=1
XMna y a nm vss sky130_fd_pr__nfet_01v8 L=0.15u W=0.84u nf=1 ad=0.2436 as=0.2436 pd=2.26 ps=2.26
+ nrd=0.345238095238095 nrs=0.345238095238095 sa=0 sb=0 sd=0 mult=1 m=1
XMnb nm en vss vss sky130_fd_pr__nfet_01v8 L=0.15u W=0.84u nf=1 ad=0.2436 as=0.2436 pd=2.26 ps=2.26
+ nrd=0.345238095238095 nrs=0.345238095238095 sa=0 sb=0 sd=0 mult=1 m=1
.ends
