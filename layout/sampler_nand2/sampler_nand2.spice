* extracted by klt extract --deck sky130

* cell sampler_nand2
* pin a
* pin en
* pin mnab_y,mpa_y,mpb_y,y
* pin mpa_py,mpb_py,nwell_vdd,vdd
* pin vss
.SUBCKT sampler_nand2 a en mnab_y|mpa_y|mpb_y|y mpa_py|mpb_py|nwell_vdd|vdd vss
* device instance $1 r0 *1 3.785,0.21 nfet
M$1 \$2 en vss vss nfet L=0.15U W=0.84U AS=0.3948P AD=0.2184P PS=2.62U PD=1.36U
* device instance $2 r0 *1 4.455,0.21 nfet
M$2 mnab_y|mpa_y|mpb_y|y a \$2 vss nfet L=0.15U W=0.84U AS=0.2184P AD=0.3948P
+ PS=1.36U PD=2.62U
* device instance $3 r0 *1 3.585,3.74 pfet
M$3 mnab_y|mpa_y|mpb_y|y en mpa_py|mpb_py|nwell_vdd|vdd
+ mpa_py|mpb_py|nwell_vdd|vdd pfet L=0.15U W=0.84U AS=0.3948P AD=0.3948P
+ PS=2.62U PD=2.62U
* device instance $4 r0 *1 4.875,3.74 pfet
M$4 mpa_py|mpb_py|nwell_vdd|vdd a mnab_y|mpa_y|mpb_y|y
+ mpa_py|mpb_py|nwell_vdd|vdd pfet L=0.15U W=0.84U AS=0.3948P AD=0.3948P
+ PS=2.62U PD=2.62U
.ENDS sampler_nand2
