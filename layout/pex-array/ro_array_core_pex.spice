* Post-layout (parasitic) subcircuit library -- GENERATED by
* layout/bin/pex-netlist.py from layout/pex-array/pex.json. Do not edit by
* hand: `python3 layout/bin/pex-netlist.py layout/pex-array/pex.json --check`
* re-extracts every cell from its committed GDS and fails if this file
* and that extraction disagree.
*
* Each cell below is `klt extract --pdk <variant> --parasitics` output
* over a composed, DRC-clean and LVS-clean cell under layout/. --pdk is
* what makes its device cards subcircuit calls on the PDK's own devices
* with unitless geometry (this repo's decks run at .option scale=1u), so
* NO device card, geometry value, R value, C value or connection is
* rewritten here. Two things are: extractor-joined net names are renamed
* to their design-level names, and a design-port-order wrapper is added
* per cell. See layout/bin/pex-netlist.py's module docstring for why,
* and layout/pex/README.md for what the parasitic model does and does
* not contain.
*
* Substrate return node: `vsubs`, declared .global below --
* klayout-tools#1503 (the extractor scopes it per-instance, which
* isolates every ground capacitance behind a 1 TOhm tie once the cell
* is instantiated rather than simulated flat). A deck including this
* library MUST tie the node itself; every sim/ record minted from it
* states which tie it used.

.global vsubs

*-----------------------------------------------------------------------
* ro_array_core_pex -- post-layout, from ../ro_array_core/ro_array_core.gds
* klt extract --parasitics: 132 devices, 96 nets
*-----------------------------------------------------------------------
.subckt ro_array_core_pex__core t2 ro2 ro4 rn1 rn2 rn3 rn4 sig_n1 sig_n1n1 sig_n1n2 sig_n1n3 ro1 ro3 t1 sig_n2 sig_n2n1 sig_n2n2 sig_n2n3 sig_n3 sig_n3n1 sig_n3n2 sig_n3n3 sig_n4 sig_n4n1 sig_n4n2 sig_n4n3 xor_an xor_ann1 xor_ann2 xor_bn xor_bnn1 xor_bnn2 en1 en2 en3 en4 vddr1 vddr2 vddr3 vddr4 vss mid midn1 midn2 py_g py_gn1 py_gn2 py_gn3 ny nyn1 nyn2 nyn3 nyn4 nyn5 nyn6 nyn7 nyn8 nyn9 nyn10 nyn11 nyn12 nyn13 nyn14 nyn15 nyn16 nyn17 nyn18 nyn19 py pyn1 pyn2 pyn3 pyn4 pyn5 pyn6 pyn7 pyn8 pyn9 pyn10 pyn11 pyn12 pyn13 pyn14 pyn15 vdd xo
* device instance $1 r0 *1 6.225,0.21 nfet
Xn1 n11__t1 en1__t0 ny__t0 vss__t56 sky130_fd_pr__nfet_01v8 L=0.15 W=0.84 AS=0.3948 AD=0.2184 PS=2.62 PD=1.36
* device instance $2 r0 *1 6.895,0.21 nfet
Xn2 sig_n1__t02 rn1__t0 n11__t0 vss__t66 sky130_fd_pr__nfet_01v8 L=0.15 W=0.84 AS=0.2184 AD=0.3948 PS=1.36 PD=2.62
* device instance $3 r0 *1 61.525,0.21 nfet
Xn3 n20__t0 en2__t1 ny__t16 vss__t57 sky130_fd_pr__nfet_01v8 L=0.15 W=0.84 AS=0.3948 AD=0.2184 PS=2.62 PD=1.36
* device instance $4 r0 *1 62.195,0.21 nfet
Xn4 sig_n1__t4 rn2__t5 n20__t1 vss__t67 sky130_fd_pr__nfet_01v8 L=0.15 W=0.84 AS=0.2184 AD=0.3948 PS=1.36 PD=2.62
* device instance $5 r0 *1 116.825,0.21 nfet
Xn5 n29__t0 en3__t1 ny__t111 vss__t58 sky130_fd_pr__nfet_01v8 L=0.15 W=0.84 AS=0.3948 AD=0.2184 PS=2.62 PD=1.36
* device instance $6 r0 *1 117.495,0.21 nfet
Xn6 sig_n1__t43 rn3__t5 n29__t1 vss__t68 sky130_fd_pr__nfet_01v8 L=0.15 W=0.84 AS=0.2184 AD=0.3948 PS=1.36 PD=2.62
* device instance $7 r0 *1 172.125,0.21 nfet
Xn7 n38__t0 en4__t1 ny__t116 vss__t59 sky130_fd_pr__nfet_01v8 L=0.15 W=0.84 AS=0.3948 AD=0.2184 PS=2.62 PD=1.36
* device instance $8 r0 *1 172.795,0.21 nfet
Xn8 sig_n1__t44 rn4__t5 n38__t1 vss__t69 sky130_fd_pr__nfet_01v8 L=0.15 W=0.84 AS=0.2184 AD=0.3948 PS=1.36 PD=2.62
* device instance $9 r0 *1 114.21,0.21 nfet
Xn9 ny__t011 vddr3__t0 vss__t2 vss__t76 sky130_fd_pr__nfet_01v8 L=2 W=0.46 AS=0.1932 AD=0.1932 PS=1.76 PD=1.76
* device instance $10 r0 *1 123.51,0.21 nfet
Xn10 ny__t012 vddr3__t20 vss__t31 vss__t77 sky130_fd_pr__nfet_01v8 L=2 W=0.46 AS=0.1932 AD=0.1932 PS=1.76 PD=1.76
* device instance $11 r0 *1 131.685,0.21 nfet
Xn11 ny__t013 vddr3__t17 vss__t28 vss__t78 sky130_fd_pr__nfet_01v8 L=2 W=0.46 AS=0.1932 AD=0.1932 PS=1.76 PD=1.76
* device instance $12 r0 *1 139.86,0.21 nfet
Xn12 ny__t014 vddr3__t18 vss__t29 vss__t79 sky130_fd_pr__nfet_01v8 L=2 W=0.46 AS=0.1932 AD=0.1932 PS=1.76 PD=1.76
* device instance $13 r0 *1 148.035,0.21 nfet
Xn13 ny__t015 vddr3__t19 vss__t30 vss__t80 sky130_fd_pr__nfet_01v8 L=2 W=0.46 AS=0.1932 AD=0.1932 PS=1.76 PD=1.76
* device instance $14 r0 *1 169.51,0.21 nfet
Xn14 ny__t016 vddr4__t0 vss__t3 vss__t81 sky130_fd_pr__nfet_01v8 L=2 W=0.48 AS=0.2016 AD=0.2016 PS=1.8 PD=1.8
* device instance $15 r0 *1 178.81,0.21 nfet
Xn15 ny__t017 vddr4__t17 vss__t24 vss__t82 sky130_fd_pr__nfet_01v8 L=2 W=0.48 AS=0.2016 AD=0.2016 PS=1.8 PD=1.8
* device instance $16 r0 *1 186.985,0.21 nfet
Xn16 ny__t018 vddr4__t18 vss__t25 vss__t83 sky130_fd_pr__nfet_01v8 L=2 W=0.48 AS=0.2016 AD=0.2016 PS=1.8 PD=1.8
* device instance $17 r0 *1 195.16,0.21 nfet
Xn17 ny__t019 vddr4__t19 vss__t26 vss__t84 sky130_fd_pr__nfet_01v8 L=2 W=0.48 AS=0.2016 AD=0.2016 PS=1.8 PD=1.8
* device instance $18 r0 *1 203.335,0.21 nfet
Xn18 ny__t020 vddr4__t20 vss__t27 vss__t85 sky130_fd_pr__nfet_01v8 L=2 W=0.48 AS=0.2016 AD=0.2016 PS=1.8 PD=1.8
* device instance $19 r0 *1 3.61,0.21 nfet
Xn19 ny__t1 vddr1__t0 vss__t0 vss__t86 sky130_fd_pr__nfet_01v8 L=2 W=0.42 AS=0.1764 AD=0.1764 PS=1.68 PD=1.68
* device instance $20 r0 *1 12.91,0.21 nfet
Xn20 ny__t12 vddr1__t17 vss__t46 vss__t87 sky130_fd_pr__nfet_01v8 L=2 W=0.42 AS=0.1764 AD=0.1764 PS=1.68 PD=1.68
* device instance $21 r0 *1 15.515,0.21 nfet
Xn21 sig_n2__t0 sig_n1__t12 ny__t02 vss__t91 sky130_fd_pr__nfet_01v8 L=0.15 W=0.42 AS=0.1974 AD=0.1974 PS=1.78 PD=1.78
* device instance $22 r0 *1 21.085,0.21 nfet
Xn22 ny__t13 vddr1__t18 vss__t47 vss__t88 sky130_fd_pr__nfet_01v8 L=2 W=0.42 AS=0.1764 AD=0.1764 PS=1.68 PD=1.68
* device instance $23 r0 *1 23.69,0.21 nfet
Xn23 sig_n3__t2 sig_n2__t3 ny__t03 vss__t92 sky130_fd_pr__nfet_01v8 L=0.15 W=0.42 AS=0.1974 AD=0.1974 PS=1.78 PD=1.78
* device instance $24 r0 *1 29.26,0.21 nfet
Xn24 ny__t14 vddr1__t20 vss__t49 vss__t89 sky130_fd_pr__nfet_01v8 L=2 W=0.42 AS=0.1764 AD=0.1764 PS=1.68 PD=1.68
* device instance $25 r0 *1 31.865,0.21 nfet
Xn25 sig_n4__t2 sig_n3__t3 ny__t04 vss__t93 sky130_fd_pr__nfet_01v8 L=0.15 W=0.42 AS=0.1974 AD=0.1974 PS=1.78 PD=1.78
* device instance $26 r0 *1 37.435,0.21 nfet
Xn26 ny__t15 vddr1__t19 vss__t48 vss__t90 sky130_fd_pr__nfet_01v8 L=2 W=0.42 AS=0.1764 AD=0.1764 PS=1.68 PD=1.68
* device instance $27 r0 *1 40.04,0.21 nfet
Xn27 rn1__t4 sig_n4__t3 ny__t05 vss__t94 sky130_fd_pr__nfet_01v8 L=0.15 W=0.42 AS=0.1974 AD=0.1974 PS=1.78 PD=1.78
* device instance $28 r0 *1 48.86,0.21 nfet
Xn28 ro1__t3 rn1__t5 vss__t41 vss__t95 sky130_fd_pr__nfet_01v8 L=0.15 W=0.42 AS=0.1974 AD=0.1974 PS=1.78 PD=1.78
* device instance $29 r0 *1 58.91,0.21 nfet
Xn29 ny__t06 vddr2__t0 vss__t1 vss__t117 sky130_fd_pr__nfet_01v8 L=2 W=0.44 AS=0.1848 AD=0.1848 PS=1.72 PD=1.72
* device instance $30 r0 *1 68.21,0.21 nfet
Xn30 ny__t07 vddr2__t20 vss__t35 vss__t118 sky130_fd_pr__nfet_01v8 L=2 W=0.44 AS=0.1848 AD=0.1848 PS=1.72 PD=1.72
* device instance $31 r0 *1 70.815,0.21 nfet
Xn31 sig_n2__t22 sig_n1__t3 ny__t17 vss__t96 sky130_fd_pr__nfet_01v8 L=0.15 W=0.42 AS=0.1974 AD=0.1974 PS=1.78 PD=1.78
* device instance $32 r0 *1 76.385,0.21 nfet
Xn32 ny__t08 vddr2__t18 vss__t33 vss__t119 sky130_fd_pr__nfet_01v8 L=2 W=0.44 AS=0.1848 AD=0.1848 PS=1.72 PD=1.72
* device instance $33 r0 *1 78.99,0.21 nfet
Xn33 sig_n3__t22 sig_n2__t32 ny__t18 vss__t97 sky130_fd_pr__nfet_01v8 L=0.15 W=0.42 AS=0.1974 AD=0.1974 PS=1.78 PD=1.78
* device instance $34 r0 *1 84.56,0.21 nfet
Xn34 ny__t09 vddr2__t19 vss__t34 vss__t120 sky130_fd_pr__nfet_01v8 L=2 W=0.44 AS=0.1848 AD=0.1848 PS=1.72 PD=1.72
* device instance $35 r0 *1 87.165,0.21 nfet
Xn35 sig_n4__t24 sig_n3__t32 ny__t19 vss__t98 sky130_fd_pr__nfet_01v8 L=0.15 W=0.42 AS=0.1974 AD=0.1974 PS=1.78 PD=1.78
* device instance $36 r0 *1 92.735,0.21 nfet
Xn36 ny__t010 vddr2__t17 vss__t32 vss__t121 sky130_fd_pr__nfet_01v8 L=2 W=0.44 AS=0.1848 AD=0.1848 PS=1.72 PD=1.72
* device instance $37 r0 *1 95.34,0.21 nfet
Xn37 rn2__t3 sig_n4__t34 ny__t110 vss__t99 sky130_fd_pr__nfet_01v8 L=0.15 W=0.42 AS=0.1974 AD=0.1974 PS=1.78 PD=1.78
* device instance $38 r0 *1 104.16,0.21 nfet
Xn38 ro2__t3 rn2__t4 vss__t38 vss__t100 sky130_fd_pr__nfet_01v8 L=0.15 W=0.42 AS=0.1974 AD=0.1974 PS=1.78 PD=1.78
* device instance $39 r0 *1 126.115,0.21 nfet
Xn39 sig_n2__t23 sig_n1__t33 ny__t112 vss__t101 sky130_fd_pr__nfet_01v8 L=0.15 W=0.42 AS=0.1974 AD=0.1974 PS=1.78 PD=1.78
* device instance $40 r0 *1 134.29,0.21 nfet
Xn40 sig_n3__t23 sig_n2__t33 ny__t113 vss__t102 sky130_fd_pr__nfet_01v8 L=0.15 W=0.42 AS=0.1974 AD=0.1974 PS=1.78 PD=1.78
* device instance $41 r0 *1 142.465,0.21 nfet
Xn41 sig_n4__t22 sig_n3__t33 ny__t114 vss__t103 sky130_fd_pr__nfet_01v8 L=0.15 W=0.42 AS=0.1974 AD=0.1974 PS=1.78 PD=1.78
* device instance $42 r0 *1 150.64,0.21 nfet
Xn42 rn3__t3 sig_n4__t32 ny__t115 vss__t104 sky130_fd_pr__nfet_01v8 L=0.15 W=0.42 AS=0.1974 AD=0.1974 PS=1.78 PD=1.78
* device instance $43 r0 *1 159.46,0.21 nfet
Xn43 ro3__t3 rn3__t4 vss__t36 vss__t105 sky130_fd_pr__nfet_01v8 L=0.15 W=0.42 AS=0.1974 AD=0.1974 PS=1.78 PD=1.78
* device instance $44 r0 *1 181.415,0.21 nfet
Xn44 sig_n2__t24 sig_n1__t34 ny__t117 vss__t106 sky130_fd_pr__nfet_01v8 L=0.15 W=0.42 AS=0.1974 AD=0.1974 PS=1.78 PD=1.78
* device instance $45 r0 *1 189.59,0.21 nfet
Xn45 sig_n3__t24 sig_n2__t34 ny__t118 vss__t107 sky130_fd_pr__nfet_01v8 L=0.15 W=0.42 AS=0.1974 AD=0.1974 PS=1.78 PD=1.78
* device instance $46 r0 *1 197.765,0.21 nfet
Xn46 sig_n4__t23 sig_n3__t34 ny__t119 vss__t108 sky130_fd_pr__nfet_01v8 L=0.15 W=0.42 AS=0.1974 AD=0.1974 PS=1.78 PD=1.78
* device instance $47 r0 *1 205.94,0.21 nfet
Xn47 rn4__t3 sig_n4__t33 ny__t120 vss__t109 sky130_fd_pr__nfet_01v8 L=0.15 W=0.42 AS=0.1974 AD=0.1974 PS=1.78 PD=1.78
* device instance $48 r0 *1 214.76,0.21 nfet
Xn48 ro4__t3 rn4__t4 vss__t44 vss__t110 sky130_fd_pr__nfet_01v8 L=0.15 W=0.42 AS=0.1974 AD=0.1974 PS=1.78 PD=1.78
* device instance $49 r0 *1 3.445,17.905 nfet
Xn49 xor_an__t2 ro1__t4 vss__t37 vss__t111 sky130_fd_pr__nfet_01v8 L=0.15 W=0.42 AS=0.1974 AD=0.1974 PS=1.78 PD=1.78
* device instance $50 r0 *1 7.78,15.585 nfet
Xn50 n80__t0 xor_an__t3 t1__t7 vss__t60 sky130_fd_pr__nfet_01v8 L=0.15 W=0.84 AS=0.3948 AD=0.2184 PS=2.62 PD=1.36
* device instance $51 r0 *1 8.45,15.585 nfet
Xn51 vss__t50 xor_bn__t32 n80__t1 vss__t70 sky130_fd_pr__nfet_01v8 L=0.15 W=0.84 AS=0.2184 AD=0.3948 PS=1.36 PD=2.62
* device instance $52 r0 *1 14.78,15.585 nfet
Xn52 n82__t0 ro1__t5 t1__t6 vss__t61 sky130_fd_pr__nfet_01v8 L=0.15 W=0.84 AS=0.3948 AD=0.2184 PS=2.62 PD=1.36
* device instance $53 r0 *1 15.45,15.585 nfet
Xn53 vss__t53 ro2__t5 n82__t1 vss__t71 sky130_fd_pr__nfet_01v8 L=0.15 W=0.84 AS=0.2184 AD=0.3948 PS=1.36 PD=2.62
* device instance $54 r0 *1 21.62,17.905 nfet
Xn54 xor_bn__t22 ro2__t4 vss__t39 vss__t112 sky130_fd_pr__nfet_01v8 L=0.15 W=0.42 AS=0.1974 AD=0.1974 PS=1.78 PD=1.78
* device instance $55 r0 *1 32.415,17.905 nfet
Xn55 xor_an__t22 ro3__t4 vss__t40 vss__t113 sky130_fd_pr__nfet_01v8 L=0.15 W=0.42 AS=0.1974 AD=0.1974 PS=1.78 PD=1.78
* device instance $56 r0 *1 36.75,15.585 nfet
Xn56 n83__t0 xor_an__t32 t2__t6 vss__t62 sky130_fd_pr__nfet_01v8 L=0.15 W=0.84 AS=0.3948 AD=0.2184 PS=2.62 PD=1.36
* device instance $57 r0 *1 37.42,15.585 nfet
Xn57 vss__t55 xor_bn__t33 n83__t1 vss__t72 sky130_fd_pr__nfet_01v8 L=0.15 W=0.84 AS=0.2184 AD=0.3948 PS=1.36 PD=2.62
* device instance $58 r0 *1 43.75,15.585 nfet
Xn58 n85__t0 ro3__t5 t2__t7 vss__t63 sky130_fd_pr__nfet_01v8 L=0.15 W=0.84 AS=0.3948 AD=0.2184 PS=2.62 PD=1.36
* device instance $59 r0 *1 44.42,15.585 nfet
Xn59 vss__t54 ro4__t5 n85__t1 vss__t73 sky130_fd_pr__nfet_01v8 L=0.15 W=0.84 AS=0.2184 AD=0.3948 PS=1.36 PD=2.62
* device instance $60 r0 *1 50.59,17.905 nfet
Xn60 xor_bn__t23 ro4__t4 vss__t42 vss__t114 sky130_fd_pr__nfet_01v8 L=0.15 W=0.42 AS=0.1974 AD=0.1974 PS=1.78 PD=1.78
* device instance $61 r0 *1 61.385,17.905 nfet
Xn61 xor_an__t23 t1__t4 vss__t43 vss__t115 sky130_fd_pr__nfet_01v8 L=0.15 W=0.42 AS=0.1974 AD=0.1974 PS=1.78 PD=1.78
* device instance $62 r0 *1 65.72,15.585 nfet
Xn62 n87__t0 xor_an__t33 xo__t2 vss__t64 sky130_fd_pr__nfet_01v8 L=0.15 W=0.84 AS=0.3948 AD=0.2184 PS=2.62 PD=1.36
* device instance $63 r0 *1 66.39,15.585 nfet
Xn63 vss__t52 xor_bn__t3 n87__t1 vss__t74 sky130_fd_pr__nfet_01v8 L=0.15 W=0.84 AS=0.2184 AD=0.3948 PS=1.36 PD=2.62
* device instance $64 r0 *1 72.72,15.585 nfet
Xn64 n89__t0 t1__t5 xo__t3 vss__t65 sky130_fd_pr__nfet_01v8 L=0.15 W=0.84 AS=0.3948 AD=0.2184 PS=2.62 PD=1.36
* device instance $65 r0 *1 73.39,15.585 nfet
Xn65 vss__t51 t2__t5 n89__t1 vss__t75 sky130_fd_pr__nfet_01v8 L=0.15 W=0.84 AS=0.2184 AD=0.3948 PS=1.36 PD=2.62
* device instance $66 r0 *1 79.56,17.905 nfet
Xn66 xor_bn__t2 t2__t4 vss__t45 vss__t116 sky130_fd_pr__nfet_01v8 L=0.15 W=0.42 AS=0.1974 AD=0.1974 PS=1.78 PD=1.78
* device instance $67 r0 *1 48.86,3.53 pfet
Xn67 ro1__t1 rn1__t2 vdd__t20 vdd__t30 sky130_fd_pr__pfet_01v8 L=0.15 W=0.84 AS=0.3948 AD=0.3948 PS=2.62 PD=2.62
* device instance $68 r0 *1 104.16,3.53 pfet
Xn68 ro2__t1 rn2__t1 vdd__t27 vdd__t37 sky130_fd_pr__pfet_01v8 L=0.15 W=0.84 AS=0.3948 AD=0.3948 PS=2.62 PD=2.62
* device instance $69 r0 *1 159.46,3.53 pfet
Xn69 ro3__t1 rn3__t2 vdd__t19 vdd__t29 sky130_fd_pr__pfet_01v8 L=0.15 W=0.84 AS=0.3948 AD=0.3948 PS=2.62 PD=2.62
* device instance $70 r0 *1 214.76,3.53 pfet
Xn70 ro4__t1 rn4__t1 vdd__t18 vdd__t28 sky130_fd_pr__pfet_01v8 L=0.15 W=0.84 AS=0.3948 AD=0.3948 PS=2.62 PD=2.62
* device instance $71 r0 *1 15.075,3.74 pfet
Xn71 sig_n2__t1 sig_n1__t32 py__t0 vddr1__t7 sky130_fd_pr__pfet_01v8 L=0.15 W=0.84 AS=0.3948 AD=0.3948 PS=2.62 PD=2.62
* device instance $72 r0 *1 23.25,3.74 pfet
Xn72 sig_n3__t0 sig_n2__t2 py__t02 vddr1__t6 sky130_fd_pr__pfet_01v8 L=0.15 W=0.84 AS=0.3948 AD=0.3948 PS=2.62 PD=2.62
* device instance $73 r0 *1 31.425,3.74 pfet
Xn73 sig_n4__t0 sig_n3__t1 py__t03 vddr1__t5 sky130_fd_pr__pfet_01v8 L=0.15 W=0.84 AS=0.3948 AD=0.3948 PS=2.62 PD=2.62
* device instance $74 r0 *1 39.6,3.74 pfet
Xn74 rn1__t1 sig_n4__t1 py__t04 vddr1__t4 sky130_fd_pr__pfet_01v8 L=0.15 W=0.84 AS=0.3948 AD=0.3948 PS=2.62 PD=2.62
* device instance $75 r0 *1 70.375,3.74 pfet
Xn75 sig_n2__t02 sig_n1__t1 py__t15 vddr2__t14 sky130_fd_pr__pfet_01v8 L=0.15 W=0.84 AS=0.3948 AD=0.3948 PS=2.62 PD=2.62
* device instance $76 r0 *1 78.55,3.74 pfet
Xn76 sig_n3__t02 sig_n2__t12 py__t16 vddr2__t13 sky130_fd_pr__pfet_01v8 L=0.15 W=0.84 AS=0.3948 AD=0.3948 PS=2.62 PD=2.62
* device instance $77 r0 *1 86.725,3.74 pfet
Xn77 sig_n4__t04 sig_n3__t12 py__t17 vddr2__t12 sky130_fd_pr__pfet_01v8 L=0.15 W=0.84 AS=0.3948 AD=0.3948 PS=2.62 PD=2.62
* device instance $78 r0 *1 94.9,3.74 pfet
Xn78 rn2__t0 sig_n4__t14 py__t18 vddr2__t11 sky130_fd_pr__pfet_01v8 L=0.15 W=0.84 AS=0.3948 AD=0.3948 PS=2.62 PD=2.62
* device instance $79 r0 *1 125.675,3.74 pfet
Xn79 sig_n2__t03 sig_n1__t13 py__t19 vddr3__t14 sky130_fd_pr__pfet_01v8 L=0.15 W=0.84 AS=0.3948 AD=0.3948 PS=2.62 PD=2.62
* device instance $80 r0 *1 133.85,3.74 pfet
Xn80 sig_n3__t03 sig_n2__t13 py__t110 vddr3__t15 sky130_fd_pr__pfet_01v8 L=0.15 W=0.84 AS=0.3948 AD=0.3948 PS=2.62 PD=2.62
* device instance $81 r0 *1 142.025,3.74 pfet
Xn81 sig_n4__t02 sig_n3__t13 py__t111 vddr3__t11 sky130_fd_pr__pfet_01v8 L=0.15 W=0.84 AS=0.3948 AD=0.3948 PS=2.62 PD=2.62
* device instance $82 r0 *1 150.2,3.74 pfet
Xn82 rn3__t0 sig_n4__t12 py__t112 vddr3__t12 sky130_fd_pr__pfet_01v8 L=0.15 W=0.84 AS=0.3948 AD=0.3948 PS=2.62 PD=2.62
* device instance $83 r0 *1 180.975,3.74 pfet
Xn83 sig_n2__t04 sig_n1__t14 py__t113 vddr4__t11 sky130_fd_pr__pfet_01v8 L=0.15 W=0.84 AS=0.3948 AD=0.3948 PS=2.62 PD=2.62
* device instance $84 r0 *1 189.15,3.74 pfet
Xn84 sig_n3__t04 sig_n2__t14 py__t114 vddr4__t15 sky130_fd_pr__pfet_01v8 L=0.15 W=0.84 AS=0.3948 AD=0.3948 PS=2.62 PD=2.62
* device instance $85 r0 *1 197.325,3.74 pfet
Xn85 sig_n4__t03 sig_n3__t14 py__t115 vddr4__t14 sky130_fd_pr__pfet_01v8 L=0.15 W=0.84 AS=0.3948 AD=0.3948 PS=2.62 PD=2.62
* device instance $86 r0 *1 205.5,3.74 pfet
Xn86 rn4__t0 sig_n4__t13 py__t116 vddr4__t13 sky130_fd_pr__pfet_01v8 L=0.15 W=0.84 AS=0.3948 AD=0.3948 PS=2.62 PD=2.62
* device instance $87 r0 *1 5.775,4.19 pfet
Xn87 sig_n1__t22 en1__t1 py_g__t1 vddr1__t3 sky130_fd_pr__pfet_01v8 L=0.15 W=0.84 AS=0.3948 AD=0.3948 PS=2.62 PD=2.62
* device instance $88 r0 *1 7.065,4.19 pfet
Xn88 py_g__t2 rn1__t3 sig_n1__t42 vddr1__t8 sky130_fd_pr__pfet_01v8 L=0.15 W=0.84 AS=0.3948 AD=0.3948 PS=2.62 PD=2.62
* device instance $89 r0 *1 12.91,3.74 pfet
Xn89 py__t1 vss__t22 vddr1__t15 vddr1__t11 sky130_fd_pr__pfet_01v8 L=2 W=0.42 AS=0.1764 AD=0.1764 PS=1.68 PD=1.68
* device instance $90 r0 *1 21.085,3.74 pfet
Xn90 py__t12 vss__t23 vddr1__t16 vddr1__t12 sky130_fd_pr__pfet_01v8 L=2 W=0.42 AS=0.1764 AD=0.1764 PS=1.68 PD=1.68
* device instance $91 r0 *1 29.26,3.74 pfet
Xn91 py__t13 vss__t21 vddr1__t14 vddr1__t10 sky130_fd_pr__pfet_01v8 L=2 W=0.42 AS=0.1764 AD=0.1764 PS=1.68 PD=1.68
* device instance $92 r0 *1 37.435,3.74 pfet
Xn92 py__t14 vss__t20 vddr1__t13 vddr1__t9 sky130_fd_pr__pfet_01v8 L=2 W=0.42 AS=0.1764 AD=0.1764 PS=1.68 PD=1.68
* device instance $93 r0 *1 61.075,4.19 pfet
Xn93 sig_n1__t0 en2__t0 py_g__t22 vddr2__t16 sky130_fd_pr__pfet_01v8 L=0.15 W=0.84 AS=0.3948 AD=0.3948 PS=2.62 PD=2.62
* device instance $94 r0 *1 62.365,4.19 pfet
Xn94 py_g__t12 rn2__t2 sig_n1__t2 vddr2__t15 sky130_fd_pr__pfet_01v8 L=0.15 W=0.84 AS=0.3948 AD=0.3948 PS=2.62 PD=2.62
* device instance $95 r0 *1 68.21,3.74 pfet
Xn95 py__t05 vss__t19 vddr2__t10 vddr2__t6 sky130_fd_pr__pfet_01v8 L=2 W=0.44 AS=0.1848 AD=0.1848 PS=1.72 PD=1.72
* device instance $96 r0 *1 76.385,3.74 pfet
Xn96 py__t06 vss__t16 vddr2__t7 vddr2__t3 sky130_fd_pr__pfet_01v8 L=2 W=0.44 AS=0.1848 AD=0.1848 PS=1.72 PD=1.72
* device instance $97 r0 *1 84.56,3.74 pfet
Xn97 py__t07 vss__t17 vddr2__t8 vddr2__t4 sky130_fd_pr__pfet_01v8 L=2 W=0.44 AS=0.1848 AD=0.1848 PS=1.72 PD=1.72
* device instance $98 r0 *1 92.735,3.74 pfet
Xn98 py__t08 vss__t18 vddr2__t9 vddr2__t5 sky130_fd_pr__pfet_01v8 L=2 W=0.44 AS=0.1848 AD=0.1848 PS=1.72 PD=1.72
* device instance $99 r0 *1 116.375,4.19 pfet
Xn99 sig_n1__t03 en3__t0 py_g__t23 vddr3__t16 sky130_fd_pr__pfet_01v8 L=0.15 W=0.84 AS=0.3948 AD=0.3948 PS=2.62 PD=2.62
* device instance $100 r0 *1 117.665,4.19 pfet
Xn100 py_g__t13 rn3__t1 sig_n1__t23 vddr3__t13 sky130_fd_pr__pfet_01v8 L=0.15 W=0.84 AS=0.3948 AD=0.3948 PS=2.62 PD=2.62
* device instance $101 r0 *1 123.51,3.74 pfet
Xn101 py__t09 vss__t14 vddr3__t9 vddr3__t5 sky130_fd_pr__pfet_01v8 L=2 W=0.46 AS=0.1932 AD=0.1932 PS=1.76 PD=1.76
* device instance $102 r0 *1 131.685,3.74 pfet
Xn102 py__t010 vss__t15 vddr3__t10 vddr3__t6 sky130_fd_pr__pfet_01v8 L=2 W=0.46 AS=0.1932 AD=0.1932 PS=1.76 PD=1.76
* device instance $103 r0 *1 139.86,3.74 pfet
Xn103 py__t011 vss__t13 vddr3__t8 vddr3__t4 sky130_fd_pr__pfet_01v8 L=2 W=0.46 AS=0.1932 AD=0.1932 PS=1.76 PD=1.76
* device instance $104 r0 *1 148.035,3.74 pfet
Xn104 py__t012 vss__t12 vddr3__t7 vddr3__t3 sky130_fd_pr__pfet_01v8 L=2 W=0.46 AS=0.1932 AD=0.1932 PS=1.76 PD=1.76
* device instance $105 r0 *1 171.675,4.19 pfet
Xn105 sig_n1__t04 en4__t0 py_g__t24 vddr4__t12 sky130_fd_pr__pfet_01v8 L=0.15 W=0.84 AS=0.3948 AD=0.3948 PS=2.62 PD=2.62
* device instance $106 r0 *1 172.965,4.19 pfet
Xn106 py_g__t14 rn4__t2 sig_n1__t24 vddr4__t16 sky130_fd_pr__pfet_01v8 L=0.15 W=0.84 AS=0.3948 AD=0.3948 PS=2.62 PD=2.62
* device instance $107 r0 *1 178.81,3.74 pfet
Xn107 py__t013 vss__t11 vddr4__t10 vddr4__t6 sky130_fd_pr__pfet_01v8 L=2 W=0.48 AS=0.2016 AD=0.2016 PS=1.8 PD=1.8
* device instance $108 r0 *1 186.985,3.74 pfet
Xn108 py__t014 vss__t8 vddr4__t7 vddr4__t3 sky130_fd_pr__pfet_01v8 L=2 W=0.48 AS=0.2016 AD=0.2016 PS=1.8 PD=1.8
* device instance $109 r0 *1 195.16,3.74 pfet
Xn109 py__t015 vss__t9 vddr4__t8 vddr4__t4 sky130_fd_pr__pfet_01v8 L=2 W=0.48 AS=0.2016 AD=0.2016 PS=1.8 PD=1.8
* device instance $110 r0 *1 203.335,3.74 pfet
Xn110 py__t016 vss__t10 vddr4__t9 vddr4__t5 sky130_fd_pr__pfet_01v8 L=2 W=0.48 AS=0.2016 AD=0.2016 PS=1.8 PD=1.8
* device instance $111 r0 *1 3.61,4.19 pfet
Xn111 py_g__t0 vss__t4 vddr1__t1 vddr1__t2 sky130_fd_pr__pfet_01v8 L=2 W=0.42 AS=0.1764 AD=0.1764 PS=1.68 PD=1.68
* device instance $112 r0 *1 3.445,21.225 pfet
Xn112 xor_an__t1 ro1__t2 vdd__t26 vdd__t36 sky130_fd_pr__pfet_01v8 L=0.15 W=0.84 AS=0.3948 AD=0.3948 PS=2.62 PD=2.62
* device instance $113 r0 *1 7.43,25.585 pfet
Xn113 mid__t1 ro1__t0 vdd__t0 vdd__t1 sky130_fd_pr__pfet_01v8 L=0.15 W=1.68 AS=0.7896 AD=0.4368 PS=4.3 PD=2.2
* device instance $114 r0 *1 8.1,25.585 pfet
Xn114 t1__t0 xor_an__t0 mid__t0 vdd__t2 sky130_fd_pr__pfet_01v8 L=0.15 W=1.68 AS=0.4368 AD=0.7896 PS=2.2 PD=4.3
* device instance $115 r0 *1 14.58,25.585 pfet
Xn115 mid__t2 xor_bn__t02 t1__t1 vdd__t11 sky130_fd_pr__pfet_01v8 L=0.15 W=1.68 AS=0.7896 AD=0.4368 PS=4.3 PD=2.2
* device instance $116 r0 *1 15.25,25.585 pfet
Xn116 vdd__t3 ro2__t0 mid__t3 vdd__t6 sky130_fd_pr__pfet_01v8 L=0.15 W=1.68 AS=0.4368 AD=0.7896 PS=2.2 PD=4.3
* device instance $117 r0 *1 21.62,21.225 pfet
Xn117 xor_bn__t12 ro2__t2 vdd__t25 vdd__t35 sky130_fd_pr__pfet_01v8 L=0.15 W=0.84 AS=0.3948 AD=0.3948 PS=2.62 PD=2.62
* device instance $118 r0 *1 32.415,21.225 pfet
Xn118 xor_an__t12 ro3__t2 vdd__t24 vdd__t34 sky130_fd_pr__pfet_01v8 L=0.15 W=0.84 AS=0.3948 AD=0.3948 PS=2.62 PD=2.62
* device instance $119 r0 *1 36.4,25.585 pfet
Xn119 mid__t02 ro3__t0 vdd__t17 vdd__t14 sky130_fd_pr__pfet_01v8 L=0.15 W=1.68 AS=0.7896 AD=0.4368 PS=4.3 PD=2.2
* device instance $120 r0 *1 37.07,25.585 pfet
Xn120 t2__t0 xor_an__t02 mid__t22 vdd__t9 sky130_fd_pr__pfet_01v8 L=0.15 W=1.68 AS=0.4368 AD=0.7896 PS=2.2 PD=4.3
* device instance $121 r0 *1 43.55,25.585 pfet
Xn121 mid__t12 xor_bn__t03 t2__t2 vdd__t15 sky130_fd_pr__pfet_01v8 L=0.15 W=1.68 AS=0.7896 AD=0.4368 PS=4.3 PD=2.2
* device instance $122 r0 *1 44.22,25.585 pfet
Xn122 vdd__t5 ro4__t0 mid__t32 vdd__t10 sky130_fd_pr__pfet_01v8 L=0.15 W=1.68 AS=0.4368 AD=0.7896 PS=2.2 PD=4.3
* device instance $123 r0 *1 50.59,21.225 pfet
Xn123 xor_bn__t13 ro4__t2 vdd__t23 vdd__t33 sky130_fd_pr__pfet_01v8 L=0.15 W=0.84 AS=0.3948 AD=0.3948 PS=2.62 PD=2.62
* device instance $124 r0 *1 58.91,4.19 pfet
Xn124 py_g__t02 vss__t5 vddr2__t1 vddr2__t2 sky130_fd_pr__pfet_01v8 L=2 W=0.44 AS=0.1848 AD=0.1848 PS=1.72 PD=1.72
* device instance $125 r0 *1 61.385,21.225 pfet
Xn125 xor_an__t13 t1__t3 vdd__t22 vdd__t32 sky130_fd_pr__pfet_01v8 L=0.15 W=0.84 AS=0.3948 AD=0.3948 PS=2.62 PD=2.62
* device instance $126 r0 *1 65.37,25.585 pfet
Xn126 mid__t13 t1__t2 vdd__t16 vdd__t13 sky130_fd_pr__pfet_01v8 L=0.15 W=1.68 AS=0.7896 AD=0.4368 PS=4.3 PD=2.2
* device instance $127 r0 *1 66.04,25.585 pfet
Xn127 xo__t0 xor_an__t03 mid__t33 vdd__t8 sky130_fd_pr__pfet_01v8 L=0.15 W=1.68 AS=0.4368 AD=0.7896 PS=2.2 PD=4.3
* device instance $128 r0 *1 72.52,25.585 pfet
Xn128 mid__t03 xor_bn__t0 xo__t1 vdd__t12 sky130_fd_pr__pfet_01v8 L=0.15 W=1.68 AS=0.7896 AD=0.4368 PS=4.3 PD=2.2
* device instance $129 r0 *1 73.19,25.585 pfet
Xn129 vdd__t4 t2__t1 mid__t23 vdd__t7 sky130_fd_pr__pfet_01v8 L=0.15 W=1.68 AS=0.4368 AD=0.7896 PS=2.2 PD=4.3
* device instance $130 r0 *1 79.56,21.225 pfet
Xn130 xor_bn__t1 t2__t3 vdd__t21 vdd__t31 sky130_fd_pr__pfet_01v8 L=0.15 W=0.84 AS=0.3948 AD=0.3948 PS=2.62 PD=2.62
* device instance $131 r0 *1 114.21,4.19 pfet
Xn131 py_g__t03 vss__t6 vddr3__t1 vddr3__t2 sky130_fd_pr__pfet_01v8 L=2 W=0.46 AS=0.1932 AD=0.1932 PS=1.76 PD=1.76
* device instance $132 r0 *1 169.51,4.19 pfet
Xn132 py_g__t04 vss__t7 vddr4__t1 vddr4__t2 sky130_fd_pr__pfet_01v8 L=2 W=0.48 AS=0.2016 AD=0.2016 PS=1.8 PD=1.8
* device instance _11_t0 r0 *1 0,0
R_11_t0 n11__t0 n11 12.8
* device instance _11_t1 r0 *1 0,0
R_11_t1 n11__t1 n11 12.8
* device instance _11 r0 *1 0,0
C_11 n11 vsubs 1.15618e-16
* device instance _20_t0 r0 *1 0,0
R_20_t0 n20__t0 n20 12.8
* device instance _20_t1 r0 *1 0,0
R_20_t1 n20__t1 n20 12.8
* device instance _20 r0 *1 0,0
C_20 n20 vsubs 1.15618e-16
* device instance _29_t0 r0 *1 0,0
R_29_t0 n29__t0 n29 12.8
* device instance _29_t1 r0 *1 0,0
R_29_t1 n29__t1 n29 12.8
* device instance _29 r0 *1 0,0
C_29 n29 vsubs 1.15618e-16
* device instance _38_t0 r0 *1 0,0
R_38_t0 n38__t0 n38 12.8
* device instance _38_t1 r0 *1 0,0
R_38_t1 n38__t1 n38 12.8
* device instance _38 r0 *1 0,0
C_38 n38 vsubs 1.15618e-16
* device instance _80_t0 r0 *1 0,0
R_80_t0 n80__t0 n80 12.8
* device instance _80_t1 r0 *1 0,0
R_80_t1 n80__t1 n80 12.8
* device instance _80 r0 *1 0,0
C_80 n80 vsubs 1.15618e-16
* device instance _82_t0 r0 *1 0,0
R_82_t0 n82__t0 n82 12.8
* device instance _82_t1 r0 *1 0,0
R_82_t1 n82__t1 n82 12.8
* device instance _82 r0 *1 0,0
C_82 n82 vsubs 1.15618e-16
* device instance _83_t0 r0 *1 0,0
R_83_t0 n83__t0 n83 12.8
* device instance _83_t1 r0 *1 0,0
R_83_t1 n83__t1 n83 12.8
* device instance _83 r0 *1 0,0
C_83 n83 vsubs 1.15618e-16
* device instance _85_t0 r0 *1 0,0
R_85_t0 n85__t0 n85 12.8
* device instance _85_t1 r0 *1 0,0
R_85_t1 n85__t1 n85 12.8
* device instance _85 r0 *1 0,0
C_85 n85 vsubs 1.15618e-16
* device instance _87_t0 r0 *1 0,0
R_87_t0 n87__t0 n87 12.8
* device instance _87_t1 r0 *1 0,0
R_87_t1 n87__t1 n87 12.8
* device instance _87 r0 *1 0,0
C_87 n87 vsubs 1.15618e-16
* device instance _89_t0 r0 *1 0,0
R_89_t0 n89__t0 n89 12.8
* device instance _89_t1 r0 *1 0,0
R_89_t1 n89__t1 n89 12.8
* device instance _89 r0 *1 0,0
C_89 n89 vsubs 1.15618e-16
* device instance a_b_b3_invb_a_mn12_g1_mp24_g0_t2_y_t0 r0 *1 0,0
Ra_b_b3_invb_a_mn12_g1_mp24_g0_t2_y_t0 t2__t0 t2 409.635106767
* device instance a_b_b3_invb_a_mn12_g1_mp24_g0_t2_y_t1 r0 *1 0,0
Ra_b_b3_invb_a_mn12_g1_mp24_g0_t2_y_t1 t2__t1 t2 294.133620825
* device instance a_b_b3_invb_a_mn12_g1_mp24_g0_t2_y_t2 r0 *1 0,0
Ra_b_b3_invb_a_mn12_g1_mp24_g0_t2_y_t2 t2__t2 t2 293.51720502
* device instance a_b_b3_invb_a_mn12_g1_mp24_g0_t2_y_t3 r0 *1 0,0
Ra_b_b3_invb_a_mn12_g1_mp24_g0_t2_y_t3 t2__t3 t2 396.642557999
* device instance a_b_b3_invb_a_mn12_g1_mp24_g0_t2_y_t4 r0 *1 0,0
Ra_b_b3_invb_a_mn12_g1_mp24_g0_t2_y_t4 t2__t4 t2 398.872164213
* device instance a_b_b3_invb_a_mn12_g1_mp24_g0_t2_y_t5 r0 *1 0,0
Ra_b_b3_invb_a_mn12_g1_mp24_g0_t2_y_t5 t2__t5 t2 294.652537151
* device instance a_b_b3_invb_a_mn12_g1_mp24_g0_t2_y_t6 r0 *1 0,0
Ra_b_b3_invb_a_mn12_g1_mp24_g0_t2_y_t6 t2__t6 t2 413.294026601
* device instance a_b_b3_invb_a_mn12_g1_mp24_g0_t2_y_t7 r0 *1 0,0
Ra_b_b3_invb_a_mn12_g1_mp24_g0_t2_y_t7 t2__t7 t2 286.911181424
* device instance a_b_b3_invb_a_mn12_g1_mp24_g0_t2_y r0 *1 0,0
Ca_b_b3_invb_a_mn12_g1_mp24_g0_t2_y t2 vsubs 1.0148008e-14
* device instance a_b_invb_a_mn12_g1_mp24_g0_ro2_y_t0 r0 *1 0,0
Ra_b_invb_a_mn12_g1_mp24_g0_ro2_y_t0 ro2__t0 ro2 190.790466254
* device instance a_b_invb_a_mn12_g1_mp24_g0_ro2_y_t1 r0 *1 0,0
Ra_b_invb_a_mn12_g1_mp24_g0_ro2_y_t1 ro2__t1 ro2 327.435987958
* device instance a_b_invb_a_mn12_g1_mp24_g0_ro2_y_t2 r0 *1 0,0
Ra_b_invb_a_mn12_g1_mp24_g0_ro2_y_t2 ro2__t2 ro2 149.02035008
* device instance a_b_invb_a_mn12_g1_mp24_g0_ro2_y_t3 r0 *1 0,0
Ra_b_invb_a_mn12_g1_mp24_g0_ro2_y_t3 ro2__t3 ro2 331.325498978
* device instance a_b_invb_a_mn12_g1_mp24_g0_ro2_y_t4 r0 *1 0,0
Ra_b_invb_a_mn12_g1_mp24_g0_ro2_y_t4 ro2__t4 ro2 145.029667721
* device instance a_b_invb_a_mn12_g1_mp24_g0_ro2_y_t5 r0 *1 0,0
Ra_b_invb_a_mn12_g1_mp24_g0_ro2_y_t5 ro2__t5 ro2 178.36702901
* device instance a_b_invb_a_mn12_g1_mp24_g0_ro2_y r0 *1 0,0
Ca_b_invb_a_mn12_g1_mp24_g0_ro2_y ro2 vsubs 1.2032511e-14
* device instance a_b_invb_a_mn12_g1_mp24_g0_ro4_y_t0 r0 *1 0,0
Ra_b_invb_a_mn12_g1_mp24_g0_ro4_y_t0 ro4__t0 ro4 184.956516017
* device instance a_b_invb_a_mn12_g1_mp24_g0_ro4_y_t1 r0 *1 0,0
Ra_b_invb_a_mn12_g1_mp24_g0_ro4_y_t1 ro4__t1 ro4 344.598603152
* device instance a_b_invb_a_mn12_g1_mp24_g0_ro4_y_t2 r0 *1 0,0
Ra_b_invb_a_mn12_g1_mp24_g0_ro4_y_t2 ro4__t2 ro4 163.416356581
* device instance a_b_invb_a_mn12_g1_mp24_g0_ro4_y_t3 r0 *1 0,0
Ra_b_invb_a_mn12_g1_mp24_g0_ro4_y_t3 ro4__t3 ro4 345.703203735
* device instance a_b_invb_a_mn12_g1_mp24_g0_ro4_y_t4 r0 *1 0,0
Ra_b_invb_a_mn12_g1_mp24_g0_ro4_y_t4 ro4__t4 ro4 162.344366613
* device instance a_b_invb_a_mn12_g1_mp24_g0_ro4_y_t5 r0 *1 0,0
Ra_b_invb_a_mn12_g1_mp24_g0_ro4_y_t5 ro4__t5 ro4 180.945053902
* device instance a_b_invb_a_mn12_g1_mp24_g0_ro4_y r0 *1 0,0
Ca_b_invb_a_mn12_g1_mp24_g0_ro4_y ro4 vsubs 1.9009314e-14
* device instance a_g_a_rn1_ro_s4_y_y_t0 r0 *1 0,0
Ra_g_a_rn1_ro_s4_y_y_t0 rn1__t0 rn1 345.096279942
* device instance a_g_a_rn1_ro_s4_y_y_t1 r0 *1 0,0
Ra_g_a_rn1_ro_s4_y_y_t1 rn1__t1 rn1 108.856657591
* device instance a_g_a_rn1_ro_s4_y_y_t2 r0 *1 0,0
Ra_g_a_rn1_ro_s4_y_y_t2 rn1__t2 rn1 234.695939179
* device instance a_g_a_rn1_ro_s4_y_y_t3 r0 *1 0,0
Ra_g_a_rn1_ro_s4_y_y_t3 rn1__t3 rn1 343.168292152
* device instance a_g_a_rn1_ro_s4_y_y_t4 r0 *1 0,0
Ra_g_a_rn1_ro_s4_y_y_t4 rn1__t4 rn1 115.011240917
* device instance a_g_a_rn1_ro_s4_y_y_t5 r0 *1 0,0
Ra_g_a_rn1_ro_s4_y_y_t5 rn1__t5 rn1 235.084690218
* device instance a_g_a_rn1_ro_s4_y_y r0 *1 0,0
Ca_g_a_rn1_ro_s4_y_y rn1 vsubs 6.563292e-15
* device instance a_g_a_rn2_ro_s4_y_y_t0 r0 *1 0,0
Ra_g_a_rn2_ro_s4_y_y_t0 rn2__t0 rn2 108.856657591
* device instance a_g_a_rn2_ro_s4_y_y_t1 r0 *1 0,0
Ra_g_a_rn2_ro_s4_y_y_t1 rn2__t1 rn2 234.695939179
* device instance a_g_a_rn2_ro_s4_y_y_t2 r0 *1 0,0
Ra_g_a_rn2_ro_s4_y_y_t2 rn2__t2 rn2 343.168292152
* device instance a_g_a_rn2_ro_s4_y_y_t3 r0 *1 0,0
Ra_g_a_rn2_ro_s4_y_y_t3 rn2__t3 rn2 115.011240917
* device instance a_g_a_rn2_ro_s4_y_y_t4 r0 *1 0,0
Ra_g_a_rn2_ro_s4_y_y_t4 rn2__t4 rn2 235.084690218
* device instance a_g_a_rn2_ro_s4_y_y_t5 r0 *1 0,0
Ra_g_a_rn2_ro_s4_y_y_t5 rn2__t5 rn2 345.096279942
* device instance a_g_a_rn2_ro_s4_y_y r0 *1 0,0
Ca_g_a_rn2_ro_s4_y_y rn2 vsubs 6.563292e-15
* device instance a_g_a_rn3_ro_s4_y_y_t0 r0 *1 0,0
Ra_g_a_rn3_ro_s4_y_y_t0 rn3__t0 rn3 108.856657591
* device instance a_g_a_rn3_ro_s4_y_y_t1 r0 *1 0,0
Ra_g_a_rn3_ro_s4_y_y_t1 rn3__t1 rn3 343.168292152
* device instance a_g_a_rn3_ro_s4_y_y_t2 r0 *1 0,0
Ra_g_a_rn3_ro_s4_y_y_t2 rn3__t2 rn3 234.695939179
* device instance a_g_a_rn3_ro_s4_y_y_t3 r0 *1 0,0
Ra_g_a_rn3_ro_s4_y_y_t3 rn3__t3 rn3 115.011240917
* device instance a_g_a_rn3_ro_s4_y_y_t4 r0 *1 0,0
Ra_g_a_rn3_ro_s4_y_y_t4 rn3__t4 rn3 235.084690218
* device instance a_g_a_rn3_ro_s4_y_y_t5 r0 *1 0,0
Ra_g_a_rn3_ro_s4_y_y_t5 rn3__t5 rn3 345.096279942
* device instance a_g_a_rn3_ro_s4_y_y r0 *1 0,0
Ca_g_a_rn3_ro_s4_y_y rn3 vsubs 6.563292e-15
* device instance a_g_a_rn4_ro_s4_y_y_t0 r0 *1 0,0
Ra_g_a_rn4_ro_s4_y_y_t0 rn4__t0 rn4 108.856657591
* device instance a_g_a_rn4_ro_s4_y_y_t1 r0 *1 0,0
Ra_g_a_rn4_ro_s4_y_y_t1 rn4__t1 rn4 234.695939179
* device instance a_g_a_rn4_ro_s4_y_y_t2 r0 *1 0,0
Ra_g_a_rn4_ro_s4_y_y_t2 rn4__t2 rn4 343.168292152
* device instance a_g_a_rn4_ro_s4_y_y_t3 r0 *1 0,0
Ra_g_a_rn4_ro_s4_y_y_t3 rn4__t3 rn4 115.011240917
* device instance a_g_a_rn4_ro_s4_y_y_t4 r0 *1 0,0
Ra_g_a_rn4_ro_s4_y_y_t4 rn4__t4 rn4 235.084690218
* device instance a_g_a_rn4_ro_s4_y_y_t5 r0 *1 0,0
Ra_g_a_rn4_ro_s4_y_y_t5 rn4__t5 rn4 345.096279942
* device instance a_g_a_rn4_ro_s4_y_y r0 *1 0,0
Ca_g_a_rn4_ro_s4_y_y rn4 vsubs 6.557974e-15
* device instance a_g_y_mnab_y_mpa_y_mpb_y_n1_s1_a_y_t0 r0 *1 0,0
Ra_g_y_mnab_y_mpa_y_mpb_y_n1_s1_a_y_t0 sig_n1__t0 sig_n1 118.690159634
* device instance a_g_y_mnab_y_mpa_y_mpb_y_n1_s1_a_y_t1 r0 *1 0,0
Ra_g_y_mnab_y_mpa_y_mpb_y_n1_s1_a_y_t1 sig_n1__t1 sig_n1 132.890468841
* device instance a_g_y_mnab_y_mpa_y_mpb_y_n1_s1_a_y_t2 r0 *1 0,0
Ra_g_y_mnab_y_mpa_y_mpb_y_n1_s1_a_y_t2 sig_n1__t2 sig_n1 88.589660111
* device instance a_g_y_mnab_y_mpa_y_mpb_y_n1_s1_a_y_t3 r0 *1 0,0
Ra_g_y_mnab_y_mpa_y_mpb_y_n1_s1_a_y_t3 sig_n1__t3 sig_n1 152.348139631
* device instance a_g_y_mnab_y_mpa_y_mpb_y_n1_s1_a_y_t4 r0 *1 0,0
Ra_g_y_mnab_y_mpa_y_mpb_y_n1_s1_a_y_t4 sig_n1__t4 sig_n1 100.849471782
* device instance a_g_y_mnab_y_mpa_y_mpb_y_n1_s1_a_y r0 *1 0,0
Ca_g_y_mnab_y_mpa_y_mpb_y_n1_s1_a_y sig_n1 vsubs 2.784627e-15
* device instance a_g_y_mnab_y_mpa_y_mpb_y_n1_s1_a_y_dup1_t0 r0 *1 0,0
Ra_g_y_mnab_y_mpa_y_mpb_y_n1_s1_a_y_dup1_t0 sig_n1__t02 sig_n1n1 100.849471782
* device instance a_g_y_mnab_y_mpa_y_mpb_y_n1_s1_a_y_dup1_t1 r0 *1 0,0
Ra_g_y_mnab_y_mpa_y_mpb_y_n1_s1_a_y_dup1_t1 sig_n1__t12 sig_n1n1 152.348139631
* device instance a_g_y_mnab_y_mpa_y_mpb_y_n1_s1_a_y_dup1_t2 r0 *1 0,0
Ra_g_y_mnab_y_mpa_y_mpb_y_n1_s1_a_y_dup1_t2 sig_n1__t22 sig_n1n1 118.690159634
* device instance a_g_y_mnab_y_mpa_y_mpb_y_n1_s1_a_y_dup1_t3 r0 *1 0,0
Ra_g_y_mnab_y_mpa_y_mpb_y_n1_s1_a_y_dup1_t3 sig_n1__t32 sig_n1n1 132.890468841
* device instance a_g_y_mnab_y_mpa_y_mpb_y_n1_s1_a_y_dup1_t4 r0 *1 0,0
Ra_g_y_mnab_y_mpa_y_mpb_y_n1_s1_a_y_dup1_t4 sig_n1__t42 sig_n1n1 88.589660111
* device instance a_g_y_mnab_y_mpa_y_mpb_y_n1_s1_a_y_dup1 r0 *1 0,0
Ca_g_y_mnab_y_mpa_y_mpb_y_n1_s1_a_y_dup1 sig_n1n1 vsubs 2.784627e-15
* device instance a_g_y_mnab_y_mpa_y_mpb_y_n1_s1_a_y_dup2_t0 r0 *1 0,0
Ra_g_y_mnab_y_mpa_y_mpb_y_n1_s1_a_y_dup2_t0 sig_n1__t03 sig_n1n2 118.690159634
* device instance a_g_y_mnab_y_mpa_y_mpb_y_n1_s1_a_y_dup2_t1 r0 *1 0,0
Ra_g_y_mnab_y_mpa_y_mpb_y_n1_s1_a_y_dup2_t1 sig_n1__t13 sig_n1n2 132.890468841
* device instance a_g_y_mnab_y_mpa_y_mpb_y_n1_s1_a_y_dup2_t2 r0 *1 0,0
Ra_g_y_mnab_y_mpa_y_mpb_y_n1_s1_a_y_dup2_t2 sig_n1__t23 sig_n1n2 88.589660111
* device instance a_g_y_mnab_y_mpa_y_mpb_y_n1_s1_a_y_dup2_t3 r0 *1 0,0
Ra_g_y_mnab_y_mpa_y_mpb_y_n1_s1_a_y_dup2_t3 sig_n1__t33 sig_n1n2 152.348139631
* device instance a_g_y_mnab_y_mpa_y_mpb_y_n1_s1_a_y_dup2_t4 r0 *1 0,0
Ra_g_y_mnab_y_mpa_y_mpb_y_n1_s1_a_y_dup2_t4 sig_n1__t43 sig_n1n2 100.849471782
* device instance a_g_y_mnab_y_mpa_y_mpb_y_n1_s1_a_y_dup2 r0 *1 0,0
Ca_g_y_mnab_y_mpa_y_mpb_y_n1_s1_a_y_dup2 sig_n1n2 vsubs 2.784627e-15
* device instance a_g_y_mnab_y_mpa_y_mpb_y_n1_s1_a_y_dup3_t0 r0 *1 0,0
Ra_g_y_mnab_y_mpa_y_mpb_y_n1_s1_a_y_dup3_t0 sig_n1__t04 sig_n1n3 118.690159634
* device instance a_g_y_mnab_y_mpa_y_mpb_y_n1_s1_a_y_dup3_t1 r0 *1 0,0
Ra_g_y_mnab_y_mpa_y_mpb_y_n1_s1_a_y_dup3_t1 sig_n1__t14 sig_n1n3 132.890468841
* device instance a_g_y_mnab_y_mpa_y_mpb_y_n1_s1_a_y_dup3_t2 r0 *1 0,0
Ra_g_y_mnab_y_mpa_y_mpb_y_n1_s1_a_y_dup3_t2 sig_n1__t24 sig_n1n3 88.589660111
* device instance a_g_y_mnab_y_mpa_y_mpb_y_n1_s1_a_y_dup3_t3 r0 *1 0,0
Ra_g_y_mnab_y_mpa_y_mpb_y_n1_s1_a_y_dup3_t3 sig_n1__t34 sig_n1n3 152.348139631
* device instance a_g_y_mnab_y_mpa_y_mpb_y_n1_s1_a_y_dup3_t4 r0 *1 0,0
Ra_g_y_mnab_y_mpa_y_mpb_y_n1_s1_a_y_dup3_t4 sig_n1__t44 sig_n1n3 100.849471782
* device instance a_g_y_mnab_y_mpa_y_mpb_y_n1_s1_a_y_dup3 r0 *1 0,0
Ca_g_y_mnab_y_mpa_y_mpb_y_n1_s1_a_y_dup3 sig_n1n3 vsubs 2.784627e-15
* device instance a_inva_a_mn12_g0_mp13_g0_ro1_y_t0 r0 *1 0,0
Ra_inva_a_mn12_g0_mp13_g0_ro1_y_t0 ro1__t0 ro1 193.192387039
* device instance a_inva_a_mn12_g0_mp13_g0_ro1_y_t1 r0 *1 0,0
Ra_inva_a_mn12_g0_mp13_g0_ro1_y_t1 ro1__t1 ro1 319.110574763
* device instance a_inva_a_mn12_g0_mp13_g0_ro1_y_t2 r0 *1 0,0
Ra_inva_a_mn12_g0_mp13_g0_ro1_y_t2 ro1__t2 ro1 205.73799354
* device instance a_inva_a_mn12_g0_mp13_g0_ro1_y_t3 r0 *1 0,0
Ra_inva_a_mn12_g0_mp13_g0_ro1_y_t3 ro1__t3 ro1 333.428460148
* device instance a_inva_a_mn12_g0_mp13_g0_ro1_y_t4 r0 *1 0,0
Ra_inva_a_mn12_g0_mp13_g0_ro1_y_t4 ro1__t4 ro1 195.06213806
* device instance a_inva_a_mn12_g0_mp13_g0_ro1_y_t5 r0 *1 0,0
Ra_inva_a_mn12_g0_mp13_g0_ro1_y_t5 ro1__t5 ro1 70.5227464495
* device instance a_inva_a_mn12_g0_mp13_g0_ro1_y r0 *1 0,0
Ca_inva_a_mn12_g0_mp13_g0_ro1_y ro1 vsubs 1.1462041e-14
* device instance a_inva_a_mn12_g0_mp13_g0_ro3_y_t0 r0 *1 0,0
Ra_inva_a_mn12_g0_mp13_g0_ro3_y_t0 ro3__t0 ro3 175.965747303
* device instance a_inva_a_mn12_g0_mp13_g0_ro3_y_t1 r0 *1 0,0
Ra_inva_a_mn12_g0_mp13_g0_ro3_y_t1 ro3__t1 ro3 342.670975174
* device instance a_inva_a_mn12_g0_mp13_g0_ro3_y_t2 r0 *1 0,0
Ra_inva_a_mn12_g0_mp13_g0_ro3_y_t2 ro3__t2 ro3 188.193283758
* device instance a_inva_a_mn12_g0_mp13_g0_ro3_y_t3 r0 *1 0,0
Ra_inva_a_mn12_g0_mp13_g0_ro3_y_t3 ro3__t3 ro3 344.678643992
* device instance a_inva_a_mn12_g0_mp13_g0_ro3_y_t4 r0 *1 0,0
Ra_inva_a_mn12_g0_mp13_g0_ro3_y_t4 ro3__t4 ro3 186.506608924
* device instance a_inva_a_mn12_g0_mp13_g0_ro3_y_t5 r0 *1 0,0
Ra_inva_a_mn12_g0_mp13_g0_ro3_y_t5 ro3__t5 ro3 139.055740848
* device instance a_inva_a_mn12_g0_mp13_g0_ro3_y r0 *1 0,0
Ca_inva_a_mn12_g0_mp13_g0_ro3_y ro3 vsubs 1.8443251e-14
* device instance a_inva_a_mn12_g0_mp13_g0_t1_y_t0 r0 *1 0,0
Ra_inva_a_mn12_g0_mp13_g0_t1_y_t0 t1__t0 t1 393.96501156
* device instance a_inva_a_mn12_g0_mp13_g0_t1_y_t1 r0 *1 0,0
Ra_inva_a_mn12_g0_mp13_g0_t1_y_t1 t1__t1 t1 312.148663125
* device instance a_inva_a_mn12_g0_mp13_g0_t1_y_t2 r0 *1 0,0
Ra_inva_a_mn12_g0_mp13_g0_t1_y_t2 t1__t2 t1 355.301959278
* device instance a_inva_a_mn12_g0_mp13_g0_t1_y_t3 r0 *1 0,0
Ra_inva_a_mn12_g0_mp13_g0_t1_y_t3 t1__t3 t1 297.753615342
* device instance a_inva_a_mn12_g0_mp13_g0_t1_y_t4 r0 *1 0,0
Ra_inva_a_mn12_g0_mp13_g0_t1_y_t4 t1__t4 t1 299.162613598
* device instance a_inva_a_mn12_g0_mp13_g0_t1_y_t5 r0 *1 0,0
Ra_inva_a_mn12_g0_mp13_g0_t1_y_t5 t1__t5 t1 447.569121132
* device instance a_inva_a_mn12_g0_mp13_g0_t1_y_t6 r0 *1 0,0
Ra_inva_a_mn12_g0_mp13_g0_t1_y_t6 t1__t6 t1 308.270155599
* device instance a_inva_a_mn12_g0_mp13_g0_t1_y_t7 r0 *1 0,0
Ra_inva_a_mn12_g0_mp13_g0_t1_y_t7 t1__t7 t1 396.959960366
* device instance a_inva_a_mn12_g0_mp13_g0_t1_y r0 *1 0,0
Ca_inva_a_mn12_g0_mp13_g0_t1_y t1 vsubs 1.3120776e-14
* device instance a_n2_s1_y_s2_a_y_t0 r0 *1 0,0
Ra_n2_s1_y_s2_a_y_t0 sig_n2__t0 sig_n2 216.012838579
* device instance a_n2_s1_y_s2_a_y_t1 r0 *1 0,0
Ra_n2_s1_y_s2_a_y_t1 sig_n2__t1 sig_n2 236.534411421
* device instance a_n2_s1_y_s2_a_y_t2 r0 *1 0,0
Ra_n2_s1_y_s2_a_y_t2 sig_n2__t2 sig_n2 216.012838579
* device instance a_n2_s1_y_s2_a_y_t3 r0 *1 0,0
Ra_n2_s1_y_s2_a_y_t3 sig_n2__t3 sig_n2 236.534411421
* device instance a_n2_s1_y_s2_a_y r0 *1 0,0
Ca_n2_s1_y_s2_a_y sig_n2 vsubs 2.620771e-15
* device instance a_n2_s1_y_s2_a_y_dup1_t0 r0 *1 0,0
Ra_n2_s1_y_s2_a_y_dup1_t0 sig_n2__t02 sig_n2n1 236.534411421
* device instance a_n2_s1_y_s2_a_y_dup1_t1 r0 *1 0,0
Ra_n2_s1_y_s2_a_y_dup1_t1 sig_n2__t12 sig_n2n1 216.012838579
* device instance a_n2_s1_y_s2_a_y_dup1_t2 r0 *1 0,0
Ra_n2_s1_y_s2_a_y_dup1_t2 sig_n2__t22 sig_n2n1 216.012838579
* device instance a_n2_s1_y_s2_a_y_dup1_t3 r0 *1 0,0
Ra_n2_s1_y_s2_a_y_dup1_t3 sig_n2__t32 sig_n2n1 236.534411421
* device instance a_n2_s1_y_s2_a_y_dup1 r0 *1 0,0
Ca_n2_s1_y_s2_a_y_dup1 sig_n2n1 vsubs 2.620771e-15
* device instance a_n2_s1_y_s2_a_y_dup2_t0 r0 *1 0,0
Ra_n2_s1_y_s2_a_y_dup2_t0 sig_n2__t03 sig_n2n2 236.534411421
* device instance a_n2_s1_y_s2_a_y_dup2_t1 r0 *1 0,0
Ra_n2_s1_y_s2_a_y_dup2_t1 sig_n2__t13 sig_n2n2 216.012838579
* device instance a_n2_s1_y_s2_a_y_dup2_t2 r0 *1 0,0
Ra_n2_s1_y_s2_a_y_dup2_t2 sig_n2__t23 sig_n2n2 216.012838579
* device instance a_n2_s1_y_s2_a_y_dup2_t3 r0 *1 0,0
Ra_n2_s1_y_s2_a_y_dup2_t3 sig_n2__t33 sig_n2n2 236.534411421
* device instance a_n2_s1_y_s2_a_y_dup2 r0 *1 0,0
Ca_n2_s1_y_s2_a_y_dup2 sig_n2n2 vsubs 2.620771e-15
* device instance a_n2_s1_y_s2_a_y_dup3_t0 r0 *1 0,0
Ra_n2_s1_y_s2_a_y_dup3_t0 sig_n2__t04 sig_n2n3 236.534411421
* device instance a_n2_s1_y_s2_a_y_dup3_t1 r0 *1 0,0
Ra_n2_s1_y_s2_a_y_dup3_t1 sig_n2__t14 sig_n2n3 216.012838579
* device instance a_n2_s1_y_s2_a_y_dup3_t2 r0 *1 0,0
Ra_n2_s1_y_s2_a_y_dup3_t2 sig_n2__t24 sig_n2n3 216.012838579
* device instance a_n2_s1_y_s2_a_y_dup3_t3 r0 *1 0,0
Ra_n2_s1_y_s2_a_y_dup3_t3 sig_n2__t34 sig_n2n3 236.534411421
* device instance a_n2_s1_y_s2_a_y_dup3 r0 *1 0,0
Ca_n2_s1_y_s2_a_y_dup3 sig_n2n3 vsubs 2.620771e-15
* device instance a_n3_s2_y_s3_a_y_t0 r0 *1 0,0
Ra_n3_s2_y_s3_a_y_t0 sig_n3__t0 sig_n3 236.534411421
* device instance a_n3_s2_y_s3_a_y_t1 r0 *1 0,0
Ra_n3_s2_y_s3_a_y_t1 sig_n3__t1 sig_n3 216.012838579
* device instance a_n3_s2_y_s3_a_y_t2 r0 *1 0,0
Ra_n3_s2_y_s3_a_y_t2 sig_n3__t2 sig_n3 216.012838579
* device instance a_n3_s2_y_s3_a_y_t3 r0 *1 0,0
Ra_n3_s2_y_s3_a_y_t3 sig_n3__t3 sig_n3 236.534411421
* device instance a_n3_s2_y_s3_a_y r0 *1 0,0
Ca_n3_s2_y_s3_a_y sig_n3 vsubs 2.620771e-15
* device instance a_n3_s2_y_s3_a_y_dup1_t0 r0 *1 0,0
Ra_n3_s2_y_s3_a_y_dup1_t0 sig_n3__t02 sig_n3n1 236.534411421
* device instance a_n3_s2_y_s3_a_y_dup1_t1 r0 *1 0,0
Ra_n3_s2_y_s3_a_y_dup1_t1 sig_n3__t12 sig_n3n1 216.012838579
* device instance a_n3_s2_y_s3_a_y_dup1_t2 r0 *1 0,0
Ra_n3_s2_y_s3_a_y_dup1_t2 sig_n3__t22 sig_n3n1 216.012838579
* device instance a_n3_s2_y_s3_a_y_dup1_t3 r0 *1 0,0
Ra_n3_s2_y_s3_a_y_dup1_t3 sig_n3__t32 sig_n3n1 236.534411421
* device instance a_n3_s2_y_s3_a_y_dup1 r0 *1 0,0
Ca_n3_s2_y_s3_a_y_dup1 sig_n3n1 vsubs 2.620771e-15
* device instance a_n3_s2_y_s3_a_y_dup2_t0 r0 *1 0,0
Ra_n3_s2_y_s3_a_y_dup2_t0 sig_n3__t03 sig_n3n2 236.534411421
* device instance a_n3_s2_y_s3_a_y_dup2_t1 r0 *1 0,0
Ra_n3_s2_y_s3_a_y_dup2_t1 sig_n3__t13 sig_n3n2 216.012838579
* device instance a_n3_s2_y_s3_a_y_dup2_t2 r0 *1 0,0
Ra_n3_s2_y_s3_a_y_dup2_t2 sig_n3__t23 sig_n3n2 216.012838579
* device instance a_n3_s2_y_s3_a_y_dup2_t3 r0 *1 0,0
Ra_n3_s2_y_s3_a_y_dup2_t3 sig_n3__t33 sig_n3n2 236.534411421
* device instance a_n3_s2_y_s3_a_y_dup2 r0 *1 0,0
Ca_n3_s2_y_s3_a_y_dup2 sig_n3n2 vsubs 2.620771e-15
* device instance a_n3_s2_y_s3_a_y_dup3_t0 r0 *1 0,0
Ra_n3_s2_y_s3_a_y_dup3_t0 sig_n3__t04 sig_n3n3 236.534411421
* device instance a_n3_s2_y_s3_a_y_dup3_t1 r0 *1 0,0
Ra_n3_s2_y_s3_a_y_dup3_t1 sig_n3__t14 sig_n3n3 216.012838579
* device instance a_n3_s2_y_s3_a_y_dup3_t2 r0 *1 0,0
Ra_n3_s2_y_s3_a_y_dup3_t2 sig_n3__t24 sig_n3n3 216.012838579
* device instance a_n3_s2_y_s3_a_y_dup3_t3 r0 *1 0,0
Ra_n3_s2_y_s3_a_y_dup3_t3 sig_n3__t34 sig_n3n3 236.534411421
* device instance a_n3_s2_y_s3_a_y_dup3 r0 *1 0,0
Ca_n3_s2_y_s3_a_y_dup3 sig_n3n3 vsubs 2.620771e-15
* device instance a_n4_s3_y_s4_a_y_t0 r0 *1 0,0
Ra_n4_s3_y_s4_a_y_t0 sig_n4__t0 sig_n4 236.534411421
* device instance a_n4_s3_y_s4_a_y_t1 r0 *1 0,0
Ra_n4_s3_y_s4_a_y_t1 sig_n4__t1 sig_n4 216.012838579
* device instance a_n4_s3_y_s4_a_y_t2 r0 *1 0,0
Ra_n4_s3_y_s4_a_y_t2 sig_n4__t2 sig_n4 216.012838579
* device instance a_n4_s3_y_s4_a_y_t3 r0 *1 0,0
Ra_n4_s3_y_s4_a_y_t3 sig_n4__t3 sig_n4 236.534411421
* device instance a_n4_s3_y_s4_a_y r0 *1 0,0
Ca_n4_s3_y_s4_a_y sig_n4 vsubs 2.620771e-15
* device instance a_n4_s3_y_s4_a_y_dup1_t0 r0 *1 0,0
Ra_n4_s3_y_s4_a_y_dup1_t0 sig_n4__t02 sig_n4n1 236.534411421
* device instance a_n4_s3_y_s4_a_y_dup1_t1 r0 *1 0,0
Ra_n4_s3_y_s4_a_y_dup1_t1 sig_n4__t12 sig_n4n1 216.012838579
* device instance a_n4_s3_y_s4_a_y_dup1_t2 r0 *1 0,0
Ra_n4_s3_y_s4_a_y_dup1_t2 sig_n4__t22 sig_n4n1 216.012838579
* device instance a_n4_s3_y_s4_a_y_dup1_t3 r0 *1 0,0
Ra_n4_s3_y_s4_a_y_dup1_t3 sig_n4__t32 sig_n4n1 236.534411421
* device instance a_n4_s3_y_s4_a_y_dup1 r0 *1 0,0
Ca_n4_s3_y_s4_a_y_dup1 sig_n4n1 vsubs 2.620771e-15
* device instance a_n4_s3_y_s4_a_y_dup2_t0 r0 *1 0,0
Ra_n4_s3_y_s4_a_y_dup2_t0 sig_n4__t03 sig_n4n2 236.534411421
* device instance a_n4_s3_y_s4_a_y_dup2_t1 r0 *1 0,0
Ra_n4_s3_y_s4_a_y_dup2_t1 sig_n4__t13 sig_n4n2 216.012838579
* device instance a_n4_s3_y_s4_a_y_dup2_t2 r0 *1 0,0
Ra_n4_s3_y_s4_a_y_dup2_t2 sig_n4__t23 sig_n4n2 216.012838579
* device instance a_n4_s3_y_s4_a_y_dup2_t3 r0 *1 0,0
Ra_n4_s3_y_s4_a_y_dup2_t3 sig_n4__t33 sig_n4n2 236.534411421
* device instance a_n4_s3_y_s4_a_y_dup2 r0 *1 0,0
Ca_n4_s3_y_s4_a_y_dup2 sig_n4n2 vsubs 2.620771e-15
* device instance a_n4_s3_y_s4_a_y_dup3_t0 r0 *1 0,0
Ra_n4_s3_y_s4_a_y_dup3_t0 sig_n4__t04 sig_n4n3 236.534411421
* device instance a_n4_s3_y_s4_a_y_dup3_t1 r0 *1 0,0
Ra_n4_s3_y_s4_a_y_dup3_t1 sig_n4__t14 sig_n4n3 216.012838579
* device instance a_n4_s3_y_s4_a_y_dup3_t2 r0 *1 0,0
Ra_n4_s3_y_s4_a_y_dup3_t2 sig_n4__t24 sig_n4n3 216.012838579
* device instance a_n4_s3_y_s4_a_y_dup3_t3 r0 *1 0,0
Ra_n4_s3_y_s4_a_y_dup3_t3 sig_n4__t34 sig_n4n3 236.534411421
* device instance a_n4_s3_y_s4_a_y_dup3 r0 *1 0,0
Ca_n4_s3_y_s4_a_y_dup3 sig_n4n3 vsubs 2.620771e-15
* device instance an_inva_y_mn34_g0_mp13_g1_y_t0 r0 *1 0,0
Ran_inva_y_mn34_g0_mp13_g1_y_t0 xor_an__t0 xor_an 286.425880004
* device instance an_inva_y_mn34_g0_mp13_g1_y_t1 r0 *1 0,0
Ran_inva_y_mn34_g0_mp13_g1_y_t1 xor_an__t1 xor_an 120.259350571
* device instance an_inva_y_mn34_g0_mp13_g1_y_t2 r0 *1 0,0
Ran_inva_y_mn34_g0_mp13_g1_y_t2 xor_an__t2 xor_an 148.815961258
* device instance an_inva_y_mn34_g0_mp13_g1_y_t3 r0 *1 0,0
Ran_inva_y_mn34_g0_mp13_g1_y_t3 xor_an__t3 xor_an 235.863908166
* device instance an_inva_y_mn34_g0_mp13_g1_y r0 *1 0,0
Can_inva_y_mn34_g0_mp13_g1_y xor_an vsubs 2.26736e-15
* device instance an_inva_y_mn34_g0_mp13_g1_y_dup1_t0 r0 *1 0,0
Ran_inva_y_mn34_g0_mp13_g1_y_dup1_t0 xor_an__t02 xor_ann1 286.425880004
* device instance an_inva_y_mn34_g0_mp13_g1_y_dup1_t1 r0 *1 0,0
Ran_inva_y_mn34_g0_mp13_g1_y_dup1_t1 xor_an__t12 xor_ann1 120.259350571
* device instance an_inva_y_mn34_g0_mp13_g1_y_dup1_t2 r0 *1 0,0
Ran_inva_y_mn34_g0_mp13_g1_y_dup1_t2 xor_an__t22 xor_ann1 148.815961258
* device instance an_inva_y_mn34_g0_mp13_g1_y_dup1_t3 r0 *1 0,0
Ran_inva_y_mn34_g0_mp13_g1_y_dup1_t3 xor_an__t32 xor_ann1 235.863908166
* device instance an_inva_y_mn34_g0_mp13_g1_y_dup1 r0 *1 0,0
Can_inva_y_mn34_g0_mp13_g1_y_dup1 xor_ann1 vsubs 2.26736e-15
* device instance an_inva_y_mn34_g0_mp13_g1_y_dup2_t0 r0 *1 0,0
Ran_inva_y_mn34_g0_mp13_g1_y_dup2_t0 xor_an__t03 xor_ann2 286.425880004
* device instance an_inva_y_mn34_g0_mp13_g1_y_dup2_t1 r0 *1 0,0
Ran_inva_y_mn34_g0_mp13_g1_y_dup2_t1 xor_an__t13 xor_ann2 120.259350571
* device instance an_inva_y_mn34_g0_mp13_g1_y_dup2_t2 r0 *1 0,0
Ran_inva_y_mn34_g0_mp13_g1_y_dup2_t2 xor_an__t23 xor_ann2 148.815961258
* device instance an_inva_y_mn34_g0_mp13_g1_y_dup2_t3 r0 *1 0,0
Ran_inva_y_mn34_g0_mp13_g1_y_dup2_t3 xor_an__t33 xor_ann2 235.863908166
* device instance an_inva_y_mn34_g0_mp13_g1_y_dup2 r0 *1 0,0
Can_inva_y_mn34_g0_mp13_g1_y_dup2 xor_ann2 vsubs 2.26736e-15
* device instance bn_invb_y_mn34_g1_mp24_g1_y_t0 r0 *1 0,0
Rbn_invb_y_mn34_g1_mp24_g1_y_t0 xor_bn__t0 xor_bn 185.302815577
* device instance bn_invb_y_mn34_g1_mp24_g1_y_t1 r0 *1 0,0
Rbn_invb_y_mn34_g1_mp24_g1_y_t1 xor_bn__t1 xor_bn 163.924646135
* device instance bn_invb_y_mn34_g1_mp24_g1_y_t2 r0 *1 0,0
Rbn_invb_y_mn34_g1_mp24_g1_y_t2 xor_bn__t2 xor_bn 173.955001003
* device instance bn_invb_y_mn34_g1_mp24_g1_y_t3 r0 *1 0,0
Rbn_invb_y_mn34_g1_mp24_g1_y_t3 xor_bn__t3 xor_bn 293.464337285
* device instance bn_invb_y_mn34_g1_mp24_g1_y r0 *1 0,0
Cbn_invb_y_mn34_g1_mp24_g1_y xor_bn vsubs 5.210018e-15
* device instance bn_invb_y_mn34_g1_mp24_g1_y_dup1_t0 r0 *1 0,0
Rbn_invb_y_mn34_g1_mp24_g1_y_dup1_t0 xor_bn__t02 xor_bnn1 185.302815577
* device instance bn_invb_y_mn34_g1_mp24_g1_y_dup1_t1 r0 *1 0,0
Rbn_invb_y_mn34_g1_mp24_g1_y_dup1_t1 xor_bn__t12 xor_bnn1 163.924646135
* device instance bn_invb_y_mn34_g1_mp24_g1_y_dup1_t2 r0 *1 0,0
Rbn_invb_y_mn34_g1_mp24_g1_y_dup1_t2 xor_bn__t22 xor_bnn1 173.955001003
* device instance bn_invb_y_mn34_g1_mp24_g1_y_dup1_t3 r0 *1 0,0
Rbn_invb_y_mn34_g1_mp24_g1_y_dup1_t3 xor_bn__t32 xor_bnn1 293.464337285
* device instance bn_invb_y_mn34_g1_mp24_g1_y_dup1 r0 *1 0,0
Cbn_invb_y_mn34_g1_mp24_g1_y_dup1 xor_bnn1 vsubs 5.210763e-15
* device instance bn_invb_y_mn34_g1_mp24_g1_y_dup2_t0 r0 *1 0,0
Rbn_invb_y_mn34_g1_mp24_g1_y_dup2_t0 xor_bn__t03 xor_bnn2 185.302815577
* device instance bn_invb_y_mn34_g1_mp24_g1_y_dup2_t1 r0 *1 0,0
Rbn_invb_y_mn34_g1_mp24_g1_y_dup2_t1 xor_bn__t13 xor_bnn2 163.924646135
* device instance bn_invb_y_mn34_g1_mp24_g1_y_dup2_t2 r0 *1 0,0
Rbn_invb_y_mn34_g1_mp24_g1_y_dup2_t2 xor_bn__t23 xor_bnn2 173.955001003
* device instance bn_invb_y_mn34_g1_mp24_g1_y_dup2_t3 r0 *1 0,0
Rbn_invb_y_mn34_g1_mp24_g1_y_dup2_t3 xor_bn__t33 xor_bnn2 293.464337285
* device instance bn_invb_y_mn34_g1_mp24_g1_y_dup2 r0 *1 0,0
Cbn_invb_y_mn34_g1_mp24_g1_y_dup2 xor_bnn2 vsubs 5.210763e-15
* device instance en_en1_g_en_t0 r0 *1 0,0
Ren_en1_g_en_t0 en1__t0 en1 259.452
* device instance en_en1_g_en_t1 r0 *1 0,0
Ren_en1_g_en_t1 en1__t1 en1 259.452
* device instance en_en1_g_en r0 *1 0,0
Cen_en1_g_en en1 vsubs 7.37613e-16
* device instance en_en2_g_en_t0 r0 *1 0,0
Ren_en2_g_en_t0 en2__t0 en2 259.452
* device instance en_en2_g_en_t1 r0 *1 0,0
Ren_en2_g_en_t1 en2__t1 en2 259.452
* device instance en_en2_g_en r0 *1 0,0
Cen_en2_g_en en2 vsubs 7.37613e-16
* device instance en_en3_g_en_t0 r0 *1 0,0
Ren_en3_g_en_t0 en3__t0 en3 259.452
* device instance en_en3_g_en_t1 r0 *1 0,0
Ren_en3_g_en_t1 en3__t1 en3 259.452
* device instance en_en3_g_en r0 *1 0,0
Cen_en3_g_en en3 vsubs 7.37613e-16
* device instance en_en4_g_en_t0 r0 *1 0,0
Ren_en4_g_en_t0 en4__t0 en4 259.452
* device instance en_en4_g_en_t1 r0 *1 0,0
Ren_en4_g_en_t1 en4__t1 en4 259.452
* device instance en_en4_g_en r0 *1 0,0
Cen_en4_g_en en4 vsubs 7.37613e-16
* device instance g_vddr_m1_mnt_g_s1_vddr_m1_s2_vddr_m1_s3_vddr_m1_s4_vddr_m1_vddr_vddr1_t0 r0 *1 0,0
Rg_vddr_m1_mnt_g_s1_vddr_m1_s2_vddr_m1_s3_vddr_m1_s4_vddr_m1_vddr_vddr1_t0 vddr1__t0 vddr1 548.247137452
* device instance g_vddr_m1_mnt_g_s1_vddr_m1_s2_vddr_m1_s3_vddr_m1_s4_vddr_m1_vddr_vddr1_t1 r0 *1 0,0
Rg_vddr_m1_mnt_g_s1_vddr_m1_s2_vddr_m1_s3_vddr_m1_s4_vddr_m1_vddr_vddr1_t1 vddr1__t1 vddr1 542.513498718
* device instance g_vddr_m1_mnt_g_s1_vddr_m1_s2_vddr_m1_s3_vddr_m1_s4_vddr_m1_vddr_vddr1_t2 r0 *1 0,0
Rg_vddr_m1_mnt_g_s1_vddr_m1_s2_vddr_m1_s3_vddr_m1_s4_vddr_m1_vddr_vddr1_t2 vddr1__t2 vddr1 542.513498718
* device instance g_vddr_m1_mnt_g_s1_vddr_m1_s2_vddr_m1_s3_vddr_m1_s4_vddr_m1_vddr_vddr1_t3 r0 *1 0,0
Rg_vddr_m1_mnt_g_s1_vddr_m1_s2_vddr_m1_s3_vddr_m1_s4_vddr_m1_vddr_vddr1_t3 vddr1__t3 vddr1 474.224411679
* device instance g_vddr_m1_mnt_g_s1_vddr_m1_s2_vddr_m1_s3_vddr_m1_s4_vddr_m1_vddr_vddr1_t4 r0 *1 0,0
Rg_vddr_m1_mnt_g_s1_vddr_m1_s2_vddr_m1_s3_vddr_m1_s4_vddr_m1_vddr_vddr1_t4 vddr1__t4 vddr1 597.728866242
* device instance g_vddr_m1_mnt_g_s1_vddr_m1_s2_vddr_m1_s3_vddr_m1_s4_vddr_m1_vddr_vddr1_t5 r0 *1 0,0
Rg_vddr_m1_mnt_g_s1_vddr_m1_s2_vddr_m1_s3_vddr_m1_s4_vddr_m1_vddr_vddr1_t5 vddr1__t5 vddr1 339.503132563
* device instance g_vddr_m1_mnt_g_s1_vddr_m1_s2_vddr_m1_s3_vddr_m1_s4_vddr_m1_vddr_vddr1_t6 r0 *1 0,0
Rg_vddr_m1_mnt_g_s1_vddr_m1_s2_vddr_m1_s3_vddr_m1_s4_vddr_m1_vddr_vddr1_t6 vddr1__t6 vddr1 83.5568030932
* device instance g_vddr_m1_mnt_g_s1_vddr_m1_s2_vddr_m1_s3_vddr_m1_s4_vddr_m1_vddr_vddr1_t7 r0 *1 0,0
Rg_vddr_m1_mnt_g_s1_vddr_m1_s2_vddr_m1_s3_vddr_m1_s4_vddr_m1_vddr_vddr1_t7 vddr1__t7 vddr1 180.105204003
* device instance g_vddr_m1_mnt_g_s1_vddr_m1_s2_vddr_m1_s3_vddr_m1_s4_vddr_m1_vddr_vddr1_t8 r0 *1 0,0
Rg_vddr_m1_mnt_g_s1_vddr_m1_s2_vddr_m1_s3_vddr_m1_s4_vddr_m1_vddr_vddr1_t8 vddr1__t8 vddr1 433.56387233
* device instance g_vddr_m1_mnt_g_s1_vddr_m1_s2_vddr_m1_s3_vddr_m1_s4_vddr_m1_vddr_vddr1_t9 r0 *1 0,0
Rg_vddr_m1_mnt_g_s1_vddr_m1_s2_vddr_m1_s3_vddr_m1_s4_vddr_m1_vddr_vddr1_t9 vddr1__t9 vddr1 529.307929685
* device instance g_vddr_m1_mnt_g_s1_vddr_m1_s2_vddr_m1_s3_vddr_m1_s4_vddr_m1_vddr_vddr1_t10 r0 *1 0,0
Rg_vddr_m1_mnt_g_s1_vddr_m1_s2_vddr_m1_s3_vddr_m1_s4_vddr_m1_vddr_vddr1_t10 vddr1__t10 vddr1 271.232773475
* device instance g_vddr_m1_mnt_g_s1_vddr_m1_s2_vddr_m1_s3_vddr_m1_s4_vddr_m1_vddr_vddr1_t11 r0 *1 0,0
Rg_vddr_m1_mnt_g_s1_vddr_m1_s2_vddr_m1_s3_vddr_m1_s4_vddr_m1_vddr_vddr1_t11 vddr1__t11 vddr1 248.149615946
* device instance g_vddr_m1_mnt_g_s1_vddr_m1_s2_vddr_m1_s3_vddr_m1_s4_vddr_m1_vddr_vddr1_t12 r0 *1 0,0
Rg_vddr_m1_mnt_g_s1_vddr_m1_s2_vddr_m1_s3_vddr_m1_s4_vddr_m1_vddr_vddr1_t12 vddr1__t12 vddr1 26.5392771065
* device instance g_vddr_m1_mnt_g_s1_vddr_m1_s2_vddr_m1_s3_vddr_m1_s4_vddr_m1_vddr_vddr1_t13 r0 *1 0,0
Rg_vddr_m1_mnt_g_s1_vddr_m1_s2_vddr_m1_s3_vddr_m1_s4_vddr_m1_vddr_vddr1_t13 vddr1__t13 vddr1 529.307929685
* device instance g_vddr_m1_mnt_g_s1_vddr_m1_s2_vddr_m1_s3_vddr_m1_s4_vddr_m1_vddr_vddr1_t14 r0 *1 0,0
Rg_vddr_m1_mnt_g_s1_vddr_m1_s2_vddr_m1_s3_vddr_m1_s4_vddr_m1_vddr_vddr1_t14 vddr1__t14 vddr1 271.232773475
* device instance g_vddr_m1_mnt_g_s1_vddr_m1_s2_vddr_m1_s3_vddr_m1_s4_vddr_m1_vddr_vddr1_t15 r0 *1 0,0
Rg_vddr_m1_mnt_g_s1_vddr_m1_s2_vddr_m1_s3_vddr_m1_s4_vddr_m1_vddr_vddr1_t15 vddr1__t15 vddr1 248.149615946
* device instance g_vddr_m1_mnt_g_s1_vddr_m1_s2_vddr_m1_s3_vddr_m1_s4_vddr_m1_vddr_vddr1_t16 r0 *1 0,0
Rg_vddr_m1_mnt_g_s1_vddr_m1_s2_vddr_m1_s3_vddr_m1_s4_vddr_m1_vddr_vddr1_t16 vddr1__t16 vddr1 26.5392771065
* device instance g_vddr_m1_mnt_g_s1_vddr_m1_s2_vddr_m1_s3_vddr_m1_s4_vddr_m1_vddr_vddr1_t17 r0 *1 0,0
Rg_vddr_m1_mnt_g_s1_vddr_m1_s2_vddr_m1_s3_vddr_m1_s4_vddr_m1_vddr_vddr1_t17 vddr1__t17 vddr1 262.134590134
* device instance g_vddr_m1_mnt_g_s1_vddr_m1_s2_vddr_m1_s3_vddr_m1_s4_vddr_m1_vddr_vddr1_t18 r0 *1 0,0
Rg_vddr_m1_mnt_g_s1_vddr_m1_s2_vddr_m1_s3_vddr_m1_s4_vddr_m1_vddr_vddr1_t18 vddr1__t18 vddr1 88.5474148697
* device instance g_vddr_m1_mnt_g_s1_vddr_m1_s2_vddr_m1_s3_vddr_m1_s4_vddr_m1_vddr_vddr1_t19 r0 *1 0,0
Rg_vddr_m1_mnt_g_s1_vddr_m1_s2_vddr_m1_s3_vddr_m1_s4_vddr_m1_vddr_vddr1_t19 vddr1__t19 vddr1 536.006712531
* device instance g_vddr_m1_mnt_g_s1_vddr_m1_s2_vddr_m1_s3_vddr_m1_s4_vddr_m1_vddr_vddr1_t20 r0 *1 0,0
Rg_vddr_m1_mnt_g_s1_vddr_m1_s2_vddr_m1_s3_vddr_m1_s4_vddr_m1_vddr_vddr1_t20 vddr1__t20 vddr1 284.083665243
* device instance g_vddr_m1_mnt_g_s1_vddr_m1_s2_vddr_m1_s3_vddr_m1_s4_vddr_m1_vddr_vddr1 r0 *1 0,0
Cg_vddr_m1_mnt_g_s1_vddr_m1_s2_vddr_m1_s3_vddr_m1_s4_vddr_m1_vddr_vddr1 vddr1 vsubs 1.4767873e-14
* device instance g_vddr_m1_mnt_g_s1_vddr_m1_s2_vddr_m1_s3_vddr_m1_s4_vddr_m1_vddr_vddr2_t0 r0 *1 0,0
Rg_vddr_m1_mnt_g_s1_vddr_m1_s2_vddr_m1_s3_vddr_m1_s4_vddr_m1_vddr_vddr2_t0 vddr2__t0 vddr2 548.481147289
* device instance g_vddr_m1_mnt_g_s1_vddr_m1_s2_vddr_m1_s3_vddr_m1_s4_vddr_m1_vddr_vddr2_t1 r0 *1 0,0
Rg_vddr_m1_mnt_g_s1_vddr_m1_s2_vddr_m1_s3_vddr_m1_s4_vddr_m1_vddr_vddr2_t1 vddr2__t1 vddr2 542.74506125
* device instance g_vddr_m1_mnt_g_s1_vddr_m1_s2_vddr_m1_s3_vddr_m1_s4_vddr_m1_vddr_vddr2_t2 r0 *1 0,0
Rg_vddr_m1_mnt_g_s1_vddr_m1_s2_vddr_m1_s3_vddr_m1_s4_vddr_m1_vddr_vddr2_t2 vddr2__t2 vddr2 542.74506125
* device instance g_vddr_m1_mnt_g_s1_vddr_m1_s2_vddr_m1_s3_vddr_m1_s4_vddr_m1_vddr_vddr2_t3 r0 *1 0,0
Rg_vddr_m1_mnt_g_s1_vddr_m1_s2_vddr_m1_s3_vddr_m1_s4_vddr_m1_vddr_vddr2_t3 vddr2__t3 vddr2 26.5506049392
* device instance g_vddr_m1_mnt_g_s1_vddr_m1_s2_vddr_m1_s3_vddr_m1_s4_vddr_m1_vddr_vddr2_t4 r0 *1 0,0
Rg_vddr_m1_mnt_g_s1_vddr_m1_s2_vddr_m1_s3_vddr_m1_s4_vddr_m1_vddr_vddr2_t4 vddr2__t4 vddr2 271.348544507
* device instance g_vddr_m1_mnt_g_s1_vddr_m1_s2_vddr_m1_s3_vddr_m1_s4_vddr_m1_vddr_vddr2_t5 r0 *1 0,0
Rg_vddr_m1_mnt_g_s1_vddr_m1_s2_vddr_m1_s3_vddr_m1_s4_vddr_m1_vddr_vddr2_t5 vddr2__t5 vddr2 529.533855647
* device instance g_vddr_m1_mnt_g_s1_vddr_m1_s2_vddr_m1_s3_vddr_m1_s4_vddr_m1_vddr_vddr2_t6 r0 *1 0,0
Rg_vddr_m1_mnt_g_s1_vddr_m1_s2_vddr_m1_s3_vddr_m1_s4_vddr_m1_vddr_vddr2_t6 vddr2__t6 vddr2 248.25553433
* device instance g_vddr_m1_mnt_g_s1_vddr_m1_s2_vddr_m1_s3_vddr_m1_s4_vddr_m1_vddr_vddr2_t7 r0 *1 0,0
Rg_vddr_m1_mnt_g_s1_vddr_m1_s2_vddr_m1_s3_vddr_m1_s4_vddr_m1_vddr_vddr2_t7 vddr2__t7 vddr2 26.5506049392
* device instance g_vddr_m1_mnt_g_s1_vddr_m1_s2_vddr_m1_s3_vddr_m1_s4_vddr_m1_vddr_vddr2_t8 r0 *1 0,0
Rg_vddr_m1_mnt_g_s1_vddr_m1_s2_vddr_m1_s3_vddr_m1_s4_vddr_m1_vddr_vddr2_t8 vddr2__t8 vddr2 271.348544507
* device instance g_vddr_m1_mnt_g_s1_vddr_m1_s2_vddr_m1_s3_vddr_m1_s4_vddr_m1_vddr_vddr2_t9 r0 *1 0,0
Rg_vddr_m1_mnt_g_s1_vddr_m1_s2_vddr_m1_s3_vddr_m1_s4_vddr_m1_vddr_vddr2_t9 vddr2__t9 vddr2 529.533855647
* device instance g_vddr_m1_mnt_g_s1_vddr_m1_s2_vddr_m1_s3_vddr_m1_s4_vddr_m1_vddr_vddr2_t10 r0 *1 0,0
Rg_vddr_m1_mnt_g_s1_vddr_m1_s2_vddr_m1_s3_vddr_m1_s4_vddr_m1_vddr_vddr2_t10 vddr2__t10 vddr2 248.25553433
* device instance g_vddr_m1_mnt_g_s1_vddr_m1_s2_vddr_m1_s3_vddr_m1_s4_vddr_m1_vddr_vddr2_t11 r0 *1 0,0
Rg_vddr_m1_mnt_g_s1_vddr_m1_s2_vddr_m1_s3_vddr_m1_s4_vddr_m1_vddr_vddr2_t11 vddr2__t11 vddr2 597.983996501
* device instance g_vddr_m1_mnt_g_s1_vddr_m1_s2_vddr_m1_s3_vddr_m1_s4_vddr_m1_vddr_vddr2_t12 r0 *1 0,0
Rg_vddr_m1_mnt_g_s1_vddr_m1_s2_vddr_m1_s3_vddr_m1_s4_vddr_m1_vddr_vddr2_t12 vddr2__t12 vddr2 339.64804362
* device instance g_vddr_m1_mnt_g_s1_vddr_m1_s2_vddr_m1_s3_vddr_m1_s4_vddr_m1_vddr_vddr2_t13 r0 *1 0,0
Rg_vddr_m1_mnt_g_s1_vddr_m1_s2_vddr_m1_s3_vddr_m1_s4_vddr_m1_vddr_vddr2_t13 vddr2__t13 vddr2 83.5924678737
* device instance g_vddr_m1_mnt_g_s1_vddr_m1_s2_vddr_m1_s3_vddr_m1_s4_vddr_m1_vddr_vddr2_t14 r0 *1 0,0
Rg_vddr_m1_mnt_g_s1_vddr_m1_s2_vddr_m1_s3_vddr_m1_s4_vddr_m1_vddr_vddr2_t14 vddr2__t14 vddr2 180.182078803
* device instance g_vddr_m1_mnt_g_s1_vddr_m1_s2_vddr_m1_s3_vddr_m1_s4_vddr_m1_vddr_vddr2_t15 r0 *1 0,0
Rg_vddr_m1_mnt_g_s1_vddr_m1_s2_vddr_m1_s3_vddr_m1_s4_vddr_m1_vddr_vddr2_t15 vddr2__t15 vddr2 433.748931592
* device instance g_vddr_m1_mnt_g_s1_vddr_m1_s2_vddr_m1_s3_vddr_m1_s4_vddr_m1_vddr_vddr2_t16 r0 *1 0,0
Rg_vddr_m1_mnt_g_s1_vddr_m1_s2_vddr_m1_s3_vddr_m1_s4_vddr_m1_vddr_vddr2_t16 vddr2__t16 vddr2 474.426826191
* device instance g_vddr_m1_mnt_g_s1_vddr_m1_s2_vddr_m1_s3_vddr_m1_s4_vddr_m1_vddr_vddr2_t17 r0 *1 0,0
Rg_vddr_m1_mnt_g_s1_vddr_m1_s2_vddr_m1_s3_vddr_m1_s4_vddr_m1_vddr_vddr2_t17 vddr2__t17 vddr2 536.235497753
* device instance g_vddr_m1_mnt_g_s1_vddr_m1_s2_vddr_m1_s3_vddr_m1_s4_vddr_m1_vddr_vddr2_t18 r0 *1 0,0
Rg_vddr_m1_mnt_g_s1_vddr_m1_s2_vddr_m1_s3_vddr_m1_s4_vddr_m1_vddr_vddr2_t18 vddr2__t18 vddr2 88.5852098068
* device instance g_vddr_m1_mnt_g_s1_vddr_m1_s2_vddr_m1_s3_vddr_m1_s4_vddr_m1_vddr_vddr2_t19 r0 *1 0,0
Rg_vddr_m1_mnt_g_s1_vddr_m1_s2_vddr_m1_s3_vddr_m1_s4_vddr_m1_vddr_vddr2_t19 vddr2__t19 vddr2 284.204921457
* device instance g_vddr_m1_mnt_g_s1_vddr_m1_s2_vddr_m1_s3_vddr_m1_s4_vddr_m1_vddr_vddr2_t20 r0 *1 0,0
Rg_vddr_m1_mnt_g_s1_vddr_m1_s2_vddr_m1_s3_vddr_m1_s4_vddr_m1_vddr_vddr2_t20 vddr2__t20 vddr2 262.246477764
* device instance g_vddr_m1_mnt_g_s1_vddr_m1_s2_vddr_m1_s3_vddr_m1_s4_vddr_m1_vddr_vddr2 r0 *1 0,0
Cg_vddr_m1_mnt_g_s1_vddr_m1_s2_vddr_m1_s3_vddr_m1_s4_vddr_m1_vddr_vddr2 vddr2 vsubs 1.4773157e-14
* device instance g_vddr_m1_mnt_g_s1_vddr_m1_s2_vddr_m1_s3_vddr_m1_s4_vddr_m1_vddr_vddr3_t0 r0 *1 0,0
Rg_vddr_m1_mnt_g_s1_vddr_m1_s2_vddr_m1_s3_vddr_m1_s4_vddr_m1_vddr_vddr3_t0 vddr3__t0 vddr3 548.715164888
* device instance g_vddr_m1_mnt_g_s1_vddr_m1_s2_vddr_m1_s3_vddr_m1_s4_vddr_m1_vddr_vddr3_t1 r0 *1 0,0
Rg_vddr_m1_mnt_g_s1_vddr_m1_s2_vddr_m1_s3_vddr_m1_s4_vddr_m1_vddr_vddr3_t1 vddr3__t1 vddr3 542.976631462
* device instance g_vddr_m1_mnt_g_s1_vddr_m1_s2_vddr_m1_s3_vddr_m1_s4_vddr_m1_vddr_vddr3_t2 r0 *1 0,0
Rg_vddr_m1_mnt_g_s1_vddr_m1_s2_vddr_m1_s3_vddr_m1_s4_vddr_m1_vddr_vddr3_t2 vddr3__t2 vddr3 542.976631462
* device instance g_vddr_m1_mnt_g_s1_vddr_m1_s2_vddr_m1_s3_vddr_m1_s4_vddr_m1_vddr_vddr3_t3 r0 *1 0,0
Rg_vddr_m1_mnt_g_s1_vddr_m1_s2_vddr_m1_s3_vddr_m1_s4_vddr_m1_vddr_vddr3_t3 vddr3__t3 vddr3 529.759789104
* device instance g_vddr_m1_mnt_g_s1_vddr_m1_s2_vddr_m1_s3_vddr_m1_s4_vddr_m1_vddr_vddr3_t4 r0 *1 0,0
Rg_vddr_m1_mnt_g_s1_vddr_m1_s2_vddr_m1_s3_vddr_m1_s4_vddr_m1_vddr_vddr3_t4 vddr3__t4 vddr3 271.46431938
* device instance g_vddr_m1_mnt_g_s1_vddr_m1_s2_vddr_m1_s3_vddr_m1_s4_vddr_m1_vddr_vddr3_t5 r0 *1 0,0
Rg_vddr_m1_mnt_g_s1_vddr_m1_s2_vddr_m1_s3_vddr_m1_s4_vddr_m1_vddr_vddr3_t5 vddr3__t5 vddr3 248.361456228
* device instance g_vddr_m1_mnt_g_s1_vddr_m1_s2_vddr_m1_s3_vddr_m1_s4_vddr_m1_vddr_vddr3_t6 r0 *1 0,0
Rg_vddr_m1_mnt_g_s1_vddr_m1_s2_vddr_m1_s3_vddr_m1_s4_vddr_m1_vddr_vddr3_t6 vddr3__t6 vddr3 26.5619331478
* device instance g_vddr_m1_mnt_g_s1_vddr_m1_s2_vddr_m1_s3_vddr_m1_s4_vddr_m1_vddr_vddr3_t7 r0 *1 0,0
Rg_vddr_m1_mnt_g_s1_vddr_m1_s2_vddr_m1_s3_vddr_m1_s4_vddr_m1_vddr_vddr3_t7 vddr3__t7 vddr3 529.759789104
* device instance g_vddr_m1_mnt_g_s1_vddr_m1_s2_vddr_m1_s3_vddr_m1_s4_vddr_m1_vddr_vddr3_t8 r0 *1 0,0
Rg_vddr_m1_mnt_g_s1_vddr_m1_s2_vddr_m1_s3_vddr_m1_s4_vddr_m1_vddr_vddr3_t8 vddr3__t8 vddr3 271.46431938
* device instance g_vddr_m1_mnt_g_s1_vddr_m1_s2_vddr_m1_s3_vddr_m1_s4_vddr_m1_vddr_vddr3_t9 r0 *1 0,0
Rg_vddr_m1_mnt_g_s1_vddr_m1_s2_vddr_m1_s3_vddr_m1_s4_vddr_m1_vddr_vddr3_t9 vddr3__t9 vddr3 248.361456228
* device instance g_vddr_m1_mnt_g_s1_vddr_m1_s2_vddr_m1_s3_vddr_m1_s4_vddr_m1_vddr_vddr3_t10 r0 *1 0,0
Rg_vddr_m1_mnt_g_s1_vddr_m1_s2_vddr_m1_s3_vddr_m1_s4_vddr_m1_vddr_vddr3_t10 vddr3__t10 vddr3 26.5619331478
* device instance g_vddr_m1_mnt_g_s1_vddr_m1_s2_vddr_m1_s3_vddr_m1_s4_vddr_m1_vddr_vddr3_t11 r0 *1 0,0
Rg_vddr_m1_mnt_g_s1_vddr_m1_s2_vddr_m1_s3_vddr_m1_s4_vddr_m1_vddr_vddr3_t11 vddr3__t11 vddr3 339.792959485
* device instance g_vddr_m1_mnt_g_s1_vddr_m1_s2_vddr_m1_s3_vddr_m1_s4_vddr_m1_vddr_vddr3_t12 r0 *1 0,0
Rg_vddr_m1_mnt_g_s1_vddr_m1_s2_vddr_m1_s3_vddr_m1_s4_vddr_m1_vddr_vddr3_t12 vddr3__t12 vddr3 598.239135223
* device instance g_vddr_m1_mnt_g_s1_vddr_m1_s2_vddr_m1_s3_vddr_m1_s4_vddr_m1_vddr_vddr3_t13 r0 *1 0,0
Rg_vddr_m1_mnt_g_s1_vddr_m1_s2_vddr_m1_s3_vddr_m1_s4_vddr_m1_vddr_vddr3_t13 vddr3__t13 vddr3 433.933996993
* device instance g_vddr_m1_mnt_g_s1_vddr_m1_s2_vddr_m1_s3_vddr_m1_s4_vddr_m1_vddr_vddr3_t14 r0 *1 0,0
Rg_vddr_m1_mnt_g_s1_vddr_m1_s2_vddr_m1_s3_vddr_m1_s4_vddr_m1_vddr_vddr3_t14 vddr3__t14 vddr3 180.258956154
* device instance g_vddr_m1_mnt_g_s1_vddr_m1_s2_vddr_m1_s3_vddr_m1_s4_vddr_m1_vddr_vddr3_t15 r0 *1 0,0
Rg_vddr_m1_mnt_g_s1_vddr_m1_s2_vddr_m1_s3_vddr_m1_s4_vddr_m1_vddr_vddr3_t15 vddr3__t15 vddr3 83.6281338372
* device instance g_vddr_m1_mnt_g_s1_vddr_m1_s2_vddr_m1_s3_vddr_m1_s4_vddr_m1_vddr_vddr3_t16 r0 *1 0,0
Rg_vddr_m1_mnt_g_s1_vddr_m1_s2_vddr_m1_s3_vddr_m1_s4_vddr_m1_vddr_vddr3_t16 vddr3__t16 vddr3 474.629247418
* device instance g_vddr_m1_mnt_g_s1_vddr_m1_s2_vddr_m1_s3_vddr_m1_s4_vddr_m1_vddr_vddr3_t17 r0 *1 0,0
Rg_vddr_m1_mnt_g_s1_vddr_m1_s2_vddr_m1_s3_vddr_m1_s4_vddr_m1_vddr_vddr3_t17 vddr3__t17 vddr3 88.6230059976
* device instance g_vddr_m1_mnt_g_s1_vddr_m1_s2_vddr_m1_s3_vddr_m1_s4_vddr_m1_vddr_vddr3_t18 r0 *1 0,0
Rg_vddr_m1_mnt_g_s1_vddr_m1_s2_vddr_m1_s3_vddr_m1_s4_vddr_m1_vddr_vddr3_t18 vddr3__t18 vddr3 284.326181692
* device instance g_vddr_m1_mnt_g_s1_vddr_m1_s2_vddr_m1_s3_vddr_m1_s4_vddr_m1_vddr_vddr3_t19 r0 *1 0,0
Rg_vddr_m1_mnt_g_s1_vddr_m1_s2_vddr_m1_s3_vddr_m1_s4_vddr_m1_vddr_vddr3_t19 vddr3__t19 vddr3 536.464290564
* device instance g_vddr_m1_mnt_g_s1_vddr_m1_s2_vddr_m1_s3_vddr_m1_s4_vddr_m1_vddr_vddr3_t20 r0 *1 0,0
Rg_vddr_m1_mnt_g_s1_vddr_m1_s2_vddr_m1_s3_vddr_m1_s4_vddr_m1_vddr_vddr3_t20 vddr3__t20 vddr3 262.358369105
* device instance g_vddr_m1_mnt_g_s1_vddr_m1_s2_vddr_m1_s3_vddr_m1_s4_vddr_m1_vddr_vddr3 r0 *1 0,0
Cg_vddr_m1_mnt_g_s1_vddr_m1_s2_vddr_m1_s3_vddr_m1_s4_vddr_m1_vddr_vddr3 vddr3 vsubs 1.4778441e-14
* device instance g_vddr_m1_mnt_g_s1_vddr_m1_s2_vddr_m1_s3_vddr_m1_s4_vddr_m1_vddr_vddr4_t0 r0 *1 0,0
Rg_vddr_m1_mnt_g_s1_vddr_m1_s2_vddr_m1_s3_vddr_m1_s4_vddr_m1_vddr_vddr4_t0 vddr4__t0 vddr4 548.949174724
* device instance g_vddr_m1_mnt_g_s1_vddr_m1_s2_vddr_m1_s3_vddr_m1_s4_vddr_m1_vddr_vddr4_t1 r0 *1 0,0
Rg_vddr_m1_mnt_g_s1_vddr_m1_s2_vddr_m1_s3_vddr_m1_s4_vddr_m1_vddr_vddr4_t1 vddr4__t1 vddr4 543.208193994
* device instance g_vddr_m1_mnt_g_s1_vddr_m1_s2_vddr_m1_s3_vddr_m1_s4_vddr_m1_vddr_vddr4_t2 r0 *1 0,0
Rg_vddr_m1_mnt_g_s1_vddr_m1_s2_vddr_m1_s3_vddr_m1_s4_vddr_m1_vddr_vddr4_t2 vddr4__t2 vddr4 543.208193994
* device instance g_vddr_m1_mnt_g_s1_vddr_m1_s2_vddr_m1_s3_vddr_m1_s4_vddr_m1_vddr_vddr4_t3 r0 *1 0,0
Rg_vddr_m1_mnt_g_s1_vddr_m1_s2_vddr_m1_s3_vddr_m1_s4_vddr_m1_vddr_vddr4_t3 vddr4__t3 vddr4 26.5732609806
* device instance g_vddr_m1_mnt_g_s1_vddr_m1_s2_vddr_m1_s3_vddr_m1_s4_vddr_m1_vddr_vddr4_t4 r0 *1 0,0
Rg_vddr_m1_mnt_g_s1_vddr_m1_s2_vddr_m1_s3_vddr_m1_s4_vddr_m1_vddr_vddr4_t4 vddr4__t4 vddr4 271.580090412
* device instance g_vddr_m1_mnt_g_s1_vddr_m1_s2_vddr_m1_s3_vddr_m1_s4_vddr_m1_vddr_vddr4_t5 r0 *1 0,0
Rg_vddr_m1_mnt_g_s1_vddr_m1_s2_vddr_m1_s3_vddr_m1_s4_vddr_m1_vddr_vddr4_t5 vddr4__t5 vddr4 529.985715066
* device instance g_vddr_m1_mnt_g_s1_vddr_m1_s2_vddr_m1_s3_vddr_m1_s4_vddr_m1_vddr_vddr4_t6 r0 *1 0,0
Rg_vddr_m1_mnt_g_s1_vddr_m1_s2_vddr_m1_s3_vddr_m1_s4_vddr_m1_vddr_vddr4_t6 vddr4__t6 vddr4 248.467374613
* device instance g_vddr_m1_mnt_g_s1_vddr_m1_s2_vddr_m1_s3_vddr_m1_s4_vddr_m1_vddr_vddr4_t7 r0 *1 0,0
Rg_vddr_m1_mnt_g_s1_vddr_m1_s2_vddr_m1_s3_vddr_m1_s4_vddr_m1_vddr_vddr4_t7 vddr4__t7 vddr4 26.5732609806
* device instance g_vddr_m1_mnt_g_s1_vddr_m1_s2_vddr_m1_s3_vddr_m1_s4_vddr_m1_vddr_vddr4_t8 r0 *1 0,0
Rg_vddr_m1_mnt_g_s1_vddr_m1_s2_vddr_m1_s3_vddr_m1_s4_vddr_m1_vddr_vddr4_t8 vddr4__t8 vddr4 271.580090412
* device instance g_vddr_m1_mnt_g_s1_vddr_m1_s2_vddr_m1_s3_vddr_m1_s4_vddr_m1_vddr_vddr4_t9 r0 *1 0,0
Rg_vddr_m1_mnt_g_s1_vddr_m1_s2_vddr_m1_s3_vddr_m1_s4_vddr_m1_vddr_vddr4_t9 vddr4__t9 vddr4 529.985715066
* device instance g_vddr_m1_mnt_g_s1_vddr_m1_s2_vddr_m1_s3_vddr_m1_s4_vddr_m1_vddr_vddr4_t10 r0 *1 0,0
Rg_vddr_m1_mnt_g_s1_vddr_m1_s2_vddr_m1_s3_vddr_m1_s4_vddr_m1_vddr_vddr4_t10 vddr4__t10 vddr4 248.467374613
* device instance g_vddr_m1_mnt_g_s1_vddr_m1_s2_vddr_m1_s3_vddr_m1_s4_vddr_m1_vddr_vddr4_t11 r0 *1 0,0
Rg_vddr_m1_mnt_g_s1_vddr_m1_s2_vddr_m1_s3_vddr_m1_s4_vddr_m1_vddr_vddr4_t11 vddr4__t11 vddr4 180.335830955
* device instance g_vddr_m1_mnt_g_s1_vddr_m1_s2_vddr_m1_s3_vddr_m1_s4_vddr_m1_vddr_vddr4_t12 r0 *1 0,0
Rg_vddr_m1_mnt_g_s1_vddr_m1_s2_vddr_m1_s3_vddr_m1_s4_vddr_m1_vddr_vddr4_t12 vddr4__t12 vddr4 474.83166193
* device instance g_vddr_m1_mnt_g_s1_vddr_m1_s2_vddr_m1_s3_vddr_m1_s4_vddr_m1_vddr_vddr4_t13 r0 *1 0,0
Rg_vddr_m1_mnt_g_s1_vddr_m1_s2_vddr_m1_s3_vddr_m1_s4_vddr_m1_vddr_vddr4_t13 vddr4__t13 vddr4 598.494265483
* device instance g_vddr_m1_mnt_g_s1_vddr_m1_s2_vddr_m1_s3_vddr_m1_s4_vddr_m1_vddr_vddr4_t14 r0 *1 0,0
Rg_vddr_m1_mnt_g_s1_vddr_m1_s2_vddr_m1_s3_vddr_m1_s4_vddr_m1_vddr_vddr4_t14 vddr4__t14 vddr4 339.937870542
* device instance g_vddr_m1_mnt_g_s1_vddr_m1_s2_vddr_m1_s3_vddr_m1_s4_vddr_m1_vddr_vddr4_t15 r0 *1 0,0
Rg_vddr_m1_mnt_g_s1_vddr_m1_s2_vddr_m1_s3_vddr_m1_s4_vddr_m1_vddr_vddr4_t15 vddr4__t15 vddr4 83.6637986178
* device instance g_vddr_m1_mnt_g_s1_vddr_m1_s2_vddr_m1_s3_vddr_m1_s4_vddr_m1_vddr_vddr4_t16 r0 *1 0,0
Rg_vddr_m1_mnt_g_s1_vddr_m1_s2_vddr_m1_s3_vddr_m1_s4_vddr_m1_vddr_vddr4_t16 vddr4__t16 vddr4 434.119056256
* device instance g_vddr_m1_mnt_g_s1_vddr_m1_s2_vddr_m1_s3_vddr_m1_s4_vddr_m1_vddr_vddr4_t17 r0 *1 0,0
Rg_vddr_m1_mnt_g_s1_vddr_m1_s2_vddr_m1_s3_vddr_m1_s4_vddr_m1_vddr_vddr4_t17 vddr4__t17 vddr4 262.470256734
* device instance g_vddr_m1_mnt_g_s1_vddr_m1_s2_vddr_m1_s3_vddr_m1_s4_vddr_m1_vddr_vddr4_t18 r0 *1 0,0
Rg_vddr_m1_mnt_g_s1_vddr_m1_s2_vddr_m1_s3_vddr_m1_s4_vddr_m1_vddr_vddr4_t18 vddr4__t18 vddr4 88.6608009347
* device instance g_vddr_m1_mnt_g_s1_vddr_m1_s2_vddr_m1_s3_vddr_m1_s4_vddr_m1_vddr_vddr4_t19 r0 *1 0,0
Rg_vddr_m1_mnt_g_s1_vddr_m1_s2_vddr_m1_s3_vddr_m1_s4_vddr_m1_vddr_vddr4_t19 vddr4__t19 vddr4 284.447437906
* device instance g_vddr_m1_mnt_g_s1_vddr_m1_s2_vddr_m1_s3_vddr_m1_s4_vddr_m1_vddr_vddr4_t20 r0 *1 0,0
Rg_vddr_m1_mnt_g_s1_vddr_m1_s2_vddr_m1_s3_vddr_m1_s4_vddr_m1_vddr_vddr4_t20 vddr4__t20 vddr4 536.693075787
* device instance g_vddr_m1_mnt_g_s1_vddr_m1_s2_vddr_m1_s3_vddr_m1_s4_vddr_m1_vddr_vddr4 r0 *1 0,0
Cg_vddr_m1_mnt_g_s1_vddr_m1_s2_vddr_m1_s3_vddr_m1_s4_vddr_m1_vddr_vddr4 vddr4 vsubs 1.4783725e-14
* device instance g_vss_m1_mph_g_s1_vss_m1_s2_vss_m1_s3_vss_m1_s4_vss_m1_vss_vss_x1_vss_x2_vss_x3_t0 r0 *1 0,0
Rg_vss_m1_mph_g_s1_vss_m1_s2_vss_m1_s3_vss_m1_s4_vss_m1_vss_vss_x1_vss_x2_vss_x3_t0 vss__t0 vss 464.089953628
* device instance g_vss_m1_mph_g_s1_vss_m1_s2_vss_m1_s3_vss_m1_s4_vss_m1_vss_vss_x1_vss_x2_vss_x3_t1 r0 *1 0,0
Rg_vss_m1_mph_g_s1_vss_m1_s2_vss_m1_s3_vss_m1_s4_vss_m1_vss_vss_x1_vss_x2_vss_x3_t1 vss__t1 vss 169.185029368
* device instance g_vss_m1_mph_g_s1_vss_m1_s2_vss_m1_s3_vss_m1_s4_vss_m1_vss_vss_x1_vss_x2_vss_x3_t2 r0 *1 0,0
Rg_vss_m1_mph_g_s1_vss_m1_s2_vss_m1_s3_vss_m1_s4_vss_m1_vss_vss_x1_vss_x2_vss_x3_t2 vss__t2 vss 131.0107669
* device instance g_vss_m1_mph_g_s1_vss_m1_s2_vss_m1_s3_vss_m1_s4_vss_m1_vss_vss_x1_vss_x2_vss_x3_t3 r0 *1 0,0
Rg_vss_m1_mph_g_s1_vss_m1_s2_vss_m1_s3_vss_m1_s4_vss_m1_vss_vss_x1_vss_x2_vss_x3_t3 vss__t3 vss 425.441212982
* device instance g_vss_m1_mph_g_s1_vss_m1_s2_vss_m1_s3_vss_m1_s4_vss_m1_vss_vss_x1_vss_x2_vss_x3_t4 r0 *1 0,0
Rg_vss_m1_mph_g_s1_vss_m1_s2_vss_m1_s3_vss_m1_s4_vss_m1_vss_vss_x1_vss_x2_vss_x3_t4 vss__t4 vss 463.447399589
* device instance g_vss_m1_mph_g_s1_vss_m1_s2_vss_m1_s3_vss_m1_s4_vss_m1_vss_vss_x1_vss_x2_vss_x3_t5 r0 *1 0,0
Rg_vss_m1_mph_g_s1_vss_m1_s2_vss_m1_s3_vss_m1_s4_vss_m1_vss_vss_x1_vss_x2_vss_x3_t5 vss__t5 vss 167.414399886
* device instance g_vss_m1_mph_g_s1_vss_m1_s2_vss_m1_s3_vss_m1_s4_vss_m1_vss_vss_x1_vss_x2_vss_x3_t6 r0 *1 0,0
Rg_vss_m1_mph_g_s1_vss_m1_s2_vss_m1_s3_vss_m1_s4_vss_m1_vss_vss_x1_vss_x2_vss_x3_t6 vss__t6 vss 128.716075806
* device instance g_vss_m1_mph_g_s1_vss_m1_s2_vss_m1_s3_vss_m1_s4_vss_m1_vss_vss_x1_vss_x2_vss_x3_t7 r0 *1 0,0
Rg_vss_m1_mph_g_s1_vss_m1_s2_vss_m1_s3_vss_m1_s4_vss_m1_vss_vss_x1_vss_x2_vss_x3_t7 vss__t7 vss 424.740194508
* device instance g_vss_m1_mph_g_s1_vss_m1_s2_vss_m1_s3_vss_m1_s4_vss_m1_vss_vss_x1_vss_x2_vss_x3_t8 r0 *1 0,0
Rg_vss_m1_mph_g_s1_vss_m1_s2_vss_m1_s3_vss_m1_s4_vss_m1_vss_vss_x1_vss_x2_vss_x3_t8 vss__t8 vss 518.313113969
* device instance g_vss_m1_mph_g_s1_vss_m1_s2_vss_m1_s3_vss_m1_s4_vss_m1_vss_vss_x1_vss_x2_vss_x3_t9 r0 *1 0,0
Rg_vss_m1_mph_g_s1_vss_m1_s2_vss_m1_s3_vss_m1_s4_vss_m1_vss_vss_x1_vss_x2_vss_x3_t9 vss__t9 vss 562.076333298
* device instance g_vss_m1_mph_g_s1_vss_m1_s2_vss_m1_s3_vss_m1_s4_vss_m1_vss_vss_x1_vss_x2_vss_x3_t10 r0 *1 0,0
Rg_vss_m1_mph_g_s1_vss_m1_s2_vss_m1_s3_vss_m1_s4_vss_m1_vss_vss_x1_vss_x2_vss_x3_t10 vss__t10 vss 605.83991032
* device instance g_vss_m1_mph_g_s1_vss_m1_s2_vss_m1_s3_vss_m1_s4_vss_m1_vss_vss_x1_vss_x2_vss_x3_t11 r0 *1 0,0
Rg_vss_m1_mph_g_s1_vss_m1_s2_vss_m1_s3_vss_m1_s4_vss_m1_vss_vss_x1_vss_x2_vss_x3_t11 vss__t11 vss 474.550351291
* device instance g_vss_m1_mph_g_s1_vss_m1_s2_vss_m1_s3_vss_m1_s4_vss_m1_vss_vss_x1_vss_x2_vss_x3_t12 r0 *1 0,0
Rg_vss_m1_mph_g_s1_vss_m1_s2_vss_m1_s3_vss_m1_s4_vss_m1_vss_vss_x1_vss_x2_vss_x3_t12 vss__t12 vss 309.811723612
* device instance g_vss_m1_mph_g_s1_vss_m1_s2_vss_m1_s3_vss_m1_s4_vss_m1_vss_vss_x1_vss_x2_vss_x3_t13 r0 *1 0,0
Rg_vss_m1_mph_g_s1_vss_m1_s2_vss_m1_s3_vss_m1_s4_vss_m1_vss_vss_x1_vss_x2_vss_x3_t13 vss__t13 vss 266.054779658
* device instance g_vss_m1_mph_g_s1_vss_m1_s2_vss_m1_s3_vss_m1_s4_vss_m1_vss_vss_x1_vss_x2_vss_x3_t14 r0 *1 0,0
Rg_vss_m1_mph_g_s1_vss_m1_s2_vss_m1_s3_vss_m1_s4_vss_m1_vss_vss_x1_vss_x2_vss_x3_t14 vss__t14 vss 178.553761049
* device instance g_vss_m1_mph_g_s1_vss_m1_s2_vss_m1_s3_vss_m1_s4_vss_m1_vss_vss_x1_vss_x2_vss_x3_t15 r0 *1 0,0
Rg_vss_m1_mph_g_s1_vss_m1_s2_vss_m1_s3_vss_m1_s4_vss_m1_vss_vss_x1_vss_x2_vss_x3_t15 vss__t15 vss 222.301281174
* device instance g_vss_m1_mph_g_s1_vss_m1_s2_vss_m1_s3_vss_m1_s4_vss_m1_vss_vss_x1_vss_x2_vss_x3_t16 r0 *1 0,0
Rg_vss_m1_mph_g_s1_vss_m1_s2_vss_m1_s3_vss_m1_s4_vss_m1_vss_vss_x1_vss_x2_vss_x3_t16 vss__t16 vss 74.0499351087
* device instance g_vss_m1_mph_g_s1_vss_m1_s2_vss_m1_s3_vss_m1_s4_vss_m1_vss_vss_x1_vss_x2_vss_x3_t17 r0 *1 0,0
Rg_vss_m1_mph_g_s1_vss_m1_s2_vss_m1_s3_vss_m1_s4_vss_m1_vss_vss_x1_vss_x2_vss_x3_t17 vss__t17 vss 30.6046545932
* device instance g_vss_m1_mph_g_s1_vss_m1_s2_vss_m1_s3_vss_m1_s4_vss_m1_vss_vss_x1_vss_x2_vss_x3_t18 r0 *1 0,0
Rg_vss_m1_mph_g_s1_vss_m1_s2_vss_m1_s3_vss_m1_s4_vss_m1_vss_vss_x1_vss_x2_vss_x3_t18 vss__t18 vss 14.8582979012
* device instance g_vss_m1_mph_g_s1_vss_m1_s2_vss_m1_s3_vss_m1_s4_vss_m1_vss_vss_x1_vss_x2_vss_x3_t19 r0 *1 0,0
Rg_vss_m1_mph_g_s1_vss_m1_s2_vss_m1_s3_vss_m1_s4_vss_m1_vss_vss_x1_vss_x2_vss_x3_t19 vss__t19 vss 117.732803572
* device instance g_vss_m1_mph_g_s1_vss_m1_s2_vss_m1_s3_vss_m1_s4_vss_m1_vss_vss_x1_vss_x2_vss_x3_t20 r0 *1 0,0
Rg_vss_m1_mph_g_s1_vss_m1_s2_vss_m1_s3_vss_m1_s4_vss_m1_vss_vss_x1_vss_x2_vss_x3_t20 vss__t20 vss 282.408200526
* device instance g_vss_m1_mph_g_s1_vss_m1_s2_vss_m1_s3_vss_m1_s4_vss_m1_vss_vss_x1_vss_x2_vss_x3_t21 r0 *1 0,0
Rg_vss_m1_mph_g_s1_vss_m1_s2_vss_m1_s3_vss_m1_s4_vss_m1_vss_vss_x1_vss_x2_vss_x3_t21 vss__t21 vss 326.166064704
* device instance g_vss_m1_mph_g_s1_vss_m1_s2_vss_m1_s3_vss_m1_s4_vss_m1_vss_vss_x1_vss_x2_vss_x3_t22 r0 *1 0,0
Rg_vss_m1_mph_g_s1_vss_m1_s2_vss_m1_s3_vss_m1_s4_vss_m1_vss_vss_x1_vss_x2_vss_x3_t22 vss__t22 vss 413.686763467
* device instance g_vss_m1_mph_g_s1_vss_m1_s2_vss_m1_s3_vss_m1_s4_vss_m1_vss_vss_x1_vss_x2_vss_x3_t23 r0 *1 0,0
Rg_vss_m1_mph_g_s1_vss_m1_s2_vss_m1_s3_vss_m1_s4_vss_m1_vss_vss_x1_vss_x2_vss_x3_t23 vss__t23 vss 369.925781672
* device instance g_vss_m1_mph_g_s1_vss_m1_s2_vss_m1_s3_vss_m1_s4_vss_m1_vss_vss_x1_vss_x2_vss_x3_t24 r0 *1 0,0
Rg_vss_m1_mph_g_s1_vss_m1_s2_vss_m1_s3_vss_m1_s4_vss_m1_vss_vss_x1_vss_x2_vss_x3_t24 vss__t24 vss 475.154891311
* device instance g_vss_m1_mph_g_s1_vss_m1_s2_vss_m1_s3_vss_m1_s4_vss_m1_vss_vss_x1_vss_x2_vss_x3_t25 r0 *1 0,0
Rg_vss_m1_mph_g_s1_vss_m1_s2_vss_m1_s3_vss_m1_s4_vss_m1_vss_vss_x1_vss_x2_vss_x3_t25 vss__t25 vss 518.866667785
* device instance g_vss_m1_mph_g_s1_vss_m1_s2_vss_m1_s3_vss_m1_s4_vss_m1_vss_vss_x1_vss_x2_vss_x3_t26 r0 *1 0,0
Rg_vss_m1_mph_g_s1_vss_m1_s2_vss_m1_s3_vss_m1_s4_vss_m1_vss_vss_x1_vss_x2_vss_x3_t26 vss__t26 vss 562.586828214
* device instance g_vss_m1_mph_g_s1_vss_m1_s2_vss_m1_s3_vss_m1_s4_vss_m1_vss_vss_x1_vss_x2_vss_x3_t27 r0 *1 0,0
Rg_vss_m1_mph_g_s1_vss_m1_s2_vss_m1_s3_vss_m1_s4_vss_m1_vss_vss_x1_vss_x2_vss_x3_t27 vss__t27 vss 606.313558946
* device instance g_vss_m1_mph_g_s1_vss_m1_s2_vss_m1_s3_vss_m1_s4_vss_m1_vss_vss_x1_vss_x2_vss_x3_t28 r0 *1 0,0
Rg_vss_m1_mph_g_s1_vss_m1_s2_vss_m1_s3_vss_m1_s4_vss_m1_vss_vss_x1_vss_x2_vss_x3_t28 vss__t28 vss 223.588896053
* device instance g_vss_m1_mph_g_s1_vss_m1_s2_vss_m1_s3_vss_m1_s4_vss_m1_vss_vss_x1_vss_x2_vss_x3_t29 r0 *1 0,0
Rg_vss_m1_mph_g_s1_vss_m1_s2_vss_m1_s3_vss_m1_s4_vss_m1_vss_vss_x1_vss_x2_vss_x3_t29 vss__t29 vss 267.131579199
* device instance g_vss_m1_mph_g_s1_vss_m1_s2_vss_m1_s3_vss_m1_s4_vss_m1_vss_vss_x1_vss_x2_vss_x3_t30 r0 *1 0,0
Rg_vss_m1_mph_g_s1_vss_m1_s2_vss_m1_s3_vss_m1_s4_vss_m1_vss_vss_x1_vss_x2_vss_x3_t30 vss__t30 vss 310.736928789
* device instance g_vss_m1_mph_g_s1_vss_m1_s2_vss_m1_s3_vss_m1_s4_vss_m1_vss_vss_x1_vss_x2_vss_x3_t31 r0 *1 0,0
Rg_vss_m1_mph_g_s1_vss_m1_s2_vss_m1_s3_vss_m1_s4_vss_m1_vss_vss_x1_vss_x2_vss_x3_t31 vss__t31 vss 180.154323876
* device instance g_vss_m1_mph_g_s1_vss_m1_s2_vss_m1_s3_vss_m1_s4_vss_m1_vss_vss_x1_vss_x2_vss_x3_t32 r0 *1 0,0
Rg_vss_m1_mph_g_s1_vss_m1_s2_vss_m1_s3_vss_m1_s4_vss_m1_vss_vss_x1_vss_x2_vss_x3_t32 vss__t32 vss 28.1940391363
* device instance g_vss_m1_mph_g_s1_vss_m1_s2_vss_m1_s3_vss_m1_s4_vss_m1_vss_vss_x1_vss_x2_vss_x3_t33 r0 *1 0,0
Rg_vss_m1_mph_g_s1_vss_m1_s2_vss_m1_s3_vss_m1_s4_vss_m1_vss_vss_x1_vss_x2_vss_x3_t33 vss__t33 vss 77.8301208781
* device instance g_vss_m1_mph_g_s1_vss_m1_s2_vss_m1_s3_vss_m1_s4_vss_m1_vss_vss_x1_vss_x2_vss_x3_t34 r0 *1 0,0
Rg_vss_m1_mph_g_s1_vss_m1_s2_vss_m1_s3_vss_m1_s4_vss_m1_vss_vss_x1_vss_x2_vss_x3_t34 vss__t34 vss 38.868749775
* device instance g_vss_m1_mph_g_s1_vss_m1_s2_vss_m1_s3_vss_m1_s4_vss_m1_vss_vss_x1_vss_x2_vss_x3_t35 r0 *1 0,0
Rg_vss_m1_mph_g_s1_vss_m1_s2_vss_m1_s3_vss_m1_s4_vss_m1_vss_vss_x1_vss_x2_vss_x3_t35 vss__t35 vss 120.146360175
* device instance g_vss_m1_mph_g_s1_vss_m1_s2_vss_m1_s3_vss_m1_s4_vss_m1_vss_vss_x1_vss_x2_vss_x3_t36 r0 *1 0,0
Rg_vss_m1_mph_g_s1_vss_m1_s2_vss_m1_s3_vss_m1_s4_vss_m1_vss_vss_x1_vss_x2_vss_x3_t36 vss__t36 vss 371.740881829
* device instance g_vss_m1_mph_g_s1_vss_m1_s2_vss_m1_s3_vss_m1_s4_vss_m1_vss_vss_x1_vss_x2_vss_x3_t37 r0 *1 0,0
Rg_vss_m1_mph_g_s1_vss_m1_s2_vss_m1_s3_vss_m1_s4_vss_m1_vss_vss_x1_vss_x2_vss_x3_t37 vss__t37 vss 469.57949473
* device instance g_vss_m1_mph_g_s1_vss_m1_s2_vss_m1_s3_vss_m1_s4_vss_m1_vss_vss_x1_vss_x2_vss_x3_t38 r0 *1 0,0
Rg_vss_m1_mph_g_s1_vss_m1_s2_vss_m1_s3_vss_m1_s4_vss_m1_vss_vss_x1_vss_x2_vss_x3_t38 vss__t38 vss 78.8194046975
* device instance g_vss_m1_mph_g_s1_vss_m1_s2_vss_m1_s3_vss_m1_s4_vss_m1_vss_vss_x1_vss_x2_vss_x3_t39 r0 *1 0,0
Rg_vss_m1_mph_g_s1_vss_m1_s2_vss_m1_s3_vss_m1_s4_vss_m1_vss_vss_x1_vss_x2_vss_x3_t39 vss__t39 vss 373.650240334
* device instance g_vss_m1_mph_g_s1_vss_m1_s2_vss_m1_s3_vss_m1_s4_vss_m1_vss_vss_x1_vss_x2_vss_x3_t40 r0 *1 0,0
Rg_vss_m1_mph_g_s1_vss_m1_s2_vss_m1_s3_vss_m1_s4_vss_m1_vss_vss_x1_vss_x2_vss_x3_t40 vss__t40 vss 317.069450978
* device instance g_vss_m1_mph_g_s1_vss_m1_s2_vss_m1_s3_vss_m1_s4_vss_m1_vss_vss_x1_vss_x2_vss_x3_t41 r0 *1 0,0
Rg_vss_m1_mph_g_s1_vss_m1_s2_vss_m1_s3_vss_m1_s4_vss_m1_vss_vss_x1_vss_x2_vss_x3_t41 vss__t41 vss 222.553076072
* device instance g_vss_m1_mph_g_s1_vss_m1_s2_vss_m1_s3_vss_m1_s4_vss_m1_vss_vss_x1_vss_x2_vss_x3_t42 r0 *1 0,0
Rg_vss_m1_mph_g_s1_vss_m1_s2_vss_m1_s3_vss_m1_s4_vss_m1_vss_vss_x1_vss_x2_vss_x3_t42 vss__t42 vss 223.213868032
* device instance g_vss_m1_mph_g_s1_vss_m1_s2_vss_m1_s3_vss_m1_s4_vss_m1_vss_vss_x1_vss_x2_vss_x3_t43 r0 *1 0,0
Rg_vss_m1_mph_g_s1_vss_m1_s2_vss_m1_s3_vss_m1_s4_vss_m1_vss_vss_x1_vss_x2_vss_x3_t43 vss__t43 vss 169.320328119
* device instance g_vss_m1_mph_g_s1_vss_m1_s2_vss_m1_s3_vss_m1_s4_vss_m1_vss_vss_x1_vss_x2_vss_x3_t44 r0 *1 0,0
Rg_vss_m1_mph_g_s1_vss_m1_s2_vss_m1_s3_vss_m1_s4_vss_m1_vss_vss_x1_vss_x2_vss_x3_t44 vss__t44 vss 667.432562636
* device instance g_vss_m1_mph_g_s1_vss_m1_s2_vss_m1_s3_vss_m1_s4_vss_m1_vss_vss_x1_vss_x2_vss_x3_t45 r0 *1 0,0
Rg_vss_m1_mph_g_s1_vss_m1_s2_vss_m1_s3_vss_m1_s4_vss_m1_vss_vss_x1_vss_x2_vss_x3_t45 vss__t45 vss 90.2361433158
* device instance g_vss_m1_mph_g_s1_vss_m1_s2_vss_m1_s3_vss_m1_s4_vss_m1_vss_vss_x1_vss_x2_vss_x3_t46 r0 *1 0,0
Rg_vss_m1_mph_g_s1_vss_m1_s2_vss_m1_s3_vss_m1_s4_vss_m1_vss_vss_x1_vss_x2_vss_x3_t46 vss__t46 vss 414.38010702
* device instance g_vss_m1_mph_g_s1_vss_m1_s2_vss_m1_s3_vss_m1_s4_vss_m1_vss_vss_x1_vss_x2_vss_x3_t47 r0 *1 0,0
Rg_vss_m1_mph_g_s1_vss_m1_s2_vss_m1_s3_vss_m1_s4_vss_m1_vss_vss_x1_vss_x2_vss_x3_t47 vss__t47 vss 370.700982966
* device instance g_vss_m1_mph_g_s1_vss_m1_s2_vss_m1_s3_vss_m1_s4_vss_m1_vss_vss_x1_vss_x2_vss_x3_t48 r0 *1 0,0
Rg_vss_m1_mph_g_s1_vss_m1_s2_vss_m1_s3_vss_m1_s4_vss_m1_vss_vss_x1_vss_x2_vss_x3_t48 vss__t48 vss 283.422875842
* device instance g_vss_m1_mph_g_s1_vss_m1_s2_vss_m1_s3_vss_m1_s4_vss_m1_vss_vss_x1_vss_x2_vss_x3_t49 r0 *1 0,0
Rg_vss_m1_mph_g_s1_vss_m1_s2_vss_m1_s3_vss_m1_s4_vss_m1_vss_vss_x1_vss_x2_vss_x3_t49 vss__t49 vss 327.045006981
* device instance g_vss_m1_mph_g_s1_vss_m1_s2_vss_m1_s3_vss_m1_s4_vss_m1_vss_vss_x1_vss_x2_vss_x3_t50 r0 *1 0,0
Rg_vss_m1_mph_g_s1_vss_m1_s2_vss_m1_s3_vss_m1_s4_vss_m1_vss_vss_x1_vss_x2_vss_x3_t50 vss__t50 vss 441.308666348
* device instance g_vss_m1_mph_g_s1_vss_m1_s2_vss_m1_s3_vss_m1_s4_vss_m1_vss_vss_x1_vss_x2_vss_x3_t51 r0 *1 0,0
Rg_vss_m1_mph_g_s1_vss_m1_s2_vss_m1_s3_vss_m1_s4_vss_m1_vss_vss_x1_vss_x2_vss_x3_t51 vss__t51 vss 106.775992962
* device instance g_vss_m1_mph_g_s1_vss_m1_s2_vss_m1_s3_vss_m1_s4_vss_m1_vss_vss_x1_vss_x2_vss_x3_t52 r0 *1 0,0
Rg_vss_m1_mph_g_s1_vss_m1_s2_vss_m1_s3_vss_m1_s4_vss_m1_vss_vss_x1_vss_x2_vss_x3_t52 vss__t52 vss 139.787806446
* device instance g_vss_m1_mph_g_s1_vss_m1_s2_vss_m1_s3_vss_m1_s4_vss_m1_vss_vss_x1_vss_x2_vss_x3_t53 r0 *1 0,0
Rg_vss_m1_mph_g_s1_vss_m1_s2_vss_m1_s3_vss_m1_s4_vss_m1_vss_vss_x1_vss_x2_vss_x3_t53 vss__t53 vss 404.184513886
* device instance g_vss_m1_mph_g_s1_vss_m1_s2_vss_m1_s3_vss_m1_s4_vss_m1_vss_vss_x1_vss_x2_vss_x3_t54 r0 *1 0,0
Rg_vss_m1_mph_g_s1_vss_m1_s2_vss_m1_s3_vss_m1_s4_vss_m1_vss_vss_x1_vss_x2_vss_x3_t54 vss__t54 vss 251.652570064
* device instance g_vss_m1_mph_g_s1_vss_m1_s2_vss_m1_s3_vss_m1_s4_vss_m1_vss_vss_x1_vss_x2_vss_x3_t55 r0 *1 0,0
Rg_vss_m1_mph_g_s1_vss_m1_s2_vss_m1_s3_vss_m1_s4_vss_m1_vss_vss_x1_vss_x2_vss_x3_t55 vss__t55 vss 288.258363215
* device instance g_vss_m1_mph_g_s1_vss_m1_s2_vss_m1_s3_vss_m1_s4_vss_m1_vss_vss_x1_vss_x2_vss_x3_t56 r0 *1 0,0
Rg_vss_m1_mph_g_s1_vss_m1_s2_vss_m1_s3_vss_m1_s4_vss_m1_vss_vss_x1_vss_x2_vss_x3_t56 vss__t56 vss 450.110642972
* device instance g_vss_m1_mph_g_s1_vss_m1_s2_vss_m1_s3_vss_m1_s4_vss_m1_vss_vss_x1_vss_x2_vss_x3_t57 r0 *1 0,0
Rg_vss_m1_mph_g_s1_vss_m1_s2_vss_m1_s3_vss_m1_s4_vss_m1_vss_vss_x1_vss_x2_vss_x3_t57 vss__t57 vss 155.347999805
* device instance g_vss_m1_mph_g_s1_vss_m1_s2_vss_m1_s3_vss_m1_s4_vss_m1_vss_vss_x1_vss_x2_vss_x3_t58 r0 *1 0,0
Rg_vss_m1_mph_g_s1_vss_m1_s2_vss_m1_s3_vss_m1_s4_vss_m1_vss_vss_x1_vss_x2_vss_x3_t58 vss__t58 vss 144.784560463
* device instance g_vss_m1_mph_g_s1_vss_m1_s2_vss_m1_s3_vss_m1_s4_vss_m1_vss_vss_x1_vss_x2_vss_x3_t59 r0 *1 0,0
Rg_vss_m1_mph_g_s1_vss_m1_s2_vss_m1_s3_vss_m1_s4_vss_m1_vss_vss_x1_vss_x2_vss_x3_t59 vss__t59 vss 439.418131888
* device instance g_vss_m1_mph_g_s1_vss_m1_s2_vss_m1_s3_vss_m1_s4_vss_m1_vss_vss_x1_vss_x2_vss_x3_t60 r0 *1 0,0
Rg_vss_m1_mph_g_s1_vss_m1_s2_vss_m1_s3_vss_m1_s4_vss_m1_vss_vss_x1_vss_x2_vss_x3_t60 vss__t60 vss 444.865065068
* device instance g_vss_m1_mph_g_s1_vss_m1_s2_vss_m1_s3_vss_m1_s4_vss_m1_vss_vss_x1_vss_x2_vss_x3_t61 r0 *1 0,0
Rg_vss_m1_mph_g_s1_vss_m1_s2_vss_m1_s3_vss_m1_s4_vss_m1_vss_vss_x1_vss_x2_vss_x3_t61 vss__t61 vss 407.735045972
* device instance g_vss_m1_mph_g_s1_vss_m1_s2_vss_m1_s3_vss_m1_s4_vss_m1_vss_vss_x1_vss_x2_vss_x3_t62 r0 *1 0,0
Rg_vss_m1_mph_g_s1_vss_m1_s2_vss_m1_s3_vss_m1_s4_vss_m1_vss_vss_x1_vss_x2_vss_x3_t62 vss__t62 vss 291.773636147
* device instance g_vss_m1_mph_g_s1_vss_m1_s2_vss_m1_s3_vss_m1_s4_vss_m1_vss_vss_x1_vss_x2_vss_x3_t63 r0 *1 0,0
Rg_vss_m1_mph_g_s1_vss_m1_s2_vss_m1_s3_vss_m1_s4_vss_m1_vss_vss_x1_vss_x2_vss_x3_t63 vss__t63 vss 255.145343152
* device instance g_vss_m1_mph_g_s1_vss_m1_s2_vss_m1_s3_vss_m1_s4_vss_m1_vss_vss_x1_vss_x2_vss_x3_t64 r0 *1 0,0
Rg_vss_m1_mph_g_s1_vss_m1_s2_vss_m1_s3_vss_m1_s4_vss_m1_vss_vss_x1_vss_x2_vss_x3_t64 vss__t64 vss 143.062871779
* device instance g_vss_m1_mph_g_s1_vss_m1_s2_vss_m1_s3_vss_m1_s4_vss_m1_vss_vss_x1_vss_x2_vss_x3_t65 r0 *1 0,0
Rg_vss_m1_mph_g_s1_vss_m1_s2_vss_m1_s3_vss_m1_s4_vss_m1_vss_vss_x1_vss_x2_vss_x3_t65 vss__t65 vss 109.811777368
* device instance g_vss_m1_mph_g_s1_vss_m1_s2_vss_m1_s3_vss_m1_s4_vss_m1_vss_vss_x1_vss_x2_vss_x3_t66 r0 *1 0,0
Rg_vss_m1_mph_g_s1_vss_m1_s2_vss_m1_s3_vss_m1_s4_vss_m1_vss_vss_x1_vss_x2_vss_x3_t66 vss__t66 vss 446.529151072
* device instance g_vss_m1_mph_g_s1_vss_m1_s2_vss_m1_s3_vss_m1_s4_vss_m1_vss_vss_x1_vss_x2_vss_x3_t67 r0 *1 0,0
Rg_vss_m1_mph_g_s1_vss_m1_s2_vss_m1_s3_vss_m1_s4_vss_m1_vss_vss_x1_vss_x2_vss_x3_t67 vss__t67 vss 151.807556521
* device instance g_vss_m1_mph_g_s1_vss_m1_s2_vss_m1_s3_vss_m1_s4_vss_m1_vss_vss_x1_vss_x2_vss_x3_t68 r0 *1 0,0
Rg_vss_m1_mph_g_s1_vss_m1_s2_vss_m1_s3_vss_m1_s4_vss_m1_vss_vss_x1_vss_x2_vss_x3_t68 vss__t68 vss 148.320408086
* device instance g_vss_m1_mph_g_s1_vss_m1_s2_vss_m1_s3_vss_m1_s4_vss_m1_vss_vss_x1_vss_x2_vss_x3_t69 r0 *1 0,0
Rg_vss_m1_mph_g_s1_vss_m1_s2_vss_m1_s3_vss_m1_s4_vss_m1_vss_vss_x1_vss_x2_vss_x3_t69 vss__t69 vss 442.999447484
* device instance g_vss_m1_mph_g_s1_vss_m1_s2_vss_m1_s3_vss_m1_s4_vss_m1_vss_vss_x1_vss_x2_vss_x3_t70 r0 *1 0,0
Rg_vss_m1_mph_g_s1_vss_m1_s2_vss_m1_s3_vss_m1_s4_vss_m1_vss_vss_x1_vss_x2_vss_x3_t70 vss__t70 vss 441.308666348
* device instance g_vss_m1_mph_g_s1_vss_m1_s2_vss_m1_s3_vss_m1_s4_vss_m1_vss_vss_x1_vss_x2_vss_x3_t71 r0 *1 0,0
Rg_vss_m1_mph_g_s1_vss_m1_s2_vss_m1_s3_vss_m1_s4_vss_m1_vss_vss_x1_vss_x2_vss_x3_t71 vss__t71 vss 404.184513886
* device instance g_vss_m1_mph_g_s1_vss_m1_s2_vss_m1_s3_vss_m1_s4_vss_m1_vss_vss_x1_vss_x2_vss_x3_t72 r0 *1 0,0
Rg_vss_m1_mph_g_s1_vss_m1_s2_vss_m1_s3_vss_m1_s4_vss_m1_vss_vss_x1_vss_x2_vss_x3_t72 vss__t72 vss 288.258363215
* device instance g_vss_m1_mph_g_s1_vss_m1_s2_vss_m1_s3_vss_m1_s4_vss_m1_vss_vss_x1_vss_x2_vss_x3_t73 r0 *1 0,0
Rg_vss_m1_mph_g_s1_vss_m1_s2_vss_m1_s3_vss_m1_s4_vss_m1_vss_vss_x1_vss_x2_vss_x3_t73 vss__t73 vss 251.652570064
* device instance g_vss_m1_mph_g_s1_vss_m1_s2_vss_m1_s3_vss_m1_s4_vss_m1_vss_vss_x1_vss_x2_vss_x3_t74 r0 *1 0,0
Rg_vss_m1_mph_g_s1_vss_m1_s2_vss_m1_s3_vss_m1_s4_vss_m1_vss_vss_x1_vss_x2_vss_x3_t74 vss__t74 vss 139.787806446
* device instance g_vss_m1_mph_g_s1_vss_m1_s2_vss_m1_s3_vss_m1_s4_vss_m1_vss_vss_x1_vss_x2_vss_x3_t75 r0 *1 0,0
Rg_vss_m1_mph_g_s1_vss_m1_s2_vss_m1_s3_vss_m1_s4_vss_m1_vss_vss_x1_vss_x2_vss_x3_t75 vss__t75 vss 106.775992962
* device instance g_vss_m1_mph_g_s1_vss_m1_s2_vss_m1_s3_vss_m1_s4_vss_m1_vss_vss_x1_vss_x2_vss_x3_t76 r0 *1 0,0
Rg_vss_m1_mph_g_s1_vss_m1_s2_vss_m1_s3_vss_m1_s4_vss_m1_vss_vss_x1_vss_x2_vss_x3_t76 vss__t76 vss 131.0107669
* device instance g_vss_m1_mph_g_s1_vss_m1_s2_vss_m1_s3_vss_m1_s4_vss_m1_vss_vss_x1_vss_x2_vss_x3_t77 r0 *1 0,0
Rg_vss_m1_mph_g_s1_vss_m1_s2_vss_m1_s3_vss_m1_s4_vss_m1_vss_vss_x1_vss_x2_vss_x3_t77 vss__t77 vss 180.154323876
* device instance g_vss_m1_mph_g_s1_vss_m1_s2_vss_m1_s3_vss_m1_s4_vss_m1_vss_vss_x1_vss_x2_vss_x3_t78 r0 *1 0,0
Rg_vss_m1_mph_g_s1_vss_m1_s2_vss_m1_s3_vss_m1_s4_vss_m1_vss_vss_x1_vss_x2_vss_x3_t78 vss__t78 vss 223.588896053
* device instance g_vss_m1_mph_g_s1_vss_m1_s2_vss_m1_s3_vss_m1_s4_vss_m1_vss_vss_x1_vss_x2_vss_x3_t79 r0 *1 0,0
Rg_vss_m1_mph_g_s1_vss_m1_s2_vss_m1_s3_vss_m1_s4_vss_m1_vss_vss_x1_vss_x2_vss_x3_t79 vss__t79 vss 267.131579199
* device instance g_vss_m1_mph_g_s1_vss_m1_s2_vss_m1_s3_vss_m1_s4_vss_m1_vss_vss_x1_vss_x2_vss_x3_t80 r0 *1 0,0
Rg_vss_m1_mph_g_s1_vss_m1_s2_vss_m1_s3_vss_m1_s4_vss_m1_vss_vss_x1_vss_x2_vss_x3_t80 vss__t80 vss 310.736928789
* device instance g_vss_m1_mph_g_s1_vss_m1_s2_vss_m1_s3_vss_m1_s4_vss_m1_vss_vss_x1_vss_x2_vss_x3_t81 r0 *1 0,0
Rg_vss_m1_mph_g_s1_vss_m1_s2_vss_m1_s3_vss_m1_s4_vss_m1_vss_vss_x1_vss_x2_vss_x3_t81 vss__t81 vss 425.441212982
* device instance g_vss_m1_mph_g_s1_vss_m1_s2_vss_m1_s3_vss_m1_s4_vss_m1_vss_vss_x1_vss_x2_vss_x3_t82 r0 *1 0,0
Rg_vss_m1_mph_g_s1_vss_m1_s2_vss_m1_s3_vss_m1_s4_vss_m1_vss_vss_x1_vss_x2_vss_x3_t82 vss__t82 vss 475.154891311
* device instance g_vss_m1_mph_g_s1_vss_m1_s2_vss_m1_s3_vss_m1_s4_vss_m1_vss_vss_x1_vss_x2_vss_x3_t83 r0 *1 0,0
Rg_vss_m1_mph_g_s1_vss_m1_s2_vss_m1_s3_vss_m1_s4_vss_m1_vss_vss_x1_vss_x2_vss_x3_t83 vss__t83 vss 518.866667785
* device instance g_vss_m1_mph_g_s1_vss_m1_s2_vss_m1_s3_vss_m1_s4_vss_m1_vss_vss_x1_vss_x2_vss_x3_t84 r0 *1 0,0
Rg_vss_m1_mph_g_s1_vss_m1_s2_vss_m1_s3_vss_m1_s4_vss_m1_vss_vss_x1_vss_x2_vss_x3_t84 vss__t84 vss 562.586828214
* device instance g_vss_m1_mph_g_s1_vss_m1_s2_vss_m1_s3_vss_m1_s4_vss_m1_vss_vss_x1_vss_x2_vss_x3_t85 r0 *1 0,0
Rg_vss_m1_mph_g_s1_vss_m1_s2_vss_m1_s3_vss_m1_s4_vss_m1_vss_vss_x1_vss_x2_vss_x3_t85 vss__t85 vss 606.313558946
* device instance g_vss_m1_mph_g_s1_vss_m1_s2_vss_m1_s3_vss_m1_s4_vss_m1_vss_vss_x1_vss_x2_vss_x3_t86 r0 *1 0,0
Rg_vss_m1_mph_g_s1_vss_m1_s2_vss_m1_s3_vss_m1_s4_vss_m1_vss_vss_x1_vss_x2_vss_x3_t86 vss__t86 vss 464.089953628
* device instance g_vss_m1_mph_g_s1_vss_m1_s2_vss_m1_s3_vss_m1_s4_vss_m1_vss_vss_x1_vss_x2_vss_x3_t87 r0 *1 0,0
Rg_vss_m1_mph_g_s1_vss_m1_s2_vss_m1_s3_vss_m1_s4_vss_m1_vss_vss_x1_vss_x2_vss_x3_t87 vss__t87 vss 414.38010702
* device instance g_vss_m1_mph_g_s1_vss_m1_s2_vss_m1_s3_vss_m1_s4_vss_m1_vss_vss_x1_vss_x2_vss_x3_t88 r0 *1 0,0
Rg_vss_m1_mph_g_s1_vss_m1_s2_vss_m1_s3_vss_m1_s4_vss_m1_vss_vss_x1_vss_x2_vss_x3_t88 vss__t88 vss 370.700982966
* device instance g_vss_m1_mph_g_s1_vss_m1_s2_vss_m1_s3_vss_m1_s4_vss_m1_vss_vss_x1_vss_x2_vss_x3_t89 r0 *1 0,0
Rg_vss_m1_mph_g_s1_vss_m1_s2_vss_m1_s3_vss_m1_s4_vss_m1_vss_vss_x1_vss_x2_vss_x3_t89 vss__t89 vss 327.045006981
* device instance g_vss_m1_mph_g_s1_vss_m1_s2_vss_m1_s3_vss_m1_s4_vss_m1_vss_vss_x1_vss_x2_vss_x3_t90 r0 *1 0,0
Rg_vss_m1_mph_g_s1_vss_m1_s2_vss_m1_s3_vss_m1_s4_vss_m1_vss_vss_x1_vss_x2_vss_x3_t90 vss__t90 vss 283.422875842
* device instance g_vss_m1_mph_g_s1_vss_m1_s2_vss_m1_s3_vss_m1_s4_vss_m1_vss_vss_x1_vss_x2_vss_x3_t91 r0 *1 0,0
Rg_vss_m1_mph_g_s1_vss_m1_s2_vss_m1_s3_vss_m1_s4_vss_m1_vss_vss_x1_vss_x2_vss_x3_t91 vss__t91 vss 400.459508327
* device instance g_vss_m1_mph_g_s1_vss_m1_s2_vss_m1_s3_vss_m1_s4_vss_m1_vss_vss_x1_vss_x2_vss_x3_t92 r0 *1 0,0
Rg_vss_m1_mph_g_s1_vss_m1_s2_vss_m1_s3_vss_m1_s4_vss_m1_vss_vss_x1_vss_x2_vss_x3_t92 vss__t92 vss 356.786894214
* device instance g_vss_m1_mph_g_s1_vss_m1_s2_vss_m1_s3_vss_m1_s4_vss_m1_vss_vss_x1_vss_x2_vss_x3_t93 r0 *1 0,0
Rg_vss_m1_mph_g_s1_vss_m1_s2_vss_m1_s3_vss_m1_s4_vss_m1_vss_vss_x1_vss_x2_vss_x3_t93 vss__t93 vss 313.140272236
* device instance g_vss_m1_mph_g_s1_vss_m1_s2_vss_m1_s3_vss_m1_s4_vss_m1_vss_vss_x1_vss_x2_vss_x3_t94 r0 *1 0,0
Rg_vss_m1_mph_g_s1_vss_m1_s2_vss_m1_s3_vss_m1_s4_vss_m1_vss_vss_x1_vss_x2_vss_x3_t94 vss__t94 vss 269.532269775
* device instance g_vss_m1_mph_g_s1_vss_m1_s2_vss_m1_s3_vss_m1_s4_vss_m1_vss_vss_x1_vss_x2_vss_x3_t95 r0 *1 0,0
Rg_vss_m1_mph_g_s1_vss_m1_s2_vss_m1_s3_vss_m1_s4_vss_m1_vss_vss_x1_vss_x2_vss_x3_t95 vss__t95 vss 222.553076072
* device instance g_vss_m1_mph_g_s1_vss_m1_s2_vss_m1_s3_vss_m1_s4_vss_m1_vss_vss_x1_vss_x2_vss_x3_t96 r0 *1 0,0
Rg_vss_m1_mph_g_s1_vss_m1_s2_vss_m1_s3_vss_m1_s4_vss_m1_vss_vss_x1_vss_x2_vss_x3_t96 vss__t96 vss 106.535038735
* device instance g_vss_m1_mph_g_s1_vss_m1_s2_vss_m1_s3_vss_m1_s4_vss_m1_vss_vss_x1_vss_x2_vss_x3_t97 r0 *1 0,0
Rg_vss_m1_mph_g_s1_vss_m1_s2_vss_m1_s3_vss_m1_s4_vss_m1_vss_vss_x1_vss_x2_vss_x3_t97 vss__t97 vss 64.7519785448
* device instance g_vss_m1_mph_g_s1_vss_m1_s2_vss_m1_s3_vss_m1_s4_vss_m1_vss_vss_x1_vss_x2_vss_x3_t98 r0 *1 0,0
Rg_vss_m1_mph_g_s1_vss_m1_s2_vss_m1_s3_vss_m1_s4_vss_m1_vss_vss_x1_vss_x2_vss_x3_t98 vss__t98 vss 29.441384364
* device instance g_vss_m1_mph_g_s1_vss_m1_s2_vss_m1_s3_vss_m1_s4_vss_m1_vss_vss_x1_vss_x2_vss_x3_t99 r0 *1 0,0
Rg_vss_m1_mph_g_s1_vss_m1_s2_vss_m1_s3_vss_m1_s4_vss_m1_vss_vss_x1_vss_x2_vss_x3_t99 vss__t99 vss 37.0357076572
* device instance g_vss_m1_mph_g_s1_vss_m1_s2_vss_m1_s3_vss_m1_s4_vss_m1_vss_vss_x1_vss_x2_vss_x3_t100 r0 *1 0,0
Rg_vss_m1_mph_g_s1_vss_m1_s2_vss_m1_s3_vss_m1_s4_vss_m1_vss_vss_x1_vss_x2_vss_x3_t100 vss__t100 vss 78.8194046975
* device instance g_vss_m1_mph_g_s1_vss_m1_s2_vss_m1_s3_vss_m1_s4_vss_m1_vss_vss_x1_vss_x2_vss_x3_t101 r0 *1 0,0
Rg_vss_m1_mph_g_s1_vss_m1_s2_vss_m1_s3_vss_m1_s4_vss_m1_vss_vss_x1_vss_x2_vss_x3_t101 vss__t101 vss 193.978784729
* device instance g_vss_m1_mph_g_s1_vss_m1_s2_vss_m1_s3_vss_m1_s4_vss_m1_vss_vss_x1_vss_x2_vss_x3_t102 r0 *1 0,0
Rg_vss_m1_mph_g_s1_vss_m1_s2_vss_m1_s3_vss_m1_s4_vss_m1_vss_vss_x1_vss_x2_vss_x3_t102 vss__t102 vss 237.455063847
* device instance g_vss_m1_mph_g_s1_vss_m1_s2_vss_m1_s3_vss_m1_s4_vss_m1_vss_vss_x1_vss_x2_vss_x3_t103 r0 *1 0,0
Rg_vss_m1_mph_g_s1_vss_m1_s2_vss_m1_s3_vss_m1_s4_vss_m1_vss_vss_x1_vss_x2_vss_x3_t103 vss__t103 vss 281.021205443
* device instance g_vss_m1_mph_g_s1_vss_m1_s2_vss_m1_s3_vss_m1_s4_vss_m1_vss_vss_x1_vss_x2_vss_x3_t104 r0 *1 0,0
Rg_vss_m1_mph_g_s1_vss_m1_s2_vss_m1_s3_vss_m1_s4_vss_m1_vss_vss_x1_vss_x2_vss_x3_t104 vss__t104 vss 324.641033468
* device instance g_vss_m1_mph_g_s1_vss_m1_s2_vss_m1_s3_vss_m1_s4_vss_m1_vss_vss_x1_vss_x2_vss_x3_t105 r0 *1 0,0
Rg_vss_m1_mph_g_s1_vss_m1_s2_vss_m1_s3_vss_m1_s4_vss_m1_vss_vss_x1_vss_x2_vss_x3_t105 vss__t105 vss 371.740881829
* device instance g_vss_m1_mph_g_s1_vss_m1_s2_vss_m1_s3_vss_m1_s4_vss_m1_vss_vss_x1_vss_x2_vss_x3_t106 r0 *1 0,0
Rg_vss_m1_mph_g_s1_vss_m1_s2_vss_m1_s3_vss_m1_s4_vss_m1_vss_vss_x1_vss_x2_vss_x3_t106 vss__t106 vss 489.082795803
* device instance g_vss_m1_mph_g_s1_vss_m1_s2_vss_m1_s3_vss_m1_s4_vss_m1_vss_vss_x1_vss_x2_vss_x3_t107 r0 *1 0,0
Rg_vss_m1_mph_g_s1_vss_m1_s2_vss_m1_s3_vss_m1_s4_vss_m1_vss_vss_x1_vss_x2_vss_x3_t107 vss__t107 vss 532.79747911
* device instance g_vss_m1_mph_g_s1_vss_m1_s2_vss_m1_s3_vss_m1_s4_vss_m1_vss_vss_x1_vss_x2_vss_x3_t108 r0 *1 0,0
Rg_vss_m1_mph_g_s1_vss_m1_s2_vss_m1_s3_vss_m1_s4_vss_m1_vss_vss_x1_vss_x2_vss_x3_t108 vss__t108 vss 576.519902937
* device instance g_vss_m1_mph_g_s1_vss_m1_s2_vss_m1_s3_vss_m1_s4_vss_m1_vss_vss_x1_vss_x2_vss_x3_t109 r0 *1 0,0
Rg_vss_m1_mph_g_s1_vss_m1_s2_vss_m1_s3_vss_m1_s4_vss_m1_vss_vss_x1_vss_x2_vss_x3_t109 vss__t109 vss 620.248430356
* device instance g_vss_m1_mph_g_s1_vss_m1_s2_vss_m1_s3_vss_m1_s4_vss_m1_vss_vss_x1_vss_x2_vss_x3_t110 r0 *1 0,0
Rg_vss_m1_mph_g_s1_vss_m1_s2_vss_m1_s3_vss_m1_s4_vss_m1_vss_vss_x1_vss_x2_vss_x3_t110 vss__t110 vss 667.432562636
* device instance g_vss_m1_mph_g_s1_vss_m1_s2_vss_m1_s3_vss_m1_s4_vss_m1_vss_vss_x1_vss_x2_vss_x3_t111 r0 *1 0,0
Rg_vss_m1_mph_g_s1_vss_m1_s2_vss_m1_s3_vss_m1_s4_vss_m1_vss_vss_x1_vss_x2_vss_x3_t111 vss__t111 vss 469.57949473
* device instance g_vss_m1_mph_g_s1_vss_m1_s2_vss_m1_s3_vss_m1_s4_vss_m1_vss_vss_x1_vss_x2_vss_x3_t112 r0 *1 0,0
Rg_vss_m1_mph_g_s1_vss_m1_s2_vss_m1_s3_vss_m1_s4_vss_m1_vss_vss_x1_vss_x2_vss_x3_t112 vss__t112 vss 373.650240334
* device instance g_vss_m1_mph_g_s1_vss_m1_s2_vss_m1_s3_vss_m1_s4_vss_m1_vss_vss_x1_vss_x2_vss_x3_t113 r0 *1 0,0
Rg_vss_m1_mph_g_s1_vss_m1_s2_vss_m1_s3_vss_m1_s4_vss_m1_vss_vss_x1_vss_x2_vss_x3_t113 vss__t113 vss 317.069450978
* device instance g_vss_m1_mph_g_s1_vss_m1_s2_vss_m1_s3_vss_m1_s4_vss_m1_vss_vss_x1_vss_x2_vss_x3_t114 r0 *1 0,0
Rg_vss_m1_mph_g_s1_vss_m1_s2_vss_m1_s3_vss_m1_s4_vss_m1_vss_vss_x1_vss_x2_vss_x3_t114 vss__t114 vss 223.213868032
* device instance g_vss_m1_mph_g_s1_vss_m1_s2_vss_m1_s3_vss_m1_s4_vss_m1_vss_vss_x1_vss_x2_vss_x3_t115 r0 *1 0,0
Rg_vss_m1_mph_g_s1_vss_m1_s2_vss_m1_s3_vss_m1_s4_vss_m1_vss_vss_x1_vss_x2_vss_x3_t115 vss__t115 vss 169.320328119
* device instance g_vss_m1_mph_g_s1_vss_m1_s2_vss_m1_s3_vss_m1_s4_vss_m1_vss_vss_x1_vss_x2_vss_x3_t116 r0 *1 0,0
Rg_vss_m1_mph_g_s1_vss_m1_s2_vss_m1_s3_vss_m1_s4_vss_m1_vss_vss_x1_vss_x2_vss_x3_t116 vss__t116 vss 90.2361433158
* device instance g_vss_m1_mph_g_s1_vss_m1_s2_vss_m1_s3_vss_m1_s4_vss_m1_vss_vss_x1_vss_x2_vss_x3_t117 r0 *1 0,0
Rg_vss_m1_mph_g_s1_vss_m1_s2_vss_m1_s3_vss_m1_s4_vss_m1_vss_vss_x1_vss_x2_vss_x3_t117 vss__t117 vss 169.185029368
* device instance g_vss_m1_mph_g_s1_vss_m1_s2_vss_m1_s3_vss_m1_s4_vss_m1_vss_vss_x1_vss_x2_vss_x3_t118 r0 *1 0,0
Rg_vss_m1_mph_g_s1_vss_m1_s2_vss_m1_s3_vss_m1_s4_vss_m1_vss_vss_x1_vss_x2_vss_x3_t118 vss__t118 vss 120.146360175
* device instance g_vss_m1_mph_g_s1_vss_m1_s2_vss_m1_s3_vss_m1_s4_vss_m1_vss_vss_x1_vss_x2_vss_x3_t119 r0 *1 0,0
Rg_vss_m1_mph_g_s1_vss_m1_s2_vss_m1_s3_vss_m1_s4_vss_m1_vss_vss_x1_vss_x2_vss_x3_t119 vss__t119 vss 77.8301208781
* device instance g_vss_m1_mph_g_s1_vss_m1_s2_vss_m1_s3_vss_m1_s4_vss_m1_vss_vss_x1_vss_x2_vss_x3_t120 r0 *1 0,0
Rg_vss_m1_mph_g_s1_vss_m1_s2_vss_m1_s3_vss_m1_s4_vss_m1_vss_vss_x1_vss_x2_vss_x3_t120 vss__t120 vss 38.868749775
* device instance g_vss_m1_mph_g_s1_vss_m1_s2_vss_m1_s3_vss_m1_s4_vss_m1_vss_vss_x1_vss_x2_vss_x3_t121 r0 *1 0,0
Rg_vss_m1_mph_g_s1_vss_m1_s2_vss_m1_s3_vss_m1_s4_vss_m1_vss_vss_x1_vss_x2_vss_x3_t121 vss__t121 vss 28.1940391363
* device instance g_vss_m1_mph_g_s1_vss_m1_s2_vss_m1_s3_vss_m1_s4_vss_m1_vss_vss_x1_vss_x2_vss_x3 r0 *1 0,0
Cg_vss_m1_mph_g_s1_vss_m1_s2_vss_m1_s3_vss_m1_s4_vss_m1_vss_vss_x1_vss_x2_vss_x3 vss vsubs 1.13344717e-13
* device instance mid_t0 r0 *1 0,0
Rmid_t0 mid__t0 mid 149.893184895
* device instance mid_t1 r0 *1 0,0
Rmid_t1 mid__t1 mid 180.889615105
* device instance mid_t2 r0 *1 0,0
Rmid_t2 mid__t2 mid 149.893184895
* device instance mid_t3 r0 *1 0,0
Rmid_t3 mid__t3 mid 180.889615105
* device instance mid r0 *1 0,0
Cmid mid vsubs 1.103314e-15
* device instance mid_dup1_t0 r0 *1 0,0
Rmid_dup1_t0 mid__t02 midn1 180.889615105
* device instance mid_dup1_t1 r0 *1 0,0
Rmid_dup1_t1 mid__t12 midn1 149.893184895
* device instance mid_dup1_t2 r0 *1 0,0
Rmid_dup1_t2 mid__t22 midn1 149.893184895
* device instance mid_dup1_t3 r0 *1 0,0
Rmid_dup1_t3 mid__t32 midn1 180.889615105
* device instance mid_dup1 r0 *1 0,0
Cmid_dup1 midn1 vsubs 1.101742e-15
* device instance mid_dup2_t0 r0 *1 0,0
Rmid_dup2_t0 mid__t03 midn2 149.893184895
* device instance mid_dup2_t1 r0 *1 0,0
Rmid_dup2_t1 mid__t13 midn2 180.889615105
* device instance mid_dup2_t2 r0 *1 0,0
Rmid_dup2_t2 mid__t23 midn2 180.889615105
* device instance mid_dup2_t3 r0 *1 0,0
Rmid_dup2_t3 mid__t33 midn2 149.893184895
* device instance mid_dup2 r0 *1 0,0
Cmid_dup2 midn2 vsubs 1.104383e-15
* device instance mpa_py_mpb_py_mph_py_py_t0 r0 *1 0,0
Rmpa_py_mpb_py_mph_py_py_t0 py_g__t0 py_g 33.64835
* device instance mpa_py_mpb_py_mph_py_py_t1 r0 *1 0,0
Rmpa_py_mpb_py_mph_py_py_t1 py_g__t1 py_g 5.23884452847
* device instance mpa_py_mpb_py_mph_py_py_t2 r0 *1 0,0
Rmpa_py_mpb_py_mph_py_py_t2 py_g__t2 py_g 28.4095054715
* device instance mpa_py_mpb_py_mph_py_py r0 *1 0,0
Cmpa_py_mpb_py_mph_py_py py_g vsubs 7.94002e-16
* device instance mpa_py_mpb_py_mph_py_py_dup1_t0 r0 *1 0,0
Rmpa_py_mpb_py_mph_py_py_dup1_t0 py_g__t02 py_gn1 33.9531
* device instance mpa_py_mpb_py_mph_py_py_dup1_t1 r0 *1 0,0
Rmpa_py_mpb_py_mph_py_py_dup1_t1 py_g__t12 py_gn1 28.6668077402
* device instance mpa_py_mpb_py_mph_py_py_dup1_t2 r0 *1 0,0
Rmpa_py_mpb_py_mph_py_py_dup1_t2 py_g__t22 py_gn1 5.28629225979
* device instance mpa_py_mpb_py_mph_py_py_dup1 r0 *1 0,0
Cmpa_py_mpb_py_mph_py_py_dup1 py_gn1 vsubs 7.95941e-16
* device instance mpa_py_mpb_py_mph_py_py_dup2_t0 r0 *1 0,0
Rmpa_py_mpb_py_mph_py_py_dup2_t0 py_g__t03 py_gn2 34.25785
* device instance mpa_py_mpb_py_mph_py_py_dup2_t1 r0 *1 0,0
Rmpa_py_mpb_py_mph_py_py_dup2_t1 py_g__t13 py_gn2 28.9241100089
* device instance mpa_py_mpb_py_mph_py_py_dup2_t2 r0 *1 0,0
Rmpa_py_mpb_py_mph_py_py_dup2_t2 py_g__t23 py_gn2 5.3337399911
* device instance mpa_py_mpb_py_mph_py_py_dup2 r0 *1 0,0
Cmpa_py_mpb_py_mph_py_py_dup2 py_gn2 vsubs 7.9788e-16
* device instance mpa_py_mpb_py_mph_py_py_dup3_t0 r0 *1 0,0
Rmpa_py_mpb_py_mph_py_py_dup3_t0 py_g__t04 py_gn3 34.5626
* device instance mpa_py_mpb_py_mph_py_py_dup3_t1 r0 *1 0,0
Rmpa_py_mpb_py_mph_py_py_dup3_t1 py_g__t14 py_gn3 29.1814122776
* device instance mpa_py_mpb_py_mph_py_py_dup3_t2 r0 *1 0,0
Rmpa_py_mpb_py_mph_py_py_dup3_t2 py_g__t24 py_gn3 5.38118772242
* device instance mpa_py_mpb_py_mph_py_py_dup3 r0 *1 0,0
Cmpa_py_mpb_py_mph_py_py_dup3 py_gn3 vsubs 7.99818e-16
* device instance ny_t0 r0 *1 0,0
Rny_t0 ny__t0 ny 53.0227
* device instance ny_t1 r0 *1 0,0
Rny_t1 ny__t1 ny 53.0227
* device instance ny r0 *1 0,0
Cny ny vsubs 2.33681e-16
* device instance ny_dup1_t0 r0 *1 0,0
Rny_dup1_t0 ny__t02 nyn1 50.4787
* device instance ny_dup1_t1 r0 *1 0,0
Rny_dup1_t1 ny__t12 nyn1 50.4787
* device instance ny_dup1 r0 *1 0,0
Cny_dup1 nyn1 vsubs 1.89586e-16
* device instance ny_dup2_t0 r0 *1 0,0
Rny_dup2_t0 ny__t03 nyn2 50.4787
* device instance ny_dup2_t1 r0 *1 0,0
Rny_dup2_t1 ny__t13 nyn2 50.4787
* device instance ny_dup2 r0 *1 0,0
Cny_dup2 nyn2 vsubs 1.89586e-16
* device instance ny_dup3_t0 r0 *1 0,0
Rny_dup3_t0 ny__t04 nyn3 50.4787
* device instance ny_dup3_t1 r0 *1 0,0
Rny_dup3_t1 ny__t14 nyn3 50.4787
* device instance ny_dup3 r0 *1 0,0
Cny_dup3 nyn3 vsubs 1.89586e-16
* device instance ny_dup4_t0 r0 *1 0,0
Rny_dup4_t0 ny__t05 nyn4 50.4787
* device instance ny_dup4_t1 r0 *1 0,0
Rny_dup4_t1 ny__t15 nyn4 50.4787
* device instance ny_dup4 r0 *1 0,0
Cny_dup4 nyn4 vsubs 1.89586e-16
* device instance ny_dup5_t0 r0 *1 0,0
Rny_dup5_t0 ny__t06 nyn5 53.185
* device instance ny_dup5_t1 r0 *1 0,0
Rny_dup5_t1 ny__t16 nyn5 53.185
* device instance ny_dup5 r0 *1 0,0
Cny_dup5 nyn5 vsubs 2.3562e-16
* device instance ny_dup6_t0 r0 *1 0,0
Rny_dup6_t0 ny__t07 nyn6 50.51025
* device instance ny_dup6_t1 r0 *1 0,0
Rny_dup6_t1 ny__t17 nyn6 50.51025
* device instance ny_dup6 r0 *1 0,0
Cny_dup6 nyn6 vsubs 1.91525e-16
* device instance ny_dup7_t0 r0 *1 0,0
Rny_dup7_t0 ny__t08 nyn7 50.51025
* device instance ny_dup7_t1 r0 *1 0,0
Rny_dup7_t1 ny__t18 nyn7 50.51025
* device instance ny_dup7 r0 *1 0,0
Cny_dup7 nyn7 vsubs 1.91525e-16
* device instance ny_dup8_t0 r0 *1 0,0
Rny_dup8_t0 ny__t09 nyn8 50.51025
* device instance ny_dup8_t1 r0 *1 0,0
Rny_dup8_t1 ny__t19 nyn8 50.51025
* device instance ny_dup8 r0 *1 0,0
Cny_dup8 nyn8 vsubs 1.91525e-16
* device instance ny_dup9_t0 r0 *1 0,0
Rny_dup9_t0 ny__t010 nyn9 50.51025
* device instance ny_dup9_t1 r0 *1 0,0
Rny_dup9_t1 ny__t110 nyn9 50.51025
* device instance ny_dup9 r0 *1 0,0
Cny_dup9 nyn9 vsubs 1.91525e-16
* device instance ny_dup10_t0 r0 *1 0,0
Rny_dup10_t0 ny__t011 nyn10 53.351
* device instance ny_dup10_t1 r0 *1 0,0
Rny_dup10_t1 ny__t111 nyn10 53.351
* device instance ny_dup10 r0 *1 0,0
Cny_dup10 nyn10 vsubs 2.37559e-16
* device instance ny_dup11_t0 r0 *1 0,0
Rny_dup11_t0 ny__t012 nyn11 50.5516
* device instance ny_dup11_t1 r0 *1 0,0
Rny_dup11_t1 ny__t112 nyn11 50.5516
* device instance ny_dup11 r0 *1 0,0
Cny_dup11 nyn11 vsubs 1.93464e-16
* device instance ny_dup12_t0 r0 *1 0,0
Rny_dup12_t0 ny__t013 nyn12 50.5516
* device instance ny_dup12_t1 r0 *1 0,0
Rny_dup12_t1 ny__t113 nyn12 50.5516
* device instance ny_dup12 r0 *1 0,0
Cny_dup12 nyn12 vsubs 1.93464e-16
* device instance ny_dup13_t0 r0 *1 0,0
Rny_dup13_t0 ny__t014 nyn13 50.5516
* device instance ny_dup13_t1 r0 *1 0,0
Rny_dup13_t1 ny__t114 nyn13 50.5516
* device instance ny_dup13 r0 *1 0,0
Cny_dup13 nyn13 vsubs 1.93464e-16
* device instance ny_dup14_t0 r0 *1 0,0
Rny_dup14_t0 ny__t015 nyn14 50.5516
* device instance ny_dup14_t1 r0 *1 0,0
Rny_dup14_t1 ny__t115 nyn14 50.5516
* device instance ny_dup14 r0 *1 0,0
Cny_dup14 nyn14 vsubs 1.93464e-16
* device instance ny_dup15_t0 r0 *1 0,0
Rny_dup15_t0 ny__t016 nyn15 53.52065
* device instance ny_dup15_t1 r0 *1 0,0
Rny_dup15_t1 ny__t116 nyn15 53.52065
* device instance ny_dup15 r0 *1 0,0
Cny_dup15 nyn15 vsubs 2.39497e-16
* device instance ny_dup16_t0 r0 *1 0,0
Rny_dup16_t0 ny__t017 nyn16 50.6022
* device instance ny_dup16_t1 r0 *1 0,0
Rny_dup16_t1 ny__t117 nyn16 50.6022
* device instance ny_dup16 r0 *1 0,0
Cny_dup16 nyn16 vsubs 1.95403e-16
* device instance ny_dup17_t0 r0 *1 0,0
Rny_dup17_t0 ny__t018 nyn17 50.6022
* device instance ny_dup17_t1 r0 *1 0,0
Rny_dup17_t1 ny__t118 nyn17 50.6022
* device instance ny_dup17 r0 *1 0,0
Cny_dup17 nyn17 vsubs 1.95403e-16
* device instance ny_dup18_t0 r0 *1 0,0
Rny_dup18_t0 ny__t019 nyn18 50.6022
* device instance ny_dup18_t1 r0 *1 0,0
Rny_dup18_t1 ny__t119 nyn18 50.6022
* device instance ny_dup18 r0 *1 0,0
Cny_dup18 nyn18 vsubs 1.95403e-16
* device instance ny_dup19_t0 r0 *1 0,0
Rny_dup19_t0 ny__t020 nyn19 50.6022
* device instance ny_dup19_t1 r0 *1 0,0
Rny_dup19_t1 ny__t120 nyn19 50.6022
* device instance ny_dup19 r0 *1 0,0
Cny_dup19 nyn19 vsubs 1.95403e-16
* device instance py_t0 r0 *1 0,0
Rpy_t0 py__t0 py 37.6683
* device instance py_t1 r0 *1 0,0
Rpy_t1 py__t1 py 37.6683
* device instance py r0 *1 0,0
Cpy py vsubs 1.9321e-16
* device instance py_dup1_t0 r0 *1 0,0
Rpy_dup1_t0 py__t02 pyn1 37.6683
* device instance py_dup1_t1 r0 *1 0,0
Rpy_dup1_t1 py__t12 pyn1 37.6683
* device instance py_dup1 r0 *1 0,0
Cpy_dup1 pyn1 vsubs 1.9321e-16
* device instance py_dup2_t0 r0 *1 0,0
Rpy_dup2_t0 py__t03 pyn2 37.6683
* device instance py_dup2_t1 r0 *1 0,0
Rpy_dup2_t1 py__t13 pyn2 37.6683
* device instance py_dup2 r0 *1 0,0
Cpy_dup2 pyn2 vsubs 1.9321e-16
* device instance py_dup3_t0 r0 *1 0,0
Rpy_dup3_t0 py__t04 pyn3 37.6683
* device instance py_dup3_t1 r0 *1 0,0
Rpy_dup3_t1 py__t14 pyn3 37.6683
* device instance py_dup3 r0 *1 0,0
Cpy_dup3 pyn3 vsubs 1.9321e-16
* device instance py_dup4_t0 r0 *1 0,0
Rpy_dup4_t0 py__t05 pyn4 37.875
* device instance py_dup4_t1 r0 *1 0,0
Rpy_dup4_t1 py__t15 pyn4 37.875
* device instance py_dup4 r0 *1 0,0
Cpy_dup4 pyn4 vsubs 1.95101e-16
* device instance py_dup5_t0 r0 *1 0,0
Rpy_dup5_t0 py__t06 pyn5 37.875
* device instance py_dup5_t1 r0 *1 0,0
Rpy_dup5_t1 py__t16 pyn5 37.875
* device instance py_dup5 r0 *1 0,0
Cpy_dup5 pyn5 vsubs 1.95101e-16
* device instance py_dup6_t0 r0 *1 0,0
Rpy_dup6_t0 py__t07 pyn6 37.875
* device instance py_dup6_t1 r0 *1 0,0
Rpy_dup6_t1 py__t17 pyn6 37.875
* device instance py_dup6 r0 *1 0,0
Cpy_dup6 pyn6 vsubs 1.95101e-16
* device instance py_dup7_t0 r0 *1 0,0
Rpy_dup7_t0 py__t08 pyn7 37.875
* device instance py_dup7_t1 r0 *1 0,0
Rpy_dup7_t1 py__t18 pyn7 37.875
* device instance py_dup7 r0 *1 0,0
Cpy_dup7 pyn7 vsubs 1.95101e-16
* device instance py_dup8_t0 r0 *1 0,0
Rpy_dup8_t0 py__t09 pyn8 38.0848
* device instance py_dup8_t1 r0 *1 0,0
Rpy_dup8_t1 py__t19 pyn8 38.0848
* device instance py_dup8 r0 *1 0,0
Cpy_dup8 pyn8 vsubs 1.96992e-16
* device instance py_dup9_t0 r0 *1 0,0
Rpy_dup9_t0 py__t010 pyn9 38.0848
* device instance py_dup9_t1 r0 *1 0,0
Rpy_dup9_t1 py__t110 pyn9 38.0848
* device instance py_dup9 r0 *1 0,0
Cpy_dup9 pyn9 vsubs 1.96992e-16
* device instance py_dup10_t0 r0 *1 0,0
Rpy_dup10_t0 py__t011 pyn10 38.0848
* device instance py_dup10_t1 r0 *1 0,0
Rpy_dup10_t1 py__t111 pyn10 38.0848
* device instance py_dup10 r0 *1 0,0
Cpy_dup10 pyn10 vsubs 1.96992e-16
* device instance py_dup11_t0 r0 *1 0,0
Rpy_dup11_t0 py__t012 pyn11 38.0848
* device instance py_dup11_t1 r0 *1 0,0
Rpy_dup11_t1 py__t112 pyn11 38.0848
* device instance py_dup11 r0 *1 0,0
Cpy_dup11 pyn11 vsubs 1.96992e-16
* device instance py_dup12_t0 r0 *1 0,0
Rpy_dup12_t0 py__t013 pyn12 38.29745
* device instance py_dup12_t1 r0 *1 0,0
Rpy_dup12_t1 py__t113 pyn12 38.29745
* device instance py_dup12 r0 *1 0,0
Cpy_dup12 pyn12 vsubs 1.98882e-16
* device instance py_dup13_t0 r0 *1 0,0
Rpy_dup13_t0 py__t014 pyn13 38.29745
* device instance py_dup13_t1 r0 *1 0,0
Rpy_dup13_t1 py__t114 pyn13 38.29745
* device instance py_dup13 r0 *1 0,0
Cpy_dup13 pyn13 vsubs 1.98882e-16
* device instance py_dup14_t0 r0 *1 0,0
Rpy_dup14_t0 py__t015 pyn14 38.29745
* device instance py_dup14_t1 r0 *1 0,0
Rpy_dup14_t1 py__t115 pyn14 38.29745
* device instance py_dup14 r0 *1 0,0
Cpy_dup14 pyn14 vsubs 1.98882e-16
* device instance py_dup15_t0 r0 *1 0,0
Rpy_dup15_t0 py__t016 pyn15 38.29745
* device instance py_dup15_t1 r0 *1 0,0
Rpy_dup15_t1 py__t116 pyn15 38.29745
* device instance py_dup15 r0 *1 0,0
Cpy_dup15 pyn15 vsubs 1.98882e-16
* device instance vdd_vdd_b1_vdd_b2_vdd_b3_vdd_b4_vdd_x1_vdd_x2_vdd_x3_t0 r0 *1 0,0
Rvdd_vdd_b1_vdd_b2_vdd_b3_vdd_b4_vdd_x1_vdd_x2_vdd_x3_t0 vdd__t0 vdd 328.063852969
* device instance vdd_vdd_b1_vdd_b2_vdd_b3_vdd_b4_vdd_x1_vdd_x2_vdd_x3_t1 r0 *1 0,0
Rvdd_vdd_b1_vdd_b2_vdd_b3_vdd_b4_vdd_x1_vdd_x2_vdd_x3_t1 vdd__t1 vdd 328.063852969
* device instance vdd_vdd_b1_vdd_b2_vdd_b3_vdd_b4_vdd_x1_vdd_x2_vdd_x3_t2 r0 *1 0,0
Rvdd_vdd_b1_vdd_b2_vdd_b3_vdd_b4_vdd_x1_vdd_x2_vdd_x3_t2 vdd__t2 vdd 323.933326474
* device instance vdd_vdd_b1_vdd_b2_vdd_b3_vdd_b4_vdd_x1_vdd_x2_vdd_x3_t3 r0 *1 0,0
Rvdd_vdd_b1_vdd_b2_vdd_b3_vdd_b4_vdd_x1_vdd_x2_vdd_x3_t3 vdd__t3 vdd 279.90435125
* device instance vdd_vdd_b1_vdd_b2_vdd_b3_vdd_b4_vdd_x1_vdd_x2_vdd_x3_t4 r0 *1 0,0
Rvdd_vdd_b1_vdd_b2_vdd_b3_vdd_b4_vdd_x1_vdd_x2_vdd_x3_t4 vdd__t4 vdd 90.261545763
* device instance vdd_vdd_b1_vdd_b2_vdd_b3_vdd_b4_vdd_x1_vdd_x2_vdd_x3_t5 r0 *1 0,0
Rvdd_vdd_b1_vdd_b2_vdd_b3_vdd_b4_vdd_x1_vdd_x2_vdd_x3_t5 vdd__t5 vdd 104.521181322
* device instance vdd_vdd_b1_vdd_b2_vdd_b3_vdd_b4_vdd_x1_vdd_x2_vdd_x3_t6 r0 *1 0,0
Rvdd_vdd_b1_vdd_b2_vdd_b3_vdd_b4_vdd_x1_vdd_x2_vdd_x3_t6 vdd__t6 vdd 279.90435125
* device instance vdd_vdd_b1_vdd_b2_vdd_b3_vdd_b4_vdd_x1_vdd_x2_vdd_x3_t7 r0 *1 0,0
Rvdd_vdd_b1_vdd_b2_vdd_b3_vdd_b4_vdd_x1_vdd_x2_vdd_x3_t7 vdd__t7 vdd 90.261545763
* device instance vdd_vdd_b1_vdd_b2_vdd_b3_vdd_b4_vdd_x1_vdd_x2_vdd_x3_t8 r0 *1 0,0
Rvdd_vdd_b1_vdd_b2_vdd_b3_vdd_b4_vdd_x1_vdd_x2_vdd_x3_t8 vdd__t8 vdd 53.1431519264
* device instance vdd_vdd_b1_vdd_b2_vdd_b3_vdd_b4_vdd_x1_vdd_x2_vdd_x3_t9 r0 *1 0,0
Rvdd_vdd_b1_vdd_b2_vdd_b3_vdd_b4_vdd_x1_vdd_x2_vdd_x3_t9 vdd__t9 vdd 146.82090586
* device instance vdd_vdd_b1_vdd_b2_vdd_b3_vdd_b4_vdd_x1_vdd_x2_vdd_x3_t10 r0 *1 0,0
Rvdd_vdd_b1_vdd_b2_vdd_b3_vdd_b4_vdd_x1_vdd_x2_vdd_x3_t10 vdd__t10 vdd 104.521181322
* device instance vdd_vdd_b1_vdd_b2_vdd_b3_vdd_b4_vdd_x1_vdd_x2_vdd_x3_t11 r0 *1 0,0
Rvdd_vdd_b1_vdd_b2_vdd_b3_vdd_b4_vdd_x1_vdd_x2_vdd_x3_t11 vdd__t11 vdd 284.025611975
* device instance vdd_vdd_b1_vdd_b2_vdd_b3_vdd_b4_vdd_x1_vdd_x2_vdd_x3_t12 r0 *1 0,0
Rvdd_vdd_b1_vdd_b2_vdd_b3_vdd_b4_vdd_x1_vdd_x2_vdd_x3_t12 vdd__t12 vdd 86.4936196129
* device instance vdd_vdd_b1_vdd_b2_vdd_b3_vdd_b4_vdd_x1_vdd_x2_vdd_x3_t13 r0 *1 0,0
Rvdd_vdd_b1_vdd_b2_vdd_b3_vdd_b4_vdd_x1_vdd_x2_vdd_x3_t13 vdd__t13 vdd 50.2710990779
* device instance vdd_vdd_b1_vdd_b2_vdd_b3_vdd_b4_vdd_x1_vdd_x2_vdd_x3_t14 r0 *1 0,0
Rvdd_vdd_b1_vdd_b2_vdd_b3_vdd_b4_vdd_x1_vdd_x2_vdd_x3_t14 vdd__t14 vdd 150.845678137
* device instance vdd_vdd_b1_vdd_b2_vdd_b3_vdd_b4_vdd_x1_vdd_x2_vdd_x3_t15 r0 *1 0,0
Rvdd_vdd_b1_vdd_b2_vdd_b3_vdd_b4_vdd_x1_vdd_x2_vdd_x3_t15 vdd__t15 vdd 108.41461315
* device instance vdd_vdd_b1_vdd_b2_vdd_b3_vdd_b4_vdd_x1_vdd_x2_vdd_x3_t16 r0 *1 0,0
Rvdd_vdd_b1_vdd_b2_vdd_b3_vdd_b4_vdd_x1_vdd_x2_vdd_x3_t16 vdd__t16 vdd 50.2710990779
* device instance vdd_vdd_b1_vdd_b2_vdd_b3_vdd_b4_vdd_x1_vdd_x2_vdd_x3_t17 r0 *1 0,0
Rvdd_vdd_b1_vdd_b2_vdd_b3_vdd_b4_vdd_x1_vdd_x2_vdd_x3_t17 vdd__t17 vdd 150.845678137
* device instance vdd_vdd_b1_vdd_b2_vdd_b3_vdd_b4_vdd_x1_vdd_x2_vdd_x3_t18 r0 *1 0,0
Rvdd_vdd_b1_vdd_b2_vdd_b3_vdd_b4_vdd_x1_vdd_x2_vdd_x3_t18 vdd__t18 vdd 965.869424629
* device instance vdd_vdd_b1_vdd_b2_vdd_b3_vdd_b4_vdd_x1_vdd_x2_vdd_x3_t19 r0 *1 0,0
Rvdd_vdd_b1_vdd_b2_vdd_b3_vdd_b4_vdd_x1_vdd_x2_vdd_x3_t19 vdd__t19 vdd 625.512134762
* device instance vdd_vdd_b1_vdd_b2_vdd_b3_vdd_b4_vdd_x1_vdd_x2_vdd_x3_t20 r0 *1 0,0
Rvdd_vdd_b1_vdd_b2_vdd_b3_vdd_b4_vdd_x1_vdd_x2_vdd_x3_t20 vdd__t20 vdd 120.990798837
* device instance vdd_vdd_b1_vdd_b2_vdd_b3_vdd_b4_vdd_x1_vdd_x2_vdd_x3_t21 r0 *1 0,0
Rvdd_vdd_b1_vdd_b2_vdd_b3_vdd_b4_vdd_x1_vdd_x2_vdd_x3_t21 vdd__t21 vdd 122.133630991
* device instance vdd_vdd_b1_vdd_b2_vdd_b3_vdd_b4_vdd_x1_vdd_x2_vdd_x3_t22 r0 *1 0,0
Rvdd_vdd_b1_vdd_b2_vdd_b3_vdd_b4_vdd_x1_vdd_x2_vdd_x3_t22 vdd__t22 vdd 13.6183889138
* device instance vdd_vdd_b1_vdd_b2_vdd_b3_vdd_b4_vdd_x1_vdd_x2_vdd_x3_t23 r0 *1 0,0
Rvdd_vdd_b1_vdd_b2_vdd_b3_vdd_b4_vdd_x1_vdd_x2_vdd_x3_t23 vdd__t23 vdd 58.9916013682
* device instance vdd_vdd_b1_vdd_b2_vdd_b3_vdd_b4_vdd_x1_vdd_x2_vdd_x3_t24 r0 *1 0,0
Rvdd_vdd_b1_vdd_b2_vdd_b3_vdd_b4_vdd_x1_vdd_x2_vdd_x3_t24 vdd__t24 vdd 171.186753232
* device instance vdd_vdd_b1_vdd_b2_vdd_b3_vdd_b4_vdd_x1_vdd_x2_vdd_x3_t25 r0 *1 0,0
Rvdd_vdd_b1_vdd_b2_vdd_b3_vdd_b4_vdd_x1_vdd_x2_vdd_x3_t25 vdd__t25 vdd 238.09164632
* device instance vdd_vdd_b1_vdd_b2_vdd_b3_vdd_b4_vdd_x1_vdd_x2_vdd_x3_t26 r0 *1 0,0
Rvdd_vdd_b1_vdd_b2_vdd_b3_vdd_b4_vdd_x1_vdd_x2_vdd_x3_t26 vdd__t26 vdd 350.811325715
* device instance vdd_vdd_b1_vdd_b2_vdd_b3_vdd_b4_vdd_x1_vdd_x2_vdd_x3_t27 r0 *1 0,0
Rvdd_vdd_b1_vdd_b2_vdd_b3_vdd_b4_vdd_x1_vdd_x2_vdd_x3_t27 vdd__t27 vdd 291.851172216
* device instance vdd_vdd_b1_vdd_b2_vdd_b3_vdd_b4_vdd_x1_vdd_x2_vdd_x3_t28 r0 *1 0,0
Rvdd_vdd_b1_vdd_b2_vdd_b3_vdd_b4_vdd_x1_vdd_x2_vdd_x3_t28 vdd__t28 vdd 965.869424629
* device instance vdd_vdd_b1_vdd_b2_vdd_b3_vdd_b4_vdd_x1_vdd_x2_vdd_x3_t29 r0 *1 0,0
Rvdd_vdd_b1_vdd_b2_vdd_b3_vdd_b4_vdd_x1_vdd_x2_vdd_x3_t29 vdd__t29 vdd 625.512134762
* device instance vdd_vdd_b1_vdd_b2_vdd_b3_vdd_b4_vdd_x1_vdd_x2_vdd_x3_t30 r0 *1 0,0
Rvdd_vdd_b1_vdd_b2_vdd_b3_vdd_b4_vdd_x1_vdd_x2_vdd_x3_t30 vdd__t30 vdd 120.990798837
* device instance vdd_vdd_b1_vdd_b2_vdd_b3_vdd_b4_vdd_x1_vdd_x2_vdd_x3_t31 r0 *1 0,0
Rvdd_vdd_b1_vdd_b2_vdd_b3_vdd_b4_vdd_x1_vdd_x2_vdd_x3_t31 vdd__t31 vdd 122.133630991
* device instance vdd_vdd_b1_vdd_b2_vdd_b3_vdd_b4_vdd_x1_vdd_x2_vdd_x3_t32 r0 *1 0,0
Rvdd_vdd_b1_vdd_b2_vdd_b3_vdd_b4_vdd_x1_vdd_x2_vdd_x3_t32 vdd__t32 vdd 13.6183889138
* device instance vdd_vdd_b1_vdd_b2_vdd_b3_vdd_b4_vdd_x1_vdd_x2_vdd_x3_t33 r0 *1 0,0
Rvdd_vdd_b1_vdd_b2_vdd_b3_vdd_b4_vdd_x1_vdd_x2_vdd_x3_t33 vdd__t33 vdd 58.9916013682
* device instance vdd_vdd_b1_vdd_b2_vdd_b3_vdd_b4_vdd_x1_vdd_x2_vdd_x3_t34 r0 *1 0,0
Rvdd_vdd_b1_vdd_b2_vdd_b3_vdd_b4_vdd_x1_vdd_x2_vdd_x3_t34 vdd__t34 vdd 171.186753232
* device instance vdd_vdd_b1_vdd_b2_vdd_b3_vdd_b4_vdd_x1_vdd_x2_vdd_x3_t35 r0 *1 0,0
Rvdd_vdd_b1_vdd_b2_vdd_b3_vdd_b4_vdd_x1_vdd_x2_vdd_x3_t35 vdd__t35 vdd 238.09164632
* device instance vdd_vdd_b1_vdd_b2_vdd_b3_vdd_b4_vdd_x1_vdd_x2_vdd_x3_t36 r0 *1 0,0
Rvdd_vdd_b1_vdd_b2_vdd_b3_vdd_b4_vdd_x1_vdd_x2_vdd_x3_t36 vdd__t36 vdd 350.811325715
* device instance vdd_vdd_b1_vdd_b2_vdd_b3_vdd_b4_vdd_x1_vdd_x2_vdd_x3_t37 r0 *1 0,0
Rvdd_vdd_b1_vdd_b2_vdd_b3_vdd_b4_vdd_x1_vdd_x2_vdd_x3_t37 vdd__t37 vdd 291.851172216
* device instance vdd_vdd_b1_vdd_b2_vdd_b3_vdd_b4_vdd_x1_vdd_x2_vdd_x3 r0 *1 0,0
Cvdd_vdd_b1_vdd_b2_vdd_b3_vdd_b4_vdd_x1_vdd_x2_vdd_x3 vdd vsubs 4.8070761e-14
* device instance xo_y_t0 r0 *1 0,0
Rxo_y_t0 xo__t0 xo 470.975867376
* device instance xo_y_t1 r0 *1 0,0
Rxo_y_t1 xo__t1 xo 473.562167793
* device instance xo_y_t2 r0 *1 0,0
Rxo_y_t2 xo__t2 xo 485.149050642
* device instance xo_y_t3 r0 *1 0,0
Rxo_y_t3 xo__t3 xo 482.421714188
* device instance xo_y r0 *1 0,0
Cxo_y xo vsubs 2.746166e-15
* device instance cc_a_b_b3_invb_a_mn12_g1_mp24_g0_t2_y_a_inva_a_mn12_g0_mp13_g0_ro3_y r0 *1 0,0
Ccc_a_b_b3_invb_a_mn12_g1_mp24_g0_t2_y_a_inva_a_mn12_g0_mp13_g0_ro3_y t2 ro3 3.3e-18
* device instance cc_a_b_b3_invb_a_mn12_g1_mp24_g0_t2_y_a_inva_a_mn12_g0_mp13_g0_t1_y r0 *1 0,0
Ccc_a_b_b3_invb_a_mn12_g1_mp24_g0_t2_y_a_inva_a_mn12_g0_mp13_g0_t1_y t2 t1 3.869e-18
* device instance cc_a_b_b3_invb_a_mn12_g1_mp24_g0_t2_y_an_inva_y_mn34_g0_mp13_g1_y r0 *1 0,0
Ccc_a_b_b3_invb_a_mn12_g1_mp24_g0_t2_y_an_inva_y_mn34_g0_mp13_g1_y t2 xor_ann2 3.3e-18
* device instance cc_a_b_b3_invb_a_mn12_g1_mp24_g0_t2_y_bn_invb_y_mn34_g1_mp24_g1_y r0 *1 0,0
Ccc_a_b_b3_invb_a_mn12_g1_mp24_g0_t2_y_bn_invb_y_mn34_g1_mp24_g1_y t2 xor_bnn2 1.377e-17
* device instance cc_a_b_b3_invb_a_mn12_g1_mp24_g0_t2_y_g_vss_m1_mph_g_s1_vss_m1_s2_vss_m1_s3_vss_m1_s4_vss_m1_vss_vss_x1_vss_x2_vss_x3 r0 *1 0,0
Ccc_a_b_b3_invb_a_mn12_g1_mp24_g0_t2_y_g_vss_m1_mph_g_s1_vss_m1_s2_vss_m1_s3_vss_m1_s4_vss_m1_vss_vss_x1_vss_x2_vss_x3 t2 vss 7.354e-18
* device instance cc_a_b_b3_invb_a_mn12_g1_mp24_g0_t2_y_mid r0 *1 0,0
Ccc_a_b_b3_invb_a_mn12_g1_mp24_g0_t2_y_mid t2 midn2 8.154e-18
* device instance cc_a_b_invb_a_mn12_g1_mp24_g0_ro2_y_g_vss_m1_mph_g_s1_vss_m1_s2_vss_m1_s3_vss_m1_s4_vss_m1_vss_vss_x1_vss_x2_vss_x3 r0 *1 0,0
Ccc_a_b_invb_a_mn12_g1_mp24_g0_ro2_y_g_vss_m1_mph_g_s1_vss_m1_s2_vss_m1_s3_vss_m1_s4_vss_m1_vss_vss_x1_vss_x2_vss_x3 ro2 vss 5.1954e-17
* device instance cc_a_b_invb_a_mn12_g1_mp24_g0_ro2_y_vdd_vdd_b1_vdd_b2_vdd_b3_vdd_b4_vdd_x1_vdd_x2_vdd_x3 r0 *1 0,0
Ccc_a_b_invb_a_mn12_g1_mp24_g0_ro2_y_vdd_vdd_b1_vdd_b2_vdd_b3_vdd_b4_vdd_x1_vdd_x2_vdd_x3 ro2 vdd 9.558e-18
* device instance cc_a_b_invb_a_mn12_g1_mp24_g0_ro4_y_g_vss_m1_mph_g_s1_vss_m1_s2_vss_m1_s3_vss_m1_s4_vss_m1_vss_vss_x1_vss_x2_vss_x3 r0 *1 0,0
Ccc_a_b_invb_a_mn12_g1_mp24_g0_ro4_y_g_vss_m1_mph_g_s1_vss_m1_s2_vss_m1_s3_vss_m1_s4_vss_m1_vss_vss_x1_vss_x2_vss_x3 ro4 vss 6.1512e-17
* device instance cc_a_b_invb_a_mn12_g1_mp24_g0_ro4_y_vdd_vdd_b1_vdd_b2_vdd_b3_vdd_b4_vdd_x1_vdd_x2_vdd_x3 r0 *1 0,0
Ccc_a_b_invb_a_mn12_g1_mp24_g0_ro4_y_vdd_vdd_b1_vdd_b2_vdd_b3_vdd_b4_vdd_x1_vdd_x2_vdd_x3 ro4 vdd 9.558e-18
* device instance cc_a_g_a_rn1_ro_s4_y_y_a_g_y_mnab_y_mpa_y_mpb_y_n1_s1_a_y r0 *1 0,0
Ccc_a_g_a_rn1_ro_s4_y_y_a_g_y_mnab_y_mpa_y_mpb_y_n1_s1_a_y rn1 sig_n1n3 6.626e-18
* device instance cc_a_g_a_rn1_ro_s4_y_y_g_vddr_m1_mnt_g_s1_vddr_m1_s2_vddr_m1_s3_vddr_m1_s4_vddr_m1_vddr_vddr1 r0 *1 0,0
Ccc_a_g_a_rn1_ro_s4_y_y_g_vddr_m1_mnt_g_s1_vddr_m1_s2_vddr_m1_s3_vddr_m1_s4_vddr_m1_vddr_vddr1 rn1 vddr1 1.5474e-17
* device instance cc_a_g_a_rn2_ro_s4_y_y_a_g_y_mnab_y_mpa_y_mpb_y_n1_s1_a_y r0 *1 0,0
Ccc_a_g_a_rn2_ro_s4_y_y_a_g_y_mnab_y_mpa_y_mpb_y_n1_s1_a_y rn2 sig_n1n3 6.626e-18
* device instance cc_a_g_a_rn2_ro_s4_y_y_g_vddr_m1_mnt_g_s1_vddr_m1_s2_vddr_m1_s3_vddr_m1_s4_vddr_m1_vddr_vddr2 r0 *1 0,0
Ccc_a_g_a_rn2_ro_s4_y_y_g_vddr_m1_mnt_g_s1_vddr_m1_s2_vddr_m1_s3_vddr_m1_s4_vddr_m1_vddr_vddr2 rn2 vddr2 1.5474e-17
* device instance cc_a_g_a_rn3_ro_s4_y_y_a_g_y_mnab_y_mpa_y_mpb_y_n1_s1_a_y r0 *1 0,0
Ccc_a_g_a_rn3_ro_s4_y_y_a_g_y_mnab_y_mpa_y_mpb_y_n1_s1_a_y rn3 sig_n1n3 6.626e-18
* device instance cc_a_g_a_rn3_ro_s4_y_y_g_vddr_m1_mnt_g_s1_vddr_m1_s2_vddr_m1_s3_vddr_m1_s4_vddr_m1_vddr_vddr3 r0 *1 0,0
Ccc_a_g_a_rn3_ro_s4_y_y_g_vddr_m1_mnt_g_s1_vddr_m1_s2_vddr_m1_s3_vddr_m1_s4_vddr_m1_vddr_vddr3 rn3 vddr3 1.5474e-17
* device instance cc_a_g_a_rn4_ro_s4_y_y_a_g_y_mnab_y_mpa_y_mpb_y_n1_s1_a_y r0 *1 0,0
Ccc_a_g_a_rn4_ro_s4_y_y_a_g_y_mnab_y_mpa_y_mpb_y_n1_s1_a_y rn4 sig_n1n3 6.626e-18
* device instance cc_a_g_a_rn4_ro_s4_y_y_g_vddr_m1_mnt_g_s1_vddr_m1_s2_vddr_m1_s3_vddr_m1_s4_vddr_m1_vddr_vddr4 r0 *1 0,0
Ccc_a_g_a_rn4_ro_s4_y_y_g_vddr_m1_mnt_g_s1_vddr_m1_s2_vddr_m1_s3_vddr_m1_s4_vddr_m1_vddr_vddr4 rn4 vddr4 1.5474e-17
* device instance cc_a_g_a_rn4_ro_s4_y_y_g_vss_m1_mph_g_s1_vss_m1_s2_vss_m1_s3_vss_m1_s4_vss_m1_vss_vss_x1_vss_x2_vss_x3 r0 *1 0,0
Ccc_a_g_a_rn4_ro_s4_y_y_g_vss_m1_mph_g_s1_vss_m1_s2_vss_m1_s3_vss_m1_s4_vss_m1_vss_vss_x1_vss_x2_vss_x3 rn4 vss 2.7612e-17
* device instance cc_a_g_y_mnab_y_mpa_y_mpb_y_n1_s1_a_y_g_vss_m1_mph_g_s1_vss_m1_s2_vss_m1_s3_vss_m1_s4_vss_m1_vss_vss_x1_vss_x2_vss_x3 r0 *1 0,0
Ccc_a_g_y_mnab_y_mpa_y_mpb_y_n1_s1_a_y_g_vss_m1_mph_g_s1_vss_m1_s2_vss_m1_s3_vss_m1_s4_vss_m1_vss_vss_x1_vss_x2_vss_x3 sig_n1n3 vss 1.5474e-17
* device instance cc_a_g_y_mnab_y_mpa_y_mpb_y_n1_s1_a_y_ny r0 *1 0,0
Ccc_a_g_y_mnab_y_mpa_y_mpb_y_n1_s1_a_y_ny sig_n1n3 nyn19 3.0903e-17
* device instance cc_a_inva_a_mn12_g0_mp13_g0_ro1_y_a_inva_a_mn12_g0_mp13_g0_t1_y r0 *1 0,0
Ccc_a_inva_a_mn12_g0_mp13_g0_ro1_y_a_inva_a_mn12_g0_mp13_g0_t1_y ro1 t1 3.3e-18
* device instance cc_a_inva_a_mn12_g0_mp13_g0_ro1_y_g_vss_m1_mph_g_s1_vss_m1_s2_vss_m1_s3_vss_m1_s4_vss_m1_vss_vss_x1_vss_x2_vss_x3 r0 *1 0,0
Ccc_a_inva_a_mn12_g0_mp13_g0_ro1_y_g_vss_m1_mph_g_s1_vss_m1_s2_vss_m1_s3_vss_m1_s4_vss_m1_vss_vss_x1_vss_x2_vss_x3 ro1 vss 1.3955e-17
* device instance cc_a_inva_a_mn12_g0_mp13_g0_ro1_y_vdd_vdd_b1_vdd_b2_vdd_b3_vdd_b4_vdd_x1_vdd_x2_vdd_x3 r0 *1 0,0
Ccc_a_inva_a_mn12_g0_mp13_g0_ro1_y_vdd_vdd_b1_vdd_b2_vdd_b3_vdd_b4_vdd_x1_vdd_x2_vdd_x3 ro1 vdd 4.1531e-17
* device instance cc_a_inva_a_mn12_g0_mp13_g0_ro3_y_g_vss_m1_mph_g_s1_vss_m1_s2_vss_m1_s3_vss_m1_s4_vss_m1_vss_vss_x1_vss_x2_vss_x3 r0 *1 0,0
Ccc_a_inva_a_mn12_g0_mp13_g0_ro3_y_g_vss_m1_mph_g_s1_vss_m1_s2_vss_m1_s3_vss_m1_s4_vss_m1_vss_vss_x1_vss_x2_vss_x3 ro3 vss 2.3513e-17
* device instance cc_a_inva_a_mn12_g0_mp13_g0_ro3_y_vdd_vdd_b1_vdd_b2_vdd_b3_vdd_b4_vdd_x1_vdd_x2_vdd_x3 r0 *1 0,0
Ccc_a_inva_a_mn12_g0_mp13_g0_ro3_y_vdd_vdd_b1_vdd_b2_vdd_b3_vdd_b4_vdd_x1_vdd_x2_vdd_x3 ro3 vdd 3.1973e-17
* device instance cc_a_inva_a_mn12_g0_mp13_g0_t1_y_an_inva_y_mn34_g0_mp13_g1_y r0 *1 0,0
Ccc_a_inva_a_mn12_g0_mp13_g0_t1_y_an_inva_y_mn34_g0_mp13_g1_y t1 xor_ann2 3.3e-18
* device instance cc_a_inva_a_mn12_g0_mp13_g0_t1_y_bn_invb_y_mn34_g1_mp24_g1_y r0 *1 0,0
Ccc_a_inva_a_mn12_g0_mp13_g0_t1_y_bn_invb_y_mn34_g1_mp24_g1_y t1 xor_bnn2 9.901e-18
* device instance cc_a_inva_a_mn12_g0_mp13_g0_t1_y_g_vss_m1_mph_g_s1_vss_m1_s2_vss_m1_s3_vss_m1_s4_vss_m1_vss_vss_x1_vss_x2_vss_x3 r0 *1 0,0
Ccc_a_inva_a_mn12_g0_mp13_g0_t1_y_g_vss_m1_mph_g_s1_vss_m1_s2_vss_m1_s3_vss_m1_s4_vss_m1_vss_vss_x1_vss_x2_vss_x3 t1 vss 1.3955e-17
* device instance cc_a_inva_a_mn12_g0_mp13_g0_t1_y_mid r0 *1 0,0
Ccc_a_inva_a_mn12_g0_mp13_g0_t1_y_mid t1 midn2 3.3e-18
* device instance cc_a_inva_a_mn12_g0_mp13_g0_t1_y_vdd_vdd_b1_vdd_b2_vdd_b3_vdd_b4_vdd_x1_vdd_x2_vdd_x3 r0 *1 0,0
Ccc_a_inva_a_mn12_g0_mp13_g0_t1_y_vdd_vdd_b1_vdd_b2_vdd_b3_vdd_b4_vdd_x1_vdd_x2_vdd_x3 t1 vdd 3.5274e-17
* device instance cc_a_inva_a_mn12_g0_mp13_g0_t1_y_xo_y r0 *1 0,0
Ccc_a_inva_a_mn12_g0_mp13_g0_t1_y_xo_y t1 xo 3.3e-18
* device instance cc_a_n2_s1_y_s2_a_y_g_vss_m1_mph_g_s1_vss_m1_s2_vss_m1_s3_vss_m1_s4_vss_m1_vss_vss_x1_vss_x2_vss_x3 r0 *1 0,0
Ccc_a_n2_s1_y_s2_a_y_g_vss_m1_mph_g_s1_vss_m1_s2_vss_m1_s3_vss_m1_s4_vss_m1_vss_vss_x1_vss_x2_vss_x3 sig_n2n3 vss 1.5474e-17
* device instance cc_a_n2_s1_y_s2_a_y_ny r0 *1 0,0
Ccc_a_n2_s1_y_s2_a_y_ny sig_n2n3 nyn19 3.0903e-17
* device instance cc_a_n3_s2_y_s3_a_y_g_vss_m1_mph_g_s1_vss_m1_s2_vss_m1_s3_vss_m1_s4_vss_m1_vss_vss_x1_vss_x2_vss_x3 r0 *1 0,0
Ccc_a_n3_s2_y_s3_a_y_g_vss_m1_mph_g_s1_vss_m1_s2_vss_m1_s3_vss_m1_s4_vss_m1_vss_vss_x1_vss_x2_vss_x3 sig_n3n3 vss 1.5474e-17
* device instance cc_a_n3_s2_y_s3_a_y_ny r0 *1 0,0
Ccc_a_n3_s2_y_s3_a_y_ny sig_n3n3 nyn19 3.0903e-17
* device instance cc_a_n4_s3_y_s4_a_y_g_vss_m1_mph_g_s1_vss_m1_s2_vss_m1_s3_vss_m1_s4_vss_m1_vss_vss_x1_vss_x2_vss_x3 r0 *1 0,0
Ccc_a_n4_s3_y_s4_a_y_g_vss_m1_mph_g_s1_vss_m1_s2_vss_m1_s3_vss_m1_s4_vss_m1_vss_vss_x1_vss_x2_vss_x3 sig_n4n3 vss 1.5474e-17
* device instance cc_a_n4_s3_y_s4_a_y_ny r0 *1 0,0
Ccc_a_n4_s3_y_s4_a_y_ny sig_n4n3 nyn19 3.0903e-17
* device instance cc_an_inva_y_mn34_g0_mp13_g1_y_vdd_vdd_b1_vdd_b2_vdd_b3_vdd_b4_vdd_x1_vdd_x2_vdd_x3 r0 *1 0,0
Ccc_an_inva_y_mn34_g0_mp13_g1_y_vdd_vdd_b1_vdd_b2_vdd_b3_vdd_b4_vdd_x1_vdd_x2_vdd_x3 xor_ann2 vdd 2.8673e-17
* device instance cc_an_inva_y_mn34_g0_mp13_g1_y_xo_y r0 *1 0,0
Ccc_an_inva_y_mn34_g0_mp13_g1_y_xo_y xor_ann2 xo 3.3e-18
* device instance cc_bn_invb_y_mn34_g1_mp24_g1_y_mid r0 *1 0,0
Ccc_bn_invb_y_mn34_g1_mp24_g1_y_mid xor_bnn2 midn2 9.901e-18
* device instance cc_bn_invb_y_mn34_g1_mp24_g1_y_vdd_vdd_b1_vdd_b2_vdd_b3_vdd_b4_vdd_x1_vdd_x2_vdd_x3 r0 *1 0,0
Ccc_bn_invb_y_mn34_g1_mp24_g1_y_vdd_vdd_b1_vdd_b2_vdd_b3_vdd_b4_vdd_x1_vdd_x2_vdd_x3 xor_bnn2 vdd 9.901e-18
* device instance cc_bn_invb_y_mn34_g1_mp24_g1_y_xo_y r0 *1 0,0
Ccc_bn_invb_y_mn34_g1_mp24_g1_y_xo_y xor_bnn2 xo 9.901e-18
* device instance cc_g_vddr_m1_mnt_g_s1_vddr_m1_s2_vddr_m1_s3_vddr_m1_s4_vddr_m1_vddr_vddr1_py r0 *1 0,0
Ccc_g_vddr_m1_mnt_g_s1_vddr_m1_s2_vddr_m1_s3_vddr_m1_s4_vddr_m1_vddr_vddr1_py vddr1 pyn15 1.2471e-17
* device instance cc_g_vddr_m1_mnt_g_s1_vddr_m1_s2_vddr_m1_s3_vddr_m1_s4_vddr_m1_vddr_vddr2_py r0 *1 0,0
Ccc_g_vddr_m1_mnt_g_s1_vddr_m1_s2_vddr_m1_s3_vddr_m1_s4_vddr_m1_vddr_vddr2_py vddr2 pyn15 1.3064e-17
* device instance cc_g_vddr_m1_mnt_g_s1_vddr_m1_s2_vddr_m1_s3_vddr_m1_s4_vddr_m1_vddr_vddr3_py r0 *1 0,0
Ccc_g_vddr_m1_mnt_g_s1_vddr_m1_s2_vddr_m1_s3_vddr_m1_s4_vddr_m1_vddr_vddr3_py vddr3 pyn15 1.3658e-17
* device instance cc_g_vddr_m1_mnt_g_s1_vddr_m1_s2_vddr_m1_s3_vddr_m1_s4_vddr_m1_vddr_vddr4_py r0 *1 0,0
Ccc_g_vddr_m1_mnt_g_s1_vddr_m1_s2_vddr_m1_s3_vddr_m1_s4_vddr_m1_vddr_vddr4_py vddr4 pyn15 1.4252e-17
* device instance cc_g_vss_m1_mph_g_s1_vss_m1_s2_vss_m1_s3_vss_m1_s4_vss_m1_vss_vss_x1_vss_x2_vss_x3_vdd_vdd_b1_vdd_b2_vdd_b3_vdd_b4_vdd_x1_vdd_x2_vdd_x3 r0 *1 0,0
Ccc_g_vss_m1_mph_g_s1_vss_m1_s2_vss_m1_s3_vss_m1_s4_vss_m1_vss_vss_x1_vss_x2_vss_x3_vdd_vdd_b1_vdd_b2_vdd_b3_vdd_b4_vdd_x1_vdd_x2_vdd_x3 vss vdd 2.3613e-17
* device instance vsubs_dctie r0 *1 0,0
Rvsubs_dctie vsubs 0 1e+12
.ends ro_array_core_pex__core

* ro_array_core_pex -- design-port-order wrapper over ro_array_core_pex__core.
* Promoted-internal layout pins kept local here: t2, rn1, rn2, rn3, rn4, sig_n1, sig_n1n1, sig_n1n2, sig_n1n3, t1, sig_n2, sig_n2n1, sig_n2n2, sig_n2n3, sig_n3, sig_n3n1, sig_n3n2, sig_n3n3, sig_n4, sig_n4n1, sig_n4n2, sig_n4n3, xor_an, xor_ann1, xor_ann2, xor_bn, xor_bnn1, xor_bnn2, mid, midn1, midn2, py_g, py_gn1, py_gn2, py_gn3, ny, nyn1, nyn2, nyn3, nyn4, nyn5, nyn6, nyn7, nyn8, nyn9, nyn10, nyn11, nyn12, nyn13, nyn14, nyn15, nyn16, nyn17, nyn18, nyn19, py, pyn1, pyn2, pyn3, pyn4, pyn5, pyn6, pyn7, pyn8, pyn9, pyn10, pyn11, pyn12, pyn13, pyn14, pyn15
.subckt ro_array_core_pex en1 en2 en3 en4 vddr1 vddr2 vddr3 vddr4 vdd vss xo ro1 ro2 ro3 ro4
xpex t2 ro2 ro4 rn1 rn2 rn3 rn4 sig_n1 sig_n1n1 sig_n1n2 sig_n1n3 ro1 ro3 t1 sig_n2 sig_n2n1 sig_n2n2 sig_n2n3 sig_n3 sig_n3n1 sig_n3n2 sig_n3n3 sig_n4 sig_n4n1 sig_n4n2 sig_n4n3 xor_an xor_ann1 xor_ann2 xor_bn xor_bnn1 xor_bnn2 en1 en2 en3 en4 vddr1 vddr2 vddr3 vddr4 vss mid midn1 midn2 py_g py_gn1 py_gn2 py_gn3 ny nyn1 nyn2 nyn3 nyn4 nyn5 nyn6 nyn7 nyn8 nyn9 nyn10 nyn11 nyn12 nyn13 nyn14 nyn15 nyn16 nyn17 nyn18 nyn19 py pyn1 pyn2 pyn3 pyn4 pyn5 pyn6 pyn7 pyn8 pyn9 pyn10 pyn11 pyn12 pyn13 pyn14 pyn15 vdd xo ro_array_core_pex__core
.ends ro_array_core_pex
