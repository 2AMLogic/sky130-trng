* extracted by klt extract --deck sky130
* parasitic model (--parasitics):
* - capacitance: net-to-ground for every net's own (non-coupled) area/perimeter, plus net-to-net for the vertical-overlap coupling `coupling` describes below -- a coupled net pair gets a direct capacitor between their two hub nodes, not just capacitors to the deck's ground/substrate net
* - coupling: vertical overlap (crossover) unconditionally -- where one net's conductor on an adjacent metal level sits directly over another *distinct* net's conductor, that overlap area is charged between the two nets instead of to ground (issue #760) -- plus lateral (same-layer, sidewall) coupling, but only for a net pair naming one of the caller's declared `--critical-net` nets (issue #976): facing-edge length within that layer's own minimum-spacing lookback is charged between the two nets, *additively* (not deducted from either net's substrate fringe term, unlike the vertical case -- a known simplification). Any same-layer pair with neither side named `--critical-net`, and fringe shielding in general, are still not modelled
* - resistance: single lumped series resistance per net, distributed as a star across that net's device terminals (issue #592) -- not a per-segment, distributed RC ladder, *unless* `--distributed-rc` names this net via `--critical-net` (issue #977, Epic #709 Phase 2b): then the net's terminals are ordered along their approximate physical spread and its total R/C is broken into a chain of per-segment resistors (segment length proportional to inter-terminal distance) with a ground capacitor at each terminal node (proportional to its adjacent segment length/2), instead of one star hub -- still an approximation (terminal position is a device-placement proxy, not true per-segment routing geometry), but a strictly finer-grained one than the single-hub star
* - frequency: quasi-static -- one frequency-independent R and C per net; no skin effect, no distributed transmission-line behavior
* - substrate tie: 1e+12 ohm to ground -- the substrate is capacitively floating in transient analysis (DC reference only); see --substrate-tie-ohms
.GLOBAL vsubs

* cell ro_array_core
* pin a,b,b3,invb_a,mn12_g1,mp24_g0,t2,y
* pin a,b,invb_a,mn12_g1,mp24_g0,ro2,y
* pin a,b,invb_a,mn12_g1,mp24_g0,ro4,y
* pin a,g_a,rn1,ro,s4_y,y
* pin a,g_a,rn2,ro,s4_y,y
* pin a,g_a,rn3,ro,s4_y,y
* pin a,g_a,rn4,ro,s4_y,y
* pin a,g_y,mnab_y,mpa_y,mpb_y,n1,s1_a,y
* pin a,g_y,mnab_y,mpa_y,mpb_y,n1,s1_a,y
* pin a,g_y,mnab_y,mpa_y,mpb_y,n1,s1_a,y
* pin a,g_y,mnab_y,mpa_y,mpb_y,n1,s1_a,y
* pin a,inva_a,mn12_g0,mp13_g0,ro1,y
* pin a,inva_a,mn12_g0,mp13_g0,ro3,y
* pin a,inva_a,mn12_g0,mp13_g0,t1,y
* pin a,n2,s1_y,s2_a,y
* pin a,n2,s1_y,s2_a,y
* pin a,n2,s1_y,s2_a,y
* pin a,n2,s1_y,s2_a,y
* pin a,n3,s2_y,s3_a,y
* pin a,n3,s2_y,s3_a,y
* pin a,n3,s2_y,s3_a,y
* pin a,n3,s2_y,s3_a,y
* pin a,n4,s3_y,s4_a,y
* pin a,n4,s3_y,s4_a,y
* pin a,n4,s3_y,s4_a,y
* pin a,n4,s3_y,s4_a,y
* pin an,inva_y,mn34_g0,mp13_g1,y
* pin an,inva_y,mn34_g0,mp13_g1,y
* pin an,inva_y,mn34_g0,mp13_g1,y
* pin bn,invb_y,mn34_g1,mp24_g1,y
* pin bn,invb_y,mn34_g1,mp24_g1,y
* pin bn,invb_y,mn34_g1,mp24_g1,y
* pin en,en1,g_en
* pin en,en2,g_en
* pin en,en3,g_en
* pin en,en4,g_en
* pin g_vddr_m1,mnt_g,s1_vddr_m1,s2_vddr_m1,s3_vddr_m1,s4_vddr_m1,vddr,vddr1
* pin g_vddr_m1,mnt_g,s1_vddr_m1,s2_vddr_m1,s3_vddr_m1,s4_vddr_m1,vddr,vddr2
* pin g_vddr_m1,mnt_g,s1_vddr_m1,s2_vddr_m1,s3_vddr_m1,s4_vddr_m1,vddr,vddr3
* pin g_vddr_m1,mnt_g,s1_vddr_m1,s2_vddr_m1,s3_vddr_m1,s4_vddr_m1,vddr,vddr4
* pin g_vss_m1,mph_g,s1_vss_m1,s2_vss_m1,s3_vss_m1,s4_vss_m1,vss,vss_x1,vss_x2,vss_x3
* pin mid
* pin mid
* pin mid
* pin mpa_py,mpb_py,mph_py,py
* pin mpa_py,mpb_py,mph_py,py
* pin mpa_py,mpb_py,mph_py,py
* pin mpa_py,mpb_py,mph_py,py
* pin ny
* pin ny
* pin ny
* pin ny
* pin ny
* pin ny
* pin ny
* pin ny
* pin ny
* pin ny
* pin ny
* pin ny
* pin ny
* pin ny
* pin ny
* pin ny
* pin ny
* pin ny
* pin ny
* pin ny
* pin py
* pin py
* pin py
* pin py
* pin py
* pin py
* pin py
* pin py
* pin py
* pin py
* pin py
* pin py
* pin py
* pin py
* pin py
* pin py
* pin vdd,vdd_b1,vdd_b2,vdd_b3,vdd_b4,vdd_x1,vdd_x2,vdd_x3
* pin xo,y
.SUBCKT ro_array_core a|b|b3|invb_a|mn12_g1|mp24_g0|t2|y
+ a|b|invb_a|mn12_g1|mp24_g0|ro2|y a|b|invb_a|mn12_g1|mp24_g0|ro4|y
+ a|g_a|rn1|ro|s4_y|y a|g_a|rn2|ro|s4_y|y a|g_a|rn3|ro|s4_y|y
+ a|g_a|rn4|ro|s4_y|y a|g_y|mnab_y|mpa_y|mpb_y|n1|s1_a|y
+ a|g_y|mnab_y|mpa_y|mpb_y|n1|s1_a|y$1 a|g_y|mnab_y|mpa_y|mpb_y|n1|s1_a|y$2
+ a|g_y|mnab_y|mpa_y|mpb_y|n1|s1_a|y$3 a|inva_a|mn12_g0|mp13_g0|ro1|y
+ a|inva_a|mn12_g0|mp13_g0|ro3|y a|inva_a|mn12_g0|mp13_g0|t1|y a|n2|s1_y|s2_a|y
+ a|n2|s1_y|s2_a|y$1 a|n2|s1_y|s2_a|y$2 a|n2|s1_y|s2_a|y$3 a|n3|s2_y|s3_a|y
+ a|n3|s2_y|s3_a|y$1 a|n3|s2_y|s3_a|y$2 a|n3|s2_y|s3_a|y$3 a|n4|s3_y|s4_a|y
+ a|n4|s3_y|s4_a|y$1 a|n4|s3_y|s4_a|y$2 a|n4|s3_y|s4_a|y$3
+ an|inva_y|mn34_g0|mp13_g1|y an|inva_y|mn34_g0|mp13_g1|y$1
+ an|inva_y|mn34_g0|mp13_g1|y$2 bn|invb_y|mn34_g1|mp24_g1|y
+ bn|invb_y|mn34_g1|mp24_g1|y$1 bn|invb_y|mn34_g1|mp24_g1|y$2 en|en1|g_en
+ en|en2|g_en en|en3|g_en en|en4|g_en
+ g_vddr_m1|mnt_g|s1_vddr_m1|s2_vddr_m1|s3_vddr_m1|s4_vddr_m1|vddr|vddr1
+ g_vddr_m1|mnt_g|s1_vddr_m1|s2_vddr_m1|s3_vddr_m1|s4_vddr_m1|vddr|vddr2
+ g_vddr_m1|mnt_g|s1_vddr_m1|s2_vddr_m1|s3_vddr_m1|s4_vddr_m1|vddr|vddr3
+ g_vddr_m1|mnt_g|s1_vddr_m1|s2_vddr_m1|s3_vddr_m1|s4_vddr_m1|vddr|vddr4
+ g_vss_m1|mph_g|s1_vss_m1|s2_vss_m1|s3_vss_m1|s4_vss_m1|vss|vss_x1|vss_x2|vss_x3
+ mid mid$1 mid$2 mpa_py|mpb_py|mph_py|py mpa_py|mpb_py|mph_py|py$1
+ mpa_py|mpb_py|mph_py|py$2 mpa_py|mpb_py|mph_py|py$3 ny ny$1 ny$2 ny$3 ny$4
+ ny$5 ny$6 ny$7 ny$8 ny$9 ny$10 ny$11 ny$12 ny$13 ny$14 ny$15 ny$16 ny$17
+ ny$18 ny$19 py py$1 py$2 py$3 py$4 py$5 py$6 py$7 py$8 py$9 py$10 py$11 py$12
+ py$13 py$14 py$15 vdd|vdd_b1|vdd_b2|vdd_b3|vdd_b4|vdd_x1|vdd_x2|vdd_x3 xo|y
* device instance $1 r0 *1 6.225,0.21 nfet
X$1 \$11__t1 en|en1|g_en__t0 ny__t0
+ g_vss_m1|mph_g|s1_vss_m1|s2_vss_m1|s3_vss_m1|s4_vss_m1|vss|vss_x1|vss_x2|vss_x3__t56
+ sky130_fd_pr__nfet_01v8 L=0.15 W=0.84 AS=0.3948 AD=0.2184 PS=2.62 PD=1.36
* device instance $2 r0 *1 6.895,0.21 nfet
X$2 a|g_y|mnab_y|mpa_y|mpb_y|n1|s1_a|y__t02 a|g_a|rn1|ro|s4_y|y__t0 \$11__t0
+ g_vss_m1|mph_g|s1_vss_m1|s2_vss_m1|s3_vss_m1|s4_vss_m1|vss|vss_x1|vss_x2|vss_x3__t66
+ sky130_fd_pr__nfet_01v8 L=0.15 W=0.84 AS=0.2184 AD=0.3948 PS=1.36 PD=2.62
* device instance $3 r0 *1 61.525,0.21 nfet
X$3 \$20__t0 en|en2|g_en__t1 ny__t16
+ g_vss_m1|mph_g|s1_vss_m1|s2_vss_m1|s3_vss_m1|s4_vss_m1|vss|vss_x1|vss_x2|vss_x3__t57
+ sky130_fd_pr__nfet_01v8 L=0.15 W=0.84 AS=0.3948 AD=0.2184 PS=2.62 PD=1.36
* device instance $4 r0 *1 62.195,0.21 nfet
X$4 a|g_y|mnab_y|mpa_y|mpb_y|n1|s1_a|y__t4 a|g_a|rn2|ro|s4_y|y__t5 \$20__t1
+ g_vss_m1|mph_g|s1_vss_m1|s2_vss_m1|s3_vss_m1|s4_vss_m1|vss|vss_x1|vss_x2|vss_x3__t67
+ sky130_fd_pr__nfet_01v8 L=0.15 W=0.84 AS=0.2184 AD=0.3948 PS=1.36 PD=2.62
* device instance $5 r0 *1 116.825,0.21 nfet
X$5 \$29__t0 en|en3|g_en__t1 ny__t111
+ g_vss_m1|mph_g|s1_vss_m1|s2_vss_m1|s3_vss_m1|s4_vss_m1|vss|vss_x1|vss_x2|vss_x3__t58
+ sky130_fd_pr__nfet_01v8 L=0.15 W=0.84 AS=0.3948 AD=0.2184 PS=2.62 PD=1.36
* device instance $6 r0 *1 117.495,0.21 nfet
X$6 a|g_y|mnab_y|mpa_y|mpb_y|n1|s1_a|y__t43 a|g_a|rn3|ro|s4_y|y__t5 \$29__t1
+ g_vss_m1|mph_g|s1_vss_m1|s2_vss_m1|s3_vss_m1|s4_vss_m1|vss|vss_x1|vss_x2|vss_x3__t68
+ sky130_fd_pr__nfet_01v8 L=0.15 W=0.84 AS=0.2184 AD=0.3948 PS=1.36 PD=2.62
* device instance $7 r0 *1 172.125,0.21 nfet
X$7 \$38__t0 en|en4|g_en__t1 ny__t116
+ g_vss_m1|mph_g|s1_vss_m1|s2_vss_m1|s3_vss_m1|s4_vss_m1|vss|vss_x1|vss_x2|vss_x3__t59
+ sky130_fd_pr__nfet_01v8 L=0.15 W=0.84 AS=0.3948 AD=0.2184 PS=2.62 PD=1.36
* device instance $8 r0 *1 172.795,0.21 nfet
X$8 a|g_y|mnab_y|mpa_y|mpb_y|n1|s1_a|y__t44 a|g_a|rn4|ro|s4_y|y__t5 \$38__t1
+ g_vss_m1|mph_g|s1_vss_m1|s2_vss_m1|s3_vss_m1|s4_vss_m1|vss|vss_x1|vss_x2|vss_x3__t69
+ sky130_fd_pr__nfet_01v8 L=0.15 W=0.84 AS=0.2184 AD=0.3948 PS=1.36 PD=2.62
* device instance $9 r0 *1 114.21,0.21 nfet
X$9 ny__t011
+ g_vddr_m1|mnt_g|s1_vddr_m1|s2_vddr_m1|s3_vddr_m1|s4_vddr_m1|vddr|vddr3__t0
+ g_vss_m1|mph_g|s1_vss_m1|s2_vss_m1|s3_vss_m1|s4_vss_m1|vss|vss_x1|vss_x2|vss_x3__t2
+ g_vss_m1|mph_g|s1_vss_m1|s2_vss_m1|s3_vss_m1|s4_vss_m1|vss|vss_x1|vss_x2|vss_x3__t76
+ sky130_fd_pr__nfet_01v8 L=2 W=0.46 AS=0.1932 AD=0.1932 PS=1.76 PD=1.76
* device instance $10 r0 *1 123.51,0.21 nfet
X$10 ny__t012
+ g_vddr_m1|mnt_g|s1_vddr_m1|s2_vddr_m1|s3_vddr_m1|s4_vddr_m1|vddr|vddr3__t20
+ g_vss_m1|mph_g|s1_vss_m1|s2_vss_m1|s3_vss_m1|s4_vss_m1|vss|vss_x1|vss_x2|vss_x3__t31
+ g_vss_m1|mph_g|s1_vss_m1|s2_vss_m1|s3_vss_m1|s4_vss_m1|vss|vss_x1|vss_x2|vss_x3__t77
+ sky130_fd_pr__nfet_01v8 L=2 W=0.46 AS=0.1932 AD=0.1932 PS=1.76 PD=1.76
* device instance $11 r0 *1 131.685,0.21 nfet
X$11 ny__t013
+ g_vddr_m1|mnt_g|s1_vddr_m1|s2_vddr_m1|s3_vddr_m1|s4_vddr_m1|vddr|vddr3__t17
+ g_vss_m1|mph_g|s1_vss_m1|s2_vss_m1|s3_vss_m1|s4_vss_m1|vss|vss_x1|vss_x2|vss_x3__t28
+ g_vss_m1|mph_g|s1_vss_m1|s2_vss_m1|s3_vss_m1|s4_vss_m1|vss|vss_x1|vss_x2|vss_x3__t78
+ sky130_fd_pr__nfet_01v8 L=2 W=0.46 AS=0.1932 AD=0.1932 PS=1.76 PD=1.76
* device instance $12 r0 *1 139.86,0.21 nfet
X$12 ny__t014
+ g_vddr_m1|mnt_g|s1_vddr_m1|s2_vddr_m1|s3_vddr_m1|s4_vddr_m1|vddr|vddr3__t18
+ g_vss_m1|mph_g|s1_vss_m1|s2_vss_m1|s3_vss_m1|s4_vss_m1|vss|vss_x1|vss_x2|vss_x3__t29
+ g_vss_m1|mph_g|s1_vss_m1|s2_vss_m1|s3_vss_m1|s4_vss_m1|vss|vss_x1|vss_x2|vss_x3__t79
+ sky130_fd_pr__nfet_01v8 L=2 W=0.46 AS=0.1932 AD=0.1932 PS=1.76 PD=1.76
* device instance $13 r0 *1 148.035,0.21 nfet
X$13 ny__t015
+ g_vddr_m1|mnt_g|s1_vddr_m1|s2_vddr_m1|s3_vddr_m1|s4_vddr_m1|vddr|vddr3__t19
+ g_vss_m1|mph_g|s1_vss_m1|s2_vss_m1|s3_vss_m1|s4_vss_m1|vss|vss_x1|vss_x2|vss_x3__t30
+ g_vss_m1|mph_g|s1_vss_m1|s2_vss_m1|s3_vss_m1|s4_vss_m1|vss|vss_x1|vss_x2|vss_x3__t80
+ sky130_fd_pr__nfet_01v8 L=2 W=0.46 AS=0.1932 AD=0.1932 PS=1.76 PD=1.76
* device instance $14 r0 *1 169.51,0.21 nfet
X$14 ny__t016
+ g_vddr_m1|mnt_g|s1_vddr_m1|s2_vddr_m1|s3_vddr_m1|s4_vddr_m1|vddr|vddr4__t0
+ g_vss_m1|mph_g|s1_vss_m1|s2_vss_m1|s3_vss_m1|s4_vss_m1|vss|vss_x1|vss_x2|vss_x3__t3
+ g_vss_m1|mph_g|s1_vss_m1|s2_vss_m1|s3_vss_m1|s4_vss_m1|vss|vss_x1|vss_x2|vss_x3__t81
+ sky130_fd_pr__nfet_01v8 L=2 W=0.48 AS=0.2016 AD=0.2016 PS=1.8 PD=1.8
* device instance $15 r0 *1 178.81,0.21 nfet
X$15 ny__t017
+ g_vddr_m1|mnt_g|s1_vddr_m1|s2_vddr_m1|s3_vddr_m1|s4_vddr_m1|vddr|vddr4__t17
+ g_vss_m1|mph_g|s1_vss_m1|s2_vss_m1|s3_vss_m1|s4_vss_m1|vss|vss_x1|vss_x2|vss_x3__t24
+ g_vss_m1|mph_g|s1_vss_m1|s2_vss_m1|s3_vss_m1|s4_vss_m1|vss|vss_x1|vss_x2|vss_x3__t82
+ sky130_fd_pr__nfet_01v8 L=2 W=0.48 AS=0.2016 AD=0.2016 PS=1.8 PD=1.8
* device instance $16 r0 *1 186.985,0.21 nfet
X$16 ny__t018
+ g_vddr_m1|mnt_g|s1_vddr_m1|s2_vddr_m1|s3_vddr_m1|s4_vddr_m1|vddr|vddr4__t18
+ g_vss_m1|mph_g|s1_vss_m1|s2_vss_m1|s3_vss_m1|s4_vss_m1|vss|vss_x1|vss_x2|vss_x3__t25
+ g_vss_m1|mph_g|s1_vss_m1|s2_vss_m1|s3_vss_m1|s4_vss_m1|vss|vss_x1|vss_x2|vss_x3__t83
+ sky130_fd_pr__nfet_01v8 L=2 W=0.48 AS=0.2016 AD=0.2016 PS=1.8 PD=1.8
* device instance $17 r0 *1 195.16,0.21 nfet
X$17 ny__t019
+ g_vddr_m1|mnt_g|s1_vddr_m1|s2_vddr_m1|s3_vddr_m1|s4_vddr_m1|vddr|vddr4__t19
+ g_vss_m1|mph_g|s1_vss_m1|s2_vss_m1|s3_vss_m1|s4_vss_m1|vss|vss_x1|vss_x2|vss_x3__t26
+ g_vss_m1|mph_g|s1_vss_m1|s2_vss_m1|s3_vss_m1|s4_vss_m1|vss|vss_x1|vss_x2|vss_x3__t84
+ sky130_fd_pr__nfet_01v8 L=2 W=0.48 AS=0.2016 AD=0.2016 PS=1.8 PD=1.8
* device instance $18 r0 *1 203.335,0.21 nfet
X$18 ny__t020
+ g_vddr_m1|mnt_g|s1_vddr_m1|s2_vddr_m1|s3_vddr_m1|s4_vddr_m1|vddr|vddr4__t20
+ g_vss_m1|mph_g|s1_vss_m1|s2_vss_m1|s3_vss_m1|s4_vss_m1|vss|vss_x1|vss_x2|vss_x3__t27
+ g_vss_m1|mph_g|s1_vss_m1|s2_vss_m1|s3_vss_m1|s4_vss_m1|vss|vss_x1|vss_x2|vss_x3__t85
+ sky130_fd_pr__nfet_01v8 L=2 W=0.48 AS=0.2016 AD=0.2016 PS=1.8 PD=1.8
* device instance $19 r0 *1 3.61,0.21 nfet
X$19 ny__t1
+ g_vddr_m1|mnt_g|s1_vddr_m1|s2_vddr_m1|s3_vddr_m1|s4_vddr_m1|vddr|vddr1__t0
+ g_vss_m1|mph_g|s1_vss_m1|s2_vss_m1|s3_vss_m1|s4_vss_m1|vss|vss_x1|vss_x2|vss_x3__t0
+ g_vss_m1|mph_g|s1_vss_m1|s2_vss_m1|s3_vss_m1|s4_vss_m1|vss|vss_x1|vss_x2|vss_x3__t86
+ sky130_fd_pr__nfet_01v8 L=2 W=0.42 AS=0.1764 AD=0.1764 PS=1.68 PD=1.68
* device instance $20 r0 *1 12.91,0.21 nfet
X$20 ny__t12
+ g_vddr_m1|mnt_g|s1_vddr_m1|s2_vddr_m1|s3_vddr_m1|s4_vddr_m1|vddr|vddr1__t17
+ g_vss_m1|mph_g|s1_vss_m1|s2_vss_m1|s3_vss_m1|s4_vss_m1|vss|vss_x1|vss_x2|vss_x3__t46
+ g_vss_m1|mph_g|s1_vss_m1|s2_vss_m1|s3_vss_m1|s4_vss_m1|vss|vss_x1|vss_x2|vss_x3__t87
+ sky130_fd_pr__nfet_01v8 L=2 W=0.42 AS=0.1764 AD=0.1764 PS=1.68 PD=1.68
* device instance $21 r0 *1 15.515,0.21 nfet
X$21 a|n2|s1_y|s2_a|y__t0 a|g_y|mnab_y|mpa_y|mpb_y|n1|s1_a|y__t12 ny__t02
+ g_vss_m1|mph_g|s1_vss_m1|s2_vss_m1|s3_vss_m1|s4_vss_m1|vss|vss_x1|vss_x2|vss_x3__t91
+ sky130_fd_pr__nfet_01v8 L=0.15 W=0.42 AS=0.1974 AD=0.1974 PS=1.78 PD=1.78
* device instance $22 r0 *1 21.085,0.21 nfet
X$22 ny__t13
+ g_vddr_m1|mnt_g|s1_vddr_m1|s2_vddr_m1|s3_vddr_m1|s4_vddr_m1|vddr|vddr1__t18
+ g_vss_m1|mph_g|s1_vss_m1|s2_vss_m1|s3_vss_m1|s4_vss_m1|vss|vss_x1|vss_x2|vss_x3__t47
+ g_vss_m1|mph_g|s1_vss_m1|s2_vss_m1|s3_vss_m1|s4_vss_m1|vss|vss_x1|vss_x2|vss_x3__t88
+ sky130_fd_pr__nfet_01v8 L=2 W=0.42 AS=0.1764 AD=0.1764 PS=1.68 PD=1.68
* device instance $23 r0 *1 23.69,0.21 nfet
X$23 a|n3|s2_y|s3_a|y__t2 a|n2|s1_y|s2_a|y__t3 ny__t03
+ g_vss_m1|mph_g|s1_vss_m1|s2_vss_m1|s3_vss_m1|s4_vss_m1|vss|vss_x1|vss_x2|vss_x3__t92
+ sky130_fd_pr__nfet_01v8 L=0.15 W=0.42 AS=0.1974 AD=0.1974 PS=1.78 PD=1.78
* device instance $24 r0 *1 29.26,0.21 nfet
X$24 ny__t14
+ g_vddr_m1|mnt_g|s1_vddr_m1|s2_vddr_m1|s3_vddr_m1|s4_vddr_m1|vddr|vddr1__t20
+ g_vss_m1|mph_g|s1_vss_m1|s2_vss_m1|s3_vss_m1|s4_vss_m1|vss|vss_x1|vss_x2|vss_x3__t49
+ g_vss_m1|mph_g|s1_vss_m1|s2_vss_m1|s3_vss_m1|s4_vss_m1|vss|vss_x1|vss_x2|vss_x3__t89
+ sky130_fd_pr__nfet_01v8 L=2 W=0.42 AS=0.1764 AD=0.1764 PS=1.68 PD=1.68
* device instance $25 r0 *1 31.865,0.21 nfet
X$25 a|n4|s3_y|s4_a|y__t2 a|n3|s2_y|s3_a|y__t3 ny__t04
+ g_vss_m1|mph_g|s1_vss_m1|s2_vss_m1|s3_vss_m1|s4_vss_m1|vss|vss_x1|vss_x2|vss_x3__t93
+ sky130_fd_pr__nfet_01v8 L=0.15 W=0.42 AS=0.1974 AD=0.1974 PS=1.78 PD=1.78
* device instance $26 r0 *1 37.435,0.21 nfet
X$26 ny__t15
+ g_vddr_m1|mnt_g|s1_vddr_m1|s2_vddr_m1|s3_vddr_m1|s4_vddr_m1|vddr|vddr1__t19
+ g_vss_m1|mph_g|s1_vss_m1|s2_vss_m1|s3_vss_m1|s4_vss_m1|vss|vss_x1|vss_x2|vss_x3__t48
+ g_vss_m1|mph_g|s1_vss_m1|s2_vss_m1|s3_vss_m1|s4_vss_m1|vss|vss_x1|vss_x2|vss_x3__t90
+ sky130_fd_pr__nfet_01v8 L=2 W=0.42 AS=0.1764 AD=0.1764 PS=1.68 PD=1.68
* device instance $27 r0 *1 40.04,0.21 nfet
X$27 a|g_a|rn1|ro|s4_y|y__t4 a|n4|s3_y|s4_a|y__t3 ny__t05
+ g_vss_m1|mph_g|s1_vss_m1|s2_vss_m1|s3_vss_m1|s4_vss_m1|vss|vss_x1|vss_x2|vss_x3__t94
+ sky130_fd_pr__nfet_01v8 L=0.15 W=0.42 AS=0.1974 AD=0.1974 PS=1.78 PD=1.78
* device instance $28 r0 *1 48.86,0.21 nfet
X$28 a|inva_a|mn12_g0|mp13_g0|ro1|y__t3 a|g_a|rn1|ro|s4_y|y__t5
+ g_vss_m1|mph_g|s1_vss_m1|s2_vss_m1|s3_vss_m1|s4_vss_m1|vss|vss_x1|vss_x2|vss_x3__t41
+ g_vss_m1|mph_g|s1_vss_m1|s2_vss_m1|s3_vss_m1|s4_vss_m1|vss|vss_x1|vss_x2|vss_x3__t95
+ sky130_fd_pr__nfet_01v8 L=0.15 W=0.42 AS=0.1974 AD=0.1974 PS=1.78 PD=1.78
* device instance $29 r0 *1 58.91,0.21 nfet
X$29 ny__t06
+ g_vddr_m1|mnt_g|s1_vddr_m1|s2_vddr_m1|s3_vddr_m1|s4_vddr_m1|vddr|vddr2__t0
+ g_vss_m1|mph_g|s1_vss_m1|s2_vss_m1|s3_vss_m1|s4_vss_m1|vss|vss_x1|vss_x2|vss_x3__t1
+ g_vss_m1|mph_g|s1_vss_m1|s2_vss_m1|s3_vss_m1|s4_vss_m1|vss|vss_x1|vss_x2|vss_x3__t117
+ sky130_fd_pr__nfet_01v8 L=2 W=0.44 AS=0.1848 AD=0.1848 PS=1.72 PD=1.72
* device instance $30 r0 *1 68.21,0.21 nfet
X$30 ny__t07
+ g_vddr_m1|mnt_g|s1_vddr_m1|s2_vddr_m1|s3_vddr_m1|s4_vddr_m1|vddr|vddr2__t20
+ g_vss_m1|mph_g|s1_vss_m1|s2_vss_m1|s3_vss_m1|s4_vss_m1|vss|vss_x1|vss_x2|vss_x3__t35
+ g_vss_m1|mph_g|s1_vss_m1|s2_vss_m1|s3_vss_m1|s4_vss_m1|vss|vss_x1|vss_x2|vss_x3__t118
+ sky130_fd_pr__nfet_01v8 L=2 W=0.44 AS=0.1848 AD=0.1848 PS=1.72 PD=1.72
* device instance $31 r0 *1 70.815,0.21 nfet
X$31 a|n2|s1_y|s2_a|y__t22 a|g_y|mnab_y|mpa_y|mpb_y|n1|s1_a|y__t3 ny__t17
+ g_vss_m1|mph_g|s1_vss_m1|s2_vss_m1|s3_vss_m1|s4_vss_m1|vss|vss_x1|vss_x2|vss_x3__t96
+ sky130_fd_pr__nfet_01v8 L=0.15 W=0.42 AS=0.1974 AD=0.1974 PS=1.78 PD=1.78
* device instance $32 r0 *1 76.385,0.21 nfet
X$32 ny__t08
+ g_vddr_m1|mnt_g|s1_vddr_m1|s2_vddr_m1|s3_vddr_m1|s4_vddr_m1|vddr|vddr2__t18
+ g_vss_m1|mph_g|s1_vss_m1|s2_vss_m1|s3_vss_m1|s4_vss_m1|vss|vss_x1|vss_x2|vss_x3__t33
+ g_vss_m1|mph_g|s1_vss_m1|s2_vss_m1|s3_vss_m1|s4_vss_m1|vss|vss_x1|vss_x2|vss_x3__t119
+ sky130_fd_pr__nfet_01v8 L=2 W=0.44 AS=0.1848 AD=0.1848 PS=1.72 PD=1.72
* device instance $33 r0 *1 78.99,0.21 nfet
X$33 a|n3|s2_y|s3_a|y__t22 a|n2|s1_y|s2_a|y__t32 ny__t18
+ g_vss_m1|mph_g|s1_vss_m1|s2_vss_m1|s3_vss_m1|s4_vss_m1|vss|vss_x1|vss_x2|vss_x3__t97
+ sky130_fd_pr__nfet_01v8 L=0.15 W=0.42 AS=0.1974 AD=0.1974 PS=1.78 PD=1.78
* device instance $34 r0 *1 84.56,0.21 nfet
X$34 ny__t09
+ g_vddr_m1|mnt_g|s1_vddr_m1|s2_vddr_m1|s3_vddr_m1|s4_vddr_m1|vddr|vddr2__t19
+ g_vss_m1|mph_g|s1_vss_m1|s2_vss_m1|s3_vss_m1|s4_vss_m1|vss|vss_x1|vss_x2|vss_x3__t34
+ g_vss_m1|mph_g|s1_vss_m1|s2_vss_m1|s3_vss_m1|s4_vss_m1|vss|vss_x1|vss_x2|vss_x3__t120
+ sky130_fd_pr__nfet_01v8 L=2 W=0.44 AS=0.1848 AD=0.1848 PS=1.72 PD=1.72
* device instance $35 r0 *1 87.165,0.21 nfet
X$35 a|n4|s3_y|s4_a|y__t24 a|n3|s2_y|s3_a|y__t32 ny__t19
+ g_vss_m1|mph_g|s1_vss_m1|s2_vss_m1|s3_vss_m1|s4_vss_m1|vss|vss_x1|vss_x2|vss_x3__t98
+ sky130_fd_pr__nfet_01v8 L=0.15 W=0.42 AS=0.1974 AD=0.1974 PS=1.78 PD=1.78
* device instance $36 r0 *1 92.735,0.21 nfet
X$36 ny__t010
+ g_vddr_m1|mnt_g|s1_vddr_m1|s2_vddr_m1|s3_vddr_m1|s4_vddr_m1|vddr|vddr2__t17
+ g_vss_m1|mph_g|s1_vss_m1|s2_vss_m1|s3_vss_m1|s4_vss_m1|vss|vss_x1|vss_x2|vss_x3__t32
+ g_vss_m1|mph_g|s1_vss_m1|s2_vss_m1|s3_vss_m1|s4_vss_m1|vss|vss_x1|vss_x2|vss_x3__t121
+ sky130_fd_pr__nfet_01v8 L=2 W=0.44 AS=0.1848 AD=0.1848 PS=1.72 PD=1.72
* device instance $37 r0 *1 95.34,0.21 nfet
X$37 a|g_a|rn2|ro|s4_y|y__t3 a|n4|s3_y|s4_a|y__t34 ny__t110
+ g_vss_m1|mph_g|s1_vss_m1|s2_vss_m1|s3_vss_m1|s4_vss_m1|vss|vss_x1|vss_x2|vss_x3__t99
+ sky130_fd_pr__nfet_01v8 L=0.15 W=0.42 AS=0.1974 AD=0.1974 PS=1.78 PD=1.78
* device instance $38 r0 *1 104.16,0.21 nfet
X$38 a|b|invb_a|mn12_g1|mp24_g0|ro2|y__t3 a|g_a|rn2|ro|s4_y|y__t4
+ g_vss_m1|mph_g|s1_vss_m1|s2_vss_m1|s3_vss_m1|s4_vss_m1|vss|vss_x1|vss_x2|vss_x3__t38
+ g_vss_m1|mph_g|s1_vss_m1|s2_vss_m1|s3_vss_m1|s4_vss_m1|vss|vss_x1|vss_x2|vss_x3__t100
+ sky130_fd_pr__nfet_01v8 L=0.15 W=0.42 AS=0.1974 AD=0.1974 PS=1.78 PD=1.78
* device instance $39 r0 *1 126.115,0.21 nfet
X$39 a|n2|s1_y|s2_a|y__t23 a|g_y|mnab_y|mpa_y|mpb_y|n1|s1_a|y__t33 ny__t112
+ g_vss_m1|mph_g|s1_vss_m1|s2_vss_m1|s3_vss_m1|s4_vss_m1|vss|vss_x1|vss_x2|vss_x3__t101
+ sky130_fd_pr__nfet_01v8 L=0.15 W=0.42 AS=0.1974 AD=0.1974 PS=1.78 PD=1.78
* device instance $40 r0 *1 134.29,0.21 nfet
X$40 a|n3|s2_y|s3_a|y__t23 a|n2|s1_y|s2_a|y__t33 ny__t113
+ g_vss_m1|mph_g|s1_vss_m1|s2_vss_m1|s3_vss_m1|s4_vss_m1|vss|vss_x1|vss_x2|vss_x3__t102
+ sky130_fd_pr__nfet_01v8 L=0.15 W=0.42 AS=0.1974 AD=0.1974 PS=1.78 PD=1.78
* device instance $41 r0 *1 142.465,0.21 nfet
X$41 a|n4|s3_y|s4_a|y__t22 a|n3|s2_y|s3_a|y__t33 ny__t114
+ g_vss_m1|mph_g|s1_vss_m1|s2_vss_m1|s3_vss_m1|s4_vss_m1|vss|vss_x1|vss_x2|vss_x3__t103
+ sky130_fd_pr__nfet_01v8 L=0.15 W=0.42 AS=0.1974 AD=0.1974 PS=1.78 PD=1.78
* device instance $42 r0 *1 150.64,0.21 nfet
X$42 a|g_a|rn3|ro|s4_y|y__t3 a|n4|s3_y|s4_a|y__t32 ny__t115
+ g_vss_m1|mph_g|s1_vss_m1|s2_vss_m1|s3_vss_m1|s4_vss_m1|vss|vss_x1|vss_x2|vss_x3__t104
+ sky130_fd_pr__nfet_01v8 L=0.15 W=0.42 AS=0.1974 AD=0.1974 PS=1.78 PD=1.78
* device instance $43 r0 *1 159.46,0.21 nfet
X$43 a|inva_a|mn12_g0|mp13_g0|ro3|y__t3 a|g_a|rn3|ro|s4_y|y__t4
+ g_vss_m1|mph_g|s1_vss_m1|s2_vss_m1|s3_vss_m1|s4_vss_m1|vss|vss_x1|vss_x2|vss_x3__t36
+ g_vss_m1|mph_g|s1_vss_m1|s2_vss_m1|s3_vss_m1|s4_vss_m1|vss|vss_x1|vss_x2|vss_x3__t105
+ sky130_fd_pr__nfet_01v8 L=0.15 W=0.42 AS=0.1974 AD=0.1974 PS=1.78 PD=1.78
* device instance $44 r0 *1 181.415,0.21 nfet
X$44 a|n2|s1_y|s2_a|y__t24 a|g_y|mnab_y|mpa_y|mpb_y|n1|s1_a|y__t34 ny__t117
+ g_vss_m1|mph_g|s1_vss_m1|s2_vss_m1|s3_vss_m1|s4_vss_m1|vss|vss_x1|vss_x2|vss_x3__t106
+ sky130_fd_pr__nfet_01v8 L=0.15 W=0.42 AS=0.1974 AD=0.1974 PS=1.78 PD=1.78
* device instance $45 r0 *1 189.59,0.21 nfet
X$45 a|n3|s2_y|s3_a|y__t24 a|n2|s1_y|s2_a|y__t34 ny__t118
+ g_vss_m1|mph_g|s1_vss_m1|s2_vss_m1|s3_vss_m1|s4_vss_m1|vss|vss_x1|vss_x2|vss_x3__t107
+ sky130_fd_pr__nfet_01v8 L=0.15 W=0.42 AS=0.1974 AD=0.1974 PS=1.78 PD=1.78
* device instance $46 r0 *1 197.765,0.21 nfet
X$46 a|n4|s3_y|s4_a|y__t23 a|n3|s2_y|s3_a|y__t34 ny__t119
+ g_vss_m1|mph_g|s1_vss_m1|s2_vss_m1|s3_vss_m1|s4_vss_m1|vss|vss_x1|vss_x2|vss_x3__t108
+ sky130_fd_pr__nfet_01v8 L=0.15 W=0.42 AS=0.1974 AD=0.1974 PS=1.78 PD=1.78
* device instance $47 r0 *1 205.94,0.21 nfet
X$47 a|g_a|rn4|ro|s4_y|y__t3 a|n4|s3_y|s4_a|y__t33 ny__t120
+ g_vss_m1|mph_g|s1_vss_m1|s2_vss_m1|s3_vss_m1|s4_vss_m1|vss|vss_x1|vss_x2|vss_x3__t109
+ sky130_fd_pr__nfet_01v8 L=0.15 W=0.42 AS=0.1974 AD=0.1974 PS=1.78 PD=1.78
* device instance $48 r0 *1 214.76,0.21 nfet
X$48 a|b|invb_a|mn12_g1|mp24_g0|ro4|y__t3 a|g_a|rn4|ro|s4_y|y__t4
+ g_vss_m1|mph_g|s1_vss_m1|s2_vss_m1|s3_vss_m1|s4_vss_m1|vss|vss_x1|vss_x2|vss_x3__t44
+ g_vss_m1|mph_g|s1_vss_m1|s2_vss_m1|s3_vss_m1|s4_vss_m1|vss|vss_x1|vss_x2|vss_x3__t110
+ sky130_fd_pr__nfet_01v8 L=0.15 W=0.42 AS=0.1974 AD=0.1974 PS=1.78 PD=1.78
* device instance $49 r0 *1 3.445,17.905 nfet
X$49 an|inva_y|mn34_g0|mp13_g1|y__t2 a|inva_a|mn12_g0|mp13_g0|ro1|y__t4
+ g_vss_m1|mph_g|s1_vss_m1|s2_vss_m1|s3_vss_m1|s4_vss_m1|vss|vss_x1|vss_x2|vss_x3__t37
+ g_vss_m1|mph_g|s1_vss_m1|s2_vss_m1|s3_vss_m1|s4_vss_m1|vss|vss_x1|vss_x2|vss_x3__t111
+ sky130_fd_pr__nfet_01v8 L=0.15 W=0.42 AS=0.1974 AD=0.1974 PS=1.78 PD=1.78
* device instance $50 r0 *1 7.78,15.585 nfet
X$50 \$80__t0 an|inva_y|mn34_g0|mp13_g1|y__t3 a|inva_a|mn12_g0|mp13_g0|t1|y__t7
+ g_vss_m1|mph_g|s1_vss_m1|s2_vss_m1|s3_vss_m1|s4_vss_m1|vss|vss_x1|vss_x2|vss_x3__t60
+ sky130_fd_pr__nfet_01v8 L=0.15 W=0.84 AS=0.3948 AD=0.2184 PS=2.62 PD=1.36
* device instance $51 r0 *1 8.45,15.585 nfet
X$51
+ g_vss_m1|mph_g|s1_vss_m1|s2_vss_m1|s3_vss_m1|s4_vss_m1|vss|vss_x1|vss_x2|vss_x3__t50
+ bn|invb_y|mn34_g1|mp24_g1|y__t32 \$80__t1
+ g_vss_m1|mph_g|s1_vss_m1|s2_vss_m1|s3_vss_m1|s4_vss_m1|vss|vss_x1|vss_x2|vss_x3__t70
+ sky130_fd_pr__nfet_01v8 L=0.15 W=0.84 AS=0.2184 AD=0.3948 PS=1.36 PD=2.62
* device instance $52 r0 *1 14.78,15.585 nfet
X$52 \$82__t0 a|inva_a|mn12_g0|mp13_g0|ro1|y__t5
+ a|inva_a|mn12_g0|mp13_g0|t1|y__t6
+ g_vss_m1|mph_g|s1_vss_m1|s2_vss_m1|s3_vss_m1|s4_vss_m1|vss|vss_x1|vss_x2|vss_x3__t61
+ sky130_fd_pr__nfet_01v8 L=0.15 W=0.84 AS=0.3948 AD=0.2184 PS=2.62 PD=1.36
* device instance $53 r0 *1 15.45,15.585 nfet
X$53
+ g_vss_m1|mph_g|s1_vss_m1|s2_vss_m1|s3_vss_m1|s4_vss_m1|vss|vss_x1|vss_x2|vss_x3__t53
+ a|b|invb_a|mn12_g1|mp24_g0|ro2|y__t5 \$82__t1
+ g_vss_m1|mph_g|s1_vss_m1|s2_vss_m1|s3_vss_m1|s4_vss_m1|vss|vss_x1|vss_x2|vss_x3__t71
+ sky130_fd_pr__nfet_01v8 L=0.15 W=0.84 AS=0.2184 AD=0.3948 PS=1.36 PD=2.62
* device instance $54 r0 *1 21.62,17.905 nfet
X$54 bn|invb_y|mn34_g1|mp24_g1|y__t22 a|b|invb_a|mn12_g1|mp24_g0|ro2|y__t4
+ g_vss_m1|mph_g|s1_vss_m1|s2_vss_m1|s3_vss_m1|s4_vss_m1|vss|vss_x1|vss_x2|vss_x3__t39
+ g_vss_m1|mph_g|s1_vss_m1|s2_vss_m1|s3_vss_m1|s4_vss_m1|vss|vss_x1|vss_x2|vss_x3__t112
+ sky130_fd_pr__nfet_01v8 L=0.15 W=0.42 AS=0.1974 AD=0.1974 PS=1.78 PD=1.78
* device instance $55 r0 *1 32.415,17.905 nfet
X$55 an|inva_y|mn34_g0|mp13_g1|y__t22 a|inva_a|mn12_g0|mp13_g0|ro3|y__t4
+ g_vss_m1|mph_g|s1_vss_m1|s2_vss_m1|s3_vss_m1|s4_vss_m1|vss|vss_x1|vss_x2|vss_x3__t40
+ g_vss_m1|mph_g|s1_vss_m1|s2_vss_m1|s3_vss_m1|s4_vss_m1|vss|vss_x1|vss_x2|vss_x3__t113
+ sky130_fd_pr__nfet_01v8 L=0.15 W=0.42 AS=0.1974 AD=0.1974 PS=1.78 PD=1.78
* device instance $56 r0 *1 36.75,15.585 nfet
X$56 \$83__t0 an|inva_y|mn34_g0|mp13_g1|y__t32
+ a|b|b3|invb_a|mn12_g1|mp24_g0|t2|y__t6
+ g_vss_m1|mph_g|s1_vss_m1|s2_vss_m1|s3_vss_m1|s4_vss_m1|vss|vss_x1|vss_x2|vss_x3__t62
+ sky130_fd_pr__nfet_01v8 L=0.15 W=0.84 AS=0.3948 AD=0.2184 PS=2.62 PD=1.36
* device instance $57 r0 *1 37.42,15.585 nfet
X$57
+ g_vss_m1|mph_g|s1_vss_m1|s2_vss_m1|s3_vss_m1|s4_vss_m1|vss|vss_x1|vss_x2|vss_x3__t55
+ bn|invb_y|mn34_g1|mp24_g1|y__t33 \$83__t1
+ g_vss_m1|mph_g|s1_vss_m1|s2_vss_m1|s3_vss_m1|s4_vss_m1|vss|vss_x1|vss_x2|vss_x3__t72
+ sky130_fd_pr__nfet_01v8 L=0.15 W=0.84 AS=0.2184 AD=0.3948 PS=1.36 PD=2.62
* device instance $58 r0 *1 43.75,15.585 nfet
X$58 \$85__t0 a|inva_a|mn12_g0|mp13_g0|ro3|y__t5
+ a|b|b3|invb_a|mn12_g1|mp24_g0|t2|y__t7
+ g_vss_m1|mph_g|s1_vss_m1|s2_vss_m1|s3_vss_m1|s4_vss_m1|vss|vss_x1|vss_x2|vss_x3__t63
+ sky130_fd_pr__nfet_01v8 L=0.15 W=0.84 AS=0.3948 AD=0.2184 PS=2.62 PD=1.36
* device instance $59 r0 *1 44.42,15.585 nfet
X$59
+ g_vss_m1|mph_g|s1_vss_m1|s2_vss_m1|s3_vss_m1|s4_vss_m1|vss|vss_x1|vss_x2|vss_x3__t54
+ a|b|invb_a|mn12_g1|mp24_g0|ro4|y__t5 \$85__t1
+ g_vss_m1|mph_g|s1_vss_m1|s2_vss_m1|s3_vss_m1|s4_vss_m1|vss|vss_x1|vss_x2|vss_x3__t73
+ sky130_fd_pr__nfet_01v8 L=0.15 W=0.84 AS=0.2184 AD=0.3948 PS=1.36 PD=2.62
* device instance $60 r0 *1 50.59,17.905 nfet
X$60 bn|invb_y|mn34_g1|mp24_g1|y__t23 a|b|invb_a|mn12_g1|mp24_g0|ro4|y__t4
+ g_vss_m1|mph_g|s1_vss_m1|s2_vss_m1|s3_vss_m1|s4_vss_m1|vss|vss_x1|vss_x2|vss_x3__t42
+ g_vss_m1|mph_g|s1_vss_m1|s2_vss_m1|s3_vss_m1|s4_vss_m1|vss|vss_x1|vss_x2|vss_x3__t114
+ sky130_fd_pr__nfet_01v8 L=0.15 W=0.42 AS=0.1974 AD=0.1974 PS=1.78 PD=1.78
* device instance $61 r0 *1 61.385,17.905 nfet
X$61 an|inva_y|mn34_g0|mp13_g1|y__t23 a|inva_a|mn12_g0|mp13_g0|t1|y__t4
+ g_vss_m1|mph_g|s1_vss_m1|s2_vss_m1|s3_vss_m1|s4_vss_m1|vss|vss_x1|vss_x2|vss_x3__t43
+ g_vss_m1|mph_g|s1_vss_m1|s2_vss_m1|s3_vss_m1|s4_vss_m1|vss|vss_x1|vss_x2|vss_x3__t115
+ sky130_fd_pr__nfet_01v8 L=0.15 W=0.42 AS=0.1974 AD=0.1974 PS=1.78 PD=1.78
* device instance $62 r0 *1 65.72,15.585 nfet
X$62 \$87__t0 an|inva_y|mn34_g0|mp13_g1|y__t33 xo|y__t2
+ g_vss_m1|mph_g|s1_vss_m1|s2_vss_m1|s3_vss_m1|s4_vss_m1|vss|vss_x1|vss_x2|vss_x3__t64
+ sky130_fd_pr__nfet_01v8 L=0.15 W=0.84 AS=0.3948 AD=0.2184 PS=2.62 PD=1.36
* device instance $63 r0 *1 66.39,15.585 nfet
X$63
+ g_vss_m1|mph_g|s1_vss_m1|s2_vss_m1|s3_vss_m1|s4_vss_m1|vss|vss_x1|vss_x2|vss_x3__t52
+ bn|invb_y|mn34_g1|mp24_g1|y__t3 \$87__t1
+ g_vss_m1|mph_g|s1_vss_m1|s2_vss_m1|s3_vss_m1|s4_vss_m1|vss|vss_x1|vss_x2|vss_x3__t74
+ sky130_fd_pr__nfet_01v8 L=0.15 W=0.84 AS=0.2184 AD=0.3948 PS=1.36 PD=2.62
* device instance $64 r0 *1 72.72,15.585 nfet
X$64 \$89__t0 a|inva_a|mn12_g0|mp13_g0|t1|y__t5 xo|y__t3
+ g_vss_m1|mph_g|s1_vss_m1|s2_vss_m1|s3_vss_m1|s4_vss_m1|vss|vss_x1|vss_x2|vss_x3__t65
+ sky130_fd_pr__nfet_01v8 L=0.15 W=0.84 AS=0.3948 AD=0.2184 PS=2.62 PD=1.36
* device instance $65 r0 *1 73.39,15.585 nfet
X$65
+ g_vss_m1|mph_g|s1_vss_m1|s2_vss_m1|s3_vss_m1|s4_vss_m1|vss|vss_x1|vss_x2|vss_x3__t51
+ a|b|b3|invb_a|mn12_g1|mp24_g0|t2|y__t5 \$89__t1
+ g_vss_m1|mph_g|s1_vss_m1|s2_vss_m1|s3_vss_m1|s4_vss_m1|vss|vss_x1|vss_x2|vss_x3__t75
+ sky130_fd_pr__nfet_01v8 L=0.15 W=0.84 AS=0.2184 AD=0.3948 PS=1.36 PD=2.62
* device instance $66 r0 *1 79.56,17.905 nfet
X$66 bn|invb_y|mn34_g1|mp24_g1|y__t2 a|b|b3|invb_a|mn12_g1|mp24_g0|t2|y__t4
+ g_vss_m1|mph_g|s1_vss_m1|s2_vss_m1|s3_vss_m1|s4_vss_m1|vss|vss_x1|vss_x2|vss_x3__t45
+ g_vss_m1|mph_g|s1_vss_m1|s2_vss_m1|s3_vss_m1|s4_vss_m1|vss|vss_x1|vss_x2|vss_x3__t116
+ sky130_fd_pr__nfet_01v8 L=0.15 W=0.42 AS=0.1974 AD=0.1974 PS=1.78 PD=1.78
* device instance $67 r0 *1 48.86,3.53 pfet
X$67 a|inva_a|mn12_g0|mp13_g0|ro1|y__t1 a|g_a|rn1|ro|s4_y|y__t2
+ vdd|vdd_b1|vdd_b2|vdd_b3|vdd_b4|vdd_x1|vdd_x2|vdd_x3__t20
+ vdd|vdd_b1|vdd_b2|vdd_b3|vdd_b4|vdd_x1|vdd_x2|vdd_x3__t30
+ sky130_fd_pr__pfet_01v8 L=0.15 W=0.84 AS=0.3948 AD=0.3948 PS=2.62 PD=2.62
* device instance $68 r0 *1 104.16,3.53 pfet
X$68 a|b|invb_a|mn12_g1|mp24_g0|ro2|y__t1 a|g_a|rn2|ro|s4_y|y__t1
+ vdd|vdd_b1|vdd_b2|vdd_b3|vdd_b4|vdd_x1|vdd_x2|vdd_x3__t27
+ vdd|vdd_b1|vdd_b2|vdd_b3|vdd_b4|vdd_x1|vdd_x2|vdd_x3__t37
+ sky130_fd_pr__pfet_01v8 L=0.15 W=0.84 AS=0.3948 AD=0.3948 PS=2.62 PD=2.62
* device instance $69 r0 *1 159.46,3.53 pfet
X$69 a|inva_a|mn12_g0|mp13_g0|ro3|y__t1 a|g_a|rn3|ro|s4_y|y__t2
+ vdd|vdd_b1|vdd_b2|vdd_b3|vdd_b4|vdd_x1|vdd_x2|vdd_x3__t19
+ vdd|vdd_b1|vdd_b2|vdd_b3|vdd_b4|vdd_x1|vdd_x2|vdd_x3__t29
+ sky130_fd_pr__pfet_01v8 L=0.15 W=0.84 AS=0.3948 AD=0.3948 PS=2.62 PD=2.62
* device instance $70 r0 *1 214.76,3.53 pfet
X$70 a|b|invb_a|mn12_g1|mp24_g0|ro4|y__t1 a|g_a|rn4|ro|s4_y|y__t1
+ vdd|vdd_b1|vdd_b2|vdd_b3|vdd_b4|vdd_x1|vdd_x2|vdd_x3__t18
+ vdd|vdd_b1|vdd_b2|vdd_b3|vdd_b4|vdd_x1|vdd_x2|vdd_x3__t28
+ sky130_fd_pr__pfet_01v8 L=0.15 W=0.84 AS=0.3948 AD=0.3948 PS=2.62 PD=2.62
* device instance $71 r0 *1 15.075,3.74 pfet
X$71 a|n2|s1_y|s2_a|y__t1 a|g_y|mnab_y|mpa_y|mpb_y|n1|s1_a|y__t32 py__t0
+ g_vddr_m1|mnt_g|s1_vddr_m1|s2_vddr_m1|s3_vddr_m1|s4_vddr_m1|vddr|vddr1__t7
+ sky130_fd_pr__pfet_01v8 L=0.15 W=0.84 AS=0.3948 AD=0.3948 PS=2.62 PD=2.62
* device instance $72 r0 *1 23.25,3.74 pfet
X$72 a|n3|s2_y|s3_a|y__t0 a|n2|s1_y|s2_a|y__t2 py__t02
+ g_vddr_m1|mnt_g|s1_vddr_m1|s2_vddr_m1|s3_vddr_m1|s4_vddr_m1|vddr|vddr1__t6
+ sky130_fd_pr__pfet_01v8 L=0.15 W=0.84 AS=0.3948 AD=0.3948 PS=2.62 PD=2.62
* device instance $73 r0 *1 31.425,3.74 pfet
X$73 a|n4|s3_y|s4_a|y__t0 a|n3|s2_y|s3_a|y__t1 py__t03
+ g_vddr_m1|mnt_g|s1_vddr_m1|s2_vddr_m1|s3_vddr_m1|s4_vddr_m1|vddr|vddr1__t5
+ sky130_fd_pr__pfet_01v8 L=0.15 W=0.84 AS=0.3948 AD=0.3948 PS=2.62 PD=2.62
* device instance $74 r0 *1 39.6,3.74 pfet
X$74 a|g_a|rn1|ro|s4_y|y__t1 a|n4|s3_y|s4_a|y__t1 py__t04
+ g_vddr_m1|mnt_g|s1_vddr_m1|s2_vddr_m1|s3_vddr_m1|s4_vddr_m1|vddr|vddr1__t4
+ sky130_fd_pr__pfet_01v8 L=0.15 W=0.84 AS=0.3948 AD=0.3948 PS=2.62 PD=2.62
* device instance $75 r0 *1 70.375,3.74 pfet
X$75 a|n2|s1_y|s2_a|y__t02 a|g_y|mnab_y|mpa_y|mpb_y|n1|s1_a|y__t1 py__t15
+ g_vddr_m1|mnt_g|s1_vddr_m1|s2_vddr_m1|s3_vddr_m1|s4_vddr_m1|vddr|vddr2__t14
+ sky130_fd_pr__pfet_01v8 L=0.15 W=0.84 AS=0.3948 AD=0.3948 PS=2.62 PD=2.62
* device instance $76 r0 *1 78.55,3.74 pfet
X$76 a|n3|s2_y|s3_a|y__t02 a|n2|s1_y|s2_a|y__t12 py__t16
+ g_vddr_m1|mnt_g|s1_vddr_m1|s2_vddr_m1|s3_vddr_m1|s4_vddr_m1|vddr|vddr2__t13
+ sky130_fd_pr__pfet_01v8 L=0.15 W=0.84 AS=0.3948 AD=0.3948 PS=2.62 PD=2.62
* device instance $77 r0 *1 86.725,3.74 pfet
X$77 a|n4|s3_y|s4_a|y__t04 a|n3|s2_y|s3_a|y__t12 py__t17
+ g_vddr_m1|mnt_g|s1_vddr_m1|s2_vddr_m1|s3_vddr_m1|s4_vddr_m1|vddr|vddr2__t12
+ sky130_fd_pr__pfet_01v8 L=0.15 W=0.84 AS=0.3948 AD=0.3948 PS=2.62 PD=2.62
* device instance $78 r0 *1 94.9,3.74 pfet
X$78 a|g_a|rn2|ro|s4_y|y__t0 a|n4|s3_y|s4_a|y__t14 py__t18
+ g_vddr_m1|mnt_g|s1_vddr_m1|s2_vddr_m1|s3_vddr_m1|s4_vddr_m1|vddr|vddr2__t11
+ sky130_fd_pr__pfet_01v8 L=0.15 W=0.84 AS=0.3948 AD=0.3948 PS=2.62 PD=2.62
* device instance $79 r0 *1 125.675,3.74 pfet
X$79 a|n2|s1_y|s2_a|y__t03 a|g_y|mnab_y|mpa_y|mpb_y|n1|s1_a|y__t13 py__t19
+ g_vddr_m1|mnt_g|s1_vddr_m1|s2_vddr_m1|s3_vddr_m1|s4_vddr_m1|vddr|vddr3__t14
+ sky130_fd_pr__pfet_01v8 L=0.15 W=0.84 AS=0.3948 AD=0.3948 PS=2.62 PD=2.62
* device instance $80 r0 *1 133.85,3.74 pfet
X$80 a|n3|s2_y|s3_a|y__t03 a|n2|s1_y|s2_a|y__t13 py__t110
+ g_vddr_m1|mnt_g|s1_vddr_m1|s2_vddr_m1|s3_vddr_m1|s4_vddr_m1|vddr|vddr3__t15
+ sky130_fd_pr__pfet_01v8 L=0.15 W=0.84 AS=0.3948 AD=0.3948 PS=2.62 PD=2.62
* device instance $81 r0 *1 142.025,3.74 pfet
X$81 a|n4|s3_y|s4_a|y__t02 a|n3|s2_y|s3_a|y__t13 py__t111
+ g_vddr_m1|mnt_g|s1_vddr_m1|s2_vddr_m1|s3_vddr_m1|s4_vddr_m1|vddr|vddr3__t11
+ sky130_fd_pr__pfet_01v8 L=0.15 W=0.84 AS=0.3948 AD=0.3948 PS=2.62 PD=2.62
* device instance $82 r0 *1 150.2,3.74 pfet
X$82 a|g_a|rn3|ro|s4_y|y__t0 a|n4|s3_y|s4_a|y__t12 py__t112
+ g_vddr_m1|mnt_g|s1_vddr_m1|s2_vddr_m1|s3_vddr_m1|s4_vddr_m1|vddr|vddr3__t12
+ sky130_fd_pr__pfet_01v8 L=0.15 W=0.84 AS=0.3948 AD=0.3948 PS=2.62 PD=2.62
* device instance $83 r0 *1 180.975,3.74 pfet
X$83 a|n2|s1_y|s2_a|y__t04 a|g_y|mnab_y|mpa_y|mpb_y|n1|s1_a|y__t14 py__t113
+ g_vddr_m1|mnt_g|s1_vddr_m1|s2_vddr_m1|s3_vddr_m1|s4_vddr_m1|vddr|vddr4__t11
+ sky130_fd_pr__pfet_01v8 L=0.15 W=0.84 AS=0.3948 AD=0.3948 PS=2.62 PD=2.62
* device instance $84 r0 *1 189.15,3.74 pfet
X$84 a|n3|s2_y|s3_a|y__t04 a|n2|s1_y|s2_a|y__t14 py__t114
+ g_vddr_m1|mnt_g|s1_vddr_m1|s2_vddr_m1|s3_vddr_m1|s4_vddr_m1|vddr|vddr4__t15
+ sky130_fd_pr__pfet_01v8 L=0.15 W=0.84 AS=0.3948 AD=0.3948 PS=2.62 PD=2.62
* device instance $85 r0 *1 197.325,3.74 pfet
X$85 a|n4|s3_y|s4_a|y__t03 a|n3|s2_y|s3_a|y__t14 py__t115
+ g_vddr_m1|mnt_g|s1_vddr_m1|s2_vddr_m1|s3_vddr_m1|s4_vddr_m1|vddr|vddr4__t14
+ sky130_fd_pr__pfet_01v8 L=0.15 W=0.84 AS=0.3948 AD=0.3948 PS=2.62 PD=2.62
* device instance $86 r0 *1 205.5,3.74 pfet
X$86 a|g_a|rn4|ro|s4_y|y__t0 a|n4|s3_y|s4_a|y__t13 py__t116
+ g_vddr_m1|mnt_g|s1_vddr_m1|s2_vddr_m1|s3_vddr_m1|s4_vddr_m1|vddr|vddr4__t13
+ sky130_fd_pr__pfet_01v8 L=0.15 W=0.84 AS=0.3948 AD=0.3948 PS=2.62 PD=2.62
* device instance $87 r0 *1 5.775,4.19 pfet
X$87 a|g_y|mnab_y|mpa_y|mpb_y|n1|s1_a|y__t22 en|en1|g_en__t1
+ mpa_py|mpb_py|mph_py|py__t1
+ g_vddr_m1|mnt_g|s1_vddr_m1|s2_vddr_m1|s3_vddr_m1|s4_vddr_m1|vddr|vddr1__t3
+ sky130_fd_pr__pfet_01v8 L=0.15 W=0.84 AS=0.3948 AD=0.3948 PS=2.62 PD=2.62
* device instance $88 r0 *1 7.065,4.19 pfet
X$88 mpa_py|mpb_py|mph_py|py__t2 a|g_a|rn1|ro|s4_y|y__t3
+ a|g_y|mnab_y|mpa_y|mpb_y|n1|s1_a|y__t42
+ g_vddr_m1|mnt_g|s1_vddr_m1|s2_vddr_m1|s3_vddr_m1|s4_vddr_m1|vddr|vddr1__t8
+ sky130_fd_pr__pfet_01v8 L=0.15 W=0.84 AS=0.3948 AD=0.3948 PS=2.62 PD=2.62
* device instance $89 r0 *1 12.91,3.74 pfet
X$89 py__t1
+ g_vss_m1|mph_g|s1_vss_m1|s2_vss_m1|s3_vss_m1|s4_vss_m1|vss|vss_x1|vss_x2|vss_x3__t22
+ g_vddr_m1|mnt_g|s1_vddr_m1|s2_vddr_m1|s3_vddr_m1|s4_vddr_m1|vddr|vddr1__t15
+ g_vddr_m1|mnt_g|s1_vddr_m1|s2_vddr_m1|s3_vddr_m1|s4_vddr_m1|vddr|vddr1__t11
+ sky130_fd_pr__pfet_01v8 L=2 W=0.42 AS=0.1764 AD=0.1764 PS=1.68 PD=1.68
* device instance $90 r0 *1 21.085,3.74 pfet
X$90 py__t12
+ g_vss_m1|mph_g|s1_vss_m1|s2_vss_m1|s3_vss_m1|s4_vss_m1|vss|vss_x1|vss_x2|vss_x3__t23
+ g_vddr_m1|mnt_g|s1_vddr_m1|s2_vddr_m1|s3_vddr_m1|s4_vddr_m1|vddr|vddr1__t16
+ g_vddr_m1|mnt_g|s1_vddr_m1|s2_vddr_m1|s3_vddr_m1|s4_vddr_m1|vddr|vddr1__t12
+ sky130_fd_pr__pfet_01v8 L=2 W=0.42 AS=0.1764 AD=0.1764 PS=1.68 PD=1.68
* device instance $91 r0 *1 29.26,3.74 pfet
X$91 py__t13
+ g_vss_m1|mph_g|s1_vss_m1|s2_vss_m1|s3_vss_m1|s4_vss_m1|vss|vss_x1|vss_x2|vss_x3__t21
+ g_vddr_m1|mnt_g|s1_vddr_m1|s2_vddr_m1|s3_vddr_m1|s4_vddr_m1|vddr|vddr1__t14
+ g_vddr_m1|mnt_g|s1_vddr_m1|s2_vddr_m1|s3_vddr_m1|s4_vddr_m1|vddr|vddr1__t10
+ sky130_fd_pr__pfet_01v8 L=2 W=0.42 AS=0.1764 AD=0.1764 PS=1.68 PD=1.68
* device instance $92 r0 *1 37.435,3.74 pfet
X$92 py__t14
+ g_vss_m1|mph_g|s1_vss_m1|s2_vss_m1|s3_vss_m1|s4_vss_m1|vss|vss_x1|vss_x2|vss_x3__t20
+ g_vddr_m1|mnt_g|s1_vddr_m1|s2_vddr_m1|s3_vddr_m1|s4_vddr_m1|vddr|vddr1__t13
+ g_vddr_m1|mnt_g|s1_vddr_m1|s2_vddr_m1|s3_vddr_m1|s4_vddr_m1|vddr|vddr1__t9
+ sky130_fd_pr__pfet_01v8 L=2 W=0.42 AS=0.1764 AD=0.1764 PS=1.68 PD=1.68
* device instance $93 r0 *1 61.075,4.19 pfet
X$93 a|g_y|mnab_y|mpa_y|mpb_y|n1|s1_a|y__t0 en|en2|g_en__t0
+ mpa_py|mpb_py|mph_py|py__t22
+ g_vddr_m1|mnt_g|s1_vddr_m1|s2_vddr_m1|s3_vddr_m1|s4_vddr_m1|vddr|vddr2__t16
+ sky130_fd_pr__pfet_01v8 L=0.15 W=0.84 AS=0.3948 AD=0.3948 PS=2.62 PD=2.62
* device instance $94 r0 *1 62.365,4.19 pfet
X$94 mpa_py|mpb_py|mph_py|py__t12 a|g_a|rn2|ro|s4_y|y__t2
+ a|g_y|mnab_y|mpa_y|mpb_y|n1|s1_a|y__t2
+ g_vddr_m1|mnt_g|s1_vddr_m1|s2_vddr_m1|s3_vddr_m1|s4_vddr_m1|vddr|vddr2__t15
+ sky130_fd_pr__pfet_01v8 L=0.15 W=0.84 AS=0.3948 AD=0.3948 PS=2.62 PD=2.62
* device instance $95 r0 *1 68.21,3.74 pfet
X$95 py__t05
+ g_vss_m1|mph_g|s1_vss_m1|s2_vss_m1|s3_vss_m1|s4_vss_m1|vss|vss_x1|vss_x2|vss_x3__t19
+ g_vddr_m1|mnt_g|s1_vddr_m1|s2_vddr_m1|s3_vddr_m1|s4_vddr_m1|vddr|vddr2__t10
+ g_vddr_m1|mnt_g|s1_vddr_m1|s2_vddr_m1|s3_vddr_m1|s4_vddr_m1|vddr|vddr2__t6
+ sky130_fd_pr__pfet_01v8 L=2 W=0.44 AS=0.1848 AD=0.1848 PS=1.72 PD=1.72
* device instance $96 r0 *1 76.385,3.74 pfet
X$96 py__t06
+ g_vss_m1|mph_g|s1_vss_m1|s2_vss_m1|s3_vss_m1|s4_vss_m1|vss|vss_x1|vss_x2|vss_x3__t16
+ g_vddr_m1|mnt_g|s1_vddr_m1|s2_vddr_m1|s3_vddr_m1|s4_vddr_m1|vddr|vddr2__t7
+ g_vddr_m1|mnt_g|s1_vddr_m1|s2_vddr_m1|s3_vddr_m1|s4_vddr_m1|vddr|vddr2__t3
+ sky130_fd_pr__pfet_01v8 L=2 W=0.44 AS=0.1848 AD=0.1848 PS=1.72 PD=1.72
* device instance $97 r0 *1 84.56,3.74 pfet
X$97 py__t07
+ g_vss_m1|mph_g|s1_vss_m1|s2_vss_m1|s3_vss_m1|s4_vss_m1|vss|vss_x1|vss_x2|vss_x3__t17
+ g_vddr_m1|mnt_g|s1_vddr_m1|s2_vddr_m1|s3_vddr_m1|s4_vddr_m1|vddr|vddr2__t8
+ g_vddr_m1|mnt_g|s1_vddr_m1|s2_vddr_m1|s3_vddr_m1|s4_vddr_m1|vddr|vddr2__t4
+ sky130_fd_pr__pfet_01v8 L=2 W=0.44 AS=0.1848 AD=0.1848 PS=1.72 PD=1.72
* device instance $98 r0 *1 92.735,3.74 pfet
X$98 py__t08
+ g_vss_m1|mph_g|s1_vss_m1|s2_vss_m1|s3_vss_m1|s4_vss_m1|vss|vss_x1|vss_x2|vss_x3__t18
+ g_vddr_m1|mnt_g|s1_vddr_m1|s2_vddr_m1|s3_vddr_m1|s4_vddr_m1|vddr|vddr2__t9
+ g_vddr_m1|mnt_g|s1_vddr_m1|s2_vddr_m1|s3_vddr_m1|s4_vddr_m1|vddr|vddr2__t5
+ sky130_fd_pr__pfet_01v8 L=2 W=0.44 AS=0.1848 AD=0.1848 PS=1.72 PD=1.72
* device instance $99 r0 *1 116.375,4.19 pfet
X$99 a|g_y|mnab_y|mpa_y|mpb_y|n1|s1_a|y__t03 en|en3|g_en__t0
+ mpa_py|mpb_py|mph_py|py__t23
+ g_vddr_m1|mnt_g|s1_vddr_m1|s2_vddr_m1|s3_vddr_m1|s4_vddr_m1|vddr|vddr3__t16
+ sky130_fd_pr__pfet_01v8 L=0.15 W=0.84 AS=0.3948 AD=0.3948 PS=2.62 PD=2.62
* device instance $100 r0 *1 117.665,4.19 pfet
X$100 mpa_py|mpb_py|mph_py|py__t13 a|g_a|rn3|ro|s4_y|y__t1
+ a|g_y|mnab_y|mpa_y|mpb_y|n1|s1_a|y__t23
+ g_vddr_m1|mnt_g|s1_vddr_m1|s2_vddr_m1|s3_vddr_m1|s4_vddr_m1|vddr|vddr3__t13
+ sky130_fd_pr__pfet_01v8 L=0.15 W=0.84 AS=0.3948 AD=0.3948 PS=2.62 PD=2.62
* device instance $101 r0 *1 123.51,3.74 pfet
X$101 py__t09
+ g_vss_m1|mph_g|s1_vss_m1|s2_vss_m1|s3_vss_m1|s4_vss_m1|vss|vss_x1|vss_x2|vss_x3__t14
+ g_vddr_m1|mnt_g|s1_vddr_m1|s2_vddr_m1|s3_vddr_m1|s4_vddr_m1|vddr|vddr3__t9
+ g_vddr_m1|mnt_g|s1_vddr_m1|s2_vddr_m1|s3_vddr_m1|s4_vddr_m1|vddr|vddr3__t5
+ sky130_fd_pr__pfet_01v8 L=2 W=0.46 AS=0.1932 AD=0.1932 PS=1.76 PD=1.76
* device instance $102 r0 *1 131.685,3.74 pfet
X$102 py__t010
+ g_vss_m1|mph_g|s1_vss_m1|s2_vss_m1|s3_vss_m1|s4_vss_m1|vss|vss_x1|vss_x2|vss_x3__t15
+ g_vddr_m1|mnt_g|s1_vddr_m1|s2_vddr_m1|s3_vddr_m1|s4_vddr_m1|vddr|vddr3__t10
+ g_vddr_m1|mnt_g|s1_vddr_m1|s2_vddr_m1|s3_vddr_m1|s4_vddr_m1|vddr|vddr3__t6
+ sky130_fd_pr__pfet_01v8 L=2 W=0.46 AS=0.1932 AD=0.1932 PS=1.76 PD=1.76
* device instance $103 r0 *1 139.86,3.74 pfet
X$103 py__t011
+ g_vss_m1|mph_g|s1_vss_m1|s2_vss_m1|s3_vss_m1|s4_vss_m1|vss|vss_x1|vss_x2|vss_x3__t13
+ g_vddr_m1|mnt_g|s1_vddr_m1|s2_vddr_m1|s3_vddr_m1|s4_vddr_m1|vddr|vddr3__t8
+ g_vddr_m1|mnt_g|s1_vddr_m1|s2_vddr_m1|s3_vddr_m1|s4_vddr_m1|vddr|vddr3__t4
+ sky130_fd_pr__pfet_01v8 L=2 W=0.46 AS=0.1932 AD=0.1932 PS=1.76 PD=1.76
* device instance $104 r0 *1 148.035,3.74 pfet
X$104 py__t012
+ g_vss_m1|mph_g|s1_vss_m1|s2_vss_m1|s3_vss_m1|s4_vss_m1|vss|vss_x1|vss_x2|vss_x3__t12
+ g_vddr_m1|mnt_g|s1_vddr_m1|s2_vddr_m1|s3_vddr_m1|s4_vddr_m1|vddr|vddr3__t7
+ g_vddr_m1|mnt_g|s1_vddr_m1|s2_vddr_m1|s3_vddr_m1|s4_vddr_m1|vddr|vddr3__t3
+ sky130_fd_pr__pfet_01v8 L=2 W=0.46 AS=0.1932 AD=0.1932 PS=1.76 PD=1.76
* device instance $105 r0 *1 171.675,4.19 pfet
X$105 a|g_y|mnab_y|mpa_y|mpb_y|n1|s1_a|y__t04 en|en4|g_en__t0
+ mpa_py|mpb_py|mph_py|py__t24
+ g_vddr_m1|mnt_g|s1_vddr_m1|s2_vddr_m1|s3_vddr_m1|s4_vddr_m1|vddr|vddr4__t12
+ sky130_fd_pr__pfet_01v8 L=0.15 W=0.84 AS=0.3948 AD=0.3948 PS=2.62 PD=2.62
* device instance $106 r0 *1 172.965,4.19 pfet
X$106 mpa_py|mpb_py|mph_py|py__t14 a|g_a|rn4|ro|s4_y|y__t2
+ a|g_y|mnab_y|mpa_y|mpb_y|n1|s1_a|y__t24
+ g_vddr_m1|mnt_g|s1_vddr_m1|s2_vddr_m1|s3_vddr_m1|s4_vddr_m1|vddr|vddr4__t16
+ sky130_fd_pr__pfet_01v8 L=0.15 W=0.84 AS=0.3948 AD=0.3948 PS=2.62 PD=2.62
* device instance $107 r0 *1 178.81,3.74 pfet
X$107 py__t013
+ g_vss_m1|mph_g|s1_vss_m1|s2_vss_m1|s3_vss_m1|s4_vss_m1|vss|vss_x1|vss_x2|vss_x3__t11
+ g_vddr_m1|mnt_g|s1_vddr_m1|s2_vddr_m1|s3_vddr_m1|s4_vddr_m1|vddr|vddr4__t10
+ g_vddr_m1|mnt_g|s1_vddr_m1|s2_vddr_m1|s3_vddr_m1|s4_vddr_m1|vddr|vddr4__t6
+ sky130_fd_pr__pfet_01v8 L=2 W=0.48 AS=0.2016 AD=0.2016 PS=1.8 PD=1.8
* device instance $108 r0 *1 186.985,3.74 pfet
X$108 py__t014
+ g_vss_m1|mph_g|s1_vss_m1|s2_vss_m1|s3_vss_m1|s4_vss_m1|vss|vss_x1|vss_x2|vss_x3__t8
+ g_vddr_m1|mnt_g|s1_vddr_m1|s2_vddr_m1|s3_vddr_m1|s4_vddr_m1|vddr|vddr4__t7
+ g_vddr_m1|mnt_g|s1_vddr_m1|s2_vddr_m1|s3_vddr_m1|s4_vddr_m1|vddr|vddr4__t3
+ sky130_fd_pr__pfet_01v8 L=2 W=0.48 AS=0.2016 AD=0.2016 PS=1.8 PD=1.8
* device instance $109 r0 *1 195.16,3.74 pfet
X$109 py__t015
+ g_vss_m1|mph_g|s1_vss_m1|s2_vss_m1|s3_vss_m1|s4_vss_m1|vss|vss_x1|vss_x2|vss_x3__t9
+ g_vddr_m1|mnt_g|s1_vddr_m1|s2_vddr_m1|s3_vddr_m1|s4_vddr_m1|vddr|vddr4__t8
+ g_vddr_m1|mnt_g|s1_vddr_m1|s2_vddr_m1|s3_vddr_m1|s4_vddr_m1|vddr|vddr4__t4
+ sky130_fd_pr__pfet_01v8 L=2 W=0.48 AS=0.2016 AD=0.2016 PS=1.8 PD=1.8
* device instance $110 r0 *1 203.335,3.74 pfet
X$110 py__t016
+ g_vss_m1|mph_g|s1_vss_m1|s2_vss_m1|s3_vss_m1|s4_vss_m1|vss|vss_x1|vss_x2|vss_x3__t10
+ g_vddr_m1|mnt_g|s1_vddr_m1|s2_vddr_m1|s3_vddr_m1|s4_vddr_m1|vddr|vddr4__t9
+ g_vddr_m1|mnt_g|s1_vddr_m1|s2_vddr_m1|s3_vddr_m1|s4_vddr_m1|vddr|vddr4__t5
+ sky130_fd_pr__pfet_01v8 L=2 W=0.48 AS=0.2016 AD=0.2016 PS=1.8 PD=1.8
* device instance $111 r0 *1 3.61,4.19 pfet
X$111 mpa_py|mpb_py|mph_py|py__t0
+ g_vss_m1|mph_g|s1_vss_m1|s2_vss_m1|s3_vss_m1|s4_vss_m1|vss|vss_x1|vss_x2|vss_x3__t4
+ g_vddr_m1|mnt_g|s1_vddr_m1|s2_vddr_m1|s3_vddr_m1|s4_vddr_m1|vddr|vddr1__t1
+ g_vddr_m1|mnt_g|s1_vddr_m1|s2_vddr_m1|s3_vddr_m1|s4_vddr_m1|vddr|vddr1__t2
+ sky130_fd_pr__pfet_01v8 L=2 W=0.42 AS=0.1764 AD=0.1764 PS=1.68 PD=1.68
* device instance $112 r0 *1 3.445,21.225 pfet
X$112 an|inva_y|mn34_g0|mp13_g1|y__t1 a|inva_a|mn12_g0|mp13_g0|ro1|y__t2
+ vdd|vdd_b1|vdd_b2|vdd_b3|vdd_b4|vdd_x1|vdd_x2|vdd_x3__t26
+ vdd|vdd_b1|vdd_b2|vdd_b3|vdd_b4|vdd_x1|vdd_x2|vdd_x3__t36
+ sky130_fd_pr__pfet_01v8 L=0.15 W=0.84 AS=0.3948 AD=0.3948 PS=2.62 PD=2.62
* device instance $113 r0 *1 7.43,25.585 pfet
X$113 mid__t1 a|inva_a|mn12_g0|mp13_g0|ro1|y__t0
+ vdd|vdd_b1|vdd_b2|vdd_b3|vdd_b4|vdd_x1|vdd_x2|vdd_x3__t0
+ vdd|vdd_b1|vdd_b2|vdd_b3|vdd_b4|vdd_x1|vdd_x2|vdd_x3__t1
+ sky130_fd_pr__pfet_01v8 L=0.15 W=1.68 AS=0.7896 AD=0.4368 PS=4.3 PD=2.2
* device instance $114 r0 *1 8.1,25.585 pfet
X$114 a|inva_a|mn12_g0|mp13_g0|t1|y__t0 an|inva_y|mn34_g0|mp13_g1|y__t0 mid__t0
+ vdd|vdd_b1|vdd_b2|vdd_b3|vdd_b4|vdd_x1|vdd_x2|vdd_x3__t2
+ sky130_fd_pr__pfet_01v8 L=0.15 W=1.68 AS=0.4368 AD=0.7896 PS=2.2 PD=4.3
* device instance $115 r0 *1 14.58,25.585 pfet
X$115 mid__t2 bn|invb_y|mn34_g1|mp24_g1|y__t02
+ a|inva_a|mn12_g0|mp13_g0|t1|y__t1
+ vdd|vdd_b1|vdd_b2|vdd_b3|vdd_b4|vdd_x1|vdd_x2|vdd_x3__t11
+ sky130_fd_pr__pfet_01v8 L=0.15 W=1.68 AS=0.7896 AD=0.4368 PS=4.3 PD=2.2
* device instance $116 r0 *1 15.25,25.585 pfet
X$116 vdd|vdd_b1|vdd_b2|vdd_b3|vdd_b4|vdd_x1|vdd_x2|vdd_x3__t3
+ a|b|invb_a|mn12_g1|mp24_g0|ro2|y__t0 mid__t3
+ vdd|vdd_b1|vdd_b2|vdd_b3|vdd_b4|vdd_x1|vdd_x2|vdd_x3__t6
+ sky130_fd_pr__pfet_01v8 L=0.15 W=1.68 AS=0.4368 AD=0.7896 PS=2.2 PD=4.3
* device instance $117 r0 *1 21.62,21.225 pfet
X$117 bn|invb_y|mn34_g1|mp24_g1|y__t12 a|b|invb_a|mn12_g1|mp24_g0|ro2|y__t2
+ vdd|vdd_b1|vdd_b2|vdd_b3|vdd_b4|vdd_x1|vdd_x2|vdd_x3__t25
+ vdd|vdd_b1|vdd_b2|vdd_b3|vdd_b4|vdd_x1|vdd_x2|vdd_x3__t35
+ sky130_fd_pr__pfet_01v8 L=0.15 W=0.84 AS=0.3948 AD=0.3948 PS=2.62 PD=2.62
* device instance $118 r0 *1 32.415,21.225 pfet
X$118 an|inva_y|mn34_g0|mp13_g1|y__t12 a|inva_a|mn12_g0|mp13_g0|ro3|y__t2
+ vdd|vdd_b1|vdd_b2|vdd_b3|vdd_b4|vdd_x1|vdd_x2|vdd_x3__t24
+ vdd|vdd_b1|vdd_b2|vdd_b3|vdd_b4|vdd_x1|vdd_x2|vdd_x3__t34
+ sky130_fd_pr__pfet_01v8 L=0.15 W=0.84 AS=0.3948 AD=0.3948 PS=2.62 PD=2.62
* device instance $119 r0 *1 36.4,25.585 pfet
X$119 mid__t02 a|inva_a|mn12_g0|mp13_g0|ro3|y__t0
+ vdd|vdd_b1|vdd_b2|vdd_b3|vdd_b4|vdd_x1|vdd_x2|vdd_x3__t17
+ vdd|vdd_b1|vdd_b2|vdd_b3|vdd_b4|vdd_x1|vdd_x2|vdd_x3__t14
+ sky130_fd_pr__pfet_01v8 L=0.15 W=1.68 AS=0.7896 AD=0.4368 PS=4.3 PD=2.2
* device instance $120 r0 *1 37.07,25.585 pfet
X$120 a|b|b3|invb_a|mn12_g1|mp24_g0|t2|y__t0 an|inva_y|mn34_g0|mp13_g1|y__t02
+ mid__t22 vdd|vdd_b1|vdd_b2|vdd_b3|vdd_b4|vdd_x1|vdd_x2|vdd_x3__t9
+ sky130_fd_pr__pfet_01v8 L=0.15 W=1.68 AS=0.4368 AD=0.7896 PS=2.2 PD=4.3
* device instance $121 r0 *1 43.55,25.585 pfet
X$121 mid__t12 bn|invb_y|mn34_g1|mp24_g1|y__t03
+ a|b|b3|invb_a|mn12_g1|mp24_g0|t2|y__t2
+ vdd|vdd_b1|vdd_b2|vdd_b3|vdd_b4|vdd_x1|vdd_x2|vdd_x3__t15
+ sky130_fd_pr__pfet_01v8 L=0.15 W=1.68 AS=0.7896 AD=0.4368 PS=4.3 PD=2.2
* device instance $122 r0 *1 44.22,25.585 pfet
X$122 vdd|vdd_b1|vdd_b2|vdd_b3|vdd_b4|vdd_x1|vdd_x2|vdd_x3__t5
+ a|b|invb_a|mn12_g1|mp24_g0|ro4|y__t0 mid__t32
+ vdd|vdd_b1|vdd_b2|vdd_b3|vdd_b4|vdd_x1|vdd_x2|vdd_x3__t10
+ sky130_fd_pr__pfet_01v8 L=0.15 W=1.68 AS=0.4368 AD=0.7896 PS=2.2 PD=4.3
* device instance $123 r0 *1 50.59,21.225 pfet
X$123 bn|invb_y|mn34_g1|mp24_g1|y__t13 a|b|invb_a|mn12_g1|mp24_g0|ro4|y__t2
+ vdd|vdd_b1|vdd_b2|vdd_b3|vdd_b4|vdd_x1|vdd_x2|vdd_x3__t23
+ vdd|vdd_b1|vdd_b2|vdd_b3|vdd_b4|vdd_x1|vdd_x2|vdd_x3__t33
+ sky130_fd_pr__pfet_01v8 L=0.15 W=0.84 AS=0.3948 AD=0.3948 PS=2.62 PD=2.62
* device instance $124 r0 *1 58.91,4.19 pfet
X$124 mpa_py|mpb_py|mph_py|py__t02
+ g_vss_m1|mph_g|s1_vss_m1|s2_vss_m1|s3_vss_m1|s4_vss_m1|vss|vss_x1|vss_x2|vss_x3__t5
+ g_vddr_m1|mnt_g|s1_vddr_m1|s2_vddr_m1|s3_vddr_m1|s4_vddr_m1|vddr|vddr2__t1
+ g_vddr_m1|mnt_g|s1_vddr_m1|s2_vddr_m1|s3_vddr_m1|s4_vddr_m1|vddr|vddr2__t2
+ sky130_fd_pr__pfet_01v8 L=2 W=0.44 AS=0.1848 AD=0.1848 PS=1.72 PD=1.72
* device instance $125 r0 *1 61.385,21.225 pfet
X$125 an|inva_y|mn34_g0|mp13_g1|y__t13 a|inva_a|mn12_g0|mp13_g0|t1|y__t3
+ vdd|vdd_b1|vdd_b2|vdd_b3|vdd_b4|vdd_x1|vdd_x2|vdd_x3__t22
+ vdd|vdd_b1|vdd_b2|vdd_b3|vdd_b4|vdd_x1|vdd_x2|vdd_x3__t32
+ sky130_fd_pr__pfet_01v8 L=0.15 W=0.84 AS=0.3948 AD=0.3948 PS=2.62 PD=2.62
* device instance $126 r0 *1 65.37,25.585 pfet
X$126 mid__t13 a|inva_a|mn12_g0|mp13_g0|t1|y__t2
+ vdd|vdd_b1|vdd_b2|vdd_b3|vdd_b4|vdd_x1|vdd_x2|vdd_x3__t16
+ vdd|vdd_b1|vdd_b2|vdd_b3|vdd_b4|vdd_x1|vdd_x2|vdd_x3__t13
+ sky130_fd_pr__pfet_01v8 L=0.15 W=1.68 AS=0.7896 AD=0.4368 PS=4.3 PD=2.2
* device instance $127 r0 *1 66.04,25.585 pfet
X$127 xo|y__t0 an|inva_y|mn34_g0|mp13_g1|y__t03 mid__t33
+ vdd|vdd_b1|vdd_b2|vdd_b3|vdd_b4|vdd_x1|vdd_x2|vdd_x3__t8
+ sky130_fd_pr__pfet_01v8 L=0.15 W=1.68 AS=0.4368 AD=0.7896 PS=2.2 PD=4.3
* device instance $128 r0 *1 72.52,25.585 pfet
X$128 mid__t03 bn|invb_y|mn34_g1|mp24_g1|y__t0 xo|y__t1
+ vdd|vdd_b1|vdd_b2|vdd_b3|vdd_b4|vdd_x1|vdd_x2|vdd_x3__t12
+ sky130_fd_pr__pfet_01v8 L=0.15 W=1.68 AS=0.7896 AD=0.4368 PS=4.3 PD=2.2
* device instance $129 r0 *1 73.19,25.585 pfet
X$129 vdd|vdd_b1|vdd_b2|vdd_b3|vdd_b4|vdd_x1|vdd_x2|vdd_x3__t4
+ a|b|b3|invb_a|mn12_g1|mp24_g0|t2|y__t1 mid__t23
+ vdd|vdd_b1|vdd_b2|vdd_b3|vdd_b4|vdd_x1|vdd_x2|vdd_x3__t7
+ sky130_fd_pr__pfet_01v8 L=0.15 W=1.68 AS=0.4368 AD=0.7896 PS=2.2 PD=4.3
* device instance $130 r0 *1 79.56,21.225 pfet
X$130 bn|invb_y|mn34_g1|mp24_g1|y__t1 a|b|b3|invb_a|mn12_g1|mp24_g0|t2|y__t3
+ vdd|vdd_b1|vdd_b2|vdd_b3|vdd_b4|vdd_x1|vdd_x2|vdd_x3__t21
+ vdd|vdd_b1|vdd_b2|vdd_b3|vdd_b4|vdd_x1|vdd_x2|vdd_x3__t31
+ sky130_fd_pr__pfet_01v8 L=0.15 W=0.84 AS=0.3948 AD=0.3948 PS=2.62 PD=2.62
* device instance $131 r0 *1 114.21,4.19 pfet
X$131 mpa_py|mpb_py|mph_py|py__t03
+ g_vss_m1|mph_g|s1_vss_m1|s2_vss_m1|s3_vss_m1|s4_vss_m1|vss|vss_x1|vss_x2|vss_x3__t6
+ g_vddr_m1|mnt_g|s1_vddr_m1|s2_vddr_m1|s3_vddr_m1|s4_vddr_m1|vddr|vddr3__t1
+ g_vddr_m1|mnt_g|s1_vddr_m1|s2_vddr_m1|s3_vddr_m1|s4_vddr_m1|vddr|vddr3__t2
+ sky130_fd_pr__pfet_01v8 L=2 W=0.46 AS=0.1932 AD=0.1932 PS=1.76 PD=1.76
* device instance $132 r0 *1 169.51,4.19 pfet
X$132 mpa_py|mpb_py|mph_py|py__t04
+ g_vss_m1|mph_g|s1_vss_m1|s2_vss_m1|s3_vss_m1|s4_vss_m1|vss|vss_x1|vss_x2|vss_x3__t7
+ g_vddr_m1|mnt_g|s1_vddr_m1|s2_vddr_m1|s3_vddr_m1|s4_vddr_m1|vddr|vddr4__t1
+ g_vddr_m1|mnt_g|s1_vddr_m1|s2_vddr_m1|s3_vddr_m1|s4_vddr_m1|vddr|vddr4__t2
+ sky130_fd_pr__pfet_01v8 L=2 W=0.48 AS=0.2016 AD=0.2016 PS=1.8 PD=1.8
* device instance _11_t0 r0 *1 0,0
R_11_t0 \$11__t0 \$11 12.8
* device instance _11_t1 r0 *1 0,0
R_11_t1 \$11__t1 \$11 12.8
* device instance _11 r0 *1 0,0
C_11 \$11 vsubs 1.15618e-16
* device instance _20_t0 r0 *1 0,0
R_20_t0 \$20__t0 \$20 12.8
* device instance _20_t1 r0 *1 0,0
R_20_t1 \$20__t1 \$20 12.8
* device instance _20 r0 *1 0,0
C_20 \$20 vsubs 1.15618e-16
* device instance _29_t0 r0 *1 0,0
R_29_t0 \$29__t0 \$29 12.8
* device instance _29_t1 r0 *1 0,0
R_29_t1 \$29__t1 \$29 12.8
* device instance _29 r0 *1 0,0
C_29 \$29 vsubs 1.15618e-16
* device instance _38_t0 r0 *1 0,0
R_38_t0 \$38__t0 \$38 12.8
* device instance _38_t1 r0 *1 0,0
R_38_t1 \$38__t1 \$38 12.8
* device instance _38 r0 *1 0,0
C_38 \$38 vsubs 1.15618e-16
* device instance _80_t0 r0 *1 0,0
R_80_t0 \$80__t0 \$80 12.8
* device instance _80_t1 r0 *1 0,0
R_80_t1 \$80__t1 \$80 12.8
* device instance _80 r0 *1 0,0
C_80 \$80 vsubs 1.15618e-16
* device instance _82_t0 r0 *1 0,0
R_82_t0 \$82__t0 \$82 12.8
* device instance _82_t1 r0 *1 0,0
R_82_t1 \$82__t1 \$82 12.8
* device instance _82 r0 *1 0,0
C_82 \$82 vsubs 1.15618e-16
* device instance _83_t0 r0 *1 0,0
R_83_t0 \$83__t0 \$83 12.8
* device instance _83_t1 r0 *1 0,0
R_83_t1 \$83__t1 \$83 12.8
* device instance _83 r0 *1 0,0
C_83 \$83 vsubs 1.15618e-16
* device instance _85_t0 r0 *1 0,0
R_85_t0 \$85__t0 \$85 12.8
* device instance _85_t1 r0 *1 0,0
R_85_t1 \$85__t1 \$85 12.8
* device instance _85 r0 *1 0,0
C_85 \$85 vsubs 1.15618e-16
* device instance _87_t0 r0 *1 0,0
R_87_t0 \$87__t0 \$87 12.8
* device instance _87_t1 r0 *1 0,0
R_87_t1 \$87__t1 \$87 12.8
* device instance _87 r0 *1 0,0
C_87 \$87 vsubs 1.15618e-16
* device instance _89_t0 r0 *1 0,0
R_89_t0 \$89__t0 \$89 12.8
* device instance _89_t1 r0 *1 0,0
R_89_t1 \$89__t1 \$89 12.8
* device instance _89 r0 *1 0,0
C_89 \$89 vsubs 1.15618e-16
* device instance a_b_b3_invb_a_mn12_g1_mp24_g0_t2_y_t0 r0 *1 0,0
Ra_b_b3_invb_a_mn12_g1_mp24_g0_t2_y_t0 a|b|b3|invb_a|mn12_g1|mp24_g0|t2|y__t0
+ a|b|b3|invb_a|mn12_g1|mp24_g0|t2|y 409.635106767
* device instance a_b_b3_invb_a_mn12_g1_mp24_g0_t2_y_t1 r0 *1 0,0
Ra_b_b3_invb_a_mn12_g1_mp24_g0_t2_y_t1 a|b|b3|invb_a|mn12_g1|mp24_g0|t2|y__t1
+ a|b|b3|invb_a|mn12_g1|mp24_g0|t2|y 294.133620825
* device instance a_b_b3_invb_a_mn12_g1_mp24_g0_t2_y_t2 r0 *1 0,0
Ra_b_b3_invb_a_mn12_g1_mp24_g0_t2_y_t2 a|b|b3|invb_a|mn12_g1|mp24_g0|t2|y__t2
+ a|b|b3|invb_a|mn12_g1|mp24_g0|t2|y 293.51720502
* device instance a_b_b3_invb_a_mn12_g1_mp24_g0_t2_y_t3 r0 *1 0,0
Ra_b_b3_invb_a_mn12_g1_mp24_g0_t2_y_t3 a|b|b3|invb_a|mn12_g1|mp24_g0|t2|y__t3
+ a|b|b3|invb_a|mn12_g1|mp24_g0|t2|y 396.642557999
* device instance a_b_b3_invb_a_mn12_g1_mp24_g0_t2_y_t4 r0 *1 0,0
Ra_b_b3_invb_a_mn12_g1_mp24_g0_t2_y_t4 a|b|b3|invb_a|mn12_g1|mp24_g0|t2|y__t4
+ a|b|b3|invb_a|mn12_g1|mp24_g0|t2|y 398.872164213
* device instance a_b_b3_invb_a_mn12_g1_mp24_g0_t2_y_t5 r0 *1 0,0
Ra_b_b3_invb_a_mn12_g1_mp24_g0_t2_y_t5 a|b|b3|invb_a|mn12_g1|mp24_g0|t2|y__t5
+ a|b|b3|invb_a|mn12_g1|mp24_g0|t2|y 294.652537151
* device instance a_b_b3_invb_a_mn12_g1_mp24_g0_t2_y_t6 r0 *1 0,0
Ra_b_b3_invb_a_mn12_g1_mp24_g0_t2_y_t6 a|b|b3|invb_a|mn12_g1|mp24_g0|t2|y__t6
+ a|b|b3|invb_a|mn12_g1|mp24_g0|t2|y 413.294026601
* device instance a_b_b3_invb_a_mn12_g1_mp24_g0_t2_y_t7 r0 *1 0,0
Ra_b_b3_invb_a_mn12_g1_mp24_g0_t2_y_t7 a|b|b3|invb_a|mn12_g1|mp24_g0|t2|y__t7
+ a|b|b3|invb_a|mn12_g1|mp24_g0|t2|y 286.911181424
* device instance a_b_b3_invb_a_mn12_g1_mp24_g0_t2_y r0 *1 0,0
Ca_b_b3_invb_a_mn12_g1_mp24_g0_t2_y a|b|b3|invb_a|mn12_g1|mp24_g0|t2|y vsubs
+ 1.0148008e-14
* device instance a_b_invb_a_mn12_g1_mp24_g0_ro2_y_t0 r0 *1 0,0
Ra_b_invb_a_mn12_g1_mp24_g0_ro2_y_t0 a|b|invb_a|mn12_g1|mp24_g0|ro2|y__t0
+ a|b|invb_a|mn12_g1|mp24_g0|ro2|y 190.790466254
* device instance a_b_invb_a_mn12_g1_mp24_g0_ro2_y_t1 r0 *1 0,0
Ra_b_invb_a_mn12_g1_mp24_g0_ro2_y_t1 a|b|invb_a|mn12_g1|mp24_g0|ro2|y__t1
+ a|b|invb_a|mn12_g1|mp24_g0|ro2|y 327.435987958
* device instance a_b_invb_a_mn12_g1_mp24_g0_ro2_y_t2 r0 *1 0,0
Ra_b_invb_a_mn12_g1_mp24_g0_ro2_y_t2 a|b|invb_a|mn12_g1|mp24_g0|ro2|y__t2
+ a|b|invb_a|mn12_g1|mp24_g0|ro2|y 149.02035008
* device instance a_b_invb_a_mn12_g1_mp24_g0_ro2_y_t3 r0 *1 0,0
Ra_b_invb_a_mn12_g1_mp24_g0_ro2_y_t3 a|b|invb_a|mn12_g1|mp24_g0|ro2|y__t3
+ a|b|invb_a|mn12_g1|mp24_g0|ro2|y 331.325498978
* device instance a_b_invb_a_mn12_g1_mp24_g0_ro2_y_t4 r0 *1 0,0
Ra_b_invb_a_mn12_g1_mp24_g0_ro2_y_t4 a|b|invb_a|mn12_g1|mp24_g0|ro2|y__t4
+ a|b|invb_a|mn12_g1|mp24_g0|ro2|y 145.029667721
* device instance a_b_invb_a_mn12_g1_mp24_g0_ro2_y_t5 r0 *1 0,0
Ra_b_invb_a_mn12_g1_mp24_g0_ro2_y_t5 a|b|invb_a|mn12_g1|mp24_g0|ro2|y__t5
+ a|b|invb_a|mn12_g1|mp24_g0|ro2|y 178.36702901
* device instance a_b_invb_a_mn12_g1_mp24_g0_ro2_y r0 *1 0,0
Ca_b_invb_a_mn12_g1_mp24_g0_ro2_y a|b|invb_a|mn12_g1|mp24_g0|ro2|y vsubs
+ 1.2032511e-14
* device instance a_b_invb_a_mn12_g1_mp24_g0_ro4_y_t0 r0 *1 0,0
Ra_b_invb_a_mn12_g1_mp24_g0_ro4_y_t0 a|b|invb_a|mn12_g1|mp24_g0|ro4|y__t0
+ a|b|invb_a|mn12_g1|mp24_g0|ro4|y 184.956516017
* device instance a_b_invb_a_mn12_g1_mp24_g0_ro4_y_t1 r0 *1 0,0
Ra_b_invb_a_mn12_g1_mp24_g0_ro4_y_t1 a|b|invb_a|mn12_g1|mp24_g0|ro4|y__t1
+ a|b|invb_a|mn12_g1|mp24_g0|ro4|y 344.598603152
* device instance a_b_invb_a_mn12_g1_mp24_g0_ro4_y_t2 r0 *1 0,0
Ra_b_invb_a_mn12_g1_mp24_g0_ro4_y_t2 a|b|invb_a|mn12_g1|mp24_g0|ro4|y__t2
+ a|b|invb_a|mn12_g1|mp24_g0|ro4|y 163.416356581
* device instance a_b_invb_a_mn12_g1_mp24_g0_ro4_y_t3 r0 *1 0,0
Ra_b_invb_a_mn12_g1_mp24_g0_ro4_y_t3 a|b|invb_a|mn12_g1|mp24_g0|ro4|y__t3
+ a|b|invb_a|mn12_g1|mp24_g0|ro4|y 345.703203735
* device instance a_b_invb_a_mn12_g1_mp24_g0_ro4_y_t4 r0 *1 0,0
Ra_b_invb_a_mn12_g1_mp24_g0_ro4_y_t4 a|b|invb_a|mn12_g1|mp24_g0|ro4|y__t4
+ a|b|invb_a|mn12_g1|mp24_g0|ro4|y 162.344366613
* device instance a_b_invb_a_mn12_g1_mp24_g0_ro4_y_t5 r0 *1 0,0
Ra_b_invb_a_mn12_g1_mp24_g0_ro4_y_t5 a|b|invb_a|mn12_g1|mp24_g0|ro4|y__t5
+ a|b|invb_a|mn12_g1|mp24_g0|ro4|y 180.945053902
* device instance a_b_invb_a_mn12_g1_mp24_g0_ro4_y r0 *1 0,0
Ca_b_invb_a_mn12_g1_mp24_g0_ro4_y a|b|invb_a|mn12_g1|mp24_g0|ro4|y vsubs
+ 1.9009314e-14
* device instance a_g_a_rn1_ro_s4_y_y_t0 r0 *1 0,0
Ra_g_a_rn1_ro_s4_y_y_t0 a|g_a|rn1|ro|s4_y|y__t0 a|g_a|rn1|ro|s4_y|y
+ 345.096279942
* device instance a_g_a_rn1_ro_s4_y_y_t1 r0 *1 0,0
Ra_g_a_rn1_ro_s4_y_y_t1 a|g_a|rn1|ro|s4_y|y__t1 a|g_a|rn1|ro|s4_y|y
+ 108.856657591
* device instance a_g_a_rn1_ro_s4_y_y_t2 r0 *1 0,0
Ra_g_a_rn1_ro_s4_y_y_t2 a|g_a|rn1|ro|s4_y|y__t2 a|g_a|rn1|ro|s4_y|y
+ 234.695939179
* device instance a_g_a_rn1_ro_s4_y_y_t3 r0 *1 0,0
Ra_g_a_rn1_ro_s4_y_y_t3 a|g_a|rn1|ro|s4_y|y__t3 a|g_a|rn1|ro|s4_y|y
+ 343.168292152
* device instance a_g_a_rn1_ro_s4_y_y_t4 r0 *1 0,0
Ra_g_a_rn1_ro_s4_y_y_t4 a|g_a|rn1|ro|s4_y|y__t4 a|g_a|rn1|ro|s4_y|y
+ 115.011240917
* device instance a_g_a_rn1_ro_s4_y_y_t5 r0 *1 0,0
Ra_g_a_rn1_ro_s4_y_y_t5 a|g_a|rn1|ro|s4_y|y__t5 a|g_a|rn1|ro|s4_y|y
+ 235.084690218
* device instance a_g_a_rn1_ro_s4_y_y r0 *1 0,0
Ca_g_a_rn1_ro_s4_y_y a|g_a|rn1|ro|s4_y|y vsubs 6.563292e-15
* device instance a_g_a_rn2_ro_s4_y_y_t0 r0 *1 0,0
Ra_g_a_rn2_ro_s4_y_y_t0 a|g_a|rn2|ro|s4_y|y__t0 a|g_a|rn2|ro|s4_y|y
+ 108.856657591
* device instance a_g_a_rn2_ro_s4_y_y_t1 r0 *1 0,0
Ra_g_a_rn2_ro_s4_y_y_t1 a|g_a|rn2|ro|s4_y|y__t1 a|g_a|rn2|ro|s4_y|y
+ 234.695939179
* device instance a_g_a_rn2_ro_s4_y_y_t2 r0 *1 0,0
Ra_g_a_rn2_ro_s4_y_y_t2 a|g_a|rn2|ro|s4_y|y__t2 a|g_a|rn2|ro|s4_y|y
+ 343.168292152
* device instance a_g_a_rn2_ro_s4_y_y_t3 r0 *1 0,0
Ra_g_a_rn2_ro_s4_y_y_t3 a|g_a|rn2|ro|s4_y|y__t3 a|g_a|rn2|ro|s4_y|y
+ 115.011240917
* device instance a_g_a_rn2_ro_s4_y_y_t4 r0 *1 0,0
Ra_g_a_rn2_ro_s4_y_y_t4 a|g_a|rn2|ro|s4_y|y__t4 a|g_a|rn2|ro|s4_y|y
+ 235.084690218
* device instance a_g_a_rn2_ro_s4_y_y_t5 r0 *1 0,0
Ra_g_a_rn2_ro_s4_y_y_t5 a|g_a|rn2|ro|s4_y|y__t5 a|g_a|rn2|ro|s4_y|y
+ 345.096279942
* device instance a_g_a_rn2_ro_s4_y_y r0 *1 0,0
Ca_g_a_rn2_ro_s4_y_y a|g_a|rn2|ro|s4_y|y vsubs 6.563292e-15
* device instance a_g_a_rn3_ro_s4_y_y_t0 r0 *1 0,0
Ra_g_a_rn3_ro_s4_y_y_t0 a|g_a|rn3|ro|s4_y|y__t0 a|g_a|rn3|ro|s4_y|y
+ 108.856657591
* device instance a_g_a_rn3_ro_s4_y_y_t1 r0 *1 0,0
Ra_g_a_rn3_ro_s4_y_y_t1 a|g_a|rn3|ro|s4_y|y__t1 a|g_a|rn3|ro|s4_y|y
+ 343.168292152
* device instance a_g_a_rn3_ro_s4_y_y_t2 r0 *1 0,0
Ra_g_a_rn3_ro_s4_y_y_t2 a|g_a|rn3|ro|s4_y|y__t2 a|g_a|rn3|ro|s4_y|y
+ 234.695939179
* device instance a_g_a_rn3_ro_s4_y_y_t3 r0 *1 0,0
Ra_g_a_rn3_ro_s4_y_y_t3 a|g_a|rn3|ro|s4_y|y__t3 a|g_a|rn3|ro|s4_y|y
+ 115.011240917
* device instance a_g_a_rn3_ro_s4_y_y_t4 r0 *1 0,0
Ra_g_a_rn3_ro_s4_y_y_t4 a|g_a|rn3|ro|s4_y|y__t4 a|g_a|rn3|ro|s4_y|y
+ 235.084690218
* device instance a_g_a_rn3_ro_s4_y_y_t5 r0 *1 0,0
Ra_g_a_rn3_ro_s4_y_y_t5 a|g_a|rn3|ro|s4_y|y__t5 a|g_a|rn3|ro|s4_y|y
+ 345.096279942
* device instance a_g_a_rn3_ro_s4_y_y r0 *1 0,0
Ca_g_a_rn3_ro_s4_y_y a|g_a|rn3|ro|s4_y|y vsubs 6.563292e-15
* device instance a_g_a_rn4_ro_s4_y_y_t0 r0 *1 0,0
Ra_g_a_rn4_ro_s4_y_y_t0 a|g_a|rn4|ro|s4_y|y__t0 a|g_a|rn4|ro|s4_y|y
+ 108.856657591
* device instance a_g_a_rn4_ro_s4_y_y_t1 r0 *1 0,0
Ra_g_a_rn4_ro_s4_y_y_t1 a|g_a|rn4|ro|s4_y|y__t1 a|g_a|rn4|ro|s4_y|y
+ 234.695939179
* device instance a_g_a_rn4_ro_s4_y_y_t2 r0 *1 0,0
Ra_g_a_rn4_ro_s4_y_y_t2 a|g_a|rn4|ro|s4_y|y__t2 a|g_a|rn4|ro|s4_y|y
+ 343.168292152
* device instance a_g_a_rn4_ro_s4_y_y_t3 r0 *1 0,0
Ra_g_a_rn4_ro_s4_y_y_t3 a|g_a|rn4|ro|s4_y|y__t3 a|g_a|rn4|ro|s4_y|y
+ 115.011240917
* device instance a_g_a_rn4_ro_s4_y_y_t4 r0 *1 0,0
Ra_g_a_rn4_ro_s4_y_y_t4 a|g_a|rn4|ro|s4_y|y__t4 a|g_a|rn4|ro|s4_y|y
+ 235.084690218
* device instance a_g_a_rn4_ro_s4_y_y_t5 r0 *1 0,0
Ra_g_a_rn4_ro_s4_y_y_t5 a|g_a|rn4|ro|s4_y|y__t5 a|g_a|rn4|ro|s4_y|y
+ 345.096279942
* device instance a_g_a_rn4_ro_s4_y_y r0 *1 0,0
Ca_g_a_rn4_ro_s4_y_y a|g_a|rn4|ro|s4_y|y vsubs 6.557974e-15
* device instance a_g_y_mnab_y_mpa_y_mpb_y_n1_s1_a_y_t0 r0 *1 0,0
Ra_g_y_mnab_y_mpa_y_mpb_y_n1_s1_a_y_t0 a|g_y|mnab_y|mpa_y|mpb_y|n1|s1_a|y__t0
+ a|g_y|mnab_y|mpa_y|mpb_y|n1|s1_a|y 118.690159634
* device instance a_g_y_mnab_y_mpa_y_mpb_y_n1_s1_a_y_t1 r0 *1 0,0
Ra_g_y_mnab_y_mpa_y_mpb_y_n1_s1_a_y_t1 a|g_y|mnab_y|mpa_y|mpb_y|n1|s1_a|y__t1
+ a|g_y|mnab_y|mpa_y|mpb_y|n1|s1_a|y 132.890468841
* device instance a_g_y_mnab_y_mpa_y_mpb_y_n1_s1_a_y_t2 r0 *1 0,0
Ra_g_y_mnab_y_mpa_y_mpb_y_n1_s1_a_y_t2 a|g_y|mnab_y|mpa_y|mpb_y|n1|s1_a|y__t2
+ a|g_y|mnab_y|mpa_y|mpb_y|n1|s1_a|y 88.589660111
* device instance a_g_y_mnab_y_mpa_y_mpb_y_n1_s1_a_y_t3 r0 *1 0,0
Ra_g_y_mnab_y_mpa_y_mpb_y_n1_s1_a_y_t3 a|g_y|mnab_y|mpa_y|mpb_y|n1|s1_a|y__t3
+ a|g_y|mnab_y|mpa_y|mpb_y|n1|s1_a|y 152.348139631
* device instance a_g_y_mnab_y_mpa_y_mpb_y_n1_s1_a_y_t4 r0 *1 0,0
Ra_g_y_mnab_y_mpa_y_mpb_y_n1_s1_a_y_t4 a|g_y|mnab_y|mpa_y|mpb_y|n1|s1_a|y__t4
+ a|g_y|mnab_y|mpa_y|mpb_y|n1|s1_a|y 100.849471782
* device instance a_g_y_mnab_y_mpa_y_mpb_y_n1_s1_a_y r0 *1 0,0
Ca_g_y_mnab_y_mpa_y_mpb_y_n1_s1_a_y a|g_y|mnab_y|mpa_y|mpb_y|n1|s1_a|y vsubs
+ 2.784627e-15
* device instance a_g_y_mnab_y_mpa_y_mpb_y_n1_s1_a_y_dup1_t0 r0 *1 0,0
Ra_g_y_mnab_y_mpa_y_mpb_y_n1_s1_a_y_dup1_t0
+ a|g_y|mnab_y|mpa_y|mpb_y|n1|s1_a|y__t02 a|g_y|mnab_y|mpa_y|mpb_y|n1|s1_a|y$1
+ 100.849471782
* device instance a_g_y_mnab_y_mpa_y_mpb_y_n1_s1_a_y_dup1_t1 r0 *1 0,0
Ra_g_y_mnab_y_mpa_y_mpb_y_n1_s1_a_y_dup1_t1
+ a|g_y|mnab_y|mpa_y|mpb_y|n1|s1_a|y__t12 a|g_y|mnab_y|mpa_y|mpb_y|n1|s1_a|y$1
+ 152.348139631
* device instance a_g_y_mnab_y_mpa_y_mpb_y_n1_s1_a_y_dup1_t2 r0 *1 0,0
Ra_g_y_mnab_y_mpa_y_mpb_y_n1_s1_a_y_dup1_t2
+ a|g_y|mnab_y|mpa_y|mpb_y|n1|s1_a|y__t22 a|g_y|mnab_y|mpa_y|mpb_y|n1|s1_a|y$1
+ 118.690159634
* device instance a_g_y_mnab_y_mpa_y_mpb_y_n1_s1_a_y_dup1_t3 r0 *1 0,0
Ra_g_y_mnab_y_mpa_y_mpb_y_n1_s1_a_y_dup1_t3
+ a|g_y|mnab_y|mpa_y|mpb_y|n1|s1_a|y__t32 a|g_y|mnab_y|mpa_y|mpb_y|n1|s1_a|y$1
+ 132.890468841
* device instance a_g_y_mnab_y_mpa_y_mpb_y_n1_s1_a_y_dup1_t4 r0 *1 0,0
Ra_g_y_mnab_y_mpa_y_mpb_y_n1_s1_a_y_dup1_t4
+ a|g_y|mnab_y|mpa_y|mpb_y|n1|s1_a|y__t42 a|g_y|mnab_y|mpa_y|mpb_y|n1|s1_a|y$1
+ 88.589660111
* device instance a_g_y_mnab_y_mpa_y_mpb_y_n1_s1_a_y_dup1 r0 *1 0,0
Ca_g_y_mnab_y_mpa_y_mpb_y_n1_s1_a_y_dup1 a|g_y|mnab_y|mpa_y|mpb_y|n1|s1_a|y$1
+ vsubs 2.784627e-15
* device instance a_g_y_mnab_y_mpa_y_mpb_y_n1_s1_a_y_dup2_t0 r0 *1 0,0
Ra_g_y_mnab_y_mpa_y_mpb_y_n1_s1_a_y_dup2_t0
+ a|g_y|mnab_y|mpa_y|mpb_y|n1|s1_a|y__t03 a|g_y|mnab_y|mpa_y|mpb_y|n1|s1_a|y$2
+ 118.690159634
* device instance a_g_y_mnab_y_mpa_y_mpb_y_n1_s1_a_y_dup2_t1 r0 *1 0,0
Ra_g_y_mnab_y_mpa_y_mpb_y_n1_s1_a_y_dup2_t1
+ a|g_y|mnab_y|mpa_y|mpb_y|n1|s1_a|y__t13 a|g_y|mnab_y|mpa_y|mpb_y|n1|s1_a|y$2
+ 132.890468841
* device instance a_g_y_mnab_y_mpa_y_mpb_y_n1_s1_a_y_dup2_t2 r0 *1 0,0
Ra_g_y_mnab_y_mpa_y_mpb_y_n1_s1_a_y_dup2_t2
+ a|g_y|mnab_y|mpa_y|mpb_y|n1|s1_a|y__t23 a|g_y|mnab_y|mpa_y|mpb_y|n1|s1_a|y$2
+ 88.589660111
* device instance a_g_y_mnab_y_mpa_y_mpb_y_n1_s1_a_y_dup2_t3 r0 *1 0,0
Ra_g_y_mnab_y_mpa_y_mpb_y_n1_s1_a_y_dup2_t3
+ a|g_y|mnab_y|mpa_y|mpb_y|n1|s1_a|y__t33 a|g_y|mnab_y|mpa_y|mpb_y|n1|s1_a|y$2
+ 152.348139631
* device instance a_g_y_mnab_y_mpa_y_mpb_y_n1_s1_a_y_dup2_t4 r0 *1 0,0
Ra_g_y_mnab_y_mpa_y_mpb_y_n1_s1_a_y_dup2_t4
+ a|g_y|mnab_y|mpa_y|mpb_y|n1|s1_a|y__t43 a|g_y|mnab_y|mpa_y|mpb_y|n1|s1_a|y$2
+ 100.849471782
* device instance a_g_y_mnab_y_mpa_y_mpb_y_n1_s1_a_y_dup2 r0 *1 0,0
Ca_g_y_mnab_y_mpa_y_mpb_y_n1_s1_a_y_dup2 a|g_y|mnab_y|mpa_y|mpb_y|n1|s1_a|y$2
+ vsubs 2.784627e-15
* device instance a_g_y_mnab_y_mpa_y_mpb_y_n1_s1_a_y_dup3_t0 r0 *1 0,0
Ra_g_y_mnab_y_mpa_y_mpb_y_n1_s1_a_y_dup3_t0
+ a|g_y|mnab_y|mpa_y|mpb_y|n1|s1_a|y__t04 a|g_y|mnab_y|mpa_y|mpb_y|n1|s1_a|y$3
+ 118.690159634
* device instance a_g_y_mnab_y_mpa_y_mpb_y_n1_s1_a_y_dup3_t1 r0 *1 0,0
Ra_g_y_mnab_y_mpa_y_mpb_y_n1_s1_a_y_dup3_t1
+ a|g_y|mnab_y|mpa_y|mpb_y|n1|s1_a|y__t14 a|g_y|mnab_y|mpa_y|mpb_y|n1|s1_a|y$3
+ 132.890468841
* device instance a_g_y_mnab_y_mpa_y_mpb_y_n1_s1_a_y_dup3_t2 r0 *1 0,0
Ra_g_y_mnab_y_mpa_y_mpb_y_n1_s1_a_y_dup3_t2
+ a|g_y|mnab_y|mpa_y|mpb_y|n1|s1_a|y__t24 a|g_y|mnab_y|mpa_y|mpb_y|n1|s1_a|y$3
+ 88.589660111
* device instance a_g_y_mnab_y_mpa_y_mpb_y_n1_s1_a_y_dup3_t3 r0 *1 0,0
Ra_g_y_mnab_y_mpa_y_mpb_y_n1_s1_a_y_dup3_t3
+ a|g_y|mnab_y|mpa_y|mpb_y|n1|s1_a|y__t34 a|g_y|mnab_y|mpa_y|mpb_y|n1|s1_a|y$3
+ 152.348139631
* device instance a_g_y_mnab_y_mpa_y_mpb_y_n1_s1_a_y_dup3_t4 r0 *1 0,0
Ra_g_y_mnab_y_mpa_y_mpb_y_n1_s1_a_y_dup3_t4
+ a|g_y|mnab_y|mpa_y|mpb_y|n1|s1_a|y__t44 a|g_y|mnab_y|mpa_y|mpb_y|n1|s1_a|y$3
+ 100.849471782
* device instance a_g_y_mnab_y_mpa_y_mpb_y_n1_s1_a_y_dup3 r0 *1 0,0
Ca_g_y_mnab_y_mpa_y_mpb_y_n1_s1_a_y_dup3 a|g_y|mnab_y|mpa_y|mpb_y|n1|s1_a|y$3
+ vsubs 2.784627e-15
* device instance a_inva_a_mn12_g0_mp13_g0_ro1_y_t0 r0 *1 0,0
Ra_inva_a_mn12_g0_mp13_g0_ro1_y_t0 a|inva_a|mn12_g0|mp13_g0|ro1|y__t0
+ a|inva_a|mn12_g0|mp13_g0|ro1|y 193.192387039
* device instance a_inva_a_mn12_g0_mp13_g0_ro1_y_t1 r0 *1 0,0
Ra_inva_a_mn12_g0_mp13_g0_ro1_y_t1 a|inva_a|mn12_g0|mp13_g0|ro1|y__t1
+ a|inva_a|mn12_g0|mp13_g0|ro1|y 319.110574763
* device instance a_inva_a_mn12_g0_mp13_g0_ro1_y_t2 r0 *1 0,0
Ra_inva_a_mn12_g0_mp13_g0_ro1_y_t2 a|inva_a|mn12_g0|mp13_g0|ro1|y__t2
+ a|inva_a|mn12_g0|mp13_g0|ro1|y 205.73799354
* device instance a_inva_a_mn12_g0_mp13_g0_ro1_y_t3 r0 *1 0,0
Ra_inva_a_mn12_g0_mp13_g0_ro1_y_t3 a|inva_a|mn12_g0|mp13_g0|ro1|y__t3
+ a|inva_a|mn12_g0|mp13_g0|ro1|y 333.428460148
* device instance a_inva_a_mn12_g0_mp13_g0_ro1_y_t4 r0 *1 0,0
Ra_inva_a_mn12_g0_mp13_g0_ro1_y_t4 a|inva_a|mn12_g0|mp13_g0|ro1|y__t4
+ a|inva_a|mn12_g0|mp13_g0|ro1|y 195.06213806
* device instance a_inva_a_mn12_g0_mp13_g0_ro1_y_t5 r0 *1 0,0
Ra_inva_a_mn12_g0_mp13_g0_ro1_y_t5 a|inva_a|mn12_g0|mp13_g0|ro1|y__t5
+ a|inva_a|mn12_g0|mp13_g0|ro1|y 70.5227464495
* device instance a_inva_a_mn12_g0_mp13_g0_ro1_y r0 *1 0,0
Ca_inva_a_mn12_g0_mp13_g0_ro1_y a|inva_a|mn12_g0|mp13_g0|ro1|y vsubs
+ 1.1462041e-14
* device instance a_inva_a_mn12_g0_mp13_g0_ro3_y_t0 r0 *1 0,0
Ra_inva_a_mn12_g0_mp13_g0_ro3_y_t0 a|inva_a|mn12_g0|mp13_g0|ro3|y__t0
+ a|inva_a|mn12_g0|mp13_g0|ro3|y 175.965747303
* device instance a_inva_a_mn12_g0_mp13_g0_ro3_y_t1 r0 *1 0,0
Ra_inva_a_mn12_g0_mp13_g0_ro3_y_t1 a|inva_a|mn12_g0|mp13_g0|ro3|y__t1
+ a|inva_a|mn12_g0|mp13_g0|ro3|y 342.670975174
* device instance a_inva_a_mn12_g0_mp13_g0_ro3_y_t2 r0 *1 0,0
Ra_inva_a_mn12_g0_mp13_g0_ro3_y_t2 a|inva_a|mn12_g0|mp13_g0|ro3|y__t2
+ a|inva_a|mn12_g0|mp13_g0|ro3|y 188.193283758
* device instance a_inva_a_mn12_g0_mp13_g0_ro3_y_t3 r0 *1 0,0
Ra_inva_a_mn12_g0_mp13_g0_ro3_y_t3 a|inva_a|mn12_g0|mp13_g0|ro3|y__t3
+ a|inva_a|mn12_g0|mp13_g0|ro3|y 344.678643992
* device instance a_inva_a_mn12_g0_mp13_g0_ro3_y_t4 r0 *1 0,0
Ra_inva_a_mn12_g0_mp13_g0_ro3_y_t4 a|inva_a|mn12_g0|mp13_g0|ro3|y__t4
+ a|inva_a|mn12_g0|mp13_g0|ro3|y 186.506608924
* device instance a_inva_a_mn12_g0_mp13_g0_ro3_y_t5 r0 *1 0,0
Ra_inva_a_mn12_g0_mp13_g0_ro3_y_t5 a|inva_a|mn12_g0|mp13_g0|ro3|y__t5
+ a|inva_a|mn12_g0|mp13_g0|ro3|y 139.055740848
* device instance a_inva_a_mn12_g0_mp13_g0_ro3_y r0 *1 0,0
Ca_inva_a_mn12_g0_mp13_g0_ro3_y a|inva_a|mn12_g0|mp13_g0|ro3|y vsubs
+ 1.8443251e-14
* device instance a_inva_a_mn12_g0_mp13_g0_t1_y_t0 r0 *1 0,0
Ra_inva_a_mn12_g0_mp13_g0_t1_y_t0 a|inva_a|mn12_g0|mp13_g0|t1|y__t0
+ a|inva_a|mn12_g0|mp13_g0|t1|y 393.96501156
* device instance a_inva_a_mn12_g0_mp13_g0_t1_y_t1 r0 *1 0,0
Ra_inva_a_mn12_g0_mp13_g0_t1_y_t1 a|inva_a|mn12_g0|mp13_g0|t1|y__t1
+ a|inva_a|mn12_g0|mp13_g0|t1|y 312.148663125
* device instance a_inva_a_mn12_g0_mp13_g0_t1_y_t2 r0 *1 0,0
Ra_inva_a_mn12_g0_mp13_g0_t1_y_t2 a|inva_a|mn12_g0|mp13_g0|t1|y__t2
+ a|inva_a|mn12_g0|mp13_g0|t1|y 355.301959278
* device instance a_inva_a_mn12_g0_mp13_g0_t1_y_t3 r0 *1 0,0
Ra_inva_a_mn12_g0_mp13_g0_t1_y_t3 a|inva_a|mn12_g0|mp13_g0|t1|y__t3
+ a|inva_a|mn12_g0|mp13_g0|t1|y 297.753615342
* device instance a_inva_a_mn12_g0_mp13_g0_t1_y_t4 r0 *1 0,0
Ra_inva_a_mn12_g0_mp13_g0_t1_y_t4 a|inva_a|mn12_g0|mp13_g0|t1|y__t4
+ a|inva_a|mn12_g0|mp13_g0|t1|y 299.162613598
* device instance a_inva_a_mn12_g0_mp13_g0_t1_y_t5 r0 *1 0,0
Ra_inva_a_mn12_g0_mp13_g0_t1_y_t5 a|inva_a|mn12_g0|mp13_g0|t1|y__t5
+ a|inva_a|mn12_g0|mp13_g0|t1|y 447.569121132
* device instance a_inva_a_mn12_g0_mp13_g0_t1_y_t6 r0 *1 0,0
Ra_inva_a_mn12_g0_mp13_g0_t1_y_t6 a|inva_a|mn12_g0|mp13_g0|t1|y__t6
+ a|inva_a|mn12_g0|mp13_g0|t1|y 308.270155599
* device instance a_inva_a_mn12_g0_mp13_g0_t1_y_t7 r0 *1 0,0
Ra_inva_a_mn12_g0_mp13_g0_t1_y_t7 a|inva_a|mn12_g0|mp13_g0|t1|y__t7
+ a|inva_a|mn12_g0|mp13_g0|t1|y 396.959960366
* device instance a_inva_a_mn12_g0_mp13_g0_t1_y r0 *1 0,0
Ca_inva_a_mn12_g0_mp13_g0_t1_y a|inva_a|mn12_g0|mp13_g0|t1|y vsubs 1.3120776e-14
* device instance a_n2_s1_y_s2_a_y_t0 r0 *1 0,0
Ra_n2_s1_y_s2_a_y_t0 a|n2|s1_y|s2_a|y__t0 a|n2|s1_y|s2_a|y 216.012838579
* device instance a_n2_s1_y_s2_a_y_t1 r0 *1 0,0
Ra_n2_s1_y_s2_a_y_t1 a|n2|s1_y|s2_a|y__t1 a|n2|s1_y|s2_a|y 236.534411421
* device instance a_n2_s1_y_s2_a_y_t2 r0 *1 0,0
Ra_n2_s1_y_s2_a_y_t2 a|n2|s1_y|s2_a|y__t2 a|n2|s1_y|s2_a|y 216.012838579
* device instance a_n2_s1_y_s2_a_y_t3 r0 *1 0,0
Ra_n2_s1_y_s2_a_y_t3 a|n2|s1_y|s2_a|y__t3 a|n2|s1_y|s2_a|y 236.534411421
* device instance a_n2_s1_y_s2_a_y r0 *1 0,0
Ca_n2_s1_y_s2_a_y a|n2|s1_y|s2_a|y vsubs 2.620771e-15
* device instance a_n2_s1_y_s2_a_y_dup1_t0 r0 *1 0,0
Ra_n2_s1_y_s2_a_y_dup1_t0 a|n2|s1_y|s2_a|y__t02 a|n2|s1_y|s2_a|y$1 236.534411421
* device instance a_n2_s1_y_s2_a_y_dup1_t1 r0 *1 0,0
Ra_n2_s1_y_s2_a_y_dup1_t1 a|n2|s1_y|s2_a|y__t12 a|n2|s1_y|s2_a|y$1 216.012838579
* device instance a_n2_s1_y_s2_a_y_dup1_t2 r0 *1 0,0
Ra_n2_s1_y_s2_a_y_dup1_t2 a|n2|s1_y|s2_a|y__t22 a|n2|s1_y|s2_a|y$1 216.012838579
* device instance a_n2_s1_y_s2_a_y_dup1_t3 r0 *1 0,0
Ra_n2_s1_y_s2_a_y_dup1_t3 a|n2|s1_y|s2_a|y__t32 a|n2|s1_y|s2_a|y$1 236.534411421
* device instance a_n2_s1_y_s2_a_y_dup1 r0 *1 0,0
Ca_n2_s1_y_s2_a_y_dup1 a|n2|s1_y|s2_a|y$1 vsubs 2.620771e-15
* device instance a_n2_s1_y_s2_a_y_dup2_t0 r0 *1 0,0
Ra_n2_s1_y_s2_a_y_dup2_t0 a|n2|s1_y|s2_a|y__t03 a|n2|s1_y|s2_a|y$2 236.534411421
* device instance a_n2_s1_y_s2_a_y_dup2_t1 r0 *1 0,0
Ra_n2_s1_y_s2_a_y_dup2_t1 a|n2|s1_y|s2_a|y__t13 a|n2|s1_y|s2_a|y$2 216.012838579
* device instance a_n2_s1_y_s2_a_y_dup2_t2 r0 *1 0,0
Ra_n2_s1_y_s2_a_y_dup2_t2 a|n2|s1_y|s2_a|y__t23 a|n2|s1_y|s2_a|y$2 216.012838579
* device instance a_n2_s1_y_s2_a_y_dup2_t3 r0 *1 0,0
Ra_n2_s1_y_s2_a_y_dup2_t3 a|n2|s1_y|s2_a|y__t33 a|n2|s1_y|s2_a|y$2 236.534411421
* device instance a_n2_s1_y_s2_a_y_dup2 r0 *1 0,0
Ca_n2_s1_y_s2_a_y_dup2 a|n2|s1_y|s2_a|y$2 vsubs 2.620771e-15
* device instance a_n2_s1_y_s2_a_y_dup3_t0 r0 *1 0,0
Ra_n2_s1_y_s2_a_y_dup3_t0 a|n2|s1_y|s2_a|y__t04 a|n2|s1_y|s2_a|y$3 236.534411421
* device instance a_n2_s1_y_s2_a_y_dup3_t1 r0 *1 0,0
Ra_n2_s1_y_s2_a_y_dup3_t1 a|n2|s1_y|s2_a|y__t14 a|n2|s1_y|s2_a|y$3 216.012838579
* device instance a_n2_s1_y_s2_a_y_dup3_t2 r0 *1 0,0
Ra_n2_s1_y_s2_a_y_dup3_t2 a|n2|s1_y|s2_a|y__t24 a|n2|s1_y|s2_a|y$3 216.012838579
* device instance a_n2_s1_y_s2_a_y_dup3_t3 r0 *1 0,0
Ra_n2_s1_y_s2_a_y_dup3_t3 a|n2|s1_y|s2_a|y__t34 a|n2|s1_y|s2_a|y$3 236.534411421
* device instance a_n2_s1_y_s2_a_y_dup3 r0 *1 0,0
Ca_n2_s1_y_s2_a_y_dup3 a|n2|s1_y|s2_a|y$3 vsubs 2.620771e-15
* device instance a_n3_s2_y_s3_a_y_t0 r0 *1 0,0
Ra_n3_s2_y_s3_a_y_t0 a|n3|s2_y|s3_a|y__t0 a|n3|s2_y|s3_a|y 236.534411421
* device instance a_n3_s2_y_s3_a_y_t1 r0 *1 0,0
Ra_n3_s2_y_s3_a_y_t1 a|n3|s2_y|s3_a|y__t1 a|n3|s2_y|s3_a|y 216.012838579
* device instance a_n3_s2_y_s3_a_y_t2 r0 *1 0,0
Ra_n3_s2_y_s3_a_y_t2 a|n3|s2_y|s3_a|y__t2 a|n3|s2_y|s3_a|y 216.012838579
* device instance a_n3_s2_y_s3_a_y_t3 r0 *1 0,0
Ra_n3_s2_y_s3_a_y_t3 a|n3|s2_y|s3_a|y__t3 a|n3|s2_y|s3_a|y 236.534411421
* device instance a_n3_s2_y_s3_a_y r0 *1 0,0
Ca_n3_s2_y_s3_a_y a|n3|s2_y|s3_a|y vsubs 2.620771e-15
* device instance a_n3_s2_y_s3_a_y_dup1_t0 r0 *1 0,0
Ra_n3_s2_y_s3_a_y_dup1_t0 a|n3|s2_y|s3_a|y__t02 a|n3|s2_y|s3_a|y$1 236.534411421
* device instance a_n3_s2_y_s3_a_y_dup1_t1 r0 *1 0,0
Ra_n3_s2_y_s3_a_y_dup1_t1 a|n3|s2_y|s3_a|y__t12 a|n3|s2_y|s3_a|y$1 216.012838579
* device instance a_n3_s2_y_s3_a_y_dup1_t2 r0 *1 0,0
Ra_n3_s2_y_s3_a_y_dup1_t2 a|n3|s2_y|s3_a|y__t22 a|n3|s2_y|s3_a|y$1 216.012838579
* device instance a_n3_s2_y_s3_a_y_dup1_t3 r0 *1 0,0
Ra_n3_s2_y_s3_a_y_dup1_t3 a|n3|s2_y|s3_a|y__t32 a|n3|s2_y|s3_a|y$1 236.534411421
* device instance a_n3_s2_y_s3_a_y_dup1 r0 *1 0,0
Ca_n3_s2_y_s3_a_y_dup1 a|n3|s2_y|s3_a|y$1 vsubs 2.620771e-15
* device instance a_n3_s2_y_s3_a_y_dup2_t0 r0 *1 0,0
Ra_n3_s2_y_s3_a_y_dup2_t0 a|n3|s2_y|s3_a|y__t03 a|n3|s2_y|s3_a|y$2 236.534411421
* device instance a_n3_s2_y_s3_a_y_dup2_t1 r0 *1 0,0
Ra_n3_s2_y_s3_a_y_dup2_t1 a|n3|s2_y|s3_a|y__t13 a|n3|s2_y|s3_a|y$2 216.012838579
* device instance a_n3_s2_y_s3_a_y_dup2_t2 r0 *1 0,0
Ra_n3_s2_y_s3_a_y_dup2_t2 a|n3|s2_y|s3_a|y__t23 a|n3|s2_y|s3_a|y$2 216.012838579
* device instance a_n3_s2_y_s3_a_y_dup2_t3 r0 *1 0,0
Ra_n3_s2_y_s3_a_y_dup2_t3 a|n3|s2_y|s3_a|y__t33 a|n3|s2_y|s3_a|y$2 236.534411421
* device instance a_n3_s2_y_s3_a_y_dup2 r0 *1 0,0
Ca_n3_s2_y_s3_a_y_dup2 a|n3|s2_y|s3_a|y$2 vsubs 2.620771e-15
* device instance a_n3_s2_y_s3_a_y_dup3_t0 r0 *1 0,0
Ra_n3_s2_y_s3_a_y_dup3_t0 a|n3|s2_y|s3_a|y__t04 a|n3|s2_y|s3_a|y$3 236.534411421
* device instance a_n3_s2_y_s3_a_y_dup3_t1 r0 *1 0,0
Ra_n3_s2_y_s3_a_y_dup3_t1 a|n3|s2_y|s3_a|y__t14 a|n3|s2_y|s3_a|y$3 216.012838579
* device instance a_n3_s2_y_s3_a_y_dup3_t2 r0 *1 0,0
Ra_n3_s2_y_s3_a_y_dup3_t2 a|n3|s2_y|s3_a|y__t24 a|n3|s2_y|s3_a|y$3 216.012838579
* device instance a_n3_s2_y_s3_a_y_dup3_t3 r0 *1 0,0
Ra_n3_s2_y_s3_a_y_dup3_t3 a|n3|s2_y|s3_a|y__t34 a|n3|s2_y|s3_a|y$3 236.534411421
* device instance a_n3_s2_y_s3_a_y_dup3 r0 *1 0,0
Ca_n3_s2_y_s3_a_y_dup3 a|n3|s2_y|s3_a|y$3 vsubs 2.620771e-15
* device instance a_n4_s3_y_s4_a_y_t0 r0 *1 0,0
Ra_n4_s3_y_s4_a_y_t0 a|n4|s3_y|s4_a|y__t0 a|n4|s3_y|s4_a|y 236.534411421
* device instance a_n4_s3_y_s4_a_y_t1 r0 *1 0,0
Ra_n4_s3_y_s4_a_y_t1 a|n4|s3_y|s4_a|y__t1 a|n4|s3_y|s4_a|y 216.012838579
* device instance a_n4_s3_y_s4_a_y_t2 r0 *1 0,0
Ra_n4_s3_y_s4_a_y_t2 a|n4|s3_y|s4_a|y__t2 a|n4|s3_y|s4_a|y 216.012838579
* device instance a_n4_s3_y_s4_a_y_t3 r0 *1 0,0
Ra_n4_s3_y_s4_a_y_t3 a|n4|s3_y|s4_a|y__t3 a|n4|s3_y|s4_a|y 236.534411421
* device instance a_n4_s3_y_s4_a_y r0 *1 0,0
Ca_n4_s3_y_s4_a_y a|n4|s3_y|s4_a|y vsubs 2.620771e-15
* device instance a_n4_s3_y_s4_a_y_dup1_t0 r0 *1 0,0
Ra_n4_s3_y_s4_a_y_dup1_t0 a|n4|s3_y|s4_a|y__t02 a|n4|s3_y|s4_a|y$1 236.534411421
* device instance a_n4_s3_y_s4_a_y_dup1_t1 r0 *1 0,0
Ra_n4_s3_y_s4_a_y_dup1_t1 a|n4|s3_y|s4_a|y__t12 a|n4|s3_y|s4_a|y$1 216.012838579
* device instance a_n4_s3_y_s4_a_y_dup1_t2 r0 *1 0,0
Ra_n4_s3_y_s4_a_y_dup1_t2 a|n4|s3_y|s4_a|y__t22 a|n4|s3_y|s4_a|y$1 216.012838579
* device instance a_n4_s3_y_s4_a_y_dup1_t3 r0 *1 0,0
Ra_n4_s3_y_s4_a_y_dup1_t3 a|n4|s3_y|s4_a|y__t32 a|n4|s3_y|s4_a|y$1 236.534411421
* device instance a_n4_s3_y_s4_a_y_dup1 r0 *1 0,0
Ca_n4_s3_y_s4_a_y_dup1 a|n4|s3_y|s4_a|y$1 vsubs 2.620771e-15
* device instance a_n4_s3_y_s4_a_y_dup2_t0 r0 *1 0,0
Ra_n4_s3_y_s4_a_y_dup2_t0 a|n4|s3_y|s4_a|y__t03 a|n4|s3_y|s4_a|y$2 236.534411421
* device instance a_n4_s3_y_s4_a_y_dup2_t1 r0 *1 0,0
Ra_n4_s3_y_s4_a_y_dup2_t1 a|n4|s3_y|s4_a|y__t13 a|n4|s3_y|s4_a|y$2 216.012838579
* device instance a_n4_s3_y_s4_a_y_dup2_t2 r0 *1 0,0
Ra_n4_s3_y_s4_a_y_dup2_t2 a|n4|s3_y|s4_a|y__t23 a|n4|s3_y|s4_a|y$2 216.012838579
* device instance a_n4_s3_y_s4_a_y_dup2_t3 r0 *1 0,0
Ra_n4_s3_y_s4_a_y_dup2_t3 a|n4|s3_y|s4_a|y__t33 a|n4|s3_y|s4_a|y$2 236.534411421
* device instance a_n4_s3_y_s4_a_y_dup2 r0 *1 0,0
Ca_n4_s3_y_s4_a_y_dup2 a|n4|s3_y|s4_a|y$2 vsubs 2.620771e-15
* device instance a_n4_s3_y_s4_a_y_dup3_t0 r0 *1 0,0
Ra_n4_s3_y_s4_a_y_dup3_t0 a|n4|s3_y|s4_a|y__t04 a|n4|s3_y|s4_a|y$3 236.534411421
* device instance a_n4_s3_y_s4_a_y_dup3_t1 r0 *1 0,0
Ra_n4_s3_y_s4_a_y_dup3_t1 a|n4|s3_y|s4_a|y__t14 a|n4|s3_y|s4_a|y$3 216.012838579
* device instance a_n4_s3_y_s4_a_y_dup3_t2 r0 *1 0,0
Ra_n4_s3_y_s4_a_y_dup3_t2 a|n4|s3_y|s4_a|y__t24 a|n4|s3_y|s4_a|y$3 216.012838579
* device instance a_n4_s3_y_s4_a_y_dup3_t3 r0 *1 0,0
Ra_n4_s3_y_s4_a_y_dup3_t3 a|n4|s3_y|s4_a|y__t34 a|n4|s3_y|s4_a|y$3 236.534411421
* device instance a_n4_s3_y_s4_a_y_dup3 r0 *1 0,0
Ca_n4_s3_y_s4_a_y_dup3 a|n4|s3_y|s4_a|y$3 vsubs 2.620771e-15
* device instance an_inva_y_mn34_g0_mp13_g1_y_t0 r0 *1 0,0
Ran_inva_y_mn34_g0_mp13_g1_y_t0 an|inva_y|mn34_g0|mp13_g1|y__t0
+ an|inva_y|mn34_g0|mp13_g1|y 286.425880004
* device instance an_inva_y_mn34_g0_mp13_g1_y_t1 r0 *1 0,0
Ran_inva_y_mn34_g0_mp13_g1_y_t1 an|inva_y|mn34_g0|mp13_g1|y__t1
+ an|inva_y|mn34_g0|mp13_g1|y 120.259350571
* device instance an_inva_y_mn34_g0_mp13_g1_y_t2 r0 *1 0,0
Ran_inva_y_mn34_g0_mp13_g1_y_t2 an|inva_y|mn34_g0|mp13_g1|y__t2
+ an|inva_y|mn34_g0|mp13_g1|y 148.815961258
* device instance an_inva_y_mn34_g0_mp13_g1_y_t3 r0 *1 0,0
Ran_inva_y_mn34_g0_mp13_g1_y_t3 an|inva_y|mn34_g0|mp13_g1|y__t3
+ an|inva_y|mn34_g0|mp13_g1|y 235.863908166
* device instance an_inva_y_mn34_g0_mp13_g1_y r0 *1 0,0
Can_inva_y_mn34_g0_mp13_g1_y an|inva_y|mn34_g0|mp13_g1|y vsubs 2.26736e-15
* device instance an_inva_y_mn34_g0_mp13_g1_y_dup1_t0 r0 *1 0,0
Ran_inva_y_mn34_g0_mp13_g1_y_dup1_t0 an|inva_y|mn34_g0|mp13_g1|y__t02
+ an|inva_y|mn34_g0|mp13_g1|y$1 286.425880004
* device instance an_inva_y_mn34_g0_mp13_g1_y_dup1_t1 r0 *1 0,0
Ran_inva_y_mn34_g0_mp13_g1_y_dup1_t1 an|inva_y|mn34_g0|mp13_g1|y__t12
+ an|inva_y|mn34_g0|mp13_g1|y$1 120.259350571
* device instance an_inva_y_mn34_g0_mp13_g1_y_dup1_t2 r0 *1 0,0
Ran_inva_y_mn34_g0_mp13_g1_y_dup1_t2 an|inva_y|mn34_g0|mp13_g1|y__t22
+ an|inva_y|mn34_g0|mp13_g1|y$1 148.815961258
* device instance an_inva_y_mn34_g0_mp13_g1_y_dup1_t3 r0 *1 0,0
Ran_inva_y_mn34_g0_mp13_g1_y_dup1_t3 an|inva_y|mn34_g0|mp13_g1|y__t32
+ an|inva_y|mn34_g0|mp13_g1|y$1 235.863908166
* device instance an_inva_y_mn34_g0_mp13_g1_y_dup1 r0 *1 0,0
Can_inva_y_mn34_g0_mp13_g1_y_dup1 an|inva_y|mn34_g0|mp13_g1|y$1 vsubs
+ 2.26736e-15
* device instance an_inva_y_mn34_g0_mp13_g1_y_dup2_t0 r0 *1 0,0
Ran_inva_y_mn34_g0_mp13_g1_y_dup2_t0 an|inva_y|mn34_g0|mp13_g1|y__t03
+ an|inva_y|mn34_g0|mp13_g1|y$2 286.425880004
* device instance an_inva_y_mn34_g0_mp13_g1_y_dup2_t1 r0 *1 0,0
Ran_inva_y_mn34_g0_mp13_g1_y_dup2_t1 an|inva_y|mn34_g0|mp13_g1|y__t13
+ an|inva_y|mn34_g0|mp13_g1|y$2 120.259350571
* device instance an_inva_y_mn34_g0_mp13_g1_y_dup2_t2 r0 *1 0,0
Ran_inva_y_mn34_g0_mp13_g1_y_dup2_t2 an|inva_y|mn34_g0|mp13_g1|y__t23
+ an|inva_y|mn34_g0|mp13_g1|y$2 148.815961258
* device instance an_inva_y_mn34_g0_mp13_g1_y_dup2_t3 r0 *1 0,0
Ran_inva_y_mn34_g0_mp13_g1_y_dup2_t3 an|inva_y|mn34_g0|mp13_g1|y__t33
+ an|inva_y|mn34_g0|mp13_g1|y$2 235.863908166
* device instance an_inva_y_mn34_g0_mp13_g1_y_dup2 r0 *1 0,0
Can_inva_y_mn34_g0_mp13_g1_y_dup2 an|inva_y|mn34_g0|mp13_g1|y$2 vsubs
+ 2.26736e-15
* device instance bn_invb_y_mn34_g1_mp24_g1_y_t0 r0 *1 0,0
Rbn_invb_y_mn34_g1_mp24_g1_y_t0 bn|invb_y|mn34_g1|mp24_g1|y__t0
+ bn|invb_y|mn34_g1|mp24_g1|y 185.302815577
* device instance bn_invb_y_mn34_g1_mp24_g1_y_t1 r0 *1 0,0
Rbn_invb_y_mn34_g1_mp24_g1_y_t1 bn|invb_y|mn34_g1|mp24_g1|y__t1
+ bn|invb_y|mn34_g1|mp24_g1|y 163.924646135
* device instance bn_invb_y_mn34_g1_mp24_g1_y_t2 r0 *1 0,0
Rbn_invb_y_mn34_g1_mp24_g1_y_t2 bn|invb_y|mn34_g1|mp24_g1|y__t2
+ bn|invb_y|mn34_g1|mp24_g1|y 173.955001003
* device instance bn_invb_y_mn34_g1_mp24_g1_y_t3 r0 *1 0,0
Rbn_invb_y_mn34_g1_mp24_g1_y_t3 bn|invb_y|mn34_g1|mp24_g1|y__t3
+ bn|invb_y|mn34_g1|mp24_g1|y 293.464337285
* device instance bn_invb_y_mn34_g1_mp24_g1_y r0 *1 0,0
Cbn_invb_y_mn34_g1_mp24_g1_y bn|invb_y|mn34_g1|mp24_g1|y vsubs 5.210018e-15
* device instance bn_invb_y_mn34_g1_mp24_g1_y_dup1_t0 r0 *1 0,0
Rbn_invb_y_mn34_g1_mp24_g1_y_dup1_t0 bn|invb_y|mn34_g1|mp24_g1|y__t02
+ bn|invb_y|mn34_g1|mp24_g1|y$1 185.302815577
* device instance bn_invb_y_mn34_g1_mp24_g1_y_dup1_t1 r0 *1 0,0
Rbn_invb_y_mn34_g1_mp24_g1_y_dup1_t1 bn|invb_y|mn34_g1|mp24_g1|y__t12
+ bn|invb_y|mn34_g1|mp24_g1|y$1 163.924646135
* device instance bn_invb_y_mn34_g1_mp24_g1_y_dup1_t2 r0 *1 0,0
Rbn_invb_y_mn34_g1_mp24_g1_y_dup1_t2 bn|invb_y|mn34_g1|mp24_g1|y__t22
+ bn|invb_y|mn34_g1|mp24_g1|y$1 173.955001003
* device instance bn_invb_y_mn34_g1_mp24_g1_y_dup1_t3 r0 *1 0,0
Rbn_invb_y_mn34_g1_mp24_g1_y_dup1_t3 bn|invb_y|mn34_g1|mp24_g1|y__t32
+ bn|invb_y|mn34_g1|mp24_g1|y$1 293.464337285
* device instance bn_invb_y_mn34_g1_mp24_g1_y_dup1 r0 *1 0,0
Cbn_invb_y_mn34_g1_mp24_g1_y_dup1 bn|invb_y|mn34_g1|mp24_g1|y$1 vsubs
+ 5.210763e-15
* device instance bn_invb_y_mn34_g1_mp24_g1_y_dup2_t0 r0 *1 0,0
Rbn_invb_y_mn34_g1_mp24_g1_y_dup2_t0 bn|invb_y|mn34_g1|mp24_g1|y__t03
+ bn|invb_y|mn34_g1|mp24_g1|y$2 185.302815577
* device instance bn_invb_y_mn34_g1_mp24_g1_y_dup2_t1 r0 *1 0,0
Rbn_invb_y_mn34_g1_mp24_g1_y_dup2_t1 bn|invb_y|mn34_g1|mp24_g1|y__t13
+ bn|invb_y|mn34_g1|mp24_g1|y$2 163.924646135
* device instance bn_invb_y_mn34_g1_mp24_g1_y_dup2_t2 r0 *1 0,0
Rbn_invb_y_mn34_g1_mp24_g1_y_dup2_t2 bn|invb_y|mn34_g1|mp24_g1|y__t23
+ bn|invb_y|mn34_g1|mp24_g1|y$2 173.955001003
* device instance bn_invb_y_mn34_g1_mp24_g1_y_dup2_t3 r0 *1 0,0
Rbn_invb_y_mn34_g1_mp24_g1_y_dup2_t3 bn|invb_y|mn34_g1|mp24_g1|y__t33
+ bn|invb_y|mn34_g1|mp24_g1|y$2 293.464337285
* device instance bn_invb_y_mn34_g1_mp24_g1_y_dup2 r0 *1 0,0
Cbn_invb_y_mn34_g1_mp24_g1_y_dup2 bn|invb_y|mn34_g1|mp24_g1|y$2 vsubs
+ 5.210763e-15
* device instance en_en1_g_en_t0 r0 *1 0,0
Ren_en1_g_en_t0 en|en1|g_en__t0 en|en1|g_en 259.452
* device instance en_en1_g_en_t1 r0 *1 0,0
Ren_en1_g_en_t1 en|en1|g_en__t1 en|en1|g_en 259.452
* device instance en_en1_g_en r0 *1 0,0
Cen_en1_g_en en|en1|g_en vsubs 7.37613e-16
* device instance en_en2_g_en_t0 r0 *1 0,0
Ren_en2_g_en_t0 en|en2|g_en__t0 en|en2|g_en 259.452
* device instance en_en2_g_en_t1 r0 *1 0,0
Ren_en2_g_en_t1 en|en2|g_en__t1 en|en2|g_en 259.452
* device instance en_en2_g_en r0 *1 0,0
Cen_en2_g_en en|en2|g_en vsubs 7.37613e-16
* device instance en_en3_g_en_t0 r0 *1 0,0
Ren_en3_g_en_t0 en|en3|g_en__t0 en|en3|g_en 259.452
* device instance en_en3_g_en_t1 r0 *1 0,0
Ren_en3_g_en_t1 en|en3|g_en__t1 en|en3|g_en 259.452
* device instance en_en3_g_en r0 *1 0,0
Cen_en3_g_en en|en3|g_en vsubs 7.37613e-16
* device instance en_en4_g_en_t0 r0 *1 0,0
Ren_en4_g_en_t0 en|en4|g_en__t0 en|en4|g_en 259.452
* device instance en_en4_g_en_t1 r0 *1 0,0
Ren_en4_g_en_t1 en|en4|g_en__t1 en|en4|g_en 259.452
* device instance en_en4_g_en r0 *1 0,0
Cen_en4_g_en en|en4|g_en vsubs 7.37613e-16
* device instance g_vddr_m1_mnt_g_s1_vddr_m1_s2_vddr_m1_s3_vddr_m1_s4_vddr_m1_vddr_vddr1_t0 r0 *1 0,0
Rg_vddr_m1_mnt_g_s1_vddr_m1_s2_vddr_m1_s3_vddr_m1_s4_vddr_m1_vddr_vddr1_t0
+ g_vddr_m1|mnt_g|s1_vddr_m1|s2_vddr_m1|s3_vddr_m1|s4_vddr_m1|vddr|vddr1__t0
+ g_vddr_m1|mnt_g|s1_vddr_m1|s2_vddr_m1|s3_vddr_m1|s4_vddr_m1|vddr|vddr1
+ 548.247137452
* device instance g_vddr_m1_mnt_g_s1_vddr_m1_s2_vddr_m1_s3_vddr_m1_s4_vddr_m1_vddr_vddr1_t1 r0 *1 0,0
Rg_vddr_m1_mnt_g_s1_vddr_m1_s2_vddr_m1_s3_vddr_m1_s4_vddr_m1_vddr_vddr1_t1
+ g_vddr_m1|mnt_g|s1_vddr_m1|s2_vddr_m1|s3_vddr_m1|s4_vddr_m1|vddr|vddr1__t1
+ g_vddr_m1|mnt_g|s1_vddr_m1|s2_vddr_m1|s3_vddr_m1|s4_vddr_m1|vddr|vddr1
+ 542.513498718
* device instance g_vddr_m1_mnt_g_s1_vddr_m1_s2_vddr_m1_s3_vddr_m1_s4_vddr_m1_vddr_vddr1_t2 r0 *1 0,0
Rg_vddr_m1_mnt_g_s1_vddr_m1_s2_vddr_m1_s3_vddr_m1_s4_vddr_m1_vddr_vddr1_t2
+ g_vddr_m1|mnt_g|s1_vddr_m1|s2_vddr_m1|s3_vddr_m1|s4_vddr_m1|vddr|vddr1__t2
+ g_vddr_m1|mnt_g|s1_vddr_m1|s2_vddr_m1|s3_vddr_m1|s4_vddr_m1|vddr|vddr1
+ 542.513498718
* device instance g_vddr_m1_mnt_g_s1_vddr_m1_s2_vddr_m1_s3_vddr_m1_s4_vddr_m1_vddr_vddr1_t3 r0 *1 0,0
Rg_vddr_m1_mnt_g_s1_vddr_m1_s2_vddr_m1_s3_vddr_m1_s4_vddr_m1_vddr_vddr1_t3
+ g_vddr_m1|mnt_g|s1_vddr_m1|s2_vddr_m1|s3_vddr_m1|s4_vddr_m1|vddr|vddr1__t3
+ g_vddr_m1|mnt_g|s1_vddr_m1|s2_vddr_m1|s3_vddr_m1|s4_vddr_m1|vddr|vddr1
+ 474.224411679
* device instance g_vddr_m1_mnt_g_s1_vddr_m1_s2_vddr_m1_s3_vddr_m1_s4_vddr_m1_vddr_vddr1_t4 r0 *1 0,0
Rg_vddr_m1_mnt_g_s1_vddr_m1_s2_vddr_m1_s3_vddr_m1_s4_vddr_m1_vddr_vddr1_t4
+ g_vddr_m1|mnt_g|s1_vddr_m1|s2_vddr_m1|s3_vddr_m1|s4_vddr_m1|vddr|vddr1__t4
+ g_vddr_m1|mnt_g|s1_vddr_m1|s2_vddr_m1|s3_vddr_m1|s4_vddr_m1|vddr|vddr1
+ 597.728866242
* device instance g_vddr_m1_mnt_g_s1_vddr_m1_s2_vddr_m1_s3_vddr_m1_s4_vddr_m1_vddr_vddr1_t5 r0 *1 0,0
Rg_vddr_m1_mnt_g_s1_vddr_m1_s2_vddr_m1_s3_vddr_m1_s4_vddr_m1_vddr_vddr1_t5
+ g_vddr_m1|mnt_g|s1_vddr_m1|s2_vddr_m1|s3_vddr_m1|s4_vddr_m1|vddr|vddr1__t5
+ g_vddr_m1|mnt_g|s1_vddr_m1|s2_vddr_m1|s3_vddr_m1|s4_vddr_m1|vddr|vddr1
+ 339.503132563
* device instance g_vddr_m1_mnt_g_s1_vddr_m1_s2_vddr_m1_s3_vddr_m1_s4_vddr_m1_vddr_vddr1_t6 r0 *1 0,0
Rg_vddr_m1_mnt_g_s1_vddr_m1_s2_vddr_m1_s3_vddr_m1_s4_vddr_m1_vddr_vddr1_t6
+ g_vddr_m1|mnt_g|s1_vddr_m1|s2_vddr_m1|s3_vddr_m1|s4_vddr_m1|vddr|vddr1__t6
+ g_vddr_m1|mnt_g|s1_vddr_m1|s2_vddr_m1|s3_vddr_m1|s4_vddr_m1|vddr|vddr1
+ 83.5568030932
* device instance g_vddr_m1_mnt_g_s1_vddr_m1_s2_vddr_m1_s3_vddr_m1_s4_vddr_m1_vddr_vddr1_t7 r0 *1 0,0
Rg_vddr_m1_mnt_g_s1_vddr_m1_s2_vddr_m1_s3_vddr_m1_s4_vddr_m1_vddr_vddr1_t7
+ g_vddr_m1|mnt_g|s1_vddr_m1|s2_vddr_m1|s3_vddr_m1|s4_vddr_m1|vddr|vddr1__t7
+ g_vddr_m1|mnt_g|s1_vddr_m1|s2_vddr_m1|s3_vddr_m1|s4_vddr_m1|vddr|vddr1
+ 180.105204003
* device instance g_vddr_m1_mnt_g_s1_vddr_m1_s2_vddr_m1_s3_vddr_m1_s4_vddr_m1_vddr_vddr1_t8 r0 *1 0,0
Rg_vddr_m1_mnt_g_s1_vddr_m1_s2_vddr_m1_s3_vddr_m1_s4_vddr_m1_vddr_vddr1_t8
+ g_vddr_m1|mnt_g|s1_vddr_m1|s2_vddr_m1|s3_vddr_m1|s4_vddr_m1|vddr|vddr1__t8
+ g_vddr_m1|mnt_g|s1_vddr_m1|s2_vddr_m1|s3_vddr_m1|s4_vddr_m1|vddr|vddr1
+ 433.56387233
* device instance g_vddr_m1_mnt_g_s1_vddr_m1_s2_vddr_m1_s3_vddr_m1_s4_vddr_m1_vddr_vddr1_t9 r0 *1 0,0
Rg_vddr_m1_mnt_g_s1_vddr_m1_s2_vddr_m1_s3_vddr_m1_s4_vddr_m1_vddr_vddr1_t9
+ g_vddr_m1|mnt_g|s1_vddr_m1|s2_vddr_m1|s3_vddr_m1|s4_vddr_m1|vddr|vddr1__t9
+ g_vddr_m1|mnt_g|s1_vddr_m1|s2_vddr_m1|s3_vddr_m1|s4_vddr_m1|vddr|vddr1
+ 529.307929685
* device instance g_vddr_m1_mnt_g_s1_vddr_m1_s2_vddr_m1_s3_vddr_m1_s4_vddr_m1_vddr_vddr1_t10 r0 *1 0,0
Rg_vddr_m1_mnt_g_s1_vddr_m1_s2_vddr_m1_s3_vddr_m1_s4_vddr_m1_vddr_vddr1_t10
+ g_vddr_m1|mnt_g|s1_vddr_m1|s2_vddr_m1|s3_vddr_m1|s4_vddr_m1|vddr|vddr1__t10
+ g_vddr_m1|mnt_g|s1_vddr_m1|s2_vddr_m1|s3_vddr_m1|s4_vddr_m1|vddr|vddr1
+ 271.232773475
* device instance g_vddr_m1_mnt_g_s1_vddr_m1_s2_vddr_m1_s3_vddr_m1_s4_vddr_m1_vddr_vddr1_t11 r0 *1 0,0
Rg_vddr_m1_mnt_g_s1_vddr_m1_s2_vddr_m1_s3_vddr_m1_s4_vddr_m1_vddr_vddr1_t11
+ g_vddr_m1|mnt_g|s1_vddr_m1|s2_vddr_m1|s3_vddr_m1|s4_vddr_m1|vddr|vddr1__t11
+ g_vddr_m1|mnt_g|s1_vddr_m1|s2_vddr_m1|s3_vddr_m1|s4_vddr_m1|vddr|vddr1
+ 248.149615946
* device instance g_vddr_m1_mnt_g_s1_vddr_m1_s2_vddr_m1_s3_vddr_m1_s4_vddr_m1_vddr_vddr1_t12 r0 *1 0,0
Rg_vddr_m1_mnt_g_s1_vddr_m1_s2_vddr_m1_s3_vddr_m1_s4_vddr_m1_vddr_vddr1_t12
+ g_vddr_m1|mnt_g|s1_vddr_m1|s2_vddr_m1|s3_vddr_m1|s4_vddr_m1|vddr|vddr1__t12
+ g_vddr_m1|mnt_g|s1_vddr_m1|s2_vddr_m1|s3_vddr_m1|s4_vddr_m1|vddr|vddr1
+ 26.5392771065
* device instance g_vddr_m1_mnt_g_s1_vddr_m1_s2_vddr_m1_s3_vddr_m1_s4_vddr_m1_vddr_vddr1_t13 r0 *1 0,0
Rg_vddr_m1_mnt_g_s1_vddr_m1_s2_vddr_m1_s3_vddr_m1_s4_vddr_m1_vddr_vddr1_t13
+ g_vddr_m1|mnt_g|s1_vddr_m1|s2_vddr_m1|s3_vddr_m1|s4_vddr_m1|vddr|vddr1__t13
+ g_vddr_m1|mnt_g|s1_vddr_m1|s2_vddr_m1|s3_vddr_m1|s4_vddr_m1|vddr|vddr1
+ 529.307929685
* device instance g_vddr_m1_mnt_g_s1_vddr_m1_s2_vddr_m1_s3_vddr_m1_s4_vddr_m1_vddr_vddr1_t14 r0 *1 0,0
Rg_vddr_m1_mnt_g_s1_vddr_m1_s2_vddr_m1_s3_vddr_m1_s4_vddr_m1_vddr_vddr1_t14
+ g_vddr_m1|mnt_g|s1_vddr_m1|s2_vddr_m1|s3_vddr_m1|s4_vddr_m1|vddr|vddr1__t14
+ g_vddr_m1|mnt_g|s1_vddr_m1|s2_vddr_m1|s3_vddr_m1|s4_vddr_m1|vddr|vddr1
+ 271.232773475
* device instance g_vddr_m1_mnt_g_s1_vddr_m1_s2_vddr_m1_s3_vddr_m1_s4_vddr_m1_vddr_vddr1_t15 r0 *1 0,0
Rg_vddr_m1_mnt_g_s1_vddr_m1_s2_vddr_m1_s3_vddr_m1_s4_vddr_m1_vddr_vddr1_t15
+ g_vddr_m1|mnt_g|s1_vddr_m1|s2_vddr_m1|s3_vddr_m1|s4_vddr_m1|vddr|vddr1__t15
+ g_vddr_m1|mnt_g|s1_vddr_m1|s2_vddr_m1|s3_vddr_m1|s4_vddr_m1|vddr|vddr1
+ 248.149615946
* device instance g_vddr_m1_mnt_g_s1_vddr_m1_s2_vddr_m1_s3_vddr_m1_s4_vddr_m1_vddr_vddr1_t16 r0 *1 0,0
Rg_vddr_m1_mnt_g_s1_vddr_m1_s2_vddr_m1_s3_vddr_m1_s4_vddr_m1_vddr_vddr1_t16
+ g_vddr_m1|mnt_g|s1_vddr_m1|s2_vddr_m1|s3_vddr_m1|s4_vddr_m1|vddr|vddr1__t16
+ g_vddr_m1|mnt_g|s1_vddr_m1|s2_vddr_m1|s3_vddr_m1|s4_vddr_m1|vddr|vddr1
+ 26.5392771065
* device instance g_vddr_m1_mnt_g_s1_vddr_m1_s2_vddr_m1_s3_vddr_m1_s4_vddr_m1_vddr_vddr1_t17 r0 *1 0,0
Rg_vddr_m1_mnt_g_s1_vddr_m1_s2_vddr_m1_s3_vddr_m1_s4_vddr_m1_vddr_vddr1_t17
+ g_vddr_m1|mnt_g|s1_vddr_m1|s2_vddr_m1|s3_vddr_m1|s4_vddr_m1|vddr|vddr1__t17
+ g_vddr_m1|mnt_g|s1_vddr_m1|s2_vddr_m1|s3_vddr_m1|s4_vddr_m1|vddr|vddr1
+ 262.134590134
* device instance g_vddr_m1_mnt_g_s1_vddr_m1_s2_vddr_m1_s3_vddr_m1_s4_vddr_m1_vddr_vddr1_t18 r0 *1 0,0
Rg_vddr_m1_mnt_g_s1_vddr_m1_s2_vddr_m1_s3_vddr_m1_s4_vddr_m1_vddr_vddr1_t18
+ g_vddr_m1|mnt_g|s1_vddr_m1|s2_vddr_m1|s3_vddr_m1|s4_vddr_m1|vddr|vddr1__t18
+ g_vddr_m1|mnt_g|s1_vddr_m1|s2_vddr_m1|s3_vddr_m1|s4_vddr_m1|vddr|vddr1
+ 88.5474148697
* device instance g_vddr_m1_mnt_g_s1_vddr_m1_s2_vddr_m1_s3_vddr_m1_s4_vddr_m1_vddr_vddr1_t19 r0 *1 0,0
Rg_vddr_m1_mnt_g_s1_vddr_m1_s2_vddr_m1_s3_vddr_m1_s4_vddr_m1_vddr_vddr1_t19
+ g_vddr_m1|mnt_g|s1_vddr_m1|s2_vddr_m1|s3_vddr_m1|s4_vddr_m1|vddr|vddr1__t19
+ g_vddr_m1|mnt_g|s1_vddr_m1|s2_vddr_m1|s3_vddr_m1|s4_vddr_m1|vddr|vddr1
+ 536.006712531
* device instance g_vddr_m1_mnt_g_s1_vddr_m1_s2_vddr_m1_s3_vddr_m1_s4_vddr_m1_vddr_vddr1_t20 r0 *1 0,0
Rg_vddr_m1_mnt_g_s1_vddr_m1_s2_vddr_m1_s3_vddr_m1_s4_vddr_m1_vddr_vddr1_t20
+ g_vddr_m1|mnt_g|s1_vddr_m1|s2_vddr_m1|s3_vddr_m1|s4_vddr_m1|vddr|vddr1__t20
+ g_vddr_m1|mnt_g|s1_vddr_m1|s2_vddr_m1|s3_vddr_m1|s4_vddr_m1|vddr|vddr1
+ 284.083665243
* device instance g_vddr_m1_mnt_g_s1_vddr_m1_s2_vddr_m1_s3_vddr_m1_s4_vddr_m1_vddr_vddr1 r0 *1 0,0
Cg_vddr_m1_mnt_g_s1_vddr_m1_s2_vddr_m1_s3_vddr_m1_s4_vddr_m1_vddr_vddr1
+ g_vddr_m1|mnt_g|s1_vddr_m1|s2_vddr_m1|s3_vddr_m1|s4_vddr_m1|vddr|vddr1 vsubs
+ 1.4767873e-14
* device instance g_vddr_m1_mnt_g_s1_vddr_m1_s2_vddr_m1_s3_vddr_m1_s4_vddr_m1_vddr_vddr2_t0 r0 *1 0,0
Rg_vddr_m1_mnt_g_s1_vddr_m1_s2_vddr_m1_s3_vddr_m1_s4_vddr_m1_vddr_vddr2_t0
+ g_vddr_m1|mnt_g|s1_vddr_m1|s2_vddr_m1|s3_vddr_m1|s4_vddr_m1|vddr|vddr2__t0
+ g_vddr_m1|mnt_g|s1_vddr_m1|s2_vddr_m1|s3_vddr_m1|s4_vddr_m1|vddr|vddr2
+ 548.481147289
* device instance g_vddr_m1_mnt_g_s1_vddr_m1_s2_vddr_m1_s3_vddr_m1_s4_vddr_m1_vddr_vddr2_t1 r0 *1 0,0
Rg_vddr_m1_mnt_g_s1_vddr_m1_s2_vddr_m1_s3_vddr_m1_s4_vddr_m1_vddr_vddr2_t1
+ g_vddr_m1|mnt_g|s1_vddr_m1|s2_vddr_m1|s3_vddr_m1|s4_vddr_m1|vddr|vddr2__t1
+ g_vddr_m1|mnt_g|s1_vddr_m1|s2_vddr_m1|s3_vddr_m1|s4_vddr_m1|vddr|vddr2
+ 542.74506125
* device instance g_vddr_m1_mnt_g_s1_vddr_m1_s2_vddr_m1_s3_vddr_m1_s4_vddr_m1_vddr_vddr2_t2 r0 *1 0,0
Rg_vddr_m1_mnt_g_s1_vddr_m1_s2_vddr_m1_s3_vddr_m1_s4_vddr_m1_vddr_vddr2_t2
+ g_vddr_m1|mnt_g|s1_vddr_m1|s2_vddr_m1|s3_vddr_m1|s4_vddr_m1|vddr|vddr2__t2
+ g_vddr_m1|mnt_g|s1_vddr_m1|s2_vddr_m1|s3_vddr_m1|s4_vddr_m1|vddr|vddr2
+ 542.74506125
* device instance g_vddr_m1_mnt_g_s1_vddr_m1_s2_vddr_m1_s3_vddr_m1_s4_vddr_m1_vddr_vddr2_t3 r0 *1 0,0
Rg_vddr_m1_mnt_g_s1_vddr_m1_s2_vddr_m1_s3_vddr_m1_s4_vddr_m1_vddr_vddr2_t3
+ g_vddr_m1|mnt_g|s1_vddr_m1|s2_vddr_m1|s3_vddr_m1|s4_vddr_m1|vddr|vddr2__t3
+ g_vddr_m1|mnt_g|s1_vddr_m1|s2_vddr_m1|s3_vddr_m1|s4_vddr_m1|vddr|vddr2
+ 26.5506049392
* device instance g_vddr_m1_mnt_g_s1_vddr_m1_s2_vddr_m1_s3_vddr_m1_s4_vddr_m1_vddr_vddr2_t4 r0 *1 0,0
Rg_vddr_m1_mnt_g_s1_vddr_m1_s2_vddr_m1_s3_vddr_m1_s4_vddr_m1_vddr_vddr2_t4
+ g_vddr_m1|mnt_g|s1_vddr_m1|s2_vddr_m1|s3_vddr_m1|s4_vddr_m1|vddr|vddr2__t4
+ g_vddr_m1|mnt_g|s1_vddr_m1|s2_vddr_m1|s3_vddr_m1|s4_vddr_m1|vddr|vddr2
+ 271.348544507
* device instance g_vddr_m1_mnt_g_s1_vddr_m1_s2_vddr_m1_s3_vddr_m1_s4_vddr_m1_vddr_vddr2_t5 r0 *1 0,0
Rg_vddr_m1_mnt_g_s1_vddr_m1_s2_vddr_m1_s3_vddr_m1_s4_vddr_m1_vddr_vddr2_t5
+ g_vddr_m1|mnt_g|s1_vddr_m1|s2_vddr_m1|s3_vddr_m1|s4_vddr_m1|vddr|vddr2__t5
+ g_vddr_m1|mnt_g|s1_vddr_m1|s2_vddr_m1|s3_vddr_m1|s4_vddr_m1|vddr|vddr2
+ 529.533855647
* device instance g_vddr_m1_mnt_g_s1_vddr_m1_s2_vddr_m1_s3_vddr_m1_s4_vddr_m1_vddr_vddr2_t6 r0 *1 0,0
Rg_vddr_m1_mnt_g_s1_vddr_m1_s2_vddr_m1_s3_vddr_m1_s4_vddr_m1_vddr_vddr2_t6
+ g_vddr_m1|mnt_g|s1_vddr_m1|s2_vddr_m1|s3_vddr_m1|s4_vddr_m1|vddr|vddr2__t6
+ g_vddr_m1|mnt_g|s1_vddr_m1|s2_vddr_m1|s3_vddr_m1|s4_vddr_m1|vddr|vddr2
+ 248.25553433
* device instance g_vddr_m1_mnt_g_s1_vddr_m1_s2_vddr_m1_s3_vddr_m1_s4_vddr_m1_vddr_vddr2_t7 r0 *1 0,0
Rg_vddr_m1_mnt_g_s1_vddr_m1_s2_vddr_m1_s3_vddr_m1_s4_vddr_m1_vddr_vddr2_t7
+ g_vddr_m1|mnt_g|s1_vddr_m1|s2_vddr_m1|s3_vddr_m1|s4_vddr_m1|vddr|vddr2__t7
+ g_vddr_m1|mnt_g|s1_vddr_m1|s2_vddr_m1|s3_vddr_m1|s4_vddr_m1|vddr|vddr2
+ 26.5506049392
* device instance g_vddr_m1_mnt_g_s1_vddr_m1_s2_vddr_m1_s3_vddr_m1_s4_vddr_m1_vddr_vddr2_t8 r0 *1 0,0
Rg_vddr_m1_mnt_g_s1_vddr_m1_s2_vddr_m1_s3_vddr_m1_s4_vddr_m1_vddr_vddr2_t8
+ g_vddr_m1|mnt_g|s1_vddr_m1|s2_vddr_m1|s3_vddr_m1|s4_vddr_m1|vddr|vddr2__t8
+ g_vddr_m1|mnt_g|s1_vddr_m1|s2_vddr_m1|s3_vddr_m1|s4_vddr_m1|vddr|vddr2
+ 271.348544507
* device instance g_vddr_m1_mnt_g_s1_vddr_m1_s2_vddr_m1_s3_vddr_m1_s4_vddr_m1_vddr_vddr2_t9 r0 *1 0,0
Rg_vddr_m1_mnt_g_s1_vddr_m1_s2_vddr_m1_s3_vddr_m1_s4_vddr_m1_vddr_vddr2_t9
+ g_vddr_m1|mnt_g|s1_vddr_m1|s2_vddr_m1|s3_vddr_m1|s4_vddr_m1|vddr|vddr2__t9
+ g_vddr_m1|mnt_g|s1_vddr_m1|s2_vddr_m1|s3_vddr_m1|s4_vddr_m1|vddr|vddr2
+ 529.533855647
* device instance g_vddr_m1_mnt_g_s1_vddr_m1_s2_vddr_m1_s3_vddr_m1_s4_vddr_m1_vddr_vddr2_t10 r0 *1 0,0
Rg_vddr_m1_mnt_g_s1_vddr_m1_s2_vddr_m1_s3_vddr_m1_s4_vddr_m1_vddr_vddr2_t10
+ g_vddr_m1|mnt_g|s1_vddr_m1|s2_vddr_m1|s3_vddr_m1|s4_vddr_m1|vddr|vddr2__t10
+ g_vddr_m1|mnt_g|s1_vddr_m1|s2_vddr_m1|s3_vddr_m1|s4_vddr_m1|vddr|vddr2
+ 248.25553433
* device instance g_vddr_m1_mnt_g_s1_vddr_m1_s2_vddr_m1_s3_vddr_m1_s4_vddr_m1_vddr_vddr2_t11 r0 *1 0,0
Rg_vddr_m1_mnt_g_s1_vddr_m1_s2_vddr_m1_s3_vddr_m1_s4_vddr_m1_vddr_vddr2_t11
+ g_vddr_m1|mnt_g|s1_vddr_m1|s2_vddr_m1|s3_vddr_m1|s4_vddr_m1|vddr|vddr2__t11
+ g_vddr_m1|mnt_g|s1_vddr_m1|s2_vddr_m1|s3_vddr_m1|s4_vddr_m1|vddr|vddr2
+ 597.983996501
* device instance g_vddr_m1_mnt_g_s1_vddr_m1_s2_vddr_m1_s3_vddr_m1_s4_vddr_m1_vddr_vddr2_t12 r0 *1 0,0
Rg_vddr_m1_mnt_g_s1_vddr_m1_s2_vddr_m1_s3_vddr_m1_s4_vddr_m1_vddr_vddr2_t12
+ g_vddr_m1|mnt_g|s1_vddr_m1|s2_vddr_m1|s3_vddr_m1|s4_vddr_m1|vddr|vddr2__t12
+ g_vddr_m1|mnt_g|s1_vddr_m1|s2_vddr_m1|s3_vddr_m1|s4_vddr_m1|vddr|vddr2
+ 339.64804362
* device instance g_vddr_m1_mnt_g_s1_vddr_m1_s2_vddr_m1_s3_vddr_m1_s4_vddr_m1_vddr_vddr2_t13 r0 *1 0,0
Rg_vddr_m1_mnt_g_s1_vddr_m1_s2_vddr_m1_s3_vddr_m1_s4_vddr_m1_vddr_vddr2_t13
+ g_vddr_m1|mnt_g|s1_vddr_m1|s2_vddr_m1|s3_vddr_m1|s4_vddr_m1|vddr|vddr2__t13
+ g_vddr_m1|mnt_g|s1_vddr_m1|s2_vddr_m1|s3_vddr_m1|s4_vddr_m1|vddr|vddr2
+ 83.5924678737
* device instance g_vddr_m1_mnt_g_s1_vddr_m1_s2_vddr_m1_s3_vddr_m1_s4_vddr_m1_vddr_vddr2_t14 r0 *1 0,0
Rg_vddr_m1_mnt_g_s1_vddr_m1_s2_vddr_m1_s3_vddr_m1_s4_vddr_m1_vddr_vddr2_t14
+ g_vddr_m1|mnt_g|s1_vddr_m1|s2_vddr_m1|s3_vddr_m1|s4_vddr_m1|vddr|vddr2__t14
+ g_vddr_m1|mnt_g|s1_vddr_m1|s2_vddr_m1|s3_vddr_m1|s4_vddr_m1|vddr|vddr2
+ 180.182078803
* device instance g_vddr_m1_mnt_g_s1_vddr_m1_s2_vddr_m1_s3_vddr_m1_s4_vddr_m1_vddr_vddr2_t15 r0 *1 0,0
Rg_vddr_m1_mnt_g_s1_vddr_m1_s2_vddr_m1_s3_vddr_m1_s4_vddr_m1_vddr_vddr2_t15
+ g_vddr_m1|mnt_g|s1_vddr_m1|s2_vddr_m1|s3_vddr_m1|s4_vddr_m1|vddr|vddr2__t15
+ g_vddr_m1|mnt_g|s1_vddr_m1|s2_vddr_m1|s3_vddr_m1|s4_vddr_m1|vddr|vddr2
+ 433.748931592
* device instance g_vddr_m1_mnt_g_s1_vddr_m1_s2_vddr_m1_s3_vddr_m1_s4_vddr_m1_vddr_vddr2_t16 r0 *1 0,0
Rg_vddr_m1_mnt_g_s1_vddr_m1_s2_vddr_m1_s3_vddr_m1_s4_vddr_m1_vddr_vddr2_t16
+ g_vddr_m1|mnt_g|s1_vddr_m1|s2_vddr_m1|s3_vddr_m1|s4_vddr_m1|vddr|vddr2__t16
+ g_vddr_m1|mnt_g|s1_vddr_m1|s2_vddr_m1|s3_vddr_m1|s4_vddr_m1|vddr|vddr2
+ 474.426826191
* device instance g_vddr_m1_mnt_g_s1_vddr_m1_s2_vddr_m1_s3_vddr_m1_s4_vddr_m1_vddr_vddr2_t17 r0 *1 0,0
Rg_vddr_m1_mnt_g_s1_vddr_m1_s2_vddr_m1_s3_vddr_m1_s4_vddr_m1_vddr_vddr2_t17
+ g_vddr_m1|mnt_g|s1_vddr_m1|s2_vddr_m1|s3_vddr_m1|s4_vddr_m1|vddr|vddr2__t17
+ g_vddr_m1|mnt_g|s1_vddr_m1|s2_vddr_m1|s3_vddr_m1|s4_vddr_m1|vddr|vddr2
+ 536.235497753
* device instance g_vddr_m1_mnt_g_s1_vddr_m1_s2_vddr_m1_s3_vddr_m1_s4_vddr_m1_vddr_vddr2_t18 r0 *1 0,0
Rg_vddr_m1_mnt_g_s1_vddr_m1_s2_vddr_m1_s3_vddr_m1_s4_vddr_m1_vddr_vddr2_t18
+ g_vddr_m1|mnt_g|s1_vddr_m1|s2_vddr_m1|s3_vddr_m1|s4_vddr_m1|vddr|vddr2__t18
+ g_vddr_m1|mnt_g|s1_vddr_m1|s2_vddr_m1|s3_vddr_m1|s4_vddr_m1|vddr|vddr2
+ 88.5852098068
* device instance g_vddr_m1_mnt_g_s1_vddr_m1_s2_vddr_m1_s3_vddr_m1_s4_vddr_m1_vddr_vddr2_t19 r0 *1 0,0
Rg_vddr_m1_mnt_g_s1_vddr_m1_s2_vddr_m1_s3_vddr_m1_s4_vddr_m1_vddr_vddr2_t19
+ g_vddr_m1|mnt_g|s1_vddr_m1|s2_vddr_m1|s3_vddr_m1|s4_vddr_m1|vddr|vddr2__t19
+ g_vddr_m1|mnt_g|s1_vddr_m1|s2_vddr_m1|s3_vddr_m1|s4_vddr_m1|vddr|vddr2
+ 284.204921457
* device instance g_vddr_m1_mnt_g_s1_vddr_m1_s2_vddr_m1_s3_vddr_m1_s4_vddr_m1_vddr_vddr2_t20 r0 *1 0,0
Rg_vddr_m1_mnt_g_s1_vddr_m1_s2_vddr_m1_s3_vddr_m1_s4_vddr_m1_vddr_vddr2_t20
+ g_vddr_m1|mnt_g|s1_vddr_m1|s2_vddr_m1|s3_vddr_m1|s4_vddr_m1|vddr|vddr2__t20
+ g_vddr_m1|mnt_g|s1_vddr_m1|s2_vddr_m1|s3_vddr_m1|s4_vddr_m1|vddr|vddr2
+ 262.246477764
* device instance g_vddr_m1_mnt_g_s1_vddr_m1_s2_vddr_m1_s3_vddr_m1_s4_vddr_m1_vddr_vddr2 r0 *1 0,0
Cg_vddr_m1_mnt_g_s1_vddr_m1_s2_vddr_m1_s3_vddr_m1_s4_vddr_m1_vddr_vddr2
+ g_vddr_m1|mnt_g|s1_vddr_m1|s2_vddr_m1|s3_vddr_m1|s4_vddr_m1|vddr|vddr2 vsubs
+ 1.4773157e-14
* device instance g_vddr_m1_mnt_g_s1_vddr_m1_s2_vddr_m1_s3_vddr_m1_s4_vddr_m1_vddr_vddr3_t0 r0 *1 0,0
Rg_vddr_m1_mnt_g_s1_vddr_m1_s2_vddr_m1_s3_vddr_m1_s4_vddr_m1_vddr_vddr3_t0
+ g_vddr_m1|mnt_g|s1_vddr_m1|s2_vddr_m1|s3_vddr_m1|s4_vddr_m1|vddr|vddr3__t0
+ g_vddr_m1|mnt_g|s1_vddr_m1|s2_vddr_m1|s3_vddr_m1|s4_vddr_m1|vddr|vddr3
+ 548.715164888
* device instance g_vddr_m1_mnt_g_s1_vddr_m1_s2_vddr_m1_s3_vddr_m1_s4_vddr_m1_vddr_vddr3_t1 r0 *1 0,0
Rg_vddr_m1_mnt_g_s1_vddr_m1_s2_vddr_m1_s3_vddr_m1_s4_vddr_m1_vddr_vddr3_t1
+ g_vddr_m1|mnt_g|s1_vddr_m1|s2_vddr_m1|s3_vddr_m1|s4_vddr_m1|vddr|vddr3__t1
+ g_vddr_m1|mnt_g|s1_vddr_m1|s2_vddr_m1|s3_vddr_m1|s4_vddr_m1|vddr|vddr3
+ 542.976631462
* device instance g_vddr_m1_mnt_g_s1_vddr_m1_s2_vddr_m1_s3_vddr_m1_s4_vddr_m1_vddr_vddr3_t2 r0 *1 0,0
Rg_vddr_m1_mnt_g_s1_vddr_m1_s2_vddr_m1_s3_vddr_m1_s4_vddr_m1_vddr_vddr3_t2
+ g_vddr_m1|mnt_g|s1_vddr_m1|s2_vddr_m1|s3_vddr_m1|s4_vddr_m1|vddr|vddr3__t2
+ g_vddr_m1|mnt_g|s1_vddr_m1|s2_vddr_m1|s3_vddr_m1|s4_vddr_m1|vddr|vddr3
+ 542.976631462
* device instance g_vddr_m1_mnt_g_s1_vddr_m1_s2_vddr_m1_s3_vddr_m1_s4_vddr_m1_vddr_vddr3_t3 r0 *1 0,0
Rg_vddr_m1_mnt_g_s1_vddr_m1_s2_vddr_m1_s3_vddr_m1_s4_vddr_m1_vddr_vddr3_t3
+ g_vddr_m1|mnt_g|s1_vddr_m1|s2_vddr_m1|s3_vddr_m1|s4_vddr_m1|vddr|vddr3__t3
+ g_vddr_m1|mnt_g|s1_vddr_m1|s2_vddr_m1|s3_vddr_m1|s4_vddr_m1|vddr|vddr3
+ 529.759789104
* device instance g_vddr_m1_mnt_g_s1_vddr_m1_s2_vddr_m1_s3_vddr_m1_s4_vddr_m1_vddr_vddr3_t4 r0 *1 0,0
Rg_vddr_m1_mnt_g_s1_vddr_m1_s2_vddr_m1_s3_vddr_m1_s4_vddr_m1_vddr_vddr3_t4
+ g_vddr_m1|mnt_g|s1_vddr_m1|s2_vddr_m1|s3_vddr_m1|s4_vddr_m1|vddr|vddr3__t4
+ g_vddr_m1|mnt_g|s1_vddr_m1|s2_vddr_m1|s3_vddr_m1|s4_vddr_m1|vddr|vddr3
+ 271.46431938
* device instance g_vddr_m1_mnt_g_s1_vddr_m1_s2_vddr_m1_s3_vddr_m1_s4_vddr_m1_vddr_vddr3_t5 r0 *1 0,0
Rg_vddr_m1_mnt_g_s1_vddr_m1_s2_vddr_m1_s3_vddr_m1_s4_vddr_m1_vddr_vddr3_t5
+ g_vddr_m1|mnt_g|s1_vddr_m1|s2_vddr_m1|s3_vddr_m1|s4_vddr_m1|vddr|vddr3__t5
+ g_vddr_m1|mnt_g|s1_vddr_m1|s2_vddr_m1|s3_vddr_m1|s4_vddr_m1|vddr|vddr3
+ 248.361456228
* device instance g_vddr_m1_mnt_g_s1_vddr_m1_s2_vddr_m1_s3_vddr_m1_s4_vddr_m1_vddr_vddr3_t6 r0 *1 0,0
Rg_vddr_m1_mnt_g_s1_vddr_m1_s2_vddr_m1_s3_vddr_m1_s4_vddr_m1_vddr_vddr3_t6
+ g_vddr_m1|mnt_g|s1_vddr_m1|s2_vddr_m1|s3_vddr_m1|s4_vddr_m1|vddr|vddr3__t6
+ g_vddr_m1|mnt_g|s1_vddr_m1|s2_vddr_m1|s3_vddr_m1|s4_vddr_m1|vddr|vddr3
+ 26.5619331478
* device instance g_vddr_m1_mnt_g_s1_vddr_m1_s2_vddr_m1_s3_vddr_m1_s4_vddr_m1_vddr_vddr3_t7 r0 *1 0,0
Rg_vddr_m1_mnt_g_s1_vddr_m1_s2_vddr_m1_s3_vddr_m1_s4_vddr_m1_vddr_vddr3_t7
+ g_vddr_m1|mnt_g|s1_vddr_m1|s2_vddr_m1|s3_vddr_m1|s4_vddr_m1|vddr|vddr3__t7
+ g_vddr_m1|mnt_g|s1_vddr_m1|s2_vddr_m1|s3_vddr_m1|s4_vddr_m1|vddr|vddr3
+ 529.759789104
* device instance g_vddr_m1_mnt_g_s1_vddr_m1_s2_vddr_m1_s3_vddr_m1_s4_vddr_m1_vddr_vddr3_t8 r0 *1 0,0
Rg_vddr_m1_mnt_g_s1_vddr_m1_s2_vddr_m1_s3_vddr_m1_s4_vddr_m1_vddr_vddr3_t8
+ g_vddr_m1|mnt_g|s1_vddr_m1|s2_vddr_m1|s3_vddr_m1|s4_vddr_m1|vddr|vddr3__t8
+ g_vddr_m1|mnt_g|s1_vddr_m1|s2_vddr_m1|s3_vddr_m1|s4_vddr_m1|vddr|vddr3
+ 271.46431938
* device instance g_vddr_m1_mnt_g_s1_vddr_m1_s2_vddr_m1_s3_vddr_m1_s4_vddr_m1_vddr_vddr3_t9 r0 *1 0,0
Rg_vddr_m1_mnt_g_s1_vddr_m1_s2_vddr_m1_s3_vddr_m1_s4_vddr_m1_vddr_vddr3_t9
+ g_vddr_m1|mnt_g|s1_vddr_m1|s2_vddr_m1|s3_vddr_m1|s4_vddr_m1|vddr|vddr3__t9
+ g_vddr_m1|mnt_g|s1_vddr_m1|s2_vddr_m1|s3_vddr_m1|s4_vddr_m1|vddr|vddr3
+ 248.361456228
* device instance g_vddr_m1_mnt_g_s1_vddr_m1_s2_vddr_m1_s3_vddr_m1_s4_vddr_m1_vddr_vddr3_t10 r0 *1 0,0
Rg_vddr_m1_mnt_g_s1_vddr_m1_s2_vddr_m1_s3_vddr_m1_s4_vddr_m1_vddr_vddr3_t10
+ g_vddr_m1|mnt_g|s1_vddr_m1|s2_vddr_m1|s3_vddr_m1|s4_vddr_m1|vddr|vddr3__t10
+ g_vddr_m1|mnt_g|s1_vddr_m1|s2_vddr_m1|s3_vddr_m1|s4_vddr_m1|vddr|vddr3
+ 26.5619331478
* device instance g_vddr_m1_mnt_g_s1_vddr_m1_s2_vddr_m1_s3_vddr_m1_s4_vddr_m1_vddr_vddr3_t11 r0 *1 0,0
Rg_vddr_m1_mnt_g_s1_vddr_m1_s2_vddr_m1_s3_vddr_m1_s4_vddr_m1_vddr_vddr3_t11
+ g_vddr_m1|mnt_g|s1_vddr_m1|s2_vddr_m1|s3_vddr_m1|s4_vddr_m1|vddr|vddr3__t11
+ g_vddr_m1|mnt_g|s1_vddr_m1|s2_vddr_m1|s3_vddr_m1|s4_vddr_m1|vddr|vddr3
+ 339.792959485
* device instance g_vddr_m1_mnt_g_s1_vddr_m1_s2_vddr_m1_s3_vddr_m1_s4_vddr_m1_vddr_vddr3_t12 r0 *1 0,0
Rg_vddr_m1_mnt_g_s1_vddr_m1_s2_vddr_m1_s3_vddr_m1_s4_vddr_m1_vddr_vddr3_t12
+ g_vddr_m1|mnt_g|s1_vddr_m1|s2_vddr_m1|s3_vddr_m1|s4_vddr_m1|vddr|vddr3__t12
+ g_vddr_m1|mnt_g|s1_vddr_m1|s2_vddr_m1|s3_vddr_m1|s4_vddr_m1|vddr|vddr3
+ 598.239135223
* device instance g_vddr_m1_mnt_g_s1_vddr_m1_s2_vddr_m1_s3_vddr_m1_s4_vddr_m1_vddr_vddr3_t13 r0 *1 0,0
Rg_vddr_m1_mnt_g_s1_vddr_m1_s2_vddr_m1_s3_vddr_m1_s4_vddr_m1_vddr_vddr3_t13
+ g_vddr_m1|mnt_g|s1_vddr_m1|s2_vddr_m1|s3_vddr_m1|s4_vddr_m1|vddr|vddr3__t13
+ g_vddr_m1|mnt_g|s1_vddr_m1|s2_vddr_m1|s3_vddr_m1|s4_vddr_m1|vddr|vddr3
+ 433.933996993
* device instance g_vddr_m1_mnt_g_s1_vddr_m1_s2_vddr_m1_s3_vddr_m1_s4_vddr_m1_vddr_vddr3_t14 r0 *1 0,0
Rg_vddr_m1_mnt_g_s1_vddr_m1_s2_vddr_m1_s3_vddr_m1_s4_vddr_m1_vddr_vddr3_t14
+ g_vddr_m1|mnt_g|s1_vddr_m1|s2_vddr_m1|s3_vddr_m1|s4_vddr_m1|vddr|vddr3__t14
+ g_vddr_m1|mnt_g|s1_vddr_m1|s2_vddr_m1|s3_vddr_m1|s4_vddr_m1|vddr|vddr3
+ 180.258956154
* device instance g_vddr_m1_mnt_g_s1_vddr_m1_s2_vddr_m1_s3_vddr_m1_s4_vddr_m1_vddr_vddr3_t15 r0 *1 0,0
Rg_vddr_m1_mnt_g_s1_vddr_m1_s2_vddr_m1_s3_vddr_m1_s4_vddr_m1_vddr_vddr3_t15
+ g_vddr_m1|mnt_g|s1_vddr_m1|s2_vddr_m1|s3_vddr_m1|s4_vddr_m1|vddr|vddr3__t15
+ g_vddr_m1|mnt_g|s1_vddr_m1|s2_vddr_m1|s3_vddr_m1|s4_vddr_m1|vddr|vddr3
+ 83.6281338372
* device instance g_vddr_m1_mnt_g_s1_vddr_m1_s2_vddr_m1_s3_vddr_m1_s4_vddr_m1_vddr_vddr3_t16 r0 *1 0,0
Rg_vddr_m1_mnt_g_s1_vddr_m1_s2_vddr_m1_s3_vddr_m1_s4_vddr_m1_vddr_vddr3_t16
+ g_vddr_m1|mnt_g|s1_vddr_m1|s2_vddr_m1|s3_vddr_m1|s4_vddr_m1|vddr|vddr3__t16
+ g_vddr_m1|mnt_g|s1_vddr_m1|s2_vddr_m1|s3_vddr_m1|s4_vddr_m1|vddr|vddr3
+ 474.629247418
* device instance g_vddr_m1_mnt_g_s1_vddr_m1_s2_vddr_m1_s3_vddr_m1_s4_vddr_m1_vddr_vddr3_t17 r0 *1 0,0
Rg_vddr_m1_mnt_g_s1_vddr_m1_s2_vddr_m1_s3_vddr_m1_s4_vddr_m1_vddr_vddr3_t17
+ g_vddr_m1|mnt_g|s1_vddr_m1|s2_vddr_m1|s3_vddr_m1|s4_vddr_m1|vddr|vddr3__t17
+ g_vddr_m1|mnt_g|s1_vddr_m1|s2_vddr_m1|s3_vddr_m1|s4_vddr_m1|vddr|vddr3
+ 88.6230059976
* device instance g_vddr_m1_mnt_g_s1_vddr_m1_s2_vddr_m1_s3_vddr_m1_s4_vddr_m1_vddr_vddr3_t18 r0 *1 0,0
Rg_vddr_m1_mnt_g_s1_vddr_m1_s2_vddr_m1_s3_vddr_m1_s4_vddr_m1_vddr_vddr3_t18
+ g_vddr_m1|mnt_g|s1_vddr_m1|s2_vddr_m1|s3_vddr_m1|s4_vddr_m1|vddr|vddr3__t18
+ g_vddr_m1|mnt_g|s1_vddr_m1|s2_vddr_m1|s3_vddr_m1|s4_vddr_m1|vddr|vddr3
+ 284.326181692
* device instance g_vddr_m1_mnt_g_s1_vddr_m1_s2_vddr_m1_s3_vddr_m1_s4_vddr_m1_vddr_vddr3_t19 r0 *1 0,0
Rg_vddr_m1_mnt_g_s1_vddr_m1_s2_vddr_m1_s3_vddr_m1_s4_vddr_m1_vddr_vddr3_t19
+ g_vddr_m1|mnt_g|s1_vddr_m1|s2_vddr_m1|s3_vddr_m1|s4_vddr_m1|vddr|vddr3__t19
+ g_vddr_m1|mnt_g|s1_vddr_m1|s2_vddr_m1|s3_vddr_m1|s4_vddr_m1|vddr|vddr3
+ 536.464290564
* device instance g_vddr_m1_mnt_g_s1_vddr_m1_s2_vddr_m1_s3_vddr_m1_s4_vddr_m1_vddr_vddr3_t20 r0 *1 0,0
Rg_vddr_m1_mnt_g_s1_vddr_m1_s2_vddr_m1_s3_vddr_m1_s4_vddr_m1_vddr_vddr3_t20
+ g_vddr_m1|mnt_g|s1_vddr_m1|s2_vddr_m1|s3_vddr_m1|s4_vddr_m1|vddr|vddr3__t20
+ g_vddr_m1|mnt_g|s1_vddr_m1|s2_vddr_m1|s3_vddr_m1|s4_vddr_m1|vddr|vddr3
+ 262.358369105
* device instance g_vddr_m1_mnt_g_s1_vddr_m1_s2_vddr_m1_s3_vddr_m1_s4_vddr_m1_vddr_vddr3 r0 *1 0,0
Cg_vddr_m1_mnt_g_s1_vddr_m1_s2_vddr_m1_s3_vddr_m1_s4_vddr_m1_vddr_vddr3
+ g_vddr_m1|mnt_g|s1_vddr_m1|s2_vddr_m1|s3_vddr_m1|s4_vddr_m1|vddr|vddr3 vsubs
+ 1.4778441e-14
* device instance g_vddr_m1_mnt_g_s1_vddr_m1_s2_vddr_m1_s3_vddr_m1_s4_vddr_m1_vddr_vddr4_t0 r0 *1 0,0
Rg_vddr_m1_mnt_g_s1_vddr_m1_s2_vddr_m1_s3_vddr_m1_s4_vddr_m1_vddr_vddr4_t0
+ g_vddr_m1|mnt_g|s1_vddr_m1|s2_vddr_m1|s3_vddr_m1|s4_vddr_m1|vddr|vddr4__t0
+ g_vddr_m1|mnt_g|s1_vddr_m1|s2_vddr_m1|s3_vddr_m1|s4_vddr_m1|vddr|vddr4
+ 548.949174724
* device instance g_vddr_m1_mnt_g_s1_vddr_m1_s2_vddr_m1_s3_vddr_m1_s4_vddr_m1_vddr_vddr4_t1 r0 *1 0,0
Rg_vddr_m1_mnt_g_s1_vddr_m1_s2_vddr_m1_s3_vddr_m1_s4_vddr_m1_vddr_vddr4_t1
+ g_vddr_m1|mnt_g|s1_vddr_m1|s2_vddr_m1|s3_vddr_m1|s4_vddr_m1|vddr|vddr4__t1
+ g_vddr_m1|mnt_g|s1_vddr_m1|s2_vddr_m1|s3_vddr_m1|s4_vddr_m1|vddr|vddr4
+ 543.208193994
* device instance g_vddr_m1_mnt_g_s1_vddr_m1_s2_vddr_m1_s3_vddr_m1_s4_vddr_m1_vddr_vddr4_t2 r0 *1 0,0
Rg_vddr_m1_mnt_g_s1_vddr_m1_s2_vddr_m1_s3_vddr_m1_s4_vddr_m1_vddr_vddr4_t2
+ g_vddr_m1|mnt_g|s1_vddr_m1|s2_vddr_m1|s3_vddr_m1|s4_vddr_m1|vddr|vddr4__t2
+ g_vddr_m1|mnt_g|s1_vddr_m1|s2_vddr_m1|s3_vddr_m1|s4_vddr_m1|vddr|vddr4
+ 543.208193994
* device instance g_vddr_m1_mnt_g_s1_vddr_m1_s2_vddr_m1_s3_vddr_m1_s4_vddr_m1_vddr_vddr4_t3 r0 *1 0,0
Rg_vddr_m1_mnt_g_s1_vddr_m1_s2_vddr_m1_s3_vddr_m1_s4_vddr_m1_vddr_vddr4_t3
+ g_vddr_m1|mnt_g|s1_vddr_m1|s2_vddr_m1|s3_vddr_m1|s4_vddr_m1|vddr|vddr4__t3
+ g_vddr_m1|mnt_g|s1_vddr_m1|s2_vddr_m1|s3_vddr_m1|s4_vddr_m1|vddr|vddr4
+ 26.5732609806
* device instance g_vddr_m1_mnt_g_s1_vddr_m1_s2_vddr_m1_s3_vddr_m1_s4_vddr_m1_vddr_vddr4_t4 r0 *1 0,0
Rg_vddr_m1_mnt_g_s1_vddr_m1_s2_vddr_m1_s3_vddr_m1_s4_vddr_m1_vddr_vddr4_t4
+ g_vddr_m1|mnt_g|s1_vddr_m1|s2_vddr_m1|s3_vddr_m1|s4_vddr_m1|vddr|vddr4__t4
+ g_vddr_m1|mnt_g|s1_vddr_m1|s2_vddr_m1|s3_vddr_m1|s4_vddr_m1|vddr|vddr4
+ 271.580090412
* device instance g_vddr_m1_mnt_g_s1_vddr_m1_s2_vddr_m1_s3_vddr_m1_s4_vddr_m1_vddr_vddr4_t5 r0 *1 0,0
Rg_vddr_m1_mnt_g_s1_vddr_m1_s2_vddr_m1_s3_vddr_m1_s4_vddr_m1_vddr_vddr4_t5
+ g_vddr_m1|mnt_g|s1_vddr_m1|s2_vddr_m1|s3_vddr_m1|s4_vddr_m1|vddr|vddr4__t5
+ g_vddr_m1|mnt_g|s1_vddr_m1|s2_vddr_m1|s3_vddr_m1|s4_vddr_m1|vddr|vddr4
+ 529.985715066
* device instance g_vddr_m1_mnt_g_s1_vddr_m1_s2_vddr_m1_s3_vddr_m1_s4_vddr_m1_vddr_vddr4_t6 r0 *1 0,0
Rg_vddr_m1_mnt_g_s1_vddr_m1_s2_vddr_m1_s3_vddr_m1_s4_vddr_m1_vddr_vddr4_t6
+ g_vddr_m1|mnt_g|s1_vddr_m1|s2_vddr_m1|s3_vddr_m1|s4_vddr_m1|vddr|vddr4__t6
+ g_vddr_m1|mnt_g|s1_vddr_m1|s2_vddr_m1|s3_vddr_m1|s4_vddr_m1|vddr|vddr4
+ 248.467374613
* device instance g_vddr_m1_mnt_g_s1_vddr_m1_s2_vddr_m1_s3_vddr_m1_s4_vddr_m1_vddr_vddr4_t7 r0 *1 0,0
Rg_vddr_m1_mnt_g_s1_vddr_m1_s2_vddr_m1_s3_vddr_m1_s4_vddr_m1_vddr_vddr4_t7
+ g_vddr_m1|mnt_g|s1_vddr_m1|s2_vddr_m1|s3_vddr_m1|s4_vddr_m1|vddr|vddr4__t7
+ g_vddr_m1|mnt_g|s1_vddr_m1|s2_vddr_m1|s3_vddr_m1|s4_vddr_m1|vddr|vddr4
+ 26.5732609806
* device instance g_vddr_m1_mnt_g_s1_vddr_m1_s2_vddr_m1_s3_vddr_m1_s4_vddr_m1_vddr_vddr4_t8 r0 *1 0,0
Rg_vddr_m1_mnt_g_s1_vddr_m1_s2_vddr_m1_s3_vddr_m1_s4_vddr_m1_vddr_vddr4_t8
+ g_vddr_m1|mnt_g|s1_vddr_m1|s2_vddr_m1|s3_vddr_m1|s4_vddr_m1|vddr|vddr4__t8
+ g_vddr_m1|mnt_g|s1_vddr_m1|s2_vddr_m1|s3_vddr_m1|s4_vddr_m1|vddr|vddr4
+ 271.580090412
* device instance g_vddr_m1_mnt_g_s1_vddr_m1_s2_vddr_m1_s3_vddr_m1_s4_vddr_m1_vddr_vddr4_t9 r0 *1 0,0
Rg_vddr_m1_mnt_g_s1_vddr_m1_s2_vddr_m1_s3_vddr_m1_s4_vddr_m1_vddr_vddr4_t9
+ g_vddr_m1|mnt_g|s1_vddr_m1|s2_vddr_m1|s3_vddr_m1|s4_vddr_m1|vddr|vddr4__t9
+ g_vddr_m1|mnt_g|s1_vddr_m1|s2_vddr_m1|s3_vddr_m1|s4_vddr_m1|vddr|vddr4
+ 529.985715066
* device instance g_vddr_m1_mnt_g_s1_vddr_m1_s2_vddr_m1_s3_vddr_m1_s4_vddr_m1_vddr_vddr4_t10 r0 *1 0,0
Rg_vddr_m1_mnt_g_s1_vddr_m1_s2_vddr_m1_s3_vddr_m1_s4_vddr_m1_vddr_vddr4_t10
+ g_vddr_m1|mnt_g|s1_vddr_m1|s2_vddr_m1|s3_vddr_m1|s4_vddr_m1|vddr|vddr4__t10
+ g_vddr_m1|mnt_g|s1_vddr_m1|s2_vddr_m1|s3_vddr_m1|s4_vddr_m1|vddr|vddr4
+ 248.467374613
* device instance g_vddr_m1_mnt_g_s1_vddr_m1_s2_vddr_m1_s3_vddr_m1_s4_vddr_m1_vddr_vddr4_t11 r0 *1 0,0
Rg_vddr_m1_mnt_g_s1_vddr_m1_s2_vddr_m1_s3_vddr_m1_s4_vddr_m1_vddr_vddr4_t11
+ g_vddr_m1|mnt_g|s1_vddr_m1|s2_vddr_m1|s3_vddr_m1|s4_vddr_m1|vddr|vddr4__t11
+ g_vddr_m1|mnt_g|s1_vddr_m1|s2_vddr_m1|s3_vddr_m1|s4_vddr_m1|vddr|vddr4
+ 180.335830955
* device instance g_vddr_m1_mnt_g_s1_vddr_m1_s2_vddr_m1_s3_vddr_m1_s4_vddr_m1_vddr_vddr4_t12 r0 *1 0,0
Rg_vddr_m1_mnt_g_s1_vddr_m1_s2_vddr_m1_s3_vddr_m1_s4_vddr_m1_vddr_vddr4_t12
+ g_vddr_m1|mnt_g|s1_vddr_m1|s2_vddr_m1|s3_vddr_m1|s4_vddr_m1|vddr|vddr4__t12
+ g_vddr_m1|mnt_g|s1_vddr_m1|s2_vddr_m1|s3_vddr_m1|s4_vddr_m1|vddr|vddr4
+ 474.83166193
* device instance g_vddr_m1_mnt_g_s1_vddr_m1_s2_vddr_m1_s3_vddr_m1_s4_vddr_m1_vddr_vddr4_t13 r0 *1 0,0
Rg_vddr_m1_mnt_g_s1_vddr_m1_s2_vddr_m1_s3_vddr_m1_s4_vddr_m1_vddr_vddr4_t13
+ g_vddr_m1|mnt_g|s1_vddr_m1|s2_vddr_m1|s3_vddr_m1|s4_vddr_m1|vddr|vddr4__t13
+ g_vddr_m1|mnt_g|s1_vddr_m1|s2_vddr_m1|s3_vddr_m1|s4_vddr_m1|vddr|vddr4
+ 598.494265483
* device instance g_vddr_m1_mnt_g_s1_vddr_m1_s2_vddr_m1_s3_vddr_m1_s4_vddr_m1_vddr_vddr4_t14 r0 *1 0,0
Rg_vddr_m1_mnt_g_s1_vddr_m1_s2_vddr_m1_s3_vddr_m1_s4_vddr_m1_vddr_vddr4_t14
+ g_vddr_m1|mnt_g|s1_vddr_m1|s2_vddr_m1|s3_vddr_m1|s4_vddr_m1|vddr|vddr4__t14
+ g_vddr_m1|mnt_g|s1_vddr_m1|s2_vddr_m1|s3_vddr_m1|s4_vddr_m1|vddr|vddr4
+ 339.937870542
* device instance g_vddr_m1_mnt_g_s1_vddr_m1_s2_vddr_m1_s3_vddr_m1_s4_vddr_m1_vddr_vddr4_t15 r0 *1 0,0
Rg_vddr_m1_mnt_g_s1_vddr_m1_s2_vddr_m1_s3_vddr_m1_s4_vddr_m1_vddr_vddr4_t15
+ g_vddr_m1|mnt_g|s1_vddr_m1|s2_vddr_m1|s3_vddr_m1|s4_vddr_m1|vddr|vddr4__t15
+ g_vddr_m1|mnt_g|s1_vddr_m1|s2_vddr_m1|s3_vddr_m1|s4_vddr_m1|vddr|vddr4
+ 83.6637986178
* device instance g_vddr_m1_mnt_g_s1_vddr_m1_s2_vddr_m1_s3_vddr_m1_s4_vddr_m1_vddr_vddr4_t16 r0 *1 0,0
Rg_vddr_m1_mnt_g_s1_vddr_m1_s2_vddr_m1_s3_vddr_m1_s4_vddr_m1_vddr_vddr4_t16
+ g_vddr_m1|mnt_g|s1_vddr_m1|s2_vddr_m1|s3_vddr_m1|s4_vddr_m1|vddr|vddr4__t16
+ g_vddr_m1|mnt_g|s1_vddr_m1|s2_vddr_m1|s3_vddr_m1|s4_vddr_m1|vddr|vddr4
+ 434.119056256
* device instance g_vddr_m1_mnt_g_s1_vddr_m1_s2_vddr_m1_s3_vddr_m1_s4_vddr_m1_vddr_vddr4_t17 r0 *1 0,0
Rg_vddr_m1_mnt_g_s1_vddr_m1_s2_vddr_m1_s3_vddr_m1_s4_vddr_m1_vddr_vddr4_t17
+ g_vddr_m1|mnt_g|s1_vddr_m1|s2_vddr_m1|s3_vddr_m1|s4_vddr_m1|vddr|vddr4__t17
+ g_vddr_m1|mnt_g|s1_vddr_m1|s2_vddr_m1|s3_vddr_m1|s4_vddr_m1|vddr|vddr4
+ 262.470256734
* device instance g_vddr_m1_mnt_g_s1_vddr_m1_s2_vddr_m1_s3_vddr_m1_s4_vddr_m1_vddr_vddr4_t18 r0 *1 0,0
Rg_vddr_m1_mnt_g_s1_vddr_m1_s2_vddr_m1_s3_vddr_m1_s4_vddr_m1_vddr_vddr4_t18
+ g_vddr_m1|mnt_g|s1_vddr_m1|s2_vddr_m1|s3_vddr_m1|s4_vddr_m1|vddr|vddr4__t18
+ g_vddr_m1|mnt_g|s1_vddr_m1|s2_vddr_m1|s3_vddr_m1|s4_vddr_m1|vddr|vddr4
+ 88.6608009347
* device instance g_vddr_m1_mnt_g_s1_vddr_m1_s2_vddr_m1_s3_vddr_m1_s4_vddr_m1_vddr_vddr4_t19 r0 *1 0,0
Rg_vddr_m1_mnt_g_s1_vddr_m1_s2_vddr_m1_s3_vddr_m1_s4_vddr_m1_vddr_vddr4_t19
+ g_vddr_m1|mnt_g|s1_vddr_m1|s2_vddr_m1|s3_vddr_m1|s4_vddr_m1|vddr|vddr4__t19
+ g_vddr_m1|mnt_g|s1_vddr_m1|s2_vddr_m1|s3_vddr_m1|s4_vddr_m1|vddr|vddr4
+ 284.447437906
* device instance g_vddr_m1_mnt_g_s1_vddr_m1_s2_vddr_m1_s3_vddr_m1_s4_vddr_m1_vddr_vddr4_t20 r0 *1 0,0
Rg_vddr_m1_mnt_g_s1_vddr_m1_s2_vddr_m1_s3_vddr_m1_s4_vddr_m1_vddr_vddr4_t20
+ g_vddr_m1|mnt_g|s1_vddr_m1|s2_vddr_m1|s3_vddr_m1|s4_vddr_m1|vddr|vddr4__t20
+ g_vddr_m1|mnt_g|s1_vddr_m1|s2_vddr_m1|s3_vddr_m1|s4_vddr_m1|vddr|vddr4
+ 536.693075787
* device instance g_vddr_m1_mnt_g_s1_vddr_m1_s2_vddr_m1_s3_vddr_m1_s4_vddr_m1_vddr_vddr4 r0 *1 0,0
Cg_vddr_m1_mnt_g_s1_vddr_m1_s2_vddr_m1_s3_vddr_m1_s4_vddr_m1_vddr_vddr4
+ g_vddr_m1|mnt_g|s1_vddr_m1|s2_vddr_m1|s3_vddr_m1|s4_vddr_m1|vddr|vddr4 vsubs
+ 1.4783725e-14
* device instance g_vss_m1_mph_g_s1_vss_m1_s2_vss_m1_s3_vss_m1_s4_vss_m1_vss_vss_x1_vss_x2_vss_x3_t0 r0 *1 0,0
Rg_vss_m1_mph_g_s1_vss_m1_s2_vss_m1_s3_vss_m1_s4_vss_m1_vss_vss_x1_vss_x2_vss_x3_t0
+ g_vss_m1|mph_g|s1_vss_m1|s2_vss_m1|s3_vss_m1|s4_vss_m1|vss|vss_x1|vss_x2|vss_x3__t0
+ g_vss_m1|mph_g|s1_vss_m1|s2_vss_m1|s3_vss_m1|s4_vss_m1|vss|vss_x1|vss_x2|vss_x3
+ 464.089953628
* device instance g_vss_m1_mph_g_s1_vss_m1_s2_vss_m1_s3_vss_m1_s4_vss_m1_vss_vss_x1_vss_x2_vss_x3_t1 r0 *1 0,0
Rg_vss_m1_mph_g_s1_vss_m1_s2_vss_m1_s3_vss_m1_s4_vss_m1_vss_vss_x1_vss_x2_vss_x3_t1
+ g_vss_m1|mph_g|s1_vss_m1|s2_vss_m1|s3_vss_m1|s4_vss_m1|vss|vss_x1|vss_x2|vss_x3__t1
+ g_vss_m1|mph_g|s1_vss_m1|s2_vss_m1|s3_vss_m1|s4_vss_m1|vss|vss_x1|vss_x2|vss_x3
+ 169.185029368
* device instance g_vss_m1_mph_g_s1_vss_m1_s2_vss_m1_s3_vss_m1_s4_vss_m1_vss_vss_x1_vss_x2_vss_x3_t2 r0 *1 0,0
Rg_vss_m1_mph_g_s1_vss_m1_s2_vss_m1_s3_vss_m1_s4_vss_m1_vss_vss_x1_vss_x2_vss_x3_t2
+ g_vss_m1|mph_g|s1_vss_m1|s2_vss_m1|s3_vss_m1|s4_vss_m1|vss|vss_x1|vss_x2|vss_x3__t2
+ g_vss_m1|mph_g|s1_vss_m1|s2_vss_m1|s3_vss_m1|s4_vss_m1|vss|vss_x1|vss_x2|vss_x3
+ 131.0107669
* device instance g_vss_m1_mph_g_s1_vss_m1_s2_vss_m1_s3_vss_m1_s4_vss_m1_vss_vss_x1_vss_x2_vss_x3_t3 r0 *1 0,0
Rg_vss_m1_mph_g_s1_vss_m1_s2_vss_m1_s3_vss_m1_s4_vss_m1_vss_vss_x1_vss_x2_vss_x3_t3
+ g_vss_m1|mph_g|s1_vss_m1|s2_vss_m1|s3_vss_m1|s4_vss_m1|vss|vss_x1|vss_x2|vss_x3__t3
+ g_vss_m1|mph_g|s1_vss_m1|s2_vss_m1|s3_vss_m1|s4_vss_m1|vss|vss_x1|vss_x2|vss_x3
+ 425.441212982
* device instance g_vss_m1_mph_g_s1_vss_m1_s2_vss_m1_s3_vss_m1_s4_vss_m1_vss_vss_x1_vss_x2_vss_x3_t4 r0 *1 0,0
Rg_vss_m1_mph_g_s1_vss_m1_s2_vss_m1_s3_vss_m1_s4_vss_m1_vss_vss_x1_vss_x2_vss_x3_t4
+ g_vss_m1|mph_g|s1_vss_m1|s2_vss_m1|s3_vss_m1|s4_vss_m1|vss|vss_x1|vss_x2|vss_x3__t4
+ g_vss_m1|mph_g|s1_vss_m1|s2_vss_m1|s3_vss_m1|s4_vss_m1|vss|vss_x1|vss_x2|vss_x3
+ 463.447399589
* device instance g_vss_m1_mph_g_s1_vss_m1_s2_vss_m1_s3_vss_m1_s4_vss_m1_vss_vss_x1_vss_x2_vss_x3_t5 r0 *1 0,0
Rg_vss_m1_mph_g_s1_vss_m1_s2_vss_m1_s3_vss_m1_s4_vss_m1_vss_vss_x1_vss_x2_vss_x3_t5
+ g_vss_m1|mph_g|s1_vss_m1|s2_vss_m1|s3_vss_m1|s4_vss_m1|vss|vss_x1|vss_x2|vss_x3__t5
+ g_vss_m1|mph_g|s1_vss_m1|s2_vss_m1|s3_vss_m1|s4_vss_m1|vss|vss_x1|vss_x2|vss_x3
+ 167.414399886
* device instance g_vss_m1_mph_g_s1_vss_m1_s2_vss_m1_s3_vss_m1_s4_vss_m1_vss_vss_x1_vss_x2_vss_x3_t6 r0 *1 0,0
Rg_vss_m1_mph_g_s1_vss_m1_s2_vss_m1_s3_vss_m1_s4_vss_m1_vss_vss_x1_vss_x2_vss_x3_t6
+ g_vss_m1|mph_g|s1_vss_m1|s2_vss_m1|s3_vss_m1|s4_vss_m1|vss|vss_x1|vss_x2|vss_x3__t6
+ g_vss_m1|mph_g|s1_vss_m1|s2_vss_m1|s3_vss_m1|s4_vss_m1|vss|vss_x1|vss_x2|vss_x3
+ 128.716075806
* device instance g_vss_m1_mph_g_s1_vss_m1_s2_vss_m1_s3_vss_m1_s4_vss_m1_vss_vss_x1_vss_x2_vss_x3_t7 r0 *1 0,0
Rg_vss_m1_mph_g_s1_vss_m1_s2_vss_m1_s3_vss_m1_s4_vss_m1_vss_vss_x1_vss_x2_vss_x3_t7
+ g_vss_m1|mph_g|s1_vss_m1|s2_vss_m1|s3_vss_m1|s4_vss_m1|vss|vss_x1|vss_x2|vss_x3__t7
+ g_vss_m1|mph_g|s1_vss_m1|s2_vss_m1|s3_vss_m1|s4_vss_m1|vss|vss_x1|vss_x2|vss_x3
+ 424.740194508
* device instance g_vss_m1_mph_g_s1_vss_m1_s2_vss_m1_s3_vss_m1_s4_vss_m1_vss_vss_x1_vss_x2_vss_x3_t8 r0 *1 0,0
Rg_vss_m1_mph_g_s1_vss_m1_s2_vss_m1_s3_vss_m1_s4_vss_m1_vss_vss_x1_vss_x2_vss_x3_t8
+ g_vss_m1|mph_g|s1_vss_m1|s2_vss_m1|s3_vss_m1|s4_vss_m1|vss|vss_x1|vss_x2|vss_x3__t8
+ g_vss_m1|mph_g|s1_vss_m1|s2_vss_m1|s3_vss_m1|s4_vss_m1|vss|vss_x1|vss_x2|vss_x3
+ 518.313113969
* device instance g_vss_m1_mph_g_s1_vss_m1_s2_vss_m1_s3_vss_m1_s4_vss_m1_vss_vss_x1_vss_x2_vss_x3_t9 r0 *1 0,0
Rg_vss_m1_mph_g_s1_vss_m1_s2_vss_m1_s3_vss_m1_s4_vss_m1_vss_vss_x1_vss_x2_vss_x3_t9
+ g_vss_m1|mph_g|s1_vss_m1|s2_vss_m1|s3_vss_m1|s4_vss_m1|vss|vss_x1|vss_x2|vss_x3__t9
+ g_vss_m1|mph_g|s1_vss_m1|s2_vss_m1|s3_vss_m1|s4_vss_m1|vss|vss_x1|vss_x2|vss_x3
+ 562.076333298
* device instance g_vss_m1_mph_g_s1_vss_m1_s2_vss_m1_s3_vss_m1_s4_vss_m1_vss_vss_x1_vss_x2_vss_x3_t10 r0 *1 0,0
Rg_vss_m1_mph_g_s1_vss_m1_s2_vss_m1_s3_vss_m1_s4_vss_m1_vss_vss_x1_vss_x2_vss_x3_t10
+ g_vss_m1|mph_g|s1_vss_m1|s2_vss_m1|s3_vss_m1|s4_vss_m1|vss|vss_x1|vss_x2|vss_x3__t10
+ g_vss_m1|mph_g|s1_vss_m1|s2_vss_m1|s3_vss_m1|s4_vss_m1|vss|vss_x1|vss_x2|vss_x3
+ 605.83991032
* device instance g_vss_m1_mph_g_s1_vss_m1_s2_vss_m1_s3_vss_m1_s4_vss_m1_vss_vss_x1_vss_x2_vss_x3_t11 r0 *1 0,0
Rg_vss_m1_mph_g_s1_vss_m1_s2_vss_m1_s3_vss_m1_s4_vss_m1_vss_vss_x1_vss_x2_vss_x3_t11
+ g_vss_m1|mph_g|s1_vss_m1|s2_vss_m1|s3_vss_m1|s4_vss_m1|vss|vss_x1|vss_x2|vss_x3__t11
+ g_vss_m1|mph_g|s1_vss_m1|s2_vss_m1|s3_vss_m1|s4_vss_m1|vss|vss_x1|vss_x2|vss_x3
+ 474.550351291
* device instance g_vss_m1_mph_g_s1_vss_m1_s2_vss_m1_s3_vss_m1_s4_vss_m1_vss_vss_x1_vss_x2_vss_x3_t12 r0 *1 0,0
Rg_vss_m1_mph_g_s1_vss_m1_s2_vss_m1_s3_vss_m1_s4_vss_m1_vss_vss_x1_vss_x2_vss_x3_t12
+ g_vss_m1|mph_g|s1_vss_m1|s2_vss_m1|s3_vss_m1|s4_vss_m1|vss|vss_x1|vss_x2|vss_x3__t12
+ g_vss_m1|mph_g|s1_vss_m1|s2_vss_m1|s3_vss_m1|s4_vss_m1|vss|vss_x1|vss_x2|vss_x3
+ 309.811723612
* device instance g_vss_m1_mph_g_s1_vss_m1_s2_vss_m1_s3_vss_m1_s4_vss_m1_vss_vss_x1_vss_x2_vss_x3_t13 r0 *1 0,0
Rg_vss_m1_mph_g_s1_vss_m1_s2_vss_m1_s3_vss_m1_s4_vss_m1_vss_vss_x1_vss_x2_vss_x3_t13
+ g_vss_m1|mph_g|s1_vss_m1|s2_vss_m1|s3_vss_m1|s4_vss_m1|vss|vss_x1|vss_x2|vss_x3__t13
+ g_vss_m1|mph_g|s1_vss_m1|s2_vss_m1|s3_vss_m1|s4_vss_m1|vss|vss_x1|vss_x2|vss_x3
+ 266.054779658
* device instance g_vss_m1_mph_g_s1_vss_m1_s2_vss_m1_s3_vss_m1_s4_vss_m1_vss_vss_x1_vss_x2_vss_x3_t14 r0 *1 0,0
Rg_vss_m1_mph_g_s1_vss_m1_s2_vss_m1_s3_vss_m1_s4_vss_m1_vss_vss_x1_vss_x2_vss_x3_t14
+ g_vss_m1|mph_g|s1_vss_m1|s2_vss_m1|s3_vss_m1|s4_vss_m1|vss|vss_x1|vss_x2|vss_x3__t14
+ g_vss_m1|mph_g|s1_vss_m1|s2_vss_m1|s3_vss_m1|s4_vss_m1|vss|vss_x1|vss_x2|vss_x3
+ 178.553761049
* device instance g_vss_m1_mph_g_s1_vss_m1_s2_vss_m1_s3_vss_m1_s4_vss_m1_vss_vss_x1_vss_x2_vss_x3_t15 r0 *1 0,0
Rg_vss_m1_mph_g_s1_vss_m1_s2_vss_m1_s3_vss_m1_s4_vss_m1_vss_vss_x1_vss_x2_vss_x3_t15
+ g_vss_m1|mph_g|s1_vss_m1|s2_vss_m1|s3_vss_m1|s4_vss_m1|vss|vss_x1|vss_x2|vss_x3__t15
+ g_vss_m1|mph_g|s1_vss_m1|s2_vss_m1|s3_vss_m1|s4_vss_m1|vss|vss_x1|vss_x2|vss_x3
+ 222.301281174
* device instance g_vss_m1_mph_g_s1_vss_m1_s2_vss_m1_s3_vss_m1_s4_vss_m1_vss_vss_x1_vss_x2_vss_x3_t16 r0 *1 0,0
Rg_vss_m1_mph_g_s1_vss_m1_s2_vss_m1_s3_vss_m1_s4_vss_m1_vss_vss_x1_vss_x2_vss_x3_t16
+ g_vss_m1|mph_g|s1_vss_m1|s2_vss_m1|s3_vss_m1|s4_vss_m1|vss|vss_x1|vss_x2|vss_x3__t16
+ g_vss_m1|mph_g|s1_vss_m1|s2_vss_m1|s3_vss_m1|s4_vss_m1|vss|vss_x1|vss_x2|vss_x3
+ 74.0499351087
* device instance g_vss_m1_mph_g_s1_vss_m1_s2_vss_m1_s3_vss_m1_s4_vss_m1_vss_vss_x1_vss_x2_vss_x3_t17 r0 *1 0,0
Rg_vss_m1_mph_g_s1_vss_m1_s2_vss_m1_s3_vss_m1_s4_vss_m1_vss_vss_x1_vss_x2_vss_x3_t17
+ g_vss_m1|mph_g|s1_vss_m1|s2_vss_m1|s3_vss_m1|s4_vss_m1|vss|vss_x1|vss_x2|vss_x3__t17
+ g_vss_m1|mph_g|s1_vss_m1|s2_vss_m1|s3_vss_m1|s4_vss_m1|vss|vss_x1|vss_x2|vss_x3
+ 30.6046545932
* device instance g_vss_m1_mph_g_s1_vss_m1_s2_vss_m1_s3_vss_m1_s4_vss_m1_vss_vss_x1_vss_x2_vss_x3_t18 r0 *1 0,0
Rg_vss_m1_mph_g_s1_vss_m1_s2_vss_m1_s3_vss_m1_s4_vss_m1_vss_vss_x1_vss_x2_vss_x3_t18
+ g_vss_m1|mph_g|s1_vss_m1|s2_vss_m1|s3_vss_m1|s4_vss_m1|vss|vss_x1|vss_x2|vss_x3__t18
+ g_vss_m1|mph_g|s1_vss_m1|s2_vss_m1|s3_vss_m1|s4_vss_m1|vss|vss_x1|vss_x2|vss_x3
+ 14.8582979012
* device instance g_vss_m1_mph_g_s1_vss_m1_s2_vss_m1_s3_vss_m1_s4_vss_m1_vss_vss_x1_vss_x2_vss_x3_t19 r0 *1 0,0
Rg_vss_m1_mph_g_s1_vss_m1_s2_vss_m1_s3_vss_m1_s4_vss_m1_vss_vss_x1_vss_x2_vss_x3_t19
+ g_vss_m1|mph_g|s1_vss_m1|s2_vss_m1|s3_vss_m1|s4_vss_m1|vss|vss_x1|vss_x2|vss_x3__t19
+ g_vss_m1|mph_g|s1_vss_m1|s2_vss_m1|s3_vss_m1|s4_vss_m1|vss|vss_x1|vss_x2|vss_x3
+ 117.732803572
* device instance g_vss_m1_mph_g_s1_vss_m1_s2_vss_m1_s3_vss_m1_s4_vss_m1_vss_vss_x1_vss_x2_vss_x3_t20 r0 *1 0,0
Rg_vss_m1_mph_g_s1_vss_m1_s2_vss_m1_s3_vss_m1_s4_vss_m1_vss_vss_x1_vss_x2_vss_x3_t20
+ g_vss_m1|mph_g|s1_vss_m1|s2_vss_m1|s3_vss_m1|s4_vss_m1|vss|vss_x1|vss_x2|vss_x3__t20
+ g_vss_m1|mph_g|s1_vss_m1|s2_vss_m1|s3_vss_m1|s4_vss_m1|vss|vss_x1|vss_x2|vss_x3
+ 282.408200526
* device instance g_vss_m1_mph_g_s1_vss_m1_s2_vss_m1_s3_vss_m1_s4_vss_m1_vss_vss_x1_vss_x2_vss_x3_t21 r0 *1 0,0
Rg_vss_m1_mph_g_s1_vss_m1_s2_vss_m1_s3_vss_m1_s4_vss_m1_vss_vss_x1_vss_x2_vss_x3_t21
+ g_vss_m1|mph_g|s1_vss_m1|s2_vss_m1|s3_vss_m1|s4_vss_m1|vss|vss_x1|vss_x2|vss_x3__t21
+ g_vss_m1|mph_g|s1_vss_m1|s2_vss_m1|s3_vss_m1|s4_vss_m1|vss|vss_x1|vss_x2|vss_x3
+ 326.166064704
* device instance g_vss_m1_mph_g_s1_vss_m1_s2_vss_m1_s3_vss_m1_s4_vss_m1_vss_vss_x1_vss_x2_vss_x3_t22 r0 *1 0,0
Rg_vss_m1_mph_g_s1_vss_m1_s2_vss_m1_s3_vss_m1_s4_vss_m1_vss_vss_x1_vss_x2_vss_x3_t22
+ g_vss_m1|mph_g|s1_vss_m1|s2_vss_m1|s3_vss_m1|s4_vss_m1|vss|vss_x1|vss_x2|vss_x3__t22
+ g_vss_m1|mph_g|s1_vss_m1|s2_vss_m1|s3_vss_m1|s4_vss_m1|vss|vss_x1|vss_x2|vss_x3
+ 413.686763467
* device instance g_vss_m1_mph_g_s1_vss_m1_s2_vss_m1_s3_vss_m1_s4_vss_m1_vss_vss_x1_vss_x2_vss_x3_t23 r0 *1 0,0
Rg_vss_m1_mph_g_s1_vss_m1_s2_vss_m1_s3_vss_m1_s4_vss_m1_vss_vss_x1_vss_x2_vss_x3_t23
+ g_vss_m1|mph_g|s1_vss_m1|s2_vss_m1|s3_vss_m1|s4_vss_m1|vss|vss_x1|vss_x2|vss_x3__t23
+ g_vss_m1|mph_g|s1_vss_m1|s2_vss_m1|s3_vss_m1|s4_vss_m1|vss|vss_x1|vss_x2|vss_x3
+ 369.925781672
* device instance g_vss_m1_mph_g_s1_vss_m1_s2_vss_m1_s3_vss_m1_s4_vss_m1_vss_vss_x1_vss_x2_vss_x3_t24 r0 *1 0,0
Rg_vss_m1_mph_g_s1_vss_m1_s2_vss_m1_s3_vss_m1_s4_vss_m1_vss_vss_x1_vss_x2_vss_x3_t24
+ g_vss_m1|mph_g|s1_vss_m1|s2_vss_m1|s3_vss_m1|s4_vss_m1|vss|vss_x1|vss_x2|vss_x3__t24
+ g_vss_m1|mph_g|s1_vss_m1|s2_vss_m1|s3_vss_m1|s4_vss_m1|vss|vss_x1|vss_x2|vss_x3
+ 475.154891311
* device instance g_vss_m1_mph_g_s1_vss_m1_s2_vss_m1_s3_vss_m1_s4_vss_m1_vss_vss_x1_vss_x2_vss_x3_t25 r0 *1 0,0
Rg_vss_m1_mph_g_s1_vss_m1_s2_vss_m1_s3_vss_m1_s4_vss_m1_vss_vss_x1_vss_x2_vss_x3_t25
+ g_vss_m1|mph_g|s1_vss_m1|s2_vss_m1|s3_vss_m1|s4_vss_m1|vss|vss_x1|vss_x2|vss_x3__t25
+ g_vss_m1|mph_g|s1_vss_m1|s2_vss_m1|s3_vss_m1|s4_vss_m1|vss|vss_x1|vss_x2|vss_x3
+ 518.866667785
* device instance g_vss_m1_mph_g_s1_vss_m1_s2_vss_m1_s3_vss_m1_s4_vss_m1_vss_vss_x1_vss_x2_vss_x3_t26 r0 *1 0,0
Rg_vss_m1_mph_g_s1_vss_m1_s2_vss_m1_s3_vss_m1_s4_vss_m1_vss_vss_x1_vss_x2_vss_x3_t26
+ g_vss_m1|mph_g|s1_vss_m1|s2_vss_m1|s3_vss_m1|s4_vss_m1|vss|vss_x1|vss_x2|vss_x3__t26
+ g_vss_m1|mph_g|s1_vss_m1|s2_vss_m1|s3_vss_m1|s4_vss_m1|vss|vss_x1|vss_x2|vss_x3
+ 562.586828214
* device instance g_vss_m1_mph_g_s1_vss_m1_s2_vss_m1_s3_vss_m1_s4_vss_m1_vss_vss_x1_vss_x2_vss_x3_t27 r0 *1 0,0
Rg_vss_m1_mph_g_s1_vss_m1_s2_vss_m1_s3_vss_m1_s4_vss_m1_vss_vss_x1_vss_x2_vss_x3_t27
+ g_vss_m1|mph_g|s1_vss_m1|s2_vss_m1|s3_vss_m1|s4_vss_m1|vss|vss_x1|vss_x2|vss_x3__t27
+ g_vss_m1|mph_g|s1_vss_m1|s2_vss_m1|s3_vss_m1|s4_vss_m1|vss|vss_x1|vss_x2|vss_x3
+ 606.313558946
* device instance g_vss_m1_mph_g_s1_vss_m1_s2_vss_m1_s3_vss_m1_s4_vss_m1_vss_vss_x1_vss_x2_vss_x3_t28 r0 *1 0,0
Rg_vss_m1_mph_g_s1_vss_m1_s2_vss_m1_s3_vss_m1_s4_vss_m1_vss_vss_x1_vss_x2_vss_x3_t28
+ g_vss_m1|mph_g|s1_vss_m1|s2_vss_m1|s3_vss_m1|s4_vss_m1|vss|vss_x1|vss_x2|vss_x3__t28
+ g_vss_m1|mph_g|s1_vss_m1|s2_vss_m1|s3_vss_m1|s4_vss_m1|vss|vss_x1|vss_x2|vss_x3
+ 223.588896053
* device instance g_vss_m1_mph_g_s1_vss_m1_s2_vss_m1_s3_vss_m1_s4_vss_m1_vss_vss_x1_vss_x2_vss_x3_t29 r0 *1 0,0
Rg_vss_m1_mph_g_s1_vss_m1_s2_vss_m1_s3_vss_m1_s4_vss_m1_vss_vss_x1_vss_x2_vss_x3_t29
+ g_vss_m1|mph_g|s1_vss_m1|s2_vss_m1|s3_vss_m1|s4_vss_m1|vss|vss_x1|vss_x2|vss_x3__t29
+ g_vss_m1|mph_g|s1_vss_m1|s2_vss_m1|s3_vss_m1|s4_vss_m1|vss|vss_x1|vss_x2|vss_x3
+ 267.131579199
* device instance g_vss_m1_mph_g_s1_vss_m1_s2_vss_m1_s3_vss_m1_s4_vss_m1_vss_vss_x1_vss_x2_vss_x3_t30 r0 *1 0,0
Rg_vss_m1_mph_g_s1_vss_m1_s2_vss_m1_s3_vss_m1_s4_vss_m1_vss_vss_x1_vss_x2_vss_x3_t30
+ g_vss_m1|mph_g|s1_vss_m1|s2_vss_m1|s3_vss_m1|s4_vss_m1|vss|vss_x1|vss_x2|vss_x3__t30
+ g_vss_m1|mph_g|s1_vss_m1|s2_vss_m1|s3_vss_m1|s4_vss_m1|vss|vss_x1|vss_x2|vss_x3
+ 310.736928789
* device instance g_vss_m1_mph_g_s1_vss_m1_s2_vss_m1_s3_vss_m1_s4_vss_m1_vss_vss_x1_vss_x2_vss_x3_t31 r0 *1 0,0
Rg_vss_m1_mph_g_s1_vss_m1_s2_vss_m1_s3_vss_m1_s4_vss_m1_vss_vss_x1_vss_x2_vss_x3_t31
+ g_vss_m1|mph_g|s1_vss_m1|s2_vss_m1|s3_vss_m1|s4_vss_m1|vss|vss_x1|vss_x2|vss_x3__t31
+ g_vss_m1|mph_g|s1_vss_m1|s2_vss_m1|s3_vss_m1|s4_vss_m1|vss|vss_x1|vss_x2|vss_x3
+ 180.154323876
* device instance g_vss_m1_mph_g_s1_vss_m1_s2_vss_m1_s3_vss_m1_s4_vss_m1_vss_vss_x1_vss_x2_vss_x3_t32 r0 *1 0,0
Rg_vss_m1_mph_g_s1_vss_m1_s2_vss_m1_s3_vss_m1_s4_vss_m1_vss_vss_x1_vss_x2_vss_x3_t32
+ g_vss_m1|mph_g|s1_vss_m1|s2_vss_m1|s3_vss_m1|s4_vss_m1|vss|vss_x1|vss_x2|vss_x3__t32
+ g_vss_m1|mph_g|s1_vss_m1|s2_vss_m1|s3_vss_m1|s4_vss_m1|vss|vss_x1|vss_x2|vss_x3
+ 28.1940391363
* device instance g_vss_m1_mph_g_s1_vss_m1_s2_vss_m1_s3_vss_m1_s4_vss_m1_vss_vss_x1_vss_x2_vss_x3_t33 r0 *1 0,0
Rg_vss_m1_mph_g_s1_vss_m1_s2_vss_m1_s3_vss_m1_s4_vss_m1_vss_vss_x1_vss_x2_vss_x3_t33
+ g_vss_m1|mph_g|s1_vss_m1|s2_vss_m1|s3_vss_m1|s4_vss_m1|vss|vss_x1|vss_x2|vss_x3__t33
+ g_vss_m1|mph_g|s1_vss_m1|s2_vss_m1|s3_vss_m1|s4_vss_m1|vss|vss_x1|vss_x2|vss_x3
+ 77.8301208781
* device instance g_vss_m1_mph_g_s1_vss_m1_s2_vss_m1_s3_vss_m1_s4_vss_m1_vss_vss_x1_vss_x2_vss_x3_t34 r0 *1 0,0
Rg_vss_m1_mph_g_s1_vss_m1_s2_vss_m1_s3_vss_m1_s4_vss_m1_vss_vss_x1_vss_x2_vss_x3_t34
+ g_vss_m1|mph_g|s1_vss_m1|s2_vss_m1|s3_vss_m1|s4_vss_m1|vss|vss_x1|vss_x2|vss_x3__t34
+ g_vss_m1|mph_g|s1_vss_m1|s2_vss_m1|s3_vss_m1|s4_vss_m1|vss|vss_x1|vss_x2|vss_x3
+ 38.868749775
* device instance g_vss_m1_mph_g_s1_vss_m1_s2_vss_m1_s3_vss_m1_s4_vss_m1_vss_vss_x1_vss_x2_vss_x3_t35 r0 *1 0,0
Rg_vss_m1_mph_g_s1_vss_m1_s2_vss_m1_s3_vss_m1_s4_vss_m1_vss_vss_x1_vss_x2_vss_x3_t35
+ g_vss_m1|mph_g|s1_vss_m1|s2_vss_m1|s3_vss_m1|s4_vss_m1|vss|vss_x1|vss_x2|vss_x3__t35
+ g_vss_m1|mph_g|s1_vss_m1|s2_vss_m1|s3_vss_m1|s4_vss_m1|vss|vss_x1|vss_x2|vss_x3
+ 120.146360175
* device instance g_vss_m1_mph_g_s1_vss_m1_s2_vss_m1_s3_vss_m1_s4_vss_m1_vss_vss_x1_vss_x2_vss_x3_t36 r0 *1 0,0
Rg_vss_m1_mph_g_s1_vss_m1_s2_vss_m1_s3_vss_m1_s4_vss_m1_vss_vss_x1_vss_x2_vss_x3_t36
+ g_vss_m1|mph_g|s1_vss_m1|s2_vss_m1|s3_vss_m1|s4_vss_m1|vss|vss_x1|vss_x2|vss_x3__t36
+ g_vss_m1|mph_g|s1_vss_m1|s2_vss_m1|s3_vss_m1|s4_vss_m1|vss|vss_x1|vss_x2|vss_x3
+ 371.740881829
* device instance g_vss_m1_mph_g_s1_vss_m1_s2_vss_m1_s3_vss_m1_s4_vss_m1_vss_vss_x1_vss_x2_vss_x3_t37 r0 *1 0,0
Rg_vss_m1_mph_g_s1_vss_m1_s2_vss_m1_s3_vss_m1_s4_vss_m1_vss_vss_x1_vss_x2_vss_x3_t37
+ g_vss_m1|mph_g|s1_vss_m1|s2_vss_m1|s3_vss_m1|s4_vss_m1|vss|vss_x1|vss_x2|vss_x3__t37
+ g_vss_m1|mph_g|s1_vss_m1|s2_vss_m1|s3_vss_m1|s4_vss_m1|vss|vss_x1|vss_x2|vss_x3
+ 469.57949473
* device instance g_vss_m1_mph_g_s1_vss_m1_s2_vss_m1_s3_vss_m1_s4_vss_m1_vss_vss_x1_vss_x2_vss_x3_t38 r0 *1 0,0
Rg_vss_m1_mph_g_s1_vss_m1_s2_vss_m1_s3_vss_m1_s4_vss_m1_vss_vss_x1_vss_x2_vss_x3_t38
+ g_vss_m1|mph_g|s1_vss_m1|s2_vss_m1|s3_vss_m1|s4_vss_m1|vss|vss_x1|vss_x2|vss_x3__t38
+ g_vss_m1|mph_g|s1_vss_m1|s2_vss_m1|s3_vss_m1|s4_vss_m1|vss|vss_x1|vss_x2|vss_x3
+ 78.8194046975
* device instance g_vss_m1_mph_g_s1_vss_m1_s2_vss_m1_s3_vss_m1_s4_vss_m1_vss_vss_x1_vss_x2_vss_x3_t39 r0 *1 0,0
Rg_vss_m1_mph_g_s1_vss_m1_s2_vss_m1_s3_vss_m1_s4_vss_m1_vss_vss_x1_vss_x2_vss_x3_t39
+ g_vss_m1|mph_g|s1_vss_m1|s2_vss_m1|s3_vss_m1|s4_vss_m1|vss|vss_x1|vss_x2|vss_x3__t39
+ g_vss_m1|mph_g|s1_vss_m1|s2_vss_m1|s3_vss_m1|s4_vss_m1|vss|vss_x1|vss_x2|vss_x3
+ 373.650240334
* device instance g_vss_m1_mph_g_s1_vss_m1_s2_vss_m1_s3_vss_m1_s4_vss_m1_vss_vss_x1_vss_x2_vss_x3_t40 r0 *1 0,0
Rg_vss_m1_mph_g_s1_vss_m1_s2_vss_m1_s3_vss_m1_s4_vss_m1_vss_vss_x1_vss_x2_vss_x3_t40
+ g_vss_m1|mph_g|s1_vss_m1|s2_vss_m1|s3_vss_m1|s4_vss_m1|vss|vss_x1|vss_x2|vss_x3__t40
+ g_vss_m1|mph_g|s1_vss_m1|s2_vss_m1|s3_vss_m1|s4_vss_m1|vss|vss_x1|vss_x2|vss_x3
+ 317.069450978
* device instance g_vss_m1_mph_g_s1_vss_m1_s2_vss_m1_s3_vss_m1_s4_vss_m1_vss_vss_x1_vss_x2_vss_x3_t41 r0 *1 0,0
Rg_vss_m1_mph_g_s1_vss_m1_s2_vss_m1_s3_vss_m1_s4_vss_m1_vss_vss_x1_vss_x2_vss_x3_t41
+ g_vss_m1|mph_g|s1_vss_m1|s2_vss_m1|s3_vss_m1|s4_vss_m1|vss|vss_x1|vss_x2|vss_x3__t41
+ g_vss_m1|mph_g|s1_vss_m1|s2_vss_m1|s3_vss_m1|s4_vss_m1|vss|vss_x1|vss_x2|vss_x3
+ 222.553076072
* device instance g_vss_m1_mph_g_s1_vss_m1_s2_vss_m1_s3_vss_m1_s4_vss_m1_vss_vss_x1_vss_x2_vss_x3_t42 r0 *1 0,0
Rg_vss_m1_mph_g_s1_vss_m1_s2_vss_m1_s3_vss_m1_s4_vss_m1_vss_vss_x1_vss_x2_vss_x3_t42
+ g_vss_m1|mph_g|s1_vss_m1|s2_vss_m1|s3_vss_m1|s4_vss_m1|vss|vss_x1|vss_x2|vss_x3__t42
+ g_vss_m1|mph_g|s1_vss_m1|s2_vss_m1|s3_vss_m1|s4_vss_m1|vss|vss_x1|vss_x2|vss_x3
+ 223.213868032
* device instance g_vss_m1_mph_g_s1_vss_m1_s2_vss_m1_s3_vss_m1_s4_vss_m1_vss_vss_x1_vss_x2_vss_x3_t43 r0 *1 0,0
Rg_vss_m1_mph_g_s1_vss_m1_s2_vss_m1_s3_vss_m1_s4_vss_m1_vss_vss_x1_vss_x2_vss_x3_t43
+ g_vss_m1|mph_g|s1_vss_m1|s2_vss_m1|s3_vss_m1|s4_vss_m1|vss|vss_x1|vss_x2|vss_x3__t43
+ g_vss_m1|mph_g|s1_vss_m1|s2_vss_m1|s3_vss_m1|s4_vss_m1|vss|vss_x1|vss_x2|vss_x3
+ 169.320328119
* device instance g_vss_m1_mph_g_s1_vss_m1_s2_vss_m1_s3_vss_m1_s4_vss_m1_vss_vss_x1_vss_x2_vss_x3_t44 r0 *1 0,0
Rg_vss_m1_mph_g_s1_vss_m1_s2_vss_m1_s3_vss_m1_s4_vss_m1_vss_vss_x1_vss_x2_vss_x3_t44
+ g_vss_m1|mph_g|s1_vss_m1|s2_vss_m1|s3_vss_m1|s4_vss_m1|vss|vss_x1|vss_x2|vss_x3__t44
+ g_vss_m1|mph_g|s1_vss_m1|s2_vss_m1|s3_vss_m1|s4_vss_m1|vss|vss_x1|vss_x2|vss_x3
+ 667.432562636
* device instance g_vss_m1_mph_g_s1_vss_m1_s2_vss_m1_s3_vss_m1_s4_vss_m1_vss_vss_x1_vss_x2_vss_x3_t45 r0 *1 0,0
Rg_vss_m1_mph_g_s1_vss_m1_s2_vss_m1_s3_vss_m1_s4_vss_m1_vss_vss_x1_vss_x2_vss_x3_t45
+ g_vss_m1|mph_g|s1_vss_m1|s2_vss_m1|s3_vss_m1|s4_vss_m1|vss|vss_x1|vss_x2|vss_x3__t45
+ g_vss_m1|mph_g|s1_vss_m1|s2_vss_m1|s3_vss_m1|s4_vss_m1|vss|vss_x1|vss_x2|vss_x3
+ 90.2361433158
* device instance g_vss_m1_mph_g_s1_vss_m1_s2_vss_m1_s3_vss_m1_s4_vss_m1_vss_vss_x1_vss_x2_vss_x3_t46 r0 *1 0,0
Rg_vss_m1_mph_g_s1_vss_m1_s2_vss_m1_s3_vss_m1_s4_vss_m1_vss_vss_x1_vss_x2_vss_x3_t46
+ g_vss_m1|mph_g|s1_vss_m1|s2_vss_m1|s3_vss_m1|s4_vss_m1|vss|vss_x1|vss_x2|vss_x3__t46
+ g_vss_m1|mph_g|s1_vss_m1|s2_vss_m1|s3_vss_m1|s4_vss_m1|vss|vss_x1|vss_x2|vss_x3
+ 414.38010702
* device instance g_vss_m1_mph_g_s1_vss_m1_s2_vss_m1_s3_vss_m1_s4_vss_m1_vss_vss_x1_vss_x2_vss_x3_t47 r0 *1 0,0
Rg_vss_m1_mph_g_s1_vss_m1_s2_vss_m1_s3_vss_m1_s4_vss_m1_vss_vss_x1_vss_x2_vss_x3_t47
+ g_vss_m1|mph_g|s1_vss_m1|s2_vss_m1|s3_vss_m1|s4_vss_m1|vss|vss_x1|vss_x2|vss_x3__t47
+ g_vss_m1|mph_g|s1_vss_m1|s2_vss_m1|s3_vss_m1|s4_vss_m1|vss|vss_x1|vss_x2|vss_x3
+ 370.700982966
* device instance g_vss_m1_mph_g_s1_vss_m1_s2_vss_m1_s3_vss_m1_s4_vss_m1_vss_vss_x1_vss_x2_vss_x3_t48 r0 *1 0,0
Rg_vss_m1_mph_g_s1_vss_m1_s2_vss_m1_s3_vss_m1_s4_vss_m1_vss_vss_x1_vss_x2_vss_x3_t48
+ g_vss_m1|mph_g|s1_vss_m1|s2_vss_m1|s3_vss_m1|s4_vss_m1|vss|vss_x1|vss_x2|vss_x3__t48
+ g_vss_m1|mph_g|s1_vss_m1|s2_vss_m1|s3_vss_m1|s4_vss_m1|vss|vss_x1|vss_x2|vss_x3
+ 283.422875842
* device instance g_vss_m1_mph_g_s1_vss_m1_s2_vss_m1_s3_vss_m1_s4_vss_m1_vss_vss_x1_vss_x2_vss_x3_t49 r0 *1 0,0
Rg_vss_m1_mph_g_s1_vss_m1_s2_vss_m1_s3_vss_m1_s4_vss_m1_vss_vss_x1_vss_x2_vss_x3_t49
+ g_vss_m1|mph_g|s1_vss_m1|s2_vss_m1|s3_vss_m1|s4_vss_m1|vss|vss_x1|vss_x2|vss_x3__t49
+ g_vss_m1|mph_g|s1_vss_m1|s2_vss_m1|s3_vss_m1|s4_vss_m1|vss|vss_x1|vss_x2|vss_x3
+ 327.045006981
* device instance g_vss_m1_mph_g_s1_vss_m1_s2_vss_m1_s3_vss_m1_s4_vss_m1_vss_vss_x1_vss_x2_vss_x3_t50 r0 *1 0,0
Rg_vss_m1_mph_g_s1_vss_m1_s2_vss_m1_s3_vss_m1_s4_vss_m1_vss_vss_x1_vss_x2_vss_x3_t50
+ g_vss_m1|mph_g|s1_vss_m1|s2_vss_m1|s3_vss_m1|s4_vss_m1|vss|vss_x1|vss_x2|vss_x3__t50
+ g_vss_m1|mph_g|s1_vss_m1|s2_vss_m1|s3_vss_m1|s4_vss_m1|vss|vss_x1|vss_x2|vss_x3
+ 441.308666348
* device instance g_vss_m1_mph_g_s1_vss_m1_s2_vss_m1_s3_vss_m1_s4_vss_m1_vss_vss_x1_vss_x2_vss_x3_t51 r0 *1 0,0
Rg_vss_m1_mph_g_s1_vss_m1_s2_vss_m1_s3_vss_m1_s4_vss_m1_vss_vss_x1_vss_x2_vss_x3_t51
+ g_vss_m1|mph_g|s1_vss_m1|s2_vss_m1|s3_vss_m1|s4_vss_m1|vss|vss_x1|vss_x2|vss_x3__t51
+ g_vss_m1|mph_g|s1_vss_m1|s2_vss_m1|s3_vss_m1|s4_vss_m1|vss|vss_x1|vss_x2|vss_x3
+ 106.775992962
* device instance g_vss_m1_mph_g_s1_vss_m1_s2_vss_m1_s3_vss_m1_s4_vss_m1_vss_vss_x1_vss_x2_vss_x3_t52 r0 *1 0,0
Rg_vss_m1_mph_g_s1_vss_m1_s2_vss_m1_s3_vss_m1_s4_vss_m1_vss_vss_x1_vss_x2_vss_x3_t52
+ g_vss_m1|mph_g|s1_vss_m1|s2_vss_m1|s3_vss_m1|s4_vss_m1|vss|vss_x1|vss_x2|vss_x3__t52
+ g_vss_m1|mph_g|s1_vss_m1|s2_vss_m1|s3_vss_m1|s4_vss_m1|vss|vss_x1|vss_x2|vss_x3
+ 139.787806446
* device instance g_vss_m1_mph_g_s1_vss_m1_s2_vss_m1_s3_vss_m1_s4_vss_m1_vss_vss_x1_vss_x2_vss_x3_t53 r0 *1 0,0
Rg_vss_m1_mph_g_s1_vss_m1_s2_vss_m1_s3_vss_m1_s4_vss_m1_vss_vss_x1_vss_x2_vss_x3_t53
+ g_vss_m1|mph_g|s1_vss_m1|s2_vss_m1|s3_vss_m1|s4_vss_m1|vss|vss_x1|vss_x2|vss_x3__t53
+ g_vss_m1|mph_g|s1_vss_m1|s2_vss_m1|s3_vss_m1|s4_vss_m1|vss|vss_x1|vss_x2|vss_x3
+ 404.184513886
* device instance g_vss_m1_mph_g_s1_vss_m1_s2_vss_m1_s3_vss_m1_s4_vss_m1_vss_vss_x1_vss_x2_vss_x3_t54 r0 *1 0,0
Rg_vss_m1_mph_g_s1_vss_m1_s2_vss_m1_s3_vss_m1_s4_vss_m1_vss_vss_x1_vss_x2_vss_x3_t54
+ g_vss_m1|mph_g|s1_vss_m1|s2_vss_m1|s3_vss_m1|s4_vss_m1|vss|vss_x1|vss_x2|vss_x3__t54
+ g_vss_m1|mph_g|s1_vss_m1|s2_vss_m1|s3_vss_m1|s4_vss_m1|vss|vss_x1|vss_x2|vss_x3
+ 251.652570064
* device instance g_vss_m1_mph_g_s1_vss_m1_s2_vss_m1_s3_vss_m1_s4_vss_m1_vss_vss_x1_vss_x2_vss_x3_t55 r0 *1 0,0
Rg_vss_m1_mph_g_s1_vss_m1_s2_vss_m1_s3_vss_m1_s4_vss_m1_vss_vss_x1_vss_x2_vss_x3_t55
+ g_vss_m1|mph_g|s1_vss_m1|s2_vss_m1|s3_vss_m1|s4_vss_m1|vss|vss_x1|vss_x2|vss_x3__t55
+ g_vss_m1|mph_g|s1_vss_m1|s2_vss_m1|s3_vss_m1|s4_vss_m1|vss|vss_x1|vss_x2|vss_x3
+ 288.258363215
* device instance g_vss_m1_mph_g_s1_vss_m1_s2_vss_m1_s3_vss_m1_s4_vss_m1_vss_vss_x1_vss_x2_vss_x3_t56 r0 *1 0,0
Rg_vss_m1_mph_g_s1_vss_m1_s2_vss_m1_s3_vss_m1_s4_vss_m1_vss_vss_x1_vss_x2_vss_x3_t56
+ g_vss_m1|mph_g|s1_vss_m1|s2_vss_m1|s3_vss_m1|s4_vss_m1|vss|vss_x1|vss_x2|vss_x3__t56
+ g_vss_m1|mph_g|s1_vss_m1|s2_vss_m1|s3_vss_m1|s4_vss_m1|vss|vss_x1|vss_x2|vss_x3
+ 450.110642972
* device instance g_vss_m1_mph_g_s1_vss_m1_s2_vss_m1_s3_vss_m1_s4_vss_m1_vss_vss_x1_vss_x2_vss_x3_t57 r0 *1 0,0
Rg_vss_m1_mph_g_s1_vss_m1_s2_vss_m1_s3_vss_m1_s4_vss_m1_vss_vss_x1_vss_x2_vss_x3_t57
+ g_vss_m1|mph_g|s1_vss_m1|s2_vss_m1|s3_vss_m1|s4_vss_m1|vss|vss_x1|vss_x2|vss_x3__t57
+ g_vss_m1|mph_g|s1_vss_m1|s2_vss_m1|s3_vss_m1|s4_vss_m1|vss|vss_x1|vss_x2|vss_x3
+ 155.347999805
* device instance g_vss_m1_mph_g_s1_vss_m1_s2_vss_m1_s3_vss_m1_s4_vss_m1_vss_vss_x1_vss_x2_vss_x3_t58 r0 *1 0,0
Rg_vss_m1_mph_g_s1_vss_m1_s2_vss_m1_s3_vss_m1_s4_vss_m1_vss_vss_x1_vss_x2_vss_x3_t58
+ g_vss_m1|mph_g|s1_vss_m1|s2_vss_m1|s3_vss_m1|s4_vss_m1|vss|vss_x1|vss_x2|vss_x3__t58
+ g_vss_m1|mph_g|s1_vss_m1|s2_vss_m1|s3_vss_m1|s4_vss_m1|vss|vss_x1|vss_x2|vss_x3
+ 144.784560463
* device instance g_vss_m1_mph_g_s1_vss_m1_s2_vss_m1_s3_vss_m1_s4_vss_m1_vss_vss_x1_vss_x2_vss_x3_t59 r0 *1 0,0
Rg_vss_m1_mph_g_s1_vss_m1_s2_vss_m1_s3_vss_m1_s4_vss_m1_vss_vss_x1_vss_x2_vss_x3_t59
+ g_vss_m1|mph_g|s1_vss_m1|s2_vss_m1|s3_vss_m1|s4_vss_m1|vss|vss_x1|vss_x2|vss_x3__t59
+ g_vss_m1|mph_g|s1_vss_m1|s2_vss_m1|s3_vss_m1|s4_vss_m1|vss|vss_x1|vss_x2|vss_x3
+ 439.418131888
* device instance g_vss_m1_mph_g_s1_vss_m1_s2_vss_m1_s3_vss_m1_s4_vss_m1_vss_vss_x1_vss_x2_vss_x3_t60 r0 *1 0,0
Rg_vss_m1_mph_g_s1_vss_m1_s2_vss_m1_s3_vss_m1_s4_vss_m1_vss_vss_x1_vss_x2_vss_x3_t60
+ g_vss_m1|mph_g|s1_vss_m1|s2_vss_m1|s3_vss_m1|s4_vss_m1|vss|vss_x1|vss_x2|vss_x3__t60
+ g_vss_m1|mph_g|s1_vss_m1|s2_vss_m1|s3_vss_m1|s4_vss_m1|vss|vss_x1|vss_x2|vss_x3
+ 444.865065068
* device instance g_vss_m1_mph_g_s1_vss_m1_s2_vss_m1_s3_vss_m1_s4_vss_m1_vss_vss_x1_vss_x2_vss_x3_t61 r0 *1 0,0
Rg_vss_m1_mph_g_s1_vss_m1_s2_vss_m1_s3_vss_m1_s4_vss_m1_vss_vss_x1_vss_x2_vss_x3_t61
+ g_vss_m1|mph_g|s1_vss_m1|s2_vss_m1|s3_vss_m1|s4_vss_m1|vss|vss_x1|vss_x2|vss_x3__t61
+ g_vss_m1|mph_g|s1_vss_m1|s2_vss_m1|s3_vss_m1|s4_vss_m1|vss|vss_x1|vss_x2|vss_x3
+ 407.735045972
* device instance g_vss_m1_mph_g_s1_vss_m1_s2_vss_m1_s3_vss_m1_s4_vss_m1_vss_vss_x1_vss_x2_vss_x3_t62 r0 *1 0,0
Rg_vss_m1_mph_g_s1_vss_m1_s2_vss_m1_s3_vss_m1_s4_vss_m1_vss_vss_x1_vss_x2_vss_x3_t62
+ g_vss_m1|mph_g|s1_vss_m1|s2_vss_m1|s3_vss_m1|s4_vss_m1|vss|vss_x1|vss_x2|vss_x3__t62
+ g_vss_m1|mph_g|s1_vss_m1|s2_vss_m1|s3_vss_m1|s4_vss_m1|vss|vss_x1|vss_x2|vss_x3
+ 291.773636147
* device instance g_vss_m1_mph_g_s1_vss_m1_s2_vss_m1_s3_vss_m1_s4_vss_m1_vss_vss_x1_vss_x2_vss_x3_t63 r0 *1 0,0
Rg_vss_m1_mph_g_s1_vss_m1_s2_vss_m1_s3_vss_m1_s4_vss_m1_vss_vss_x1_vss_x2_vss_x3_t63
+ g_vss_m1|mph_g|s1_vss_m1|s2_vss_m1|s3_vss_m1|s4_vss_m1|vss|vss_x1|vss_x2|vss_x3__t63
+ g_vss_m1|mph_g|s1_vss_m1|s2_vss_m1|s3_vss_m1|s4_vss_m1|vss|vss_x1|vss_x2|vss_x3
+ 255.145343152
* device instance g_vss_m1_mph_g_s1_vss_m1_s2_vss_m1_s3_vss_m1_s4_vss_m1_vss_vss_x1_vss_x2_vss_x3_t64 r0 *1 0,0
Rg_vss_m1_mph_g_s1_vss_m1_s2_vss_m1_s3_vss_m1_s4_vss_m1_vss_vss_x1_vss_x2_vss_x3_t64
+ g_vss_m1|mph_g|s1_vss_m1|s2_vss_m1|s3_vss_m1|s4_vss_m1|vss|vss_x1|vss_x2|vss_x3__t64
+ g_vss_m1|mph_g|s1_vss_m1|s2_vss_m1|s3_vss_m1|s4_vss_m1|vss|vss_x1|vss_x2|vss_x3
+ 143.062871779
* device instance g_vss_m1_mph_g_s1_vss_m1_s2_vss_m1_s3_vss_m1_s4_vss_m1_vss_vss_x1_vss_x2_vss_x3_t65 r0 *1 0,0
Rg_vss_m1_mph_g_s1_vss_m1_s2_vss_m1_s3_vss_m1_s4_vss_m1_vss_vss_x1_vss_x2_vss_x3_t65
+ g_vss_m1|mph_g|s1_vss_m1|s2_vss_m1|s3_vss_m1|s4_vss_m1|vss|vss_x1|vss_x2|vss_x3__t65
+ g_vss_m1|mph_g|s1_vss_m1|s2_vss_m1|s3_vss_m1|s4_vss_m1|vss|vss_x1|vss_x2|vss_x3
+ 109.811777368
* device instance g_vss_m1_mph_g_s1_vss_m1_s2_vss_m1_s3_vss_m1_s4_vss_m1_vss_vss_x1_vss_x2_vss_x3_t66 r0 *1 0,0
Rg_vss_m1_mph_g_s1_vss_m1_s2_vss_m1_s3_vss_m1_s4_vss_m1_vss_vss_x1_vss_x2_vss_x3_t66
+ g_vss_m1|mph_g|s1_vss_m1|s2_vss_m1|s3_vss_m1|s4_vss_m1|vss|vss_x1|vss_x2|vss_x3__t66
+ g_vss_m1|mph_g|s1_vss_m1|s2_vss_m1|s3_vss_m1|s4_vss_m1|vss|vss_x1|vss_x2|vss_x3
+ 446.529151072
* device instance g_vss_m1_mph_g_s1_vss_m1_s2_vss_m1_s3_vss_m1_s4_vss_m1_vss_vss_x1_vss_x2_vss_x3_t67 r0 *1 0,0
Rg_vss_m1_mph_g_s1_vss_m1_s2_vss_m1_s3_vss_m1_s4_vss_m1_vss_vss_x1_vss_x2_vss_x3_t67
+ g_vss_m1|mph_g|s1_vss_m1|s2_vss_m1|s3_vss_m1|s4_vss_m1|vss|vss_x1|vss_x2|vss_x3__t67
+ g_vss_m1|mph_g|s1_vss_m1|s2_vss_m1|s3_vss_m1|s4_vss_m1|vss|vss_x1|vss_x2|vss_x3
+ 151.807556521
* device instance g_vss_m1_mph_g_s1_vss_m1_s2_vss_m1_s3_vss_m1_s4_vss_m1_vss_vss_x1_vss_x2_vss_x3_t68 r0 *1 0,0
Rg_vss_m1_mph_g_s1_vss_m1_s2_vss_m1_s3_vss_m1_s4_vss_m1_vss_vss_x1_vss_x2_vss_x3_t68
+ g_vss_m1|mph_g|s1_vss_m1|s2_vss_m1|s3_vss_m1|s4_vss_m1|vss|vss_x1|vss_x2|vss_x3__t68
+ g_vss_m1|mph_g|s1_vss_m1|s2_vss_m1|s3_vss_m1|s4_vss_m1|vss|vss_x1|vss_x2|vss_x3
+ 148.320408086
* device instance g_vss_m1_mph_g_s1_vss_m1_s2_vss_m1_s3_vss_m1_s4_vss_m1_vss_vss_x1_vss_x2_vss_x3_t69 r0 *1 0,0
Rg_vss_m1_mph_g_s1_vss_m1_s2_vss_m1_s3_vss_m1_s4_vss_m1_vss_vss_x1_vss_x2_vss_x3_t69
+ g_vss_m1|mph_g|s1_vss_m1|s2_vss_m1|s3_vss_m1|s4_vss_m1|vss|vss_x1|vss_x2|vss_x3__t69
+ g_vss_m1|mph_g|s1_vss_m1|s2_vss_m1|s3_vss_m1|s4_vss_m1|vss|vss_x1|vss_x2|vss_x3
+ 442.999447484
* device instance g_vss_m1_mph_g_s1_vss_m1_s2_vss_m1_s3_vss_m1_s4_vss_m1_vss_vss_x1_vss_x2_vss_x3_t70 r0 *1 0,0
Rg_vss_m1_mph_g_s1_vss_m1_s2_vss_m1_s3_vss_m1_s4_vss_m1_vss_vss_x1_vss_x2_vss_x3_t70
+ g_vss_m1|mph_g|s1_vss_m1|s2_vss_m1|s3_vss_m1|s4_vss_m1|vss|vss_x1|vss_x2|vss_x3__t70
+ g_vss_m1|mph_g|s1_vss_m1|s2_vss_m1|s3_vss_m1|s4_vss_m1|vss|vss_x1|vss_x2|vss_x3
+ 441.308666348
* device instance g_vss_m1_mph_g_s1_vss_m1_s2_vss_m1_s3_vss_m1_s4_vss_m1_vss_vss_x1_vss_x2_vss_x3_t71 r0 *1 0,0
Rg_vss_m1_mph_g_s1_vss_m1_s2_vss_m1_s3_vss_m1_s4_vss_m1_vss_vss_x1_vss_x2_vss_x3_t71
+ g_vss_m1|mph_g|s1_vss_m1|s2_vss_m1|s3_vss_m1|s4_vss_m1|vss|vss_x1|vss_x2|vss_x3__t71
+ g_vss_m1|mph_g|s1_vss_m1|s2_vss_m1|s3_vss_m1|s4_vss_m1|vss|vss_x1|vss_x2|vss_x3
+ 404.184513886
* device instance g_vss_m1_mph_g_s1_vss_m1_s2_vss_m1_s3_vss_m1_s4_vss_m1_vss_vss_x1_vss_x2_vss_x3_t72 r0 *1 0,0
Rg_vss_m1_mph_g_s1_vss_m1_s2_vss_m1_s3_vss_m1_s4_vss_m1_vss_vss_x1_vss_x2_vss_x3_t72
+ g_vss_m1|mph_g|s1_vss_m1|s2_vss_m1|s3_vss_m1|s4_vss_m1|vss|vss_x1|vss_x2|vss_x3__t72
+ g_vss_m1|mph_g|s1_vss_m1|s2_vss_m1|s3_vss_m1|s4_vss_m1|vss|vss_x1|vss_x2|vss_x3
+ 288.258363215
* device instance g_vss_m1_mph_g_s1_vss_m1_s2_vss_m1_s3_vss_m1_s4_vss_m1_vss_vss_x1_vss_x2_vss_x3_t73 r0 *1 0,0
Rg_vss_m1_mph_g_s1_vss_m1_s2_vss_m1_s3_vss_m1_s4_vss_m1_vss_vss_x1_vss_x2_vss_x3_t73
+ g_vss_m1|mph_g|s1_vss_m1|s2_vss_m1|s3_vss_m1|s4_vss_m1|vss|vss_x1|vss_x2|vss_x3__t73
+ g_vss_m1|mph_g|s1_vss_m1|s2_vss_m1|s3_vss_m1|s4_vss_m1|vss|vss_x1|vss_x2|vss_x3
+ 251.652570064
* device instance g_vss_m1_mph_g_s1_vss_m1_s2_vss_m1_s3_vss_m1_s4_vss_m1_vss_vss_x1_vss_x2_vss_x3_t74 r0 *1 0,0
Rg_vss_m1_mph_g_s1_vss_m1_s2_vss_m1_s3_vss_m1_s4_vss_m1_vss_vss_x1_vss_x2_vss_x3_t74
+ g_vss_m1|mph_g|s1_vss_m1|s2_vss_m1|s3_vss_m1|s4_vss_m1|vss|vss_x1|vss_x2|vss_x3__t74
+ g_vss_m1|mph_g|s1_vss_m1|s2_vss_m1|s3_vss_m1|s4_vss_m1|vss|vss_x1|vss_x2|vss_x3
+ 139.787806446
* device instance g_vss_m1_mph_g_s1_vss_m1_s2_vss_m1_s3_vss_m1_s4_vss_m1_vss_vss_x1_vss_x2_vss_x3_t75 r0 *1 0,0
Rg_vss_m1_mph_g_s1_vss_m1_s2_vss_m1_s3_vss_m1_s4_vss_m1_vss_vss_x1_vss_x2_vss_x3_t75
+ g_vss_m1|mph_g|s1_vss_m1|s2_vss_m1|s3_vss_m1|s4_vss_m1|vss|vss_x1|vss_x2|vss_x3__t75
+ g_vss_m1|mph_g|s1_vss_m1|s2_vss_m1|s3_vss_m1|s4_vss_m1|vss|vss_x1|vss_x2|vss_x3
+ 106.775992962
* device instance g_vss_m1_mph_g_s1_vss_m1_s2_vss_m1_s3_vss_m1_s4_vss_m1_vss_vss_x1_vss_x2_vss_x3_t76 r0 *1 0,0
Rg_vss_m1_mph_g_s1_vss_m1_s2_vss_m1_s3_vss_m1_s4_vss_m1_vss_vss_x1_vss_x2_vss_x3_t76
+ g_vss_m1|mph_g|s1_vss_m1|s2_vss_m1|s3_vss_m1|s4_vss_m1|vss|vss_x1|vss_x2|vss_x3__t76
+ g_vss_m1|mph_g|s1_vss_m1|s2_vss_m1|s3_vss_m1|s4_vss_m1|vss|vss_x1|vss_x2|vss_x3
+ 131.0107669
* device instance g_vss_m1_mph_g_s1_vss_m1_s2_vss_m1_s3_vss_m1_s4_vss_m1_vss_vss_x1_vss_x2_vss_x3_t77 r0 *1 0,0
Rg_vss_m1_mph_g_s1_vss_m1_s2_vss_m1_s3_vss_m1_s4_vss_m1_vss_vss_x1_vss_x2_vss_x3_t77
+ g_vss_m1|mph_g|s1_vss_m1|s2_vss_m1|s3_vss_m1|s4_vss_m1|vss|vss_x1|vss_x2|vss_x3__t77
+ g_vss_m1|mph_g|s1_vss_m1|s2_vss_m1|s3_vss_m1|s4_vss_m1|vss|vss_x1|vss_x2|vss_x3
+ 180.154323876
* device instance g_vss_m1_mph_g_s1_vss_m1_s2_vss_m1_s3_vss_m1_s4_vss_m1_vss_vss_x1_vss_x2_vss_x3_t78 r0 *1 0,0
Rg_vss_m1_mph_g_s1_vss_m1_s2_vss_m1_s3_vss_m1_s4_vss_m1_vss_vss_x1_vss_x2_vss_x3_t78
+ g_vss_m1|mph_g|s1_vss_m1|s2_vss_m1|s3_vss_m1|s4_vss_m1|vss|vss_x1|vss_x2|vss_x3__t78
+ g_vss_m1|mph_g|s1_vss_m1|s2_vss_m1|s3_vss_m1|s4_vss_m1|vss|vss_x1|vss_x2|vss_x3
+ 223.588896053
* device instance g_vss_m1_mph_g_s1_vss_m1_s2_vss_m1_s3_vss_m1_s4_vss_m1_vss_vss_x1_vss_x2_vss_x3_t79 r0 *1 0,0
Rg_vss_m1_mph_g_s1_vss_m1_s2_vss_m1_s3_vss_m1_s4_vss_m1_vss_vss_x1_vss_x2_vss_x3_t79
+ g_vss_m1|mph_g|s1_vss_m1|s2_vss_m1|s3_vss_m1|s4_vss_m1|vss|vss_x1|vss_x2|vss_x3__t79
+ g_vss_m1|mph_g|s1_vss_m1|s2_vss_m1|s3_vss_m1|s4_vss_m1|vss|vss_x1|vss_x2|vss_x3
+ 267.131579199
* device instance g_vss_m1_mph_g_s1_vss_m1_s2_vss_m1_s3_vss_m1_s4_vss_m1_vss_vss_x1_vss_x2_vss_x3_t80 r0 *1 0,0
Rg_vss_m1_mph_g_s1_vss_m1_s2_vss_m1_s3_vss_m1_s4_vss_m1_vss_vss_x1_vss_x2_vss_x3_t80
+ g_vss_m1|mph_g|s1_vss_m1|s2_vss_m1|s3_vss_m1|s4_vss_m1|vss|vss_x1|vss_x2|vss_x3__t80
+ g_vss_m1|mph_g|s1_vss_m1|s2_vss_m1|s3_vss_m1|s4_vss_m1|vss|vss_x1|vss_x2|vss_x3
+ 310.736928789
* device instance g_vss_m1_mph_g_s1_vss_m1_s2_vss_m1_s3_vss_m1_s4_vss_m1_vss_vss_x1_vss_x2_vss_x3_t81 r0 *1 0,0
Rg_vss_m1_mph_g_s1_vss_m1_s2_vss_m1_s3_vss_m1_s4_vss_m1_vss_vss_x1_vss_x2_vss_x3_t81
+ g_vss_m1|mph_g|s1_vss_m1|s2_vss_m1|s3_vss_m1|s4_vss_m1|vss|vss_x1|vss_x2|vss_x3__t81
+ g_vss_m1|mph_g|s1_vss_m1|s2_vss_m1|s3_vss_m1|s4_vss_m1|vss|vss_x1|vss_x2|vss_x3
+ 425.441212982
* device instance g_vss_m1_mph_g_s1_vss_m1_s2_vss_m1_s3_vss_m1_s4_vss_m1_vss_vss_x1_vss_x2_vss_x3_t82 r0 *1 0,0
Rg_vss_m1_mph_g_s1_vss_m1_s2_vss_m1_s3_vss_m1_s4_vss_m1_vss_vss_x1_vss_x2_vss_x3_t82
+ g_vss_m1|mph_g|s1_vss_m1|s2_vss_m1|s3_vss_m1|s4_vss_m1|vss|vss_x1|vss_x2|vss_x3__t82
+ g_vss_m1|mph_g|s1_vss_m1|s2_vss_m1|s3_vss_m1|s4_vss_m1|vss|vss_x1|vss_x2|vss_x3
+ 475.154891311
* device instance g_vss_m1_mph_g_s1_vss_m1_s2_vss_m1_s3_vss_m1_s4_vss_m1_vss_vss_x1_vss_x2_vss_x3_t83 r0 *1 0,0
Rg_vss_m1_mph_g_s1_vss_m1_s2_vss_m1_s3_vss_m1_s4_vss_m1_vss_vss_x1_vss_x2_vss_x3_t83
+ g_vss_m1|mph_g|s1_vss_m1|s2_vss_m1|s3_vss_m1|s4_vss_m1|vss|vss_x1|vss_x2|vss_x3__t83
+ g_vss_m1|mph_g|s1_vss_m1|s2_vss_m1|s3_vss_m1|s4_vss_m1|vss|vss_x1|vss_x2|vss_x3
+ 518.866667785
* device instance g_vss_m1_mph_g_s1_vss_m1_s2_vss_m1_s3_vss_m1_s4_vss_m1_vss_vss_x1_vss_x2_vss_x3_t84 r0 *1 0,0
Rg_vss_m1_mph_g_s1_vss_m1_s2_vss_m1_s3_vss_m1_s4_vss_m1_vss_vss_x1_vss_x2_vss_x3_t84
+ g_vss_m1|mph_g|s1_vss_m1|s2_vss_m1|s3_vss_m1|s4_vss_m1|vss|vss_x1|vss_x2|vss_x3__t84
+ g_vss_m1|mph_g|s1_vss_m1|s2_vss_m1|s3_vss_m1|s4_vss_m1|vss|vss_x1|vss_x2|vss_x3
+ 562.586828214
* device instance g_vss_m1_mph_g_s1_vss_m1_s2_vss_m1_s3_vss_m1_s4_vss_m1_vss_vss_x1_vss_x2_vss_x3_t85 r0 *1 0,0
Rg_vss_m1_mph_g_s1_vss_m1_s2_vss_m1_s3_vss_m1_s4_vss_m1_vss_vss_x1_vss_x2_vss_x3_t85
+ g_vss_m1|mph_g|s1_vss_m1|s2_vss_m1|s3_vss_m1|s4_vss_m1|vss|vss_x1|vss_x2|vss_x3__t85
+ g_vss_m1|mph_g|s1_vss_m1|s2_vss_m1|s3_vss_m1|s4_vss_m1|vss|vss_x1|vss_x2|vss_x3
+ 606.313558946
* device instance g_vss_m1_mph_g_s1_vss_m1_s2_vss_m1_s3_vss_m1_s4_vss_m1_vss_vss_x1_vss_x2_vss_x3_t86 r0 *1 0,0
Rg_vss_m1_mph_g_s1_vss_m1_s2_vss_m1_s3_vss_m1_s4_vss_m1_vss_vss_x1_vss_x2_vss_x3_t86
+ g_vss_m1|mph_g|s1_vss_m1|s2_vss_m1|s3_vss_m1|s4_vss_m1|vss|vss_x1|vss_x2|vss_x3__t86
+ g_vss_m1|mph_g|s1_vss_m1|s2_vss_m1|s3_vss_m1|s4_vss_m1|vss|vss_x1|vss_x2|vss_x3
+ 464.089953628
* device instance g_vss_m1_mph_g_s1_vss_m1_s2_vss_m1_s3_vss_m1_s4_vss_m1_vss_vss_x1_vss_x2_vss_x3_t87 r0 *1 0,0
Rg_vss_m1_mph_g_s1_vss_m1_s2_vss_m1_s3_vss_m1_s4_vss_m1_vss_vss_x1_vss_x2_vss_x3_t87
+ g_vss_m1|mph_g|s1_vss_m1|s2_vss_m1|s3_vss_m1|s4_vss_m1|vss|vss_x1|vss_x2|vss_x3__t87
+ g_vss_m1|mph_g|s1_vss_m1|s2_vss_m1|s3_vss_m1|s4_vss_m1|vss|vss_x1|vss_x2|vss_x3
+ 414.38010702
* device instance g_vss_m1_mph_g_s1_vss_m1_s2_vss_m1_s3_vss_m1_s4_vss_m1_vss_vss_x1_vss_x2_vss_x3_t88 r0 *1 0,0
Rg_vss_m1_mph_g_s1_vss_m1_s2_vss_m1_s3_vss_m1_s4_vss_m1_vss_vss_x1_vss_x2_vss_x3_t88
+ g_vss_m1|mph_g|s1_vss_m1|s2_vss_m1|s3_vss_m1|s4_vss_m1|vss|vss_x1|vss_x2|vss_x3__t88
+ g_vss_m1|mph_g|s1_vss_m1|s2_vss_m1|s3_vss_m1|s4_vss_m1|vss|vss_x1|vss_x2|vss_x3
+ 370.700982966
* device instance g_vss_m1_mph_g_s1_vss_m1_s2_vss_m1_s3_vss_m1_s4_vss_m1_vss_vss_x1_vss_x2_vss_x3_t89 r0 *1 0,0
Rg_vss_m1_mph_g_s1_vss_m1_s2_vss_m1_s3_vss_m1_s4_vss_m1_vss_vss_x1_vss_x2_vss_x3_t89
+ g_vss_m1|mph_g|s1_vss_m1|s2_vss_m1|s3_vss_m1|s4_vss_m1|vss|vss_x1|vss_x2|vss_x3__t89
+ g_vss_m1|mph_g|s1_vss_m1|s2_vss_m1|s3_vss_m1|s4_vss_m1|vss|vss_x1|vss_x2|vss_x3
+ 327.045006981
* device instance g_vss_m1_mph_g_s1_vss_m1_s2_vss_m1_s3_vss_m1_s4_vss_m1_vss_vss_x1_vss_x2_vss_x3_t90 r0 *1 0,0
Rg_vss_m1_mph_g_s1_vss_m1_s2_vss_m1_s3_vss_m1_s4_vss_m1_vss_vss_x1_vss_x2_vss_x3_t90
+ g_vss_m1|mph_g|s1_vss_m1|s2_vss_m1|s3_vss_m1|s4_vss_m1|vss|vss_x1|vss_x2|vss_x3__t90
+ g_vss_m1|mph_g|s1_vss_m1|s2_vss_m1|s3_vss_m1|s4_vss_m1|vss|vss_x1|vss_x2|vss_x3
+ 283.422875842
* device instance g_vss_m1_mph_g_s1_vss_m1_s2_vss_m1_s3_vss_m1_s4_vss_m1_vss_vss_x1_vss_x2_vss_x3_t91 r0 *1 0,0
Rg_vss_m1_mph_g_s1_vss_m1_s2_vss_m1_s3_vss_m1_s4_vss_m1_vss_vss_x1_vss_x2_vss_x3_t91
+ g_vss_m1|mph_g|s1_vss_m1|s2_vss_m1|s3_vss_m1|s4_vss_m1|vss|vss_x1|vss_x2|vss_x3__t91
+ g_vss_m1|mph_g|s1_vss_m1|s2_vss_m1|s3_vss_m1|s4_vss_m1|vss|vss_x1|vss_x2|vss_x3
+ 400.459508327
* device instance g_vss_m1_mph_g_s1_vss_m1_s2_vss_m1_s3_vss_m1_s4_vss_m1_vss_vss_x1_vss_x2_vss_x3_t92 r0 *1 0,0
Rg_vss_m1_mph_g_s1_vss_m1_s2_vss_m1_s3_vss_m1_s4_vss_m1_vss_vss_x1_vss_x2_vss_x3_t92
+ g_vss_m1|mph_g|s1_vss_m1|s2_vss_m1|s3_vss_m1|s4_vss_m1|vss|vss_x1|vss_x2|vss_x3__t92
+ g_vss_m1|mph_g|s1_vss_m1|s2_vss_m1|s3_vss_m1|s4_vss_m1|vss|vss_x1|vss_x2|vss_x3
+ 356.786894214
* device instance g_vss_m1_mph_g_s1_vss_m1_s2_vss_m1_s3_vss_m1_s4_vss_m1_vss_vss_x1_vss_x2_vss_x3_t93 r0 *1 0,0
Rg_vss_m1_mph_g_s1_vss_m1_s2_vss_m1_s3_vss_m1_s4_vss_m1_vss_vss_x1_vss_x2_vss_x3_t93
+ g_vss_m1|mph_g|s1_vss_m1|s2_vss_m1|s3_vss_m1|s4_vss_m1|vss|vss_x1|vss_x2|vss_x3__t93
+ g_vss_m1|mph_g|s1_vss_m1|s2_vss_m1|s3_vss_m1|s4_vss_m1|vss|vss_x1|vss_x2|vss_x3
+ 313.140272236
* device instance g_vss_m1_mph_g_s1_vss_m1_s2_vss_m1_s3_vss_m1_s4_vss_m1_vss_vss_x1_vss_x2_vss_x3_t94 r0 *1 0,0
Rg_vss_m1_mph_g_s1_vss_m1_s2_vss_m1_s3_vss_m1_s4_vss_m1_vss_vss_x1_vss_x2_vss_x3_t94
+ g_vss_m1|mph_g|s1_vss_m1|s2_vss_m1|s3_vss_m1|s4_vss_m1|vss|vss_x1|vss_x2|vss_x3__t94
+ g_vss_m1|mph_g|s1_vss_m1|s2_vss_m1|s3_vss_m1|s4_vss_m1|vss|vss_x1|vss_x2|vss_x3
+ 269.532269775
* device instance g_vss_m1_mph_g_s1_vss_m1_s2_vss_m1_s3_vss_m1_s4_vss_m1_vss_vss_x1_vss_x2_vss_x3_t95 r0 *1 0,0
Rg_vss_m1_mph_g_s1_vss_m1_s2_vss_m1_s3_vss_m1_s4_vss_m1_vss_vss_x1_vss_x2_vss_x3_t95
+ g_vss_m1|mph_g|s1_vss_m1|s2_vss_m1|s3_vss_m1|s4_vss_m1|vss|vss_x1|vss_x2|vss_x3__t95
+ g_vss_m1|mph_g|s1_vss_m1|s2_vss_m1|s3_vss_m1|s4_vss_m1|vss|vss_x1|vss_x2|vss_x3
+ 222.553076072
* device instance g_vss_m1_mph_g_s1_vss_m1_s2_vss_m1_s3_vss_m1_s4_vss_m1_vss_vss_x1_vss_x2_vss_x3_t96 r0 *1 0,0
Rg_vss_m1_mph_g_s1_vss_m1_s2_vss_m1_s3_vss_m1_s4_vss_m1_vss_vss_x1_vss_x2_vss_x3_t96
+ g_vss_m1|mph_g|s1_vss_m1|s2_vss_m1|s3_vss_m1|s4_vss_m1|vss|vss_x1|vss_x2|vss_x3__t96
+ g_vss_m1|mph_g|s1_vss_m1|s2_vss_m1|s3_vss_m1|s4_vss_m1|vss|vss_x1|vss_x2|vss_x3
+ 106.535038735
* device instance g_vss_m1_mph_g_s1_vss_m1_s2_vss_m1_s3_vss_m1_s4_vss_m1_vss_vss_x1_vss_x2_vss_x3_t97 r0 *1 0,0
Rg_vss_m1_mph_g_s1_vss_m1_s2_vss_m1_s3_vss_m1_s4_vss_m1_vss_vss_x1_vss_x2_vss_x3_t97
+ g_vss_m1|mph_g|s1_vss_m1|s2_vss_m1|s3_vss_m1|s4_vss_m1|vss|vss_x1|vss_x2|vss_x3__t97
+ g_vss_m1|mph_g|s1_vss_m1|s2_vss_m1|s3_vss_m1|s4_vss_m1|vss|vss_x1|vss_x2|vss_x3
+ 64.7519785448
* device instance g_vss_m1_mph_g_s1_vss_m1_s2_vss_m1_s3_vss_m1_s4_vss_m1_vss_vss_x1_vss_x2_vss_x3_t98 r0 *1 0,0
Rg_vss_m1_mph_g_s1_vss_m1_s2_vss_m1_s3_vss_m1_s4_vss_m1_vss_vss_x1_vss_x2_vss_x3_t98
+ g_vss_m1|mph_g|s1_vss_m1|s2_vss_m1|s3_vss_m1|s4_vss_m1|vss|vss_x1|vss_x2|vss_x3__t98
+ g_vss_m1|mph_g|s1_vss_m1|s2_vss_m1|s3_vss_m1|s4_vss_m1|vss|vss_x1|vss_x2|vss_x3
+ 29.441384364
* device instance g_vss_m1_mph_g_s1_vss_m1_s2_vss_m1_s3_vss_m1_s4_vss_m1_vss_vss_x1_vss_x2_vss_x3_t99 r0 *1 0,0
Rg_vss_m1_mph_g_s1_vss_m1_s2_vss_m1_s3_vss_m1_s4_vss_m1_vss_vss_x1_vss_x2_vss_x3_t99
+ g_vss_m1|mph_g|s1_vss_m1|s2_vss_m1|s3_vss_m1|s4_vss_m1|vss|vss_x1|vss_x2|vss_x3__t99
+ g_vss_m1|mph_g|s1_vss_m1|s2_vss_m1|s3_vss_m1|s4_vss_m1|vss|vss_x1|vss_x2|vss_x3
+ 37.0357076572
* device instance g_vss_m1_mph_g_s1_vss_m1_s2_vss_m1_s3_vss_m1_s4_vss_m1_vss_vss_x1_vss_x2_vss_x3_t100 r0 *1 0,0
Rg_vss_m1_mph_g_s1_vss_m1_s2_vss_m1_s3_vss_m1_s4_vss_m1_vss_vss_x1_vss_x2_vss_x3_t100
+ g_vss_m1|mph_g|s1_vss_m1|s2_vss_m1|s3_vss_m1|s4_vss_m1|vss|vss_x1|vss_x2|vss_x3__t100
+ g_vss_m1|mph_g|s1_vss_m1|s2_vss_m1|s3_vss_m1|s4_vss_m1|vss|vss_x1|vss_x2|vss_x3
+ 78.8194046975
* device instance g_vss_m1_mph_g_s1_vss_m1_s2_vss_m1_s3_vss_m1_s4_vss_m1_vss_vss_x1_vss_x2_vss_x3_t101 r0 *1 0,0
Rg_vss_m1_mph_g_s1_vss_m1_s2_vss_m1_s3_vss_m1_s4_vss_m1_vss_vss_x1_vss_x2_vss_x3_t101
+ g_vss_m1|mph_g|s1_vss_m1|s2_vss_m1|s3_vss_m1|s4_vss_m1|vss|vss_x1|vss_x2|vss_x3__t101
+ g_vss_m1|mph_g|s1_vss_m1|s2_vss_m1|s3_vss_m1|s4_vss_m1|vss|vss_x1|vss_x2|vss_x3
+ 193.978784729
* device instance g_vss_m1_mph_g_s1_vss_m1_s2_vss_m1_s3_vss_m1_s4_vss_m1_vss_vss_x1_vss_x2_vss_x3_t102 r0 *1 0,0
Rg_vss_m1_mph_g_s1_vss_m1_s2_vss_m1_s3_vss_m1_s4_vss_m1_vss_vss_x1_vss_x2_vss_x3_t102
+ g_vss_m1|mph_g|s1_vss_m1|s2_vss_m1|s3_vss_m1|s4_vss_m1|vss|vss_x1|vss_x2|vss_x3__t102
+ g_vss_m1|mph_g|s1_vss_m1|s2_vss_m1|s3_vss_m1|s4_vss_m1|vss|vss_x1|vss_x2|vss_x3
+ 237.455063847
* device instance g_vss_m1_mph_g_s1_vss_m1_s2_vss_m1_s3_vss_m1_s4_vss_m1_vss_vss_x1_vss_x2_vss_x3_t103 r0 *1 0,0
Rg_vss_m1_mph_g_s1_vss_m1_s2_vss_m1_s3_vss_m1_s4_vss_m1_vss_vss_x1_vss_x2_vss_x3_t103
+ g_vss_m1|mph_g|s1_vss_m1|s2_vss_m1|s3_vss_m1|s4_vss_m1|vss|vss_x1|vss_x2|vss_x3__t103
+ g_vss_m1|mph_g|s1_vss_m1|s2_vss_m1|s3_vss_m1|s4_vss_m1|vss|vss_x1|vss_x2|vss_x3
+ 281.021205443
* device instance g_vss_m1_mph_g_s1_vss_m1_s2_vss_m1_s3_vss_m1_s4_vss_m1_vss_vss_x1_vss_x2_vss_x3_t104 r0 *1 0,0
Rg_vss_m1_mph_g_s1_vss_m1_s2_vss_m1_s3_vss_m1_s4_vss_m1_vss_vss_x1_vss_x2_vss_x3_t104
+ g_vss_m1|mph_g|s1_vss_m1|s2_vss_m1|s3_vss_m1|s4_vss_m1|vss|vss_x1|vss_x2|vss_x3__t104
+ g_vss_m1|mph_g|s1_vss_m1|s2_vss_m1|s3_vss_m1|s4_vss_m1|vss|vss_x1|vss_x2|vss_x3
+ 324.641033468
* device instance g_vss_m1_mph_g_s1_vss_m1_s2_vss_m1_s3_vss_m1_s4_vss_m1_vss_vss_x1_vss_x2_vss_x3_t105 r0 *1 0,0
Rg_vss_m1_mph_g_s1_vss_m1_s2_vss_m1_s3_vss_m1_s4_vss_m1_vss_vss_x1_vss_x2_vss_x3_t105
+ g_vss_m1|mph_g|s1_vss_m1|s2_vss_m1|s3_vss_m1|s4_vss_m1|vss|vss_x1|vss_x2|vss_x3__t105
+ g_vss_m1|mph_g|s1_vss_m1|s2_vss_m1|s3_vss_m1|s4_vss_m1|vss|vss_x1|vss_x2|vss_x3
+ 371.740881829
* device instance g_vss_m1_mph_g_s1_vss_m1_s2_vss_m1_s3_vss_m1_s4_vss_m1_vss_vss_x1_vss_x2_vss_x3_t106 r0 *1 0,0
Rg_vss_m1_mph_g_s1_vss_m1_s2_vss_m1_s3_vss_m1_s4_vss_m1_vss_vss_x1_vss_x2_vss_x3_t106
+ g_vss_m1|mph_g|s1_vss_m1|s2_vss_m1|s3_vss_m1|s4_vss_m1|vss|vss_x1|vss_x2|vss_x3__t106
+ g_vss_m1|mph_g|s1_vss_m1|s2_vss_m1|s3_vss_m1|s4_vss_m1|vss|vss_x1|vss_x2|vss_x3
+ 489.082795803
* device instance g_vss_m1_mph_g_s1_vss_m1_s2_vss_m1_s3_vss_m1_s4_vss_m1_vss_vss_x1_vss_x2_vss_x3_t107 r0 *1 0,0
Rg_vss_m1_mph_g_s1_vss_m1_s2_vss_m1_s3_vss_m1_s4_vss_m1_vss_vss_x1_vss_x2_vss_x3_t107
+ g_vss_m1|mph_g|s1_vss_m1|s2_vss_m1|s3_vss_m1|s4_vss_m1|vss|vss_x1|vss_x2|vss_x3__t107
+ g_vss_m1|mph_g|s1_vss_m1|s2_vss_m1|s3_vss_m1|s4_vss_m1|vss|vss_x1|vss_x2|vss_x3
+ 532.79747911
* device instance g_vss_m1_mph_g_s1_vss_m1_s2_vss_m1_s3_vss_m1_s4_vss_m1_vss_vss_x1_vss_x2_vss_x3_t108 r0 *1 0,0
Rg_vss_m1_mph_g_s1_vss_m1_s2_vss_m1_s3_vss_m1_s4_vss_m1_vss_vss_x1_vss_x2_vss_x3_t108
+ g_vss_m1|mph_g|s1_vss_m1|s2_vss_m1|s3_vss_m1|s4_vss_m1|vss|vss_x1|vss_x2|vss_x3__t108
+ g_vss_m1|mph_g|s1_vss_m1|s2_vss_m1|s3_vss_m1|s4_vss_m1|vss|vss_x1|vss_x2|vss_x3
+ 576.519902937
* device instance g_vss_m1_mph_g_s1_vss_m1_s2_vss_m1_s3_vss_m1_s4_vss_m1_vss_vss_x1_vss_x2_vss_x3_t109 r0 *1 0,0
Rg_vss_m1_mph_g_s1_vss_m1_s2_vss_m1_s3_vss_m1_s4_vss_m1_vss_vss_x1_vss_x2_vss_x3_t109
+ g_vss_m1|mph_g|s1_vss_m1|s2_vss_m1|s3_vss_m1|s4_vss_m1|vss|vss_x1|vss_x2|vss_x3__t109
+ g_vss_m1|mph_g|s1_vss_m1|s2_vss_m1|s3_vss_m1|s4_vss_m1|vss|vss_x1|vss_x2|vss_x3
+ 620.248430356
* device instance g_vss_m1_mph_g_s1_vss_m1_s2_vss_m1_s3_vss_m1_s4_vss_m1_vss_vss_x1_vss_x2_vss_x3_t110 r0 *1 0,0
Rg_vss_m1_mph_g_s1_vss_m1_s2_vss_m1_s3_vss_m1_s4_vss_m1_vss_vss_x1_vss_x2_vss_x3_t110
+ g_vss_m1|mph_g|s1_vss_m1|s2_vss_m1|s3_vss_m1|s4_vss_m1|vss|vss_x1|vss_x2|vss_x3__t110
+ g_vss_m1|mph_g|s1_vss_m1|s2_vss_m1|s3_vss_m1|s4_vss_m1|vss|vss_x1|vss_x2|vss_x3
+ 667.432562636
* device instance g_vss_m1_mph_g_s1_vss_m1_s2_vss_m1_s3_vss_m1_s4_vss_m1_vss_vss_x1_vss_x2_vss_x3_t111 r0 *1 0,0
Rg_vss_m1_mph_g_s1_vss_m1_s2_vss_m1_s3_vss_m1_s4_vss_m1_vss_vss_x1_vss_x2_vss_x3_t111
+ g_vss_m1|mph_g|s1_vss_m1|s2_vss_m1|s3_vss_m1|s4_vss_m1|vss|vss_x1|vss_x2|vss_x3__t111
+ g_vss_m1|mph_g|s1_vss_m1|s2_vss_m1|s3_vss_m1|s4_vss_m1|vss|vss_x1|vss_x2|vss_x3
+ 469.57949473
* device instance g_vss_m1_mph_g_s1_vss_m1_s2_vss_m1_s3_vss_m1_s4_vss_m1_vss_vss_x1_vss_x2_vss_x3_t112 r0 *1 0,0
Rg_vss_m1_mph_g_s1_vss_m1_s2_vss_m1_s3_vss_m1_s4_vss_m1_vss_vss_x1_vss_x2_vss_x3_t112
+ g_vss_m1|mph_g|s1_vss_m1|s2_vss_m1|s3_vss_m1|s4_vss_m1|vss|vss_x1|vss_x2|vss_x3__t112
+ g_vss_m1|mph_g|s1_vss_m1|s2_vss_m1|s3_vss_m1|s4_vss_m1|vss|vss_x1|vss_x2|vss_x3
+ 373.650240334
* device instance g_vss_m1_mph_g_s1_vss_m1_s2_vss_m1_s3_vss_m1_s4_vss_m1_vss_vss_x1_vss_x2_vss_x3_t113 r0 *1 0,0
Rg_vss_m1_mph_g_s1_vss_m1_s2_vss_m1_s3_vss_m1_s4_vss_m1_vss_vss_x1_vss_x2_vss_x3_t113
+ g_vss_m1|mph_g|s1_vss_m1|s2_vss_m1|s3_vss_m1|s4_vss_m1|vss|vss_x1|vss_x2|vss_x3__t113
+ g_vss_m1|mph_g|s1_vss_m1|s2_vss_m1|s3_vss_m1|s4_vss_m1|vss|vss_x1|vss_x2|vss_x3
+ 317.069450978
* device instance g_vss_m1_mph_g_s1_vss_m1_s2_vss_m1_s3_vss_m1_s4_vss_m1_vss_vss_x1_vss_x2_vss_x3_t114 r0 *1 0,0
Rg_vss_m1_mph_g_s1_vss_m1_s2_vss_m1_s3_vss_m1_s4_vss_m1_vss_vss_x1_vss_x2_vss_x3_t114
+ g_vss_m1|mph_g|s1_vss_m1|s2_vss_m1|s3_vss_m1|s4_vss_m1|vss|vss_x1|vss_x2|vss_x3__t114
+ g_vss_m1|mph_g|s1_vss_m1|s2_vss_m1|s3_vss_m1|s4_vss_m1|vss|vss_x1|vss_x2|vss_x3
+ 223.213868032
* device instance g_vss_m1_mph_g_s1_vss_m1_s2_vss_m1_s3_vss_m1_s4_vss_m1_vss_vss_x1_vss_x2_vss_x3_t115 r0 *1 0,0
Rg_vss_m1_mph_g_s1_vss_m1_s2_vss_m1_s3_vss_m1_s4_vss_m1_vss_vss_x1_vss_x2_vss_x3_t115
+ g_vss_m1|mph_g|s1_vss_m1|s2_vss_m1|s3_vss_m1|s4_vss_m1|vss|vss_x1|vss_x2|vss_x3__t115
+ g_vss_m1|mph_g|s1_vss_m1|s2_vss_m1|s3_vss_m1|s4_vss_m1|vss|vss_x1|vss_x2|vss_x3
+ 169.320328119
* device instance g_vss_m1_mph_g_s1_vss_m1_s2_vss_m1_s3_vss_m1_s4_vss_m1_vss_vss_x1_vss_x2_vss_x3_t116 r0 *1 0,0
Rg_vss_m1_mph_g_s1_vss_m1_s2_vss_m1_s3_vss_m1_s4_vss_m1_vss_vss_x1_vss_x2_vss_x3_t116
+ g_vss_m1|mph_g|s1_vss_m1|s2_vss_m1|s3_vss_m1|s4_vss_m1|vss|vss_x1|vss_x2|vss_x3__t116
+ g_vss_m1|mph_g|s1_vss_m1|s2_vss_m1|s3_vss_m1|s4_vss_m1|vss|vss_x1|vss_x2|vss_x3
+ 90.2361433158
* device instance g_vss_m1_mph_g_s1_vss_m1_s2_vss_m1_s3_vss_m1_s4_vss_m1_vss_vss_x1_vss_x2_vss_x3_t117 r0 *1 0,0
Rg_vss_m1_mph_g_s1_vss_m1_s2_vss_m1_s3_vss_m1_s4_vss_m1_vss_vss_x1_vss_x2_vss_x3_t117
+ g_vss_m1|mph_g|s1_vss_m1|s2_vss_m1|s3_vss_m1|s4_vss_m1|vss|vss_x1|vss_x2|vss_x3__t117
+ g_vss_m1|mph_g|s1_vss_m1|s2_vss_m1|s3_vss_m1|s4_vss_m1|vss|vss_x1|vss_x2|vss_x3
+ 169.185029368
* device instance g_vss_m1_mph_g_s1_vss_m1_s2_vss_m1_s3_vss_m1_s4_vss_m1_vss_vss_x1_vss_x2_vss_x3_t118 r0 *1 0,0
Rg_vss_m1_mph_g_s1_vss_m1_s2_vss_m1_s3_vss_m1_s4_vss_m1_vss_vss_x1_vss_x2_vss_x3_t118
+ g_vss_m1|mph_g|s1_vss_m1|s2_vss_m1|s3_vss_m1|s4_vss_m1|vss|vss_x1|vss_x2|vss_x3__t118
+ g_vss_m1|mph_g|s1_vss_m1|s2_vss_m1|s3_vss_m1|s4_vss_m1|vss|vss_x1|vss_x2|vss_x3
+ 120.146360175
* device instance g_vss_m1_mph_g_s1_vss_m1_s2_vss_m1_s3_vss_m1_s4_vss_m1_vss_vss_x1_vss_x2_vss_x3_t119 r0 *1 0,0
Rg_vss_m1_mph_g_s1_vss_m1_s2_vss_m1_s3_vss_m1_s4_vss_m1_vss_vss_x1_vss_x2_vss_x3_t119
+ g_vss_m1|mph_g|s1_vss_m1|s2_vss_m1|s3_vss_m1|s4_vss_m1|vss|vss_x1|vss_x2|vss_x3__t119
+ g_vss_m1|mph_g|s1_vss_m1|s2_vss_m1|s3_vss_m1|s4_vss_m1|vss|vss_x1|vss_x2|vss_x3
+ 77.8301208781
* device instance g_vss_m1_mph_g_s1_vss_m1_s2_vss_m1_s3_vss_m1_s4_vss_m1_vss_vss_x1_vss_x2_vss_x3_t120 r0 *1 0,0
Rg_vss_m1_mph_g_s1_vss_m1_s2_vss_m1_s3_vss_m1_s4_vss_m1_vss_vss_x1_vss_x2_vss_x3_t120
+ g_vss_m1|mph_g|s1_vss_m1|s2_vss_m1|s3_vss_m1|s4_vss_m1|vss|vss_x1|vss_x2|vss_x3__t120
+ g_vss_m1|mph_g|s1_vss_m1|s2_vss_m1|s3_vss_m1|s4_vss_m1|vss|vss_x1|vss_x2|vss_x3
+ 38.868749775
* device instance g_vss_m1_mph_g_s1_vss_m1_s2_vss_m1_s3_vss_m1_s4_vss_m1_vss_vss_x1_vss_x2_vss_x3_t121 r0 *1 0,0
Rg_vss_m1_mph_g_s1_vss_m1_s2_vss_m1_s3_vss_m1_s4_vss_m1_vss_vss_x1_vss_x2_vss_x3_t121
+ g_vss_m1|mph_g|s1_vss_m1|s2_vss_m1|s3_vss_m1|s4_vss_m1|vss|vss_x1|vss_x2|vss_x3__t121
+ g_vss_m1|mph_g|s1_vss_m1|s2_vss_m1|s3_vss_m1|s4_vss_m1|vss|vss_x1|vss_x2|vss_x3
+ 28.1940391363
* device instance g_vss_m1_mph_g_s1_vss_m1_s2_vss_m1_s3_vss_m1_s4_vss_m1_vss_vss_x1_vss_x2_vss_x3 r0 *1 0,0
Cg_vss_m1_mph_g_s1_vss_m1_s2_vss_m1_s3_vss_m1_s4_vss_m1_vss_vss_x1_vss_x2_vss_x3
+ g_vss_m1|mph_g|s1_vss_m1|s2_vss_m1|s3_vss_m1|s4_vss_m1|vss|vss_x1|vss_x2|vss_x3
+ vsubs 1.13344717e-13
* device instance mid_t0 r0 *1 0,0
Rmid_t0 mid__t0 mid 149.893184895
* device instance mid_t1 r0 *1 0,0
Rmid_t1 mid__t1 mid 180.889615105
* device instance mid_t2 r0 *1 0,0
Rmid_t2 mid__t2 mid 149.893184895
* device instance mid_t3 r0 *1 0,0
Rmid_t3 mid__t3 mid 180.889615105
* device instance mid r0 *1 0,0
Cmid mid vsubs 1.103314e-15
* device instance mid_dup1_t0 r0 *1 0,0
Rmid_dup1_t0 mid__t02 mid$1 180.889615105
* device instance mid_dup1_t1 r0 *1 0,0
Rmid_dup1_t1 mid__t12 mid$1 149.893184895
* device instance mid_dup1_t2 r0 *1 0,0
Rmid_dup1_t2 mid__t22 mid$1 149.893184895
* device instance mid_dup1_t3 r0 *1 0,0
Rmid_dup1_t3 mid__t32 mid$1 180.889615105
* device instance mid_dup1 r0 *1 0,0
Cmid_dup1 mid$1 vsubs 1.101742e-15
* device instance mid_dup2_t0 r0 *1 0,0
Rmid_dup2_t0 mid__t03 mid$2 149.893184895
* device instance mid_dup2_t1 r0 *1 0,0
Rmid_dup2_t1 mid__t13 mid$2 180.889615105
* device instance mid_dup2_t2 r0 *1 0,0
Rmid_dup2_t2 mid__t23 mid$2 180.889615105
* device instance mid_dup2_t3 r0 *1 0,0
Rmid_dup2_t3 mid__t33 mid$2 149.893184895
* device instance mid_dup2 r0 *1 0,0
Cmid_dup2 mid$2 vsubs 1.104383e-15
* device instance mpa_py_mpb_py_mph_py_py_t0 r0 *1 0,0
Rmpa_py_mpb_py_mph_py_py_t0 mpa_py|mpb_py|mph_py|py__t0 mpa_py|mpb_py|mph_py|py
+ 33.64835
* device instance mpa_py_mpb_py_mph_py_py_t1 r0 *1 0,0
Rmpa_py_mpb_py_mph_py_py_t1 mpa_py|mpb_py|mph_py|py__t1 mpa_py|mpb_py|mph_py|py
+ 5.23884452847
* device instance mpa_py_mpb_py_mph_py_py_t2 r0 *1 0,0
Rmpa_py_mpb_py_mph_py_py_t2 mpa_py|mpb_py|mph_py|py__t2 mpa_py|mpb_py|mph_py|py
+ 28.4095054715
* device instance mpa_py_mpb_py_mph_py_py r0 *1 0,0
Cmpa_py_mpb_py_mph_py_py mpa_py|mpb_py|mph_py|py vsubs 7.94002e-16
* device instance mpa_py_mpb_py_mph_py_py_dup1_t0 r0 *1 0,0
Rmpa_py_mpb_py_mph_py_py_dup1_t0 mpa_py|mpb_py|mph_py|py__t02
+ mpa_py|mpb_py|mph_py|py$1 33.9531
* device instance mpa_py_mpb_py_mph_py_py_dup1_t1 r0 *1 0,0
Rmpa_py_mpb_py_mph_py_py_dup1_t1 mpa_py|mpb_py|mph_py|py__t12
+ mpa_py|mpb_py|mph_py|py$1 28.6668077402
* device instance mpa_py_mpb_py_mph_py_py_dup1_t2 r0 *1 0,0
Rmpa_py_mpb_py_mph_py_py_dup1_t2 mpa_py|mpb_py|mph_py|py__t22
+ mpa_py|mpb_py|mph_py|py$1 5.28629225979
* device instance mpa_py_mpb_py_mph_py_py_dup1 r0 *1 0,0
Cmpa_py_mpb_py_mph_py_py_dup1 mpa_py|mpb_py|mph_py|py$1 vsubs 7.95941e-16
* device instance mpa_py_mpb_py_mph_py_py_dup2_t0 r0 *1 0,0
Rmpa_py_mpb_py_mph_py_py_dup2_t0 mpa_py|mpb_py|mph_py|py__t03
+ mpa_py|mpb_py|mph_py|py$2 34.25785
* device instance mpa_py_mpb_py_mph_py_py_dup2_t1 r0 *1 0,0
Rmpa_py_mpb_py_mph_py_py_dup2_t1 mpa_py|mpb_py|mph_py|py__t13
+ mpa_py|mpb_py|mph_py|py$2 28.9241100089
* device instance mpa_py_mpb_py_mph_py_py_dup2_t2 r0 *1 0,0
Rmpa_py_mpb_py_mph_py_py_dup2_t2 mpa_py|mpb_py|mph_py|py__t23
+ mpa_py|mpb_py|mph_py|py$2 5.3337399911
* device instance mpa_py_mpb_py_mph_py_py_dup2 r0 *1 0,0
Cmpa_py_mpb_py_mph_py_py_dup2 mpa_py|mpb_py|mph_py|py$2 vsubs 7.9788e-16
* device instance mpa_py_mpb_py_mph_py_py_dup3_t0 r0 *1 0,0
Rmpa_py_mpb_py_mph_py_py_dup3_t0 mpa_py|mpb_py|mph_py|py__t04
+ mpa_py|mpb_py|mph_py|py$3 34.5626
* device instance mpa_py_mpb_py_mph_py_py_dup3_t1 r0 *1 0,0
Rmpa_py_mpb_py_mph_py_py_dup3_t1 mpa_py|mpb_py|mph_py|py__t14
+ mpa_py|mpb_py|mph_py|py$3 29.1814122776
* device instance mpa_py_mpb_py_mph_py_py_dup3_t2 r0 *1 0,0
Rmpa_py_mpb_py_mph_py_py_dup3_t2 mpa_py|mpb_py|mph_py|py__t24
+ mpa_py|mpb_py|mph_py|py$3 5.38118772242
* device instance mpa_py_mpb_py_mph_py_py_dup3 r0 *1 0,0
Cmpa_py_mpb_py_mph_py_py_dup3 mpa_py|mpb_py|mph_py|py$3 vsubs 7.99818e-16
* device instance ny_t0 r0 *1 0,0
Rny_t0 ny__t0 ny 53.0227
* device instance ny_t1 r0 *1 0,0
Rny_t1 ny__t1 ny 53.0227
* device instance ny r0 *1 0,0
Cny ny vsubs 2.33681e-16
* device instance ny_dup1_t0 r0 *1 0,0
Rny_dup1_t0 ny__t02 ny$1 50.4787
* device instance ny_dup1_t1 r0 *1 0,0
Rny_dup1_t1 ny__t12 ny$1 50.4787
* device instance ny_dup1 r0 *1 0,0
Cny_dup1 ny$1 vsubs 1.89586e-16
* device instance ny_dup2_t0 r0 *1 0,0
Rny_dup2_t0 ny__t03 ny$2 50.4787
* device instance ny_dup2_t1 r0 *1 0,0
Rny_dup2_t1 ny__t13 ny$2 50.4787
* device instance ny_dup2 r0 *1 0,0
Cny_dup2 ny$2 vsubs 1.89586e-16
* device instance ny_dup3_t0 r0 *1 0,0
Rny_dup3_t0 ny__t04 ny$3 50.4787
* device instance ny_dup3_t1 r0 *1 0,0
Rny_dup3_t1 ny__t14 ny$3 50.4787
* device instance ny_dup3 r0 *1 0,0
Cny_dup3 ny$3 vsubs 1.89586e-16
* device instance ny_dup4_t0 r0 *1 0,0
Rny_dup4_t0 ny__t05 ny$4 50.4787
* device instance ny_dup4_t1 r0 *1 0,0
Rny_dup4_t1 ny__t15 ny$4 50.4787
* device instance ny_dup4 r0 *1 0,0
Cny_dup4 ny$4 vsubs 1.89586e-16
* device instance ny_dup5_t0 r0 *1 0,0
Rny_dup5_t0 ny__t06 ny$5 53.185
* device instance ny_dup5_t1 r0 *1 0,0
Rny_dup5_t1 ny__t16 ny$5 53.185
* device instance ny_dup5 r0 *1 0,0
Cny_dup5 ny$5 vsubs 2.3562e-16
* device instance ny_dup6_t0 r0 *1 0,0
Rny_dup6_t0 ny__t07 ny$6 50.51025
* device instance ny_dup6_t1 r0 *1 0,0
Rny_dup6_t1 ny__t17 ny$6 50.51025
* device instance ny_dup6 r0 *1 0,0
Cny_dup6 ny$6 vsubs 1.91525e-16
* device instance ny_dup7_t0 r0 *1 0,0
Rny_dup7_t0 ny__t08 ny$7 50.51025
* device instance ny_dup7_t1 r0 *1 0,0
Rny_dup7_t1 ny__t18 ny$7 50.51025
* device instance ny_dup7 r0 *1 0,0
Cny_dup7 ny$7 vsubs 1.91525e-16
* device instance ny_dup8_t0 r0 *1 0,0
Rny_dup8_t0 ny__t09 ny$8 50.51025
* device instance ny_dup8_t1 r0 *1 0,0
Rny_dup8_t1 ny__t19 ny$8 50.51025
* device instance ny_dup8 r0 *1 0,0
Cny_dup8 ny$8 vsubs 1.91525e-16
* device instance ny_dup9_t0 r0 *1 0,0
Rny_dup9_t0 ny__t010 ny$9 50.51025
* device instance ny_dup9_t1 r0 *1 0,0
Rny_dup9_t1 ny__t110 ny$9 50.51025
* device instance ny_dup9 r0 *1 0,0
Cny_dup9 ny$9 vsubs 1.91525e-16
* device instance ny_dup10_t0 r0 *1 0,0
Rny_dup10_t0 ny__t011 ny$10 53.351
* device instance ny_dup10_t1 r0 *1 0,0
Rny_dup10_t1 ny__t111 ny$10 53.351
* device instance ny_dup10 r0 *1 0,0
Cny_dup10 ny$10 vsubs 2.37559e-16
* device instance ny_dup11_t0 r0 *1 0,0
Rny_dup11_t0 ny__t012 ny$11 50.5516
* device instance ny_dup11_t1 r0 *1 0,0
Rny_dup11_t1 ny__t112 ny$11 50.5516
* device instance ny_dup11 r0 *1 0,0
Cny_dup11 ny$11 vsubs 1.93464e-16
* device instance ny_dup12_t0 r0 *1 0,0
Rny_dup12_t0 ny__t013 ny$12 50.5516
* device instance ny_dup12_t1 r0 *1 0,0
Rny_dup12_t1 ny__t113 ny$12 50.5516
* device instance ny_dup12 r0 *1 0,0
Cny_dup12 ny$12 vsubs 1.93464e-16
* device instance ny_dup13_t0 r0 *1 0,0
Rny_dup13_t0 ny__t014 ny$13 50.5516
* device instance ny_dup13_t1 r0 *1 0,0
Rny_dup13_t1 ny__t114 ny$13 50.5516
* device instance ny_dup13 r0 *1 0,0
Cny_dup13 ny$13 vsubs 1.93464e-16
* device instance ny_dup14_t0 r0 *1 0,0
Rny_dup14_t0 ny__t015 ny$14 50.5516
* device instance ny_dup14_t1 r0 *1 0,0
Rny_dup14_t1 ny__t115 ny$14 50.5516
* device instance ny_dup14 r0 *1 0,0
Cny_dup14 ny$14 vsubs 1.93464e-16
* device instance ny_dup15_t0 r0 *1 0,0
Rny_dup15_t0 ny__t016 ny$15 53.52065
* device instance ny_dup15_t1 r0 *1 0,0
Rny_dup15_t1 ny__t116 ny$15 53.52065
* device instance ny_dup15 r0 *1 0,0
Cny_dup15 ny$15 vsubs 2.39497e-16
* device instance ny_dup16_t0 r0 *1 0,0
Rny_dup16_t0 ny__t017 ny$16 50.6022
* device instance ny_dup16_t1 r0 *1 0,0
Rny_dup16_t1 ny__t117 ny$16 50.6022
* device instance ny_dup16 r0 *1 0,0
Cny_dup16 ny$16 vsubs 1.95403e-16
* device instance ny_dup17_t0 r0 *1 0,0
Rny_dup17_t0 ny__t018 ny$17 50.6022
* device instance ny_dup17_t1 r0 *1 0,0
Rny_dup17_t1 ny__t118 ny$17 50.6022
* device instance ny_dup17 r0 *1 0,0
Cny_dup17 ny$17 vsubs 1.95403e-16
* device instance ny_dup18_t0 r0 *1 0,0
Rny_dup18_t0 ny__t019 ny$18 50.6022
* device instance ny_dup18_t1 r0 *1 0,0
Rny_dup18_t1 ny__t119 ny$18 50.6022
* device instance ny_dup18 r0 *1 0,0
Cny_dup18 ny$18 vsubs 1.95403e-16
* device instance ny_dup19_t0 r0 *1 0,0
Rny_dup19_t0 ny__t020 ny$19 50.6022
* device instance ny_dup19_t1 r0 *1 0,0
Rny_dup19_t1 ny__t120 ny$19 50.6022
* device instance ny_dup19 r0 *1 0,0
Cny_dup19 ny$19 vsubs 1.95403e-16
* device instance py_t0 r0 *1 0,0
Rpy_t0 py__t0 py 37.6683
* device instance py_t1 r0 *1 0,0
Rpy_t1 py__t1 py 37.6683
* device instance py r0 *1 0,0
Cpy py vsubs 1.9321e-16
* device instance py_dup1_t0 r0 *1 0,0
Rpy_dup1_t0 py__t02 py$1 37.6683
* device instance py_dup1_t1 r0 *1 0,0
Rpy_dup1_t1 py__t12 py$1 37.6683
* device instance py_dup1 r0 *1 0,0
Cpy_dup1 py$1 vsubs 1.9321e-16
* device instance py_dup2_t0 r0 *1 0,0
Rpy_dup2_t0 py__t03 py$2 37.6683
* device instance py_dup2_t1 r0 *1 0,0
Rpy_dup2_t1 py__t13 py$2 37.6683
* device instance py_dup2 r0 *1 0,0
Cpy_dup2 py$2 vsubs 1.9321e-16
* device instance py_dup3_t0 r0 *1 0,0
Rpy_dup3_t0 py__t04 py$3 37.6683
* device instance py_dup3_t1 r0 *1 0,0
Rpy_dup3_t1 py__t14 py$3 37.6683
* device instance py_dup3 r0 *1 0,0
Cpy_dup3 py$3 vsubs 1.9321e-16
* device instance py_dup4_t0 r0 *1 0,0
Rpy_dup4_t0 py__t05 py$4 37.875
* device instance py_dup4_t1 r0 *1 0,0
Rpy_dup4_t1 py__t15 py$4 37.875
* device instance py_dup4 r0 *1 0,0
Cpy_dup4 py$4 vsubs 1.95101e-16
* device instance py_dup5_t0 r0 *1 0,0
Rpy_dup5_t0 py__t06 py$5 37.875
* device instance py_dup5_t1 r0 *1 0,0
Rpy_dup5_t1 py__t16 py$5 37.875
* device instance py_dup5 r0 *1 0,0
Cpy_dup5 py$5 vsubs 1.95101e-16
* device instance py_dup6_t0 r0 *1 0,0
Rpy_dup6_t0 py__t07 py$6 37.875
* device instance py_dup6_t1 r0 *1 0,0
Rpy_dup6_t1 py__t17 py$6 37.875
* device instance py_dup6 r0 *1 0,0
Cpy_dup6 py$6 vsubs 1.95101e-16
* device instance py_dup7_t0 r0 *1 0,0
Rpy_dup7_t0 py__t08 py$7 37.875
* device instance py_dup7_t1 r0 *1 0,0
Rpy_dup7_t1 py__t18 py$7 37.875
* device instance py_dup7 r0 *1 0,0
Cpy_dup7 py$7 vsubs 1.95101e-16
* device instance py_dup8_t0 r0 *1 0,0
Rpy_dup8_t0 py__t09 py$8 38.0848
* device instance py_dup8_t1 r0 *1 0,0
Rpy_dup8_t1 py__t19 py$8 38.0848
* device instance py_dup8 r0 *1 0,0
Cpy_dup8 py$8 vsubs 1.96992e-16
* device instance py_dup9_t0 r0 *1 0,0
Rpy_dup9_t0 py__t010 py$9 38.0848
* device instance py_dup9_t1 r0 *1 0,0
Rpy_dup9_t1 py__t110 py$9 38.0848
* device instance py_dup9 r0 *1 0,0
Cpy_dup9 py$9 vsubs 1.96992e-16
* device instance py_dup10_t0 r0 *1 0,0
Rpy_dup10_t0 py__t011 py$10 38.0848
* device instance py_dup10_t1 r0 *1 0,0
Rpy_dup10_t1 py__t111 py$10 38.0848
* device instance py_dup10 r0 *1 0,0
Cpy_dup10 py$10 vsubs 1.96992e-16
* device instance py_dup11_t0 r0 *1 0,0
Rpy_dup11_t0 py__t012 py$11 38.0848
* device instance py_dup11_t1 r0 *1 0,0
Rpy_dup11_t1 py__t112 py$11 38.0848
* device instance py_dup11 r0 *1 0,0
Cpy_dup11 py$11 vsubs 1.96992e-16
* device instance py_dup12_t0 r0 *1 0,0
Rpy_dup12_t0 py__t013 py$12 38.29745
* device instance py_dup12_t1 r0 *1 0,0
Rpy_dup12_t1 py__t113 py$12 38.29745
* device instance py_dup12 r0 *1 0,0
Cpy_dup12 py$12 vsubs 1.98882e-16
* device instance py_dup13_t0 r0 *1 0,0
Rpy_dup13_t0 py__t014 py$13 38.29745
* device instance py_dup13_t1 r0 *1 0,0
Rpy_dup13_t1 py__t114 py$13 38.29745
* device instance py_dup13 r0 *1 0,0
Cpy_dup13 py$13 vsubs 1.98882e-16
* device instance py_dup14_t0 r0 *1 0,0
Rpy_dup14_t0 py__t015 py$14 38.29745
* device instance py_dup14_t1 r0 *1 0,0
Rpy_dup14_t1 py__t115 py$14 38.29745
* device instance py_dup14 r0 *1 0,0
Cpy_dup14 py$14 vsubs 1.98882e-16
* device instance py_dup15_t0 r0 *1 0,0
Rpy_dup15_t0 py__t016 py$15 38.29745
* device instance py_dup15_t1 r0 *1 0,0
Rpy_dup15_t1 py__t116 py$15 38.29745
* device instance py_dup15 r0 *1 0,0
Cpy_dup15 py$15 vsubs 1.98882e-16
* device instance vdd_vdd_b1_vdd_b2_vdd_b3_vdd_b4_vdd_x1_vdd_x2_vdd_x3_t0 r0 *1 0,0
Rvdd_vdd_b1_vdd_b2_vdd_b3_vdd_b4_vdd_x1_vdd_x2_vdd_x3_t0
+ vdd|vdd_b1|vdd_b2|vdd_b3|vdd_b4|vdd_x1|vdd_x2|vdd_x3__t0
+ vdd|vdd_b1|vdd_b2|vdd_b3|vdd_b4|vdd_x1|vdd_x2|vdd_x3 328.063852969
* device instance vdd_vdd_b1_vdd_b2_vdd_b3_vdd_b4_vdd_x1_vdd_x2_vdd_x3_t1 r0 *1 0,0
Rvdd_vdd_b1_vdd_b2_vdd_b3_vdd_b4_vdd_x1_vdd_x2_vdd_x3_t1
+ vdd|vdd_b1|vdd_b2|vdd_b3|vdd_b4|vdd_x1|vdd_x2|vdd_x3__t1
+ vdd|vdd_b1|vdd_b2|vdd_b3|vdd_b4|vdd_x1|vdd_x2|vdd_x3 328.063852969
* device instance vdd_vdd_b1_vdd_b2_vdd_b3_vdd_b4_vdd_x1_vdd_x2_vdd_x3_t2 r0 *1 0,0
Rvdd_vdd_b1_vdd_b2_vdd_b3_vdd_b4_vdd_x1_vdd_x2_vdd_x3_t2
+ vdd|vdd_b1|vdd_b2|vdd_b3|vdd_b4|vdd_x1|vdd_x2|vdd_x3__t2
+ vdd|vdd_b1|vdd_b2|vdd_b3|vdd_b4|vdd_x1|vdd_x2|vdd_x3 323.933326474
* device instance vdd_vdd_b1_vdd_b2_vdd_b3_vdd_b4_vdd_x1_vdd_x2_vdd_x3_t3 r0 *1 0,0
Rvdd_vdd_b1_vdd_b2_vdd_b3_vdd_b4_vdd_x1_vdd_x2_vdd_x3_t3
+ vdd|vdd_b1|vdd_b2|vdd_b3|vdd_b4|vdd_x1|vdd_x2|vdd_x3__t3
+ vdd|vdd_b1|vdd_b2|vdd_b3|vdd_b4|vdd_x1|vdd_x2|vdd_x3 279.90435125
* device instance vdd_vdd_b1_vdd_b2_vdd_b3_vdd_b4_vdd_x1_vdd_x2_vdd_x3_t4 r0 *1 0,0
Rvdd_vdd_b1_vdd_b2_vdd_b3_vdd_b4_vdd_x1_vdd_x2_vdd_x3_t4
+ vdd|vdd_b1|vdd_b2|vdd_b3|vdd_b4|vdd_x1|vdd_x2|vdd_x3__t4
+ vdd|vdd_b1|vdd_b2|vdd_b3|vdd_b4|vdd_x1|vdd_x2|vdd_x3 90.261545763
* device instance vdd_vdd_b1_vdd_b2_vdd_b3_vdd_b4_vdd_x1_vdd_x2_vdd_x3_t5 r0 *1 0,0
Rvdd_vdd_b1_vdd_b2_vdd_b3_vdd_b4_vdd_x1_vdd_x2_vdd_x3_t5
+ vdd|vdd_b1|vdd_b2|vdd_b3|vdd_b4|vdd_x1|vdd_x2|vdd_x3__t5
+ vdd|vdd_b1|vdd_b2|vdd_b3|vdd_b4|vdd_x1|vdd_x2|vdd_x3 104.521181322
* device instance vdd_vdd_b1_vdd_b2_vdd_b3_vdd_b4_vdd_x1_vdd_x2_vdd_x3_t6 r0 *1 0,0
Rvdd_vdd_b1_vdd_b2_vdd_b3_vdd_b4_vdd_x1_vdd_x2_vdd_x3_t6
+ vdd|vdd_b1|vdd_b2|vdd_b3|vdd_b4|vdd_x1|vdd_x2|vdd_x3__t6
+ vdd|vdd_b1|vdd_b2|vdd_b3|vdd_b4|vdd_x1|vdd_x2|vdd_x3 279.90435125
* device instance vdd_vdd_b1_vdd_b2_vdd_b3_vdd_b4_vdd_x1_vdd_x2_vdd_x3_t7 r0 *1 0,0
Rvdd_vdd_b1_vdd_b2_vdd_b3_vdd_b4_vdd_x1_vdd_x2_vdd_x3_t7
+ vdd|vdd_b1|vdd_b2|vdd_b3|vdd_b4|vdd_x1|vdd_x2|vdd_x3__t7
+ vdd|vdd_b1|vdd_b2|vdd_b3|vdd_b4|vdd_x1|vdd_x2|vdd_x3 90.261545763
* device instance vdd_vdd_b1_vdd_b2_vdd_b3_vdd_b4_vdd_x1_vdd_x2_vdd_x3_t8 r0 *1 0,0
Rvdd_vdd_b1_vdd_b2_vdd_b3_vdd_b4_vdd_x1_vdd_x2_vdd_x3_t8
+ vdd|vdd_b1|vdd_b2|vdd_b3|vdd_b4|vdd_x1|vdd_x2|vdd_x3__t8
+ vdd|vdd_b1|vdd_b2|vdd_b3|vdd_b4|vdd_x1|vdd_x2|vdd_x3 53.1431519264
* device instance vdd_vdd_b1_vdd_b2_vdd_b3_vdd_b4_vdd_x1_vdd_x2_vdd_x3_t9 r0 *1 0,0
Rvdd_vdd_b1_vdd_b2_vdd_b3_vdd_b4_vdd_x1_vdd_x2_vdd_x3_t9
+ vdd|vdd_b1|vdd_b2|vdd_b3|vdd_b4|vdd_x1|vdd_x2|vdd_x3__t9
+ vdd|vdd_b1|vdd_b2|vdd_b3|vdd_b4|vdd_x1|vdd_x2|vdd_x3 146.82090586
* device instance vdd_vdd_b1_vdd_b2_vdd_b3_vdd_b4_vdd_x1_vdd_x2_vdd_x3_t10 r0 *1 0,0
Rvdd_vdd_b1_vdd_b2_vdd_b3_vdd_b4_vdd_x1_vdd_x2_vdd_x3_t10
+ vdd|vdd_b1|vdd_b2|vdd_b3|vdd_b4|vdd_x1|vdd_x2|vdd_x3__t10
+ vdd|vdd_b1|vdd_b2|vdd_b3|vdd_b4|vdd_x1|vdd_x2|vdd_x3 104.521181322
* device instance vdd_vdd_b1_vdd_b2_vdd_b3_vdd_b4_vdd_x1_vdd_x2_vdd_x3_t11 r0 *1 0,0
Rvdd_vdd_b1_vdd_b2_vdd_b3_vdd_b4_vdd_x1_vdd_x2_vdd_x3_t11
+ vdd|vdd_b1|vdd_b2|vdd_b3|vdd_b4|vdd_x1|vdd_x2|vdd_x3__t11
+ vdd|vdd_b1|vdd_b2|vdd_b3|vdd_b4|vdd_x1|vdd_x2|vdd_x3 284.025611975
* device instance vdd_vdd_b1_vdd_b2_vdd_b3_vdd_b4_vdd_x1_vdd_x2_vdd_x3_t12 r0 *1 0,0
Rvdd_vdd_b1_vdd_b2_vdd_b3_vdd_b4_vdd_x1_vdd_x2_vdd_x3_t12
+ vdd|vdd_b1|vdd_b2|vdd_b3|vdd_b4|vdd_x1|vdd_x2|vdd_x3__t12
+ vdd|vdd_b1|vdd_b2|vdd_b3|vdd_b4|vdd_x1|vdd_x2|vdd_x3 86.4936196129
* device instance vdd_vdd_b1_vdd_b2_vdd_b3_vdd_b4_vdd_x1_vdd_x2_vdd_x3_t13 r0 *1 0,0
Rvdd_vdd_b1_vdd_b2_vdd_b3_vdd_b4_vdd_x1_vdd_x2_vdd_x3_t13
+ vdd|vdd_b1|vdd_b2|vdd_b3|vdd_b4|vdd_x1|vdd_x2|vdd_x3__t13
+ vdd|vdd_b1|vdd_b2|vdd_b3|vdd_b4|vdd_x1|vdd_x2|vdd_x3 50.2710990779
* device instance vdd_vdd_b1_vdd_b2_vdd_b3_vdd_b4_vdd_x1_vdd_x2_vdd_x3_t14 r0 *1 0,0
Rvdd_vdd_b1_vdd_b2_vdd_b3_vdd_b4_vdd_x1_vdd_x2_vdd_x3_t14
+ vdd|vdd_b1|vdd_b2|vdd_b3|vdd_b4|vdd_x1|vdd_x2|vdd_x3__t14
+ vdd|vdd_b1|vdd_b2|vdd_b3|vdd_b4|vdd_x1|vdd_x2|vdd_x3 150.845678137
* device instance vdd_vdd_b1_vdd_b2_vdd_b3_vdd_b4_vdd_x1_vdd_x2_vdd_x3_t15 r0 *1 0,0
Rvdd_vdd_b1_vdd_b2_vdd_b3_vdd_b4_vdd_x1_vdd_x2_vdd_x3_t15
+ vdd|vdd_b1|vdd_b2|vdd_b3|vdd_b4|vdd_x1|vdd_x2|vdd_x3__t15
+ vdd|vdd_b1|vdd_b2|vdd_b3|vdd_b4|vdd_x1|vdd_x2|vdd_x3 108.41461315
* device instance vdd_vdd_b1_vdd_b2_vdd_b3_vdd_b4_vdd_x1_vdd_x2_vdd_x3_t16 r0 *1 0,0
Rvdd_vdd_b1_vdd_b2_vdd_b3_vdd_b4_vdd_x1_vdd_x2_vdd_x3_t16
+ vdd|vdd_b1|vdd_b2|vdd_b3|vdd_b4|vdd_x1|vdd_x2|vdd_x3__t16
+ vdd|vdd_b1|vdd_b2|vdd_b3|vdd_b4|vdd_x1|vdd_x2|vdd_x3 50.2710990779
* device instance vdd_vdd_b1_vdd_b2_vdd_b3_vdd_b4_vdd_x1_vdd_x2_vdd_x3_t17 r0 *1 0,0
Rvdd_vdd_b1_vdd_b2_vdd_b3_vdd_b4_vdd_x1_vdd_x2_vdd_x3_t17
+ vdd|vdd_b1|vdd_b2|vdd_b3|vdd_b4|vdd_x1|vdd_x2|vdd_x3__t17
+ vdd|vdd_b1|vdd_b2|vdd_b3|vdd_b4|vdd_x1|vdd_x2|vdd_x3 150.845678137
* device instance vdd_vdd_b1_vdd_b2_vdd_b3_vdd_b4_vdd_x1_vdd_x2_vdd_x3_t18 r0 *1 0,0
Rvdd_vdd_b1_vdd_b2_vdd_b3_vdd_b4_vdd_x1_vdd_x2_vdd_x3_t18
+ vdd|vdd_b1|vdd_b2|vdd_b3|vdd_b4|vdd_x1|vdd_x2|vdd_x3__t18
+ vdd|vdd_b1|vdd_b2|vdd_b3|vdd_b4|vdd_x1|vdd_x2|vdd_x3 965.869424629
* device instance vdd_vdd_b1_vdd_b2_vdd_b3_vdd_b4_vdd_x1_vdd_x2_vdd_x3_t19 r0 *1 0,0
Rvdd_vdd_b1_vdd_b2_vdd_b3_vdd_b4_vdd_x1_vdd_x2_vdd_x3_t19
+ vdd|vdd_b1|vdd_b2|vdd_b3|vdd_b4|vdd_x1|vdd_x2|vdd_x3__t19
+ vdd|vdd_b1|vdd_b2|vdd_b3|vdd_b4|vdd_x1|vdd_x2|vdd_x3 625.512134762
* device instance vdd_vdd_b1_vdd_b2_vdd_b3_vdd_b4_vdd_x1_vdd_x2_vdd_x3_t20 r0 *1 0,0
Rvdd_vdd_b1_vdd_b2_vdd_b3_vdd_b4_vdd_x1_vdd_x2_vdd_x3_t20
+ vdd|vdd_b1|vdd_b2|vdd_b3|vdd_b4|vdd_x1|vdd_x2|vdd_x3__t20
+ vdd|vdd_b1|vdd_b2|vdd_b3|vdd_b4|vdd_x1|vdd_x2|vdd_x3 120.990798837
* device instance vdd_vdd_b1_vdd_b2_vdd_b3_vdd_b4_vdd_x1_vdd_x2_vdd_x3_t21 r0 *1 0,0
Rvdd_vdd_b1_vdd_b2_vdd_b3_vdd_b4_vdd_x1_vdd_x2_vdd_x3_t21
+ vdd|vdd_b1|vdd_b2|vdd_b3|vdd_b4|vdd_x1|vdd_x2|vdd_x3__t21
+ vdd|vdd_b1|vdd_b2|vdd_b3|vdd_b4|vdd_x1|vdd_x2|vdd_x3 122.133630991
* device instance vdd_vdd_b1_vdd_b2_vdd_b3_vdd_b4_vdd_x1_vdd_x2_vdd_x3_t22 r0 *1 0,0
Rvdd_vdd_b1_vdd_b2_vdd_b3_vdd_b4_vdd_x1_vdd_x2_vdd_x3_t22
+ vdd|vdd_b1|vdd_b2|vdd_b3|vdd_b4|vdd_x1|vdd_x2|vdd_x3__t22
+ vdd|vdd_b1|vdd_b2|vdd_b3|vdd_b4|vdd_x1|vdd_x2|vdd_x3 13.6183889138
* device instance vdd_vdd_b1_vdd_b2_vdd_b3_vdd_b4_vdd_x1_vdd_x2_vdd_x3_t23 r0 *1 0,0
Rvdd_vdd_b1_vdd_b2_vdd_b3_vdd_b4_vdd_x1_vdd_x2_vdd_x3_t23
+ vdd|vdd_b1|vdd_b2|vdd_b3|vdd_b4|vdd_x1|vdd_x2|vdd_x3__t23
+ vdd|vdd_b1|vdd_b2|vdd_b3|vdd_b4|vdd_x1|vdd_x2|vdd_x3 58.9916013682
* device instance vdd_vdd_b1_vdd_b2_vdd_b3_vdd_b4_vdd_x1_vdd_x2_vdd_x3_t24 r0 *1 0,0
Rvdd_vdd_b1_vdd_b2_vdd_b3_vdd_b4_vdd_x1_vdd_x2_vdd_x3_t24
+ vdd|vdd_b1|vdd_b2|vdd_b3|vdd_b4|vdd_x1|vdd_x2|vdd_x3__t24
+ vdd|vdd_b1|vdd_b2|vdd_b3|vdd_b4|vdd_x1|vdd_x2|vdd_x3 171.186753232
* device instance vdd_vdd_b1_vdd_b2_vdd_b3_vdd_b4_vdd_x1_vdd_x2_vdd_x3_t25 r0 *1 0,0
Rvdd_vdd_b1_vdd_b2_vdd_b3_vdd_b4_vdd_x1_vdd_x2_vdd_x3_t25
+ vdd|vdd_b1|vdd_b2|vdd_b3|vdd_b4|vdd_x1|vdd_x2|vdd_x3__t25
+ vdd|vdd_b1|vdd_b2|vdd_b3|vdd_b4|vdd_x1|vdd_x2|vdd_x3 238.09164632
* device instance vdd_vdd_b1_vdd_b2_vdd_b3_vdd_b4_vdd_x1_vdd_x2_vdd_x3_t26 r0 *1 0,0
Rvdd_vdd_b1_vdd_b2_vdd_b3_vdd_b4_vdd_x1_vdd_x2_vdd_x3_t26
+ vdd|vdd_b1|vdd_b2|vdd_b3|vdd_b4|vdd_x1|vdd_x2|vdd_x3__t26
+ vdd|vdd_b1|vdd_b2|vdd_b3|vdd_b4|vdd_x1|vdd_x2|vdd_x3 350.811325715
* device instance vdd_vdd_b1_vdd_b2_vdd_b3_vdd_b4_vdd_x1_vdd_x2_vdd_x3_t27 r0 *1 0,0
Rvdd_vdd_b1_vdd_b2_vdd_b3_vdd_b4_vdd_x1_vdd_x2_vdd_x3_t27
+ vdd|vdd_b1|vdd_b2|vdd_b3|vdd_b4|vdd_x1|vdd_x2|vdd_x3__t27
+ vdd|vdd_b1|vdd_b2|vdd_b3|vdd_b4|vdd_x1|vdd_x2|vdd_x3 291.851172216
* device instance vdd_vdd_b1_vdd_b2_vdd_b3_vdd_b4_vdd_x1_vdd_x2_vdd_x3_t28 r0 *1 0,0
Rvdd_vdd_b1_vdd_b2_vdd_b3_vdd_b4_vdd_x1_vdd_x2_vdd_x3_t28
+ vdd|vdd_b1|vdd_b2|vdd_b3|vdd_b4|vdd_x1|vdd_x2|vdd_x3__t28
+ vdd|vdd_b1|vdd_b2|vdd_b3|vdd_b4|vdd_x1|vdd_x2|vdd_x3 965.869424629
* device instance vdd_vdd_b1_vdd_b2_vdd_b3_vdd_b4_vdd_x1_vdd_x2_vdd_x3_t29 r0 *1 0,0
Rvdd_vdd_b1_vdd_b2_vdd_b3_vdd_b4_vdd_x1_vdd_x2_vdd_x3_t29
+ vdd|vdd_b1|vdd_b2|vdd_b3|vdd_b4|vdd_x1|vdd_x2|vdd_x3__t29
+ vdd|vdd_b1|vdd_b2|vdd_b3|vdd_b4|vdd_x1|vdd_x2|vdd_x3 625.512134762
* device instance vdd_vdd_b1_vdd_b2_vdd_b3_vdd_b4_vdd_x1_vdd_x2_vdd_x3_t30 r0 *1 0,0
Rvdd_vdd_b1_vdd_b2_vdd_b3_vdd_b4_vdd_x1_vdd_x2_vdd_x3_t30
+ vdd|vdd_b1|vdd_b2|vdd_b3|vdd_b4|vdd_x1|vdd_x2|vdd_x3__t30
+ vdd|vdd_b1|vdd_b2|vdd_b3|vdd_b4|vdd_x1|vdd_x2|vdd_x3 120.990798837
* device instance vdd_vdd_b1_vdd_b2_vdd_b3_vdd_b4_vdd_x1_vdd_x2_vdd_x3_t31 r0 *1 0,0
Rvdd_vdd_b1_vdd_b2_vdd_b3_vdd_b4_vdd_x1_vdd_x2_vdd_x3_t31
+ vdd|vdd_b1|vdd_b2|vdd_b3|vdd_b4|vdd_x1|vdd_x2|vdd_x3__t31
+ vdd|vdd_b1|vdd_b2|vdd_b3|vdd_b4|vdd_x1|vdd_x2|vdd_x3 122.133630991
* device instance vdd_vdd_b1_vdd_b2_vdd_b3_vdd_b4_vdd_x1_vdd_x2_vdd_x3_t32 r0 *1 0,0
Rvdd_vdd_b1_vdd_b2_vdd_b3_vdd_b4_vdd_x1_vdd_x2_vdd_x3_t32
+ vdd|vdd_b1|vdd_b2|vdd_b3|vdd_b4|vdd_x1|vdd_x2|vdd_x3__t32
+ vdd|vdd_b1|vdd_b2|vdd_b3|vdd_b4|vdd_x1|vdd_x2|vdd_x3 13.6183889138
* device instance vdd_vdd_b1_vdd_b2_vdd_b3_vdd_b4_vdd_x1_vdd_x2_vdd_x3_t33 r0 *1 0,0
Rvdd_vdd_b1_vdd_b2_vdd_b3_vdd_b4_vdd_x1_vdd_x2_vdd_x3_t33
+ vdd|vdd_b1|vdd_b2|vdd_b3|vdd_b4|vdd_x1|vdd_x2|vdd_x3__t33
+ vdd|vdd_b1|vdd_b2|vdd_b3|vdd_b4|vdd_x1|vdd_x2|vdd_x3 58.9916013682
* device instance vdd_vdd_b1_vdd_b2_vdd_b3_vdd_b4_vdd_x1_vdd_x2_vdd_x3_t34 r0 *1 0,0
Rvdd_vdd_b1_vdd_b2_vdd_b3_vdd_b4_vdd_x1_vdd_x2_vdd_x3_t34
+ vdd|vdd_b1|vdd_b2|vdd_b3|vdd_b4|vdd_x1|vdd_x2|vdd_x3__t34
+ vdd|vdd_b1|vdd_b2|vdd_b3|vdd_b4|vdd_x1|vdd_x2|vdd_x3 171.186753232
* device instance vdd_vdd_b1_vdd_b2_vdd_b3_vdd_b4_vdd_x1_vdd_x2_vdd_x3_t35 r0 *1 0,0
Rvdd_vdd_b1_vdd_b2_vdd_b3_vdd_b4_vdd_x1_vdd_x2_vdd_x3_t35
+ vdd|vdd_b1|vdd_b2|vdd_b3|vdd_b4|vdd_x1|vdd_x2|vdd_x3__t35
+ vdd|vdd_b1|vdd_b2|vdd_b3|vdd_b4|vdd_x1|vdd_x2|vdd_x3 238.09164632
* device instance vdd_vdd_b1_vdd_b2_vdd_b3_vdd_b4_vdd_x1_vdd_x2_vdd_x3_t36 r0 *1 0,0
Rvdd_vdd_b1_vdd_b2_vdd_b3_vdd_b4_vdd_x1_vdd_x2_vdd_x3_t36
+ vdd|vdd_b1|vdd_b2|vdd_b3|vdd_b4|vdd_x1|vdd_x2|vdd_x3__t36
+ vdd|vdd_b1|vdd_b2|vdd_b3|vdd_b4|vdd_x1|vdd_x2|vdd_x3 350.811325715
* device instance vdd_vdd_b1_vdd_b2_vdd_b3_vdd_b4_vdd_x1_vdd_x2_vdd_x3_t37 r0 *1 0,0
Rvdd_vdd_b1_vdd_b2_vdd_b3_vdd_b4_vdd_x1_vdd_x2_vdd_x3_t37
+ vdd|vdd_b1|vdd_b2|vdd_b3|vdd_b4|vdd_x1|vdd_x2|vdd_x3__t37
+ vdd|vdd_b1|vdd_b2|vdd_b3|vdd_b4|vdd_x1|vdd_x2|vdd_x3 291.851172216
* device instance vdd_vdd_b1_vdd_b2_vdd_b3_vdd_b4_vdd_x1_vdd_x2_vdd_x3 r0 *1 0,0
Cvdd_vdd_b1_vdd_b2_vdd_b3_vdd_b4_vdd_x1_vdd_x2_vdd_x3
+ vdd|vdd_b1|vdd_b2|vdd_b3|vdd_b4|vdd_x1|vdd_x2|vdd_x3 vsubs 4.8070761e-14
* device instance xo_y_t0 r0 *1 0,0
Rxo_y_t0 xo|y__t0 xo|y 470.975867376
* device instance xo_y_t1 r0 *1 0,0
Rxo_y_t1 xo|y__t1 xo|y 473.562167793
* device instance xo_y_t2 r0 *1 0,0
Rxo_y_t2 xo|y__t2 xo|y 485.149050642
* device instance xo_y_t3 r0 *1 0,0
Rxo_y_t3 xo|y__t3 xo|y 482.421714188
* device instance xo_y r0 *1 0,0
Cxo_y xo|y vsubs 2.746166e-15
* device instance cc_a_b_b3_invb_a_mn12_g1_mp24_g0_t2_y_a_inva_a_mn12_g0_mp13_g0_ro3_y r0 *1 0,0
Ccc_a_b_b3_invb_a_mn12_g1_mp24_g0_t2_y_a_inva_a_mn12_g0_mp13_g0_ro3_y
+ a|b|b3|invb_a|mn12_g1|mp24_g0|t2|y a|inva_a|mn12_g0|mp13_g0|ro3|y 3.3e-18
* device instance cc_a_b_b3_invb_a_mn12_g1_mp24_g0_t2_y_a_inva_a_mn12_g0_mp13_g0_t1_y r0 *1 0,0
Ccc_a_b_b3_invb_a_mn12_g1_mp24_g0_t2_y_a_inva_a_mn12_g0_mp13_g0_t1_y
+ a|b|b3|invb_a|mn12_g1|mp24_g0|t2|y a|inva_a|mn12_g0|mp13_g0|t1|y 3.869e-18
* device instance cc_a_b_b3_invb_a_mn12_g1_mp24_g0_t2_y_an_inva_y_mn34_g0_mp13_g1_y r0 *1 0,0
Ccc_a_b_b3_invb_a_mn12_g1_mp24_g0_t2_y_an_inva_y_mn34_g0_mp13_g1_y
+ a|b|b3|invb_a|mn12_g1|mp24_g0|t2|y an|inva_y|mn34_g0|mp13_g1|y$2 3.3e-18
* device instance cc_a_b_b3_invb_a_mn12_g1_mp24_g0_t2_y_bn_invb_y_mn34_g1_mp24_g1_y r0 *1 0,0
Ccc_a_b_b3_invb_a_mn12_g1_mp24_g0_t2_y_bn_invb_y_mn34_g1_mp24_g1_y
+ a|b|b3|invb_a|mn12_g1|mp24_g0|t2|y bn|invb_y|mn34_g1|mp24_g1|y$2 1.377e-17
* device instance cc_a_b_b3_invb_a_mn12_g1_mp24_g0_t2_y_g_vss_m1_mph_g_s1_vss_m1_s2_vss_m1_s3_vss_m1_s4_vss_m1_vss_vss_x1_vss_x2_vss_x3 r0 *1 0,0
Ccc_a_b_b3_invb_a_mn12_g1_mp24_g0_t2_y_g_vss_m1_mph_g_s1_vss_m1_s2_vss_m1_s3_vss_m1_s4_vss_m1_vss_vss_x1_vss_x2_vss_x3
+ a|b|b3|invb_a|mn12_g1|mp24_g0|t2|y
+ g_vss_m1|mph_g|s1_vss_m1|s2_vss_m1|s3_vss_m1|s4_vss_m1|vss|vss_x1|vss_x2|vss_x3
+ 7.354e-18
* device instance cc_a_b_b3_invb_a_mn12_g1_mp24_g0_t2_y_mid r0 *1 0,0
Ccc_a_b_b3_invb_a_mn12_g1_mp24_g0_t2_y_mid a|b|b3|invb_a|mn12_g1|mp24_g0|t2|y
+ mid$2 8.154e-18
* device instance cc_a_b_invb_a_mn12_g1_mp24_g0_ro2_y_g_vss_m1_mph_g_s1_vss_m1_s2_vss_m1_s3_vss_m1_s4_vss_m1_vss_vss_x1_vss_x2_vss_x3 r0 *1 0,0
Ccc_a_b_invb_a_mn12_g1_mp24_g0_ro2_y_g_vss_m1_mph_g_s1_vss_m1_s2_vss_m1_s3_vss_m1_s4_vss_m1_vss_vss_x1_vss_x2_vss_x3
+ a|b|invb_a|mn12_g1|mp24_g0|ro2|y
+ g_vss_m1|mph_g|s1_vss_m1|s2_vss_m1|s3_vss_m1|s4_vss_m1|vss|vss_x1|vss_x2|vss_x3
+ 5.1954e-17
* device instance cc_a_b_invb_a_mn12_g1_mp24_g0_ro2_y_vdd_vdd_b1_vdd_b2_vdd_b3_vdd_b4_vdd_x1_vdd_x2_vdd_x3 r0 *1 0,0
Ccc_a_b_invb_a_mn12_g1_mp24_g0_ro2_y_vdd_vdd_b1_vdd_b2_vdd_b3_vdd_b4_vdd_x1_vdd_x2_vdd_x3
+ a|b|invb_a|mn12_g1|mp24_g0|ro2|y
+ vdd|vdd_b1|vdd_b2|vdd_b3|vdd_b4|vdd_x1|vdd_x2|vdd_x3 9.558e-18
* device instance cc_a_b_invb_a_mn12_g1_mp24_g0_ro4_y_g_vss_m1_mph_g_s1_vss_m1_s2_vss_m1_s3_vss_m1_s4_vss_m1_vss_vss_x1_vss_x2_vss_x3 r0 *1 0,0
Ccc_a_b_invb_a_mn12_g1_mp24_g0_ro4_y_g_vss_m1_mph_g_s1_vss_m1_s2_vss_m1_s3_vss_m1_s4_vss_m1_vss_vss_x1_vss_x2_vss_x3
+ a|b|invb_a|mn12_g1|mp24_g0|ro4|y
+ g_vss_m1|mph_g|s1_vss_m1|s2_vss_m1|s3_vss_m1|s4_vss_m1|vss|vss_x1|vss_x2|vss_x3
+ 6.1512e-17
* device instance cc_a_b_invb_a_mn12_g1_mp24_g0_ro4_y_vdd_vdd_b1_vdd_b2_vdd_b3_vdd_b4_vdd_x1_vdd_x2_vdd_x3 r0 *1 0,0
Ccc_a_b_invb_a_mn12_g1_mp24_g0_ro4_y_vdd_vdd_b1_vdd_b2_vdd_b3_vdd_b4_vdd_x1_vdd_x2_vdd_x3
+ a|b|invb_a|mn12_g1|mp24_g0|ro4|y
+ vdd|vdd_b1|vdd_b2|vdd_b3|vdd_b4|vdd_x1|vdd_x2|vdd_x3 9.558e-18
* device instance cc_a_g_a_rn1_ro_s4_y_y_a_g_y_mnab_y_mpa_y_mpb_y_n1_s1_a_y r0 *1 0,0
Ccc_a_g_a_rn1_ro_s4_y_y_a_g_y_mnab_y_mpa_y_mpb_y_n1_s1_a_y a|g_a|rn1|ro|s4_y|y
+ a|g_y|mnab_y|mpa_y|mpb_y|n1|s1_a|y$3 6.626e-18
* device instance cc_a_g_a_rn1_ro_s4_y_y_g_vddr_m1_mnt_g_s1_vddr_m1_s2_vddr_m1_s3_vddr_m1_s4_vddr_m1_vddr_vddr1 r0 *1 0,0
Ccc_a_g_a_rn1_ro_s4_y_y_g_vddr_m1_mnt_g_s1_vddr_m1_s2_vddr_m1_s3_vddr_m1_s4_vddr_m1_vddr_vddr1
+ a|g_a|rn1|ro|s4_y|y
+ g_vddr_m1|mnt_g|s1_vddr_m1|s2_vddr_m1|s3_vddr_m1|s4_vddr_m1|vddr|vddr1
+ 1.5474e-17
* device instance cc_a_g_a_rn2_ro_s4_y_y_a_g_y_mnab_y_mpa_y_mpb_y_n1_s1_a_y r0 *1 0,0
Ccc_a_g_a_rn2_ro_s4_y_y_a_g_y_mnab_y_mpa_y_mpb_y_n1_s1_a_y a|g_a|rn2|ro|s4_y|y
+ a|g_y|mnab_y|mpa_y|mpb_y|n1|s1_a|y$3 6.626e-18
* device instance cc_a_g_a_rn2_ro_s4_y_y_g_vddr_m1_mnt_g_s1_vddr_m1_s2_vddr_m1_s3_vddr_m1_s4_vddr_m1_vddr_vddr2 r0 *1 0,0
Ccc_a_g_a_rn2_ro_s4_y_y_g_vddr_m1_mnt_g_s1_vddr_m1_s2_vddr_m1_s3_vddr_m1_s4_vddr_m1_vddr_vddr2
+ a|g_a|rn2|ro|s4_y|y
+ g_vddr_m1|mnt_g|s1_vddr_m1|s2_vddr_m1|s3_vddr_m1|s4_vddr_m1|vddr|vddr2
+ 1.5474e-17
* device instance cc_a_g_a_rn3_ro_s4_y_y_a_g_y_mnab_y_mpa_y_mpb_y_n1_s1_a_y r0 *1 0,0
Ccc_a_g_a_rn3_ro_s4_y_y_a_g_y_mnab_y_mpa_y_mpb_y_n1_s1_a_y a|g_a|rn3|ro|s4_y|y
+ a|g_y|mnab_y|mpa_y|mpb_y|n1|s1_a|y$3 6.626e-18
* device instance cc_a_g_a_rn3_ro_s4_y_y_g_vddr_m1_mnt_g_s1_vddr_m1_s2_vddr_m1_s3_vddr_m1_s4_vddr_m1_vddr_vddr3 r0 *1 0,0
Ccc_a_g_a_rn3_ro_s4_y_y_g_vddr_m1_mnt_g_s1_vddr_m1_s2_vddr_m1_s3_vddr_m1_s4_vddr_m1_vddr_vddr3
+ a|g_a|rn3|ro|s4_y|y
+ g_vddr_m1|mnt_g|s1_vddr_m1|s2_vddr_m1|s3_vddr_m1|s4_vddr_m1|vddr|vddr3
+ 1.5474e-17
* device instance cc_a_g_a_rn4_ro_s4_y_y_a_g_y_mnab_y_mpa_y_mpb_y_n1_s1_a_y r0 *1 0,0
Ccc_a_g_a_rn4_ro_s4_y_y_a_g_y_mnab_y_mpa_y_mpb_y_n1_s1_a_y a|g_a|rn4|ro|s4_y|y
+ a|g_y|mnab_y|mpa_y|mpb_y|n1|s1_a|y$3 6.626e-18
* device instance cc_a_g_a_rn4_ro_s4_y_y_g_vddr_m1_mnt_g_s1_vddr_m1_s2_vddr_m1_s3_vddr_m1_s4_vddr_m1_vddr_vddr4 r0 *1 0,0
Ccc_a_g_a_rn4_ro_s4_y_y_g_vddr_m1_mnt_g_s1_vddr_m1_s2_vddr_m1_s3_vddr_m1_s4_vddr_m1_vddr_vddr4
+ a|g_a|rn4|ro|s4_y|y
+ g_vddr_m1|mnt_g|s1_vddr_m1|s2_vddr_m1|s3_vddr_m1|s4_vddr_m1|vddr|vddr4
+ 1.5474e-17
* device instance cc_a_g_a_rn4_ro_s4_y_y_g_vss_m1_mph_g_s1_vss_m1_s2_vss_m1_s3_vss_m1_s4_vss_m1_vss_vss_x1_vss_x2_vss_x3 r0 *1 0,0
Ccc_a_g_a_rn4_ro_s4_y_y_g_vss_m1_mph_g_s1_vss_m1_s2_vss_m1_s3_vss_m1_s4_vss_m1_vss_vss_x1_vss_x2_vss_x3
+ a|g_a|rn4|ro|s4_y|y
+ g_vss_m1|mph_g|s1_vss_m1|s2_vss_m1|s3_vss_m1|s4_vss_m1|vss|vss_x1|vss_x2|vss_x3
+ 2.7612e-17
* device instance cc_a_g_y_mnab_y_mpa_y_mpb_y_n1_s1_a_y_g_vss_m1_mph_g_s1_vss_m1_s2_vss_m1_s3_vss_m1_s4_vss_m1_vss_vss_x1_vss_x2_vss_x3 r0 *1 0,0
Ccc_a_g_y_mnab_y_mpa_y_mpb_y_n1_s1_a_y_g_vss_m1_mph_g_s1_vss_m1_s2_vss_m1_s3_vss_m1_s4_vss_m1_vss_vss_x1_vss_x2_vss_x3
+ a|g_y|mnab_y|mpa_y|mpb_y|n1|s1_a|y$3
+ g_vss_m1|mph_g|s1_vss_m1|s2_vss_m1|s3_vss_m1|s4_vss_m1|vss|vss_x1|vss_x2|vss_x3
+ 1.5474e-17
* device instance cc_a_g_y_mnab_y_mpa_y_mpb_y_n1_s1_a_y_ny r0 *1 0,0
Ccc_a_g_y_mnab_y_mpa_y_mpb_y_n1_s1_a_y_ny a|g_y|mnab_y|mpa_y|mpb_y|n1|s1_a|y$3
+ ny$19 3.0903e-17
* device instance cc_a_inva_a_mn12_g0_mp13_g0_ro1_y_a_inva_a_mn12_g0_mp13_g0_t1_y r0 *1 0,0
Ccc_a_inva_a_mn12_g0_mp13_g0_ro1_y_a_inva_a_mn12_g0_mp13_g0_t1_y
+ a|inva_a|mn12_g0|mp13_g0|ro1|y a|inva_a|mn12_g0|mp13_g0|t1|y 3.3e-18
* device instance cc_a_inva_a_mn12_g0_mp13_g0_ro1_y_g_vss_m1_mph_g_s1_vss_m1_s2_vss_m1_s3_vss_m1_s4_vss_m1_vss_vss_x1_vss_x2_vss_x3 r0 *1 0,0
Ccc_a_inva_a_mn12_g0_mp13_g0_ro1_y_g_vss_m1_mph_g_s1_vss_m1_s2_vss_m1_s3_vss_m1_s4_vss_m1_vss_vss_x1_vss_x2_vss_x3
+ a|inva_a|mn12_g0|mp13_g0|ro1|y
+ g_vss_m1|mph_g|s1_vss_m1|s2_vss_m1|s3_vss_m1|s4_vss_m1|vss|vss_x1|vss_x2|vss_x3
+ 1.3955e-17
* device instance cc_a_inva_a_mn12_g0_mp13_g0_ro1_y_vdd_vdd_b1_vdd_b2_vdd_b3_vdd_b4_vdd_x1_vdd_x2_vdd_x3 r0 *1 0,0
Ccc_a_inva_a_mn12_g0_mp13_g0_ro1_y_vdd_vdd_b1_vdd_b2_vdd_b3_vdd_b4_vdd_x1_vdd_x2_vdd_x3
+ a|inva_a|mn12_g0|mp13_g0|ro1|y
+ vdd|vdd_b1|vdd_b2|vdd_b3|vdd_b4|vdd_x1|vdd_x2|vdd_x3 4.1531e-17
* device instance cc_a_inva_a_mn12_g0_mp13_g0_ro3_y_g_vss_m1_mph_g_s1_vss_m1_s2_vss_m1_s3_vss_m1_s4_vss_m1_vss_vss_x1_vss_x2_vss_x3 r0 *1 0,0
Ccc_a_inva_a_mn12_g0_mp13_g0_ro3_y_g_vss_m1_mph_g_s1_vss_m1_s2_vss_m1_s3_vss_m1_s4_vss_m1_vss_vss_x1_vss_x2_vss_x3
+ a|inva_a|mn12_g0|mp13_g0|ro3|y
+ g_vss_m1|mph_g|s1_vss_m1|s2_vss_m1|s3_vss_m1|s4_vss_m1|vss|vss_x1|vss_x2|vss_x3
+ 2.3513e-17
* device instance cc_a_inva_a_mn12_g0_mp13_g0_ro3_y_vdd_vdd_b1_vdd_b2_vdd_b3_vdd_b4_vdd_x1_vdd_x2_vdd_x3 r0 *1 0,0
Ccc_a_inva_a_mn12_g0_mp13_g0_ro3_y_vdd_vdd_b1_vdd_b2_vdd_b3_vdd_b4_vdd_x1_vdd_x2_vdd_x3
+ a|inva_a|mn12_g0|mp13_g0|ro3|y
+ vdd|vdd_b1|vdd_b2|vdd_b3|vdd_b4|vdd_x1|vdd_x2|vdd_x3 3.1973e-17
* device instance cc_a_inva_a_mn12_g0_mp13_g0_t1_y_an_inva_y_mn34_g0_mp13_g1_y r0 *1 0,0
Ccc_a_inva_a_mn12_g0_mp13_g0_t1_y_an_inva_y_mn34_g0_mp13_g1_y
+ a|inva_a|mn12_g0|mp13_g0|t1|y an|inva_y|mn34_g0|mp13_g1|y$2 3.3e-18
* device instance cc_a_inva_a_mn12_g0_mp13_g0_t1_y_bn_invb_y_mn34_g1_mp24_g1_y r0 *1 0,0
Ccc_a_inva_a_mn12_g0_mp13_g0_t1_y_bn_invb_y_mn34_g1_mp24_g1_y
+ a|inva_a|mn12_g0|mp13_g0|t1|y bn|invb_y|mn34_g1|mp24_g1|y$2 9.901e-18
* device instance cc_a_inva_a_mn12_g0_mp13_g0_t1_y_g_vss_m1_mph_g_s1_vss_m1_s2_vss_m1_s3_vss_m1_s4_vss_m1_vss_vss_x1_vss_x2_vss_x3 r0 *1 0,0
Ccc_a_inva_a_mn12_g0_mp13_g0_t1_y_g_vss_m1_mph_g_s1_vss_m1_s2_vss_m1_s3_vss_m1_s4_vss_m1_vss_vss_x1_vss_x2_vss_x3
+ a|inva_a|mn12_g0|mp13_g0|t1|y
+ g_vss_m1|mph_g|s1_vss_m1|s2_vss_m1|s3_vss_m1|s4_vss_m1|vss|vss_x1|vss_x2|vss_x3
+ 1.3955e-17
* device instance cc_a_inva_a_mn12_g0_mp13_g0_t1_y_mid r0 *1 0,0
Ccc_a_inva_a_mn12_g0_mp13_g0_t1_y_mid a|inva_a|mn12_g0|mp13_g0|t1|y mid$2
+ 3.3e-18
* device instance cc_a_inva_a_mn12_g0_mp13_g0_t1_y_vdd_vdd_b1_vdd_b2_vdd_b3_vdd_b4_vdd_x1_vdd_x2_vdd_x3 r0 *1 0,0
Ccc_a_inva_a_mn12_g0_mp13_g0_t1_y_vdd_vdd_b1_vdd_b2_vdd_b3_vdd_b4_vdd_x1_vdd_x2_vdd_x3
+ a|inva_a|mn12_g0|mp13_g0|t1|y
+ vdd|vdd_b1|vdd_b2|vdd_b3|vdd_b4|vdd_x1|vdd_x2|vdd_x3 3.5274e-17
* device instance cc_a_inva_a_mn12_g0_mp13_g0_t1_y_xo_y r0 *1 0,0
Ccc_a_inva_a_mn12_g0_mp13_g0_t1_y_xo_y a|inva_a|mn12_g0|mp13_g0|t1|y xo|y
+ 3.3e-18
* device instance cc_a_n2_s1_y_s2_a_y_g_vss_m1_mph_g_s1_vss_m1_s2_vss_m1_s3_vss_m1_s4_vss_m1_vss_vss_x1_vss_x2_vss_x3 r0 *1 0,0
Ccc_a_n2_s1_y_s2_a_y_g_vss_m1_mph_g_s1_vss_m1_s2_vss_m1_s3_vss_m1_s4_vss_m1_vss_vss_x1_vss_x2_vss_x3
+ a|n2|s1_y|s2_a|y$3
+ g_vss_m1|mph_g|s1_vss_m1|s2_vss_m1|s3_vss_m1|s4_vss_m1|vss|vss_x1|vss_x2|vss_x3
+ 1.5474e-17
* device instance cc_a_n2_s1_y_s2_a_y_ny r0 *1 0,0
Ccc_a_n2_s1_y_s2_a_y_ny a|n2|s1_y|s2_a|y$3 ny$19 3.0903e-17
* device instance cc_a_n3_s2_y_s3_a_y_g_vss_m1_mph_g_s1_vss_m1_s2_vss_m1_s3_vss_m1_s4_vss_m1_vss_vss_x1_vss_x2_vss_x3 r0 *1 0,0
Ccc_a_n3_s2_y_s3_a_y_g_vss_m1_mph_g_s1_vss_m1_s2_vss_m1_s3_vss_m1_s4_vss_m1_vss_vss_x1_vss_x2_vss_x3
+ a|n3|s2_y|s3_a|y$3
+ g_vss_m1|mph_g|s1_vss_m1|s2_vss_m1|s3_vss_m1|s4_vss_m1|vss|vss_x1|vss_x2|vss_x3
+ 1.5474e-17
* device instance cc_a_n3_s2_y_s3_a_y_ny r0 *1 0,0
Ccc_a_n3_s2_y_s3_a_y_ny a|n3|s2_y|s3_a|y$3 ny$19 3.0903e-17
* device instance cc_a_n4_s3_y_s4_a_y_g_vss_m1_mph_g_s1_vss_m1_s2_vss_m1_s3_vss_m1_s4_vss_m1_vss_vss_x1_vss_x2_vss_x3 r0 *1 0,0
Ccc_a_n4_s3_y_s4_a_y_g_vss_m1_mph_g_s1_vss_m1_s2_vss_m1_s3_vss_m1_s4_vss_m1_vss_vss_x1_vss_x2_vss_x3
+ a|n4|s3_y|s4_a|y$3
+ g_vss_m1|mph_g|s1_vss_m1|s2_vss_m1|s3_vss_m1|s4_vss_m1|vss|vss_x1|vss_x2|vss_x3
+ 1.5474e-17
* device instance cc_a_n4_s3_y_s4_a_y_ny r0 *1 0,0
Ccc_a_n4_s3_y_s4_a_y_ny a|n4|s3_y|s4_a|y$3 ny$19 3.0903e-17
* device instance cc_an_inva_y_mn34_g0_mp13_g1_y_vdd_vdd_b1_vdd_b2_vdd_b3_vdd_b4_vdd_x1_vdd_x2_vdd_x3 r0 *1 0,0
Ccc_an_inva_y_mn34_g0_mp13_g1_y_vdd_vdd_b1_vdd_b2_vdd_b3_vdd_b4_vdd_x1_vdd_x2_vdd_x3
+ an|inva_y|mn34_g0|mp13_g1|y$2
+ vdd|vdd_b1|vdd_b2|vdd_b3|vdd_b4|vdd_x1|vdd_x2|vdd_x3 2.8673e-17
* device instance cc_an_inva_y_mn34_g0_mp13_g1_y_xo_y r0 *1 0,0
Ccc_an_inva_y_mn34_g0_mp13_g1_y_xo_y an|inva_y|mn34_g0|mp13_g1|y$2 xo|y 3.3e-18
* device instance cc_bn_invb_y_mn34_g1_mp24_g1_y_mid r0 *1 0,0
Ccc_bn_invb_y_mn34_g1_mp24_g1_y_mid bn|invb_y|mn34_g1|mp24_g1|y$2 mid$2
+ 9.901e-18
* device instance cc_bn_invb_y_mn34_g1_mp24_g1_y_vdd_vdd_b1_vdd_b2_vdd_b3_vdd_b4_vdd_x1_vdd_x2_vdd_x3 r0 *1 0,0
Ccc_bn_invb_y_mn34_g1_mp24_g1_y_vdd_vdd_b1_vdd_b2_vdd_b3_vdd_b4_vdd_x1_vdd_x2_vdd_x3
+ bn|invb_y|mn34_g1|mp24_g1|y$2
+ vdd|vdd_b1|vdd_b2|vdd_b3|vdd_b4|vdd_x1|vdd_x2|vdd_x3 9.901e-18
* device instance cc_bn_invb_y_mn34_g1_mp24_g1_y_xo_y r0 *1 0,0
Ccc_bn_invb_y_mn34_g1_mp24_g1_y_xo_y bn|invb_y|mn34_g1|mp24_g1|y$2 xo|y
+ 9.901e-18
* device instance cc_g_vddr_m1_mnt_g_s1_vddr_m1_s2_vddr_m1_s3_vddr_m1_s4_vddr_m1_vddr_vddr1_py r0 *1 0,0
Ccc_g_vddr_m1_mnt_g_s1_vddr_m1_s2_vddr_m1_s3_vddr_m1_s4_vddr_m1_vddr_vddr1_py
+ g_vddr_m1|mnt_g|s1_vddr_m1|s2_vddr_m1|s3_vddr_m1|s4_vddr_m1|vddr|vddr1 py$15
+ 1.2471e-17
* device instance cc_g_vddr_m1_mnt_g_s1_vddr_m1_s2_vddr_m1_s3_vddr_m1_s4_vddr_m1_vddr_vddr2_py r0 *1 0,0
Ccc_g_vddr_m1_mnt_g_s1_vddr_m1_s2_vddr_m1_s3_vddr_m1_s4_vddr_m1_vddr_vddr2_py
+ g_vddr_m1|mnt_g|s1_vddr_m1|s2_vddr_m1|s3_vddr_m1|s4_vddr_m1|vddr|vddr2 py$15
+ 1.3064e-17
* device instance cc_g_vddr_m1_mnt_g_s1_vddr_m1_s2_vddr_m1_s3_vddr_m1_s4_vddr_m1_vddr_vddr3_py r0 *1 0,0
Ccc_g_vddr_m1_mnt_g_s1_vddr_m1_s2_vddr_m1_s3_vddr_m1_s4_vddr_m1_vddr_vddr3_py
+ g_vddr_m1|mnt_g|s1_vddr_m1|s2_vddr_m1|s3_vddr_m1|s4_vddr_m1|vddr|vddr3 py$15
+ 1.3658e-17
* device instance cc_g_vddr_m1_mnt_g_s1_vddr_m1_s2_vddr_m1_s3_vddr_m1_s4_vddr_m1_vddr_vddr4_py r0 *1 0,0
Ccc_g_vddr_m1_mnt_g_s1_vddr_m1_s2_vddr_m1_s3_vddr_m1_s4_vddr_m1_vddr_vddr4_py
+ g_vddr_m1|mnt_g|s1_vddr_m1|s2_vddr_m1|s3_vddr_m1|s4_vddr_m1|vddr|vddr4 py$15
+ 1.4252e-17
* device instance cc_g_vss_m1_mph_g_s1_vss_m1_s2_vss_m1_s3_vss_m1_s4_vss_m1_vss_vss_x1_vss_x2_vss_x3_vdd_vdd_b1_vdd_b2_vdd_b3_vdd_b4_vdd_x1_vdd_x2_vdd_x3 r0 *1 0,0
Ccc_g_vss_m1_mph_g_s1_vss_m1_s2_vss_m1_s3_vss_m1_s4_vss_m1_vss_vss_x1_vss_x2_vss_x3_vdd_vdd_b1_vdd_b2_vdd_b3_vdd_b4_vdd_x1_vdd_x2_vdd_x3
+ g_vss_m1|mph_g|s1_vss_m1|s2_vss_m1|s3_vss_m1|s4_vss_m1|vss|vss_x1|vss_x2|vss_x3
+ vdd|vdd_b1|vdd_b2|vdd_b3|vdd_b4|vdd_x1|vdd_x2|vdd_x3 2.3613e-17
* device instance vsubs_dctie r0 *1 0,0
Rvsubs_dctie vsubs 0 1e+12
.ENDS ro_array_core
