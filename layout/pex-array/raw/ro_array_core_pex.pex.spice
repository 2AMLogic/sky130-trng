* extracted by klt extract --deck sky130
* parasitic model (--parasitics):
* - capacitance: net-to-ground for every net's own (non-coupled) area/perimeter, plus net-to-net for the vertical-overlap coupling `coupling` describes below -- a coupled net pair gets a direct capacitor between their two hub nodes, not just capacitors to the deck's ground/substrate net
* - coupling: vertical overlap (crossover) unconditionally -- where one net's conductor on an adjacent metal level sits directly over another *distinct* net's conductor, that overlap area is charged between the two nets instead of to ground (issue #760) -- plus lateral (same-layer, sidewall) coupling, but only for a net pair naming one of the caller's declared `--critical-net` nets (issue #976): facing-edge length within that layer's own minimum-spacing lookback is charged between the two nets, *additively* (not deducted from either net's substrate fringe term, unlike the vertical case -- a known simplification). Any same-layer pair with neither side named `--critical-net`, and fringe shielding in general, are still not modelled
* - resistance: single lumped series resistance per net, distributed as a star across that net's device terminals (issue #592) -- not a per-segment, distributed RC ladder, *unless* `--distributed-rc` names this net via `--critical-net` (issue #977, Epic #709 Phase 2b): then the net's terminals are ordered along their approximate physical spread and its total R/C is broken into a chain of per-segment resistors (segment length proportional to inter-terminal distance) with a ground capacitor at each terminal node (proportional to its adjacent segment length/2), instead of one star hub -- still an approximation (terminal position is a device-placement proxy, not true per-segment routing geometry), but a strictly finer-grained one than the single-hub star
* - frequency: quasi-static -- one frequency-independent R and C per net; no skin effect, no distributed transmission-line behavior

* cell ro_array_core
* pin a,b,b3,invb_a,mn12_g1,mp24_g0,t2,y
* pin a,b,invb_a,mn12_g1,mp24_g0,ro2,y
* pin a,b,invb_a,mn12_g1,mp24_g0,ro4,y
* pin a,g_a,rn1,ro,s4_y,y
* pin a,g_a,rn2,ro,s4_y,y
* pin a,g_a,rn3,ro,s4_y,y
* pin a,g_a,rn4,ro,s4_y,y
* pin a,g_y,mnab_y,mpa_y,mpb_y,n1,s1_a,y
* pin a,g_y,mnab_y,mpa_y,mpb_y,n1,s1_a,y
* pin a,g_y,mnab_y,mpa_y,mpb_y,n1,s1_a,y
* pin a,g_y,mnab_y,mpa_y,mpb_y,n1,s1_a,y
* pin a,inva_a,mn12_g0,mp13_g0,ro1,y
* pin a,inva_a,mn12_g0,mp13_g0,ro3,y
* pin a,inva_a,mn12_g0,mp13_g0,t1,y
* pin a,n2,s1_y,s2_a,y
* pin a,n2,s1_y,s2_a,y
* pin a,n2,s1_y,s2_a,y
* pin a,n2,s1_y,s2_a,y
* pin a,n3,s2_y,s3_a,y
* pin a,n3,s2_y,s3_a,y
* pin a,n3,s2_y,s3_a,y
* pin a,n3,s2_y,s3_a,y
* pin a,n4,s3_y,s4_a,y
* pin a,n4,s3_y,s4_a,y
* pin a,n4,s3_y,s4_a,y
* pin a,n4,s3_y,s4_a,y
* pin an,inva_y,mn34_g0,mp13_g1,y
* pin an,inva_y,mn34_g0,mp13_g1,y
* pin an,inva_y,mn34_g0,mp13_g1,y
* pin bn,invb_y,mn34_g1,mp24_g1,y
* pin bn,invb_y,mn34_g1,mp24_g1,y
* pin bn,invb_y,mn34_g1,mp24_g1,y
* pin en,en1,g_en
* pin en,en2,g_en
* pin en,en3,g_en
* pin en,en4,g_en
* pin g_vddr_m1,mnt_g,s1_vddr_m1,s2_vddr_m1,s3_vddr_m1,s4_vddr_m1,vddr,vddr1
* pin g_vddr_m1,mnt_g,s1_vddr_m1,s2_vddr_m1,s3_vddr_m1,s4_vddr_m1,vddr,vddr2
* pin g_vddr_m1,mnt_g,s1_vddr_m1,s2_vddr_m1,s3_vddr_m1,s4_vddr_m1,vddr,vddr3
* pin g_vddr_m1,mnt_g,s1_vddr_m1,s2_vddr_m1,s3_vddr_m1,s4_vddr_m1,vddr,vddr4
* pin g_vss_m1,mph_g,s1_vss_m1,s2_vss_m1,s3_vss_m1,s4_vss_m1,vss,vss_x1,vss_x2,vss_x3
* pin mid
* pin mid
* pin mid
* pin mpa_py,mpb_py,mph_py,py
* pin mpa_py,mpb_py,mph_py,py
* pin mpa_py,mpb_py,mph_py,py
* pin mpa_py,mpb_py,mph_py,py
* pin ny
* pin ny
* pin ny
* pin ny
* pin ny
* pin ny
* pin ny
* pin ny
* pin ny
* pin ny
* pin ny
* pin ny
* pin ny
* pin ny
* pin ny
* pin ny
* pin ny
* pin ny
* pin ny
* pin ny
* pin py
* pin py
* pin py
* pin py
* pin py
* pin py
* pin py
* pin py
* pin py
* pin py
* pin py
* pin py
* pin py
* pin py
* pin py
* pin py
* pin vdd,vdd_b1,vdd_b2,vdd_b3,vdd_b4,vdd_x1,vdd_x2,vdd_x3
* pin xo,y
.SUBCKT ro_array_core a|b|b3|invb_a|mn12_g1|mp24_g0|t2|y
+ a|b|invb_a|mn12_g1|mp24_g0|ro2|y a|b|invb_a|mn12_g1|mp24_g0|ro4|y
+ a|g_a|rn1|ro|s4_y|y a|g_a|rn2|ro|s4_y|y a|g_a|rn3|ro|s4_y|y
+ a|g_a|rn4|ro|s4_y|y a|g_y|mnab_y|mpa_y|mpb_y|n1|s1_a|y
+ a|g_y|mnab_y|mpa_y|mpb_y|n1|s1_a|y$1 a|g_y|mnab_y|mpa_y|mpb_y|n1|s1_a|y$2
+ a|g_y|mnab_y|mpa_y|mpb_y|n1|s1_a|y$3 a|inva_a|mn12_g0|mp13_g0|ro1|y
+ a|inva_a|mn12_g0|mp13_g0|ro3|y a|inva_a|mn12_g0|mp13_g0|t1|y a|n2|s1_y|s2_a|y
+ a|n2|s1_y|s2_a|y$1 a|n2|s1_y|s2_a|y$2 a|n2|s1_y|s2_a|y$3 a|n3|s2_y|s3_a|y
+ a|n3|s2_y|s3_a|y$1 a|n3|s2_y|s3_a|y$2 a|n3|s2_y|s3_a|y$3 a|n4|s3_y|s4_a|y
+ a|n4|s3_y|s4_a|y$1 a|n4|s3_y|s4_a|y$2 a|n4|s3_y|s4_a|y$3
+ an|inva_y|mn34_g0|mp13_g1|y an|inva_y|mn34_g0|mp13_g1|y$1
+ an|inva_y|mn34_g0|mp13_g1|y$2 bn|invb_y|mn34_g1|mp24_g1|y
+ bn|invb_y|mn34_g1|mp24_g1|y$1 bn|invb_y|mn34_g1|mp24_g1|y$2 en|en1|g_en
+ en|en2|g_en en|en3|g_en en|en4|g_en
+ g_vddr_m1|mnt_g|s1_vddr_m1|s2_vddr_m1|s3_vddr_m1|s4_vddr_m1|vddr|vddr1
+ g_vddr_m1|mnt_g|s1_vddr_m1|s2_vddr_m1|s3_vddr_m1|s4_vddr_m1|vddr|vddr2
+ g_vddr_m1|mnt_g|s1_vddr_m1|s2_vddr_m1|s3_vddr_m1|s4_vddr_m1|vddr|vddr3
+ g_vddr_m1|mnt_g|s1_vddr_m1|s2_vddr_m1|s3_vddr_m1|s4_vddr_m1|vddr|vddr4
+ g_vss_m1|mph_g|s1_vss_m1|s2_vss_m1|s3_vss_m1|s4_vss_m1|vss|vss_x1|vss_x2|vss_x3
+ mid mid$1 mid$2 mpa_py|mpb_py|mph_py|py mpa_py|mpb_py|mph_py|py$1
+ mpa_py|mpb_py|mph_py|py$2 mpa_py|mpb_py|mph_py|py$3 ny ny$1 ny$2 ny$3 ny$4
+ ny$5 ny$6 ny$7 ny$8 ny$9 ny$10 ny$11 ny$12 ny$13 ny$14 ny$15 ny$16 ny$17
+ ny$18 ny$19 py py$1 py$2 py$3 py$4 py$5 py$6 py$7 py$8 py$9 py$10 py$11 py$12
+ py$13 py$14 py$15 vdd|vdd_b1|vdd_b2|vdd_b3|vdd_b4|vdd_x1|vdd_x2|vdd_x3 xo|y
* device instance $1 r0 *1 5.975,0.21 nfet
X$1 \$12__t1 en\x7cen1\x7cg_en__t0 ny__t0
+ g_vss_m1\x7cmph_g\x7cs1_vss_m1\x7cs2_vss_m1\x7cs3_vss_m1\x7cs4_vss_m1\x7cvss\x7cvss_x1\x7cvss_x2\x7cvss_x3__t56
+ sky130_fd_pr__nfet_01v8 L=0.15 W=0.84 AS=0.3948 AD=0.2184 PS=2.62 PD=1.36
* device instance $2 r0 *1 6.645,0.21 nfet
X$2 a\x7cg_y\x7cmnab_y\x7cmpa_y\x7cmpb_y\x7cn1\x7cs1_a\x7cy__t0
+ a\x7cg_a\x7crn1\x7cro\x7cs4_y\x7cy__t0 \$12__t0
+ g_vss_m1\x7cmph_g\x7cs1_vss_m1\x7cs2_vss_m1\x7cs3_vss_m1\x7cs4_vss_m1\x7cvss\x7cvss_x1\x7cvss_x2\x7cvss_x3__t66
+ sky130_fd_pr__nfet_01v8 L=0.15 W=0.84 AS=0.2184 AD=0.3948 PS=1.36 PD=2.62
* device instance $3 r0 *1 61.275,0.21 nfet
X$3 \$22__t0 en\x7cen2\x7cg_en__t1 ny__t16
+ g_vss_m1\x7cmph_g\x7cs1_vss_m1\x7cs2_vss_m1\x7cs3_vss_m1\x7cs4_vss_m1\x7cvss\x7cvss_x1\x7cvss_x2\x7cvss_x3__t57
+ sky130_fd_pr__nfet_01v8 L=0.15 W=0.84 AS=0.3948 AD=0.2184 PS=2.62 PD=1.36
* device instance $4 r0 *1 61.945,0.21 nfet
X$4 a\x7cg_y\x7cmnab_y\x7cmpa_y\x7cmpb_y\x7cn1\x7cs1_a\x7cy__t42
+ a\x7cg_a\x7crn2\x7cro\x7cs4_y\x7cy__t5 \$22__t1
+ g_vss_m1\x7cmph_g\x7cs1_vss_m1\x7cs2_vss_m1\x7cs3_vss_m1\x7cs4_vss_m1\x7cvss\x7cvss_x1\x7cvss_x2\x7cvss_x3__t67
+ sky130_fd_pr__nfet_01v8 L=0.15 W=0.84 AS=0.2184 AD=0.3948 PS=1.36 PD=2.62
* device instance $5 r0 *1 116.575,0.21 nfet
X$5 \$30__t0 en\x7cen3\x7cg_en__t1 ny__t111
+ g_vss_m1\x7cmph_g\x7cs1_vss_m1\x7cs2_vss_m1\x7cs3_vss_m1\x7cs4_vss_m1\x7cvss\x7cvss_x1\x7cvss_x2\x7cvss_x3__t58
+ sky130_fd_pr__nfet_01v8 L=0.15 W=0.84 AS=0.3948 AD=0.2184 PS=2.62 PD=1.36
* device instance $6 r0 *1 117.245,0.21 nfet
X$6 a\x7cg_y\x7cmnab_y\x7cmpa_y\x7cmpb_y\x7cn1\x7cs1_a\x7cy__t43
+ a\x7cg_a\x7crn3\x7cro\x7cs4_y\x7cy__t5 \$30__t1
+ g_vss_m1\x7cmph_g\x7cs1_vss_m1\x7cs2_vss_m1\x7cs3_vss_m1\x7cs4_vss_m1\x7cvss\x7cvss_x1\x7cvss_x2\x7cvss_x3__t68
+ sky130_fd_pr__nfet_01v8 L=0.15 W=0.84 AS=0.2184 AD=0.3948 PS=1.36 PD=2.62
* device instance $7 r0 *1 171.875,0.21 nfet
X$7 \$39__t0 en\x7cen4\x7cg_en__t1 ny__t116
+ g_vss_m1\x7cmph_g\x7cs1_vss_m1\x7cs2_vss_m1\x7cs3_vss_m1\x7cs4_vss_m1\x7cvss\x7cvss_x1\x7cvss_x2\x7cvss_x3__t59
+ sky130_fd_pr__nfet_01v8 L=0.15 W=0.84 AS=0.3948 AD=0.2184 PS=2.62 PD=1.36
* device instance $8 r0 *1 172.545,0.21 nfet
X$8 a\x7cg_y\x7cmnab_y\x7cmpa_y\x7cmpb_y\x7cn1\x7cs1_a\x7cy__t44
+ a\x7cg_a\x7crn4\x7cro\x7cs4_y\x7cy__t5 \$39__t1
+ g_vss_m1\x7cmph_g\x7cs1_vss_m1\x7cs2_vss_m1\x7cs3_vss_m1\x7cs4_vss_m1\x7cvss\x7cvss_x1\x7cvss_x2\x7cvss_x3__t69
+ sky130_fd_pr__nfet_01v8 L=0.15 W=0.84 AS=0.2184 AD=0.3948 PS=1.36 PD=2.62
* device instance $9 r0 *1 114.21,0.21 nfet
X$9 ny__t011
+ g_vddr_m1\x7cmnt_g\x7cs1_vddr_m1\x7cs2_vddr_m1\x7cs3_vddr_m1\x7cs4_vddr_m1\x7cvddr\x7cvddr3__t0
+ g_vss_m1\x7cmph_g\x7cs1_vss_m1\x7cs2_vss_m1\x7cs3_vss_m1\x7cs4_vss_m1\x7cvss\x7cvss_x1\x7cvss_x2\x7cvss_x3__t2
+ g_vss_m1\x7cmph_g\x7cs1_vss_m1\x7cs2_vss_m1\x7cs3_vss_m1\x7cs4_vss_m1\x7cvss\x7cvss_x1\x7cvss_x2\x7cvss_x3__t76
+ sky130_fd_pr__nfet_01v8 L=2 W=0.46 AS=0.1932 AD=0.1932 PS=1.76 PD=1.76
* device instance $10 r0 *1 123.51,0.21 nfet
X$10 ny__t012
+ g_vddr_m1\x7cmnt_g\x7cs1_vddr_m1\x7cs2_vddr_m1\x7cs3_vddr_m1\x7cs4_vddr_m1\x7cvddr\x7cvddr3__t20
+ g_vss_m1\x7cmph_g\x7cs1_vss_m1\x7cs2_vss_m1\x7cs3_vss_m1\x7cs4_vss_m1\x7cvss\x7cvss_x1\x7cvss_x2\x7cvss_x3__t31
+ g_vss_m1\x7cmph_g\x7cs1_vss_m1\x7cs2_vss_m1\x7cs3_vss_m1\x7cs4_vss_m1\x7cvss\x7cvss_x1\x7cvss_x2\x7cvss_x3__t77
+ sky130_fd_pr__nfet_01v8 L=2 W=0.46 AS=0.1932 AD=0.1932 PS=1.76 PD=1.76
* device instance $11 r0 *1 131.685,0.21 nfet
X$11 ny__t013
+ g_vddr_m1\x7cmnt_g\x7cs1_vddr_m1\x7cs2_vddr_m1\x7cs3_vddr_m1\x7cs4_vddr_m1\x7cvddr\x7cvddr3__t19
+ g_vss_m1\x7cmph_g\x7cs1_vss_m1\x7cs2_vss_m1\x7cs3_vss_m1\x7cs4_vss_m1\x7cvss\x7cvss_x1\x7cvss_x2\x7cvss_x3__t30
+ g_vss_m1\x7cmph_g\x7cs1_vss_m1\x7cs2_vss_m1\x7cs3_vss_m1\x7cs4_vss_m1\x7cvss\x7cvss_x1\x7cvss_x2\x7cvss_x3__t78
+ sky130_fd_pr__nfet_01v8 L=2 W=0.46 AS=0.1932 AD=0.1932 PS=1.76 PD=1.76
* device instance $12 r0 *1 139.86,0.21 nfet
X$12 ny__t014
+ g_vddr_m1\x7cmnt_g\x7cs1_vddr_m1\x7cs2_vddr_m1\x7cs3_vddr_m1\x7cs4_vddr_m1\x7cvddr\x7cvddr3__t17
+ g_vss_m1\x7cmph_g\x7cs1_vss_m1\x7cs2_vss_m1\x7cs3_vss_m1\x7cs4_vss_m1\x7cvss\x7cvss_x1\x7cvss_x2\x7cvss_x3__t28
+ g_vss_m1\x7cmph_g\x7cs1_vss_m1\x7cs2_vss_m1\x7cs3_vss_m1\x7cs4_vss_m1\x7cvss\x7cvss_x1\x7cvss_x2\x7cvss_x3__t79
+ sky130_fd_pr__nfet_01v8 L=2 W=0.46 AS=0.1932 AD=0.1932 PS=1.76 PD=1.76
* device instance $13 r0 *1 148.035,0.21 nfet
X$13 ny__t015
+ g_vddr_m1\x7cmnt_g\x7cs1_vddr_m1\x7cs2_vddr_m1\x7cs3_vddr_m1\x7cs4_vddr_m1\x7cvddr\x7cvddr3__t18
+ g_vss_m1\x7cmph_g\x7cs1_vss_m1\x7cs2_vss_m1\x7cs3_vss_m1\x7cs4_vss_m1\x7cvss\x7cvss_x1\x7cvss_x2\x7cvss_x3__t29
+ g_vss_m1\x7cmph_g\x7cs1_vss_m1\x7cs2_vss_m1\x7cs3_vss_m1\x7cs4_vss_m1\x7cvss\x7cvss_x1\x7cvss_x2\x7cvss_x3__t80
+ sky130_fd_pr__nfet_01v8 L=2 W=0.46 AS=0.1932 AD=0.1932 PS=1.76 PD=1.76
* device instance $14 r0 *1 169.51,0.21 nfet
X$14 ny__t016
+ g_vddr_m1\x7cmnt_g\x7cs1_vddr_m1\x7cs2_vddr_m1\x7cs3_vddr_m1\x7cs4_vddr_m1\x7cvddr\x7cvddr4__t0
+ g_vss_m1\x7cmph_g\x7cs1_vss_m1\x7cs2_vss_m1\x7cs3_vss_m1\x7cs4_vss_m1\x7cvss\x7cvss_x1\x7cvss_x2\x7cvss_x3__t3
+ g_vss_m1\x7cmph_g\x7cs1_vss_m1\x7cs2_vss_m1\x7cs3_vss_m1\x7cs4_vss_m1\x7cvss\x7cvss_x1\x7cvss_x2\x7cvss_x3__t81
+ sky130_fd_pr__nfet_01v8 L=2 W=0.48 AS=0.2016 AD=0.2016 PS=1.8 PD=1.8
* device instance $15 r0 *1 178.81,0.21 nfet
X$15 ny__t017
+ g_vddr_m1\x7cmnt_g\x7cs1_vddr_m1\x7cs2_vddr_m1\x7cs3_vddr_m1\x7cs4_vddr_m1\x7cvddr\x7cvddr4__t20
+ g_vss_m1\x7cmph_g\x7cs1_vss_m1\x7cs2_vss_m1\x7cs3_vss_m1\x7cs4_vss_m1\x7cvss\x7cvss_x1\x7cvss_x2\x7cvss_x3__t27
+ g_vss_m1\x7cmph_g\x7cs1_vss_m1\x7cs2_vss_m1\x7cs3_vss_m1\x7cs4_vss_m1\x7cvss\x7cvss_x1\x7cvss_x2\x7cvss_x3__t82
+ sky130_fd_pr__nfet_01v8 L=2 W=0.48 AS=0.2016 AD=0.2016 PS=1.8 PD=1.8
* device instance $16 r0 *1 186.985,0.21 nfet
X$16 ny__t018
+ g_vddr_m1\x7cmnt_g\x7cs1_vddr_m1\x7cs2_vddr_m1\x7cs3_vddr_m1\x7cs4_vddr_m1\x7cvddr\x7cvddr4__t19
+ g_vss_m1\x7cmph_g\x7cs1_vss_m1\x7cs2_vss_m1\x7cs3_vss_m1\x7cs4_vss_m1\x7cvss\x7cvss_x1\x7cvss_x2\x7cvss_x3__t26
+ g_vss_m1\x7cmph_g\x7cs1_vss_m1\x7cs2_vss_m1\x7cs3_vss_m1\x7cs4_vss_m1\x7cvss\x7cvss_x1\x7cvss_x2\x7cvss_x3__t83
+ sky130_fd_pr__nfet_01v8 L=2 W=0.48 AS=0.2016 AD=0.2016 PS=1.8 PD=1.8
* device instance $17 r0 *1 195.16,0.21 nfet
X$17 ny__t019
+ g_vddr_m1\x7cmnt_g\x7cs1_vddr_m1\x7cs2_vddr_m1\x7cs3_vddr_m1\x7cs4_vddr_m1\x7cvddr\x7cvddr4__t18
+ g_vss_m1\x7cmph_g\x7cs1_vss_m1\x7cs2_vss_m1\x7cs3_vss_m1\x7cs4_vss_m1\x7cvss\x7cvss_x1\x7cvss_x2\x7cvss_x3__t25
+ g_vss_m1\x7cmph_g\x7cs1_vss_m1\x7cs2_vss_m1\x7cs3_vss_m1\x7cs4_vss_m1\x7cvss\x7cvss_x1\x7cvss_x2\x7cvss_x3__t84
+ sky130_fd_pr__nfet_01v8 L=2 W=0.48 AS=0.2016 AD=0.2016 PS=1.8 PD=1.8
* device instance $18 r0 *1 203.335,0.21 nfet
X$18 ny__t020
+ g_vddr_m1\x7cmnt_g\x7cs1_vddr_m1\x7cs2_vddr_m1\x7cs3_vddr_m1\x7cs4_vddr_m1\x7cvddr\x7cvddr4__t17
+ g_vss_m1\x7cmph_g\x7cs1_vss_m1\x7cs2_vss_m1\x7cs3_vss_m1\x7cs4_vss_m1\x7cvss\x7cvss_x1\x7cvss_x2\x7cvss_x3__t24
+ g_vss_m1\x7cmph_g\x7cs1_vss_m1\x7cs2_vss_m1\x7cs3_vss_m1\x7cs4_vss_m1\x7cvss\x7cvss_x1\x7cvss_x2\x7cvss_x3__t85
+ sky130_fd_pr__nfet_01v8 L=2 W=0.48 AS=0.2016 AD=0.2016 PS=1.8 PD=1.8
* device instance $19 r0 *1 3.61,0.21 nfet
X$19 ny__t1
+ g_vddr_m1\x7cmnt_g\x7cs1_vddr_m1\x7cs2_vddr_m1\x7cs3_vddr_m1\x7cs4_vddr_m1\x7cvddr\x7cvddr1__t0
+ g_vss_m1\x7cmph_g\x7cs1_vss_m1\x7cs2_vss_m1\x7cs3_vss_m1\x7cs4_vss_m1\x7cvss\x7cvss_x1\x7cvss_x2\x7cvss_x3__t0
+ g_vss_m1\x7cmph_g\x7cs1_vss_m1\x7cs2_vss_m1\x7cs3_vss_m1\x7cs4_vss_m1\x7cvss\x7cvss_x1\x7cvss_x2\x7cvss_x3__t86
+ sky130_fd_pr__nfet_01v8 L=2 W=0.42 AS=0.1764 AD=0.1764 PS=1.68 PD=1.68
* device instance $20 r0 *1 12.91,0.21 nfet
X$20 ny__t12
+ g_vddr_m1\x7cmnt_g\x7cs1_vddr_m1\x7cs2_vddr_m1\x7cs3_vddr_m1\x7cs4_vddr_m1\x7cvddr\x7cvddr1__t17
+ g_vss_m1\x7cmph_g\x7cs1_vss_m1\x7cs2_vss_m1\x7cs3_vss_m1\x7cs4_vss_m1\x7cvss\x7cvss_x1\x7cvss_x2\x7cvss_x3__t46
+ g_vss_m1\x7cmph_g\x7cs1_vss_m1\x7cs2_vss_m1\x7cs3_vss_m1\x7cs4_vss_m1\x7cvss\x7cvss_x1\x7cvss_x2\x7cvss_x3__t87
+ sky130_fd_pr__nfet_01v8 L=2 W=0.42 AS=0.1764 AD=0.1764 PS=1.68 PD=1.68
* device instance $21 r0 *1 15.275,0.21 nfet
X$21 a\x7cn2\x7cs1_y\x7cs2_a\x7cy__t0
+ a\x7cg_y\x7cmnab_y\x7cmpa_y\x7cmpb_y\x7cn1\x7cs1_a\x7cy__t1 ny__t02
+ g_vss_m1\x7cmph_g\x7cs1_vss_m1\x7cs2_vss_m1\x7cs3_vss_m1\x7cs4_vss_m1\x7cvss\x7cvss_x1\x7cvss_x2\x7cvss_x3__t91
+ sky130_fd_pr__nfet_01v8 L=0.15 W=0.42 AS=0.1974 AD=0.1974 PS=1.78 PD=1.78
* device instance $22 r0 *1 21.085,0.21 nfet
X$22 ny__t13
+ g_vddr_m1\x7cmnt_g\x7cs1_vddr_m1\x7cs2_vddr_m1\x7cs3_vddr_m1\x7cs4_vddr_m1\x7cvddr\x7cvddr1__t20
+ g_vss_m1\x7cmph_g\x7cs1_vss_m1\x7cs2_vss_m1\x7cs3_vss_m1\x7cs4_vss_m1\x7cvss\x7cvss_x1\x7cvss_x2\x7cvss_x3__t49
+ g_vss_m1\x7cmph_g\x7cs1_vss_m1\x7cs2_vss_m1\x7cs3_vss_m1\x7cs4_vss_m1\x7cvss\x7cvss_x1\x7cvss_x2\x7cvss_x3__t88
+ sky130_fd_pr__nfet_01v8 L=2 W=0.42 AS=0.1764 AD=0.1764 PS=1.68 PD=1.68
* device instance $23 r0 *1 23.45,0.21 nfet
X$23 a\x7cn3\x7cs2_y\x7cs3_a\x7cy__t22 a\x7cn2\x7cs1_y\x7cs2_a\x7cy__t3 ny__t03
+ g_vss_m1\x7cmph_g\x7cs1_vss_m1\x7cs2_vss_m1\x7cs3_vss_m1\x7cs4_vss_m1\x7cvss\x7cvss_x1\x7cvss_x2\x7cvss_x3__t92
+ sky130_fd_pr__nfet_01v8 L=0.15 W=0.42 AS=0.1974 AD=0.1974 PS=1.78 PD=1.78
* device instance $24 r0 *1 29.26,0.21 nfet
X$24 ny__t14
+ g_vddr_m1\x7cmnt_g\x7cs1_vddr_m1\x7cs2_vddr_m1\x7cs3_vddr_m1\x7cs4_vddr_m1\x7cvddr\x7cvddr1__t18
+ g_vss_m1\x7cmph_g\x7cs1_vss_m1\x7cs2_vss_m1\x7cs3_vss_m1\x7cs4_vss_m1\x7cvss\x7cvss_x1\x7cvss_x2\x7cvss_x3__t47
+ g_vss_m1\x7cmph_g\x7cs1_vss_m1\x7cs2_vss_m1\x7cs3_vss_m1\x7cs4_vss_m1\x7cvss\x7cvss_x1\x7cvss_x2\x7cvss_x3__t89
+ sky130_fd_pr__nfet_01v8 L=2 W=0.42 AS=0.1764 AD=0.1764 PS=1.68 PD=1.68
* device instance $25 r0 *1 31.625,0.21 nfet
X$25 a\x7cn4\x7cs3_y\x7cs4_a\x7cy__t23 a\x7cn3\x7cs2_y\x7cs3_a\x7cy__t32
+ ny__t04
+ g_vss_m1\x7cmph_g\x7cs1_vss_m1\x7cs2_vss_m1\x7cs3_vss_m1\x7cs4_vss_m1\x7cvss\x7cvss_x1\x7cvss_x2\x7cvss_x3__t93
+ sky130_fd_pr__nfet_01v8 L=0.15 W=0.42 AS=0.1974 AD=0.1974 PS=1.78 PD=1.78
* device instance $26 r0 *1 37.435,0.21 nfet
X$26 ny__t15
+ g_vddr_m1\x7cmnt_g\x7cs1_vddr_m1\x7cs2_vddr_m1\x7cs3_vddr_m1\x7cs4_vddr_m1\x7cvddr\x7cvddr1__t19
+ g_vss_m1\x7cmph_g\x7cs1_vss_m1\x7cs2_vss_m1\x7cs3_vss_m1\x7cs4_vss_m1\x7cvss\x7cvss_x1\x7cvss_x2\x7cvss_x3__t48
+ g_vss_m1\x7cmph_g\x7cs1_vss_m1\x7cs2_vss_m1\x7cs3_vss_m1\x7cs4_vss_m1\x7cvss\x7cvss_x1\x7cvss_x2\x7cvss_x3__t90
+ sky130_fd_pr__nfet_01v8 L=2 W=0.42 AS=0.1764 AD=0.1764 PS=1.68 PD=1.68
* device instance $27 r0 *1 39.8,0.21 nfet
X$27 a\x7cg_a\x7crn1\x7cro\x7cs4_y\x7cy__t4 a\x7cn4\x7cs3_y\x7cs4_a\x7cy__t33
+ ny__t05
+ g_vss_m1\x7cmph_g\x7cs1_vss_m1\x7cs2_vss_m1\x7cs3_vss_m1\x7cs4_vss_m1\x7cvss\x7cvss_x1\x7cvss_x2\x7cvss_x3__t94
+ sky130_fd_pr__nfet_01v8 L=0.15 W=0.42 AS=0.1974 AD=0.1974 PS=1.78 PD=1.78
* device instance $28 r0 *1 48.86,0.21 nfet
X$28 a\x7cinva_a\x7cmn12_g0\x7cmp13_g0\x7cro1\x7cy__t3
+ a\x7cg_a\x7crn1\x7cro\x7cs4_y\x7cy__t5
+ g_vss_m1\x7cmph_g\x7cs1_vss_m1\x7cs2_vss_m1\x7cs3_vss_m1\x7cs4_vss_m1\x7cvss\x7cvss_x1\x7cvss_x2\x7cvss_x3__t41
+ g_vss_m1\x7cmph_g\x7cs1_vss_m1\x7cs2_vss_m1\x7cs3_vss_m1\x7cs4_vss_m1\x7cvss\x7cvss_x1\x7cvss_x2\x7cvss_x3__t95
+ sky130_fd_pr__nfet_01v8 L=0.15 W=0.42 AS=0.1974 AD=0.1974 PS=1.78 PD=1.78
* device instance $29 r0 *1 58.91,0.21 nfet
X$29 ny__t06
+ g_vddr_m1\x7cmnt_g\x7cs1_vddr_m1\x7cs2_vddr_m1\x7cs3_vddr_m1\x7cs4_vddr_m1\x7cvddr\x7cvddr2__t0
+ g_vss_m1\x7cmph_g\x7cs1_vss_m1\x7cs2_vss_m1\x7cs3_vss_m1\x7cs4_vss_m1\x7cvss\x7cvss_x1\x7cvss_x2\x7cvss_x3__t1
+ g_vss_m1\x7cmph_g\x7cs1_vss_m1\x7cs2_vss_m1\x7cs3_vss_m1\x7cs4_vss_m1\x7cvss\x7cvss_x1\x7cvss_x2\x7cvss_x3__t117
+ sky130_fd_pr__nfet_01v8 L=2 W=0.44 AS=0.1848 AD=0.1848 PS=1.72 PD=1.72
* device instance $30 r0 *1 68.21,0.21 nfet
X$30 ny__t07
+ g_vddr_m1\x7cmnt_g\x7cs1_vddr_m1\x7cs2_vddr_m1\x7cs3_vddr_m1\x7cs4_vddr_m1\x7cvddr\x7cvddr2__t20
+ g_vss_m1\x7cmph_g\x7cs1_vss_m1\x7cs2_vss_m1\x7cs3_vss_m1\x7cs4_vss_m1\x7cvss\x7cvss_x1\x7cvss_x2\x7cvss_x3__t35
+ g_vss_m1\x7cmph_g\x7cs1_vss_m1\x7cs2_vss_m1\x7cs3_vss_m1\x7cs4_vss_m1\x7cvss\x7cvss_x1\x7cvss_x2\x7cvss_x3__t118
+ sky130_fd_pr__nfet_01v8 L=2 W=0.44 AS=0.1848 AD=0.1848 PS=1.72 PD=1.72
* device instance $31 r0 *1 70.575,0.21 nfet
X$31 a\x7cn2\x7cs1_y\x7cs2_a\x7cy__t22
+ a\x7cg_y\x7cmnab_y\x7cmpa_y\x7cmpb_y\x7cn1\x7cs1_a\x7cy__t32 ny__t17
+ g_vss_m1\x7cmph_g\x7cs1_vss_m1\x7cs2_vss_m1\x7cs3_vss_m1\x7cs4_vss_m1\x7cvss\x7cvss_x1\x7cvss_x2\x7cvss_x3__t96
+ sky130_fd_pr__nfet_01v8 L=0.15 W=0.42 AS=0.1974 AD=0.1974 PS=1.78 PD=1.78
* device instance $32 r0 *1 76.385,0.21 nfet
X$32 ny__t08
+ g_vddr_m1\x7cmnt_g\x7cs1_vddr_m1\x7cs2_vddr_m1\x7cs3_vddr_m1\x7cs4_vddr_m1\x7cvddr\x7cvddr2__t19
+ g_vss_m1\x7cmph_g\x7cs1_vss_m1\x7cs2_vss_m1\x7cs3_vss_m1\x7cs4_vss_m1\x7cvss\x7cvss_x1\x7cvss_x2\x7cvss_x3__t34
+ g_vss_m1\x7cmph_g\x7cs1_vss_m1\x7cs2_vss_m1\x7cs3_vss_m1\x7cs4_vss_m1\x7cvss\x7cvss_x1\x7cvss_x2\x7cvss_x3__t119
+ sky130_fd_pr__nfet_01v8 L=2 W=0.44 AS=0.1848 AD=0.1848 PS=1.72 PD=1.72
* device instance $33 r0 *1 78.75,0.21 nfet
X$33 a\x7cn3\x7cs2_y\x7cs3_a\x7cy__t2 a\x7cn2\x7cs1_y\x7cs2_a\x7cy__t32 ny__t18
+ g_vss_m1\x7cmph_g\x7cs1_vss_m1\x7cs2_vss_m1\x7cs3_vss_m1\x7cs4_vss_m1\x7cvss\x7cvss_x1\x7cvss_x2\x7cvss_x3__t97
+ sky130_fd_pr__nfet_01v8 L=0.15 W=0.42 AS=0.1974 AD=0.1974 PS=1.78 PD=1.78
* device instance $34 r0 *1 84.56,0.21 nfet
X$34 ny__t09
+ g_vddr_m1\x7cmnt_g\x7cs1_vddr_m1\x7cs2_vddr_m1\x7cs3_vddr_m1\x7cs4_vddr_m1\x7cvddr\x7cvddr2__t18
+ g_vss_m1\x7cmph_g\x7cs1_vss_m1\x7cs2_vss_m1\x7cs3_vss_m1\x7cs4_vss_m1\x7cvss\x7cvss_x1\x7cvss_x2\x7cvss_x3__t33
+ g_vss_m1\x7cmph_g\x7cs1_vss_m1\x7cs2_vss_m1\x7cs3_vss_m1\x7cs4_vss_m1\x7cvss\x7cvss_x1\x7cvss_x2\x7cvss_x3__t120
+ sky130_fd_pr__nfet_01v8 L=2 W=0.44 AS=0.1848 AD=0.1848 PS=1.72 PD=1.72
* device instance $35 r0 *1 86.925,0.21 nfet
X$35 a\x7cn4\x7cs3_y\x7cs4_a\x7cy__t2 a\x7cn3\x7cs2_y\x7cs3_a\x7cy__t3 ny__t19
+ g_vss_m1\x7cmph_g\x7cs1_vss_m1\x7cs2_vss_m1\x7cs3_vss_m1\x7cs4_vss_m1\x7cvss\x7cvss_x1\x7cvss_x2\x7cvss_x3__t98
+ sky130_fd_pr__nfet_01v8 L=0.15 W=0.42 AS=0.1974 AD=0.1974 PS=1.78 PD=1.78
* device instance $36 r0 *1 92.735,0.21 nfet
X$36 ny__t010
+ g_vddr_m1\x7cmnt_g\x7cs1_vddr_m1\x7cs2_vddr_m1\x7cs3_vddr_m1\x7cs4_vddr_m1\x7cvddr\x7cvddr2__t17
+ g_vss_m1\x7cmph_g\x7cs1_vss_m1\x7cs2_vss_m1\x7cs3_vss_m1\x7cs4_vss_m1\x7cvss\x7cvss_x1\x7cvss_x2\x7cvss_x3__t32
+ g_vss_m1\x7cmph_g\x7cs1_vss_m1\x7cs2_vss_m1\x7cs3_vss_m1\x7cs4_vss_m1\x7cvss\x7cvss_x1\x7cvss_x2\x7cvss_x3__t121
+ sky130_fd_pr__nfet_01v8 L=2 W=0.44 AS=0.1848 AD=0.1848 PS=1.72 PD=1.72
* device instance $37 r0 *1 95.1,0.21 nfet
X$37 a\x7cg_a\x7crn2\x7cro\x7cs4_y\x7cy__t3 a\x7cn4\x7cs3_y\x7cs4_a\x7cy__t3
+ ny__t110
+ g_vss_m1\x7cmph_g\x7cs1_vss_m1\x7cs2_vss_m1\x7cs3_vss_m1\x7cs4_vss_m1\x7cvss\x7cvss_x1\x7cvss_x2\x7cvss_x3__t99
+ sky130_fd_pr__nfet_01v8 L=0.15 W=0.42 AS=0.1974 AD=0.1974 PS=1.78 PD=1.78
* device instance $38 r0 *1 104.16,0.21 nfet
X$38 a\x7cb\x7cinvb_a\x7cmn12_g1\x7cmp24_g0\x7cro2\x7cy__t3
+ a\x7cg_a\x7crn2\x7cro\x7cs4_y\x7cy__t4
+ g_vss_m1\x7cmph_g\x7cs1_vss_m1\x7cs2_vss_m1\x7cs3_vss_m1\x7cs4_vss_m1\x7cvss\x7cvss_x1\x7cvss_x2\x7cvss_x3__t43
+ g_vss_m1\x7cmph_g\x7cs1_vss_m1\x7cs2_vss_m1\x7cs3_vss_m1\x7cs4_vss_m1\x7cvss\x7cvss_x1\x7cvss_x2\x7cvss_x3__t100
+ sky130_fd_pr__nfet_01v8 L=0.15 W=0.42 AS=0.1974 AD=0.1974 PS=1.78 PD=1.78
* device instance $39 r0 *1 125.875,0.21 nfet
X$39 a\x7cn2\x7cs1_y\x7cs2_a\x7cy__t23
+ a\x7cg_y\x7cmnab_y\x7cmpa_y\x7cmpb_y\x7cn1\x7cs1_a\x7cy__t33 ny__t112
+ g_vss_m1\x7cmph_g\x7cs1_vss_m1\x7cs2_vss_m1\x7cs3_vss_m1\x7cs4_vss_m1\x7cvss\x7cvss_x1\x7cvss_x2\x7cvss_x3__t101
+ sky130_fd_pr__nfet_01v8 L=0.15 W=0.42 AS=0.1974 AD=0.1974 PS=1.78 PD=1.78
* device instance $40 r0 *1 134.05,0.21 nfet
X$40 a\x7cn3\x7cs2_y\x7cs3_a\x7cy__t23 a\x7cn2\x7cs1_y\x7cs2_a\x7cy__t33
+ ny__t113
+ g_vss_m1\x7cmph_g\x7cs1_vss_m1\x7cs2_vss_m1\x7cs3_vss_m1\x7cs4_vss_m1\x7cvss\x7cvss_x1\x7cvss_x2\x7cvss_x3__t102
+ sky130_fd_pr__nfet_01v8 L=0.15 W=0.42 AS=0.1974 AD=0.1974 PS=1.78 PD=1.78
* device instance $41 r0 *1 142.225,0.21 nfet
X$41 a\x7cn4\x7cs3_y\x7cs4_a\x7cy__t22 a\x7cn3\x7cs2_y\x7cs3_a\x7cy__t33
+ ny__t114
+ g_vss_m1\x7cmph_g\x7cs1_vss_m1\x7cs2_vss_m1\x7cs3_vss_m1\x7cs4_vss_m1\x7cvss\x7cvss_x1\x7cvss_x2\x7cvss_x3__t103
+ sky130_fd_pr__nfet_01v8 L=0.15 W=0.42 AS=0.1974 AD=0.1974 PS=1.78 PD=1.78
* device instance $42 r0 *1 150.4,0.21 nfet
X$42 a\x7cg_a\x7crn3\x7cro\x7cs4_y\x7cy__t3 a\x7cn4\x7cs3_y\x7cs4_a\x7cy__t32
+ ny__t115
+ g_vss_m1\x7cmph_g\x7cs1_vss_m1\x7cs2_vss_m1\x7cs3_vss_m1\x7cs4_vss_m1\x7cvss\x7cvss_x1\x7cvss_x2\x7cvss_x3__t104
+ sky130_fd_pr__nfet_01v8 L=0.15 W=0.42 AS=0.1974 AD=0.1974 PS=1.78 PD=1.78
* device instance $43 r0 *1 159.46,0.21 nfet
X$43 a\x7cinva_a\x7cmn12_g0\x7cmp13_g0\x7cro3\x7cy__t3
+ a\x7cg_a\x7crn3\x7cro\x7cs4_y\x7cy__t4
+ g_vss_m1\x7cmph_g\x7cs1_vss_m1\x7cs2_vss_m1\x7cs3_vss_m1\x7cs4_vss_m1\x7cvss\x7cvss_x1\x7cvss_x2\x7cvss_x3__t42
+ g_vss_m1\x7cmph_g\x7cs1_vss_m1\x7cs2_vss_m1\x7cs3_vss_m1\x7cs4_vss_m1\x7cvss\x7cvss_x1\x7cvss_x2\x7cvss_x3__t105
+ sky130_fd_pr__nfet_01v8 L=0.15 W=0.42 AS=0.1974 AD=0.1974 PS=1.78 PD=1.78
* device instance $44 r0 *1 181.175,0.21 nfet
X$44 a\x7cn2\x7cs1_y\x7cs2_a\x7cy__t24
+ a\x7cg_y\x7cmnab_y\x7cmpa_y\x7cmpb_y\x7cn1\x7cs1_a\x7cy__t34 ny__t117
+ g_vss_m1\x7cmph_g\x7cs1_vss_m1\x7cs2_vss_m1\x7cs3_vss_m1\x7cs4_vss_m1\x7cvss\x7cvss_x1\x7cvss_x2\x7cvss_x3__t106
+ sky130_fd_pr__nfet_01v8 L=0.15 W=0.42 AS=0.1974 AD=0.1974 PS=1.78 PD=1.78
* device instance $45 r0 *1 189.35,0.21 nfet
X$45 a\x7cn3\x7cs2_y\x7cs3_a\x7cy__t24 a\x7cn2\x7cs1_y\x7cs2_a\x7cy__t34
+ ny__t118
+ g_vss_m1\x7cmph_g\x7cs1_vss_m1\x7cs2_vss_m1\x7cs3_vss_m1\x7cs4_vss_m1\x7cvss\x7cvss_x1\x7cvss_x2\x7cvss_x3__t107
+ sky130_fd_pr__nfet_01v8 L=0.15 W=0.42 AS=0.1974 AD=0.1974 PS=1.78 PD=1.78
* device instance $46 r0 *1 197.525,0.21 nfet
X$46 a\x7cn4\x7cs3_y\x7cs4_a\x7cy__t24 a\x7cn3\x7cs2_y\x7cs3_a\x7cy__t34
+ ny__t119
+ g_vss_m1\x7cmph_g\x7cs1_vss_m1\x7cs2_vss_m1\x7cs3_vss_m1\x7cs4_vss_m1\x7cvss\x7cvss_x1\x7cvss_x2\x7cvss_x3__t108
+ sky130_fd_pr__nfet_01v8 L=0.15 W=0.42 AS=0.1974 AD=0.1974 PS=1.78 PD=1.78
* device instance $47 r0 *1 205.7,0.21 nfet
X$47 a\x7cg_a\x7crn4\x7cro\x7cs4_y\x7cy__t3 a\x7cn4\x7cs3_y\x7cs4_a\x7cy__t34
+ ny__t120
+ g_vss_m1\x7cmph_g\x7cs1_vss_m1\x7cs2_vss_m1\x7cs3_vss_m1\x7cs4_vss_m1\x7cvss\x7cvss_x1\x7cvss_x2\x7cvss_x3__t109
+ sky130_fd_pr__nfet_01v8 L=0.15 W=0.42 AS=0.1974 AD=0.1974 PS=1.78 PD=1.78
* device instance $48 r0 *1 214.76,0.21 nfet
X$48 a\x7cb\x7cinvb_a\x7cmn12_g1\x7cmp24_g0\x7cro4\x7cy__t3
+ a\x7cg_a\x7crn4\x7cro\x7cs4_y\x7cy__t4
+ g_vss_m1\x7cmph_g\x7cs1_vss_m1\x7cs2_vss_m1\x7cs3_vss_m1\x7cs4_vss_m1\x7cvss\x7cvss_x1\x7cvss_x2\x7cvss_x3__t37
+ g_vss_m1\x7cmph_g\x7cs1_vss_m1\x7cs2_vss_m1\x7cs3_vss_m1\x7cs4_vss_m1\x7cvss\x7cvss_x1\x7cvss_x2\x7cvss_x3__t110
+ sky130_fd_pr__nfet_01v8 L=0.15 W=0.42 AS=0.1974 AD=0.1974 PS=1.78 PD=1.78
* device instance $49 r0 *1 3.445,17.905 nfet
X$49 an\x7cinva_y\x7cmn34_g0\x7cmp13_g1\x7cy__t2
+ a\x7cinva_a\x7cmn12_g0\x7cmp13_g0\x7cro1\x7cy__t4
+ g_vss_m1\x7cmph_g\x7cs1_vss_m1\x7cs2_vss_m1\x7cs3_vss_m1\x7cs4_vss_m1\x7cvss\x7cvss_x1\x7cvss_x2\x7cvss_x3__t45
+ g_vss_m1\x7cmph_g\x7cs1_vss_m1\x7cs2_vss_m1\x7cs3_vss_m1\x7cs4_vss_m1\x7cvss\x7cvss_x1\x7cvss_x2\x7cvss_x3__t111
+ sky130_fd_pr__nfet_01v8 L=0.15 W=0.42 AS=0.1974 AD=0.1974 PS=1.78 PD=1.78
* device instance $50 r0 *1 7.78,15.585 nfet
X$50 \$79__t0 an\x7cinva_y\x7cmn34_g0\x7cmp13_g1\x7cy__t3
+ a\x7cinva_a\x7cmn12_g0\x7cmp13_g0\x7ct1\x7cy__t7
+ g_vss_m1\x7cmph_g\x7cs1_vss_m1\x7cs2_vss_m1\x7cs3_vss_m1\x7cs4_vss_m1\x7cvss\x7cvss_x1\x7cvss_x2\x7cvss_x3__t60
+ sky130_fd_pr__nfet_01v8 L=0.15 W=0.84 AS=0.3948 AD=0.2184 PS=2.62 PD=1.36
* device instance $51 r0 *1 8.45,15.585 nfet
X$51
+ g_vss_m1\x7cmph_g\x7cs1_vss_m1\x7cs2_vss_m1\x7cs3_vss_m1\x7cs4_vss_m1\x7cvss\x7cvss_x1\x7cvss_x2\x7cvss_x3__t55
+ bn\x7cinvb_y\x7cmn34_g1\x7cmp24_g1\x7cy__t3 \$79__t1
+ g_vss_m1\x7cmph_g\x7cs1_vss_m1\x7cs2_vss_m1\x7cs3_vss_m1\x7cs4_vss_m1\x7cvss\x7cvss_x1\x7cvss_x2\x7cvss_x3__t70
+ sky130_fd_pr__nfet_01v8 L=0.15 W=0.84 AS=0.2184 AD=0.3948 PS=1.36 PD=2.62
* device instance $52 r0 *1 14.78,15.585 nfet
X$52 \$81__t0 a\x7cinva_a\x7cmn12_g0\x7cmp13_g0\x7cro1\x7cy__t5
+ a\x7cinva_a\x7cmn12_g0\x7cmp13_g0\x7ct1\x7cy__t6
+ g_vss_m1\x7cmph_g\x7cs1_vss_m1\x7cs2_vss_m1\x7cs3_vss_m1\x7cs4_vss_m1\x7cvss\x7cvss_x1\x7cvss_x2\x7cvss_x3__t61
+ sky130_fd_pr__nfet_01v8 L=0.15 W=0.84 AS=0.3948 AD=0.2184 PS=2.62 PD=1.36
* device instance $53 r0 *1 15.45,15.585 nfet
X$53
+ g_vss_m1\x7cmph_g\x7cs1_vss_m1\x7cs2_vss_m1\x7cs3_vss_m1\x7cs4_vss_m1\x7cvss\x7cvss_x1\x7cvss_x2\x7cvss_x3__t50
+ a\x7cb\x7cinvb_a\x7cmn12_g1\x7cmp24_g0\x7cro2\x7cy__t5 \$81__t1
+ g_vss_m1\x7cmph_g\x7cs1_vss_m1\x7cs2_vss_m1\x7cs3_vss_m1\x7cs4_vss_m1\x7cvss\x7cvss_x1\x7cvss_x2\x7cvss_x3__t71
+ sky130_fd_pr__nfet_01v8 L=0.15 W=0.84 AS=0.2184 AD=0.3948 PS=1.36 PD=2.62
* device instance $54 r0 *1 21.62,17.905 nfet
X$54 bn\x7cinvb_y\x7cmn34_g1\x7cmp24_g1\x7cy__t2
+ a\x7cb\x7cinvb_a\x7cmn12_g1\x7cmp24_g0\x7cro2\x7cy__t4
+ g_vss_m1\x7cmph_g\x7cs1_vss_m1\x7cs2_vss_m1\x7cs3_vss_m1\x7cs4_vss_m1\x7cvss\x7cvss_x1\x7cvss_x2\x7cvss_x3__t40
+ g_vss_m1\x7cmph_g\x7cs1_vss_m1\x7cs2_vss_m1\x7cs3_vss_m1\x7cs4_vss_m1\x7cvss\x7cvss_x1\x7cvss_x2\x7cvss_x3__t112
+ sky130_fd_pr__nfet_01v8 L=0.15 W=0.42 AS=0.1974 AD=0.1974 PS=1.78 PD=1.78
* device instance $55 r0 *1 32.415,17.905 nfet
X$55 an\x7cinva_y\x7cmn34_g0\x7cmp13_g1\x7cy__t22
+ a\x7cinva_a\x7cmn12_g0\x7cmp13_g0\x7cro3\x7cy__t4
+ g_vss_m1\x7cmph_g\x7cs1_vss_m1\x7cs2_vss_m1\x7cs3_vss_m1\x7cs4_vss_m1\x7cvss\x7cvss_x1\x7cvss_x2\x7cvss_x3__t39
+ g_vss_m1\x7cmph_g\x7cs1_vss_m1\x7cs2_vss_m1\x7cs3_vss_m1\x7cs4_vss_m1\x7cvss\x7cvss_x1\x7cvss_x2\x7cvss_x3__t113
+ sky130_fd_pr__nfet_01v8 L=0.15 W=0.42 AS=0.1974 AD=0.1974 PS=1.78 PD=1.78
* device instance $56 r0 *1 36.75,15.585 nfet
X$56 \$82__t0 an\x7cinva_y\x7cmn34_g0\x7cmp13_g1\x7cy__t32
+ a\x7cb\x7cb3\x7cinvb_a\x7cmn12_g1\x7cmp24_g0\x7ct2\x7cy__t7
+ g_vss_m1\x7cmph_g\x7cs1_vss_m1\x7cs2_vss_m1\x7cs3_vss_m1\x7cs4_vss_m1\x7cvss\x7cvss_x1\x7cvss_x2\x7cvss_x3__t62
+ sky130_fd_pr__nfet_01v8 L=0.15 W=0.84 AS=0.3948 AD=0.2184 PS=2.62 PD=1.36
* device instance $57 r0 *1 37.42,15.585 nfet
X$57
+ g_vss_m1\x7cmph_g\x7cs1_vss_m1\x7cs2_vss_m1\x7cs3_vss_m1\x7cs4_vss_m1\x7cvss\x7cvss_x1\x7cvss_x2\x7cvss_x3__t51
+ bn\x7cinvb_y\x7cmn34_g1\x7cmp24_g1\x7cy__t32 \$82__t1
+ g_vss_m1\x7cmph_g\x7cs1_vss_m1\x7cs2_vss_m1\x7cs3_vss_m1\x7cs4_vss_m1\x7cvss\x7cvss_x1\x7cvss_x2\x7cvss_x3__t72
+ sky130_fd_pr__nfet_01v8 L=0.15 W=0.84 AS=0.2184 AD=0.3948 PS=1.36 PD=2.62
* device instance $58 r0 *1 43.75,15.585 nfet
X$58 \$84__t0 a\x7cinva_a\x7cmn12_g0\x7cmp13_g0\x7cro3\x7cy__t5
+ a\x7cb\x7cb3\x7cinvb_a\x7cmn12_g1\x7cmp24_g0\x7ct2\x7cy__t6
+ g_vss_m1\x7cmph_g\x7cs1_vss_m1\x7cs2_vss_m1\x7cs3_vss_m1\x7cs4_vss_m1\x7cvss\x7cvss_x1\x7cvss_x2\x7cvss_x3__t63
+ sky130_fd_pr__nfet_01v8 L=0.15 W=0.84 AS=0.3948 AD=0.2184 PS=2.62 PD=1.36
* device instance $59 r0 *1 44.42,15.585 nfet
X$59
+ g_vss_m1\x7cmph_g\x7cs1_vss_m1\x7cs2_vss_m1\x7cs3_vss_m1\x7cs4_vss_m1\x7cvss\x7cvss_x1\x7cvss_x2\x7cvss_x3__t52
+ a\x7cb\x7cinvb_a\x7cmn12_g1\x7cmp24_g0\x7cro4\x7cy__t5 \$84__t1
+ g_vss_m1\x7cmph_g\x7cs1_vss_m1\x7cs2_vss_m1\x7cs3_vss_m1\x7cs4_vss_m1\x7cvss\x7cvss_x1\x7cvss_x2\x7cvss_x3__t73
+ sky130_fd_pr__nfet_01v8 L=0.15 W=0.84 AS=0.2184 AD=0.3948 PS=1.36 PD=2.62
* device instance $60 r0 *1 50.59,17.905 nfet
X$60 bn\x7cinvb_y\x7cmn34_g1\x7cmp24_g1\x7cy__t22
+ a\x7cb\x7cinvb_a\x7cmn12_g1\x7cmp24_g0\x7cro4\x7cy__t4
+ g_vss_m1\x7cmph_g\x7cs1_vss_m1\x7cs2_vss_m1\x7cs3_vss_m1\x7cs4_vss_m1\x7cvss\x7cvss_x1\x7cvss_x2\x7cvss_x3__t36
+ g_vss_m1\x7cmph_g\x7cs1_vss_m1\x7cs2_vss_m1\x7cs3_vss_m1\x7cs4_vss_m1\x7cvss\x7cvss_x1\x7cvss_x2\x7cvss_x3__t114
+ sky130_fd_pr__nfet_01v8 L=0.15 W=0.42 AS=0.1974 AD=0.1974 PS=1.78 PD=1.78
* device instance $61 r0 *1 61.385,17.905 nfet
X$61 an\x7cinva_y\x7cmn34_g0\x7cmp13_g1\x7cy__t23
+ a\x7cinva_a\x7cmn12_g0\x7cmp13_g0\x7ct1\x7cy__t4
+ g_vss_m1\x7cmph_g\x7cs1_vss_m1\x7cs2_vss_m1\x7cs3_vss_m1\x7cs4_vss_m1\x7cvss\x7cvss_x1\x7cvss_x2\x7cvss_x3__t44
+ g_vss_m1\x7cmph_g\x7cs1_vss_m1\x7cs2_vss_m1\x7cs3_vss_m1\x7cs4_vss_m1\x7cvss\x7cvss_x1\x7cvss_x2\x7cvss_x3__t115
+ sky130_fd_pr__nfet_01v8 L=0.15 W=0.42 AS=0.1974 AD=0.1974 PS=1.78 PD=1.78
* device instance $62 r0 *1 65.72,15.585 nfet
X$62 \$87__t0 an\x7cinva_y\x7cmn34_g0\x7cmp13_g1\x7cy__t33 xo\x7cy__t2
+ g_vss_m1\x7cmph_g\x7cs1_vss_m1\x7cs2_vss_m1\x7cs3_vss_m1\x7cs4_vss_m1\x7cvss\x7cvss_x1\x7cvss_x2\x7cvss_x3__t64
+ sky130_fd_pr__nfet_01v8 L=0.15 W=0.84 AS=0.3948 AD=0.2184 PS=2.62 PD=1.36
* device instance $63 r0 *1 66.39,15.585 nfet
X$63
+ g_vss_m1\x7cmph_g\x7cs1_vss_m1\x7cs2_vss_m1\x7cs3_vss_m1\x7cs4_vss_m1\x7cvss\x7cvss_x1\x7cvss_x2\x7cvss_x3__t54
+ bn\x7cinvb_y\x7cmn34_g1\x7cmp24_g1\x7cy__t33 \$87__t1
+ g_vss_m1\x7cmph_g\x7cs1_vss_m1\x7cs2_vss_m1\x7cs3_vss_m1\x7cs4_vss_m1\x7cvss\x7cvss_x1\x7cvss_x2\x7cvss_x3__t74
+ sky130_fd_pr__nfet_01v8 L=0.15 W=0.84 AS=0.2184 AD=0.3948 PS=1.36 PD=2.62
* device instance $64 r0 *1 72.72,15.585 nfet
X$64 \$89__t0 a\x7cinva_a\x7cmn12_g0\x7cmp13_g0\x7ct1\x7cy__t5 xo\x7cy__t3
+ g_vss_m1\x7cmph_g\x7cs1_vss_m1\x7cs2_vss_m1\x7cs3_vss_m1\x7cs4_vss_m1\x7cvss\x7cvss_x1\x7cvss_x2\x7cvss_x3__t65
+ sky130_fd_pr__nfet_01v8 L=0.15 W=0.84 AS=0.3948 AD=0.2184 PS=2.62 PD=1.36
* device instance $65 r0 *1 73.39,15.585 nfet
X$65
+ g_vss_m1\x7cmph_g\x7cs1_vss_m1\x7cs2_vss_m1\x7cs3_vss_m1\x7cs4_vss_m1\x7cvss\x7cvss_x1\x7cvss_x2\x7cvss_x3__t53
+ a\x7cb\x7cb3\x7cinvb_a\x7cmn12_g1\x7cmp24_g0\x7ct2\x7cy__t5 \$89__t1
+ g_vss_m1\x7cmph_g\x7cs1_vss_m1\x7cs2_vss_m1\x7cs3_vss_m1\x7cs4_vss_m1\x7cvss\x7cvss_x1\x7cvss_x2\x7cvss_x3__t75
+ sky130_fd_pr__nfet_01v8 L=0.15 W=0.84 AS=0.2184 AD=0.3948 PS=1.36 PD=2.62
* device instance $66 r0 *1 79.56,17.905 nfet
X$66 bn\x7cinvb_y\x7cmn34_g1\x7cmp24_g1\x7cy__t23
+ a\x7cb\x7cb3\x7cinvb_a\x7cmn12_g1\x7cmp24_g0\x7ct2\x7cy__t4
+ g_vss_m1\x7cmph_g\x7cs1_vss_m1\x7cs2_vss_m1\x7cs3_vss_m1\x7cs4_vss_m1\x7cvss\x7cvss_x1\x7cvss_x2\x7cvss_x3__t38
+ g_vss_m1\x7cmph_g\x7cs1_vss_m1\x7cs2_vss_m1\x7cs3_vss_m1\x7cs4_vss_m1\x7cvss\x7cvss_x1\x7cvss_x2\x7cvss_x3__t116
+ sky130_fd_pr__nfet_01v8 L=0.15 W=0.42 AS=0.1974 AD=0.1974 PS=1.78 PD=1.78
* device instance $67 r0 *1 48.86,3.53 pfet
X$67 a\x7cinva_a\x7cmn12_g0\x7cmp13_g0\x7cro1\x7cy__t1
+ a\x7cg_a\x7crn1\x7cro\x7cs4_y\x7cy__t2
+ vdd\x7cvdd_b1\x7cvdd_b2\x7cvdd_b3\x7cvdd_b4\x7cvdd_x1\x7cvdd_x2\x7cvdd_x3__t18
+ vdd\x7cvdd_b1\x7cvdd_b2\x7cvdd_b3\x7cvdd_b4\x7cvdd_x1\x7cvdd_x2\x7cvdd_x3__t28
+ sky130_fd_pr__pfet_01v8 L=0.15 W=0.84 AS=0.3948 AD=0.3948 PS=2.62 PD=2.62
* device instance $68 r0 *1 104.16,3.53 pfet
X$68 a\x7cb\x7cinvb_a\x7cmn12_g1\x7cmp24_g0\x7cro2\x7cy__t1
+ a\x7cg_a\x7crn2\x7cro\x7cs4_y\x7cy__t1
+ vdd\x7cvdd_b1\x7cvdd_b2\x7cvdd_b3\x7cvdd_b4\x7cvdd_x1\x7cvdd_x2\x7cvdd_x3__t25
+ vdd\x7cvdd_b1\x7cvdd_b2\x7cvdd_b3\x7cvdd_b4\x7cvdd_x1\x7cvdd_x2\x7cvdd_x3__t35
+ sky130_fd_pr__pfet_01v8 L=0.15 W=0.84 AS=0.3948 AD=0.3948 PS=2.62 PD=2.62
* device instance $69 r0 *1 159.46,3.53 pfet
X$69 a\x7cinva_a\x7cmn12_g0\x7cmp13_g0\x7cro3\x7cy__t1
+ a\x7cg_a\x7crn3\x7cro\x7cs4_y\x7cy__t2
+ vdd\x7cvdd_b1\x7cvdd_b2\x7cvdd_b3\x7cvdd_b4\x7cvdd_x1\x7cvdd_x2\x7cvdd_x3__t27
+ vdd\x7cvdd_b1\x7cvdd_b2\x7cvdd_b3\x7cvdd_b4\x7cvdd_x1\x7cvdd_x2\x7cvdd_x3__t37
+ sky130_fd_pr__pfet_01v8 L=0.15 W=0.84 AS=0.3948 AD=0.3948 PS=2.62 PD=2.62
* device instance $70 r0 *1 214.76,3.53 pfet
X$70 a\x7cb\x7cinvb_a\x7cmn12_g1\x7cmp24_g0\x7cro4\x7cy__t1
+ a\x7cg_a\x7crn4\x7cro\x7cs4_y\x7cy__t2
+ vdd\x7cvdd_b1\x7cvdd_b2\x7cvdd_b3\x7cvdd_b4\x7cvdd_x1\x7cvdd_x2\x7cvdd_x3__t26
+ vdd\x7cvdd_b1\x7cvdd_b2\x7cvdd_b3\x7cvdd_b4\x7cvdd_x1\x7cvdd_x2\x7cvdd_x3__t36
+ sky130_fd_pr__pfet_01v8 L=0.15 W=0.84 AS=0.3948 AD=0.3948 PS=2.62 PD=2.62
* device instance $71 r0 *1 5.775,3.74 pfet
X$71 a\x7cg_y\x7cmnab_y\x7cmpa_y\x7cmpb_y\x7cn1\x7cs1_a\x7cy__t2
+ en\x7cen1\x7cg_en__t1 mpa_py\x7cmpb_py\x7cmph_py\x7cpy__t1
+ g_vddr_m1\x7cmnt_g\x7cs1_vddr_m1\x7cs2_vddr_m1\x7cs3_vddr_m1\x7cs4_vddr_m1\x7cvddr\x7cvddr1__t3
+ sky130_fd_pr__pfet_01v8 L=0.15 W=0.84 AS=0.3948 AD=0.3948 PS=2.62 PD=2.62
* device instance $72 r0 *1 7.065,3.74 pfet
X$72 mpa_py\x7cmpb_py\x7cmph_py\x7cpy__t2
+ a\x7cg_a\x7crn1\x7cro\x7cs4_y\x7cy__t3
+ a\x7cg_y\x7cmnab_y\x7cmpa_y\x7cmpb_y\x7cn1\x7cs1_a\x7cy__t4
+ g_vddr_m1\x7cmnt_g\x7cs1_vddr_m1\x7cs2_vddr_m1\x7cs3_vddr_m1\x7cs4_vddr_m1\x7cvddr\x7cvddr1__t8
+ sky130_fd_pr__pfet_01v8 L=0.15 W=0.84 AS=0.3948 AD=0.3948 PS=2.62 PD=2.62
* device instance $73 r0 *1 15.075,3.74 pfet
X$73 a\x7cn2\x7cs1_y\x7cs2_a\x7cy__t1
+ a\x7cg_y\x7cmnab_y\x7cmpa_y\x7cmpb_y\x7cn1\x7cs1_a\x7cy__t3 py__t0
+ g_vddr_m1\x7cmnt_g\x7cs1_vddr_m1\x7cs2_vddr_m1\x7cs3_vddr_m1\x7cs4_vddr_m1\x7cvddr\x7cvddr1__t7
+ sky130_fd_pr__pfet_01v8 L=0.15 W=0.84 AS=0.3948 AD=0.3948 PS=2.62 PD=2.62
* device instance $74 r0 *1 23.25,3.74 pfet
X$74 a\x7cn3\x7cs2_y\x7cs3_a\x7cy__t02 a\x7cn2\x7cs1_y\x7cs2_a\x7cy__t2 py__t02
+ g_vddr_m1\x7cmnt_g\x7cs1_vddr_m1\x7cs2_vddr_m1\x7cs3_vddr_m1\x7cs4_vddr_m1\x7cvddr\x7cvddr1__t6
+ sky130_fd_pr__pfet_01v8 L=0.15 W=0.84 AS=0.3948 AD=0.3948 PS=2.62 PD=2.62
* device instance $75 r0 *1 31.425,3.74 pfet
X$75 a\x7cn4\x7cs3_y\x7cs4_a\x7cy__t03 a\x7cn3\x7cs2_y\x7cs3_a\x7cy__t12
+ py__t03
+ g_vddr_m1\x7cmnt_g\x7cs1_vddr_m1\x7cs2_vddr_m1\x7cs3_vddr_m1\x7cs4_vddr_m1\x7cvddr\x7cvddr1__t5
+ sky130_fd_pr__pfet_01v8 L=0.15 W=0.84 AS=0.3948 AD=0.3948 PS=2.62 PD=2.62
* device instance $76 r0 *1 39.6,3.74 pfet
X$76 a\x7cg_a\x7crn1\x7cro\x7cs4_y\x7cy__t1 a\x7cn4\x7cs3_y\x7cs4_a\x7cy__t13
+ py__t04
+ g_vddr_m1\x7cmnt_g\x7cs1_vddr_m1\x7cs2_vddr_m1\x7cs3_vddr_m1\x7cs4_vddr_m1\x7cvddr\x7cvddr1__t4
+ sky130_fd_pr__pfet_01v8 L=0.15 W=0.84 AS=0.3948 AD=0.3948 PS=2.62 PD=2.62
* device instance $77 r0 *1 61.075,3.74 pfet
X$77 a\x7cg_y\x7cmnab_y\x7cmpa_y\x7cmpb_y\x7cn1\x7cs1_a\x7cy__t02
+ en\x7cen2\x7cg_en__t0 mpa_py\x7cmpb_py\x7cmph_py\x7cpy__t22
+ g_vddr_m1\x7cmnt_g\x7cs1_vddr_m1\x7cs2_vddr_m1\x7cs3_vddr_m1\x7cs4_vddr_m1\x7cvddr\x7cvddr2__t16
+ sky130_fd_pr__pfet_01v8 L=0.15 W=0.84 AS=0.3948 AD=0.3948 PS=2.62 PD=2.62
* device instance $78 r0 *1 62.365,3.74 pfet
X$78 mpa_py\x7cmpb_py\x7cmph_py\x7cpy__t12
+ a\x7cg_a\x7crn2\x7cro\x7cs4_y\x7cy__t2
+ a\x7cg_y\x7cmnab_y\x7cmpa_y\x7cmpb_y\x7cn1\x7cs1_a\x7cy__t22
+ g_vddr_m1\x7cmnt_g\x7cs1_vddr_m1\x7cs2_vddr_m1\x7cs3_vddr_m1\x7cs4_vddr_m1\x7cvddr\x7cvddr2__t15
+ sky130_fd_pr__pfet_01v8 L=0.15 W=0.84 AS=0.3948 AD=0.3948 PS=2.62 PD=2.62
* device instance $79 r0 *1 70.375,3.74 pfet
X$79 a\x7cn2\x7cs1_y\x7cs2_a\x7cy__t02
+ a\x7cg_y\x7cmnab_y\x7cmpa_y\x7cmpb_y\x7cn1\x7cs1_a\x7cy__t12 py__t15
+ g_vddr_m1\x7cmnt_g\x7cs1_vddr_m1\x7cs2_vddr_m1\x7cs3_vddr_m1\x7cs4_vddr_m1\x7cvddr\x7cvddr2__t14
+ sky130_fd_pr__pfet_01v8 L=0.15 W=0.84 AS=0.3948 AD=0.3948 PS=2.62 PD=2.62
* device instance $80 r0 *1 78.55,3.74 pfet
X$80 a\x7cn3\x7cs2_y\x7cs3_a\x7cy__t0 a\x7cn2\x7cs1_y\x7cs2_a\x7cy__t12 py__t16
+ g_vddr_m1\x7cmnt_g\x7cs1_vddr_m1\x7cs2_vddr_m1\x7cs3_vddr_m1\x7cs4_vddr_m1\x7cvddr\x7cvddr2__t13
+ sky130_fd_pr__pfet_01v8 L=0.15 W=0.84 AS=0.3948 AD=0.3948 PS=2.62 PD=2.62
* device instance $81 r0 *1 86.725,3.74 pfet
X$81 a\x7cn4\x7cs3_y\x7cs4_a\x7cy__t0 a\x7cn3\x7cs2_y\x7cs3_a\x7cy__t1 py__t17
+ g_vddr_m1\x7cmnt_g\x7cs1_vddr_m1\x7cs2_vddr_m1\x7cs3_vddr_m1\x7cs4_vddr_m1\x7cvddr\x7cvddr2__t12
+ sky130_fd_pr__pfet_01v8 L=0.15 W=0.84 AS=0.3948 AD=0.3948 PS=2.62 PD=2.62
* device instance $82 r0 *1 94.9,3.74 pfet
X$82 a\x7cg_a\x7crn2\x7cro\x7cs4_y\x7cy__t0 a\x7cn4\x7cs3_y\x7cs4_a\x7cy__t1
+ py__t18
+ g_vddr_m1\x7cmnt_g\x7cs1_vddr_m1\x7cs2_vddr_m1\x7cs3_vddr_m1\x7cs4_vddr_m1\x7cvddr\x7cvddr2__t11
+ sky130_fd_pr__pfet_01v8 L=0.15 W=0.84 AS=0.3948 AD=0.3948 PS=2.62 PD=2.62
* device instance $83 r0 *1 116.375,3.74 pfet
X$83 a\x7cg_y\x7cmnab_y\x7cmpa_y\x7cmpb_y\x7cn1\x7cs1_a\x7cy__t03
+ en\x7cen3\x7cg_en__t0 mpa_py\x7cmpb_py\x7cmph_py\x7cpy__t23
+ g_vddr_m1\x7cmnt_g\x7cs1_vddr_m1\x7cs2_vddr_m1\x7cs3_vddr_m1\x7cs4_vddr_m1\x7cvddr\x7cvddr3__t15
+ sky130_fd_pr__pfet_01v8 L=0.15 W=0.84 AS=0.3948 AD=0.3948 PS=2.62 PD=2.62
* device instance $84 r0 *1 117.665,3.74 pfet
X$84 mpa_py\x7cmpb_py\x7cmph_py\x7cpy__t13
+ a\x7cg_a\x7crn3\x7cro\x7cs4_y\x7cy__t1
+ a\x7cg_y\x7cmnab_y\x7cmpa_y\x7cmpb_y\x7cn1\x7cs1_a\x7cy__t23
+ g_vddr_m1\x7cmnt_g\x7cs1_vddr_m1\x7cs2_vddr_m1\x7cs3_vddr_m1\x7cs4_vddr_m1\x7cvddr\x7cvddr3__t14
+ sky130_fd_pr__pfet_01v8 L=0.15 W=0.84 AS=0.3948 AD=0.3948 PS=2.62 PD=2.62
* device instance $85 r0 *1 125.675,3.74 pfet
X$85 a\x7cn2\x7cs1_y\x7cs2_a\x7cy__t03
+ a\x7cg_y\x7cmnab_y\x7cmpa_y\x7cmpb_y\x7cn1\x7cs1_a\x7cy__t13 py__t19
+ g_vddr_m1\x7cmnt_g\x7cs1_vddr_m1\x7cs2_vddr_m1\x7cs3_vddr_m1\x7cs4_vddr_m1\x7cvddr\x7cvddr3__t13
+ sky130_fd_pr__pfet_01v8 L=0.15 W=0.84 AS=0.3948 AD=0.3948 PS=2.62 PD=2.62
* device instance $86 r0 *1 133.85,3.74 pfet
X$86 a\x7cn3\x7cs2_y\x7cs3_a\x7cy__t03 a\x7cn2\x7cs1_y\x7cs2_a\x7cy__t13
+ py__t110
+ g_vddr_m1\x7cmnt_g\x7cs1_vddr_m1\x7cs2_vddr_m1\x7cs3_vddr_m1\x7cs4_vddr_m1\x7cvddr\x7cvddr3__t12
+ sky130_fd_pr__pfet_01v8 L=0.15 W=0.84 AS=0.3948 AD=0.3948 PS=2.62 PD=2.62
* device instance $87 r0 *1 142.025,3.74 pfet
X$87 a\x7cn4\x7cs3_y\x7cs4_a\x7cy__t02 a\x7cn3\x7cs2_y\x7cs3_a\x7cy__t13
+ py__t111
+ g_vddr_m1\x7cmnt_g\x7cs1_vddr_m1\x7cs2_vddr_m1\x7cs3_vddr_m1\x7cs4_vddr_m1\x7cvddr\x7cvddr3__t11
+ sky130_fd_pr__pfet_01v8 L=0.15 W=0.84 AS=0.3948 AD=0.3948 PS=2.62 PD=2.62
* device instance $88 r0 *1 150.2,3.74 pfet
X$88 a\x7cg_a\x7crn3\x7cro\x7cs4_y\x7cy__t0 a\x7cn4\x7cs3_y\x7cs4_a\x7cy__t12
+ py__t112
+ g_vddr_m1\x7cmnt_g\x7cs1_vddr_m1\x7cs2_vddr_m1\x7cs3_vddr_m1\x7cs4_vddr_m1\x7cvddr\x7cvddr3__t16
+ sky130_fd_pr__pfet_01v8 L=0.15 W=0.84 AS=0.3948 AD=0.3948 PS=2.62 PD=2.62
* device instance $89 r0 *1 171.675,3.74 pfet
X$89 a\x7cg_y\x7cmnab_y\x7cmpa_y\x7cmpb_y\x7cn1\x7cs1_a\x7cy__t04
+ en\x7cen4\x7cg_en__t0 mpa_py\x7cmpb_py\x7cmph_py\x7cpy__t24
+ g_vddr_m1\x7cmnt_g\x7cs1_vddr_m1\x7cs2_vddr_m1\x7cs3_vddr_m1\x7cs4_vddr_m1\x7cvddr\x7cvddr4__t16
+ sky130_fd_pr__pfet_01v8 L=0.15 W=0.84 AS=0.3948 AD=0.3948 PS=2.62 PD=2.62
* device instance $90 r0 *1 172.965,3.74 pfet
X$90 mpa_py\x7cmpb_py\x7cmph_py\x7cpy__t14
+ a\x7cg_a\x7crn4\x7cro\x7cs4_y\x7cy__t1
+ a\x7cg_y\x7cmnab_y\x7cmpa_y\x7cmpb_y\x7cn1\x7cs1_a\x7cy__t24
+ g_vddr_m1\x7cmnt_g\x7cs1_vddr_m1\x7cs2_vddr_m1\x7cs3_vddr_m1\x7cs4_vddr_m1\x7cvddr\x7cvddr4__t15
+ sky130_fd_pr__pfet_01v8 L=0.15 W=0.84 AS=0.3948 AD=0.3948 PS=2.62 PD=2.62
* device instance $91 r0 *1 180.975,3.74 pfet
X$91 a\x7cn2\x7cs1_y\x7cs2_a\x7cy__t04
+ a\x7cg_y\x7cmnab_y\x7cmpa_y\x7cmpb_y\x7cn1\x7cs1_a\x7cy__t14 py__t113
+ g_vddr_m1\x7cmnt_g\x7cs1_vddr_m1\x7cs2_vddr_m1\x7cs3_vddr_m1\x7cs4_vddr_m1\x7cvddr\x7cvddr4__t14
+ sky130_fd_pr__pfet_01v8 L=0.15 W=0.84 AS=0.3948 AD=0.3948 PS=2.62 PD=2.62
* device instance $92 r0 *1 189.15,3.74 pfet
X$92 a\x7cn3\x7cs2_y\x7cs3_a\x7cy__t04 a\x7cn2\x7cs1_y\x7cs2_a\x7cy__t14
+ py__t114
+ g_vddr_m1\x7cmnt_g\x7cs1_vddr_m1\x7cs2_vddr_m1\x7cs3_vddr_m1\x7cs4_vddr_m1\x7cvddr\x7cvddr4__t13
+ sky130_fd_pr__pfet_01v8 L=0.15 W=0.84 AS=0.3948 AD=0.3948 PS=2.62 PD=2.62
* device instance $93 r0 *1 197.325,3.74 pfet
X$93 a\x7cn4\x7cs3_y\x7cs4_a\x7cy__t04 a\x7cn3\x7cs2_y\x7cs3_a\x7cy__t14
+ py__t115
+ g_vddr_m1\x7cmnt_g\x7cs1_vddr_m1\x7cs2_vddr_m1\x7cs3_vddr_m1\x7cs4_vddr_m1\x7cvddr\x7cvddr4__t12
+ sky130_fd_pr__pfet_01v8 L=0.15 W=0.84 AS=0.3948 AD=0.3948 PS=2.62 PD=2.62
* device instance $94 r0 *1 205.5,3.74 pfet
X$94 a\x7cg_a\x7crn4\x7cro\x7cs4_y\x7cy__t0 a\x7cn4\x7cs3_y\x7cs4_a\x7cy__t14
+ py__t116
+ g_vddr_m1\x7cmnt_g\x7cs1_vddr_m1\x7cs2_vddr_m1\x7cs3_vddr_m1\x7cs4_vddr_m1\x7cvddr\x7cvddr4__t11
+ sky130_fd_pr__pfet_01v8 L=0.15 W=0.84 AS=0.3948 AD=0.3948 PS=2.62 PD=2.62
* device instance $95 r0 *1 3.61,3.74 pfet
X$95 mpa_py\x7cmpb_py\x7cmph_py\x7cpy__t0
+ g_vss_m1\x7cmph_g\x7cs1_vss_m1\x7cs2_vss_m1\x7cs3_vss_m1\x7cs4_vss_m1\x7cvss\x7cvss_x1\x7cvss_x2\x7cvss_x3__t4
+ g_vddr_m1\x7cmnt_g\x7cs1_vddr_m1\x7cs2_vddr_m1\x7cs3_vddr_m1\x7cs4_vddr_m1\x7cvddr\x7cvddr1__t1
+ g_vddr_m1\x7cmnt_g\x7cs1_vddr_m1\x7cs2_vddr_m1\x7cs3_vddr_m1\x7cs4_vddr_m1\x7cvddr\x7cvddr1__t2
+ sky130_fd_pr__pfet_01v8 L=2 W=0.42 AS=0.1764 AD=0.1764 PS=1.68 PD=1.68
* device instance $96 r0 *1 3.445,21.225 pfet
X$96 an\x7cinva_y\x7cmn34_g0\x7cmp13_g1\x7cy__t1
+ a\x7cinva_a\x7cmn12_g0\x7cmp13_g0\x7cro1\x7cy__t2
+ vdd\x7cvdd_b1\x7cvdd_b2\x7cvdd_b3\x7cvdd_b4\x7cvdd_x1\x7cvdd_x2\x7cvdd_x3__t22
+ vdd\x7cvdd_b1\x7cvdd_b2\x7cvdd_b3\x7cvdd_b4\x7cvdd_x1\x7cvdd_x2\x7cvdd_x3__t32
+ sky130_fd_pr__pfet_01v8 L=0.15 W=0.84 AS=0.3948 AD=0.3948 PS=2.62 PD=2.62
* device instance $97 r0 *1 7.43,25.585 pfet
X$97 mid__t1 a\x7cinva_a\x7cmn12_g0\x7cmp13_g0\x7cro1\x7cy__t0
+ vdd\x7cvdd_b1\x7cvdd_b2\x7cvdd_b3\x7cvdd_b4\x7cvdd_x1\x7cvdd_x2\x7cvdd_x3__t0
+ vdd\x7cvdd_b1\x7cvdd_b2\x7cvdd_b3\x7cvdd_b4\x7cvdd_x1\x7cvdd_x2\x7cvdd_x3__t1
+ sky130_fd_pr__pfet_01v8 L=0.15 W=1.68 AS=0.7896 AD=0.4368 PS=4.3 PD=2.2
* device instance $98 r0 *1 8.1,25.585 pfet
X$98 a\x7cinva_a\x7cmn12_g0\x7cmp13_g0\x7ct1\x7cy__t0
+ an\x7cinva_y\x7cmn34_g0\x7cmp13_g1\x7cy__t0 mid__t0
+ vdd\x7cvdd_b1\x7cvdd_b2\x7cvdd_b3\x7cvdd_b4\x7cvdd_x1\x7cvdd_x2\x7cvdd_x3__t2
+ sky130_fd_pr__pfet_01v8 L=0.15 W=1.68 AS=0.4368 AD=0.7896 PS=2.2 PD=4.3
* device instance $99 r0 *1 12.91,3.74 pfet
X$99 py__t1
+ g_vss_m1\x7cmph_g\x7cs1_vss_m1\x7cs2_vss_m1\x7cs3_vss_m1\x7cs4_vss_m1\x7cvss\x7cvss_x1\x7cvss_x2\x7cvss_x3__t21
+ g_vddr_m1\x7cmnt_g\x7cs1_vddr_m1\x7cs2_vddr_m1\x7cs3_vddr_m1\x7cs4_vddr_m1\x7cvddr\x7cvddr1__t14
+ g_vddr_m1\x7cmnt_g\x7cs1_vddr_m1\x7cs2_vddr_m1\x7cs3_vddr_m1\x7cs4_vddr_m1\x7cvddr\x7cvddr1__t10
+ sky130_fd_pr__pfet_01v8 L=2 W=0.42 AS=0.1764 AD=0.1764 PS=1.68 PD=1.68
* device instance $100 r0 *1 14.58,25.585 pfet
X$100 mid__t2 bn\x7cinvb_y\x7cmn34_g1\x7cmp24_g1\x7cy__t0
+ a\x7cinva_a\x7cmn12_g0\x7cmp13_g0\x7ct1\x7cy__t1
+ vdd\x7cvdd_b1\x7cvdd_b2\x7cvdd_b3\x7cvdd_b4\x7cvdd_x1\x7cvdd_x2\x7cvdd_x3__t15
+ sky130_fd_pr__pfet_01v8 L=0.15 W=1.68 AS=0.7896 AD=0.4368 PS=4.3 PD=2.2
* device instance $101 r0 *1 15.25,25.585 pfet
X$101
+ vdd\x7cvdd_b1\x7cvdd_b2\x7cvdd_b3\x7cvdd_b4\x7cvdd_x1\x7cvdd_x2\x7cvdd_x3__t5
+ a\x7cb\x7cinvb_a\x7cmn12_g1\x7cmp24_g0\x7cro2\x7cy__t0 mid__t3
+ vdd\x7cvdd_b1\x7cvdd_b2\x7cvdd_b3\x7cvdd_b4\x7cvdd_x1\x7cvdd_x2\x7cvdd_x3__t10
+ sky130_fd_pr__pfet_01v8 L=0.15 W=1.68 AS=0.4368 AD=0.7896 PS=2.2 PD=4.3
* device instance $102 r0 *1 21.085,3.74 pfet
X$102 py__t12
+ g_vss_m1\x7cmph_g\x7cs1_vss_m1\x7cs2_vss_m1\x7cs3_vss_m1\x7cs4_vss_m1\x7cvss\x7cvss_x1\x7cvss_x2\x7cvss_x3__t22
+ g_vddr_m1\x7cmnt_g\x7cs1_vddr_m1\x7cs2_vddr_m1\x7cs3_vddr_m1\x7cs4_vddr_m1\x7cvddr\x7cvddr1__t15
+ g_vddr_m1\x7cmnt_g\x7cs1_vddr_m1\x7cs2_vddr_m1\x7cs3_vddr_m1\x7cs4_vddr_m1\x7cvddr\x7cvddr1__t11
+ sky130_fd_pr__pfet_01v8 L=2 W=0.42 AS=0.1764 AD=0.1764 PS=1.68 PD=1.68
* device instance $103 r0 *1 21.62,21.225 pfet
X$103 bn\x7cinvb_y\x7cmn34_g1\x7cmp24_g1\x7cy__t1
+ a\x7cb\x7cinvb_a\x7cmn12_g1\x7cmp24_g0\x7cro2\x7cy__t2
+ vdd\x7cvdd_b1\x7cvdd_b2\x7cvdd_b3\x7cvdd_b4\x7cvdd_x1\x7cvdd_x2\x7cvdd_x3__t19
+ vdd\x7cvdd_b1\x7cvdd_b2\x7cvdd_b3\x7cvdd_b4\x7cvdd_x1\x7cvdd_x2\x7cvdd_x3__t29
+ sky130_fd_pr__pfet_01v8 L=0.15 W=0.84 AS=0.3948 AD=0.3948 PS=2.62 PD=2.62
* device instance $104 r0 *1 29.26,3.74 pfet
X$104 py__t13
+ g_vss_m1\x7cmph_g\x7cs1_vss_m1\x7cs2_vss_m1\x7cs3_vss_m1\x7cs4_vss_m1\x7cvss\x7cvss_x1\x7cvss_x2\x7cvss_x3__t20
+ g_vddr_m1\x7cmnt_g\x7cs1_vddr_m1\x7cs2_vddr_m1\x7cs3_vddr_m1\x7cs4_vddr_m1\x7cvddr\x7cvddr1__t13
+ g_vddr_m1\x7cmnt_g\x7cs1_vddr_m1\x7cs2_vddr_m1\x7cs3_vddr_m1\x7cs4_vddr_m1\x7cvddr\x7cvddr1__t9
+ sky130_fd_pr__pfet_01v8 L=2 W=0.42 AS=0.1764 AD=0.1764 PS=1.68 PD=1.68
* device instance $105 r0 *1 32.415,21.225 pfet
X$105 an\x7cinva_y\x7cmn34_g0\x7cmp13_g1\x7cy__t12
+ a\x7cinva_a\x7cmn12_g0\x7cmp13_g0\x7cro3\x7cy__t2
+ vdd\x7cvdd_b1\x7cvdd_b2\x7cvdd_b3\x7cvdd_b4\x7cvdd_x1\x7cvdd_x2\x7cvdd_x3__t20
+ vdd\x7cvdd_b1\x7cvdd_b2\x7cvdd_b3\x7cvdd_b4\x7cvdd_x1\x7cvdd_x2\x7cvdd_x3__t30
+ sky130_fd_pr__pfet_01v8 L=0.15 W=0.84 AS=0.3948 AD=0.3948 PS=2.62 PD=2.62
* device instance $106 r0 *1 36.4,25.585 pfet
X$106 mid__t12 a\x7cinva_a\x7cmn12_g0\x7cmp13_g0\x7cro3\x7cy__t0
+ vdd\x7cvdd_b1\x7cvdd_b2\x7cvdd_b3\x7cvdd_b4\x7cvdd_x1\x7cvdd_x2\x7cvdd_x3__t16
+ vdd\x7cvdd_b1\x7cvdd_b2\x7cvdd_b3\x7cvdd_b4\x7cvdd_x1\x7cvdd_x2\x7cvdd_x3__t13
+ sky130_fd_pr__pfet_01v8 L=0.15 W=1.68 AS=0.7896 AD=0.4368 PS=4.3 PD=2.2
* device instance $107 r0 *1 37.07,25.585 pfet
X$107 a\x7cb\x7cb3\x7cinvb_a\x7cmn12_g1\x7cmp24_g0\x7ct2\x7cy__t0
+ an\x7cinva_y\x7cmn34_g0\x7cmp13_g1\x7cy__t02 mid__t22
+ vdd\x7cvdd_b1\x7cvdd_b2\x7cvdd_b3\x7cvdd_b4\x7cvdd_x1\x7cvdd_x2\x7cvdd_x3__t6
+ sky130_fd_pr__pfet_01v8 L=0.15 W=1.68 AS=0.4368 AD=0.7896 PS=2.2 PD=4.3
* device instance $108 r0 *1 37.435,3.74 pfet
X$108 py__t14
+ g_vss_m1\x7cmph_g\x7cs1_vss_m1\x7cs2_vss_m1\x7cs3_vss_m1\x7cs4_vss_m1\x7cvss\x7cvss_x1\x7cvss_x2\x7cvss_x3__t23
+ g_vddr_m1\x7cmnt_g\x7cs1_vddr_m1\x7cs2_vddr_m1\x7cs3_vddr_m1\x7cs4_vddr_m1\x7cvddr\x7cvddr1__t16
+ g_vddr_m1\x7cmnt_g\x7cs1_vddr_m1\x7cs2_vddr_m1\x7cs3_vddr_m1\x7cs4_vddr_m1\x7cvddr\x7cvddr1__t12
+ sky130_fd_pr__pfet_01v8 L=2 W=0.42 AS=0.1764 AD=0.1764 PS=1.68 PD=1.68
* device instance $109 r0 *1 43.55,25.585 pfet
X$109 mid__t02 bn\x7cinvb_y\x7cmn34_g1\x7cmp24_g1\x7cy__t02
+ a\x7cb\x7cb3\x7cinvb_a\x7cmn12_g1\x7cmp24_g0\x7ct2\x7cy__t2
+ vdd\x7cvdd_b1\x7cvdd_b2\x7cvdd_b3\x7cvdd_b4\x7cvdd_x1\x7cvdd_x2\x7cvdd_x3__t12
+ sky130_fd_pr__pfet_01v8 L=0.15 W=1.68 AS=0.7896 AD=0.4368 PS=4.3 PD=2.2
* device instance $110 r0 *1 44.22,25.585 pfet
X$110
+ vdd\x7cvdd_b1\x7cvdd_b2\x7cvdd_b3\x7cvdd_b4\x7cvdd_x1\x7cvdd_x2\x7cvdd_x3__t4
+ a\x7cb\x7cinvb_a\x7cmn12_g1\x7cmp24_g0\x7cro4\x7cy__t0 mid__t32
+ vdd\x7cvdd_b1\x7cvdd_b2\x7cvdd_b3\x7cvdd_b4\x7cvdd_x1\x7cvdd_x2\x7cvdd_x3__t8
+ sky130_fd_pr__pfet_01v8 L=0.15 W=1.68 AS=0.4368 AD=0.7896 PS=2.2 PD=4.3
* device instance $111 r0 *1 50.59,21.225 pfet
X$111 bn\x7cinvb_y\x7cmn34_g1\x7cmp24_g1\x7cy__t12
+ a\x7cb\x7cinvb_a\x7cmn12_g1\x7cmp24_g0\x7cro4\x7cy__t2
+ vdd\x7cvdd_b1\x7cvdd_b2\x7cvdd_b3\x7cvdd_b4\x7cvdd_x1\x7cvdd_x2\x7cvdd_x3__t21
+ vdd\x7cvdd_b1\x7cvdd_b2\x7cvdd_b3\x7cvdd_b4\x7cvdd_x1\x7cvdd_x2\x7cvdd_x3__t31
+ sky130_fd_pr__pfet_01v8 L=0.15 W=0.84 AS=0.3948 AD=0.3948 PS=2.62 PD=2.62
* device instance $112 r0 *1 58.91,3.74 pfet
X$112 mpa_py\x7cmpb_py\x7cmph_py\x7cpy__t02
+ g_vss_m1\x7cmph_g\x7cs1_vss_m1\x7cs2_vss_m1\x7cs3_vss_m1\x7cs4_vss_m1\x7cvss\x7cvss_x1\x7cvss_x2\x7cvss_x3__t5
+ g_vddr_m1\x7cmnt_g\x7cs1_vddr_m1\x7cs2_vddr_m1\x7cs3_vddr_m1\x7cs4_vddr_m1\x7cvddr\x7cvddr2__t1
+ g_vddr_m1\x7cmnt_g\x7cs1_vddr_m1\x7cs2_vddr_m1\x7cs3_vddr_m1\x7cs4_vddr_m1\x7cvddr\x7cvddr2__t2
+ sky130_fd_pr__pfet_01v8 L=2 W=0.44 AS=0.1848 AD=0.1848 PS=1.72 PD=1.72
* device instance $113 r0 *1 61.385,21.225 pfet
X$113 an\x7cinva_y\x7cmn34_g0\x7cmp13_g1\x7cy__t13
+ a\x7cinva_a\x7cmn12_g0\x7cmp13_g0\x7ct1\x7cy__t3
+ vdd\x7cvdd_b1\x7cvdd_b2\x7cvdd_b3\x7cvdd_b4\x7cvdd_x1\x7cvdd_x2\x7cvdd_x3__t23
+ vdd\x7cvdd_b1\x7cvdd_b2\x7cvdd_b3\x7cvdd_b4\x7cvdd_x1\x7cvdd_x2\x7cvdd_x3__t33
+ sky130_fd_pr__pfet_01v8 L=0.15 W=0.84 AS=0.3948 AD=0.3948 PS=2.62 PD=2.62
* device instance $114 r0 *1 65.37,25.585 pfet
X$114 mid__t13 a\x7cinva_a\x7cmn12_g0\x7cmp13_g0\x7ct1\x7cy__t2
+ vdd\x7cvdd_b1\x7cvdd_b2\x7cvdd_b3\x7cvdd_b4\x7cvdd_x1\x7cvdd_x2\x7cvdd_x3__t17
+ vdd\x7cvdd_b1\x7cvdd_b2\x7cvdd_b3\x7cvdd_b4\x7cvdd_x1\x7cvdd_x2\x7cvdd_x3__t14
+ sky130_fd_pr__pfet_01v8 L=0.15 W=1.68 AS=0.7896 AD=0.4368 PS=4.3 PD=2.2
* device instance $115 r0 *1 66.04,25.585 pfet
X$115 xo\x7cy__t0 an\x7cinva_y\x7cmn34_g0\x7cmp13_g1\x7cy__t03 mid__t33
+ vdd\x7cvdd_b1\x7cvdd_b2\x7cvdd_b3\x7cvdd_b4\x7cvdd_x1\x7cvdd_x2\x7cvdd_x3__t9
+ sky130_fd_pr__pfet_01v8 L=0.15 W=1.68 AS=0.4368 AD=0.7896 PS=2.2 PD=4.3
* device instance $116 r0 *1 68.21,3.74 pfet
X$116 py__t05
+ g_vss_m1\x7cmph_g\x7cs1_vss_m1\x7cs2_vss_m1\x7cs3_vss_m1\x7cs4_vss_m1\x7cvss\x7cvss_x1\x7cvss_x2\x7cvss_x3__t19
+ g_vddr_m1\x7cmnt_g\x7cs1_vddr_m1\x7cs2_vddr_m1\x7cs3_vddr_m1\x7cs4_vddr_m1\x7cvddr\x7cvddr2__t10
+ g_vddr_m1\x7cmnt_g\x7cs1_vddr_m1\x7cs2_vddr_m1\x7cs3_vddr_m1\x7cs4_vddr_m1\x7cvddr\x7cvddr2__t6
+ sky130_fd_pr__pfet_01v8 L=2 W=0.44 AS=0.1848 AD=0.1848 PS=1.72 PD=1.72
* device instance $117 r0 *1 72.52,25.585 pfet
X$117 mid__t03 bn\x7cinvb_y\x7cmn34_g1\x7cmp24_g1\x7cy__t03 xo\x7cy__t1
+ vdd\x7cvdd_b1\x7cvdd_b2\x7cvdd_b3\x7cvdd_b4\x7cvdd_x1\x7cvdd_x2\x7cvdd_x3__t11
+ sky130_fd_pr__pfet_01v8 L=0.15 W=1.68 AS=0.7896 AD=0.4368 PS=4.3 PD=2.2
* device instance $118 r0 *1 73.19,25.585 pfet
X$118
+ vdd\x7cvdd_b1\x7cvdd_b2\x7cvdd_b3\x7cvdd_b4\x7cvdd_x1\x7cvdd_x2\x7cvdd_x3__t3
+ a\x7cb\x7cb3\x7cinvb_a\x7cmn12_g1\x7cmp24_g0\x7ct2\x7cy__t1 mid__t23
+ vdd\x7cvdd_b1\x7cvdd_b2\x7cvdd_b3\x7cvdd_b4\x7cvdd_x1\x7cvdd_x2\x7cvdd_x3__t7
+ sky130_fd_pr__pfet_01v8 L=0.15 W=1.68 AS=0.4368 AD=0.7896 PS=2.2 PD=4.3
* device instance $119 r0 *1 76.385,3.74 pfet
X$119 py__t06
+ g_vss_m1\x7cmph_g\x7cs1_vss_m1\x7cs2_vss_m1\x7cs3_vss_m1\x7cs4_vss_m1\x7cvss\x7cvss_x1\x7cvss_x2\x7cvss_x3__t18
+ g_vddr_m1\x7cmnt_g\x7cs1_vddr_m1\x7cs2_vddr_m1\x7cs3_vddr_m1\x7cs4_vddr_m1\x7cvddr\x7cvddr2__t9
+ g_vddr_m1\x7cmnt_g\x7cs1_vddr_m1\x7cs2_vddr_m1\x7cs3_vddr_m1\x7cs4_vddr_m1\x7cvddr\x7cvddr2__t5
+ sky130_fd_pr__pfet_01v8 L=2 W=0.44 AS=0.1848 AD=0.1848 PS=1.72 PD=1.72
* device instance $120 r0 *1 79.56,21.225 pfet
X$120 bn\x7cinvb_y\x7cmn34_g1\x7cmp24_g1\x7cy__t13
+ a\x7cb\x7cb3\x7cinvb_a\x7cmn12_g1\x7cmp24_g0\x7ct2\x7cy__t3
+ vdd\x7cvdd_b1\x7cvdd_b2\x7cvdd_b3\x7cvdd_b4\x7cvdd_x1\x7cvdd_x2\x7cvdd_x3__t24
+ vdd\x7cvdd_b1\x7cvdd_b2\x7cvdd_b3\x7cvdd_b4\x7cvdd_x1\x7cvdd_x2\x7cvdd_x3__t34
+ sky130_fd_pr__pfet_01v8 L=0.15 W=0.84 AS=0.3948 AD=0.3948 PS=2.62 PD=2.62
* device instance $121 r0 *1 84.56,3.74 pfet
X$121 py__t07
+ g_vss_m1\x7cmph_g\x7cs1_vss_m1\x7cs2_vss_m1\x7cs3_vss_m1\x7cs4_vss_m1\x7cvss\x7cvss_x1\x7cvss_x2\x7cvss_x3__t17
+ g_vddr_m1\x7cmnt_g\x7cs1_vddr_m1\x7cs2_vddr_m1\x7cs3_vddr_m1\x7cs4_vddr_m1\x7cvddr\x7cvddr2__t8
+ g_vddr_m1\x7cmnt_g\x7cs1_vddr_m1\x7cs2_vddr_m1\x7cs3_vddr_m1\x7cs4_vddr_m1\x7cvddr\x7cvddr2__t4
+ sky130_fd_pr__pfet_01v8 L=2 W=0.44 AS=0.1848 AD=0.1848 PS=1.72 PD=1.72
* device instance $122 r0 *1 92.735,3.74 pfet
X$122 py__t08
+ g_vss_m1\x7cmph_g\x7cs1_vss_m1\x7cs2_vss_m1\x7cs3_vss_m1\x7cs4_vss_m1\x7cvss\x7cvss_x1\x7cvss_x2\x7cvss_x3__t16
+ g_vddr_m1\x7cmnt_g\x7cs1_vddr_m1\x7cs2_vddr_m1\x7cs3_vddr_m1\x7cs4_vddr_m1\x7cvddr\x7cvddr2__t7
+ g_vddr_m1\x7cmnt_g\x7cs1_vddr_m1\x7cs2_vddr_m1\x7cs3_vddr_m1\x7cs4_vddr_m1\x7cvddr\x7cvddr2__t3
+ sky130_fd_pr__pfet_01v8 L=2 W=0.44 AS=0.1848 AD=0.1848 PS=1.72 PD=1.72
* device instance $123 r0 *1 114.21,3.74 pfet
X$123 mpa_py\x7cmpb_py\x7cmph_py\x7cpy__t03
+ g_vss_m1\x7cmph_g\x7cs1_vss_m1\x7cs2_vss_m1\x7cs3_vss_m1\x7cs4_vss_m1\x7cvss\x7cvss_x1\x7cvss_x2\x7cvss_x3__t6
+ g_vddr_m1\x7cmnt_g\x7cs1_vddr_m1\x7cs2_vddr_m1\x7cs3_vddr_m1\x7cs4_vddr_m1\x7cvddr\x7cvddr3__t1
+ g_vddr_m1\x7cmnt_g\x7cs1_vddr_m1\x7cs2_vddr_m1\x7cs3_vddr_m1\x7cs4_vddr_m1\x7cvddr\x7cvddr3__t2
+ sky130_fd_pr__pfet_01v8 L=2 W=0.46 AS=0.1932 AD=0.1932 PS=1.76 PD=1.76
* device instance $124 r0 *1 123.51,3.74 pfet
X$124 py__t09
+ g_vss_m1\x7cmph_g\x7cs1_vss_m1\x7cs2_vss_m1\x7cs3_vss_m1\x7cs4_vss_m1\x7cvss\x7cvss_x1\x7cvss_x2\x7cvss_x3__t15
+ g_vddr_m1\x7cmnt_g\x7cs1_vddr_m1\x7cs2_vddr_m1\x7cs3_vddr_m1\x7cs4_vddr_m1\x7cvddr\x7cvddr3__t10
+ g_vddr_m1\x7cmnt_g\x7cs1_vddr_m1\x7cs2_vddr_m1\x7cs3_vddr_m1\x7cs4_vddr_m1\x7cvddr\x7cvddr3__t6
+ sky130_fd_pr__pfet_01v8 L=2 W=0.46 AS=0.1932 AD=0.1932 PS=1.76 PD=1.76
* device instance $125 r0 *1 131.685,3.74 pfet
X$125 py__t010
+ g_vss_m1\x7cmph_g\x7cs1_vss_m1\x7cs2_vss_m1\x7cs3_vss_m1\x7cs4_vss_m1\x7cvss\x7cvss_x1\x7cvss_x2\x7cvss_x3__t12
+ g_vddr_m1\x7cmnt_g\x7cs1_vddr_m1\x7cs2_vddr_m1\x7cs3_vddr_m1\x7cs4_vddr_m1\x7cvddr\x7cvddr3__t7
+ g_vddr_m1\x7cmnt_g\x7cs1_vddr_m1\x7cs2_vddr_m1\x7cs3_vddr_m1\x7cs4_vddr_m1\x7cvddr\x7cvddr3__t3
+ sky130_fd_pr__pfet_01v8 L=2 W=0.46 AS=0.1932 AD=0.1932 PS=1.76 PD=1.76
* device instance $126 r0 *1 139.86,3.74 pfet
X$126 py__t011
+ g_vss_m1\x7cmph_g\x7cs1_vss_m1\x7cs2_vss_m1\x7cs3_vss_m1\x7cs4_vss_m1\x7cvss\x7cvss_x1\x7cvss_x2\x7cvss_x3__t14
+ g_vddr_m1\x7cmnt_g\x7cs1_vddr_m1\x7cs2_vddr_m1\x7cs3_vddr_m1\x7cs4_vddr_m1\x7cvddr\x7cvddr3__t9
+ g_vddr_m1\x7cmnt_g\x7cs1_vddr_m1\x7cs2_vddr_m1\x7cs3_vddr_m1\x7cs4_vddr_m1\x7cvddr\x7cvddr3__t5
+ sky130_fd_pr__pfet_01v8 L=2 W=0.46 AS=0.1932 AD=0.1932 PS=1.76 PD=1.76
* device instance $127 r0 *1 148.035,3.74 pfet
X$127 py__t012
+ g_vss_m1\x7cmph_g\x7cs1_vss_m1\x7cs2_vss_m1\x7cs3_vss_m1\x7cs4_vss_m1\x7cvss\x7cvss_x1\x7cvss_x2\x7cvss_x3__t13
+ g_vddr_m1\x7cmnt_g\x7cs1_vddr_m1\x7cs2_vddr_m1\x7cs3_vddr_m1\x7cs4_vddr_m1\x7cvddr\x7cvddr3__t8
+ g_vddr_m1\x7cmnt_g\x7cs1_vddr_m1\x7cs2_vddr_m1\x7cs3_vddr_m1\x7cs4_vddr_m1\x7cvddr\x7cvddr3__t4
+ sky130_fd_pr__pfet_01v8 L=2 W=0.46 AS=0.1932 AD=0.1932 PS=1.76 PD=1.76
* device instance $128 r0 *1 169.51,3.74 pfet
X$128 mpa_py\x7cmpb_py\x7cmph_py\x7cpy__t04
+ g_vss_m1\x7cmph_g\x7cs1_vss_m1\x7cs2_vss_m1\x7cs3_vss_m1\x7cs4_vss_m1\x7cvss\x7cvss_x1\x7cvss_x2\x7cvss_x3__t7
+ g_vddr_m1\x7cmnt_g\x7cs1_vddr_m1\x7cs2_vddr_m1\x7cs3_vddr_m1\x7cs4_vddr_m1\x7cvddr\x7cvddr4__t1
+ g_vddr_m1\x7cmnt_g\x7cs1_vddr_m1\x7cs2_vddr_m1\x7cs3_vddr_m1\x7cs4_vddr_m1\x7cvddr\x7cvddr4__t2
+ sky130_fd_pr__pfet_01v8 L=2 W=0.48 AS=0.2016 AD=0.2016 PS=1.8 PD=1.8
* device instance $129 r0 *1 178.81,3.74 pfet
X$129 py__t013
+ g_vss_m1\x7cmph_g\x7cs1_vss_m1\x7cs2_vss_m1\x7cs3_vss_m1\x7cs4_vss_m1\x7cvss\x7cvss_x1\x7cvss_x2\x7cvss_x3__t11
+ g_vddr_m1\x7cmnt_g\x7cs1_vddr_m1\x7cs2_vddr_m1\x7cs3_vddr_m1\x7cs4_vddr_m1\x7cvddr\x7cvddr4__t10
+ g_vddr_m1\x7cmnt_g\x7cs1_vddr_m1\x7cs2_vddr_m1\x7cs3_vddr_m1\x7cs4_vddr_m1\x7cvddr\x7cvddr4__t6
+ sky130_fd_pr__pfet_01v8 L=2 W=0.48 AS=0.2016 AD=0.2016 PS=1.8 PD=1.8
* device instance $130 r0 *1 186.985,3.74 pfet
X$130 py__t014
+ g_vss_m1\x7cmph_g\x7cs1_vss_m1\x7cs2_vss_m1\x7cs3_vss_m1\x7cs4_vss_m1\x7cvss\x7cvss_x1\x7cvss_x2\x7cvss_x3__t10
+ g_vddr_m1\x7cmnt_g\x7cs1_vddr_m1\x7cs2_vddr_m1\x7cs3_vddr_m1\x7cs4_vddr_m1\x7cvddr\x7cvddr4__t9
+ g_vddr_m1\x7cmnt_g\x7cs1_vddr_m1\x7cs2_vddr_m1\x7cs3_vddr_m1\x7cs4_vddr_m1\x7cvddr\x7cvddr4__t5
+ sky130_fd_pr__pfet_01v8 L=2 W=0.48 AS=0.2016 AD=0.2016 PS=1.8 PD=1.8
* device instance $131 r0 *1 195.16,3.74 pfet
X$131 py__t015
+ g_vss_m1\x7cmph_g\x7cs1_vss_m1\x7cs2_vss_m1\x7cs3_vss_m1\x7cs4_vss_m1\x7cvss\x7cvss_x1\x7cvss_x2\x7cvss_x3__t9
+ g_vddr_m1\x7cmnt_g\x7cs1_vddr_m1\x7cs2_vddr_m1\x7cs3_vddr_m1\x7cs4_vddr_m1\x7cvddr\x7cvddr4__t8
+ g_vddr_m1\x7cmnt_g\x7cs1_vddr_m1\x7cs2_vddr_m1\x7cs3_vddr_m1\x7cs4_vddr_m1\x7cvddr\x7cvddr4__t4
+ sky130_fd_pr__pfet_01v8 L=2 W=0.48 AS=0.2016 AD=0.2016 PS=1.8 PD=1.8
* device instance $132 r0 *1 203.335,3.74 pfet
X$132 py__t016
+ g_vss_m1\x7cmph_g\x7cs1_vss_m1\x7cs2_vss_m1\x7cs3_vss_m1\x7cs4_vss_m1\x7cvss\x7cvss_x1\x7cvss_x2\x7cvss_x3__t8
+ g_vddr_m1\x7cmnt_g\x7cs1_vddr_m1\x7cs2_vddr_m1\x7cs3_vddr_m1\x7cs4_vddr_m1\x7cvddr\x7cvddr4__t7
+ g_vddr_m1\x7cmnt_g\x7cs1_vddr_m1\x7cs2_vddr_m1\x7cs3_vddr_m1\x7cs4_vddr_m1\x7cvddr\x7cvddr4__t3
+ sky130_fd_pr__pfet_01v8 L=2 W=0.48 AS=0.2016 AD=0.2016 PS=1.8 PD=1.8
* device instance _12_t0 r0 *1 0,0
R_12_t0 \$12__t0 \$12 12.8
* device instance _12_t1 r0 *1 0,0
R_12_t1 \$12__t1 \$12 12.8
* device instance _12 r0 *1 0,0
C_12 \$12 vsubs 1.15618e-16
* device instance _22_t0 r0 *1 0,0
R_22_t0 \$22__t0 \$22 12.8
* device instance _22_t1 r0 *1 0,0
R_22_t1 \$22__t1 \$22 12.8
* device instance _22 r0 *1 0,0
C_22 \$22 vsubs 1.15618e-16
* device instance _30_t0 r0 *1 0,0
R_30_t0 \$30__t0 \$30 12.8
* device instance _30_t1 r0 *1 0,0
R_30_t1 \$30__t1 \$30 12.8
* device instance _30 r0 *1 0,0
C_30 \$30 vsubs 1.15618e-16
* device instance _39_t0 r0 *1 0,0
R_39_t0 \$39__t0 \$39 12.8
* device instance _39_t1 r0 *1 0,0
R_39_t1 \$39__t1 \$39 12.8
* device instance _39 r0 *1 0,0
C_39 \$39 vsubs 1.15618e-16
* device instance _79_t0 r0 *1 0,0
R_79_t0 \$79__t0 \$79 12.8
* device instance _79_t1 r0 *1 0,0
R_79_t1 \$79__t1 \$79 12.8
* device instance _79 r0 *1 0,0
C_79 \$79 vsubs 1.15618e-16
* device instance _81_t0 r0 *1 0,0
R_81_t0 \$81__t0 \$81 12.8
* device instance _81_t1 r0 *1 0,0
R_81_t1 \$81__t1 \$81 12.8
* device instance _81 r0 *1 0,0
C_81 \$81 vsubs 1.15618e-16
* device instance _82_t0 r0 *1 0,0
R_82_t0 \$82__t0 \$82 12.8
* device instance _82_t1 r0 *1 0,0
R_82_t1 \$82__t1 \$82 12.8
* device instance _82 r0 *1 0,0
C_82 \$82 vsubs 1.15618e-16
* device instance _84_t0 r0 *1 0,0
R_84_t0 \$84__t0 \$84 12.8
* device instance _84_t1 r0 *1 0,0
R_84_t1 \$84__t1 \$84 12.8
* device instance _84 r0 *1 0,0
C_84 \$84 vsubs 1.15618e-16
* device instance _87_t0 r0 *1 0,0
R_87_t0 \$87__t0 \$87 12.8
* device instance _87_t1 r0 *1 0,0
R_87_t1 \$87__t1 \$87 12.8
* device instance _87 r0 *1 0,0
C_87 \$87 vsubs 1.15618e-16
* device instance _89_t0 r0 *1 0,0
R_89_t0 \$89__t0 \$89 12.8
* device instance _89_t1 r0 *1 0,0
R_89_t1 \$89__t1 \$89 12.8
* device instance _89 r0 *1 0,0
C_89 \$89 vsubs 1.15618e-16
* device instance an_inva_y_mn34_g0_mp13_g1_y_t0 r0 *1 0,0
Ran_inva_y_mn34_g0_mp13_g1_y_t0 an\x7cinva_y\x7cmn34_g0\x7cmp13_g1\x7cy__t0
+ an|inva_y|mn34_g0|mp13_g1|y 308.267015586
* device instance an_inva_y_mn34_g0_mp13_g1_y_t1 r0 *1 0,0
Ran_inva_y_mn34_g0_mp13_g1_y_t1 an\x7cinva_y\x7cmn34_g0\x7cmp13_g1\x7cy__t1
+ an|inva_y|mn34_g0|mp13_g1|y 129.429614029
* device instance an_inva_y_mn34_g0_mp13_g1_y_t2 r0 *1 0,0
Ran_inva_y_mn34_g0_mp13_g1_y_t2 an\x7cinva_y\x7cmn34_g0\x7cmp13_g1\x7cy__t2
+ an|inva_y|mn34_g0|mp13_g1|y 160.163782155
* device instance an_inva_y_mn34_g0_mp13_g1_y_t3 r0 *1 0,0
Ran_inva_y_mn34_g0_mp13_g1_y_t3 an\x7cinva_y\x7cmn34_g0\x7cmp13_g1\x7cy__t3
+ an|inva_y|mn34_g0|mp13_g1|y 253.84948823
* device instance an_inva_y_mn34_g0_mp13_g1_y r0 *1 0,0
Can_inva_y_mn34_g0_mp13_g1_y an|inva_y|mn34_g0|mp13_g1|y vsubs 2.183901e-15
* device instance an_inva_y_mn34_g0_mp13_g1_y_dup1_t0 r0 *1 0,0
Ran_inva_y_mn34_g0_mp13_g1_y_dup1_t0
+ an\x7cinva_y\x7cmn34_g0\x7cmp13_g1\x7cy__t02 an|inva_y|mn34_g0|mp13_g1|y$1
+ 308.267015586
* device instance an_inva_y_mn34_g0_mp13_g1_y_dup1_t1 r0 *1 0,0
Ran_inva_y_mn34_g0_mp13_g1_y_dup1_t1
+ an\x7cinva_y\x7cmn34_g0\x7cmp13_g1\x7cy__t12 an|inva_y|mn34_g0|mp13_g1|y$1
+ 129.429614029
* device instance an_inva_y_mn34_g0_mp13_g1_y_dup1_t2 r0 *1 0,0
Ran_inva_y_mn34_g0_mp13_g1_y_dup1_t2
+ an\x7cinva_y\x7cmn34_g0\x7cmp13_g1\x7cy__t22 an|inva_y|mn34_g0|mp13_g1|y$1
+ 160.163782155
* device instance an_inva_y_mn34_g0_mp13_g1_y_dup1_t3 r0 *1 0,0
Ran_inva_y_mn34_g0_mp13_g1_y_dup1_t3
+ an\x7cinva_y\x7cmn34_g0\x7cmp13_g1\x7cy__t32 an|inva_y|mn34_g0|mp13_g1|y$1
+ 253.84948823
* device instance an_inva_y_mn34_g0_mp13_g1_y_dup1 r0 *1 0,0
Can_inva_y_mn34_g0_mp13_g1_y_dup1 an|inva_y|mn34_g0|mp13_g1|y$1 vsubs
+ 2.183901e-15
* device instance an_inva_y_mn34_g0_mp13_g1_y_dup2_t0 r0 *1 0,0
Ran_inva_y_mn34_g0_mp13_g1_y_dup2_t0
+ an\x7cinva_y\x7cmn34_g0\x7cmp13_g1\x7cy__t03 an|inva_y|mn34_g0|mp13_g1|y$2
+ 308.267015586
* device instance an_inva_y_mn34_g0_mp13_g1_y_dup2_t1 r0 *1 0,0
Ran_inva_y_mn34_g0_mp13_g1_y_dup2_t1
+ an\x7cinva_y\x7cmn34_g0\x7cmp13_g1\x7cy__t13 an|inva_y|mn34_g0|mp13_g1|y$2
+ 129.429614029
* device instance an_inva_y_mn34_g0_mp13_g1_y_dup2_t2 r0 *1 0,0
Ran_inva_y_mn34_g0_mp13_g1_y_dup2_t2
+ an\x7cinva_y\x7cmn34_g0\x7cmp13_g1\x7cy__t23 an|inva_y|mn34_g0|mp13_g1|y$2
+ 160.163782155
* device instance an_inva_y_mn34_g0_mp13_g1_y_dup2_t3 r0 *1 0,0
Ran_inva_y_mn34_g0_mp13_g1_y_dup2_t3
+ an\x7cinva_y\x7cmn34_g0\x7cmp13_g1\x7cy__t33 an|inva_y|mn34_g0|mp13_g1|y$2
+ 253.84948823
* device instance an_inva_y_mn34_g0_mp13_g1_y_dup2 r0 *1 0,0
Can_inva_y_mn34_g0_mp13_g1_y_dup2 an|inva_y|mn34_g0|mp13_g1|y$2 vsubs
+ 2.183901e-15
* device instance a_b_b3_invb_a_mn12_g1_mp24_g0_t2_y_t0 r0 *1 0,0
Ra_b_b3_invb_a_mn12_g1_mp24_g0_t2_y_t0
+ a\x7cb\x7cb3\x7cinvb_a\x7cmn12_g1\x7cmp24_g0\x7ct2\x7cy__t0
+ a|b|b3|invb_a|mn12_g1|mp24_g0|t2|y 436.725341736
* device instance a_b_b3_invb_a_mn12_g1_mp24_g0_t2_y_t1 r0 *1 0,0
Ra_b_b3_invb_a_mn12_g1_mp24_g0_t2_y_t1
+ a\x7cb\x7cb3\x7cinvb_a\x7cmn12_g1\x7cmp24_g0\x7ct2\x7cy__t1
+ a|b|b3|invb_a|mn12_g1|mp24_g0|t2|y 313.585442139
* device instance a_b_b3_invb_a_mn12_g1_mp24_g0_t2_y_t2 r0 *1 0,0
Ra_b_b3_invb_a_mn12_g1_mp24_g0_t2_y_t2
+ a\x7cb\x7cb3\x7cinvb_a\x7cmn12_g1\x7cmp24_g0\x7ct2\x7cy__t2
+ a|b|b3|invb_a|mn12_g1|mp24_g0|t2|y 312.928261153
* device instance a_b_b3_invb_a_mn12_g1_mp24_g0_t2_y_t3 r0 *1 0,0
Ra_b_b3_invb_a_mn12_g1_mp24_g0_t2_y_t3
+ a\x7cb\x7cb3\x7cinvb_a\x7cmn12_g1\x7cmp24_g0\x7ct2\x7cy__t3
+ a|b|b3|invb_a|mn12_g1|mp24_g0|t2|y 422.873561928
* device instance a_b_b3_invb_a_mn12_g1_mp24_g0_t2_y_t4 r0 *1 0,0
Ra_b_b3_invb_a_mn12_g1_mp24_g0_t2_y_t4
+ a\x7cb\x7cb3\x7cinvb_a\x7cmn12_g1\x7cmp24_g0\x7ct2\x7cy__t4
+ a|b|b3|invb_a|mn12_g1|mp24_g0|t2|y 425.2506178
* device instance a_b_b3_invb_a_mn12_g1_mp24_g0_t2_y_t5 r0 *1 0,0
Ra_b_b3_invb_a_mn12_g1_mp24_g0_t2_y_t5
+ a\x7cb\x7cb3\x7cinvb_a\x7cmn12_g1\x7cmp24_g0\x7ct2\x7cy__t5
+ a|b|b3|invb_a|mn12_g1|mp24_g0|t2|y 314.138675751
* device instance a_b_b3_invb_a_mn12_g1_mp24_g0_t2_y_t6 r0 *1 0,0
Ra_b_b3_invb_a_mn12_g1_mp24_g0_t2_y_t6
+ a\x7cb\x7cb3\x7cinvb_a\x7cmn12_g1\x7cmp24_g0\x7ct2\x7cy__t6
+ a|b|b3|invb_a|mn12_g1|mp24_g0|t2|y 305.885364036
* device instance a_b_b3_invb_a_mn12_g1_mp24_g0_t2_y_t7 r0 *1 0,0
Ra_b_b3_invb_a_mn12_g1_mp24_g0_t2_y_t7
+ a\x7cb\x7cb3\x7cinvb_a\x7cmn12_g1\x7cmp24_g0\x7ct2\x7cy__t7
+ a|b|b3|invb_a|mn12_g1|mp24_g0|t2|y 440.626235455
* device instance a_b_b3_invb_a_mn12_g1_mp24_g0_t2_y r0 *1 0,0
Ca_b_b3_invb_a_mn12_g1_mp24_g0_t2_y a|b|b3|invb_a|mn12_g1|mp24_g0|t2|y vsubs
+ 9.92118e-15
* device instance a_b_invb_a_mn12_g1_mp24_g0_ro2_y_t0 r0 *1 0,0
Ra_b_invb_a_mn12_g1_mp24_g0_ro2_y_t0
+ a\x7cb\x7cinvb_a\x7cmn12_g1\x7cmp24_g0\x7cro2\x7cy__t0
+ a|b|invb_a|mn12_g1|mp24_g0|ro2|y 219.72486532
* device instance a_b_invb_a_mn12_g1_mp24_g0_ro2_y_t1 r0 *1 0,0
Ra_b_invb_a_mn12_g1_mp24_g0_ro2_y_t1
+ a\x7cb\x7cinvb_a\x7cmn12_g1\x7cmp24_g0\x7cro2\x7cy__t1
+ a|b|invb_a|mn12_g1|mp24_g0|ro2|y 377.093414402
* device instance a_b_invb_a_mn12_g1_mp24_g0_ro2_y_t2 r0 *1 0,0
Ra_b_invb_a_mn12_g1_mp24_g0_ro2_y_t2
+ a\x7cb\x7cinvb_a\x7cmn12_g1\x7cmp24_g0\x7cro2\x7cy__t2
+ a|b|invb_a|mn12_g1|mp24_g0|ro2|y 171.620086654
* device instance a_b_invb_a_mn12_g1_mp24_g0_ro2_y_t3 r0 *1 0,0
Ra_b_invb_a_mn12_g1_mp24_g0_ro2_y_t3
+ a\x7cb\x7cinvb_a\x7cmn12_g1\x7cmp24_g0\x7cro2\x7cy__t3
+ a|b|invb_a|mn12_g1|mp24_g0|ro2|y 381.572790662
* device instance a_b_invb_a_mn12_g1_mp24_g0_ro2_y_t4 r0 *1 0,0
Ra_b_invb_a_mn12_g1_mp24_g0_ro2_y_t4
+ a\x7cb\x7cinvb_a\x7cmn12_g1\x7cmp24_g0\x7cro2\x7cy__t4
+ a|b|invb_a|mn12_g1|mp24_g0|ro2|y 167.024195879
* device instance a_b_invb_a_mn12_g1_mp24_g0_ro2_y_t5 r0 *1 0,0
Ra_b_invb_a_mn12_g1_mp24_g0_ro2_y_t5
+ a\x7cb\x7cinvb_a\x7cmn12_g1\x7cmp24_g0\x7cro2\x7cy__t5
+ a|b|invb_a|mn12_g1|mp24_g0|ro2|y 205.417347084
* device instance a_b_invb_a_mn12_g1_mp24_g0_ro2_y r0 *1 0,0
Ca_b_invb_a_mn12_g1_mp24_g0_ro2_y a|b|invb_a|mn12_g1|mp24_g0|ro2|y vsubs
+ 1.1936456e-14
* device instance a_b_invb_a_mn12_g1_mp24_g0_ro4_y_t0 r0 *1 0,0
Ra_b_invb_a_mn12_g1_mp24_g0_ro4_y_t0
+ a\x7cb\x7cinvb_a\x7cmn12_g1\x7cmp24_g0\x7cro4\x7cy__t0
+ a|b|invb_a|mn12_g1|mp24_g0|ro4|y 211.788447954
* device instance a_b_invb_a_mn12_g1_mp24_g0_ro4_y_t1 r0 *1 0,0
Ra_b_invb_a_mn12_g1_mp24_g0_ro4_y_t1
+ a\x7cb\x7cinvb_a\x7cmn12_g1\x7cmp24_g0\x7cro4\x7cy__t1
+ a|b|invb_a|mn12_g1|mp24_g0|ro4|y 394.590063114
* device instance a_b_invb_a_mn12_g1_mp24_g0_ro4_y_t2 r0 *1 0,0
Ra_b_invb_a_mn12_g1_mp24_g0_ro4_y_t2
+ a\x7cb\x7cinvb_a\x7cmn12_g1\x7cmp24_g0\x7cro4\x7cy__t2
+ a|b|invb_a|mn12_g1|mp24_g0|ro4|y 187.123423797
* device instance a_b_invb_a_mn12_g1_mp24_g0_ro4_y_t3 r0 *1 0,0
Ra_b_invb_a_mn12_g1_mp24_g0_ro4_y_t3
+ a\x7cb\x7cinvb_a\x7cmn12_g1\x7cmp24_g0\x7cro4\x7cy__t3
+ a|b|invb_a|mn12_g1|mp24_g0|ro4|y 395.854909837
* device instance a_b_invb_a_mn12_g1_mp24_g0_ro4_y_t4 r0 *1 0,0
Ra_b_invb_a_mn12_g1_mp24_g0_ro4_y_t4
+ a\x7cb\x7cinvb_a\x7cmn12_g1\x7cmp24_g0\x7cro4\x7cy__t4
+ a|b|invb_a|mn12_g1|mp24_g0|ro4|y 185.895918562
* device instance a_b_invb_a_mn12_g1_mp24_g0_ro4_y_t5 r0 *1 0,0
Ra_b_invb_a_mn12_g1_mp24_g0_ro4_y_t5
+ a\x7cb\x7cinvb_a\x7cmn12_g1\x7cmp24_g0\x7cro4\x7cy__t5
+ a|b|invb_a|mn12_g1|mp24_g0|ro4|y 207.195036736
* device instance a_b_invb_a_mn12_g1_mp24_g0_ro4_y r0 *1 0,0
Ca_b_invb_a_mn12_g1_mp24_g0_ro4_y a|b|invb_a|mn12_g1|mp24_g0|ro4|y vsubs
+ 1.891326e-14
* device instance a_g_a_rn1_ro_s4_y_y_t0 r0 *1 0,0
Ra_g_a_rn1_ro_s4_y_y_t0 a\x7cg_a\x7crn1\x7cro\x7cs4_y\x7cy__t0
+ a|g_a|rn1|ro|s4_y|y 390.628947889
* device instance a_g_a_rn1_ro_s4_y_y_t1 r0 *1 0,0
Ra_g_a_rn1_ro_s4_y_y_t1 a\x7cg_a\x7crn1\x7cro\x7cs4_y\x7cy__t1
+ a|g_a|rn1|ro|s4_y|y 123.915720768
* device instance a_g_a_rn1_ro_s4_y_y_t2 r0 *1 0,0
Ra_g_a_rn1_ro_s4_y_y_t2 a\x7cg_a\x7crn1\x7cro\x7cs4_y\x7cy__t2
+ a|g_a|rn1|ro|s4_y|y 265.314164861
* device instance a_g_a_rn1_ro_s4_y_y_t3 r0 *1 0,0
Ra_g_a_rn1_ro_s4_y_y_t3 a\x7cg_a\x7crn1\x7cro\x7cs4_y\x7cy__t3
+ a|g_a|rn1|ro|s4_y|y 384.216215082
* device instance a_g_a_rn1_ro_s4_y_y_t4 r0 *1 0,0
Ra_g_a_rn1_ro_s4_y_y_t4 a\x7cg_a\x7crn1\x7cro\x7cs4_y\x7cy__t4
+ a|g_a|rn1|ro|s4_y|y 126.702317094
* device instance a_g_a_rn1_ro_s4_y_y_t5 r0 *1 0,0
Ra_g_a_rn1_ro_s4_y_y_t5 a\x7cg_a\x7crn1\x7cro\x7cs4_y\x7cy__t5
+ a|g_a|rn1|ro|s4_y|y 265.524234306
* device instance a_g_a_rn1_ro_s4_y_y r0 *1 0,0
Ca_g_a_rn1_ro_s4_y_y a|g_a|rn1|ro|s4_y|y vsubs 6.402999e-15
* device instance a_g_a_rn2_ro_s4_y_y_t0 r0 *1 0,0
Ra_g_a_rn2_ro_s4_y_y_t0 a\x7cg_a\x7crn2\x7cro\x7cs4_y\x7cy__t0
+ a|g_a|rn2|ro|s4_y|y 123.915720768
* device instance a_g_a_rn2_ro_s4_y_y_t1 r0 *1 0,0
Ra_g_a_rn2_ro_s4_y_y_t1 a\x7cg_a\x7crn2\x7cro\x7cs4_y\x7cy__t1
+ a|g_a|rn2|ro|s4_y|y 265.314164861
* device instance a_g_a_rn2_ro_s4_y_y_t2 r0 *1 0,0
Ra_g_a_rn2_ro_s4_y_y_t2 a\x7cg_a\x7crn2\x7cro\x7cs4_y\x7cy__t2
+ a|g_a|rn2|ro|s4_y|y 384.216215082
* device instance a_g_a_rn2_ro_s4_y_y_t3 r0 *1 0,0
Ra_g_a_rn2_ro_s4_y_y_t3 a\x7cg_a\x7crn2\x7cro\x7cs4_y\x7cy__t3
+ a|g_a|rn2|ro|s4_y|y 126.702317094
* device instance a_g_a_rn2_ro_s4_y_y_t4 r0 *1 0,0
Ra_g_a_rn2_ro_s4_y_y_t4 a\x7cg_a\x7crn2\x7cro\x7cs4_y\x7cy__t4
+ a|g_a|rn2|ro|s4_y|y 265.524234306
* device instance a_g_a_rn2_ro_s4_y_y_t5 r0 *1 0,0
Ra_g_a_rn2_ro_s4_y_y_t5 a\x7cg_a\x7crn2\x7cro\x7cs4_y\x7cy__t5
+ a|g_a|rn2|ro|s4_y|y 390.628947889
* device instance a_g_a_rn2_ro_s4_y_y r0 *1 0,0
Ca_g_a_rn2_ro_s4_y_y a|g_a|rn2|ro|s4_y|y vsubs 6.402999e-15
* device instance a_g_a_rn3_ro_s4_y_y_t0 r0 *1 0,0
Ra_g_a_rn3_ro_s4_y_y_t0 a\x7cg_a\x7crn3\x7cro\x7cs4_y\x7cy__t0
+ a|g_a|rn3|ro|s4_y|y 123.915720768
* device instance a_g_a_rn3_ro_s4_y_y_t1 r0 *1 0,0
Ra_g_a_rn3_ro_s4_y_y_t1 a\x7cg_a\x7crn3\x7cro\x7cs4_y\x7cy__t1
+ a|g_a|rn3|ro|s4_y|y 384.216215082
* device instance a_g_a_rn3_ro_s4_y_y_t2 r0 *1 0,0
Ra_g_a_rn3_ro_s4_y_y_t2 a\x7cg_a\x7crn3\x7cro\x7cs4_y\x7cy__t2
+ a|g_a|rn3|ro|s4_y|y 265.314164861
* device instance a_g_a_rn3_ro_s4_y_y_t3 r0 *1 0,0
Ra_g_a_rn3_ro_s4_y_y_t3 a\x7cg_a\x7crn3\x7cro\x7cs4_y\x7cy__t3
+ a|g_a|rn3|ro|s4_y|y 126.702317094
* device instance a_g_a_rn3_ro_s4_y_y_t4 r0 *1 0,0
Ra_g_a_rn3_ro_s4_y_y_t4 a\x7cg_a\x7crn3\x7cro\x7cs4_y\x7cy__t4
+ a|g_a|rn3|ro|s4_y|y 265.524234306
* device instance a_g_a_rn3_ro_s4_y_y_t5 r0 *1 0,0
Ra_g_a_rn3_ro_s4_y_y_t5 a\x7cg_a\x7crn3\x7cro\x7cs4_y\x7cy__t5
+ a|g_a|rn3|ro|s4_y|y 390.628947889
* device instance a_g_a_rn3_ro_s4_y_y r0 *1 0,0
Ca_g_a_rn3_ro_s4_y_y a|g_a|rn3|ro|s4_y|y vsubs 6.402999e-15
* device instance a_g_a_rn4_ro_s4_y_y_t0 r0 *1 0,0
Ra_g_a_rn4_ro_s4_y_y_t0 a\x7cg_a\x7crn4\x7cro\x7cs4_y\x7cy__t0
+ a|g_a|rn4|ro|s4_y|y 123.915720768
* device instance a_g_a_rn4_ro_s4_y_y_t1 r0 *1 0,0
Ra_g_a_rn4_ro_s4_y_y_t1 a\x7cg_a\x7crn4\x7cro\x7cs4_y\x7cy__t1
+ a|g_a|rn4|ro|s4_y|y 384.216215082
* device instance a_g_a_rn4_ro_s4_y_y_t2 r0 *1 0,0
Ra_g_a_rn4_ro_s4_y_y_t2 a\x7cg_a\x7crn4\x7cro\x7cs4_y\x7cy__t2
+ a|g_a|rn4|ro|s4_y|y 265.314164861
* device instance a_g_a_rn4_ro_s4_y_y_t3 r0 *1 0,0
Ra_g_a_rn4_ro_s4_y_y_t3 a\x7cg_a\x7crn4\x7cro\x7cs4_y\x7cy__t3
+ a|g_a|rn4|ro|s4_y|y 126.702317094
* device instance a_g_a_rn4_ro_s4_y_y_t4 r0 *1 0,0
Ra_g_a_rn4_ro_s4_y_y_t4 a\x7cg_a\x7crn4\x7cro\x7cs4_y\x7cy__t4
+ a|g_a|rn4|ro|s4_y|y 265.524234306
* device instance a_g_a_rn4_ro_s4_y_y_t5 r0 *1 0,0
Ra_g_a_rn4_ro_s4_y_y_t5 a\x7cg_a\x7crn4\x7cro\x7cs4_y\x7cy__t5
+ a|g_a|rn4|ro|s4_y|y 390.628947889
* device instance a_g_a_rn4_ro_s4_y_y r0 *1 0,0
Ca_g_a_rn4_ro_s4_y_y a|g_a|rn4|ro|s4_y|y vsubs 6.400128e-15
* device instance a_g_y_mnab_y_mpa_y_mpb_y_n1_s1_a_y_t0 r0 *1 0,0
Ra_g_y_mnab_y_mpa_y_mpb_y_n1_s1_a_y_t0
+ a\x7cg_y\x7cmnab_y\x7cmpa_y\x7cmpb_y\x7cn1\x7cs1_a\x7cy__t0
+ a|g_y|mnab_y|mpa_y|mpb_y|n1|s1_a|y 114.324644013
* device instance a_g_y_mnab_y_mpa_y_mpb_y_n1_s1_a_y_t1 r0 *1 0,0
Ra_g_y_mnab_y_mpa_y_mpb_y_n1_s1_a_y_t1
+ a\x7cg_y\x7cmnab_y\x7cmpa_y\x7cmpb_y\x7cn1\x7cs1_a\x7cy__t1
+ a|g_y|mnab_y|mpa_y|mpb_y|n1|s1_a|y 165.838297843
* device instance a_g_y_mnab_y_mpa_y_mpb_y_n1_s1_a_y_t2 r0 *1 0,0
Ra_g_y_mnab_y_mpa_y_mpb_y_n1_s1_a_y_t2
+ a\x7cg_y\x7cmnab_y\x7cmpa_y\x7cmpb_y\x7cn1\x7cs1_a\x7cy__t2
+ a|g_y|mnab_y|mpa_y|mpb_y|n1|s1_a|y 128.359871717
* device instance a_g_y_mnab_y_mpa_y_mpb_y_n1_s1_a_y_t3 r0 *1 0,0
Ra_g_y_mnab_y_mpa_y_mpb_y_n1_s1_a_y_t3
+ a\x7cg_y\x7cmnab_y\x7cmpa_y\x7cmpb_y\x7cn1\x7cs1_a\x7cy__t3
+ a|g_y|mnab_y|mpa_y|mpb_y|n1|s1_a|y 153.784254215
* device instance a_g_y_mnab_y_mpa_y_mpb_y_n1_s1_a_y_t4 r0 *1 0,0
Ra_g_y_mnab_y_mpa_y_mpb_y_n1_s1_a_y_t4
+ a\x7cg_y\x7cmnab_y\x7cmpa_y\x7cmpb_y\x7cn1\x7cs1_a\x7cy__t4
+ a|g_y|mnab_y|mpa_y|mpb_y|n1|s1_a|y 93.6501322123
* device instance a_g_y_mnab_y_mpa_y_mpb_y_n1_s1_a_y r0 *1 0,0
Ca_g_y_mnab_y_mpa_y_mpb_y_n1_s1_a_y a|g_y|mnab_y|mpa_y|mpb_y|n1|s1_a|y vsubs
+ 2.632209e-15
* device instance a_g_y_mnab_y_mpa_y_mpb_y_n1_s1_a_y_dup1_t0 r0 *1 0,0
Ra_g_y_mnab_y_mpa_y_mpb_y_n1_s1_a_y_dup1_t0
+ a\x7cg_y\x7cmnab_y\x7cmpa_y\x7cmpb_y\x7cn1\x7cs1_a\x7cy__t02
+ a|g_y|mnab_y|mpa_y|mpb_y|n1|s1_a|y$1 128.359871717
* device instance a_g_y_mnab_y_mpa_y_mpb_y_n1_s1_a_y_dup1_t1 r0 *1 0,0
Ra_g_y_mnab_y_mpa_y_mpb_y_n1_s1_a_y_dup1_t1
+ a\x7cg_y\x7cmnab_y\x7cmpa_y\x7cmpb_y\x7cn1\x7cs1_a\x7cy__t12
+ a|g_y|mnab_y|mpa_y|mpb_y|n1|s1_a|y$1 153.784254215
* device instance a_g_y_mnab_y_mpa_y_mpb_y_n1_s1_a_y_dup1_t2 r0 *1 0,0
Ra_g_y_mnab_y_mpa_y_mpb_y_n1_s1_a_y_dup1_t2
+ a\x7cg_y\x7cmnab_y\x7cmpa_y\x7cmpb_y\x7cn1\x7cs1_a\x7cy__t22
+ a|g_y|mnab_y|mpa_y|mpb_y|n1|s1_a|y$1 93.6501322123
* device instance a_g_y_mnab_y_mpa_y_mpb_y_n1_s1_a_y_dup1_t3 r0 *1 0,0
Ra_g_y_mnab_y_mpa_y_mpb_y_n1_s1_a_y_dup1_t3
+ a\x7cg_y\x7cmnab_y\x7cmpa_y\x7cmpb_y\x7cn1\x7cs1_a\x7cy__t32
+ a|g_y|mnab_y|mpa_y|mpb_y|n1|s1_a|y$1 165.838297843
* device instance a_g_y_mnab_y_mpa_y_mpb_y_n1_s1_a_y_dup1_t4 r0 *1 0,0
Ra_g_y_mnab_y_mpa_y_mpb_y_n1_s1_a_y_dup1_t4
+ a\x7cg_y\x7cmnab_y\x7cmpa_y\x7cmpb_y\x7cn1\x7cs1_a\x7cy__t42
+ a|g_y|mnab_y|mpa_y|mpb_y|n1|s1_a|y$1 114.324644013
* device instance a_g_y_mnab_y_mpa_y_mpb_y_n1_s1_a_y_dup1 r0 *1 0,0
Ca_g_y_mnab_y_mpa_y_mpb_y_n1_s1_a_y_dup1 a|g_y|mnab_y|mpa_y|mpb_y|n1|s1_a|y$1
+ vsubs 2.632209e-15
* device instance a_g_y_mnab_y_mpa_y_mpb_y_n1_s1_a_y_dup2_t0 r0 *1 0,0
Ra_g_y_mnab_y_mpa_y_mpb_y_n1_s1_a_y_dup2_t0
+ a\x7cg_y\x7cmnab_y\x7cmpa_y\x7cmpb_y\x7cn1\x7cs1_a\x7cy__t03
+ a|g_y|mnab_y|mpa_y|mpb_y|n1|s1_a|y$2 128.359871717
* device instance a_g_y_mnab_y_mpa_y_mpb_y_n1_s1_a_y_dup2_t1 r0 *1 0,0
Ra_g_y_mnab_y_mpa_y_mpb_y_n1_s1_a_y_dup2_t1
+ a\x7cg_y\x7cmnab_y\x7cmpa_y\x7cmpb_y\x7cn1\x7cs1_a\x7cy__t13
+ a|g_y|mnab_y|mpa_y|mpb_y|n1|s1_a|y$2 153.784254215
* device instance a_g_y_mnab_y_mpa_y_mpb_y_n1_s1_a_y_dup2_t2 r0 *1 0,0
Ra_g_y_mnab_y_mpa_y_mpb_y_n1_s1_a_y_dup2_t2
+ a\x7cg_y\x7cmnab_y\x7cmpa_y\x7cmpb_y\x7cn1\x7cs1_a\x7cy__t23
+ a|g_y|mnab_y|mpa_y|mpb_y|n1|s1_a|y$2 93.6501322123
* device instance a_g_y_mnab_y_mpa_y_mpb_y_n1_s1_a_y_dup2_t3 r0 *1 0,0
Ra_g_y_mnab_y_mpa_y_mpb_y_n1_s1_a_y_dup2_t3
+ a\x7cg_y\x7cmnab_y\x7cmpa_y\x7cmpb_y\x7cn1\x7cs1_a\x7cy__t33
+ a|g_y|mnab_y|mpa_y|mpb_y|n1|s1_a|y$2 165.838297843
* device instance a_g_y_mnab_y_mpa_y_mpb_y_n1_s1_a_y_dup2_t4 r0 *1 0,0
Ra_g_y_mnab_y_mpa_y_mpb_y_n1_s1_a_y_dup2_t4
+ a\x7cg_y\x7cmnab_y\x7cmpa_y\x7cmpb_y\x7cn1\x7cs1_a\x7cy__t43
+ a|g_y|mnab_y|mpa_y|mpb_y|n1|s1_a|y$2 114.324644013
* device instance a_g_y_mnab_y_mpa_y_mpb_y_n1_s1_a_y_dup2 r0 *1 0,0
Ca_g_y_mnab_y_mpa_y_mpb_y_n1_s1_a_y_dup2 a|g_y|mnab_y|mpa_y|mpb_y|n1|s1_a|y$2
+ vsubs 2.632209e-15
* device instance a_g_y_mnab_y_mpa_y_mpb_y_n1_s1_a_y_dup3_t0 r0 *1 0,0
Ra_g_y_mnab_y_mpa_y_mpb_y_n1_s1_a_y_dup3_t0
+ a\x7cg_y\x7cmnab_y\x7cmpa_y\x7cmpb_y\x7cn1\x7cs1_a\x7cy__t04
+ a|g_y|mnab_y|mpa_y|mpb_y|n1|s1_a|y$3 128.359871717
* device instance a_g_y_mnab_y_mpa_y_mpb_y_n1_s1_a_y_dup3_t1 r0 *1 0,0
Ra_g_y_mnab_y_mpa_y_mpb_y_n1_s1_a_y_dup3_t1
+ a\x7cg_y\x7cmnab_y\x7cmpa_y\x7cmpb_y\x7cn1\x7cs1_a\x7cy__t14
+ a|g_y|mnab_y|mpa_y|mpb_y|n1|s1_a|y$3 153.784254215
* device instance a_g_y_mnab_y_mpa_y_mpb_y_n1_s1_a_y_dup3_t2 r0 *1 0,0
Ra_g_y_mnab_y_mpa_y_mpb_y_n1_s1_a_y_dup3_t2
+ a\x7cg_y\x7cmnab_y\x7cmpa_y\x7cmpb_y\x7cn1\x7cs1_a\x7cy__t24
+ a|g_y|mnab_y|mpa_y|mpb_y|n1|s1_a|y$3 93.6501322123
* device instance a_g_y_mnab_y_mpa_y_mpb_y_n1_s1_a_y_dup3_t3 r0 *1 0,0
Ra_g_y_mnab_y_mpa_y_mpb_y_n1_s1_a_y_dup3_t3
+ a\x7cg_y\x7cmnab_y\x7cmpa_y\x7cmpb_y\x7cn1\x7cs1_a\x7cy__t34
+ a|g_y|mnab_y|mpa_y|mpb_y|n1|s1_a|y$3 165.838297843
* device instance a_g_y_mnab_y_mpa_y_mpb_y_n1_s1_a_y_dup3_t4 r0 *1 0,0
Ra_g_y_mnab_y_mpa_y_mpb_y_n1_s1_a_y_dup3_t4
+ a\x7cg_y\x7cmnab_y\x7cmpa_y\x7cmpb_y\x7cn1\x7cs1_a\x7cy__t44
+ a|g_y|mnab_y|mpa_y|mpb_y|n1|s1_a|y$3 114.324644013
* device instance a_g_y_mnab_y_mpa_y_mpb_y_n1_s1_a_y_dup3 r0 *1 0,0
Ca_g_y_mnab_y_mpa_y_mpb_y_n1_s1_a_y_dup3 a|g_y|mnab_y|mpa_y|mpb_y|n1|s1_a|y$3
+ vsubs 2.632209e-15
* device instance a_inva_a_mn12_g0_mp13_g0_ro1_y_t0 r0 *1 0,0
Ra_inva_a_mn12_g0_mp13_g0_ro1_y_t0
+ a\x7cinva_a\x7cmn12_g0\x7cmp13_g0\x7cro1\x7cy__t0
+ a|inva_a|mn12_g0|mp13_g0|ro1|y 222.600380746
* device instance a_inva_a_mn12_g0_mp13_g0_ro1_y_t1 r0 *1 0,0
Ra_inva_a_mn12_g0_mp13_g0_ro1_y_t1
+ a\x7cinva_a\x7cmn12_g0\x7cmp13_g0\x7cro1\x7cy__t1
+ a|inva_a|mn12_g0|mp13_g0|ro1|y 367.685997005
* device instance a_inva_a_mn12_g0_mp13_g0_ro1_y_t2 r0 *1 0,0
Ra_inva_a_mn12_g0_mp13_g0_ro1_y_t2
+ a\x7cinva_a\x7cmn12_g0\x7cmp13_g0\x7cro1\x7cy__t2
+ a|inva_a|mn12_g0|mp13_g0|ro1|y 237.055695608
* device instance a_inva_a_mn12_g0_mp13_g0_ro1_y_t3 r0 *1 0,0
Ra_inva_a_mn12_g0_mp13_g0_ro1_y_t3
+ a\x7cinva_a\x7cmn12_g0\x7cmp13_g0\x7cro1\x7cy__t3
+ a|inva_a|mn12_g0|mp13_g0|ro1|y 384.183369324
* device instance a_inva_a_mn12_g0_mp13_g0_ro1_y_t4 r0 *1 0,0
Ra_inva_a_mn12_g0_mp13_g0_ro1_y_t4
+ a\x7cinva_a\x7cmn12_g0\x7cmp13_g0\x7cro1\x7cy__t4
+ a|inva_a|mn12_g0|mp13_g0|ro1|y 224.754747672
* device instance a_inva_a_mn12_g0_mp13_g0_ro1_y_t5 r0 *1 0,0
Ra_inva_a_mn12_g0_mp13_g0_ro1_y_t5
+ a\x7cinva_a\x7cmn12_g0\x7cmp13_g0\x7cro1\x7cy__t5
+ a|inva_a|mn12_g0|mp13_g0|ro1|y 81.257809645
* device instance a_inva_a_mn12_g0_mp13_g0_ro1_y r0 *1 0,0
Ca_inva_a_mn12_g0_mp13_g0_ro1_y a|inva_a|mn12_g0|mp13_g0|ro1|y vsubs
+ 1.136614e-14
* device instance a_inva_a_mn12_g0_mp13_g0_ro3_y_t0 r0 *1 0,0
Ra_inva_a_mn12_g0_mp13_g0_ro3_y_t0
+ a\x7cinva_a\x7cmn12_g0\x7cmp13_g0\x7cro3\x7cy__t0
+ a|inva_a|mn12_g0|mp13_g0|ro3|y 201.584080775
* device instance a_inva_a_mn12_g0_mp13_g0_ro3_y_t1 r0 *1 0,0
Ra_inva_a_mn12_g0_mp13_g0_ro3_y_t1
+ a\x7cinva_a\x7cmn12_g0\x7cmp13_g0\x7cro3\x7cy__t1
+ a|inva_a|mn12_g0|mp13_g0|ro3|y 392.559430443
* device instance a_inva_a_mn12_g0_mp13_g0_ro3_y_t2 r0 *1 0,0
Ra_inva_a_mn12_g0_mp13_g0_ro3_y_t2
+ a\x7cinva_a\x7cmn12_g0\x7cmp13_g0\x7cro3\x7cy__t2
+ a|inva_a|mn12_g0|mp13_g0|ro3|y 215.591788151
* device instance a_inva_a_mn12_g0_mp13_g0_ro3_y_t3 r0 *1 0,0
Ra_inva_a_mn12_g0_mp13_g0_ro3_y_t3
+ a\x7cinva_a\x7cmn12_g0\x7cmp13_g0\x7cro3\x7cy__t3
+ a|inva_a|mn12_g0|mp13_g0|ro3|y 394.859389835
* device instance a_inva_a_mn12_g0_mp13_g0_ro3_y_t4 r0 *1 0,0
Ra_inva_a_mn12_g0_mp13_g0_ro3_y_t4
+ a\x7cinva_a\x7cmn12_g0\x7cmp13_g0\x7cro3\x7cy__t4
+ a|inva_a|mn12_g0|mp13_g0|ro3|y 213.659555309
* device instance a_inva_a_mn12_g0_mp13_g0_ro3_y_t5 r0 *1 0,0
Ra_inva_a_mn12_g0_mp13_g0_ro3_y_t5
+ a\x7cinva_a\x7cmn12_g0\x7cmp13_g0\x7cro3\x7cy__t5
+ a|inva_a|mn12_g0|mp13_g0|ro3|y 159.300455486
* device instance a_inva_a_mn12_g0_mp13_g0_ro3_y r0 *1 0,0
Ca_inva_a_mn12_g0_mp13_g0_ro3_y a|inva_a|mn12_g0|mp13_g0|ro3|y vsubs
+ 1.834735e-14
* device instance a_inva_a_mn12_g0_mp13_g0_t1_y_t0 r0 *1 0,0
Ra_inva_a_mn12_g0_mp13_g0_t1_y_t0
+ a\x7cinva_a\x7cmn12_g0\x7cmp13_g0\x7ct1\x7cy__t0
+ a|inva_a|mn12_g0|mp13_g0|t1|y 419.786258702
* device instance a_inva_a_mn12_g0_mp13_g0_t1_y_t1 r0 *1 0,0
Ra_inva_a_mn12_g0_mp13_g0_t1_y_t1
+ a\x7cinva_a\x7cmn12_g0\x7cmp13_g0\x7ct1\x7cy__t1
+ a|inva_a|mn12_g0|mp13_g0|t1|y 332.607504746
* device instance a_inva_a_mn12_g0_mp13_g0_t1_y_t2 r0 *1 0,0
Ra_inva_a_mn12_g0_mp13_g0_t1_y_t2
+ a\x7cinva_a\x7cmn12_g0\x7cmp13_g0\x7ct1\x7cy__t2
+ a|inva_a|mn12_g0|mp13_g0|t1|y 378.589153398
* device instance a_inva_a_mn12_g0_mp13_g0_t1_y_t3 r0 *1 0,0
Ra_inva_a_mn12_g0_mp13_g0_t1_y_t3
+ a\x7cinva_a\x7cmn12_g0\x7cmp13_g0\x7ct1\x7cy__t3
+ a|inva_a|mn12_g0|mp13_g0|t1|y 317.26897702
* device instance a_inva_a_mn12_g0_mp13_g0_t1_y_t4 r0 *1 0,0
Ra_inva_a_mn12_g0_mp13_g0_t1_y_t4
+ a\x7cinva_a\x7cmn12_g0\x7cmp13_g0\x7ct1\x7cy__t4
+ a|inva_a|mn12_g0|mp13_g0|t1|y 318.770323812
* device instance a_inva_a_mn12_g0_mp13_g0_t1_y_t5 r0 *1 0,0
Ra_inva_a_mn12_g0_mp13_g0_t1_y_t5
+ a\x7cinva_a\x7cmn12_g0\x7cmp13_g0\x7ct1\x7cy__t5
+ a|inva_a|mn12_g0|mp13_g0|t1|y 476.903687784
* device instance a_inva_a_mn12_g0_mp13_g0_t1_y_t6 r0 *1 0,0
Ra_inva_a_mn12_g0_mp13_g0_t1_y_t6
+ a\x7cinva_a\x7cmn12_g0\x7cmp13_g0\x7ct1\x7cy__t6
+ a|inva_a|mn12_g0|mp13_g0|t1|y 328.474792154
* device instance a_inva_a_mn12_g0_mp13_g0_t1_y_t7 r0 *1 0,0
Ra_inva_a_mn12_g0_mp13_g0_t1_y_t7
+ a\x7cinva_a\x7cmn12_g0\x7cmp13_g0\x7ct1\x7cy__t7
+ a|inva_a|mn12_g0|mp13_g0|t1|y 422.977502385
* device instance a_inva_a_mn12_g0_mp13_g0_t1_y r0 *1 0,0
Ca_inva_a_mn12_g0_mp13_g0_t1_y a|inva_a|mn12_g0|mp13_g0|t1|y vsubs 1.2918394e-14
* device instance a_n2_s1_y_s2_a_y_t0 r0 *1 0,0
Ra_n2_s1_y_s2_a_y_t0 a\x7cn2\x7cs1_y\x7cs2_a\x7cy__t0 a|n2|s1_y|s2_a|y
+ 225.155136025
* device instance a_n2_s1_y_s2_a_y_t1 r0 *1 0,0
Ra_n2_s1_y_s2_a_y_t1 a\x7cn2\x7cs1_y\x7cs2_a\x7cy__t1 a|n2|s1_y|s2_a|y
+ 234.635313975
* device instance a_n2_s1_y_s2_a_y_t2 r0 *1 0,0
Ra_n2_s1_y_s2_a_y_t2 a\x7cn2\x7cs1_y\x7cs2_a\x7cy__t2 a|n2|s1_y|s2_a|y
+ 225.155136025
* device instance a_n2_s1_y_s2_a_y_t3 r0 *1 0,0
Ra_n2_s1_y_s2_a_y_t3 a\x7cn2\x7cs1_y\x7cs2_a\x7cy__t3 a|n2|s1_y|s2_a|y
+ 234.635313975
* device instance a_n2_s1_y_s2_a_y r0 *1 0,0
Ca_n2_s1_y_s2_a_y a|n2|s1_y|s2_a|y vsubs 2.529995e-15
* device instance a_n2_s1_y_s2_a_y_dup1_t0 r0 *1 0,0
Ra_n2_s1_y_s2_a_y_dup1_t0 a\x7cn2\x7cs1_y\x7cs2_a\x7cy__t02 a|n2|s1_y|s2_a|y$1
+ 234.635313975
* device instance a_n2_s1_y_s2_a_y_dup1_t1 r0 *1 0,0
Ra_n2_s1_y_s2_a_y_dup1_t1 a\x7cn2\x7cs1_y\x7cs2_a\x7cy__t12 a|n2|s1_y|s2_a|y$1
+ 225.155136025
* device instance a_n2_s1_y_s2_a_y_dup1_t2 r0 *1 0,0
Ra_n2_s1_y_s2_a_y_dup1_t2 a\x7cn2\x7cs1_y\x7cs2_a\x7cy__t22 a|n2|s1_y|s2_a|y$1
+ 225.155136025
* device instance a_n2_s1_y_s2_a_y_dup1_t3 r0 *1 0,0
Ra_n2_s1_y_s2_a_y_dup1_t3 a\x7cn2\x7cs1_y\x7cs2_a\x7cy__t32 a|n2|s1_y|s2_a|y$1
+ 234.635313975
* device instance a_n2_s1_y_s2_a_y_dup1 r0 *1 0,0
Ca_n2_s1_y_s2_a_y_dup1 a|n2|s1_y|s2_a|y$1 vsubs 2.529995e-15
* device instance a_n2_s1_y_s2_a_y_dup2_t0 r0 *1 0,0
Ra_n2_s1_y_s2_a_y_dup2_t0 a\x7cn2\x7cs1_y\x7cs2_a\x7cy__t03 a|n2|s1_y|s2_a|y$2
+ 234.635313975
* device instance a_n2_s1_y_s2_a_y_dup2_t1 r0 *1 0,0
Ra_n2_s1_y_s2_a_y_dup2_t1 a\x7cn2\x7cs1_y\x7cs2_a\x7cy__t13 a|n2|s1_y|s2_a|y$2
+ 225.155136025
* device instance a_n2_s1_y_s2_a_y_dup2_t2 r0 *1 0,0
Ra_n2_s1_y_s2_a_y_dup2_t2 a\x7cn2\x7cs1_y\x7cs2_a\x7cy__t23 a|n2|s1_y|s2_a|y$2
+ 225.155136025
* device instance a_n2_s1_y_s2_a_y_dup2_t3 r0 *1 0,0
Ra_n2_s1_y_s2_a_y_dup2_t3 a\x7cn2\x7cs1_y\x7cs2_a\x7cy__t33 a|n2|s1_y|s2_a|y$2
+ 234.635313975
* device instance a_n2_s1_y_s2_a_y_dup2 r0 *1 0,0
Ca_n2_s1_y_s2_a_y_dup2 a|n2|s1_y|s2_a|y$2 vsubs 2.529995e-15
* device instance a_n2_s1_y_s2_a_y_dup3_t0 r0 *1 0,0
Ra_n2_s1_y_s2_a_y_dup3_t0 a\x7cn2\x7cs1_y\x7cs2_a\x7cy__t04 a|n2|s1_y|s2_a|y$3
+ 234.635313975
* device instance a_n2_s1_y_s2_a_y_dup3_t1 r0 *1 0,0
Ra_n2_s1_y_s2_a_y_dup3_t1 a\x7cn2\x7cs1_y\x7cs2_a\x7cy__t14 a|n2|s1_y|s2_a|y$3
+ 225.155136025
* device instance a_n2_s1_y_s2_a_y_dup3_t2 r0 *1 0,0
Ra_n2_s1_y_s2_a_y_dup3_t2 a\x7cn2\x7cs1_y\x7cs2_a\x7cy__t24 a|n2|s1_y|s2_a|y$3
+ 225.155136025
* device instance a_n2_s1_y_s2_a_y_dup3_t3 r0 *1 0,0
Ra_n2_s1_y_s2_a_y_dup3_t3 a\x7cn2\x7cs1_y\x7cs2_a\x7cy__t34 a|n2|s1_y|s2_a|y$3
+ 234.635313975
* device instance a_n2_s1_y_s2_a_y_dup3 r0 *1 0,0
Ca_n2_s1_y_s2_a_y_dup3 a|n2|s1_y|s2_a|y$3 vsubs 2.529995e-15
* device instance a_n3_s2_y_s3_a_y_t0 r0 *1 0,0
Ra_n3_s2_y_s3_a_y_t0 a\x7cn3\x7cs2_y\x7cs3_a\x7cy__t0 a|n3|s2_y|s3_a|y
+ 234.635313975
* device instance a_n3_s2_y_s3_a_y_t1 r0 *1 0,0
Ra_n3_s2_y_s3_a_y_t1 a\x7cn3\x7cs2_y\x7cs3_a\x7cy__t1 a|n3|s2_y|s3_a|y
+ 225.155136025
* device instance a_n3_s2_y_s3_a_y_t2 r0 *1 0,0
Ra_n3_s2_y_s3_a_y_t2 a\x7cn3\x7cs2_y\x7cs3_a\x7cy__t2 a|n3|s2_y|s3_a|y
+ 225.155136025
* device instance a_n3_s2_y_s3_a_y_t3 r0 *1 0,0
Ra_n3_s2_y_s3_a_y_t3 a\x7cn3\x7cs2_y\x7cs3_a\x7cy__t3 a|n3|s2_y|s3_a|y
+ 234.635313975
* device instance a_n3_s2_y_s3_a_y r0 *1 0,0
Ca_n3_s2_y_s3_a_y a|n3|s2_y|s3_a|y vsubs 2.529995e-15
* device instance a_n3_s2_y_s3_a_y_dup1_t0 r0 *1 0,0
Ra_n3_s2_y_s3_a_y_dup1_t0 a\x7cn3\x7cs2_y\x7cs3_a\x7cy__t02 a|n3|s2_y|s3_a|y$1
+ 234.635313975
* device instance a_n3_s2_y_s3_a_y_dup1_t1 r0 *1 0,0
Ra_n3_s2_y_s3_a_y_dup1_t1 a\x7cn3\x7cs2_y\x7cs3_a\x7cy__t12 a|n3|s2_y|s3_a|y$1
+ 225.155136025
* device instance a_n3_s2_y_s3_a_y_dup1_t2 r0 *1 0,0
Ra_n3_s2_y_s3_a_y_dup1_t2 a\x7cn3\x7cs2_y\x7cs3_a\x7cy__t22 a|n3|s2_y|s3_a|y$1
+ 225.155136025
* device instance a_n3_s2_y_s3_a_y_dup1_t3 r0 *1 0,0
Ra_n3_s2_y_s3_a_y_dup1_t3 a\x7cn3\x7cs2_y\x7cs3_a\x7cy__t32 a|n3|s2_y|s3_a|y$1
+ 234.635313975
* device instance a_n3_s2_y_s3_a_y_dup1 r0 *1 0,0
Ca_n3_s2_y_s3_a_y_dup1 a|n3|s2_y|s3_a|y$1 vsubs 2.529995e-15
* device instance a_n3_s2_y_s3_a_y_dup2_t0 r0 *1 0,0
Ra_n3_s2_y_s3_a_y_dup2_t0 a\x7cn3\x7cs2_y\x7cs3_a\x7cy__t03 a|n3|s2_y|s3_a|y$2
+ 234.635313975
* device instance a_n3_s2_y_s3_a_y_dup2_t1 r0 *1 0,0
Ra_n3_s2_y_s3_a_y_dup2_t1 a\x7cn3\x7cs2_y\x7cs3_a\x7cy__t13 a|n3|s2_y|s3_a|y$2
+ 225.155136025
* device instance a_n3_s2_y_s3_a_y_dup2_t2 r0 *1 0,0
Ra_n3_s2_y_s3_a_y_dup2_t2 a\x7cn3\x7cs2_y\x7cs3_a\x7cy__t23 a|n3|s2_y|s3_a|y$2
+ 225.155136025
* device instance a_n3_s2_y_s3_a_y_dup2_t3 r0 *1 0,0
Ra_n3_s2_y_s3_a_y_dup2_t3 a\x7cn3\x7cs2_y\x7cs3_a\x7cy__t33 a|n3|s2_y|s3_a|y$2
+ 234.635313975
* device instance a_n3_s2_y_s3_a_y_dup2 r0 *1 0,0
Ca_n3_s2_y_s3_a_y_dup2 a|n3|s2_y|s3_a|y$2 vsubs 2.529995e-15
* device instance a_n3_s2_y_s3_a_y_dup3_t0 r0 *1 0,0
Ra_n3_s2_y_s3_a_y_dup3_t0 a\x7cn3\x7cs2_y\x7cs3_a\x7cy__t04 a|n3|s2_y|s3_a|y$3
+ 234.635313975
* device instance a_n3_s2_y_s3_a_y_dup3_t1 r0 *1 0,0
Ra_n3_s2_y_s3_a_y_dup3_t1 a\x7cn3\x7cs2_y\x7cs3_a\x7cy__t14 a|n3|s2_y|s3_a|y$3
+ 225.155136025
* device instance a_n3_s2_y_s3_a_y_dup3_t2 r0 *1 0,0
Ra_n3_s2_y_s3_a_y_dup3_t2 a\x7cn3\x7cs2_y\x7cs3_a\x7cy__t24 a|n3|s2_y|s3_a|y$3
+ 225.155136025
* device instance a_n3_s2_y_s3_a_y_dup3_t3 r0 *1 0,0
Ra_n3_s2_y_s3_a_y_dup3_t3 a\x7cn3\x7cs2_y\x7cs3_a\x7cy__t34 a|n3|s2_y|s3_a|y$3
+ 234.635313975
* device instance a_n3_s2_y_s3_a_y_dup3 r0 *1 0,0
Ca_n3_s2_y_s3_a_y_dup3 a|n3|s2_y|s3_a|y$3 vsubs 2.529995e-15
* device instance a_n4_s3_y_s4_a_y_t0 r0 *1 0,0
Ra_n4_s3_y_s4_a_y_t0 a\x7cn4\x7cs3_y\x7cs4_a\x7cy__t0 a|n4|s3_y|s4_a|y
+ 234.635313975
* device instance a_n4_s3_y_s4_a_y_t1 r0 *1 0,0
Ra_n4_s3_y_s4_a_y_t1 a\x7cn4\x7cs3_y\x7cs4_a\x7cy__t1 a|n4|s3_y|s4_a|y
+ 225.155136025
* device instance a_n4_s3_y_s4_a_y_t2 r0 *1 0,0
Ra_n4_s3_y_s4_a_y_t2 a\x7cn4\x7cs3_y\x7cs4_a\x7cy__t2 a|n4|s3_y|s4_a|y
+ 225.155136025
* device instance a_n4_s3_y_s4_a_y_t3 r0 *1 0,0
Ra_n4_s3_y_s4_a_y_t3 a\x7cn4\x7cs3_y\x7cs4_a\x7cy__t3 a|n4|s3_y|s4_a|y
+ 234.635313975
* device instance a_n4_s3_y_s4_a_y r0 *1 0,0
Ca_n4_s3_y_s4_a_y a|n4|s3_y|s4_a|y vsubs 2.529995e-15
* device instance a_n4_s3_y_s4_a_y_dup1_t0 r0 *1 0,0
Ra_n4_s3_y_s4_a_y_dup1_t0 a\x7cn4\x7cs3_y\x7cs4_a\x7cy__t02 a|n4|s3_y|s4_a|y$1
+ 234.635313975
* device instance a_n4_s3_y_s4_a_y_dup1_t1 r0 *1 0,0
Ra_n4_s3_y_s4_a_y_dup1_t1 a\x7cn4\x7cs3_y\x7cs4_a\x7cy__t12 a|n4|s3_y|s4_a|y$1
+ 225.155136025
* device instance a_n4_s3_y_s4_a_y_dup1_t2 r0 *1 0,0
Ra_n4_s3_y_s4_a_y_dup1_t2 a\x7cn4\x7cs3_y\x7cs4_a\x7cy__t22 a|n4|s3_y|s4_a|y$1
+ 225.155136025
* device instance a_n4_s3_y_s4_a_y_dup1_t3 r0 *1 0,0
Ra_n4_s3_y_s4_a_y_dup1_t3 a\x7cn4\x7cs3_y\x7cs4_a\x7cy__t32 a|n4|s3_y|s4_a|y$1
+ 234.635313975
* device instance a_n4_s3_y_s4_a_y_dup1 r0 *1 0,0
Ca_n4_s3_y_s4_a_y_dup1 a|n4|s3_y|s4_a|y$1 vsubs 2.529995e-15
* device instance a_n4_s3_y_s4_a_y_dup2_t0 r0 *1 0,0
Ra_n4_s3_y_s4_a_y_dup2_t0 a\x7cn4\x7cs3_y\x7cs4_a\x7cy__t03 a|n4|s3_y|s4_a|y$2
+ 234.635313975
* device instance a_n4_s3_y_s4_a_y_dup2_t1 r0 *1 0,0
Ra_n4_s3_y_s4_a_y_dup2_t1 a\x7cn4\x7cs3_y\x7cs4_a\x7cy__t13 a|n4|s3_y|s4_a|y$2
+ 225.155136025
* device instance a_n4_s3_y_s4_a_y_dup2_t2 r0 *1 0,0
Ra_n4_s3_y_s4_a_y_dup2_t2 a\x7cn4\x7cs3_y\x7cs4_a\x7cy__t23 a|n4|s3_y|s4_a|y$2
+ 225.155136025
* device instance a_n4_s3_y_s4_a_y_dup2_t3 r0 *1 0,0
Ra_n4_s3_y_s4_a_y_dup2_t3 a\x7cn4\x7cs3_y\x7cs4_a\x7cy__t33 a|n4|s3_y|s4_a|y$2
+ 234.635313975
* device instance a_n4_s3_y_s4_a_y_dup2 r0 *1 0,0
Ca_n4_s3_y_s4_a_y_dup2 a|n4|s3_y|s4_a|y$2 vsubs 2.529995e-15
* device instance a_n4_s3_y_s4_a_y_dup3_t0 r0 *1 0,0
Ra_n4_s3_y_s4_a_y_dup3_t0 a\x7cn4\x7cs3_y\x7cs4_a\x7cy__t04 a|n4|s3_y|s4_a|y$3
+ 234.635313975
* device instance a_n4_s3_y_s4_a_y_dup3_t1 r0 *1 0,0
Ra_n4_s3_y_s4_a_y_dup3_t1 a\x7cn4\x7cs3_y\x7cs4_a\x7cy__t14 a|n4|s3_y|s4_a|y$3
+ 225.155136025
* device instance a_n4_s3_y_s4_a_y_dup3_t2 r0 *1 0,0
Ra_n4_s3_y_s4_a_y_dup3_t2 a\x7cn4\x7cs3_y\x7cs4_a\x7cy__t24 a|n4|s3_y|s4_a|y$3
+ 225.155136025
* device instance a_n4_s3_y_s4_a_y_dup3_t3 r0 *1 0,0
Ra_n4_s3_y_s4_a_y_dup3_t3 a\x7cn4\x7cs3_y\x7cs4_a\x7cy__t34 a|n4|s3_y|s4_a|y$3
+ 234.635313975
* device instance a_n4_s3_y_s4_a_y_dup3 r0 *1 0,0
Ca_n4_s3_y_s4_a_y_dup3 a|n4|s3_y|s4_a|y$3 vsubs 2.529995e-15
* device instance bn_invb_y_mn34_g1_mp24_g1_y_t0 r0 *1 0,0
Rbn_invb_y_mn34_g1_mp24_g1_y_t0 bn\x7cinvb_y\x7cmn34_g1\x7cmp24_g1\x7cy__t0
+ bn|invb_y|mn34_g1|mp24_g1|y 198.995695593
* device instance bn_invb_y_mn34_g1_mp24_g1_y_t1 r0 *1 0,0
Rbn_invb_y_mn34_g1_mp24_g1_y_t1 bn\x7cinvb_y\x7cmn34_g1\x7cmp24_g1\x7cy__t1
+ bn|invb_y|mn34_g1|mp24_g1|y 176.037794575
* device instance bn_invb_y_mn34_g1_mp24_g1_y_t2 r0 *1 0,0
Rbn_invb_y_mn34_g1_mp24_g1_y_t2 bn\x7cinvb_y\x7cmn34_g1\x7cmp24_g1\x7cy__t2
+ bn|invb_y|mn34_g1|mp24_g1|y 186.809338642
* device instance bn_invb_y_mn34_g1_mp24_g1_y_t3 r0 *1 0,0
Rbn_invb_y_mn34_g1_mp24_g1_y_t3 bn\x7cinvb_y\x7cmn34_g1\x7cmp24_g1\x7cy__t3
+ bn|invb_y|mn34_g1|mp24_g1|y 315.14977119
* device instance bn_invb_y_mn34_g1_mp24_g1_y r0 *1 0,0
Cbn_invb_y_mn34_g1_mp24_g1_y bn|invb_y|mn34_g1|mp24_g1|y vsubs 5.127304e-15
* device instance bn_invb_y_mn34_g1_mp24_g1_y_dup1_t0 r0 *1 0,0
Rbn_invb_y_mn34_g1_mp24_g1_y_dup1_t0
+ bn\x7cinvb_y\x7cmn34_g1\x7cmp24_g1\x7cy__t02 bn|invb_y|mn34_g1|mp24_g1|y$1
+ 198.995695593
* device instance bn_invb_y_mn34_g1_mp24_g1_y_dup1_t1 r0 *1 0,0
Rbn_invb_y_mn34_g1_mp24_g1_y_dup1_t1
+ bn\x7cinvb_y\x7cmn34_g1\x7cmp24_g1\x7cy__t12 bn|invb_y|mn34_g1|mp24_g1|y$1
+ 176.037794575
* device instance bn_invb_y_mn34_g1_mp24_g1_y_dup1_t2 r0 *1 0,0
Rbn_invb_y_mn34_g1_mp24_g1_y_dup1_t2
+ bn\x7cinvb_y\x7cmn34_g1\x7cmp24_g1\x7cy__t22 bn|invb_y|mn34_g1|mp24_g1|y$1
+ 186.809338642
* device instance bn_invb_y_mn34_g1_mp24_g1_y_dup1_t3 r0 *1 0,0
Rbn_invb_y_mn34_g1_mp24_g1_y_dup1_t3
+ bn\x7cinvb_y\x7cmn34_g1\x7cmp24_g1\x7cy__t32 bn|invb_y|mn34_g1|mp24_g1|y$1
+ 315.14977119
* device instance bn_invb_y_mn34_g1_mp24_g1_y_dup1 r0 *1 0,0
Cbn_invb_y_mn34_g1_mp24_g1_y_dup1 bn|invb_y|mn34_g1|mp24_g1|y$1 vsubs
+ 5.127304e-15
* device instance bn_invb_y_mn34_g1_mp24_g1_y_dup2_t0 r0 *1 0,0
Rbn_invb_y_mn34_g1_mp24_g1_y_dup2_t0
+ bn\x7cinvb_y\x7cmn34_g1\x7cmp24_g1\x7cy__t03 bn|invb_y|mn34_g1|mp24_g1|y$2
+ 198.995695593
* device instance bn_invb_y_mn34_g1_mp24_g1_y_dup2_t1 r0 *1 0,0
Rbn_invb_y_mn34_g1_mp24_g1_y_dup2_t1
+ bn\x7cinvb_y\x7cmn34_g1\x7cmp24_g1\x7cy__t13 bn|invb_y|mn34_g1|mp24_g1|y$2
+ 176.037794575
* device instance bn_invb_y_mn34_g1_mp24_g1_y_dup2_t2 r0 *1 0,0
Rbn_invb_y_mn34_g1_mp24_g1_y_dup2_t2
+ bn\x7cinvb_y\x7cmn34_g1\x7cmp24_g1\x7cy__t23 bn|invb_y|mn34_g1|mp24_g1|y$2
+ 186.809338642
* device instance bn_invb_y_mn34_g1_mp24_g1_y_dup2_t3 r0 *1 0,0
Rbn_invb_y_mn34_g1_mp24_g1_y_dup2_t3
+ bn\x7cinvb_y\x7cmn34_g1\x7cmp24_g1\x7cy__t33 bn|invb_y|mn34_g1|mp24_g1|y$2
+ 315.14977119
* device instance bn_invb_y_mn34_g1_mp24_g1_y_dup2 r0 *1 0,0
Cbn_invb_y_mn34_g1_mp24_g1_y_dup2 bn|invb_y|mn34_g1|mp24_g1|y$2 vsubs
+ 5.126559e-15
* device instance en_en1_g_en_t0 r0 *1 0,0
Ren_en1_g_en_t0 en\x7cen1\x7cg_en__t0 en|en1|g_en 236.31895
* device instance en_en1_g_en_t1 r0 *1 0,0
Ren_en1_g_en_t1 en\x7cen1\x7cg_en__t1 en|en1|g_en 236.31895
* device instance en_en1_g_en r0 *1 0,0
Cen_en1_g_en en|en1|g_en vsubs 5.93421e-16
* device instance en_en2_g_en_t0 r0 *1 0,0
Ren_en2_g_en_t0 en\x7cen2\x7cg_en__t0 en|en2|g_en 236.31895
* device instance en_en2_g_en_t1 r0 *1 0,0
Ren_en2_g_en_t1 en\x7cen2\x7cg_en__t1 en|en2|g_en 236.31895
* device instance en_en2_g_en r0 *1 0,0
Cen_en2_g_en en|en2|g_en vsubs 5.93421e-16
* device instance en_en3_g_en_t0 r0 *1 0,0
Ren_en3_g_en_t0 en\x7cen3\x7cg_en__t0 en|en3|g_en 236.31895
* device instance en_en3_g_en_t1 r0 *1 0,0
Ren_en3_g_en_t1 en\x7cen3\x7cg_en__t1 en|en3|g_en 236.31895
* device instance en_en3_g_en r0 *1 0,0
Cen_en3_g_en en|en3|g_en vsubs 5.93421e-16
* device instance en_en4_g_en_t0 r0 *1 0,0
Ren_en4_g_en_t0 en\x7cen4\x7cg_en__t0 en|en4|g_en 236.31895
* device instance en_en4_g_en_t1 r0 *1 0,0
Ren_en4_g_en_t1 en\x7cen4\x7cg_en__t1 en|en4|g_en 236.31895
* device instance en_en4_g_en r0 *1 0,0
Cen_en4_g_en en|en4|g_en vsubs 5.93421e-16
* device instance g_vddr_m1_mnt_g_s1_vddr_m1_s2_vddr_m1_s3_vddr_m1_s4_vddr_m1_vddr_vddr1_t0 r0 *1 0,0
Rg_vddr_m1_mnt_g_s1_vddr_m1_s2_vddr_m1_s3_vddr_m1_s4_vddr_m1_vddr_vddr1_t0
+ g_vddr_m1\x7cmnt_g\x7cs1_vddr_m1\x7cs2_vddr_m1\x7cs3_vddr_m1\x7cs4_vddr_m1\x7cvddr\x7cvddr1__t0
+ g_vddr_m1|mnt_g|s1_vddr_m1|s2_vddr_m1|s3_vddr_m1|s4_vddr_m1|vddr|vddr1
+ 176.705854837
* device instance g_vddr_m1_mnt_g_s1_vddr_m1_s2_vddr_m1_s3_vddr_m1_s4_vddr_m1_vddr_vddr1_t1 r0 *1 0,0
Rg_vddr_m1_mnt_g_s1_vddr_m1_s2_vddr_m1_s3_vddr_m1_s4_vddr_m1_vddr_vddr1_t1
+ g_vddr_m1\x7cmnt_g\x7cs1_vddr_m1\x7cs2_vddr_m1\x7cs3_vddr_m1\x7cs4_vddr_m1\x7cvddr\x7cvddr1__t1
+ g_vddr_m1|mnt_g|s1_vddr_m1|s2_vddr_m1|s3_vddr_m1|s4_vddr_m1|vddr|vddr1
+ 174.772567871
* device instance g_vddr_m1_mnt_g_s1_vddr_m1_s2_vddr_m1_s3_vddr_m1_s4_vddr_m1_vddr_vddr1_t2 r0 *1 0,0
Rg_vddr_m1_mnt_g_s1_vddr_m1_s2_vddr_m1_s3_vddr_m1_s4_vddr_m1_vddr_vddr1_t2
+ g_vddr_m1\x7cmnt_g\x7cs1_vddr_m1\x7cs2_vddr_m1\x7cs3_vddr_m1\x7cs4_vddr_m1\x7cvddr\x7cvddr1__t2
+ g_vddr_m1|mnt_g|s1_vddr_m1|s2_vddr_m1|s3_vddr_m1|s4_vddr_m1|vddr|vddr1
+ 174.772567871
* device instance g_vddr_m1_mnt_g_s1_vddr_m1_s2_vddr_m1_s3_vddr_m1_s4_vddr_m1_vddr_vddr1_t3 r0 *1 0,0
Rg_vddr_m1_mnt_g_s1_vddr_m1_s2_vddr_m1_s3_vddr_m1_s4_vddr_m1_vddr_vddr1_t3
+ g_vddr_m1\x7cmnt_g\x7cs1_vddr_m1\x7cs2_vddr_m1\x7cs3_vddr_m1\x7cs4_vddr_m1\x7cvddr\x7cvddr1__t3
+ g_vddr_m1|mnt_g|s1_vddr_m1|s2_vddr_m1|s3_vddr_m1|s4_vddr_m1|vddr|vddr1
+ 152.713109213
* device instance g_vddr_m1_mnt_g_s1_vddr_m1_s2_vddr_m1_s3_vddr_m1_s4_vddr_m1_vddr_vddr1_t4 r0 *1 0,0
Rg_vddr_m1_mnt_g_s1_vddr_m1_s2_vddr_m1_s3_vddr_m1_s4_vddr_m1_vddr_vddr1_t4
+ g_vddr_m1\x7cmnt_g\x7cs1_vddr_m1\x7cs2_vddr_m1\x7cs3_vddr_m1\x7cs4_vddr_m1\x7cvddr\x7cvddr1__t4
+ g_vddr_m1|mnt_g|s1_vddr_m1|s2_vddr_m1|s3_vddr_m1|s4_vddr_m1|vddr|vddr1
+ 192.841625692
* device instance g_vddr_m1_mnt_g_s1_vddr_m1_s2_vddr_m1_s3_vddr_m1_s4_vddr_m1_vddr_vddr1_t5 r0 *1 0,0
Rg_vddr_m1_mnt_g_s1_vddr_m1_s2_vddr_m1_s3_vddr_m1_s4_vddr_m1_vddr_vddr1_t5
+ g_vddr_m1\x7cmnt_g\x7cs1_vddr_m1\x7cs2_vddr_m1\x7cs3_vddr_m1\x7cs4_vddr_m1\x7cvddr\x7cvddr1__t5
+ g_vddr_m1|mnt_g|s1_vddr_m1|s2_vddr_m1|s3_vddr_m1|s4_vddr_m1|vddr|vddr1
+ 109.575837063
* device instance g_vddr_m1_mnt_g_s1_vddr_m1_s2_vddr_m1_s3_vddr_m1_s4_vddr_m1_vddr_vddr1_t6 r0 *1 0,0
Rg_vddr_m1_mnt_g_s1_vddr_m1_s2_vddr_m1_s3_vddr_m1_s4_vddr_m1_vddr_vddr1_t6
+ g_vddr_m1\x7cmnt_g\x7cs1_vddr_m1\x7cs2_vddr_m1\x7cs3_vddr_m1\x7cs4_vddr_m1\x7cvddr\x7cvddr1__t6
+ g_vddr_m1|mnt_g|s1_vddr_m1|s2_vddr_m1|s3_vddr_m1|s4_vddr_m1|vddr|vddr1
+ 27.2150557571
* device instance g_vddr_m1_mnt_g_s1_vddr_m1_s2_vddr_m1_s3_vddr_m1_s4_vddr_m1_vddr_vddr1_t7 r0 *1 0,0
Rg_vddr_m1_mnt_g_s1_vddr_m1_s2_vddr_m1_s3_vddr_m1_s4_vddr_m1_vddr_vddr1_t7
+ g_vddr_m1\x7cmnt_g\x7cs1_vddr_m1\x7cs2_vddr_m1\x7cs3_vddr_m1\x7cs4_vddr_m1\x7cvddr\x7cvddr1__t7
+ g_vddr_m1|mnt_g|s1_vddr_m1|s2_vddr_m1|s3_vddr_m1|s4_vddr_m1|vddr|vddr1
+ 58.217507459
* device instance g_vddr_m1_mnt_g_s1_vddr_m1_s2_vddr_m1_s3_vddr_m1_s4_vddr_m1_vddr_vddr1_t8 r0 *1 0,0
Rg_vddr_m1_mnt_g_s1_vddr_m1_s2_vddr_m1_s3_vddr_m1_s4_vddr_m1_vddr_vddr1_t8
+ g_vddr_m1\x7cmnt_g\x7cs1_vddr_m1\x7cs2_vddr_m1\x7cs3_vddr_m1\x7cs4_vddr_m1\x7cvddr\x7cvddr1__t8
+ g_vddr_m1|mnt_g|s1_vddr_m1|s2_vddr_m1|s3_vddr_m1|s4_vddr_m1|vddr|vddr1
+ 139.573716122
* device instance g_vddr_m1_mnt_g_s1_vddr_m1_s2_vddr_m1_s3_vddr_m1_s4_vddr_m1_vddr_vddr1_t9 r0 *1 0,0
Rg_vddr_m1_mnt_g_s1_vddr_m1_s2_vddr_m1_s3_vddr_m1_s4_vddr_m1_vddr_vddr1_t9
+ g_vddr_m1\x7cmnt_g\x7cs1_vddr_m1\x7cs2_vddr_m1\x7cs3_vddr_m1\x7cs4_vddr_m1\x7cvddr\x7cvddr1__t9
+ g_vddr_m1|mnt_g|s1_vddr_m1|s2_vddr_m1|s3_vddr_m1|s4_vddr_m1|vddr|vddr1
+ 87.5707429456
* device instance g_vddr_m1_mnt_g_s1_vddr_m1_s2_vddr_m1_s3_vddr_m1_s4_vddr_m1_vddr_vddr1_t10 r0 *1 0,0
Rg_vddr_m1_mnt_g_s1_vddr_m1_s2_vddr_m1_s3_vddr_m1_s4_vddr_m1_vddr_vddr1_t10
+ g_vddr_m1\x7cmnt_g\x7cs1_vddr_m1\x7cs2_vddr_m1\x7cs3_vddr_m1\x7cs4_vddr_m1\x7cvddr\x7cvddr1__t10
+ g_vddr_m1|mnt_g|s1_vddr_m1|s2_vddr_m1|s3_vddr_m1|s4_vddr_m1|vddr|vddr1
+ 80.1325456503
* device instance g_vddr_m1_mnt_g_s1_vddr_m1_s2_vddr_m1_s3_vddr_m1_s4_vddr_m1_vddr_vddr1_t11 r0 *1 0,0
Rg_vddr_m1_mnt_g_s1_vddr_m1_s2_vddr_m1_s3_vddr_m1_s4_vddr_m1_vddr_vddr1_t11
+ g_vddr_m1\x7cmnt_g\x7cs1_vddr_m1\x7cs2_vddr_m1\x7cs3_vddr_m1\x7cs4_vddr_m1\x7cvddr\x7cvddr1__t11
+ g_vddr_m1|mnt_g|s1_vddr_m1|s2_vddr_m1|s3_vddr_m1|s4_vddr_m1|vddr|vddr1
+ 9.35511008331
* device instance g_vddr_m1_mnt_g_s1_vddr_m1_s2_vddr_m1_s3_vddr_m1_s4_vddr_m1_vddr_vddr1_t12 r0 *1 0,0
Rg_vddr_m1_mnt_g_s1_vddr_m1_s2_vddr_m1_s3_vddr_m1_s4_vddr_m1_vddr_vddr1_t12
+ g_vddr_m1\x7cmnt_g\x7cs1_vddr_m1\x7cs2_vddr_m1\x7cs3_vddr_m1\x7cs4_vddr_m1\x7cvddr\x7cvddr1__t12
+ g_vddr_m1|mnt_g|s1_vddr_m1|s2_vddr_m1|s3_vddr_m1|s4_vddr_m1|vddr|vddr1
+ 170.77639087
* device instance g_vddr_m1_mnt_g_s1_vddr_m1_s2_vddr_m1_s3_vddr_m1_s4_vddr_m1_vddr_vddr1_t13 r0 *1 0,0
Rg_vddr_m1_mnt_g_s1_vddr_m1_s2_vddr_m1_s3_vddr_m1_s4_vddr_m1_vddr_vddr1_t13
+ g_vddr_m1\x7cmnt_g\x7cs1_vddr_m1\x7cs2_vddr_m1\x7cs3_vddr_m1\x7cs4_vddr_m1\x7cvddr\x7cvddr1__t13
+ g_vddr_m1|mnt_g|s1_vddr_m1|s2_vddr_m1|s3_vddr_m1|s4_vddr_m1|vddr|vddr1
+ 87.5707429456
* device instance g_vddr_m1_mnt_g_s1_vddr_m1_s2_vddr_m1_s3_vddr_m1_s4_vddr_m1_vddr_vddr1_t14 r0 *1 0,0
Rg_vddr_m1_mnt_g_s1_vddr_m1_s2_vddr_m1_s3_vddr_m1_s4_vddr_m1_vddr_vddr1_t14
+ g_vddr_m1\x7cmnt_g\x7cs1_vddr_m1\x7cs2_vddr_m1\x7cs3_vddr_m1\x7cs4_vddr_m1\x7cvddr\x7cvddr1__t14
+ g_vddr_m1|mnt_g|s1_vddr_m1|s2_vddr_m1|s3_vddr_m1|s4_vddr_m1|vddr|vddr1
+ 80.1325456503
* device instance g_vddr_m1_mnt_g_s1_vddr_m1_s2_vddr_m1_s3_vddr_m1_s4_vddr_m1_vddr_vddr1_t15 r0 *1 0,0
Rg_vddr_m1_mnt_g_s1_vddr_m1_s2_vddr_m1_s3_vddr_m1_s4_vddr_m1_vddr_vddr1_t15
+ g_vddr_m1\x7cmnt_g\x7cs1_vddr_m1\x7cs2_vddr_m1\x7cs3_vddr_m1\x7cs4_vddr_m1\x7cvddr\x7cvddr1__t15
+ g_vddr_m1|mnt_g|s1_vddr_m1|s2_vddr_m1|s3_vddr_m1|s4_vddr_m1|vddr|vddr1
+ 9.35511008331
* device instance g_vddr_m1_mnt_g_s1_vddr_m1_s2_vddr_m1_s3_vddr_m1_s4_vddr_m1_vddr_vddr1_t16 r0 *1 0,0
Rg_vddr_m1_mnt_g_s1_vddr_m1_s2_vddr_m1_s3_vddr_m1_s4_vddr_m1_vddr_vddr1_t16
+ g_vddr_m1\x7cmnt_g\x7cs1_vddr_m1\x7cs2_vddr_m1\x7cs3_vddr_m1\x7cs4_vddr_m1\x7cvddr\x7cvddr1__t16
+ g_vddr_m1|mnt_g|s1_vddr_m1|s2_vddr_m1|s3_vddr_m1|s4_vddr_m1|vddr|vddr1
+ 170.77639087
* device instance g_vddr_m1_mnt_g_s1_vddr_m1_s2_vddr_m1_s3_vddr_m1_s4_vddr_m1_vddr_vddr1_t17 r0 *1 0,0
Rg_vddr_m1_mnt_g_s1_vddr_m1_s2_vddr_m1_s3_vddr_m1_s4_vddr_m1_vddr_vddr1_t17
+ g_vddr_m1\x7cmnt_g\x7cs1_vddr_m1\x7cs2_vddr_m1\x7cs3_vddr_m1\x7cs4_vddr_m1\x7cvddr\x7cvddr1__t17
+ g_vddr_m1|mnt_g|s1_vddr_m1|s2_vddr_m1|s3_vddr_m1|s4_vddr_m1|vddr|vddr1
+ 84.2658502947
* device instance g_vddr_m1_mnt_g_s1_vddr_m1_s2_vddr_m1_s3_vddr_m1_s4_vddr_m1_vddr_vddr1_t18 r0 *1 0,0
Rg_vddr_m1_mnt_g_s1_vddr_m1_s2_vddr_m1_s3_vddr_m1_s4_vddr_m1_vddr_vddr1_t18
+ g_vddr_m1\x7cmnt_g\x7cs1_vddr_m1\x7cs2_vddr_m1\x7cs3_vddr_m1\x7cs4_vddr_m1\x7cvddr\x7cvddr1__t18
+ g_vddr_m1|mnt_g|s1_vddr_m1|s2_vddr_m1|s3_vddr_m1|s4_vddr_m1|vddr|vddr1
+ 91.3681764814
* device instance g_vddr_m1_mnt_g_s1_vddr_m1_s2_vddr_m1_s3_vddr_m1_s4_vddr_m1_vddr_vddr1_t19 r0 *1 0,0
Rg_vddr_m1_mnt_g_s1_vddr_m1_s2_vddr_m1_s3_vddr_m1_s4_vddr_m1_vddr_vddr1_t19
+ g_vddr_m1\x7cmnt_g\x7cs1_vddr_m1\x7cs2_vddr_m1\x7cs3_vddr_m1\x7cs4_vddr_m1\x7cvddr\x7cvddr1__t19
+ g_vddr_m1|mnt_g|s1_vddr_m1|s2_vddr_m1|s3_vddr_m1|s4_vddr_m1|vddr|vddr1
+ 172.754404667
* device instance g_vddr_m1_mnt_g_s1_vddr_m1_s2_vddr_m1_s3_vddr_m1_s4_vddr_m1_vddr_vddr1_t20 r0 *1 0,0
Rg_vddr_m1_mnt_g_s1_vddr_m1_s2_vddr_m1_s3_vddr_m1_s4_vddr_m1_vddr_vddr1_t20
+ g_vddr_m1\x7cmnt_g\x7cs1_vddr_m1\x7cs2_vddr_m1\x7cs3_vddr_m1\x7cs4_vddr_m1\x7cvddr\x7cvddr1__t20
+ g_vddr_m1|mnt_g|s1_vddr_m1|s2_vddr_m1|s3_vddr_m1|s4_vddr_m1|vddr|vddr1
+ 27.6952475736
* device instance g_vddr_m1_mnt_g_s1_vddr_m1_s2_vddr_m1_s3_vddr_m1_s4_vddr_m1_vddr_vddr1 r0 *1 0,0
Cg_vddr_m1_mnt_g_s1_vddr_m1_s2_vddr_m1_s3_vddr_m1_s4_vddr_m1_vddr_vddr1
+ g_vddr_m1|mnt_g|s1_vddr_m1|s2_vddr_m1|s3_vddr_m1|s4_vddr_m1|vddr|vddr1 vsubs
+ 1.2363377e-14
* device instance g_vddr_m1_mnt_g_s1_vddr_m1_s2_vddr_m1_s3_vddr_m1_s4_vddr_m1_vddr_vddr2_t0 r0 *1 0,0
Rg_vddr_m1_mnt_g_s1_vddr_m1_s2_vddr_m1_s3_vddr_m1_s4_vddr_m1_vddr_vddr2_t0
+ g_vddr_m1\x7cmnt_g\x7cs1_vddr_m1\x7cs2_vddr_m1\x7cs3_vddr_m1\x7cs4_vddr_m1\x7cvddr\x7cvddr2__t0
+ g_vddr_m1|mnt_g|s1_vddr_m1|s2_vddr_m1|s3_vddr_m1|s4_vddr_m1|vddr|vddr2
+ 176.936070155
* device instance g_vddr_m1_mnt_g_s1_vddr_m1_s2_vddr_m1_s3_vddr_m1_s4_vddr_m1_vddr_vddr2_t1 r0 *1 0,0
Rg_vddr_m1_mnt_g_s1_vddr_m1_s2_vddr_m1_s3_vddr_m1_s4_vddr_m1_vddr_vddr2_t1
+ g_vddr_m1\x7cmnt_g\x7cs1_vddr_m1\x7cs2_vddr_m1\x7cs3_vddr_m1\x7cs4_vddr_m1\x7cvddr\x7cvddr2__t1
+ g_vddr_m1|mnt_g|s1_vddr_m1|s2_vddr_m1|s3_vddr_m1|s4_vddr_m1|vddr|vddr2
+ 175.00026447
* device instance g_vddr_m1_mnt_g_s1_vddr_m1_s2_vddr_m1_s3_vddr_m1_s4_vddr_m1_vddr_vddr2_t2 r0 *1 0,0
Rg_vddr_m1_mnt_g_s1_vddr_m1_s2_vddr_m1_s3_vddr_m1_s4_vddr_m1_vddr_vddr2_t2
+ g_vddr_m1\x7cmnt_g\x7cs1_vddr_m1\x7cs2_vddr_m1\x7cs3_vddr_m1\x7cs4_vddr_m1\x7cvddr\x7cvddr2__t2
+ g_vddr_m1|mnt_g|s1_vddr_m1|s2_vddr_m1|s3_vddr_m1|s4_vddr_m1|vddr|vddr2
+ 175.00026447
* device instance g_vddr_m1_mnt_g_s1_vddr_m1_s2_vddr_m1_s3_vddr_m1_s4_vddr_m1_vddr_vddr2_t3 r0 *1 0,0
Rg_vddr_m1_mnt_g_s1_vddr_m1_s2_vddr_m1_s3_vddr_m1_s4_vddr_m1_vddr_vddr2_t3
+ g_vddr_m1\x7cmnt_g\x7cs1_vddr_m1\x7cs2_vddr_m1\x7cs3_vddr_m1\x7cs4_vddr_m1\x7cvddr\x7cvddr2__t3
+ g_vddr_m1|mnt_g|s1_vddr_m1|s2_vddr_m1|s3_vddr_m1|s4_vddr_m1|vddr|vddr2
+ 170.998881184
* device instance g_vddr_m1_mnt_g_s1_vddr_m1_s2_vddr_m1_s3_vddr_m1_s4_vddr_m1_vddr_vddr2_t4 r0 *1 0,0
Rg_vddr_m1_mnt_g_s1_vddr_m1_s2_vddr_m1_s3_vddr_m1_s4_vddr_m1_vddr_vddr2_t4
+ g_vddr_m1\x7cmnt_g\x7cs1_vddr_m1\x7cs2_vddr_m1\x7cs3_vddr_m1\x7cs4_vddr_m1\x7cvddr\x7cvddr2__t4
+ g_vddr_m1|mnt_g|s1_vddr_m1|s2_vddr_m1|s3_vddr_m1|s4_vddr_m1|vddr|vddr2
+ 87.6848315616
* device instance g_vddr_m1_mnt_g_s1_vddr_m1_s2_vddr_m1_s3_vddr_m1_s4_vddr_m1_vddr_vddr2_t5 r0 *1 0,0
Rg_vddr_m1_mnt_g_s1_vddr_m1_s2_vddr_m1_s3_vddr_m1_s4_vddr_m1_vddr_vddr2_t5
+ g_vddr_m1\x7cmnt_g\x7cs1_vddr_m1\x7cs2_vddr_m1\x7cs3_vddr_m1\x7cs4_vddr_m1\x7cvddr\x7cvddr2__t5
+ g_vddr_m1|mnt_g|s1_vddr_m1|s2_vddr_m1|s3_vddr_m1|s4_vddr_m1|vddr|vddr2
+ 9.36729807585
* device instance g_vddr_m1_mnt_g_s1_vddr_m1_s2_vddr_m1_s3_vddr_m1_s4_vddr_m1_vddr_vddr2_t6 r0 *1 0,0
Rg_vddr_m1_mnt_g_s1_vddr_m1_s2_vddr_m1_s3_vddr_m1_s4_vddr_m1_vddr_vddr2_t6
+ g_vddr_m1\x7cmnt_g\x7cs1_vddr_m1\x7cs2_vddr_m1\x7cs3_vddr_m1\x7cs4_vddr_m1\x7cvddr\x7cvddr2__t6
+ g_vddr_m1|mnt_g|s1_vddr_m1|s2_vddr_m1|s3_vddr_m1|s4_vddr_m1|vddr|vddr2
+ 80.2369436595
* device instance g_vddr_m1_mnt_g_s1_vddr_m1_s2_vddr_m1_s3_vddr_m1_s4_vddr_m1_vddr_vddr2_t7 r0 *1 0,0
Rg_vddr_m1_mnt_g_s1_vddr_m1_s2_vddr_m1_s3_vddr_m1_s4_vddr_m1_vddr_vddr2_t7
+ g_vddr_m1\x7cmnt_g\x7cs1_vddr_m1\x7cs2_vddr_m1\x7cs3_vddr_m1\x7cs4_vddr_m1\x7cvddr\x7cvddr2__t7
+ g_vddr_m1|mnt_g|s1_vddr_m1|s2_vddr_m1|s3_vddr_m1|s4_vddr_m1|vddr|vddr2
+ 170.998881184
* device instance g_vddr_m1_mnt_g_s1_vddr_m1_s2_vddr_m1_s3_vddr_m1_s4_vddr_m1_vddr_vddr2_t8 r0 *1 0,0
Rg_vddr_m1_mnt_g_s1_vddr_m1_s2_vddr_m1_s3_vddr_m1_s4_vddr_m1_vddr_vddr2_t8
+ g_vddr_m1\x7cmnt_g\x7cs1_vddr_m1\x7cs2_vddr_m1\x7cs3_vddr_m1\x7cs4_vddr_m1\x7cvddr\x7cvddr2__t8
+ g_vddr_m1|mnt_g|s1_vddr_m1|s2_vddr_m1|s3_vddr_m1|s4_vddr_m1|vddr|vddr2
+ 87.6848315616
* device instance g_vddr_m1_mnt_g_s1_vddr_m1_s2_vddr_m1_s3_vddr_m1_s4_vddr_m1_vddr_vddr2_t9 r0 *1 0,0
Rg_vddr_m1_mnt_g_s1_vddr_m1_s2_vddr_m1_s3_vddr_m1_s4_vddr_m1_vddr_vddr2_t9
+ g_vddr_m1\x7cmnt_g\x7cs1_vddr_m1\x7cs2_vddr_m1\x7cs3_vddr_m1\x7cs4_vddr_m1\x7cvddr\x7cvddr2__t9
+ g_vddr_m1|mnt_g|s1_vddr_m1|s2_vddr_m1|s3_vddr_m1|s4_vddr_m1|vddr|vddr2
+ 9.36729807585
* device instance g_vddr_m1_mnt_g_s1_vddr_m1_s2_vddr_m1_s3_vddr_m1_s4_vddr_m1_vddr_vddr2_t10 r0 *1 0,0
Rg_vddr_m1_mnt_g_s1_vddr_m1_s2_vddr_m1_s3_vddr_m1_s4_vddr_m1_vddr_vddr2_t10
+ g_vddr_m1\x7cmnt_g\x7cs1_vddr_m1\x7cs2_vddr_m1\x7cs3_vddr_m1\x7cs4_vddr_m1\x7cvddr\x7cvddr2__t10
+ g_vddr_m1|mnt_g|s1_vddr_m1|s2_vddr_m1|s3_vddr_m1|s4_vddr_m1|vddr|vddr2
+ 80.2369436595
* device instance g_vddr_m1_mnt_g_s1_vddr_m1_s2_vddr_m1_s3_vddr_m1_s4_vddr_m1_vddr_vddr2_t11 r0 *1 0,0
Rg_vddr_m1_mnt_g_s1_vddr_m1_s2_vddr_m1_s3_vddr_m1_s4_vddr_m1_vddr_vddr2_t11
+ g_vddr_m1\x7cmnt_g\x7cs1_vddr_m1\x7cs2_vddr_m1\x7cs3_vddr_m1\x7cs4_vddr_m1\x7cvddr\x7cvddr2__t11
+ g_vddr_m1|mnt_g|s1_vddr_m1|s2_vddr_m1|s3_vddr_m1|s4_vddr_m1|vddr|vddr2
+ 193.092862959
* device instance g_vddr_m1_mnt_g_s1_vddr_m1_s2_vddr_m1_s3_vddr_m1_s4_vddr_m1_vddr_vddr2_t12 r0 *1 0,0
Rg_vddr_m1_mnt_g_s1_vddr_m1_s2_vddr_m1_s3_vddr_m1_s4_vddr_m1_vddr_vddr2_t12
+ g_vddr_m1\x7cmnt_g\x7cs1_vddr_m1\x7cs2_vddr_m1\x7cs3_vddr_m1\x7cs4_vddr_m1\x7cvddr\x7cvddr2__t12
+ g_vddr_m1|mnt_g|s1_vddr_m1|s2_vddr_m1|s3_vddr_m1|s4_vddr_m1|vddr|vddr2
+ 109.718594281
* device instance g_vddr_m1_mnt_g_s1_vddr_m1_s2_vddr_m1_s3_vddr_m1_s4_vddr_m1_vddr_vddr2_t13 r0 *1 0,0
Rg_vddr_m1_mnt_g_s1_vddr_m1_s2_vddr_m1_s3_vddr_m1_s4_vddr_m1_vddr_vddr2_t13
+ g_vddr_m1\x7cmnt_g\x7cs1_vddr_m1\x7cs2_vddr_m1\x7cs3_vddr_m1\x7cs4_vddr_m1\x7cvddr\x7cvddr2__t13
+ g_vddr_m1|mnt_g|s1_vddr_m1|s2_vddr_m1|s3_vddr_m1|s4_vddr_m1|vddr|vddr2
+ 27.250511983
* device instance g_vddr_m1_mnt_g_s1_vddr_m1_s2_vddr_m1_s3_vddr_m1_s4_vddr_m1_vddr_vddr2_t14 r0 *1 0,0
Rg_vddr_m1_mnt_g_s1_vddr_m1_s2_vddr_m1_s3_vddr_m1_s4_vddr_m1_vddr_vddr2_t14
+ g_vddr_m1\x7cmnt_g\x7cs1_vddr_m1\x7cs2_vddr_m1\x7cs3_vddr_m1\x7cs4_vddr_m1\x7cvddr\x7cvddr2__t14
+ g_vddr_m1|mnt_g|s1_vddr_m1|s2_vddr_m1|s3_vddr_m1|s4_vddr_m1|vddr|vddr2
+ 58.2933541931
* device instance g_vddr_m1_mnt_g_s1_vddr_m1_s2_vddr_m1_s3_vddr_m1_s4_vddr_m1_vddr_vddr2_t15 r0 *1 0,0
Rg_vddr_m1_mnt_g_s1_vddr_m1_s2_vddr_m1_s3_vddr_m1_s4_vddr_m1_vddr_vddr2_t15
+ g_vddr_m1\x7cmnt_g\x7cs1_vddr_m1\x7cs2_vddr_m1\x7cs3_vddr_m1\x7cs4_vddr_m1\x7cvddr\x7cvddr2__t15
+ g_vddr_m1|mnt_g|s1_vddr_m1|s2_vddr_m1|s3_vddr_m1|s4_vddr_m1|vddr|vddr2
+ 139.755555074
* device instance g_vddr_m1_mnt_g_s1_vddr_m1_s2_vddr_m1_s3_vddr_m1_s4_vddr_m1_vddr_vddr2_t16 r0 *1 0,0
Rg_vddr_m1_mnt_g_s1_vddr_m1_s2_vddr_m1_s3_vddr_m1_s4_vddr_m1_vddr_vddr2_t16
+ g_vddr_m1\x7cmnt_g\x7cs1_vddr_m1\x7cs2_vddr_m1\x7cs3_vddr_m1\x7cs4_vddr_m1\x7cvddr\x7cvddr2__t16
+ g_vddr_m1|mnt_g|s1_vddr_m1|s2_vddr_m1|s3_vddr_m1|s4_vddr_m1|vddr|vddr2
+ 152.912066384
* device instance g_vddr_m1_mnt_g_s1_vddr_m1_s2_vddr_m1_s3_vddr_m1_s4_vddr_m1_vddr_vddr2_t17 r0 *1 0,0
Rg_vddr_m1_mnt_g_s1_vddr_m1_s2_vddr_m1_s3_vddr_m1_s4_vddr_m1_vddr_vddr2_t17
+ g_vddr_m1\x7cmnt_g\x7cs1_vddr_m1\x7cs2_vddr_m1\x7cs3_vddr_m1\x7cs4_vddr_m1\x7cvddr\x7cvddr2__t17
+ g_vddr_m1|mnt_g|s1_vddr_m1|s2_vddr_m1|s3_vddr_m1|s4_vddr_m1|vddr|vddr2
+ 172.97947197
* device instance g_vddr_m1_mnt_g_s1_vddr_m1_s2_vddr_m1_s3_vddr_m1_s4_vddr_m1_vddr_vddr2_t18 r0 *1 0,0
Rg_vddr_m1_mnt_g_s1_vddr_m1_s2_vddr_m1_s3_vddr_m1_s4_vddr_m1_vddr_vddr2_t18
+ g_vddr_m1\x7cmnt_g\x7cs1_vddr_m1\x7cs2_vddr_m1\x7cs3_vddr_m1\x7cs4_vddr_m1\x7cvddr\x7cvddr2__t18
+ g_vddr_m1|mnt_g|s1_vddr_m1|s2_vddr_m1|s3_vddr_m1|s4_vddr_m1|vddr|vddr2
+ 91.4872124567
* device instance g_vddr_m1_mnt_g_s1_vddr_m1_s2_vddr_m1_s3_vddr_m1_s4_vddr_m1_vddr_vddr2_t19 r0 *1 0,0
Rg_vddr_m1_mnt_g_s1_vddr_m1_s2_vddr_m1_s3_vddr_m1_s4_vddr_m1_vddr_vddr2_t19
+ g_vddr_m1\x7cmnt_g\x7cs1_vddr_m1\x7cs2_vddr_m1\x7cs3_vddr_m1\x7cs4_vddr_m1\x7cvddr\x7cvddr2__t19
+ g_vddr_m1|mnt_g|s1_vddr_m1|s2_vddr_m1|s3_vddr_m1|s4_vddr_m1|vddr|vddr2
+ 27.7313294014
* device instance g_vddr_m1_mnt_g_s1_vddr_m1_s2_vddr_m1_s3_vddr_m1_s4_vddr_m1_vddr_vddr2_t20 r0 *1 0,0
Rg_vddr_m1_mnt_g_s1_vddr_m1_s2_vddr_m1_s3_vddr_m1_s4_vddr_m1_vddr_vddr2_t20
+ g_vddr_m1\x7cmnt_g\x7cs1_vddr_m1\x7cs2_vddr_m1\x7cs3_vddr_m1\x7cs4_vddr_m1\x7cvddr\x7cvddr2__t20
+ g_vddr_m1|mnt_g|s1_vddr_m1|s2_vddr_m1|s3_vddr_m1|s4_vddr_m1|vddr|vddr2
+ 84.3756332417
* device instance g_vddr_m1_mnt_g_s1_vddr_m1_s2_vddr_m1_s3_vddr_m1_s4_vddr_m1_vddr_vddr2 r0 *1 0,0
Cg_vddr_m1_mnt_g_s1_vddr_m1_s2_vddr_m1_s3_vddr_m1_s4_vddr_m1_vddr_vddr2
+ g_vddr_m1|mnt_g|s1_vddr_m1|s2_vddr_m1|s3_vddr_m1|s4_vddr_m1|vddr|vddr2 vsubs
+ 1.2368661e-14
* device instance g_vddr_m1_mnt_g_s1_vddr_m1_s2_vddr_m1_s3_vddr_m1_s4_vddr_m1_vddr_vddr3_t0 r0 *1 0,0
Rg_vddr_m1_mnt_g_s1_vddr_m1_s2_vddr_m1_s3_vddr_m1_s4_vddr_m1_vddr_vddr3_t0
+ g_vddr_m1\x7cmnt_g\x7cs1_vddr_m1\x7cs2_vddr_m1\x7cs3_vddr_m1\x7cs4_vddr_m1\x7cvddr\x7cvddr3__t0
+ g_vddr_m1|mnt_g|s1_vddr_m1|s2_vddr_m1|s3_vddr_m1|s4_vddr_m1|vddr|vddr3
+ 177.166308742
* device instance g_vddr_m1_mnt_g_s1_vddr_m1_s2_vddr_m1_s3_vddr_m1_s4_vddr_m1_vddr_vddr3_t1 r0 *1 0,0
Rg_vddr_m1_mnt_g_s1_vddr_m1_s2_vddr_m1_s3_vddr_m1_s4_vddr_m1_vddr_vddr3_t1
+ g_vddr_m1\x7cmnt_g\x7cs1_vddr_m1\x7cs2_vddr_m1\x7cs3_vddr_m1\x7cs4_vddr_m1\x7cvddr\x7cvddr3__t1
+ g_vddr_m1|mnt_g|s1_vddr_m1|s2_vddr_m1|s3_vddr_m1|s4_vddr_m1|vddr|vddr3
+ 175.227984085
* device instance g_vddr_m1_mnt_g_s1_vddr_m1_s2_vddr_m1_s3_vddr_m1_s4_vddr_m1_vddr_vddr3_t2 r0 *1 0,0
Rg_vddr_m1_mnt_g_s1_vddr_m1_s2_vddr_m1_s3_vddr_m1_s4_vddr_m1_vddr_vddr3_t2
+ g_vddr_m1\x7cmnt_g\x7cs1_vddr_m1\x7cs2_vddr_m1\x7cs3_vddr_m1\x7cs4_vddr_m1\x7cvddr\x7cvddr3__t2
+ g_vddr_m1|mnt_g|s1_vddr_m1|s2_vddr_m1|s3_vddr_m1|s4_vddr_m1|vddr|vddr3
+ 175.227984085
* device instance g_vddr_m1_mnt_g_s1_vddr_m1_s2_vddr_m1_s3_vddr_m1_s4_vddr_m1_vddr_vddr3_t3 r0 *1 0,0
Rg_vddr_m1_mnt_g_s1_vddr_m1_s2_vddr_m1_s3_vddr_m1_s4_vddr_m1_vddr_vddr3_t3
+ g_vddr_m1\x7cmnt_g\x7cs1_vddr_m1\x7cs2_vddr_m1\x7cs3_vddr_m1\x7cs4_vddr_m1\x7cvddr\x7cvddr3__t3
+ g_vddr_m1|mnt_g|s1_vddr_m1|s2_vddr_m1|s3_vddr_m1|s4_vddr_m1|vddr|vddr3
+ 9.37948730032
* device instance g_vddr_m1_mnt_g_s1_vddr_m1_s2_vddr_m1_s3_vddr_m1_s4_vddr_m1_vddr_vddr3_t4 r0 *1 0,0
Rg_vddr_m1_mnt_g_s1_vddr_m1_s2_vddr_m1_s3_vddr_m1_s4_vddr_m1_vddr_vddr3_t4
+ g_vddr_m1\x7cmnt_g\x7cs1_vddr_m1\x7cs2_vddr_m1\x7cs3_vddr_m1\x7cs4_vddr_m1\x7cvddr\x7cvddr3__t4
+ g_vddr_m1|mnt_g|s1_vddr_m1|s2_vddr_m1|s3_vddr_m1|s4_vddr_m1|vddr|vddr3
+ 171.221393986
* device instance g_vddr_m1_mnt_g_s1_vddr_m1_s2_vddr_m1_s3_vddr_m1_s4_vddr_m1_vddr_vddr3_t5 r0 *1 0,0
Rg_vddr_m1_mnt_g_s1_vddr_m1_s2_vddr_m1_s3_vddr_m1_s4_vddr_m1_vddr_vddr3_t5
+ g_vddr_m1\x7cmnt_g\x7cs1_vddr_m1\x7cs2_vddr_m1\x7cs3_vddr_m1\x7cs4_vddr_m1\x7cvddr\x7cvddr3__t5
+ g_vddr_m1|mnt_g|s1_vddr_m1|s2_vddr_m1|s3_vddr_m1|s4_vddr_m1|vddr|vddr3
+ 87.7989317094
* device instance g_vddr_m1_mnt_g_s1_vddr_m1_s2_vddr_m1_s3_vddr_m1_s4_vddr_m1_vddr_vddr3_t6 r0 *1 0,0
Rg_vddr_m1_mnt_g_s1_vddr_m1_s2_vddr_m1_s3_vddr_m1_s4_vddr_m1_vddr_vddr3_t6
+ g_vddr_m1\x7cmnt_g\x7cs1_vddr_m1\x7cs2_vddr_m1\x7cs3_vddr_m1\x7cs4_vddr_m1\x7cvddr\x7cvddr3__t6
+ g_vddr_m1|mnt_g|s1_vddr_m1|s2_vddr_m1|s3_vddr_m1|s4_vddr_m1|vddr|vddr3
+ 80.341352221
* device instance g_vddr_m1_mnt_g_s1_vddr_m1_s2_vddr_m1_s3_vddr_m1_s4_vddr_m1_vddr_vddr3_t7 r0 *1 0,0
Rg_vddr_m1_mnt_g_s1_vddr_m1_s2_vddr_m1_s3_vddr_m1_s4_vddr_m1_vddr_vddr3_t7
+ g_vddr_m1\x7cmnt_g\x7cs1_vddr_m1\x7cs2_vddr_m1\x7cs3_vddr_m1\x7cs4_vddr_m1\x7cvddr\x7cvddr3__t7
+ g_vddr_m1|mnt_g|s1_vddr_m1|s2_vddr_m1|s3_vddr_m1|s4_vddr_m1|vddr|vddr3
+ 9.37948730032
* device instance g_vddr_m1_mnt_g_s1_vddr_m1_s2_vddr_m1_s3_vddr_m1_s4_vddr_m1_vddr_vddr3_t8 r0 *1 0,0
Rg_vddr_m1_mnt_g_s1_vddr_m1_s2_vddr_m1_s3_vddr_m1_s4_vddr_m1_vddr_vddr3_t8
+ g_vddr_m1\x7cmnt_g\x7cs1_vddr_m1\x7cs2_vddr_m1\x7cs3_vddr_m1\x7cs4_vddr_m1\x7cvddr\x7cvddr3__t8
+ g_vddr_m1|mnt_g|s1_vddr_m1|s2_vddr_m1|s3_vddr_m1|s4_vddr_m1|vddr|vddr3
+ 171.221393986
* device instance g_vddr_m1_mnt_g_s1_vddr_m1_s2_vddr_m1_s3_vddr_m1_s4_vddr_m1_vddr_vddr3_t9 r0 *1 0,0
Rg_vddr_m1_mnt_g_s1_vddr_m1_s2_vddr_m1_s3_vddr_m1_s4_vddr_m1_vddr_vddr3_t9
+ g_vddr_m1\x7cmnt_g\x7cs1_vddr_m1\x7cs2_vddr_m1\x7cs3_vddr_m1\x7cs4_vddr_m1\x7cvddr\x7cvddr3__t9
+ g_vddr_m1|mnt_g|s1_vddr_m1|s2_vddr_m1|s3_vddr_m1|s4_vddr_m1|vddr|vddr3
+ 87.7989317094
* device instance g_vddr_m1_mnt_g_s1_vddr_m1_s2_vddr_m1_s3_vddr_m1_s4_vddr_m1_vddr_vddr3_t10 r0 *1 0,0
Rg_vddr_m1_mnt_g_s1_vddr_m1_s2_vddr_m1_s3_vddr_m1_s4_vddr_m1_vddr_vddr3_t10
+ g_vddr_m1\x7cmnt_g\x7cs1_vddr_m1\x7cs2_vddr_m1\x7cs3_vddr_m1\x7cs4_vddr_m1\x7cvddr\x7cvddr3__t10
+ g_vddr_m1|mnt_g|s1_vddr_m1|s2_vddr_m1|s3_vddr_m1|s4_vddr_m1|vddr|vddr3
+ 80.341352221
* device instance g_vddr_m1_mnt_g_s1_vddr_m1_s2_vddr_m1_s3_vddr_m1_s4_vddr_m1_vddr_vddr3_t11 r0 *1 0,0
Rg_vddr_m1_mnt_g_s1_vddr_m1_s2_vddr_m1_s3_vddr_m1_s4_vddr_m1_vddr_vddr3_t11
+ g_vddr_m1\x7cmnt_g\x7cs1_vddr_m1\x7cs2_vddr_m1\x7cs3_vddr_m1\x7cs4_vddr_m1\x7cvddr\x7cvddr3__t11
+ g_vddr_m1|mnt_g|s1_vddr_m1|s2_vddr_m1|s3_vddr_m1|s4_vddr_m1|vddr|vddr3
+ 109.861365928
* device instance g_vddr_m1_mnt_g_s1_vddr_m1_s2_vddr_m1_s3_vddr_m1_s4_vddr_m1_vddr_vddr3_t12 r0 *1 0,0
Rg_vddr_m1_mnt_g_s1_vddr_m1_s2_vddr_m1_s3_vddr_m1_s4_vddr_m1_vddr_vddr3_t12
+ g_vddr_m1\x7cmnt_g\x7cs1_vddr_m1\x7cs2_vddr_m1\x7cs3_vddr_m1\x7cs4_vddr_m1\x7cvddr\x7cvddr3__t12
+ g_vddr_m1|mnt_g|s1_vddr_m1|s2_vddr_m1|s3_vddr_m1|s4_vddr_m1|vddr|vddr3
+ 27.2859717928
* device instance g_vddr_m1_mnt_g_s1_vddr_m1_s2_vddr_m1_s3_vddr_m1_s4_vddr_m1_vddr_vddr3_t13 r0 *1 0,0
Rg_vddr_m1_mnt_g_s1_vddr_m1_s2_vddr_m1_s3_vddr_m1_s4_vddr_m1_vddr_vddr3_t13
+ g_vddr_m1\x7cmnt_g\x7cs1_vddr_m1\x7cs2_vddr_m1\x7cs3_vddr_m1\x7cs4_vddr_m1\x7cvddr\x7cvddr3__t13
+ g_vddr_m1|mnt_g|s1_vddr_m1|s2_vddr_m1|s3_vddr_m1|s4_vddr_m1|vddr|vddr3
+ 58.3692085936
* device instance g_vddr_m1_mnt_g_s1_vddr_m1_s2_vddr_m1_s3_vddr_m1_s4_vddr_m1_vddr_vddr3_t14 r0 *1 0,0
Rg_vddr_m1_mnt_g_s1_vddr_m1_s2_vddr_m1_s3_vddr_m1_s4_vddr_m1_vddr_vddr3_t14
+ g_vddr_m1\x7cmnt_g\x7cs1_vddr_m1\x7cs2_vddr_m1\x7cs3_vddr_m1\x7cs4_vddr_m1\x7cvddr\x7cvddr3__t14
+ g_vddr_m1|mnt_g|s1_vddr_m1|s2_vddr_m1|s3_vddr_m1|s4_vddr_m1|vddr|vddr3
+ 139.937412406
* device instance g_vddr_m1_mnt_g_s1_vddr_m1_s2_vddr_m1_s3_vddr_m1_s4_vddr_m1_vddr_vddr3_t15 r0 *1 0,0
Rg_vddr_m1_mnt_g_s1_vddr_m1_s2_vddr_m1_s3_vddr_m1_s4_vddr_m1_vddr_vddr3_t15
+ g_vddr_m1\x7cmnt_g\x7cs1_vddr_m1\x7cs2_vddr_m1\x7cs3_vddr_m1\x7cs4_vddr_m1\x7cvddr\x7cvddr3__t15
+ g_vddr_m1|mnt_g|s1_vddr_m1|s2_vddr_m1|s3_vddr_m1|s4_vddr_m1|vddr|vddr3
+ 153.111043665
* device instance g_vddr_m1_mnt_g_s1_vddr_m1_s2_vddr_m1_s3_vddr_m1_s4_vddr_m1_vddr_vddr3_t16 r0 *1 0,0
Rg_vddr_m1_mnt_g_s1_vddr_m1_s2_vddr_m1_s3_vddr_m1_s4_vddr_m1_vddr_vddr3_t16
+ g_vddr_m1\x7cmnt_g\x7cs1_vddr_m1\x7cs2_vddr_m1\x7cs3_vddr_m1\x7cs4_vddr_m1\x7cvddr\x7cvddr3__t16
+ g_vddr_m1|mnt_g|s1_vddr_m1|s2_vddr_m1|s3_vddr_m1|s4_vddr_m1|vddr|vddr3
+ 193.344125621
* device instance g_vddr_m1_mnt_g_s1_vddr_m1_s2_vddr_m1_s3_vddr_m1_s4_vddr_m1_vddr_vddr3_t17 r0 *1 0,0
Rg_vddr_m1_mnt_g_s1_vddr_m1_s2_vddr_m1_s3_vddr_m1_s4_vddr_m1_vddr_vddr3_t17
+ g_vddr_m1\x7cmnt_g\x7cs1_vddr_m1\x7cs2_vddr_m1\x7cs3_vddr_m1\x7cs4_vddr_m1\x7cvddr\x7cvddr3__t17
+ g_vddr_m1|mnt_g|s1_vddr_m1|s2_vddr_m1|s3_vddr_m1|s4_vddr_m1|vddr|vddr3
+ 91.606260464
* device instance g_vddr_m1_mnt_g_s1_vddr_m1_s2_vddr_m1_s3_vddr_m1_s4_vddr_m1_vddr_vddr3_t18 r0 *1 0,0
Rg_vddr_m1_mnt_g_s1_vddr_m1_s2_vddr_m1_s3_vddr_m1_s4_vddr_m1_vddr_vddr3_t18
+ g_vddr_m1\x7cmnt_g\x7cs1_vddr_m1\x7cs2_vddr_m1\x7cs3_vddr_m1\x7cs4_vddr_m1\x7cvddr\x7cvddr3__t18
+ g_vddr_m1|mnt_g|s1_vddr_m1|s2_vddr_m1|s3_vddr_m1|s4_vddr_m1|vddr|vddr3
+ 173.204562023
* device instance g_vddr_m1_mnt_g_s1_vddr_m1_s2_vddr_m1_s3_vddr_m1_s4_vddr_m1_vddr_vddr3_t19 r0 *1 0,0
Rg_vddr_m1_mnt_g_s1_vddr_m1_s2_vddr_m1_s3_vddr_m1_s4_vddr_m1_vddr_vddr3_t19
+ g_vddr_m1\x7cmnt_g\x7cs1_vddr_m1\x7cs2_vddr_m1\x7cs3_vddr_m1\x7cs4_vddr_m1\x7cvddr\x7cvddr3__t19
+ g_vddr_m1|mnt_g|s1_vddr_m1|s2_vddr_m1|s3_vddr_m1|s4_vddr_m1|vddr|vddr3
+ 27.7674148762
* device instance g_vddr_m1_mnt_g_s1_vddr_m1_s2_vddr_m1_s3_vddr_m1_s4_vddr_m1_vddr_vddr3_t20 r0 *1 0,0
Rg_vddr_m1_mnt_g_s1_vddr_m1_s2_vddr_m1_s3_vddr_m1_s4_vddr_m1_vddr_vddr3_t20
+ g_vddr_m1\x7cmnt_g\x7cs1_vddr_m1\x7cs2_vddr_m1\x7cs3_vddr_m1\x7cs4_vddr_m1\x7cvddr\x7cvddr3__t20
+ g_vddr_m1|mnt_g|s1_vddr_m1|s2_vddr_m1|s3_vddr_m1|s4_vddr_m1|vddr|vddr3
+ 84.4854272854
* device instance g_vddr_m1_mnt_g_s1_vddr_m1_s2_vddr_m1_s3_vddr_m1_s4_vddr_m1_vddr_vddr3 r0 *1 0,0
Cg_vddr_m1_mnt_g_s1_vddr_m1_s2_vddr_m1_s3_vddr_m1_s4_vddr_m1_vddr_vddr3
+ g_vddr_m1|mnt_g|s1_vddr_m1|s2_vddr_m1|s3_vddr_m1|s4_vddr_m1|vddr|vddr3 vsubs
+ 1.2373945e-14
* device instance g_vddr_m1_mnt_g_s1_vddr_m1_s2_vddr_m1_s3_vddr_m1_s4_vddr_m1_vddr_vddr4_t0 r0 *1 0,0
Rg_vddr_m1_mnt_g_s1_vddr_m1_s2_vddr_m1_s3_vddr_m1_s4_vddr_m1_vddr_vddr4_t0
+ g_vddr_m1\x7cmnt_g\x7cs1_vddr_m1\x7cs2_vddr_m1\x7cs3_vddr_m1\x7cs4_vddr_m1\x7cvddr\x7cvddr4__t0
+ g_vddr_m1|mnt_g|s1_vddr_m1|s2_vddr_m1|s3_vddr_m1|s4_vddr_m1|vddr|vddr4
+ 177.3965706
* device instance g_vddr_m1_mnt_g_s1_vddr_m1_s2_vddr_m1_s3_vddr_m1_s4_vddr_m1_vddr_vddr4_t1 r0 *1 0,0
Rg_vddr_m1_mnt_g_s1_vddr_m1_s2_vddr_m1_s3_vddr_m1_s4_vddr_m1_vddr_vddr4_t1
+ g_vddr_m1\x7cmnt_g\x7cs1_vddr_m1\x7cs2_vddr_m1\x7cs3_vddr_m1\x7cs4_vddr_m1\x7cvddr\x7cvddr4__t1
+ g_vddr_m1|mnt_g|s1_vddr_m1|s2_vddr_m1|s3_vddr_m1|s4_vddr_m1|vddr|vddr4
+ 175.455726715
* device instance g_vddr_m1_mnt_g_s1_vddr_m1_s2_vddr_m1_s3_vddr_m1_s4_vddr_m1_vddr_vddr4_t2 r0 *1 0,0
Rg_vddr_m1_mnt_g_s1_vddr_m1_s2_vddr_m1_s3_vddr_m1_s4_vddr_m1_vddr_vddr4_t2
+ g_vddr_m1\x7cmnt_g\x7cs1_vddr_m1\x7cs2_vddr_m1\x7cs3_vddr_m1\x7cs4_vddr_m1\x7cvddr\x7cvddr4__t2
+ g_vddr_m1|mnt_g|s1_vddr_m1|s2_vddr_m1|s3_vddr_m1|s4_vddr_m1|vddr|vddr4
+ 175.455726715
* device instance g_vddr_m1_mnt_g_s1_vddr_m1_s2_vddr_m1_s3_vddr_m1_s4_vddr_m1_vddr_vddr4_t3 r0 *1 0,0
Rg_vddr_m1_mnt_g_s1_vddr_m1_s2_vddr_m1_s3_vddr_m1_s4_vddr_m1_vddr_vddr4_t3
+ g_vddr_m1\x7cmnt_g\x7cs1_vddr_m1\x7cs2_vddr_m1\x7cs3_vddr_m1\x7cs4_vddr_m1\x7cvddr\x7cvddr4__t3
+ g_vddr_m1|mnt_g|s1_vddr_m1|s2_vddr_m1|s3_vddr_m1|s4_vddr_m1|vddr|vddr4
+ 171.443929278
* device instance g_vddr_m1_mnt_g_s1_vddr_m1_s2_vddr_m1_s3_vddr_m1_s4_vddr_m1_vddr_vddr4_t4 r0 *1 0,0
Rg_vddr_m1_mnt_g_s1_vddr_m1_s2_vddr_m1_s3_vddr_m1_s4_vddr_m1_vddr_vddr4_t4
+ g_vddr_m1\x7cmnt_g\x7cs1_vddr_m1\x7cs2_vddr_m1\x7cs3_vddr_m1\x7cs4_vddr_m1\x7cvddr\x7cvddr4__t4
+ g_vddr_m1|mnt_g|s1_vddr_m1|s2_vddr_m1|s3_vddr_m1|s4_vddr_m1|vddr|vddr4
+ 87.9130433891
* device instance g_vddr_m1_mnt_g_s1_vddr_m1_s2_vddr_m1_s3_vddr_m1_s4_vddr_m1_vddr_vddr4_t5 r0 *1 0,0
Rg_vddr_m1_mnt_g_s1_vddr_m1_s2_vddr_m1_s3_vddr_m1_s4_vddr_m1_vddr_vddr4_t5
+ g_vddr_m1\x7cmnt_g\x7cs1_vddr_m1\x7cs2_vddr_m1\x7cs3_vddr_m1\x7cs4_vddr_m1\x7cvddr\x7cvddr4__t5
+ g_vddr_m1|mnt_g|s1_vddr_m1|s2_vddr_m1|s3_vddr_m1|s4_vddr_m1|vddr|vddr4
+ 9.39167775674
* device instance g_vddr_m1_mnt_g_s1_vddr_m1_s2_vddr_m1_s3_vddr_m1_s4_vddr_m1_vddr_vddr4_t6 r0 *1 0,0
Rg_vddr_m1_mnt_g_s1_vddr_m1_s2_vddr_m1_s3_vddr_m1_s4_vddr_m1_vddr_vddr4_t6
+ g_vddr_m1\x7cmnt_g\x7cs1_vddr_m1\x7cs2_vddr_m1\x7cs3_vddr_m1\x7cs4_vddr_m1\x7cvddr\x7cvddr4__t6
+ g_vddr_m1|mnt_g|s1_vddr_m1|s2_vddr_m1|s3_vddr_m1|s4_vddr_m1|vddr|vddr4
+ 80.4457713349
* device instance g_vddr_m1_mnt_g_s1_vddr_m1_s2_vddr_m1_s3_vddr_m1_s4_vddr_m1_vddr_vddr4_t7 r0 *1 0,0
Rg_vddr_m1_mnt_g_s1_vddr_m1_s2_vddr_m1_s3_vddr_m1_s4_vddr_m1_vddr_vddr4_t7
+ g_vddr_m1\x7cmnt_g\x7cs1_vddr_m1\x7cs2_vddr_m1\x7cs3_vddr_m1\x7cs4_vddr_m1\x7cvddr\x7cvddr4__t7
+ g_vddr_m1|mnt_g|s1_vddr_m1|s2_vddr_m1|s3_vddr_m1|s4_vddr_m1|vddr|vddr4
+ 171.443929278
* device instance g_vddr_m1_mnt_g_s1_vddr_m1_s2_vddr_m1_s3_vddr_m1_s4_vddr_m1_vddr_vddr4_t8 r0 *1 0,0
Rg_vddr_m1_mnt_g_s1_vddr_m1_s2_vddr_m1_s3_vddr_m1_s4_vddr_m1_vddr_vddr4_t8
+ g_vddr_m1\x7cmnt_g\x7cs1_vddr_m1\x7cs2_vddr_m1\x7cs3_vddr_m1\x7cs4_vddr_m1\x7cvddr\x7cvddr4__t8
+ g_vddr_m1|mnt_g|s1_vddr_m1|s2_vddr_m1|s3_vddr_m1|s4_vddr_m1|vddr|vddr4
+ 87.9130433891
* device instance g_vddr_m1_mnt_g_s1_vddr_m1_s2_vddr_m1_s3_vddr_m1_s4_vddr_m1_vddr_vddr4_t9 r0 *1 0,0
Rg_vddr_m1_mnt_g_s1_vddr_m1_s2_vddr_m1_s3_vddr_m1_s4_vddr_m1_vddr_vddr4_t9
+ g_vddr_m1\x7cmnt_g\x7cs1_vddr_m1\x7cs2_vddr_m1\x7cs3_vddr_m1\x7cs4_vddr_m1\x7cvddr\x7cvddr4__t9
+ g_vddr_m1|mnt_g|s1_vddr_m1|s2_vddr_m1|s3_vddr_m1|s4_vddr_m1|vddr|vddr4
+ 9.39167775674
* device instance g_vddr_m1_mnt_g_s1_vddr_m1_s2_vddr_m1_s3_vddr_m1_s4_vddr_m1_vddr_vddr4_t10 r0 *1 0,0
Rg_vddr_m1_mnt_g_s1_vddr_m1_s2_vddr_m1_s3_vddr_m1_s4_vddr_m1_vddr_vddr4_t10
+ g_vddr_m1\x7cmnt_g\x7cs1_vddr_m1\x7cs2_vddr_m1\x7cs3_vddr_m1\x7cs4_vddr_m1\x7cvddr\x7cvddr4__t10
+ g_vddr_m1|mnt_g|s1_vddr_m1|s2_vddr_m1|s3_vddr_m1|s4_vddr_m1|vddr|vddr4
+ 80.4457713349
* device instance g_vddr_m1_mnt_g_s1_vddr_m1_s2_vddr_m1_s3_vddr_m1_s4_vddr_m1_vddr_vddr4_t11 r0 *1 0,0
Rg_vddr_m1_mnt_g_s1_vddr_m1_s2_vddr_m1_s3_vddr_m1_s4_vddr_m1_vddr_vddr4_t11
+ g_vddr_m1\x7cmnt_g\x7cs1_vddr_m1\x7cs2_vddr_m1\x7cs3_vddr_m1\x7cs4_vddr_m1\x7cvddr\x7cvddr4__t11
+ g_vddr_m1|mnt_g|s1_vddr_m1|s2_vddr_m1|s3_vddr_m1|s4_vddr_m1|vddr|vddr4
+ 193.595413678
* device instance g_vddr_m1_mnt_g_s1_vddr_m1_s2_vddr_m1_s3_vddr_m1_s4_vddr_m1_vddr_vddr4_t12 r0 *1 0,0
Rg_vddr_m1_mnt_g_s1_vddr_m1_s2_vddr_m1_s3_vddr_m1_s4_vddr_m1_vddr_vddr4_t12
+ g_vddr_m1\x7cmnt_g\x7cs1_vddr_m1\x7cs2_vddr_m1\x7cs3_vddr_m1\x7cs4_vddr_m1\x7cvddr\x7cvddr4__t12
+ g_vddr_m1|mnt_g|s1_vddr_m1|s2_vddr_m1|s3_vddr_m1|s4_vddr_m1|vddr|vddr4
+ 110.004152004
* device instance g_vddr_m1_mnt_g_s1_vddr_m1_s2_vddr_m1_s3_vddr_m1_s4_vddr_m1_vddr_vddr4_t13 r0 *1 0,0
Rg_vddr_m1_mnt_g_s1_vddr_m1_s2_vddr_m1_s3_vddr_m1_s4_vddr_m1_vddr_vddr4_t13
+ g_vddr_m1\x7cmnt_g\x7cs1_vddr_m1\x7cs2_vddr_m1\x7cs3_vddr_m1\x7cs4_vddr_m1\x7cvddr\x7cvddr4__t13
+ g_vddr_m1|mnt_g|s1_vddr_m1|s2_vddr_m1|s3_vddr_m1|s4_vddr_m1|vddr|vddr4
+ 27.3214351864
* device instance g_vddr_m1_mnt_g_s1_vddr_m1_s2_vddr_m1_s3_vddr_m1_s4_vddr_m1_vddr_vddr4_t14 r0 *1 0,0
Rg_vddr_m1_mnt_g_s1_vddr_m1_s2_vddr_m1_s3_vddr_m1_s4_vddr_m1_vddr_vddr4_t14
+ g_vddr_m1\x7cmnt_g\x7cs1_vddr_m1\x7cs2_vddr_m1\x7cs3_vddr_m1\x7cs4_vddr_m1\x7cvddr\x7cvddr4__t14
+ g_vddr_m1|mnt_g|s1_vddr_m1|s2_vddr_m1|s3_vddr_m1|s4_vddr_m1|vddr|vddr4
+ 58.4450706605
* device instance g_vddr_m1_mnt_g_s1_vddr_m1_s2_vddr_m1_s3_vddr_m1_s4_vddr_m1_vddr_vddr4_t15 r0 *1 0,0
Rg_vddr_m1_mnt_g_s1_vddr_m1_s2_vddr_m1_s3_vddr_m1_s4_vddr_m1_vddr_vddr4_t15
+ g_vddr_m1\x7cmnt_g\x7cs1_vddr_m1\x7cs2_vddr_m1\x7cs3_vddr_m1\x7cs4_vddr_m1\x7cvddr\x7cvddr4__t15
+ g_vddr_m1|mnt_g|s1_vddr_m1|s2_vddr_m1|s3_vddr_m1|s4_vddr_m1|vddr|vddr4
+ 140.119288117
* device instance g_vddr_m1_mnt_g_s1_vddr_m1_s2_vddr_m1_s3_vddr_m1_s4_vddr_m1_vddr_vddr4_t16 r0 *1 0,0
Rg_vddr_m1_mnt_g_s1_vddr_m1_s2_vddr_m1_s3_vddr_m1_s4_vddr_m1_vddr_vddr4_t16
+ g_vddr_m1\x7cmnt_g\x7cs1_vddr_m1\x7cs2_vddr_m1\x7cs3_vddr_m1\x7cs4_vddr_m1\x7cvddr\x7cvddr4__t16
+ g_vddr_m1|mnt_g|s1_vddr_m1|s2_vddr_m1|s3_vddr_m1|s4_vddr_m1|vddr|vddr4
+ 153.310041056
* device instance g_vddr_m1_mnt_g_s1_vddr_m1_s2_vddr_m1_s3_vddr_m1_s4_vddr_m1_vddr_vddr4_t17 r0 *1 0,0
Rg_vddr_m1_mnt_g_s1_vddr_m1_s2_vddr_m1_s3_vddr_m1_s4_vddr_m1_vddr_vddr4_t17
+ g_vddr_m1\x7cmnt_g\x7cs1_vddr_m1\x7cs2_vddr_m1\x7cs3_vddr_m1\x7cs4_vddr_m1\x7cvddr\x7cvddr4__t17
+ g_vddr_m1|mnt_g|s1_vddr_m1|s2_vddr_m1|s3_vddr_m1|s4_vddr_m1|vddr|vddr4
+ 173.429674824
* device instance g_vddr_m1_mnt_g_s1_vddr_m1_s2_vddr_m1_s3_vddr_m1_s4_vddr_m1_vddr_vddr4_t18 r0 *1 0,0
Rg_vddr_m1_mnt_g_s1_vddr_m1_s2_vddr_m1_s3_vddr_m1_s4_vddr_m1_vddr_vddr4_t18
+ g_vddr_m1\x7cmnt_g\x7cs1_vddr_m1\x7cs2_vddr_m1\x7cs3_vddr_m1\x7cs4_vddr_m1\x7cvddr\x7cvddr4__t18
+ g_vddr_m1|mnt_g|s1_vddr_m1|s2_vddr_m1|s3_vddr_m1|s4_vddr_m1|vddr|vddr4
+ 91.7253205032
* device instance g_vddr_m1_mnt_g_s1_vddr_m1_s2_vddr_m1_s3_vddr_m1_s4_vddr_m1_vddr_vddr4_t19 r0 *1 0,0
Rg_vddr_m1_mnt_g_s1_vddr_m1_s2_vddr_m1_s3_vddr_m1_s4_vddr_m1_vddr_vddr4_t19
+ g_vddr_m1\x7cmnt_g\x7cs1_vddr_m1\x7cs2_vddr_m1\x7cs3_vddr_m1\x7cs4_vddr_m1\x7cvddr\x7cvddr4__t19
+ g_vddr_m1|mnt_g|s1_vddr_m1|s2_vddr_m1|s3_vddr_m1|s4_vddr_m1|vddr|vddr4
+ 27.8035039982
* device instance g_vddr_m1_mnt_g_s1_vddr_m1_s2_vddr_m1_s3_vddr_m1_s4_vddr_m1_vddr_vddr4_t20 r0 *1 0,0
Rg_vddr_m1_mnt_g_s1_vddr_m1_s2_vddr_m1_s3_vddr_m1_s4_vddr_m1_vddr_vddr4_t20
+ g_vddr_m1\x7cmnt_g\x7cs1_vddr_m1\x7cs2_vddr_m1\x7cs3_vddr_m1\x7cs4_vddr_m1\x7cvddr\x7cvddr4__t20
+ g_vddr_m1|mnt_g|s1_vddr_m1|s2_vddr_m1|s3_vddr_m1|s4_vddr_m1|vddr|vddr4
+ 84.5952324257
* device instance g_vddr_m1_mnt_g_s1_vddr_m1_s2_vddr_m1_s3_vddr_m1_s4_vddr_m1_vddr_vddr4 r0 *1 0,0
Cg_vddr_m1_mnt_g_s1_vddr_m1_s2_vddr_m1_s3_vddr_m1_s4_vddr_m1_vddr_vddr4
+ g_vddr_m1|mnt_g|s1_vddr_m1|s2_vddr_m1|s3_vddr_m1|s4_vddr_m1|vddr|vddr4 vsubs
+ 1.2379228e-14
* device instance g_vss_m1_mph_g_s1_vss_m1_s2_vss_m1_s3_vss_m1_s4_vss_m1_vss_vss_x1_vss_x2_vss_x3_t0 r0 *1 0,0
Rg_vss_m1_mph_g_s1_vss_m1_s2_vss_m1_s3_vss_m1_s4_vss_m1_vss_vss_x1_vss_x2_vss_x3_t0
+ g_vss_m1\x7cmph_g\x7cs1_vss_m1\x7cs2_vss_m1\x7cs3_vss_m1\x7cs4_vss_m1\x7cvss\x7cvss_x1\x7cvss_x2\x7cvss_x3__t0
+ g_vss_m1|mph_g|s1_vss_m1|s2_vss_m1|s3_vss_m1|s4_vss_m1|vss|vss_x1|vss_x2|vss_x3
+ 220.053549692
* device instance g_vss_m1_mph_g_s1_vss_m1_s2_vss_m1_s3_vss_m1_s4_vss_m1_vss_vss_x1_vss_x2_vss_x3_t1 r0 *1 0,0
Rg_vss_m1_mph_g_s1_vss_m1_s2_vss_m1_s3_vss_m1_s4_vss_m1_vss_vss_x1_vss_x2_vss_x3_t1
+ g_vss_m1\x7cmph_g\x7cs1_vss_m1\x7cs2_vss_m1\x7cs3_vss_m1\x7cs4_vss_m1\x7cvss\x7cvss_x1\x7cvss_x2\x7cvss_x3__t1
+ g_vss_m1|mph_g|s1_vss_m1|s2_vss_m1|s3_vss_m1|s4_vss_m1|vss|vss_x1|vss_x2|vss_x3
+ 80.1402572982
* device instance g_vss_m1_mph_g_s1_vss_m1_s2_vss_m1_s3_vss_m1_s4_vss_m1_vss_vss_x1_vss_x2_vss_x3_t2 r0 *1 0,0
Rg_vss_m1_mph_g_s1_vss_m1_s2_vss_m1_s3_vss_m1_s4_vss_m1_vss_vss_x1_vss_x2_vss_x3_t2
+ g_vss_m1\x7cmph_g\x7cs1_vss_m1\x7cs2_vss_m1\x7cs3_vss_m1\x7cs4_vss_m1\x7cvss\x7cvss_x1\x7cvss_x2\x7cvss_x3__t2
+ g_vss_m1|mph_g|s1_vss_m1|s2_vss_m1|s3_vss_m1|s4_vss_m1|vss|vss_x1|vss_x2|vss_x3
+ 62.2674786199
* device instance g_vss_m1_mph_g_s1_vss_m1_s2_vss_m1_s3_vss_m1_s4_vss_m1_vss_vss_x1_vss_x2_vss_x3_t3 r0 *1 0,0
Rg_vss_m1_mph_g_s1_vss_m1_s2_vss_m1_s3_vss_m1_s4_vss_m1_vss_vss_x1_vss_x2_vss_x3_t3
+ g_vss_m1\x7cmph_g\x7cs1_vss_m1\x7cs2_vss_m1\x7cs3_vss_m1\x7cs4_vss_m1\x7cvss\x7cvss_x1\x7cvss_x2\x7cvss_x3__t3
+ g_vss_m1|mph_g|s1_vss_m1|s2_vss_m1|s3_vss_m1|s4_vss_m1|vss|vss_x1|vss_x2|vss_x3
+ 201.960141844
* device instance g_vss_m1_mph_g_s1_vss_m1_s2_vss_m1_s3_vss_m1_s4_vss_m1_vss_vss_x1_vss_x2_vss_x3_t4 r0 *1 0,0
Rg_vss_m1_mph_g_s1_vss_m1_s2_vss_m1_s3_vss_m1_s4_vss_m1_vss_vss_x1_vss_x2_vss_x3_t4
+ g_vss_m1\x7cmph_g\x7cs1_vss_m1\x7cs2_vss_m1\x7cs3_vss_m1\x7cs4_vss_m1\x7cvss\x7cvss_x1\x7cvss_x2\x7cvss_x3__t4
+ g_vss_m1|mph_g|s1_vss_m1|s2_vss_m1|s3_vss_m1|s4_vss_m1|vss|vss_x1|vss_x2|vss_x3
+ 219.761256149
* device instance g_vss_m1_mph_g_s1_vss_m1_s2_vss_m1_s3_vss_m1_s4_vss_m1_vss_vss_x1_vss_x2_vss_x3_t5 r0 *1 0,0
Rg_vss_m1_mph_g_s1_vss_m1_s2_vss_m1_s3_vss_m1_s4_vss_m1_vss_vss_x1_vss_x2_vss_x3_t5
+ g_vss_m1\x7cmph_g\x7cs1_vss_m1\x7cs2_vss_m1\x7cs3_vss_m1\x7cs4_vss_m1\x7cvss\x7cvss_x1\x7cvss_x2\x7cvss_x3__t5
+ g_vss_m1|mph_g|s1_vss_m1|s2_vss_m1|s3_vss_m1|s4_vss_m1|vss|vss_x1|vss_x2|vss_x3
+ 79.3341402675
* device instance g_vss_m1_mph_g_s1_vss_m1_s2_vss_m1_s3_vss_m1_s4_vss_m1_vss_vss_x1_vss_x2_vss_x3_t6 r0 *1 0,0
Rg_vss_m1_mph_g_s1_vss_m1_s2_vss_m1_s3_vss_m1_s4_vss_m1_vss_vss_x1_vss_x2_vss_x3_t6
+ g_vss_m1\x7cmph_g\x7cs1_vss_m1\x7cs2_vss_m1\x7cs3_vss_m1\x7cs4_vss_m1\x7cvss\x7cvss_x1\x7cvss_x2\x7cvss_x3__t6
+ g_vss_m1|mph_g|s1_vss_m1|s2_vss_m1|s3_vss_m1|s4_vss_m1|vss|vss_x1|vss_x2|vss_x3
+ 61.2264964361
* device instance g_vss_m1_mph_g_s1_vss_m1_s2_vss_m1_s3_vss_m1_s4_vss_m1_vss_vss_x1_vss_x2_vss_x3_t7 r0 *1 0,0
Rg_vss_m1_mph_g_s1_vss_m1_s2_vss_m1_s3_vss_m1_s4_vss_m1_vss_vss_x1_vss_x2_vss_x3_t7
+ g_vss_m1\x7cmph_g\x7cs1_vss_m1\x7cs2_vss_m1\x7cs3_vss_m1\x7cs4_vss_m1\x7cvss\x7cvss_x1\x7cvss_x2\x7cvss_x3__t7
+ g_vss_m1|mph_g|s1_vss_m1|s2_vss_m1|s3_vss_m1|s4_vss_m1|vss|vss_x1|vss_x2|vss_x3
+ 201.641622355
* device instance g_vss_m1_mph_g_s1_vss_m1_s2_vss_m1_s3_vss_m1_s4_vss_m1_vss_vss_x1_vss_x2_vss_x3_t8 r0 *1 0,0
Rg_vss_m1_mph_g_s1_vss_m1_s2_vss_m1_s3_vss_m1_s4_vss_m1_vss_vss_x1_vss_x2_vss_x3_t8
+ g_vss_m1\x7cmph_g\x7cs1_vss_m1\x7cs2_vss_m1\x7cs3_vss_m1\x7cs4_vss_m1\x7cvss\x7cvss_x1\x7cvss_x2\x7cvss_x3__t8
+ g_vss_m1|mph_g|s1_vss_m1|s2_vss_m1|s3_vss_m1|s4_vss_m1|vss|vss_x1|vss_x2|vss_x3
+ 287.548221707
* device instance g_vss_m1_mph_g_s1_vss_m1_s2_vss_m1_s3_vss_m1_s4_vss_m1_vss_vss_x1_vss_x2_vss_x3_t9 r0 *1 0,0
Rg_vss_m1_mph_g_s1_vss_m1_s2_vss_m1_s3_vss_m1_s4_vss_m1_vss_vss_x1_vss_x2_vss_x3_t9
+ g_vss_m1\x7cmph_g\x7cs1_vss_m1\x7cs2_vss_m1\x7cs3_vss_m1\x7cs4_vss_m1\x7cvss\x7cvss_x1\x7cvss_x2\x7cvss_x3__t9
+ g_vss_m1|mph_g|s1_vss_m1|s2_vss_m1|s3_vss_m1|s4_vss_m1|vss|vss_x1|vss_x2|vss_x3
+ 266.785557348
* device instance g_vss_m1_mph_g_s1_vss_m1_s2_vss_m1_s3_vss_m1_s4_vss_m1_vss_vss_x1_vss_x2_vss_x3_t10 r0 *1 0,0
Rg_vss_m1_mph_g_s1_vss_m1_s2_vss_m1_s3_vss_m1_s4_vss_m1_vss_vss_x1_vss_x2_vss_x3_t10
+ g_vss_m1\x7cmph_g\x7cs1_vss_m1\x7cs2_vss_m1\x7cs3_vss_m1\x7cs4_vss_m1\x7cvss\x7cvss_x1\x7cvss_x2\x7cvss_x3__t10
+ g_vss_m1|mph_g|s1_vss_m1|s2_vss_m1|s3_vss_m1|s4_vss_m1|vss|vss_x1|vss_x2|vss_x3
+ 246.023057824
* device instance g_vss_m1_mph_g_s1_vss_m1_s2_vss_m1_s3_vss_m1_s4_vss_m1_vss_vss_x1_vss_x2_vss_x3_t11 r0 *1 0,0
Rg_vss_m1_mph_g_s1_vss_m1_s2_vss_m1_s3_vss_m1_s4_vss_m1_vss_vss_x1_vss_x2_vss_x3_t11
+ g_vss_m1\x7cmph_g\x7cs1_vss_m1\x7cs2_vss_m1\x7cs3_vss_m1\x7cs4_vss_m1\x7cvss\x7cvss_x1\x7cvss_x2\x7cvss_x3__t11
+ g_vss_m1|mph_g|s1_vss_m1|s2_vss_m1|s3_vss_m1|s4_vss_m1|vss|vss_x1|vss_x2|vss_x3
+ 225.260768716
* device instance g_vss_m1_mph_g_s1_vss_m1_s2_vss_m1_s3_vss_m1_s4_vss_m1_vss_vss_x1_vss_x2_vss_x3_t12 r0 *1 0,0
Rg_vss_m1_mph_g_s1_vss_m1_s2_vss_m1_s3_vss_m1_s4_vss_m1_vss_vss_x1_vss_x2_vss_x3_t12
+ g_vss_m1\x7cmph_g\x7cs1_vss_m1\x7cs2_vss_m1\x7cs3_vss_m1\x7cs4_vss_m1\x7cvss\x7cvss_x1\x7cvss_x2\x7cvss_x3__t12
+ g_vss_m1|mph_g|s1_vss_m1|s2_vss_m1|s3_vss_m1|s4_vss_m1|vss|vss_x1|vss_x2|vss_x3
+ 105.586379749
* device instance g_vss_m1_mph_g_s1_vss_m1_s2_vss_m1_s3_vss_m1_s4_vss_m1_vss_vss_x1_vss_x2_vss_x3_t13 r0 *1 0,0
Rg_vss_m1_mph_g_s1_vss_m1_s2_vss_m1_s3_vss_m1_s4_vss_m1_vss_vss_x1_vss_x2_vss_x3_t13
+ g_vss_m1\x7cmph_g\x7cs1_vss_m1\x7cs2_vss_m1\x7cs3_vss_m1\x7cs4_vss_m1\x7cvss\x7cvss_x1\x7cvss_x2\x7cvss_x3__t13
+ g_vss_m1|mph_g|s1_vss_m1|s2_vss_m1|s3_vss_m1|s4_vss_m1|vss|vss_x1|vss_x2|vss_x3
+ 147.104013986
* device instance g_vss_m1_mph_g_s1_vss_m1_s2_vss_m1_s3_vss_m1_s4_vss_m1_vss_vss_x1_vss_x2_vss_x3_t14 r0 *1 0,0
Rg_vss_m1_mph_g_s1_vss_m1_s2_vss_m1_s3_vss_m1_s4_vss_m1_vss_vss_x1_vss_x2_vss_x3_t14
+ g_vss_m1\x7cmph_g\x7cs1_vss_m1\x7cs2_vss_m1\x7cs3_vss_m1\x7cs4_vss_m1\x7cvss\x7cvss_x1\x7cvss_x2\x7cvss_x3__t14
+ g_vss_m1|mph_g|s1_vss_m1|s2_vss_m1|s3_vss_m1|s4_vss_m1|vss|vss_x1|vss_x2|vss_x3
+ 126.344404209
* device instance g_vss_m1_mph_g_s1_vss_m1_s2_vss_m1_s3_vss_m1_s4_vss_m1_vss_vss_x1_vss_x2_vss_x3_t15 r0 *1 0,0
Rg_vss_m1_mph_g_s1_vss_m1_s2_vss_m1_s3_vss_m1_s4_vss_m1_vss_vss_x1_vss_x2_vss_x3_t15
+ g_vss_m1\x7cmph_g\x7cs1_vss_m1\x7cs2_vss_m1\x7cs3_vss_m1\x7cs4_vss_m1\x7cvss\x7cvss_x1\x7cvss_x2\x7cvss_x3__t15
+ g_vss_m1|mph_g|s1_vss_m1|s2_vss_m1|s3_vss_m1|s4_vss_m1|vss|vss_x1|vss_x2|vss_x3
+ 84.8311043863
* device instance g_vss_m1_mph_g_s1_vss_m1_s2_vss_m1_s3_vss_m1_s4_vss_m1_vss_vss_x1_vss_x2_vss_x3_t16 r0 *1 0,0
Rg_vss_m1_mph_g_s1_vss_m1_s2_vss_m1_s3_vss_m1_s4_vss_m1_vss_vss_x1_vss_x2_vss_x3_t16
+ g_vss_m1\x7cmph_g\x7cs1_vss_m1\x7cs2_vss_m1\x7cs3_vss_m1\x7cs4_vss_m1\x7cvss\x7cvss_x1\x7cvss_x2\x7cvss_x3__t16
+ g_vss_m1|mph_g|s1_vss_m1|s2_vss_m1|s3_vss_m1|s4_vss_m1|vss|vss_x1|vss_x2|vss_x3
+ 7.14730727485
* device instance g_vss_m1_mph_g_s1_vss_m1_s2_vss_m1_s3_vss_m1_s4_vss_m1_vss_vss_x1_vss_x2_vss_x3_t17 r0 *1 0,0
Rg_vss_m1_mph_g_s1_vss_m1_s2_vss_m1_s3_vss_m1_s4_vss_m1_vss_vss_x1_vss_x2_vss_x3_t17
+ g_vss_m1\x7cmph_g\x7cs1_vss_m1\x7cs2_vss_m1\x7cs3_vss_m1\x7cs4_vss_m1\x7cvss\x7cvss_x1\x7cvss_x2\x7cvss_x3__t17
+ g_vss_m1|mph_g|s1_vss_m1|s2_vss_m1|s3_vss_m1|s4_vss_m1|vss|vss_x1|vss_x2|vss_x3
+ 14.3932375433
* device instance g_vss_m1_mph_g_s1_vss_m1_s2_vss_m1_s3_vss_m1_s4_vss_m1_vss_vss_x1_vss_x2_vss_x3_t18 r0 *1 0,0
Rg_vss_m1_mph_g_s1_vss_m1_s2_vss_m1_s3_vss_m1_s4_vss_m1_vss_vss_x1_vss_x2_vss_x3_t18
+ g_vss_m1\x7cmph_g\x7cs1_vss_m1\x7cs2_vss_m1\x7cs3_vss_m1\x7cs4_vss_m1\x7cvss\x7cvss_x1\x7cvss_x2\x7cvss_x3__t18
+ g_vss_m1|mph_g|s1_vss_m1|s2_vss_m1|s3_vss_m1|s4_vss_m1|vss|vss_x1|vss_x2|vss_x3
+ 35.0072012887
* device instance g_vss_m1_mph_g_s1_vss_m1_s2_vss_m1_s3_vss_m1_s4_vss_m1_vss_vss_x1_vss_x2_vss_x3_t19 r0 *1 0,0
Rg_vss_m1_mph_g_s1_vss_m1_s2_vss_m1_s3_vss_m1_s4_vss_m1_vss_vss_x1_vss_x2_vss_x3_t19
+ g_vss_m1\x7cmph_g\x7cs1_vss_m1\x7cs2_vss_m1\x7cs3_vss_m1\x7cs4_vss_m1\x7cvss\x7cvss_x1\x7cvss_x2\x7cvss_x3__t19
+ g_vss_m1|mph_g|s1_vss_m1|s2_vss_m1|s3_vss_m1|s4_vss_m1|vss|vss_x1|vss_x2|vss_x3
+ 55.7324014067
* device instance g_vss_m1_mph_g_s1_vss_m1_s2_vss_m1_s3_vss_m1_s4_vss_m1_vss_vss_x1_vss_x2_vss_x3_t20 r0 *1 0,0
Rg_vss_m1_mph_g_s1_vss_m1_s2_vss_m1_s3_vss_m1_s4_vss_m1_vss_vss_x1_vss_x2_vss_x3_t20
+ g_vss_m1\x7cmph_g\x7cs1_vss_m1\x7cs2_vss_m1\x7cs3_vss_m1\x7cs4_vss_m1\x7cvss\x7cvss_x1\x7cvss_x2\x7cvss_x3__t20
+ g_vss_m1|mph_g|s1_vss_m1|s2_vss_m1|s3_vss_m1|s4_vss_m1|vss|vss_x1|vss_x2|vss_x3
+ 154.619869503
* device instance g_vss_m1_mph_g_s1_vss_m1_s2_vss_m1_s3_vss_m1_s4_vss_m1_vss_vss_x1_vss_x2_vss_x3_t21 r0 *1 0,0
Rg_vss_m1_mph_g_s1_vss_m1_s2_vss_m1_s3_vss_m1_s4_vss_m1_vss_vss_x1_vss_x2_vss_x3_t21
+ g_vss_m1\x7cmph_g\x7cs1_vss_m1\x7cs2_vss_m1\x7cs3_vss_m1\x7cs4_vss_m1\x7cvss\x7cvss_x1\x7cvss_x2\x7cvss_x3__t21
+ g_vss_m1|mph_g|s1_vss_m1|s2_vss_m1|s3_vss_m1|s4_vss_m1|vss|vss_x1|vss_x2|vss_x3
+ 196.142210673
* device instance g_vss_m1_mph_g_s1_vss_m1_s2_vss_m1_s3_vss_m1_s4_vss_m1_vss_vss_x1_vss_x2_vss_x3_t22 r0 *1 0,0
Rg_vss_m1_mph_g_s1_vss_m1_s2_vss_m1_s3_vss_m1_s4_vss_m1_vss_vss_x1_vss_x2_vss_x3_t22
+ g_vss_m1\x7cmph_g\x7cs1_vss_m1\x7cs2_vss_m1\x7cs3_vss_m1\x7cs4_vss_m1\x7cvss\x7cvss_x1\x7cvss_x2\x7cvss_x3__t22
+ g_vss_m1|mph_g|s1_vss_m1|s2_vss_m1|s3_vss_m1|s4_vss_m1|vss|vss_x1|vss_x2|vss_x3
+ 175.380747637
* device instance g_vss_m1_mph_g_s1_vss_m1_s2_vss_m1_s3_vss_m1_s4_vss_m1_vss_vss_x1_vss_x2_vss_x3_t23 r0 *1 0,0
Rg_vss_m1_mph_g_s1_vss_m1_s2_vss_m1_s3_vss_m1_s4_vss_m1_vss_vss_x1_vss_x2_vss_x3_t23
+ g_vss_m1\x7cmph_g\x7cs1_vss_m1\x7cs2_vss_m1\x7cs3_vss_m1\x7cs4_vss_m1\x7cvss\x7cvss_x1\x7cvss_x2\x7cvss_x3__t23
+ g_vss_m1|mph_g|s1_vss_m1|s2_vss_m1|s3_vss_m1|s4_vss_m1|vss|vss_x1|vss_x2|vss_x3
+ 133.859848416
* device instance g_vss_m1_mph_g_s1_vss_m1_s2_vss_m1_s3_vss_m1_s4_vss_m1_vss_vss_x1_vss_x2_vss_x3_t24 r0 *1 0,0
Rg_vss_m1_mph_g_s1_vss_m1_s2_vss_m1_s3_vss_m1_s4_vss_m1_vss_vss_x1_vss_x2_vss_x3_t24
+ g_vss_m1\x7cmph_g\x7cs1_vss_m1\x7cs2_vss_m1\x7cs3_vss_m1\x7cs4_vss_m1\x7cvss\x7cvss_x1\x7cvss_x2\x7cvss_x3__t24
+ g_vss_m1|mph_g|s1_vss_m1|s2_vss_m1|s3_vss_m1|s4_vss_m1|vss|vss_x1|vss_x2|vss_x3
+ 287.771671355
* device instance g_vss_m1_mph_g_s1_vss_m1_s2_vss_m1_s3_vss_m1_s4_vss_m1_vss_vss_x1_vss_x2_vss_x3_t25 r0 *1 0,0
Rg_vss_m1_mph_g_s1_vss_m1_s2_vss_m1_s3_vss_m1_s4_vss_m1_vss_vss_x1_vss_x2_vss_x3_t25
+ g_vss_m1\x7cmph_g\x7cs1_vss_m1\x7cs2_vss_m1\x7cs3_vss_m1\x7cs4_vss_m1\x7cvss\x7cvss_x1\x7cvss_x2\x7cvss_x3__t25
+ g_vss_m1|mph_g|s1_vss_m1|s2_vss_m1|s3_vss_m1|s4_vss_m1|vss|vss_x1|vss_x2|vss_x3
+ 267.026381912
* device instance g_vss_m1_mph_g_s1_vss_m1_s2_vss_m1_s3_vss_m1_s4_vss_m1_vss_vss_x1_vss_x2_vss_x3_t26 r0 *1 0,0
Rg_vss_m1_mph_g_s1_vss_m1_s2_vss_m1_s3_vss_m1_s4_vss_m1_vss_vss_x1_vss_x2_vss_x3_t26
+ g_vss_m1\x7cmph_g\x7cs1_vss_m1\x7cs2_vss_m1\x7cs3_vss_m1\x7cs4_vss_m1\x7cvss\x7cvss_x1\x7cvss_x2\x7cvss_x3__t26
+ g_vss_m1|mph_g|s1_vss_m1|s2_vss_m1|s3_vss_m1|s4_vss_m1|vss|vss_x1|vss_x2|vss_x3
+ 246.284185463
* device instance g_vss_m1_mph_g_s1_vss_m1_s2_vss_m1_s3_vss_m1_s4_vss_m1_vss_vss_x1_vss_x2_vss_x3_t27 r0 *1 0,0
Rg_vss_m1_mph_g_s1_vss_m1_s2_vss_m1_s3_vss_m1_s4_vss_m1_vss_vss_x1_vss_x2_vss_x3_t27
+ g_vss_m1\x7cmph_g\x7cs1_vss_m1\x7cs2_vss_m1\x7cs3_vss_m1\x7cs4_vss_m1\x7cvss\x7cvss_x1\x7cvss_x2\x7cvss_x3__t27
+ g_vss_m1|mph_g|s1_vss_m1|s2_vss_m1|s3_vss_m1|s4_vss_m1|vss|vss_x1|vss_x2|vss_x3
+ 225.545935344
* device instance g_vss_m1_mph_g_s1_vss_m1_s2_vss_m1_s3_vss_m1_s4_vss_m1_vss_vss_x1_vss_x2_vss_x3_t28 r0 *1 0,0
Rg_vss_m1_mph_g_s1_vss_m1_s2_vss_m1_s3_vss_m1_s4_vss_m1_vss_vss_x1_vss_x2_vss_x3_t28
+ g_vss_m1\x7cmph_g\x7cs1_vss_m1\x7cs2_vss_m1\x7cs3_vss_m1\x7cs4_vss_m1\x7cvss\x7cvss_x1\x7cvss_x2\x7cvss_x3__t28
+ g_vss_m1|mph_g|s1_vss_m1|s2_vss_m1|s3_vss_m1|s4_vss_m1|vss|vss_x1|vss_x2|vss_x3
+ 126.852132433
* device instance g_vss_m1_mph_g_s1_vss_m1_s2_vss_m1_s3_vss_m1_s4_vss_m1_vss_vss_x1_vss_x2_vss_x3_t29 r0 *1 0,0
Rg_vss_m1_mph_g_s1_vss_m1_s2_vss_m1_s3_vss_m1_s4_vss_m1_vss_vss_x1_vss_x2_vss_x3_t29
+ g_vss_m1\x7cmph_g\x7cs1_vss_m1\x7cs2_vss_m1\x7cs3_vss_m1\x7cs4_vss_m1\x7cvss\x7cvss_x1\x7cvss_x2\x7cvss_x3__t29
+ g_vss_m1|mph_g|s1_vss_m1|s2_vss_m1|s3_vss_m1|s4_vss_m1|vss|vss_x1|vss_x2|vss_x3
+ 147.540319773
* device instance g_vss_m1_mph_g_s1_vss_m1_s2_vss_m1_s3_vss_m1_s4_vss_m1_vss_vss_x1_vss_x2_vss_x3_t30 r0 *1 0,0
Rg_vss_m1_mph_g_s1_vss_m1_s2_vss_m1_s3_vss_m1_s4_vss_m1_vss_vss_x1_vss_x2_vss_x3_t30
+ g_vss_m1\x7cmph_g\x7cs1_vss_m1\x7cs2_vss_m1\x7cs3_vss_m1\x7cs4_vss_m1\x7cvss\x7cvss_x1\x7cvss_x2\x7cvss_x3__t30
+ g_vss_m1|mph_g|s1_vss_m1|s2_vss_m1|s3_vss_m1|s4_vss_m1|vss|vss_x1|vss_x2|vss_x3
+ 106.193401944
* device instance g_vss_m1_mph_g_s1_vss_m1_s2_vss_m1_s3_vss_m1_s4_vss_m1_vss_vss_x1_vss_x2_vss_x3_t31 r0 *1 0,0
Rg_vss_m1_mph_g_s1_vss_m1_s2_vss_m1_s3_vss_m1_s4_vss_m1_vss_vss_x1_vss_x2_vss_x3_t31
+ g_vss_m1\x7cmph_g\x7cs1_vss_m1\x7cs2_vss_m1\x7cs3_vss_m1\x7cs4_vss_m1\x7cvss\x7cvss_x1\x7cvss_x2\x7cvss_x3__t31
+ g_vss_m1|mph_g|s1_vss_m1|s2_vss_m1|s3_vss_m1|s4_vss_m1|vss|vss_x1|vss_x2|vss_x3
+ 85.585461962
* device instance g_vss_m1_mph_g_s1_vss_m1_s2_vss_m1_s3_vss_m1_s4_vss_m1_vss_vss_x1_vss_x2_vss_x3_t32 r0 *1 0,0
Rg_vss_m1_mph_g_s1_vss_m1_s2_vss_m1_s3_vss_m1_s4_vss_m1_vss_vss_x1_vss_x2_vss_x3_t32
+ g_vss_m1\x7cmph_g\x7cs1_vss_m1\x7cs2_vss_m1\x7cs3_vss_m1\x7cs4_vss_m1\x7cvss\x7cvss_x1\x7cvss_x2\x7cvss_x3__t32
+ g_vss_m1|mph_g|s1_vss_m1|s2_vss_m1|s3_vss_m1|s4_vss_m1|vss|vss_x1|vss_x2|vss_x3
+ 13.4029485233
* device instance g_vss_m1_mph_g_s1_vss_m1_s2_vss_m1_s3_vss_m1_s4_vss_m1_vss_vss_x1_vss_x2_vss_x3_t33 r0 *1 0,0
Rg_vss_m1_mph_g_s1_vss_m1_s2_vss_m1_s3_vss_m1_s4_vss_m1_vss_vss_x1_vss_x2_vss_x3_t33
+ g_vss_m1\x7cmph_g\x7cs1_vss_m1\x7cs2_vss_m1\x7cs3_vss_m1\x7cs4_vss_m1\x7cvss\x7cvss_x1\x7cvss_x2\x7cvss_x3__t33
+ g_vss_m1|mph_g|s1_vss_m1|s2_vss_m1|s3_vss_m1|s4_vss_m1|vss|vss_x1|vss_x2|vss_x3
+ 18.3226721527
* device instance g_vss_m1_mph_g_s1_vss_m1_s2_vss_m1_s3_vss_m1_s4_vss_m1_vss_vss_x1_vss_x2_vss_x3_t34 r0 *1 0,0
Rg_vss_m1_mph_g_s1_vss_m1_s2_vss_m1_s3_vss_m1_s4_vss_m1_vss_vss_x1_vss_x2_vss_x3_t34
+ g_vss_m1\x7cmph_g\x7cs1_vss_m1\x7cs2_vss_m1\x7cs3_vss_m1\x7cs4_vss_m1\x7cvss\x7cvss_x1\x7cvss_x2\x7cvss_x3__t34
+ g_vss_m1|mph_g|s1_vss_m1|s2_vss_m1|s3_vss_m1|s4_vss_m1|vss|vss_x1|vss_x2|vss_x3
+ 36.7975429874
* device instance g_vss_m1_mph_g_s1_vss_m1_s2_vss_m1_s3_vss_m1_s4_vss_m1_vss_vss_x1_vss_x2_vss_x3_t35 r0 *1 0,0
Rg_vss_m1_mph_g_s1_vss_m1_s2_vss_m1_s3_vss_m1_s4_vss_m1_vss_vss_x1_vss_x2_vss_x3_t35
+ g_vss_m1\x7cmph_g\x7cs1_vss_m1\x7cs2_vss_m1\x7cs3_vss_m1\x7cs4_vss_m1\x7cvss\x7cvss_x1\x7cvss_x2\x7cvss_x3__t35
+ g_vss_m1|mph_g|s1_vss_m1|s2_vss_m1|s3_vss_m1|s4_vss_m1|vss|vss_x1|vss_x2|vss_x3
+ 56.8740326898
* device instance g_vss_m1_mph_g_s1_vss_m1_s2_vss_m1_s3_vss_m1_s4_vss_m1_vss_vss_x1_vss_x2_vss_x3_t36 r0 *1 0,0
Rg_vss_m1_mph_g_s1_vss_m1_s2_vss_m1_s3_vss_m1_s4_vss_m1_vss_vss_x1_vss_x2_vss_x3_t36
+ g_vss_m1\x7cmph_g\x7cs1_vss_m1\x7cs2_vss_m1\x7cs3_vss_m1\x7cs4_vss_m1\x7cvss\x7cvss_x1\x7cvss_x2\x7cvss_x3__t36
+ g_vss_m1|mph_g|s1_vss_m1|s2_vss_m1|s3_vss_m1|s4_vss_m1|vss|vss_x1|vss_x2|vss_x3
+ 105.79511568
* device instance g_vss_m1_mph_g_s1_vss_m1_s2_vss_m1_s3_vss_m1_s4_vss_m1_vss_vss_x1_vss_x2_vss_x3_t37 r0 *1 0,0
Rg_vss_m1_mph_g_s1_vss_m1_s2_vss_m1_s3_vss_m1_s4_vss_m1_vss_vss_x1_vss_x2_vss_x3_t37
+ g_vss_m1\x7cmph_g\x7cs1_vss_m1\x7cs2_vss_m1\x7cs3_vss_m1\x7cs4_vss_m1\x7cvss\x7cvss_x1\x7cvss_x2\x7cvss_x3__t37
+ g_vss_m1|mph_g|s1_vss_m1|s2_vss_m1|s3_vss_m1|s4_vss_m1|vss|vss_x1|vss_x2|vss_x3
+ 316.768352419
* device instance g_vss_m1_mph_g_s1_vss_m1_s2_vss_m1_s3_vss_m1_s4_vss_m1_vss_vss_x1_vss_x2_vss_x3_t38 r0 *1 0,0
Rg_vss_m1_mph_g_s1_vss_m1_s2_vss_m1_s3_vss_m1_s4_vss_m1_vss_vss_x1_vss_x2_vss_x3_t38
+ g_vss_m1\x7cmph_g\x7cs1_vss_m1\x7cs2_vss_m1\x7cs3_vss_m1\x7cs4_vss_m1\x7cvss\x7cvss_x1\x7cvss_x2\x7cvss_x3__t38
+ g_vss_m1|mph_g|s1_vss_m1|s2_vss_m1|s3_vss_m1|s4_vss_m1|vss|vss_x1|vss_x2|vss_x3
+ 42.7631916268
* device instance g_vss_m1_mph_g_s1_vss_m1_s2_vss_m1_s3_vss_m1_s4_vss_m1_vss_vss_x1_vss_x2_vss_x3_t39 r0 *1 0,0
Rg_vss_m1_mph_g_s1_vss_m1_s2_vss_m1_s3_vss_m1_s4_vss_m1_vss_vss_x1_vss_x2_vss_x3_t39
+ g_vss_m1\x7cmph_g\x7cs1_vss_m1\x7cs2_vss_m1\x7cs3_vss_m1\x7cs4_vss_m1\x7cvss\x7cvss_x1\x7cvss_x2\x7cvss_x3__t39
+ g_vss_m1|mph_g|s1_vss_m1|s2_vss_m1|s3_vss_m1|s4_vss_m1|vss|vss_x1|vss_x2|vss_x3
+ 150.316129803
* device instance g_vss_m1_mph_g_s1_vss_m1_s2_vss_m1_s3_vss_m1_s4_vss_m1_vss_vss_x1_vss_x2_vss_x3_t40 r0 *1 0,0
Rg_vss_m1_mph_g_s1_vss_m1_s2_vss_m1_s3_vss_m1_s4_vss_m1_vss_vss_x1_vss_x2_vss_x3_t40
+ g_vss_m1\x7cmph_g\x7cs1_vss_m1\x7cs2_vss_m1\x7cs3_vss_m1\x7cs4_vss_m1\x7cvss\x7cvss_x1\x7cvss_x2\x7cvss_x3__t40
+ g_vss_m1|mph_g|s1_vss_m1|s2_vss_m1|s3_vss_m1|s4_vss_m1|vss|vss_x1|vss_x2|vss_x3
+ 177.157493945
* device instance g_vss_m1_mph_g_s1_vss_m1_s2_vss_m1_s3_vss_m1_s4_vss_m1_vss_vss_x1_vss_x2_vss_x3_t41 r0 *1 0,0
Rg_vss_m1_mph_g_s1_vss_m1_s2_vss_m1_s3_vss_m1_s4_vss_m1_vss_vss_x1_vss_x2_vss_x3_t41
+ g_vss_m1\x7cmph_g\x7cs1_vss_m1\x7cs2_vss_m1\x7cs3_vss_m1\x7cs4_vss_m1\x7cvss\x7cvss_x1\x7cvss_x2\x7cvss_x3__t41
+ g_vss_m1|mph_g|s1_vss_m1|s2_vss_m1|s3_vss_m1|s4_vss_m1|vss|vss_x1|vss_x2|vss_x3
+ 105.460276245
* device instance g_vss_m1_mph_g_s1_vss_m1_s2_vss_m1_s3_vss_m1_s4_vss_m1_vss_vss_x1_vss_x2_vss_x3_t42 r0 *1 0,0
Rg_vss_m1_mph_g_s1_vss_m1_s2_vss_m1_s3_vss_m1_s4_vss_m1_vss_vss_x1_vss_x2_vss_x3_t42
+ g_vss_m1\x7cmph_g\x7cs1_vss_m1\x7cs2_vss_m1\x7cs3_vss_m1\x7cs4_vss_m1\x7cvss\x7cvss_x1\x7cvss_x2\x7cvss_x3__t42
+ g_vss_m1|mph_g|s1_vss_m1|s2_vss_m1|s3_vss_m1|s4_vss_m1|vss|vss_x1|vss_x2|vss_x3
+ 176.48286245
* device instance g_vss_m1_mph_g_s1_vss_m1_s2_vss_m1_s3_vss_m1_s4_vss_m1_vss_vss_x1_vss_x2_vss_x3_t43 r0 *1 0,0
Rg_vss_m1_mph_g_s1_vss_m1_s2_vss_m1_s3_vss_m1_s4_vss_m1_vss_vss_x1_vss_x2_vss_x3_t43
+ g_vss_m1\x7cmph_g\x7cs1_vss_m1\x7cs2_vss_m1\x7cs3_vss_m1\x7cs4_vss_m1\x7cvss\x7cvss_x1\x7cvss_x2\x7cvss_x3__t43
+ g_vss_m1|mph_g|s1_vss_m1|s2_vss_m1|s3_vss_m1|s4_vss_m1|vss|vss_x1|vss_x2|vss_x3
+ 37.4979243289
* device instance g_vss_m1_mph_g_s1_vss_m1_s2_vss_m1_s3_vss_m1_s4_vss_m1_vss_vss_x1_vss_x2_vss_x3_t44 r0 *1 0,0
Rg_vss_m1_mph_g_s1_vss_m1_s2_vss_m1_s3_vss_m1_s4_vss_m1_vss_vss_x1_vss_x2_vss_x3_t44
+ g_vss_m1\x7cmph_g\x7cs1_vss_m1\x7cs2_vss_m1\x7cs3_vss_m1\x7cs4_vss_m1\x7cvss\x7cvss_x1\x7cvss_x2\x7cvss_x3__t44
+ g_vss_m1|mph_g|s1_vss_m1|s2_vss_m1|s3_vss_m1|s4_vss_m1|vss|vss_x1|vss_x2|vss_x3
+ 80.2350697012
* device instance g_vss_m1_mph_g_s1_vss_m1_s2_vss_m1_s3_vss_m1_s4_vss_m1_vss_vss_x1_vss_x2_vss_x3_t45 r0 *1 0,0
Rg_vss_m1_mph_g_s1_vss_m1_s2_vss_m1_s3_vss_m1_s4_vss_m1_vss_vss_x1_vss_x2_vss_x3_t45
+ g_vss_m1\x7cmph_g\x7cs1_vss_m1\x7cs2_vss_m1\x7cs3_vss_m1\x7cs4_vss_m1\x7cvss\x7cvss_x1\x7cvss_x2\x7cvss_x3__t45
+ g_vss_m1|mph_g|s1_vss_m1|s2_vss_m1|s3_vss_m1|s4_vss_m1|vss|vss_x1|vss_x2|vss_x3
+ 222.666716336
* device instance g_vss_m1_mph_g_s1_vss_m1_s2_vss_m1_s3_vss_m1_s4_vss_m1_vss_vss_x1_vss_x2_vss_x3_t46 r0 *1 0,0
Rg_vss_m1_mph_g_s1_vss_m1_s2_vss_m1_s3_vss_m1_s4_vss_m1_vss_vss_x1_vss_x2_vss_x3_t46
+ g_vss_m1\x7cmph_g\x7cs1_vss_m1\x7cs2_vss_m1\x7cs3_vss_m1\x7cs4_vss_m1\x7cvss\x7cvss_x1\x7cvss_x2\x7cvss_x3__t46
+ g_vss_m1|mph_g|s1_vss_m1|s2_vss_m1|s3_vss_m1|s4_vss_m1|vss|vss_x1|vss_x2|vss_x3
+ 196.469646093
* device instance g_vss_m1_mph_g_s1_vss_m1_s2_vss_m1_s3_vss_m1_s4_vss_m1_vss_vss_x1_vss_x2_vss_x3_t47 r0 *1 0,0
Rg_vss_m1_mph_g_s1_vss_m1_s2_vss_m1_s3_vss_m1_s4_vss_m1_vss_vss_x1_vss_x2_vss_x3_t47
+ g_vss_m1\x7cmph_g\x7cs1_vss_m1\x7cs2_vss_m1\x7cs3_vss_m1\x7cs4_vss_m1\x7cvss\x7cvss_x1\x7cvss_x2\x7cvss_x3__t47
+ g_vss_m1|mph_g|s1_vss_m1|s2_vss_m1|s3_vss_m1|s4_vss_m1|vss|vss_x1|vss_x2|vss_x3
+ 155.03502531
* device instance g_vss_m1_mph_g_s1_vss_m1_s2_vss_m1_s3_vss_m1_s4_vss_m1_vss_vss_x1_vss_x2_vss_x3_t48 r0 *1 0,0
Rg_vss_m1_mph_g_s1_vss_m1_s2_vss_m1_s3_vss_m1_s4_vss_m1_vss_vss_x1_vss_x2_vss_x3_t48
+ g_vss_m1\x7cmph_g\x7cs1_vss_m1\x7cs2_vss_m1\x7cs3_vss_m1\x7cs4_vss_m1\x7cvss\x7cvss_x1\x7cvss_x2\x7cvss_x3__t48
+ g_vss_m1|mph_g|s1_vss_m1|s2_vss_m1|s3_vss_m1|s4_vss_m1|vss|vss_x1|vss_x2|vss_x3
+ 134.339175394
* device instance g_vss_m1_mph_g_s1_vss_m1_s2_vss_m1_s3_vss_m1_s4_vss_m1_vss_vss_x1_vss_x2_vss_x3_t49 r0 *1 0,0
Rg_vss_m1_mph_g_s1_vss_m1_s2_vss_m1_s3_vss_m1_s4_vss_m1_vss_vss_x1_vss_x2_vss_x3_t49
+ g_vss_m1\x7cmph_g\x7cs1_vss_m1\x7cs2_vss_m1\x7cs3_vss_m1\x7cs4_vss_m1\x7cvss\x7cvss_x1\x7cvss_x2\x7cvss_x3__t49
+ g_vss_m1|mph_g|s1_vss_m1|s2_vss_m1|s3_vss_m1|s4_vss_m1|vss|vss_x1|vss_x2|vss_x3
+ 175.746868165
* device instance g_vss_m1_mph_g_s1_vss_m1_s2_vss_m1_s3_vss_m1_s4_vss_m1_vss_vss_x1_vss_x2_vss_x3_t50 r0 *1 0,0
Rg_vss_m1_mph_g_s1_vss_m1_s2_vss_m1_s3_vss_m1_s4_vss_m1_vss_vss_x1_vss_x2_vss_x3_t50
+ g_vss_m1\x7cmph_g\x7cs1_vss_m1\x7cs2_vss_m1\x7cs3_vss_m1\x7cs4_vss_m1\x7cvss\x7cvss_x1\x7cvss_x2\x7cvss_x3__t50
+ g_vss_m1|mph_g|s1_vss_m1|s2_vss_m1|s3_vss_m1|s4_vss_m1|vss|vss_x1|vss_x2|vss_x3
+ 191.641187936
* device instance g_vss_m1_mph_g_s1_vss_m1_s2_vss_m1_s3_vss_m1_s4_vss_m1_vss_vss_x1_vss_x2_vss_x3_t51 r0 *1 0,0
Rg_vss_m1_mph_g_s1_vss_m1_s2_vss_m1_s3_vss_m1_s4_vss_m1_vss_vss_x1_vss_x2_vss_x3_t51
+ g_vss_m1\x7cmph_g\x7cs1_vss_m1\x7cs2_vss_m1\x7cs3_vss_m1\x7cs4_vss_m1\x7cvss\x7cvss_x1\x7cvss_x2\x7cvss_x3__t51
+ g_vss_m1|mph_g|s1_vss_m1|s2_vss_m1|s3_vss_m1|s4_vss_m1|vss|vss_x1|vss_x2|vss_x3
+ 136.646026782
* device instance g_vss_m1_mph_g_s1_vss_m1_s2_vss_m1_s3_vss_m1_s4_vss_m1_vss_vss_x1_vss_x2_vss_x3_t52 r0 *1 0,0
Rg_vss_m1_mph_g_s1_vss_m1_s2_vss_m1_s3_vss_m1_s4_vss_m1_vss_vss_x1_vss_x2_vss_x3_t52
+ g_vss_m1\x7cmph_g\x7cs1_vss_m1\x7cs2_vss_m1\x7cs3_vss_m1\x7cs4_vss_m1\x7cvss\x7cvss_x1\x7cvss_x2\x7cvss_x3__t52
+ g_vss_m1|mph_g|s1_vss_m1|s2_vss_m1|s3_vss_m1|s4_vss_m1|vss|vss_x1|vss_x2|vss_x3
+ 119.28111081
* device instance g_vss_m1_mph_g_s1_vss_m1_s2_vss_m1_s3_vss_m1_s4_vss_m1_vss_vss_x1_vss_x2_vss_x3_t53 r0 *1 0,0
Rg_vss_m1_mph_g_s1_vss_m1_s2_vss_m1_s3_vss_m1_s4_vss_m1_vss_vss_x1_vss_x2_vss_x3_t53
+ g_vss_m1\x7cmph_g\x7cs1_vss_m1\x7cs2_vss_m1\x7cs3_vss_m1\x7cs4_vss_m1\x7cvss\x7cvss_x1\x7cvss_x2\x7cvss_x3__t53
+ g_vss_m1|mph_g|s1_vss_m1|s2_vss_m1|s3_vss_m1|s4_vss_m1|vss|vss_x1|vss_x2|vss_x3
+ 50.5754594071
* device instance g_vss_m1_mph_g_s1_vss_m1_s2_vss_m1_s3_vss_m1_s4_vss_m1_vss_vss_x1_vss_x2_vss_x3_t54 r0 *1 0,0
Rg_vss_m1_mph_g_s1_vss_m1_s2_vss_m1_s3_vss_m1_s4_vss_m1_vss_vss_x1_vss_x2_vss_x3_t54
+ g_vss_m1\x7cmph_g\x7cs1_vss_m1\x7cs2_vss_m1\x7cs3_vss_m1\x7cs4_vss_m1\x7cvss\x7cvss_x1\x7cvss_x2\x7cvss_x3__t54
+ g_vss_m1|mph_g|s1_vss_m1|s2_vss_m1|s3_vss_m1|s4_vss_m1|vss|vss_x1|vss_x2|vss_x3
+ 66.2239149584
* device instance g_vss_m1_mph_g_s1_vss_m1_s2_vss_m1_s3_vss_m1_s4_vss_m1_vss_vss_x1_vss_x2_vss_x3_t55 r0 *1 0,0
Rg_vss_m1_mph_g_s1_vss_m1_s2_vss_m1_s3_vss_m1_s4_vss_m1_vss_vss_x1_vss_x2_vss_x3_t55
+ g_vss_m1\x7cmph_g\x7cs1_vss_m1\x7cs2_vss_m1\x7cs3_vss_m1\x7cs4_vss_m1\x7cvss\x7cvss_x1\x7cvss_x2\x7cvss_x3__t55
+ g_vss_m1|mph_g|s1_vss_m1|s2_vss_m1|s3_vss_m1|s4_vss_m1|vss|vss_x1|vss_x2|vss_x3
+ 209.253247464
* device instance g_vss_m1_mph_g_s1_vss_m1_s2_vss_m1_s3_vss_m1_s4_vss_m1_vss_vss_x1_vss_x2_vss_x3_t56 r0 *1 0,0
Rg_vss_m1_mph_g_s1_vss_m1_s2_vss_m1_s3_vss_m1_s4_vss_m1_vss_vss_x1_vss_x2_vss_x3_t56
+ g_vss_m1\x7cmph_g\x7cs1_vss_m1\x7cs2_vss_m1\x7cs3_vss_m1\x7cs4_vss_m1\x7cvss\x7cvss_x1\x7cvss_x2\x7cvss_x3__t56
+ g_vss_m1|mph_g|s1_vss_m1|s2_vss_m1|s3_vss_m1|s4_vss_m1|vss|vss_x1|vss_x2|vss_x3
+ 214.055361508
* device instance g_vss_m1_mph_g_s1_vss_m1_s2_vss_m1_s3_vss_m1_s4_vss_m1_vss_vss_x1_vss_x2_vss_x3_t57 r0 *1 0,0
Rg_vss_m1_mph_g_s1_vss_m1_s2_vss_m1_s3_vss_m1_s4_vss_m1_vss_vss_x1_vss_x2_vss_x3_t57
+ g_vss_m1\x7cmph_g\x7cs1_vss_m1\x7cs2_vss_m1\x7cs3_vss_m1\x7cs4_vss_m1\x7cvss\x7cvss_x1\x7cvss_x2\x7cvss_x3__t57
+ g_vss_m1|mph_g|s1_vss_m1|s2_vss_m1|s3_vss_m1|s4_vss_m1|vss|vss_x1|vss_x2|vss_x3
+ 74.2023775071
* device instance g_vss_m1_mph_g_s1_vss_m1_s2_vss_m1_s3_vss_m1_s4_vss_m1_vss_vss_x1_vss_x2_vss_x3_t58 r0 *1 0,0
Rg_vss_m1_mph_g_s1_vss_m1_s2_vss_m1_s3_vss_m1_s4_vss_m1_vss_vss_x1_vss_x2_vss_x3_t58
+ g_vss_m1\x7cmph_g\x7cs1_vss_m1\x7cs2_vss_m1\x7cs3_vss_m1\x7cs4_vss_m1\x7cvss\x7cvss_x1\x7cvss_x2\x7cvss_x3__t58
+ g_vss_m1|mph_g|s1_vss_m1|s2_vss_m1|s3_vss_m1|s4_vss_m1|vss|vss_x1|vss_x2|vss_x3
+ 68.1774875681
* device instance g_vss_m1_mph_g_s1_vss_m1_s2_vss_m1_s3_vss_m1_s4_vss_m1_vss_vss_x1_vss_x2_vss_x3_t59 r0 *1 0,0
Rg_vss_m1_mph_g_s1_vss_m1_s2_vss_m1_s3_vss_m1_s4_vss_m1_vss_vss_x1_vss_x2_vss_x3_t59
+ g_vss_m1\x7cmph_g\x7cs1_vss_m1\x7cs2_vss_m1\x7cs3_vss_m1\x7cs4_vss_m1\x7cvss\x7cvss_x1\x7cvss_x2\x7cvss_x3__t59
+ g_vss_m1|mph_g|s1_vss_m1|s2_vss_m1|s3_vss_m1|s4_vss_m1|vss|vss_x1|vss_x2|vss_x3
+ 207.957276239
* device instance g_vss_m1_mph_g_s1_vss_m1_s2_vss_m1_s3_vss_m1_s4_vss_m1_vss_vss_x1_vss_x2_vss_x3_t60 r0 *1 0,0
Rg_vss_m1_mph_g_s1_vss_m1_s2_vss_m1_s3_vss_m1_s4_vss_m1_vss_vss_x1_vss_x2_vss_x3_t60
+ g_vss_m1\x7cmph_g\x7cs1_vss_m1\x7cs2_vss_m1\x7cs3_vss_m1\x7cs4_vss_m1\x7cvss\x7cvss_x1\x7cvss_x2\x7cvss_x3__t60
+ g_vss_m1|mph_g|s1_vss_m1|s2_vss_m1|s3_vss_m1|s4_vss_m1|vss|vss_x1|vss_x2|vss_x3
+ 210.940444225
* device instance g_vss_m1_mph_g_s1_vss_m1_s2_vss_m1_s3_vss_m1_s4_vss_m1_vss_vss_x1_vss_x2_vss_x3_t61 r0 *1 0,0
Rg_vss_m1_mph_g_s1_vss_m1_s2_vss_m1_s3_vss_m1_s4_vss_m1_vss_vss_x1_vss_x2_vss_x3_t61
+ g_vss_m1\x7cmph_g\x7cs1_vss_m1\x7cs2_vss_m1\x7cs3_vss_m1\x7cs4_vss_m1\x7cvss\x7cvss_x1\x7cvss_x2\x7cvss_x3__t61
+ g_vss_m1|mph_g|s1_vss_m1|s2_vss_m1|s3_vss_m1|s4_vss_m1|vss|vss_x1|vss_x2|vss_x3
+ 193.325588965
* device instance g_vss_m1_mph_g_s1_vss_m1_s2_vss_m1_s3_vss_m1_s4_vss_m1_vss_vss_x1_vss_x2_vss_x3_t62 r0 *1 0,0
Rg_vss_m1_mph_g_s1_vss_m1_s2_vss_m1_s3_vss_m1_s4_vss_m1_vss_vss_x1_vss_x2_vss_x3_t62
+ g_vss_m1\x7cmph_g\x7cs1_vss_m1\x7cs2_vss_m1\x7cs3_vss_m1\x7cs4_vss_m1\x7cvss\x7cvss_x1\x7cvss_x2\x7cvss_x3__t62
+ g_vss_m1|mph_g|s1_vss_m1|s2_vss_m1|s3_vss_m1|s4_vss_m1|vss|vss_x1|vss_x2|vss_x3
+ 138.313618174
* device instance g_vss_m1_mph_g_s1_vss_m1_s2_vss_m1_s3_vss_m1_s4_vss_m1_vss_vss_x1_vss_x2_vss_x3_t63 r0 *1 0,0
Rg_vss_m1_mph_g_s1_vss_m1_s2_vss_m1_s3_vss_m1_s4_vss_m1_vss_vss_x1_vss_x2_vss_x3_t63
+ g_vss_m1\x7cmph_g\x7cs1_vss_m1\x7cs2_vss_m1\x7cs3_vss_m1\x7cs4_vss_m1\x7cvss\x7cvss_x1\x7cvss_x2\x7cvss_x3__t63
+ g_vss_m1|mph_g|s1_vss_m1|s2_vss_m1|s3_vss_m1|s4_vss_m1|vss|vss_x1|vss_x2|vss_x3
+ 120.937970598
* device instance g_vss_m1_mph_g_s1_vss_m1_s2_vss_m1_s3_vss_m1_s4_vss_m1_vss_vss_x1_vss_x2_vss_x3_t64 r0 *1 0,0
Rg_vss_m1_mph_g_s1_vss_m1_s2_vss_m1_s3_vss_m1_s4_vss_m1_vss_vss_x1_vss_x2_vss_x3_t64
+ g_vss_m1\x7cmph_g\x7cs1_vss_m1\x7cs2_vss_m1\x7cs3_vss_m1\x7cs4_vss_m1\x7cvss\x7cvss_x1\x7cvss_x2\x7cvss_x3__t64
+ g_vss_m1|mph_g|s1_vss_m1|s2_vss_m1|s3_vss_m1|s4_vss_m1|vss|vss_x1|vss_x2|vss_x3
+ 67.7768260575
* device instance g_vss_m1_mph_g_s1_vss_m1_s2_vss_m1_s3_vss_m1_s4_vss_m1_vss_vss_x1_vss_x2_vss_x3_t65 r0 *1 0,0
Rg_vss_m1_mph_g_s1_vss_m1_s2_vss_m1_s3_vss_m1_s4_vss_m1_vss_vss_x1_vss_x2_vss_x3_t65
+ g_vss_m1\x7cmph_g\x7cs1_vss_m1\x7cs2_vss_m1\x7cs3_vss_m1\x7cs4_vss_m1\x7cvss\x7cvss_x1\x7cvss_x2\x7cvss_x3__t65
+ g_vss_m1|mph_g|s1_vss_m1|s2_vss_m1|s3_vss_m1|s4_vss_m1|vss|vss_x1|vss_x2|vss_x3
+ 52.0140109153
* device instance g_vss_m1_mph_g_s1_vss_m1_s2_vss_m1_s3_vss_m1_s4_vss_m1_vss_vss_x1_vss_x2_vss_x3_t66 r0 *1 0,0
Rg_vss_m1_mph_g_s1_vss_m1_s2_vss_m1_s3_vss_m1_s4_vss_m1_vss_vss_x1_vss_x2_vss_x3_t66
+ g_vss_m1\x7cmph_g\x7cs1_vss_m1\x7cs2_vss_m1\x7cs3_vss_m1\x7cs4_vss_m1\x7cvss\x7cvss_x1\x7cvss_x2\x7cvss_x3__t66
+ g_vss_m1|mph_g|s1_vss_m1|s2_vss_m1|s3_vss_m1|s4_vss_m1|vss|vss_x1|vss_x2|vss_x3
+ 212.356175236
* device instance g_vss_m1_mph_g_s1_vss_m1_s2_vss_m1_s3_vss_m1_s4_vss_m1_vss_vss_x1_vss_x2_vss_x3_t67 r0 *1 0,0
Rg_vss_m1_mph_g_s1_vss_m1_s2_vss_m1_s3_vss_m1_s4_vss_m1_vss_vss_x1_vss_x2_vss_x3_t67
+ g_vss_m1\x7cmph_g\x7cs1_vss_m1\x7cs2_vss_m1\x7cs3_vss_m1\x7cs4_vss_m1\x7cvss\x7cvss_x1\x7cvss_x2\x7cvss_x3__t67
+ g_vss_m1|mph_g|s1_vss_m1|s2_vss_m1|s3_vss_m1|s4_vss_m1|vss|vss_x1|vss_x2|vss_x3
+ 72.5222524761
* device instance g_vss_m1_mph_g_s1_vss_m1_s2_vss_m1_s3_vss_m1_s4_vss_m1_vss_vss_x1_vss_x2_vss_x3_t68 r0 *1 0,0
Rg_vss_m1_mph_g_s1_vss_m1_s2_vss_m1_s3_vss_m1_s4_vss_m1_vss_vss_x1_vss_x2_vss_x3_t68
+ g_vss_m1\x7cmph_g\x7cs1_vss_m1\x7cs2_vss_m1\x7cs3_vss_m1\x7cs4_vss_m1\x7cvss\x7cvss_x1\x7cvss_x2\x7cvss_x3__t68
+ g_vss_m1|mph_g|s1_vss_m1|s2_vss_m1|s3_vss_m1|s4_vss_m1|vss|vss_x1|vss_x2|vss_x3
+ 69.8547850446
* device instance g_vss_m1_mph_g_s1_vss_m1_s2_vss_m1_s3_vss_m1_s4_vss_m1_vss_vss_x1_vss_x2_vss_x3_t69 r0 *1 0,0
Rg_vss_m1_mph_g_s1_vss_m1_s2_vss_m1_s3_vss_m1_s4_vss_m1_vss_vss_x1_vss_x2_vss_x3_t69
+ g_vss_m1\x7cmph_g\x7cs1_vss_m1\x7cs2_vss_m1\x7cs3_vss_m1\x7cs4_vss_m1\x7cvss\x7cvss_x1\x7cvss_x2\x7cvss_x3__t69
+ g_vss_m1|mph_g|s1_vss_m1|s2_vss_m1|s3_vss_m1|s4_vss_m1|vss|vss_x1|vss_x2|vss_x3
+ 209.656354135
* device instance g_vss_m1_mph_g_s1_vss_m1_s2_vss_m1_s3_vss_m1_s4_vss_m1_vss_vss_x1_vss_x2_vss_x3_t70 r0 *1 0,0
Rg_vss_m1_mph_g_s1_vss_m1_s2_vss_m1_s3_vss_m1_s4_vss_m1_vss_vss_x1_vss_x2_vss_x3_t70
+ g_vss_m1\x7cmph_g\x7cs1_vss_m1\x7cs2_vss_m1\x7cs3_vss_m1\x7cs4_vss_m1\x7cvss\x7cvss_x1\x7cvss_x2\x7cvss_x3__t70
+ g_vss_m1|mph_g|s1_vss_m1|s2_vss_m1|s3_vss_m1|s4_vss_m1|vss|vss_x1|vss_x2|vss_x3
+ 209.253247464
* device instance g_vss_m1_mph_g_s1_vss_m1_s2_vss_m1_s3_vss_m1_s4_vss_m1_vss_vss_x1_vss_x2_vss_x3_t71 r0 *1 0,0
Rg_vss_m1_mph_g_s1_vss_m1_s2_vss_m1_s3_vss_m1_s4_vss_m1_vss_vss_x1_vss_x2_vss_x3_t71
+ g_vss_m1\x7cmph_g\x7cs1_vss_m1\x7cs2_vss_m1\x7cs3_vss_m1\x7cs4_vss_m1\x7cvss\x7cvss_x1\x7cvss_x2\x7cvss_x3__t71
+ g_vss_m1|mph_g|s1_vss_m1|s2_vss_m1|s3_vss_m1|s4_vss_m1|vss|vss_x1|vss_x2|vss_x3
+ 191.641187936
* device instance g_vss_m1_mph_g_s1_vss_m1_s2_vss_m1_s3_vss_m1_s4_vss_m1_vss_vss_x1_vss_x2_vss_x3_t72 r0 *1 0,0
Rg_vss_m1_mph_g_s1_vss_m1_s2_vss_m1_s3_vss_m1_s4_vss_m1_vss_vss_x1_vss_x2_vss_x3_t72
+ g_vss_m1\x7cmph_g\x7cs1_vss_m1\x7cs2_vss_m1\x7cs3_vss_m1\x7cs4_vss_m1\x7cvss\x7cvss_x1\x7cvss_x2\x7cvss_x3__t72
+ g_vss_m1|mph_g|s1_vss_m1|s2_vss_m1|s3_vss_m1|s4_vss_m1|vss|vss_x1|vss_x2|vss_x3
+ 136.646026782
* device instance g_vss_m1_mph_g_s1_vss_m1_s2_vss_m1_s3_vss_m1_s4_vss_m1_vss_vss_x1_vss_x2_vss_x3_t73 r0 *1 0,0
Rg_vss_m1_mph_g_s1_vss_m1_s2_vss_m1_s3_vss_m1_s4_vss_m1_vss_vss_x1_vss_x2_vss_x3_t73
+ g_vss_m1\x7cmph_g\x7cs1_vss_m1\x7cs2_vss_m1\x7cs3_vss_m1\x7cs4_vss_m1\x7cvss\x7cvss_x1\x7cvss_x2\x7cvss_x3__t73
+ g_vss_m1|mph_g|s1_vss_m1|s2_vss_m1|s3_vss_m1|s4_vss_m1|vss|vss_x1|vss_x2|vss_x3
+ 119.28111081
* device instance g_vss_m1_mph_g_s1_vss_m1_s2_vss_m1_s3_vss_m1_s4_vss_m1_vss_vss_x1_vss_x2_vss_x3_t74 r0 *1 0,0
Rg_vss_m1_mph_g_s1_vss_m1_s2_vss_m1_s3_vss_m1_s4_vss_m1_vss_vss_x1_vss_x2_vss_x3_t74
+ g_vss_m1\x7cmph_g\x7cs1_vss_m1\x7cs2_vss_m1\x7cs3_vss_m1\x7cs4_vss_m1\x7cvss\x7cvss_x1\x7cvss_x2\x7cvss_x3__t74
+ g_vss_m1|mph_g|s1_vss_m1|s2_vss_m1|s3_vss_m1|s4_vss_m1|vss|vss_x1|vss_x2|vss_x3
+ 66.2239149584
* device instance g_vss_m1_mph_g_s1_vss_m1_s2_vss_m1_s3_vss_m1_s4_vss_m1_vss_vss_x1_vss_x2_vss_x3_t75 r0 *1 0,0
Rg_vss_m1_mph_g_s1_vss_m1_s2_vss_m1_s3_vss_m1_s4_vss_m1_vss_vss_x1_vss_x2_vss_x3_t75
+ g_vss_m1\x7cmph_g\x7cs1_vss_m1\x7cs2_vss_m1\x7cs3_vss_m1\x7cs4_vss_m1\x7cvss\x7cvss_x1\x7cvss_x2\x7cvss_x3__t75
+ g_vss_m1|mph_g|s1_vss_m1|s2_vss_m1|s3_vss_m1|s4_vss_m1|vss|vss_x1|vss_x2|vss_x3
+ 50.5754594071
* device instance g_vss_m1_mph_g_s1_vss_m1_s2_vss_m1_s3_vss_m1_s4_vss_m1_vss_vss_x1_vss_x2_vss_x3_t76 r0 *1 0,0
Rg_vss_m1_mph_g_s1_vss_m1_s2_vss_m1_s3_vss_m1_s4_vss_m1_vss_vss_x1_vss_x2_vss_x3_t76
+ g_vss_m1\x7cmph_g\x7cs1_vss_m1\x7cs2_vss_m1\x7cs3_vss_m1\x7cs4_vss_m1\x7cvss\x7cvss_x1\x7cvss_x2\x7cvss_x3__t76
+ g_vss_m1|mph_g|s1_vss_m1|s2_vss_m1|s3_vss_m1|s4_vss_m1|vss|vss_x1|vss_x2|vss_x3
+ 62.2674786199
* device instance g_vss_m1_mph_g_s1_vss_m1_s2_vss_m1_s3_vss_m1_s4_vss_m1_vss_vss_x1_vss_x2_vss_x3_t77 r0 *1 0,0
Rg_vss_m1_mph_g_s1_vss_m1_s2_vss_m1_s3_vss_m1_s4_vss_m1_vss_vss_x1_vss_x2_vss_x3_t77
+ g_vss_m1\x7cmph_g\x7cs1_vss_m1\x7cs2_vss_m1\x7cs3_vss_m1\x7cs4_vss_m1\x7cvss\x7cvss_x1\x7cvss_x2\x7cvss_x3__t77
+ g_vss_m1|mph_g|s1_vss_m1|s2_vss_m1|s3_vss_m1|s4_vss_m1|vss|vss_x1|vss_x2|vss_x3
+ 85.585461962
* device instance g_vss_m1_mph_g_s1_vss_m1_s2_vss_m1_s3_vss_m1_s4_vss_m1_vss_vss_x1_vss_x2_vss_x3_t78 r0 *1 0,0
Rg_vss_m1_mph_g_s1_vss_m1_s2_vss_m1_s3_vss_m1_s4_vss_m1_vss_vss_x1_vss_x2_vss_x3_t78
+ g_vss_m1\x7cmph_g\x7cs1_vss_m1\x7cs2_vss_m1\x7cs3_vss_m1\x7cs4_vss_m1\x7cvss\x7cvss_x1\x7cvss_x2\x7cvss_x3__t78
+ g_vss_m1|mph_g|s1_vss_m1|s2_vss_m1|s3_vss_m1|s4_vss_m1|vss|vss_x1|vss_x2|vss_x3
+ 106.193401944
* device instance g_vss_m1_mph_g_s1_vss_m1_s2_vss_m1_s3_vss_m1_s4_vss_m1_vss_vss_x1_vss_x2_vss_x3_t79 r0 *1 0,0
Rg_vss_m1_mph_g_s1_vss_m1_s2_vss_m1_s3_vss_m1_s4_vss_m1_vss_vss_x1_vss_x2_vss_x3_t79
+ g_vss_m1\x7cmph_g\x7cs1_vss_m1\x7cs2_vss_m1\x7cs3_vss_m1\x7cs4_vss_m1\x7cvss\x7cvss_x1\x7cvss_x2\x7cvss_x3__t79
+ g_vss_m1|mph_g|s1_vss_m1|s2_vss_m1|s3_vss_m1|s4_vss_m1|vss|vss_x1|vss_x2|vss_x3
+ 126.852132433
* device instance g_vss_m1_mph_g_s1_vss_m1_s2_vss_m1_s3_vss_m1_s4_vss_m1_vss_vss_x1_vss_x2_vss_x3_t80 r0 *1 0,0
Rg_vss_m1_mph_g_s1_vss_m1_s2_vss_m1_s3_vss_m1_s4_vss_m1_vss_vss_x1_vss_x2_vss_x3_t80
+ g_vss_m1\x7cmph_g\x7cs1_vss_m1\x7cs2_vss_m1\x7cs3_vss_m1\x7cs4_vss_m1\x7cvss\x7cvss_x1\x7cvss_x2\x7cvss_x3__t80
+ g_vss_m1|mph_g|s1_vss_m1|s2_vss_m1|s3_vss_m1|s4_vss_m1|vss|vss_x1|vss_x2|vss_x3
+ 147.540319773
* device instance g_vss_m1_mph_g_s1_vss_m1_s2_vss_m1_s3_vss_m1_s4_vss_m1_vss_vss_x1_vss_x2_vss_x3_t81 r0 *1 0,0
Rg_vss_m1_mph_g_s1_vss_m1_s2_vss_m1_s3_vss_m1_s4_vss_m1_vss_vss_x1_vss_x2_vss_x3_t81
+ g_vss_m1\x7cmph_g\x7cs1_vss_m1\x7cs2_vss_m1\x7cs3_vss_m1\x7cs4_vss_m1\x7cvss\x7cvss_x1\x7cvss_x2\x7cvss_x3__t81
+ g_vss_m1|mph_g|s1_vss_m1|s2_vss_m1|s3_vss_m1|s4_vss_m1|vss|vss_x1|vss_x2|vss_x3
+ 201.960141844
* device instance g_vss_m1_mph_g_s1_vss_m1_s2_vss_m1_s3_vss_m1_s4_vss_m1_vss_vss_x1_vss_x2_vss_x3_t82 r0 *1 0,0
Rg_vss_m1_mph_g_s1_vss_m1_s2_vss_m1_s3_vss_m1_s4_vss_m1_vss_vss_x1_vss_x2_vss_x3_t82
+ g_vss_m1\x7cmph_g\x7cs1_vss_m1\x7cs2_vss_m1\x7cs3_vss_m1\x7cs4_vss_m1\x7cvss\x7cvss_x1\x7cvss_x2\x7cvss_x3__t82
+ g_vss_m1|mph_g|s1_vss_m1|s2_vss_m1|s3_vss_m1|s4_vss_m1|vss|vss_x1|vss_x2|vss_x3
+ 225.545935344
* device instance g_vss_m1_mph_g_s1_vss_m1_s2_vss_m1_s3_vss_m1_s4_vss_m1_vss_vss_x1_vss_x2_vss_x3_t83 r0 *1 0,0
Rg_vss_m1_mph_g_s1_vss_m1_s2_vss_m1_s3_vss_m1_s4_vss_m1_vss_vss_x1_vss_x2_vss_x3_t83
+ g_vss_m1\x7cmph_g\x7cs1_vss_m1\x7cs2_vss_m1\x7cs3_vss_m1\x7cs4_vss_m1\x7cvss\x7cvss_x1\x7cvss_x2\x7cvss_x3__t83
+ g_vss_m1|mph_g|s1_vss_m1|s2_vss_m1|s3_vss_m1|s4_vss_m1|vss|vss_x1|vss_x2|vss_x3
+ 246.284185463
* device instance g_vss_m1_mph_g_s1_vss_m1_s2_vss_m1_s3_vss_m1_s4_vss_m1_vss_vss_x1_vss_x2_vss_x3_t84 r0 *1 0,0
Rg_vss_m1_mph_g_s1_vss_m1_s2_vss_m1_s3_vss_m1_s4_vss_m1_vss_vss_x1_vss_x2_vss_x3_t84
+ g_vss_m1\x7cmph_g\x7cs1_vss_m1\x7cs2_vss_m1\x7cs3_vss_m1\x7cs4_vss_m1\x7cvss\x7cvss_x1\x7cvss_x2\x7cvss_x3__t84
+ g_vss_m1|mph_g|s1_vss_m1|s2_vss_m1|s3_vss_m1|s4_vss_m1|vss|vss_x1|vss_x2|vss_x3
+ 267.026381912
* device instance g_vss_m1_mph_g_s1_vss_m1_s2_vss_m1_s3_vss_m1_s4_vss_m1_vss_vss_x1_vss_x2_vss_x3_t85 r0 *1 0,0
Rg_vss_m1_mph_g_s1_vss_m1_s2_vss_m1_s3_vss_m1_s4_vss_m1_vss_vss_x1_vss_x2_vss_x3_t85
+ g_vss_m1\x7cmph_g\x7cs1_vss_m1\x7cs2_vss_m1\x7cs3_vss_m1\x7cs4_vss_m1\x7cvss\x7cvss_x1\x7cvss_x2\x7cvss_x3__t85
+ g_vss_m1|mph_g|s1_vss_m1|s2_vss_m1|s3_vss_m1|s4_vss_m1|vss|vss_x1|vss_x2|vss_x3
+ 287.771671355
* device instance g_vss_m1_mph_g_s1_vss_m1_s2_vss_m1_s3_vss_m1_s4_vss_m1_vss_vss_x1_vss_x2_vss_x3_t86 r0 *1 0,0
Rg_vss_m1_mph_g_s1_vss_m1_s2_vss_m1_s3_vss_m1_s4_vss_m1_vss_vss_x1_vss_x2_vss_x3_t86
+ g_vss_m1\x7cmph_g\x7cs1_vss_m1\x7cs2_vss_m1\x7cs3_vss_m1\x7cs4_vss_m1\x7cvss\x7cvss_x1\x7cvss_x2\x7cvss_x3__t86
+ g_vss_m1|mph_g|s1_vss_m1|s2_vss_m1|s3_vss_m1|s4_vss_m1|vss|vss_x1|vss_x2|vss_x3
+ 220.053549692
* device instance g_vss_m1_mph_g_s1_vss_m1_s2_vss_m1_s3_vss_m1_s4_vss_m1_vss_vss_x1_vss_x2_vss_x3_t87 r0 *1 0,0
Rg_vss_m1_mph_g_s1_vss_m1_s2_vss_m1_s3_vss_m1_s4_vss_m1_vss_vss_x1_vss_x2_vss_x3_t87
+ g_vss_m1\x7cmph_g\x7cs1_vss_m1\x7cs2_vss_m1\x7cs3_vss_m1\x7cs4_vss_m1\x7cvss\x7cvss_x1\x7cvss_x2\x7cvss_x3__t87
+ g_vss_m1|mph_g|s1_vss_m1|s2_vss_m1|s3_vss_m1|s4_vss_m1|vss|vss_x1|vss_x2|vss_x3
+ 196.469646093
* device instance g_vss_m1_mph_g_s1_vss_m1_s2_vss_m1_s3_vss_m1_s4_vss_m1_vss_vss_x1_vss_x2_vss_x3_t88 r0 *1 0,0
Rg_vss_m1_mph_g_s1_vss_m1_s2_vss_m1_s3_vss_m1_s4_vss_m1_vss_vss_x1_vss_x2_vss_x3_t88
+ g_vss_m1\x7cmph_g\x7cs1_vss_m1\x7cs2_vss_m1\x7cs3_vss_m1\x7cs4_vss_m1\x7cvss\x7cvss_x1\x7cvss_x2\x7cvss_x3__t88
+ g_vss_m1|mph_g|s1_vss_m1|s2_vss_m1|s3_vss_m1|s4_vss_m1|vss|vss_x1|vss_x2|vss_x3
+ 175.746868165
* device instance g_vss_m1_mph_g_s1_vss_m1_s2_vss_m1_s3_vss_m1_s4_vss_m1_vss_vss_x1_vss_x2_vss_x3_t89 r0 *1 0,0
Rg_vss_m1_mph_g_s1_vss_m1_s2_vss_m1_s3_vss_m1_s4_vss_m1_vss_vss_x1_vss_x2_vss_x3_t89
+ g_vss_m1\x7cmph_g\x7cs1_vss_m1\x7cs2_vss_m1\x7cs3_vss_m1\x7cs4_vss_m1\x7cvss\x7cvss_x1\x7cvss_x2\x7cvss_x3__t89
+ g_vss_m1|mph_g|s1_vss_m1|s2_vss_m1|s3_vss_m1|s4_vss_m1|vss|vss_x1|vss_x2|vss_x3
+ 155.03502531
* device instance g_vss_m1_mph_g_s1_vss_m1_s2_vss_m1_s3_vss_m1_s4_vss_m1_vss_vss_x1_vss_x2_vss_x3_t90 r0 *1 0,0
Rg_vss_m1_mph_g_s1_vss_m1_s2_vss_m1_s3_vss_m1_s4_vss_m1_vss_vss_x1_vss_x2_vss_x3_t90
+ g_vss_m1\x7cmph_g\x7cs1_vss_m1\x7cs2_vss_m1\x7cs3_vss_m1\x7cs4_vss_m1\x7cvss\x7cvss_x1\x7cvss_x2\x7cvss_x3__t90
+ g_vss_m1|mph_g|s1_vss_m1|s2_vss_m1|s3_vss_m1|s4_vss_m1|vss|vss_x1|vss_x2|vss_x3
+ 134.339175394
* device instance g_vss_m1_mph_g_s1_vss_m1_s2_vss_m1_s3_vss_m1_s4_vss_m1_vss_vss_x1_vss_x2_vss_x3_t91 r0 *1 0,0
Rg_vss_m1_mph_g_s1_vss_m1_s2_vss_m1_s3_vss_m1_s4_vss_m1_vss_vss_x1_vss_x2_vss_x3_t91
+ g_vss_m1\x7cmph_g\x7cs1_vss_m1\x7cs2_vss_m1\x7cs3_vss_m1\x7cs4_vss_m1\x7cvss\x7cvss_x1\x7cvss_x2\x7cvss_x3__t91
+ g_vss_m1|mph_g|s1_vss_m1|s2_vss_m1|s3_vss_m1|s4_vss_m1|vss|vss_x1|vss_x2|vss_x3
+ 190.473701188
* device instance g_vss_m1_mph_g_s1_vss_m1_s2_vss_m1_s3_vss_m1_s4_vss_m1_vss_vss_x1_vss_x2_vss_x3_t92 r0 *1 0,0
Rg_vss_m1_mph_g_s1_vss_m1_s2_vss_m1_s3_vss_m1_s4_vss_m1_vss_vss_x1_vss_x2_vss_x3_t92
+ g_vss_m1\x7cmph_g\x7cs1_vss_m1\x7cs2_vss_m1\x7cs3_vss_m1\x7cs4_vss_m1\x7cvss\x7cvss_x1\x7cvss_x2\x7cvss_x3__t92
+ g_vss_m1|mph_g|s1_vss_m1|s2_vss_m1|s3_vss_m1|s4_vss_m1|vss|vss_x1|vss_x2|vss_x3
+ 169.753700674
* device instance g_vss_m1_mph_g_s1_vss_m1_s2_vss_m1_s3_vss_m1_s4_vss_m1_vss_vss_x1_vss_x2_vss_x3_t93 r0 *1 0,0
Rg_vss_m1_mph_g_s1_vss_m1_s2_vss_m1_s3_vss_m1_s4_vss_m1_vss_vss_x1_vss_x2_vss_x3_t93
+ g_vss_m1\x7cmph_g\x7cs1_vss_m1\x7cs2_vss_m1\x7cs3_vss_m1\x7cs4_vss_m1\x7cvss\x7cvss_x1\x7cvss_x2\x7cvss_x3__t93
+ g_vss_m1|mph_g|s1_vss_m1|s2_vss_m1|s3_vss_m1|s4_vss_m1|vss|vss_x1|vss_x2|vss_x3
+ 149.045847007
* device instance g_vss_m1_mph_g_s1_vss_m1_s2_vss_m1_s3_vss_m1_s4_vss_m1_vss_vss_x1_vss_x2_vss_x3_t94 r0 *1 0,0
Rg_vss_m1_mph_g_s1_vss_m1_s2_vss_m1_s3_vss_m1_s4_vss_m1_vss_vss_x1_vss_x2_vss_x3_t94
+ g_vss_m1\x7cmph_g\x7cs1_vss_m1\x7cs2_vss_m1\x7cs3_vss_m1\x7cs4_vss_m1\x7cvss\x7cvss_x1\x7cvss_x2\x7cvss_x3__t94
+ g_vss_m1|mph_g|s1_vss_m1|s2_vss_m1|s3_vss_m1|s4_vss_m1|vss|vss_x1|vss_x2|vss_x3
+ 128.356019325
* device instance g_vss_m1_mph_g_s1_vss_m1_s2_vss_m1_s3_vss_m1_s4_vss_m1_vss_vss_x1_vss_x2_vss_x3_t95 r0 *1 0,0
Rg_vss_m1_mph_g_s1_vss_m1_s2_vss_m1_s3_vss_m1_s4_vss_m1_vss_vss_x1_vss_x2_vss_x3_t95
+ g_vss_m1\x7cmph_g\x7cs1_vss_m1\x7cs2_vss_m1\x7cs3_vss_m1\x7cs4_vss_m1\x7cvss\x7cvss_x1\x7cvss_x2\x7cvss_x3__t95
+ g_vss_m1|mph_g|s1_vss_m1|s2_vss_m1|s3_vss_m1|s4_vss_m1|vss|vss_x1|vss_x2|vss_x3
+ 105.460276245
* device instance g_vss_m1_mph_g_s1_vss_m1_s2_vss_m1_s3_vss_m1_s4_vss_m1_vss_vss_x1_vss_x2_vss_x3_t96 r0 *1 0,0
Rg_vss_m1_mph_g_s1_vss_m1_s2_vss_m1_s3_vss_m1_s4_vss_m1_vss_vss_x1_vss_x2_vss_x3_t96
+ g_vss_m1\x7cmph_g\x7cs1_vss_m1\x7cs2_vss_m1\x7cs3_vss_m1\x7cs4_vss_m1\x7cvss\x7cvss_x1\x7cvss_x2\x7cvss_x3__t96
+ g_vss_m1|mph_g|s1_vss_m1|s2_vss_m1|s3_vss_m1|s4_vss_m1|vss|vss_x1|vss_x2|vss_x3
+ 51.0094455219
* device instance g_vss_m1_mph_g_s1_vss_m1_s2_vss_m1_s3_vss_m1_s4_vss_m1_vss_vss_x1_vss_x2_vss_x3_t97 r0 *1 0,0
Rg_vss_m1_mph_g_s1_vss_m1_s2_vss_m1_s3_vss_m1_s4_vss_m1_vss_vss_x1_vss_x2_vss_x3_t97
+ g_vss_m1\x7cmph_g\x7cs1_vss_m1\x7cs2_vss_m1\x7cs3_vss_m1\x7cs4_vss_m1\x7cvss\x7cvss_x1\x7cvss_x2\x7cvss_x3__t97
+ g_vss_m1|mph_g|s1_vss_m1|s2_vss_m1|s3_vss_m1|s4_vss_m1|vss|vss_x1|vss_x2|vss_x3
+ 31.1579094651
* device instance g_vss_m1_mph_g_s1_vss_m1_s2_vss_m1_s3_vss_m1_s4_vss_m1_vss_vss_x1_vss_x2_vss_x3_t98 r0 *1 0,0
Rg_vss_m1_mph_g_s1_vss_m1_s2_vss_m1_s3_vss_m1_s4_vss_m1_vss_vss_x1_vss_x2_vss_x3_t98
+ g_vss_m1\x7cmph_g\x7cs1_vss_m1\x7cs2_vss_m1\x7cs3_vss_m1\x7cs4_vss_m1\x7cvss\x7cvss_x1\x7cvss_x2\x7cvss_x3__t98
+ g_vss_m1|mph_g|s1_vss_m1|s2_vss_m1|s3_vss_m1|s4_vss_m1|vss|vss_x1|vss_x2|vss_x3
+ 14.2100204577
* device instance g_vss_m1_mph_g_s1_vss_m1_s2_vss_m1_s3_vss_m1_s4_vss_m1_vss_vss_x1_vss_x2_vss_x3_t99 r0 *1 0,0
Rg_vss_m1_mph_g_s1_vss_m1_s2_vss_m1_s3_vss_m1_s4_vss_m1_vss_vss_x1_vss_x2_vss_x3_t99
+ g_vss_m1\x7cmph_g\x7cs1_vss_m1\x7cs2_vss_m1\x7cs3_vss_m1\x7cs4_vss_m1\x7cvss\x7cvss_x1\x7cvss_x2\x7cvss_x3__t99
+ g_vss_m1|mph_g|s1_vss_m1|s2_vss_m1|s3_vss_m1|s4_vss_m1|vss|vss_x1|vss_x2|vss_x3
+ 17.184051035
* device instance g_vss_m1_mph_g_s1_vss_m1_s2_vss_m1_s3_vss_m1_s4_vss_m1_vss_vss_x1_vss_x2_vss_x3_t100 r0 *1 0,0
Rg_vss_m1_mph_g_s1_vss_m1_s2_vss_m1_s3_vss_m1_s4_vss_m1_vss_vss_x1_vss_x2_vss_x3_t100
+ g_vss_m1\x7cmph_g\x7cs1_vss_m1\x7cs2_vss_m1\x7cs3_vss_m1\x7cs4_vss_m1\x7cvss\x7cvss_x1\x7cvss_x2\x7cvss_x3__t100
+ g_vss_m1|mph_g|s1_vss_m1|s2_vss_m1|s3_vss_m1|s4_vss_m1|vss|vss_x1|vss_x2|vss_x3
+ 37.4979243289
* device instance g_vss_m1_mph_g_s1_vss_m1_s2_vss_m1_s3_vss_m1_s4_vss_m1_vss_vss_x1_vss_x2_vss_x3_t101 r0 *1 0,0
Rg_vss_m1_mph_g_s1_vss_m1_s2_vss_m1_s3_vss_m1_s4_vss_m1_vss_vss_x1_vss_x2_vss_x3_t101
+ g_vss_m1\x7cmph_g\x7cs1_vss_m1\x7cs2_vss_m1\x7cs3_vss_m1\x7cs4_vss_m1\x7cvss\x7cvss_x1\x7cvss_x2\x7cvss_x3__t101
+ g_vss_m1|mph_g|s1_vss_m1|s2_vss_m1|s3_vss_m1|s4_vss_m1|vss|vss_x1|vss_x2|vss_x3
+ 91.5400358686
* device instance g_vss_m1_mph_g_s1_vss_m1_s2_vss_m1_s3_vss_m1_s4_vss_m1_vss_vss_x1_vss_x2_vss_x3_t102 r0 *1 0,0
Rg_vss_m1_mph_g_s1_vss_m1_s2_vss_m1_s3_vss_m1_s4_vss_m1_vss_vss_x1_vss_x2_vss_x3_t102
+ g_vss_m1\x7cmph_g\x7cs1_vss_m1\x7cs2_vss_m1\x7cs3_vss_m1\x7cs4_vss_m1\x7cvss\x7cvss_x1\x7cvss_x2\x7cvss_x3__t102
+ g_vss_m1|mph_g|s1_vss_m1|s2_vss_m1|s3_vss_m1|s4_vss_m1|vss|vss_x1|vss_x2|vss_x3
+ 112.165920396
* device instance g_vss_m1_mph_g_s1_vss_m1_s2_vss_m1_s3_vss_m1_s4_vss_m1_vss_vss_x1_vss_x2_vss_x3_t103 r0 *1 0,0
Rg_vss_m1_mph_g_s1_vss_m1_s2_vss_m1_s3_vss_m1_s4_vss_m1_vss_vss_x1_vss_x2_vss_x3_t103
+ g_vss_m1\x7cmph_g\x7cs1_vss_m1\x7cs2_vss_m1\x7cs3_vss_m1\x7cs4_vss_m1\x7cvss\x7cvss_x1\x7cvss_x2\x7cvss_x3__t103
+ g_vss_m1|mph_g|s1_vss_m1|s2_vss_m1|s3_vss_m1|s4_vss_m1|vss|vss_x1|vss_x2|vss_x3
+ 132.834734911
* device instance g_vss_m1_mph_g_s1_vss_m1_s2_vss_m1_s3_vss_m1_s4_vss_m1_vss_vss_x1_vss_x2_vss_x3_t104 r0 *1 0,0
Rg_vss_m1_mph_g_s1_vss_m1_s2_vss_m1_s3_vss_m1_s4_vss_m1_vss_vss_x1_vss_x2_vss_x3_t104
+ g_vss_m1\x7cmph_g\x7cs1_vss_m1\x7cs2_vss_m1\x7cs3_vss_m1\x7cs4_vss_m1\x7cvss\x7cvss_x1\x7cvss_x2\x7cvss_x3__t104
+ g_vss_m1|mph_g|s1_vss_m1|s2_vss_m1|s3_vss_m1|s4_vss_m1|vss|vss_x1|vss_x2|vss_x3
+ 153.529142084
* device instance g_vss_m1_mph_g_s1_vss_m1_s2_vss_m1_s3_vss_m1_s4_vss_m1_vss_vss_x1_vss_x2_vss_x3_t105 r0 *1 0,0
Rg_vss_m1_mph_g_s1_vss_m1_s2_vss_m1_s3_vss_m1_s4_vss_m1_vss_vss_x1_vss_x2_vss_x3_t105
+ g_vss_m1\x7cmph_g\x7cs1_vss_m1\x7cs2_vss_m1\x7cs3_vss_m1\x7cs4_vss_m1\x7cvss\x7cvss_x1\x7cvss_x2\x7cvss_x3__t105
+ g_vss_m1|mph_g|s1_vss_m1|s2_vss_m1|s3_vss_m1|s4_vss_m1|vss|vss_x1|vss_x2|vss_x3
+ 176.48286245
* device instance g_vss_m1_mph_g_s1_vss_m1_s2_vss_m1_s3_vss_m1_s4_vss_m1_vss_vss_x1_vss_x2_vss_x3_t106 r0 *1 0,0
Rg_vss_m1_mph_g_s1_vss_m1_s2_vss_m1_s3_vss_m1_s4_vss_m1_vss_vss_x1_vss_x2_vss_x3_t106
+ g_vss_m1\x7cmph_g\x7cs1_vss_m1\x7cs2_vss_m1\x7cs3_vss_m1\x7cs4_vss_m1\x7cvss\x7cvss_x1\x7cvss_x2\x7cvss_x3__t106
+ g_vss_m1|mph_g|s1_vss_m1|s2_vss_m1|s3_vss_m1|s4_vss_m1|vss|vss_x1|vss_x2|vss_x3
+ 231.544973488
* device instance g_vss_m1_mph_g_s1_vss_m1_s2_vss_m1_s3_vss_m1_s4_vss_m1_vss_vss_x1_vss_x2_vss_x3_t107 r0 *1 0,0
Rg_vss_m1_mph_g_s1_vss_m1_s2_vss_m1_s3_vss_m1_s4_vss_m1_vss_vss_x1_vss_x2_vss_x3_t107
+ g_vss_m1\x7cmph_g\x7cs1_vss_m1\x7cs2_vss_m1\x7cs3_vss_m1\x7cs4_vss_m1\x7cvss\x7cvss_x1\x7cvss_x2\x7cvss_x3__t107
+ g_vss_m1|mph_g|s1_vss_m1|s2_vss_m1|s3_vss_m1|s4_vss_m1|vss|vss_x1|vss_x2|vss_x3
+ 252.28447043
* device instance g_vss_m1_mph_g_s1_vss_m1_s2_vss_m1_s3_vss_m1_s4_vss_m1_vss_vss_x1_vss_x2_vss_x3_t108 r0 *1 0,0
Rg_vss_m1_mph_g_s1_vss_m1_s2_vss_m1_s3_vss_m1_s4_vss_m1_vss_vss_x1_vss_x2_vss_x3_t108
+ g_vss_m1\x7cmph_g\x7cs1_vss_m1\x7cs2_vss_m1\x7cs3_vss_m1\x7cs4_vss_m1\x7cvss\x7cvss_x1\x7cvss_x2\x7cvss_x3__t108
+ g_vss_m1|mph_g|s1_vss_m1|s2_vss_m1|s3_vss_m1|s4_vss_m1|vss|vss_x1|vss_x2|vss_x3
+ 273.027637544
* device instance g_vss_m1_mph_g_s1_vss_m1_s2_vss_m1_s3_vss_m1_s4_vss_m1_vss_vss_x1_vss_x2_vss_x3_t109 r0 *1 0,0
Rg_vss_m1_mph_g_s1_vss_m1_s2_vss_m1_s3_vss_m1_s4_vss_m1_vss_vss_x1_vss_x2_vss_x3_t109
+ g_vss_m1\x7cmph_g\x7cs1_vss_m1\x7cs2_vss_m1\x7cs3_vss_m1\x7cs4_vss_m1\x7cvss\x7cvss_x1\x7cvss_x2\x7cvss_x3__t109
+ g_vss_m1|mph_g|s1_vss_m1|s2_vss_m1|s3_vss_m1|s4_vss_m1|vss|vss_x1|vss_x2|vss_x3
+ 293.773697384
* device instance g_vss_m1_mph_g_s1_vss_m1_s2_vss_m1_s3_vss_m1_s4_vss_m1_vss_vss_x1_vss_x2_vss_x3_t110 r0 *1 0,0
Rg_vss_m1_mph_g_s1_vss_m1_s2_vss_m1_s3_vss_m1_s4_vss_m1_vss_vss_x1_vss_x2_vss_x3_t110
+ g_vss_m1\x7cmph_g\x7cs1_vss_m1\x7cs2_vss_m1\x7cs3_vss_m1\x7cs4_vss_m1\x7cvss\x7cvss_x1\x7cvss_x2\x7cvss_x3__t110
+ g_vss_m1|mph_g|s1_vss_m1|s2_vss_m1|s3_vss_m1|s4_vss_m1|vss|vss_x1|vss_x2|vss_x3
+ 316.768352419
* device instance g_vss_m1_mph_g_s1_vss_m1_s2_vss_m1_s3_vss_m1_s4_vss_m1_vss_vss_x1_vss_x2_vss_x3_t111 r0 *1 0,0
Rg_vss_m1_mph_g_s1_vss_m1_s2_vss_m1_s3_vss_m1_s4_vss_m1_vss_vss_x1_vss_x2_vss_x3_t111
+ g_vss_m1\x7cmph_g\x7cs1_vss_m1\x7cs2_vss_m1\x7cs3_vss_m1\x7cs4_vss_m1\x7cvss\x7cvss_x1\x7cvss_x2\x7cvss_x3__t111
+ g_vss_m1|mph_g|s1_vss_m1|s2_vss_m1|s3_vss_m1|s4_vss_m1|vss|vss_x1|vss_x2|vss_x3
+ 222.666716336
* device instance g_vss_m1_mph_g_s1_vss_m1_s2_vss_m1_s3_vss_m1_s4_vss_m1_vss_vss_x1_vss_x2_vss_x3_t112 r0 *1 0,0
Rg_vss_m1_mph_g_s1_vss_m1_s2_vss_m1_s3_vss_m1_s4_vss_m1_vss_vss_x1_vss_x2_vss_x3_t112
+ g_vss_m1\x7cmph_g\x7cs1_vss_m1\x7cs2_vss_m1\x7cs3_vss_m1\x7cs4_vss_m1\x7cvss\x7cvss_x1\x7cvss_x2\x7cvss_x3__t112
+ g_vss_m1|mph_g|s1_vss_m1|s2_vss_m1|s3_vss_m1|s4_vss_m1|vss|vss_x1|vss_x2|vss_x3
+ 177.157493945
* device instance g_vss_m1_mph_g_s1_vss_m1_s2_vss_m1_s3_vss_m1_s4_vss_m1_vss_vss_x1_vss_x2_vss_x3_t113 r0 *1 0,0
Rg_vss_m1_mph_g_s1_vss_m1_s2_vss_m1_s3_vss_m1_s4_vss_m1_vss_vss_x1_vss_x2_vss_x3_t113
+ g_vss_m1\x7cmph_g\x7cs1_vss_m1\x7cs2_vss_m1\x7cs3_vss_m1\x7cs4_vss_m1\x7cvss\x7cvss_x1\x7cvss_x2\x7cvss_x3__t113
+ g_vss_m1|mph_g|s1_vss_m1|s2_vss_m1|s3_vss_m1|s4_vss_m1|vss|vss_x1|vss_x2|vss_x3
+ 150.316129803
* device instance g_vss_m1_mph_g_s1_vss_m1_s2_vss_m1_s3_vss_m1_s4_vss_m1_vss_vss_x1_vss_x2_vss_x3_t114 r0 *1 0,0
Rg_vss_m1_mph_g_s1_vss_m1_s2_vss_m1_s3_vss_m1_s4_vss_m1_vss_vss_x1_vss_x2_vss_x3_t114
+ g_vss_m1\x7cmph_g\x7cs1_vss_m1\x7cs2_vss_m1\x7cs3_vss_m1\x7cs4_vss_m1\x7cvss\x7cvss_x1\x7cvss_x2\x7cvss_x3__t114
+ g_vss_m1|mph_g|s1_vss_m1|s2_vss_m1|s3_vss_m1|s4_vss_m1|vss|vss_x1|vss_x2|vss_x3
+ 105.79511568
* device instance g_vss_m1_mph_g_s1_vss_m1_s2_vss_m1_s3_vss_m1_s4_vss_m1_vss_vss_x1_vss_x2_vss_x3_t115 r0 *1 0,0
Rg_vss_m1_mph_g_s1_vss_m1_s2_vss_m1_s3_vss_m1_s4_vss_m1_vss_vss_x1_vss_x2_vss_x3_t115
+ g_vss_m1\x7cmph_g\x7cs1_vss_m1\x7cs2_vss_m1\x7cs3_vss_m1\x7cs4_vss_m1\x7cvss\x7cvss_x1\x7cvss_x2\x7cvss_x3__t115
+ g_vss_m1|mph_g|s1_vss_m1|s2_vss_m1|s3_vss_m1|s4_vss_m1|vss|vss_x1|vss_x2|vss_x3
+ 80.2350697012
* device instance g_vss_m1_mph_g_s1_vss_m1_s2_vss_m1_s3_vss_m1_s4_vss_m1_vss_vss_x1_vss_x2_vss_x3_t116 r0 *1 0,0
Rg_vss_m1_mph_g_s1_vss_m1_s2_vss_m1_s3_vss_m1_s4_vss_m1_vss_vss_x1_vss_x2_vss_x3_t116
+ g_vss_m1\x7cmph_g\x7cs1_vss_m1\x7cs2_vss_m1\x7cs3_vss_m1\x7cs4_vss_m1\x7cvss\x7cvss_x1\x7cvss_x2\x7cvss_x3__t116
+ g_vss_m1|mph_g|s1_vss_m1|s2_vss_m1|s3_vss_m1|s4_vss_m1|vss|vss_x1|vss_x2|vss_x3
+ 42.7631916268
* device instance g_vss_m1_mph_g_s1_vss_m1_s2_vss_m1_s3_vss_m1_s4_vss_m1_vss_vss_x1_vss_x2_vss_x3_t117 r0 *1 0,0
Rg_vss_m1_mph_g_s1_vss_m1_s2_vss_m1_s3_vss_m1_s4_vss_m1_vss_vss_x1_vss_x2_vss_x3_t117
+ g_vss_m1\x7cmph_g\x7cs1_vss_m1\x7cs2_vss_m1\x7cs3_vss_m1\x7cs4_vss_m1\x7cvss\x7cvss_x1\x7cvss_x2\x7cvss_x3__t117
+ g_vss_m1|mph_g|s1_vss_m1|s2_vss_m1|s3_vss_m1|s4_vss_m1|vss|vss_x1|vss_x2|vss_x3
+ 80.1402572982
* device instance g_vss_m1_mph_g_s1_vss_m1_s2_vss_m1_s3_vss_m1_s4_vss_m1_vss_vss_x1_vss_x2_vss_x3_t118 r0 *1 0,0
Rg_vss_m1_mph_g_s1_vss_m1_s2_vss_m1_s3_vss_m1_s4_vss_m1_vss_vss_x1_vss_x2_vss_x3_t118
+ g_vss_m1\x7cmph_g\x7cs1_vss_m1\x7cs2_vss_m1\x7cs3_vss_m1\x7cs4_vss_m1\x7cvss\x7cvss_x1\x7cvss_x2\x7cvss_x3__t118
+ g_vss_m1|mph_g|s1_vss_m1|s2_vss_m1|s3_vss_m1|s4_vss_m1|vss|vss_x1|vss_x2|vss_x3
+ 56.8740326898
* device instance g_vss_m1_mph_g_s1_vss_m1_s2_vss_m1_s3_vss_m1_s4_vss_m1_vss_vss_x1_vss_x2_vss_x3_t119 r0 *1 0,0
Rg_vss_m1_mph_g_s1_vss_m1_s2_vss_m1_s3_vss_m1_s4_vss_m1_vss_vss_x1_vss_x2_vss_x3_t119
+ g_vss_m1\x7cmph_g\x7cs1_vss_m1\x7cs2_vss_m1\x7cs3_vss_m1\x7cs4_vss_m1\x7cvss\x7cvss_x1\x7cvss_x2\x7cvss_x3__t119
+ g_vss_m1|mph_g|s1_vss_m1|s2_vss_m1|s3_vss_m1|s4_vss_m1|vss|vss_x1|vss_x2|vss_x3
+ 36.7975429874
* device instance g_vss_m1_mph_g_s1_vss_m1_s2_vss_m1_s3_vss_m1_s4_vss_m1_vss_vss_x1_vss_x2_vss_x3_t120 r0 *1 0,0
Rg_vss_m1_mph_g_s1_vss_m1_s2_vss_m1_s3_vss_m1_s4_vss_m1_vss_vss_x1_vss_x2_vss_x3_t120
+ g_vss_m1\x7cmph_g\x7cs1_vss_m1\x7cs2_vss_m1\x7cs3_vss_m1\x7cs4_vss_m1\x7cvss\x7cvss_x1\x7cvss_x2\x7cvss_x3__t120
+ g_vss_m1|mph_g|s1_vss_m1|s2_vss_m1|s3_vss_m1|s4_vss_m1|vss|vss_x1|vss_x2|vss_x3
+ 18.3226721527
* device instance g_vss_m1_mph_g_s1_vss_m1_s2_vss_m1_s3_vss_m1_s4_vss_m1_vss_vss_x1_vss_x2_vss_x3_t121 r0 *1 0,0
Rg_vss_m1_mph_g_s1_vss_m1_s2_vss_m1_s3_vss_m1_s4_vss_m1_vss_vss_x1_vss_x2_vss_x3_t121
+ g_vss_m1\x7cmph_g\x7cs1_vss_m1\x7cs2_vss_m1\x7cs3_vss_m1\x7cs4_vss_m1\x7cvss\x7cvss_x1\x7cvss_x2\x7cvss_x3__t121
+ g_vss_m1|mph_g|s1_vss_m1|s2_vss_m1|s3_vss_m1|s4_vss_m1|vss|vss_x1|vss_x2|vss_x3
+ 13.4029485233
* device instance g_vss_m1_mph_g_s1_vss_m1_s2_vss_m1_s3_vss_m1_s4_vss_m1_vss_vss_x1_vss_x2_vss_x3 r0 *1 0,0
Cg_vss_m1_mph_g_s1_vss_m1_s2_vss_m1_s3_vss_m1_s4_vss_m1_vss_vss_x1_vss_x2_vss_x3
+ g_vss_m1|mph_g|s1_vss_m1|s2_vss_m1|s3_vss_m1|s4_vss_m1|vss|vss_x1|vss_x2|vss_x3
+ vsubs 1.03531672e-13
* device instance mid_t0 r0 *1 0,0
Rmid_t0 mid__t0 mid 149.893184895
* device instance mid_t1 r0 *1 0,0
Rmid_t1 mid__t1 mid 180.889615105
* device instance mid_t2 r0 *1 0,0
Rmid_t2 mid__t2 mid 149.893184895
* device instance mid_t3 r0 *1 0,0
Rmid_t3 mid__t3 mid 180.889615105
* device instance mid r0 *1 0,0
Cmid mid vsubs 1.103314e-15
* device instance mid_dup1_t0 r0 *1 0,0
Rmid_dup1_t0 mid__t02 mid$1 149.893184895
* device instance mid_dup1_t1 r0 *1 0,0
Rmid_dup1_t1 mid__t12 mid$1 180.889615105
* device instance mid_dup1_t2 r0 *1 0,0
Rmid_dup1_t2 mid__t22 mid$1 149.893184895
* device instance mid_dup1_t3 r0 *1 0,0
Rmid_dup1_t3 mid__t32 mid$1 180.889615105
* device instance mid_dup1 r0 *1 0,0
Cmid_dup1 mid$1 vsubs 1.101742e-15
* device instance mid_dup2_t0 r0 *1 0,0
Rmid_dup2_t0 mid__t03 mid$2 149.893184895
* device instance mid_dup2_t1 r0 *1 0,0
Rmid_dup2_t1 mid__t13 mid$2 180.889615105
* device instance mid_dup2_t2 r0 *1 0,0
Rmid_dup2_t2 mid__t23 mid$2 180.889615105
* device instance mid_dup2_t3 r0 *1 0,0
Rmid_dup2_t3 mid__t33 mid$2 149.893184895
* device instance mid_dup2 r0 *1 0,0
Cmid_dup2 mid$2 vsubs 1.104383e-15
* device instance mpa_py_mpb_py_mph_py_py_t0 r0 *1 0,0
Rmpa_py_mpb_py_mph_py_py_t0 mpa_py\x7cmpb_py\x7cmph_py\x7cpy__t0
+ mpa_py|mpb_py|mph_py|py 70.17055
* device instance mpa_py_mpb_py_mph_py_py_t1 r0 *1 0,0
Rmpa_py_mpb_py_mph_py_py_t1 mpa_py\x7cmpb_py\x7cmph_py\x7cpy__t1
+ mpa_py|mpb_py|mph_py|py 10.9251301157
* device instance mpa_py_mpb_py_mph_py_py_t2 r0 *1 0,0
Rmpa_py_mpb_py_mph_py_py_t2 mpa_py\x7cmpb_py\x7cmph_py\x7cpy__t2
+ mpa_py|mpb_py|mph_py|py 59.2454198843
* device instance mpa_py_mpb_py_mph_py_py r0 *1 0,0
Cmpa_py_mpb_py_mph_py_py mpa_py|mpb_py|mph_py|py vsubs 7.94002e-16
* device instance mpa_py_mpb_py_mph_py_py_dup1_t0 r0 *1 0,0
Rmpa_py_mpb_py_mph_py_py_dup1_t0 mpa_py\x7cmpb_py\x7cmph_py\x7cpy__t02
+ mpa_py|mpb_py|mph_py|py$1 70.3684
* device instance mpa_py_mpb_py_mph_py_py_dup1_t1 r0 *1 0,0
Rmpa_py_mpb_py_mph_py_py_dup1_t1 mpa_py\x7cmpb_py\x7cmph_py\x7cpy__t12
+ mpa_py|mpb_py|mph_py|py$1 59.4124658363
* device instance mpa_py_mpb_py_mph_py_py_dup1_t2 r0 *1 0,0
Rmpa_py_mpb_py_mph_py_py_dup1_t2 mpa_py\x7cmpb_py\x7cmph_py\x7cpy__t22
+ mpa_py|mpb_py|mph_py|py$1 10.9559341637
* device instance mpa_py_mpb_py_mph_py_py_dup1 r0 *1 0,0
Cmpa_py_mpb_py_mph_py_py_dup1 mpa_py|mpb_py|mph_py|py$1 vsubs 7.95941e-16
* device instance mpa_py_mpb_py_mph_py_py_dup2_t0 r0 *1 0,0
Rmpa_py_mpb_py_mph_py_py_dup2_t0 mpa_py\x7cmpb_py\x7cmph_py\x7cpy__t03
+ mpa_py|mpb_py|mph_py|py$2 70.5682
* device instance mpa_py_mpb_py_mph_py_py_dup2_t1 r0 *1 0,0
Rmpa_py_mpb_py_mph_py_py_dup2_t1 mpa_py\x7cmpb_py\x7cmph_py\x7cpy__t13
+ mpa_py|mpb_py|mph_py|py$2 59.5811581851
* device instance mpa_py_mpb_py_mph_py_py_dup2_t2 r0 *1 0,0
Rmpa_py_mpb_py_mph_py_py_dup2_t2 mpa_py\x7cmpb_py\x7cmph_py\x7cpy__t23
+ mpa_py|mpb_py|mph_py|py$2 10.9870418149
* device instance mpa_py_mpb_py_mph_py_py_dup2 r0 *1 0,0
Cmpa_py_mpb_py_mph_py_py_dup2 mpa_py|mpb_py|mph_py|py$2 vsubs 7.9788e-16
* device instance mpa_py_mpb_py_mph_py_py_dup3_t0 r0 *1 0,0
Rmpa_py_mpb_py_mph_py_py_dup3_t0 mpa_py\x7cmpb_py\x7cmph_py\x7cpy__t04
+ mpa_py|mpb_py|mph_py|py$3 70.77005
* device instance mpa_py_mpb_py_mph_py_py_dup3_t1 r0 *1 0,0
Rmpa_py_mpb_py_mph_py_py_dup3_t1 mpa_py\x7cmpb_py\x7cmph_py\x7cpy__t14
+ mpa_py|mpb_py|mph_py|py$3 59.7515813612
* device instance mpa_py_mpb_py_mph_py_py_dup3_t2 r0 *1 0,0
Rmpa_py_mpb_py_mph_py_py_dup3_t2 mpa_py\x7cmpb_py\x7cmph_py\x7cpy__t24
+ mpa_py|mpb_py|mph_py|py$3 11.0184686388
* device instance mpa_py_mpb_py_mph_py_py_dup3 r0 *1 0,0
Cmpa_py_mpb_py_mph_py_py_dup3 mpa_py|mpb_py|mph_py|py$3 vsubs 7.99818e-16
* device instance ny_t0 r0 *1 0,0
Rny_t0 ny__t0 ny 44.45845
* device instance ny_t1 r0 *1 0,0
Rny_t1 ny__t1 ny 44.45845
* device instance ny r0 *1 0,0
Cny ny vsubs 2.11758e-16
* device instance ny_dup1_t0 r0 *1 0,0
Rny_dup1_t0 ny__t02 ny$1 41.7022
* device instance ny_dup1_t1 r0 *1 0,0
Rny_dup1_t1 ny__t12 ny$1 41.7022
* device instance ny_dup1 r0 *1 0,0
Cny_dup1 ny$1 vsubs 1.70111e-16
* device instance ny_dup2_t0 r0 *1 0,0
Rny_dup2_t0 ny__t03 ny$2 41.7022
* device instance ny_dup2_t1 r0 *1 0,0
Rny_dup2_t1 ny__t13 ny$2 41.7022
* device instance ny_dup2 r0 *1 0,0
Cny_dup2 ny$2 vsubs 1.70111e-16
* device instance ny_dup3_t0 r0 *1 0,0
Rny_dup3_t0 ny__t04 ny$3 41.7022
* device instance ny_dup3_t1 r0 *1 0,0
Rny_dup3_t1 ny__t14 ny$3 41.7022
* device instance ny_dup3 r0 *1 0,0
Cny_dup3 ny$3 vsubs 1.70111e-16
* device instance ny_dup4_t0 r0 *1 0,0
Rny_dup4_t0 ny__t05 ny$4 41.7022
* device instance ny_dup4_t1 r0 *1 0,0
Rny_dup4_t1 ny__t15 ny$4 41.7022
* device instance ny_dup4 r0 *1 0,0
Cny_dup4 ny$4 vsubs 1.70111e-16
* device instance ny_dup5_t0 r0 *1 0,0
Rny_dup5_t0 ny__t06 ny$5 44.6445
* device instance ny_dup5_t1 r0 *1 0,0
Rny_dup5_t1 ny__t16 ny$5 44.6445
* device instance ny_dup5 r0 *1 0,0
Cny_dup5 ny$5 vsubs 2.13697e-16
* device instance ny_dup6_t0 r0 *1 0,0
Rny_dup6_t0 ny__t07 ny$6 41.76295
* device instance ny_dup6_t1 r0 *1 0,0
Rny_dup6_t1 ny__t17 ny$6 41.76295
* device instance ny_dup6 r0 *1 0,0
Cny_dup6 ny$6 vsubs 1.7205e-16
* device instance ny_dup7_t0 r0 *1 0,0
Rny_dup7_t0 ny__t08 ny$7 41.76295
* device instance ny_dup7_t1 r0 *1 0,0
Rny_dup7_t1 ny__t18 ny$7 41.76295
* device instance ny_dup7 r0 *1 0,0
Cny_dup7 ny$7 vsubs 1.7205e-16
* device instance ny_dup8_t0 r0 *1 0,0
Rny_dup8_t0 ny__t09 ny$8 41.76295
* device instance ny_dup8_t1 r0 *1 0,0
Rny_dup8_t1 ny__t19 ny$8 41.76295
* device instance ny_dup8 r0 *1 0,0
Cny_dup8 ny$8 vsubs 1.7205e-16
* device instance ny_dup9_t0 r0 *1 0,0
Rny_dup9_t0 ny__t010 ny$9 41.76295
* device instance ny_dup9_t1 r0 *1 0,0
Rny_dup9_t1 ny__t110 ny$9 41.76295
* device instance ny_dup9 r0 *1 0,0
Cny_dup9 ny$9 vsubs 1.7205e-16
* device instance ny_dup10_t0 r0 *1 0,0
Rny_dup10_t0 ny__t011 ny$10 44.8339
* device instance ny_dup10_t1 r0 *1 0,0
Rny_dup10_t1 ny__t111 ny$10 44.8339
* device instance ny_dup10 r0 *1 0,0
Cny_dup10 ny$10 vsubs 2.15636e-16
* device instance ny_dup11_t0 r0 *1 0,0
Rny_dup11_t0 ny__t012 ny$11 41.8333
* device instance ny_dup11_t1 r0 *1 0,0
Rny_dup11_t1 ny__t112 ny$11 41.8333
* device instance ny_dup11 r0 *1 0,0
Cny_dup11 ny$11 vsubs 1.73989e-16
* device instance ny_dup12_t0 r0 *1 0,0
Rny_dup12_t0 ny__t013 ny$12 41.8333
* device instance ny_dup12_t1 r0 *1 0,0
Rny_dup12_t1 ny__t113 ny$12 41.8333
* device instance ny_dup12 r0 *1 0,0
Cny_dup12 ny$12 vsubs 1.73989e-16
* device instance ny_dup13_t0 r0 *1 0,0
Rny_dup13_t0 ny__t014 ny$13 41.8333
* device instance ny_dup13_t1 r0 *1 0,0
Rny_dup13_t1 ny__t114 ny$13 41.8333
* device instance ny_dup13 r0 *1 0,0
Cny_dup13 ny$13 vsubs 1.73989e-16
* device instance ny_dup14_t0 r0 *1 0,0
Rny_dup14_t0 ny__t015 ny$14 41.8333
* device instance ny_dup14_t1 r0 *1 0,0
Rny_dup14_t1 ny__t115 ny$14 41.8333
* device instance ny_dup14 r0 *1 0,0
Cny_dup14 ny$14 vsubs 1.73989e-16
* device instance ny_dup15_t0 r0 *1 0,0
Rny_dup15_t0 ny__t016 ny$15 45.02655
* device instance ny_dup15_t1 r0 *1 0,0
Rny_dup15_t1 ny__t116 ny$15 45.02655
* device instance ny_dup15 r0 *1 0,0
Cny_dup15 ny$15 vsubs 2.17575e-16
* device instance ny_dup16_t0 r0 *1 0,0
Rny_dup16_t0 ny__t017 ny$16 41.9128
* device instance ny_dup16_t1 r0 *1 0,0
Rny_dup16_t1 ny__t117 ny$16 41.9128
* device instance ny_dup16 r0 *1 0,0
Cny_dup16 ny$16 vsubs 1.75928e-16
* device instance ny_dup17_t0 r0 *1 0,0
Rny_dup17_t0 ny__t018 ny$17 41.9128
* device instance ny_dup17_t1 r0 *1 0,0
Rny_dup17_t1 ny__t118 ny$17 41.9128
* device instance ny_dup17 r0 *1 0,0
Cny_dup17 ny$17 vsubs 1.75928e-16
* device instance ny_dup18_t0 r0 *1 0,0
Rny_dup18_t0 ny__t019 ny$18 41.9128
* device instance ny_dup18_t1 r0 *1 0,0
Rny_dup18_t1 ny__t119 ny$18 41.9128
* device instance ny_dup18 r0 *1 0,0
Cny_dup18 ny$18 vsubs 1.75928e-16
* device instance ny_dup19_t0 r0 *1 0,0
Rny_dup19_t0 ny__t020 ny$19 41.9128
* device instance ny_dup19_t1 r0 *1 0,0
Rny_dup19_t1 ny__t120 ny$19 41.9128
* device instance ny_dup19 r0 *1 0,0
Cny_dup19 ny$19 vsubs 1.75928e-16
* device instance py_t0 r0 *1 0,0
Rpy_t0 py__t0 py 37.6683
* device instance py_t1 r0 *1 0,0
Rpy_t1 py__t1 py 37.6683
* device instance py r0 *1 0,0
Cpy py vsubs 1.9321e-16
* device instance py_dup1_t0 r0 *1 0,0
Rpy_dup1_t0 py__t02 py$1 37.6683
* device instance py_dup1_t1 r0 *1 0,0
Rpy_dup1_t1 py__t12 py$1 37.6683
* device instance py_dup1 r0 *1 0,0
Cpy_dup1 py$1 vsubs 1.9321e-16
* device instance py_dup2_t0 r0 *1 0,0
Rpy_dup2_t0 py__t03 py$2 37.6683
* device instance py_dup2_t1 r0 *1 0,0
Rpy_dup2_t1 py__t13 py$2 37.6683
* device instance py_dup2 r0 *1 0,0
Cpy_dup2 py$2 vsubs 1.9321e-16
* device instance py_dup3_t0 r0 *1 0,0
Rpy_dup3_t0 py__t04 py$3 37.6683
* device instance py_dup3_t1 r0 *1 0,0
Rpy_dup3_t1 py__t14 py$3 37.6683
* device instance py_dup3 r0 *1 0,0
Cpy_dup3 py$3 vsubs 1.9321e-16
* device instance py_dup4_t0 r0 *1 0,0
Rpy_dup4_t0 py__t05 py$4 37.875
* device instance py_dup4_t1 r0 *1 0,0
Rpy_dup4_t1 py__t15 py$4 37.875
* device instance py_dup4 r0 *1 0,0
Cpy_dup4 py$4 vsubs 1.95101e-16
* device instance py_dup5_t0 r0 *1 0,0
Rpy_dup5_t0 py__t06 py$5 37.875
* device instance py_dup5_t1 r0 *1 0,0
Rpy_dup5_t1 py__t16 py$5 37.875
* device instance py_dup5 r0 *1 0,0
Cpy_dup5 py$5 vsubs 1.95101e-16
* device instance py_dup6_t0 r0 *1 0,0
Rpy_dup6_t0 py__t07 py$6 37.875
* device instance py_dup6_t1 r0 *1 0,0
Rpy_dup6_t1 py__t17 py$6 37.875
* device instance py_dup6 r0 *1 0,0
Cpy_dup6 py$6 vsubs 1.95101e-16
* device instance py_dup7_t0 r0 *1 0,0
Rpy_dup7_t0 py__t08 py$7 37.875
* device instance py_dup7_t1 r0 *1 0,0
Rpy_dup7_t1 py__t18 py$7 37.875
* device instance py_dup7 r0 *1 0,0
Cpy_dup7 py$7 vsubs 1.95101e-16
* device instance py_dup8_t0 r0 *1 0,0
Rpy_dup8_t0 py__t09 py$8 38.0848
* device instance py_dup8_t1 r0 *1 0,0
Rpy_dup8_t1 py__t19 py$8 38.0848
* device instance py_dup8 r0 *1 0,0
Cpy_dup8 py$8 vsubs 1.96992e-16
* device instance py_dup9_t0 r0 *1 0,0
Rpy_dup9_t0 py__t010 py$9 38.0848
* device instance py_dup9_t1 r0 *1 0,0
Rpy_dup9_t1 py__t110 py$9 38.0848
* device instance py_dup9 r0 *1 0,0
Cpy_dup9 py$9 vsubs 1.96992e-16
* device instance py_dup10_t0 r0 *1 0,0
Rpy_dup10_t0 py__t011 py$10 38.0848
* device instance py_dup10_t1 r0 *1 0,0
Rpy_dup10_t1 py__t111 py$10 38.0848
* device instance py_dup10 r0 *1 0,0
Cpy_dup10 py$10 vsubs 1.96992e-16
* device instance py_dup11_t0 r0 *1 0,0
Rpy_dup11_t0 py__t012 py$11 38.0848
* device instance py_dup11_t1 r0 *1 0,0
Rpy_dup11_t1 py__t112 py$11 38.0848
* device instance py_dup11 r0 *1 0,0
Cpy_dup11 py$11 vsubs 1.96992e-16
* device instance py_dup12_t0 r0 *1 0,0
Rpy_dup12_t0 py__t013 py$12 38.29745
* device instance py_dup12_t1 r0 *1 0,0
Rpy_dup12_t1 py__t113 py$12 38.29745
* device instance py_dup12 r0 *1 0,0
Cpy_dup12 py$12 vsubs 1.98882e-16
* device instance py_dup13_t0 r0 *1 0,0
Rpy_dup13_t0 py__t014 py$13 38.29745
* device instance py_dup13_t1 r0 *1 0,0
Rpy_dup13_t1 py__t114 py$13 38.29745
* device instance py_dup13 r0 *1 0,0
Cpy_dup13 py$13 vsubs 1.98882e-16
* device instance py_dup14_t0 r0 *1 0,0
Rpy_dup14_t0 py__t015 py$14 38.29745
* device instance py_dup14_t1 r0 *1 0,0
Rpy_dup14_t1 py__t115 py$14 38.29745
* device instance py_dup14 r0 *1 0,0
Cpy_dup14 py$14 vsubs 1.98882e-16
* device instance py_dup15_t0 r0 *1 0,0
Rpy_dup15_t0 py__t016 py$15 38.29745
* device instance py_dup15_t1 r0 *1 0,0
Rpy_dup15_t1 py__t116 py$15 38.29745
* device instance py_dup15 r0 *1 0,0
Cpy_dup15 py$15 vsubs 1.98882e-16
* device instance vdd_vdd_b1_vdd_b2_vdd_b3_vdd_b4_vdd_x1_vdd_x2_vdd_x3_t0 r0 *1 0,0
Rvdd_vdd_b1_vdd_b2_vdd_b3_vdd_b4_vdd_x1_vdd_x2_vdd_x3_t0
+ vdd\x7cvdd_b1\x7cvdd_b2\x7cvdd_b3\x7cvdd_b4\x7cvdd_x1\x7cvdd_x2\x7cvdd_x3__t0
+ vdd|vdd_b1|vdd_b2|vdd_b3|vdd_b4|vdd_x1|vdd_x2|vdd_x3 329.598140068
* device instance vdd_vdd_b1_vdd_b2_vdd_b3_vdd_b4_vdd_x1_vdd_x2_vdd_x3_t1 r0 *1 0,0
Rvdd_vdd_b1_vdd_b2_vdd_b3_vdd_b4_vdd_x1_vdd_x2_vdd_x3_t1
+ vdd\x7cvdd_b1\x7cvdd_b2\x7cvdd_b3\x7cvdd_b4\x7cvdd_x1\x7cvdd_x2\x7cvdd_x3__t1
+ vdd|vdd_b1|vdd_b2|vdd_b3|vdd_b4|vdd_x1|vdd_x2|vdd_x3 329.598140068
* device instance vdd_vdd_b1_vdd_b2_vdd_b3_vdd_b4_vdd_x1_vdd_x2_vdd_x3_t2 r0 *1 0,0
Rvdd_vdd_b1_vdd_b2_vdd_b3_vdd_b4_vdd_x1_vdd_x2_vdd_x3_t2
+ vdd\x7cvdd_b1\x7cvdd_b2\x7cvdd_b3\x7cvdd_b4\x7cvdd_x1\x7cvdd_x2\x7cvdd_x3__t2
+ vdd|vdd_b1|vdd_b2|vdd_b3|vdd_b4|vdd_x1|vdd_x2|vdd_x3 325.448295951
* device instance vdd_vdd_b1_vdd_b2_vdd_b3_vdd_b4_vdd_x1_vdd_x2_vdd_x3_t3 r0 *1 0,0
Rvdd_vdd_b1_vdd_b2_vdd_b3_vdd_b4_vdd_x1_vdd_x2_vdd_x3_t3
+ vdd\x7cvdd_b1\x7cvdd_b2\x7cvdd_b3\x7cvdd_b4\x7cvdd_x1\x7cvdd_x2\x7cvdd_x3__t3
+ vdd|vdd_b1|vdd_b2|vdd_b3|vdd_b4|vdd_x1|vdd_x2|vdd_x3 90.6836804295
* device instance vdd_vdd_b1_vdd_b2_vdd_b3_vdd_b4_vdd_x1_vdd_x2_vdd_x3_t4 r0 *1 0,0
Rvdd_vdd_b1_vdd_b2_vdd_b3_vdd_b4_vdd_x1_vdd_x2_vdd_x3_t4
+ vdd\x7cvdd_b1\x7cvdd_b2\x7cvdd_b3\x7cvdd_b4\x7cvdd_x1\x7cvdd_x2\x7cvdd_x3__t4
+ vdd|vdd_b1|vdd_b2|vdd_b3|vdd_b4|vdd_x1|vdd_x2|vdd_x3 105.010005369
* device instance vdd_vdd_b1_vdd_b2_vdd_b3_vdd_b4_vdd_x1_vdd_x2_vdd_x3_t5 r0 *1 0,0
Rvdd_vdd_b1_vdd_b2_vdd_b3_vdd_b4_vdd_x1_vdd_x2_vdd_x3_t5
+ vdd\x7cvdd_b1\x7cvdd_b2\x7cvdd_b3\x7cvdd_b4\x7cvdd_x1\x7cvdd_x2\x7cvdd_x3__t5
+ vdd|vdd_b1|vdd_b2|vdd_b3|vdd_b4|vdd_x1|vdd_x2|vdd_x3 281.213406274
* device instance vdd_vdd_b1_vdd_b2_vdd_b3_vdd_b4_vdd_x1_vdd_x2_vdd_x3_t6 r0 *1 0,0
Rvdd_vdd_b1_vdd_b2_vdd_b3_vdd_b4_vdd_x1_vdd_x2_vdd_x3_t6
+ vdd\x7cvdd_b1\x7cvdd_b2\x7cvdd_b3\x7cvdd_b4\x7cvdd_x1\x7cvdd_x2\x7cvdd_x3__t6
+ vdd|vdd_b1|vdd_b2|vdd_b3|vdd_b4|vdd_x1|vdd_x2|vdd_x3 147.507557009
* device instance vdd_vdd_b1_vdd_b2_vdd_b3_vdd_b4_vdd_x1_vdd_x2_vdd_x3_t7 r0 *1 0,0
Rvdd_vdd_b1_vdd_b2_vdd_b3_vdd_b4_vdd_x1_vdd_x2_vdd_x3_t7
+ vdd\x7cvdd_b1\x7cvdd_b2\x7cvdd_b3\x7cvdd_b4\x7cvdd_x1\x7cvdd_x2\x7cvdd_x3__t7
+ vdd|vdd_b1|vdd_b2|vdd_b3|vdd_b4|vdd_x1|vdd_x2|vdd_x3 90.6836804295
* device instance vdd_vdd_b1_vdd_b2_vdd_b3_vdd_b4_vdd_x1_vdd_x2_vdd_x3_t8 r0 *1 0,0
Rvdd_vdd_b1_vdd_b2_vdd_b3_vdd_b4_vdd_x1_vdd_x2_vdd_x3_t8
+ vdd\x7cvdd_b1\x7cvdd_b2\x7cvdd_b3\x7cvdd_b4\x7cvdd_x1\x7cvdd_x2\x7cvdd_x3__t8
+ vdd|vdd_b1|vdd_b2|vdd_b3|vdd_b4|vdd_x1|vdd_x2|vdd_x3 105.010005369
* device instance vdd_vdd_b1_vdd_b2_vdd_b3_vdd_b4_vdd_x1_vdd_x2_vdd_x3_t9 r0 *1 0,0
Rvdd_vdd_b1_vdd_b2_vdd_b3_vdd_b4_vdd_x1_vdd_x2_vdd_x3_t9
+ vdd\x7cvdd_b1\x7cvdd_b2\x7cvdd_b3\x7cvdd_b4\x7cvdd_x1\x7cvdd_x2\x7cvdd_x3__t9
+ vdd|vdd_b1|vdd_b2|vdd_b3|vdd_b4|vdd_x1|vdd_x2|vdd_x3 53.3916915068
* device instance vdd_vdd_b1_vdd_b2_vdd_b3_vdd_b4_vdd_x1_vdd_x2_vdd_x3_t10 r0 *1 0,0
Rvdd_vdd_b1_vdd_b2_vdd_b3_vdd_b4_vdd_x1_vdd_x2_vdd_x3_t10
+ vdd\x7cvdd_b1\x7cvdd_b2\x7cvdd_b3\x7cvdd_b4\x7cvdd_x1\x7cvdd_x2\x7cvdd_x3__t10
+ vdd|vdd_b1|vdd_b2|vdd_b3|vdd_b4|vdd_x1|vdd_x2|vdd_x3 281.213406274
* device instance vdd_vdd_b1_vdd_b2_vdd_b3_vdd_b4_vdd_x1_vdd_x2_vdd_x3_t11 r0 *1 0,0
Rvdd_vdd_b1_vdd_b2_vdd_b3_vdd_b4_vdd_x1_vdd_x2_vdd_x3_t11
+ vdd\x7cvdd_b1\x7cvdd_b2\x7cvdd_b3\x7cvdd_b4\x7cvdd_x1\x7cvdd_x2\x7cvdd_x3__t11
+ vdd|vdd_b1|vdd_b2|vdd_b3|vdd_b4|vdd_x1|vdd_x2|vdd_x3 86.8981324645
* device instance vdd_vdd_b1_vdd_b2_vdd_b3_vdd_b4_vdd_x1_vdd_x2_vdd_x3_t12 r0 *1 0,0
Rvdd_vdd_b1_vdd_b2_vdd_b3_vdd_b4_vdd_x1_vdd_x2_vdd_x3_t12
+ vdd\x7cvdd_b1\x7cvdd_b2\x7cvdd_b3\x7cvdd_b4\x7cvdd_x1\x7cvdd_x2\x7cvdd_x3__t12
+ vdd|vdd_b1|vdd_b2|vdd_b3|vdd_b4|vdd_x1|vdd_x2|vdd_x3 108.921645976
* device instance vdd_vdd_b1_vdd_b2_vdd_b3_vdd_b4_vdd_x1_vdd_x2_vdd_x3_t13 r0 *1 0,0
Rvdd_vdd_b1_vdd_b2_vdd_b3_vdd_b4_vdd_x1_vdd_x2_vdd_x3_t13
+ vdd\x7cvdd_b1\x7cvdd_b2\x7cvdd_b3\x7cvdd_b4\x7cvdd_x1\x7cvdd_x2\x7cvdd_x3__t13
+ vdd|vdd_b1|vdd_b2|vdd_b3|vdd_b4|vdd_x1|vdd_x2|vdd_x3 151.551152317
* device instance vdd_vdd_b1_vdd_b2_vdd_b3_vdd_b4_vdd_x1_vdd_x2_vdd_x3_t14 r0 *1 0,0
Rvdd_vdd_b1_vdd_b2_vdd_b3_vdd_b4_vdd_x1_vdd_x2_vdd_x3_t14
+ vdd\x7cvdd_b1\x7cvdd_b2\x7cvdd_b3\x7cvdd_b4\x7cvdd_x1\x7cvdd_x2\x7cvdd_x3__t14
+ vdd|vdd_b1|vdd_b2|vdd_b3|vdd_b4|vdd_x1|vdd_x2|vdd_x3 50.5062066585
* device instance vdd_vdd_b1_vdd_b2_vdd_b3_vdd_b4_vdd_x1_vdd_x2_vdd_x3_t15 r0 *1 0,0
Rvdd_vdd_b1_vdd_b2_vdd_b3_vdd_b4_vdd_x1_vdd_x2_vdd_x3_t15
+ vdd\x7cvdd_b1\x7cvdd_b2\x7cvdd_b3\x7cvdd_b4\x7cvdd_x1\x7cvdd_x2\x7cvdd_x3__t15
+ vdd|vdd_b1|vdd_b2|vdd_b3|vdd_b4|vdd_x1|vdd_x2|vdd_x3 285.353941287
* device instance vdd_vdd_b1_vdd_b2_vdd_b3_vdd_b4_vdd_x1_vdd_x2_vdd_x3_t16 r0 *1 0,0
Rvdd_vdd_b1_vdd_b2_vdd_b3_vdd_b4_vdd_x1_vdd_x2_vdd_x3_t16
+ vdd\x7cvdd_b1\x7cvdd_b2\x7cvdd_b3\x7cvdd_b4\x7cvdd_x1\x7cvdd_x2\x7cvdd_x3__t16
+ vdd|vdd_b1|vdd_b2|vdd_b3|vdd_b4|vdd_x1|vdd_x2|vdd_x3 151.551152317
* device instance vdd_vdd_b1_vdd_b2_vdd_b3_vdd_b4_vdd_x1_vdd_x2_vdd_x3_t17 r0 *1 0,0
Rvdd_vdd_b1_vdd_b2_vdd_b3_vdd_b4_vdd_x1_vdd_x2_vdd_x3_t17
+ vdd\x7cvdd_b1\x7cvdd_b2\x7cvdd_b3\x7cvdd_b4\x7cvdd_x1\x7cvdd_x2\x7cvdd_x3__t17
+ vdd|vdd_b1|vdd_b2|vdd_b3|vdd_b4|vdd_x1|vdd_x2|vdd_x3 50.5062066585
* device instance vdd_vdd_b1_vdd_b2_vdd_b3_vdd_b4_vdd_x1_vdd_x2_vdd_x3_t18 r0 *1 0,0
Rvdd_vdd_b1_vdd_b2_vdd_b3_vdd_b4_vdd_x1_vdd_x2_vdd_x3_t18
+ vdd\x7cvdd_b1\x7cvdd_b2\x7cvdd_b3\x7cvdd_b4\x7cvdd_x1\x7cvdd_x2\x7cvdd_x3__t18
+ vdd|vdd_b1|vdd_b2|vdd_b3|vdd_b4|vdd_x1|vdd_x2|vdd_x3 121.556647893
* device instance vdd_vdd_b1_vdd_b2_vdd_b3_vdd_b4_vdd_x1_vdd_x2_vdd_x3_t19 r0 *1 0,0
Rvdd_vdd_b1_vdd_b2_vdd_b3_vdd_b4_vdd_x1_vdd_x2_vdd_x3_t19
+ vdd\x7cvdd_b1\x7cvdd_b2\x7cvdd_b3\x7cvdd_b4\x7cvdd_x1\x7cvdd_x2\x7cvdd_x3__t19
+ vdd|vdd_b1|vdd_b2|vdd_b3|vdd_b4|vdd_x1|vdd_x2|vdd_x3 239.205151931
* device instance vdd_vdd_b1_vdd_b2_vdd_b3_vdd_b4_vdd_x1_vdd_x2_vdd_x3_t20 r0 *1 0,0
Rvdd_vdd_b1_vdd_b2_vdd_b3_vdd_b4_vdd_x1_vdd_x2_vdd_x3_t20
+ vdd\x7cvdd_b1\x7cvdd_b2\x7cvdd_b3\x7cvdd_b4\x7cvdd_x1\x7cvdd_x2\x7cvdd_x3__t20
+ vdd|vdd_b1|vdd_b2|vdd_b3|vdd_b4|vdd_x1|vdd_x2|vdd_x3 171.987358433
* device instance vdd_vdd_b1_vdd_b2_vdd_b3_vdd_b4_vdd_x1_vdd_x2_vdd_x3_t21 r0 *1 0,0
Rvdd_vdd_b1_vdd_b2_vdd_b3_vdd_b4_vdd_x1_vdd_x2_vdd_x3_t21
+ vdd\x7cvdd_b1\x7cvdd_b2\x7cvdd_b3\x7cvdd_b4\x7cvdd_x1\x7cvdd_x2\x7cvdd_x3__t21
+ vdd|vdd_b1|vdd_b2|vdd_b3|vdd_b4|vdd_x1|vdd_x2|vdd_x3 59.2674929427
* device instance vdd_vdd_b1_vdd_b2_vdd_b3_vdd_b4_vdd_x1_vdd_x2_vdd_x3_t22 r0 *1 0,0
Rvdd_vdd_b1_vdd_b2_vdd_b3_vdd_b4_vdd_x1_vdd_x2_vdd_x3_t22
+ vdd\x7cvdd_b1\x7cvdd_b2\x7cvdd_b3\x7cvdd_b4\x7cvdd_x1\x7cvdd_x2\x7cvdd_x3__t22
+ vdd|vdd_b1|vdd_b2|vdd_b3|vdd_b4|vdd_x1|vdd_x2|vdd_x3 352.45199806
* device instance vdd_vdd_b1_vdd_b2_vdd_b3_vdd_b4_vdd_x1_vdd_x2_vdd_x3_t23 r0 *1 0,0
Rvdd_vdd_b1_vdd_b2_vdd_b3_vdd_b4_vdd_x1_vdd_x2_vdd_x3_t23
+ vdd\x7cvdd_b1\x7cvdd_b2\x7cvdd_b3\x7cvdd_b4\x7cvdd_x1\x7cvdd_x2\x7cvdd_x3__t23
+ vdd|vdd_b1|vdd_b2|vdd_b3|vdd_b4|vdd_x1|vdd_x2|vdd_x3 13.682079315
* device instance vdd_vdd_b1_vdd_b2_vdd_b3_vdd_b4_vdd_x1_vdd_x2_vdd_x3_t24 r0 *1 0,0
Rvdd_vdd_b1_vdd_b2_vdd_b3_vdd_b4_vdd_x1_vdd_x2_vdd_x3_t24
+ vdd\x7cvdd_b1\x7cvdd_b2\x7cvdd_b3\x7cvdd_b4\x7cvdd_x1\x7cvdd_x2\x7cvdd_x3__t24
+ vdd|vdd_b1|vdd_b2|vdd_b3|vdd_b4|vdd_x1|vdd_x2|vdd_x3 122.704824838
* device instance vdd_vdd_b1_vdd_b2_vdd_b3_vdd_b4_vdd_x1_vdd_x2_vdd_x3_t25 r0 *1 0,0
Rvdd_vdd_b1_vdd_b2_vdd_b3_vdd_b4_vdd_x1_vdd_x2_vdd_x3_t25
+ vdd\x7cvdd_b1\x7cvdd_b2\x7cvdd_b3\x7cvdd_b4\x7cvdd_x1\x7cvdd_x2\x7cvdd_x3__t25
+ vdd|vdd_b1|vdd_b2|vdd_b3|vdd_b4|vdd_x1|vdd_x2|vdd_x3 293.216100063
* device instance vdd_vdd_b1_vdd_b2_vdd_b3_vdd_b4_vdd_x1_vdd_x2_vdd_x3_t26 r0 *1 0,0
Rvdd_vdd_b1_vdd_b2_vdd_b3_vdd_b4_vdd_x1_vdd_x2_vdd_x3_t26
+ vdd\x7cvdd_b1\x7cvdd_b2\x7cvdd_b3\x7cvdd_b4\x7cvdd_x1\x7cvdd_x2\x7cvdd_x3__t26
+ vdd|vdd_b1|vdd_b2|vdd_b3|vdd_b4|vdd_x1|vdd_x2|vdd_x3 970.386597075
* device instance vdd_vdd_b1_vdd_b2_vdd_b3_vdd_b4_vdd_x1_vdd_x2_vdd_x3_t27 r0 *1 0,0
Rvdd_vdd_b1_vdd_b2_vdd_b3_vdd_b4_vdd_x1_vdd_x2_vdd_x3_t27
+ vdd\x7cvdd_b1\x7cvdd_b2\x7cvdd_b3\x7cvdd_b4\x7cvdd_x1\x7cvdd_x2\x7cvdd_x3__t27
+ vdd|vdd_b1|vdd_b2|vdd_b3|vdd_b4|vdd_x1|vdd_x2|vdd_x3 628.437526236
* device instance vdd_vdd_b1_vdd_b2_vdd_b3_vdd_b4_vdd_x1_vdd_x2_vdd_x3_t28 r0 *1 0,0
Rvdd_vdd_b1_vdd_b2_vdd_b3_vdd_b4_vdd_x1_vdd_x2_vdd_x3_t28
+ vdd\x7cvdd_b1\x7cvdd_b2\x7cvdd_b3\x7cvdd_b4\x7cvdd_x1\x7cvdd_x2\x7cvdd_x3__t28
+ vdd|vdd_b1|vdd_b2|vdd_b3|vdd_b4|vdd_x1|vdd_x2|vdd_x3 121.556647893
* device instance vdd_vdd_b1_vdd_b2_vdd_b3_vdd_b4_vdd_x1_vdd_x2_vdd_x3_t29 r0 *1 0,0
Rvdd_vdd_b1_vdd_b2_vdd_b3_vdd_b4_vdd_x1_vdd_x2_vdd_x3_t29
+ vdd\x7cvdd_b1\x7cvdd_b2\x7cvdd_b3\x7cvdd_b4\x7cvdd_x1\x7cvdd_x2\x7cvdd_x3__t29
+ vdd|vdd_b1|vdd_b2|vdd_b3|vdd_b4|vdd_x1|vdd_x2|vdd_x3 239.205151931
* device instance vdd_vdd_b1_vdd_b2_vdd_b3_vdd_b4_vdd_x1_vdd_x2_vdd_x3_t30 r0 *1 0,0
Rvdd_vdd_b1_vdd_b2_vdd_b3_vdd_b4_vdd_x1_vdd_x2_vdd_x3_t30
+ vdd\x7cvdd_b1\x7cvdd_b2\x7cvdd_b3\x7cvdd_b4\x7cvdd_x1\x7cvdd_x2\x7cvdd_x3__t30
+ vdd|vdd_b1|vdd_b2|vdd_b3|vdd_b4|vdd_x1|vdd_x2|vdd_x3 171.987358433
* device instance vdd_vdd_b1_vdd_b2_vdd_b3_vdd_b4_vdd_x1_vdd_x2_vdd_x3_t31 r0 *1 0,0
Rvdd_vdd_b1_vdd_b2_vdd_b3_vdd_b4_vdd_x1_vdd_x2_vdd_x3_t31
+ vdd\x7cvdd_b1\x7cvdd_b2\x7cvdd_b3\x7cvdd_b4\x7cvdd_x1\x7cvdd_x2\x7cvdd_x3__t31
+ vdd|vdd_b1|vdd_b2|vdd_b3|vdd_b4|vdd_x1|vdd_x2|vdd_x3 59.2674929427
* device instance vdd_vdd_b1_vdd_b2_vdd_b3_vdd_b4_vdd_x1_vdd_x2_vdd_x3_t32 r0 *1 0,0
Rvdd_vdd_b1_vdd_b2_vdd_b3_vdd_b4_vdd_x1_vdd_x2_vdd_x3_t32
+ vdd\x7cvdd_b1\x7cvdd_b2\x7cvdd_b3\x7cvdd_b4\x7cvdd_x1\x7cvdd_x2\x7cvdd_x3__t32
+ vdd|vdd_b1|vdd_b2|vdd_b3|vdd_b4|vdd_x1|vdd_x2|vdd_x3 352.45199806
* device instance vdd_vdd_b1_vdd_b2_vdd_b3_vdd_b4_vdd_x1_vdd_x2_vdd_x3_t33 r0 *1 0,0
Rvdd_vdd_b1_vdd_b2_vdd_b3_vdd_b4_vdd_x1_vdd_x2_vdd_x3_t33
+ vdd\x7cvdd_b1\x7cvdd_b2\x7cvdd_b3\x7cvdd_b4\x7cvdd_x1\x7cvdd_x2\x7cvdd_x3__t33
+ vdd|vdd_b1|vdd_b2|vdd_b3|vdd_b4|vdd_x1|vdd_x2|vdd_x3 13.682079315
* device instance vdd_vdd_b1_vdd_b2_vdd_b3_vdd_b4_vdd_x1_vdd_x2_vdd_x3_t34 r0 *1 0,0
Rvdd_vdd_b1_vdd_b2_vdd_b3_vdd_b4_vdd_x1_vdd_x2_vdd_x3_t34
+ vdd\x7cvdd_b1\x7cvdd_b2\x7cvdd_b3\x7cvdd_b4\x7cvdd_x1\x7cvdd_x2\x7cvdd_x3__t34
+ vdd|vdd_b1|vdd_b2|vdd_b3|vdd_b4|vdd_x1|vdd_x2|vdd_x3 122.704824838
* device instance vdd_vdd_b1_vdd_b2_vdd_b3_vdd_b4_vdd_x1_vdd_x2_vdd_x3_t35 r0 *1 0,0
Rvdd_vdd_b1_vdd_b2_vdd_b3_vdd_b4_vdd_x1_vdd_x2_vdd_x3_t35
+ vdd\x7cvdd_b1\x7cvdd_b2\x7cvdd_b3\x7cvdd_b4\x7cvdd_x1\x7cvdd_x2\x7cvdd_x3__t35
+ vdd|vdd_b1|vdd_b2|vdd_b3|vdd_b4|vdd_x1|vdd_x2|vdd_x3 293.216100063
* device instance vdd_vdd_b1_vdd_b2_vdd_b3_vdd_b4_vdd_x1_vdd_x2_vdd_x3_t36 r0 *1 0,0
Rvdd_vdd_b1_vdd_b2_vdd_b3_vdd_b4_vdd_x1_vdd_x2_vdd_x3_t36
+ vdd\x7cvdd_b1\x7cvdd_b2\x7cvdd_b3\x7cvdd_b4\x7cvdd_x1\x7cvdd_x2\x7cvdd_x3__t36
+ vdd|vdd_b1|vdd_b2|vdd_b3|vdd_b4|vdd_x1|vdd_x2|vdd_x3 970.386597075
* device instance vdd_vdd_b1_vdd_b2_vdd_b3_vdd_b4_vdd_x1_vdd_x2_vdd_x3_t37 r0 *1 0,0
Rvdd_vdd_b1_vdd_b2_vdd_b3_vdd_b4_vdd_x1_vdd_x2_vdd_x3_t37
+ vdd\x7cvdd_b1\x7cvdd_b2\x7cvdd_b3\x7cvdd_b4\x7cvdd_x1\x7cvdd_x2\x7cvdd_x3__t37
+ vdd|vdd_b1|vdd_b2|vdd_b3|vdd_b4|vdd_x1|vdd_x2|vdd_x3 628.437526236
* device instance vdd_vdd_b1_vdd_b2_vdd_b3_vdd_b4_vdd_x1_vdd_x2_vdd_x3 r0 *1 0,0
Cvdd_vdd_b1_vdd_b2_vdd_b3_vdd_b4_vdd_x1_vdd_x2_vdd_x3
+ vdd|vdd_b1|vdd_b2|vdd_b3|vdd_b4|vdd_x1|vdd_x2|vdd_x3 vsubs 4.8070761e-14
* device instance xo_y_t0 r0 *1 0,0
Rxo_y_t0 xo\x7cy__t0 xo|y 467.37167839
* device instance xo_y_t1 r0 *1 0,0
Rxo_y_t1 xo\x7cy__t1 xo|y 469.93818689
* device instance xo_y_t2 r0 *1 0,0
Rxo_y_t2 xo\x7cy__t2 xo|y 481.436399982
* device instance xo_y_t3 r0 *1 0,0
Rxo_y_t3 xo\x7cy__t3 xo|y 478.729934738
* device instance xo_y r0 *1 0,0
Cxo_y xo|y vsubs 2.728628e-15
* device instance cc_an_inva_y_mn34_g0_mp13_g1_y_a_b_b3_invb_a_mn12_g1_mp24_g0_t2_y r0 *1 0,0
Ccc_an_inva_y_mn34_g0_mp13_g1_y_a_b_b3_invb_a_mn12_g1_mp24_g0_t2_y
+ an|inva_y|mn34_g0|mp13_g1|y$2 a|b|b3|invb_a|mn12_g1|mp24_g0|t2|y 3.3e-18
* device instance cc_an_inva_y_mn34_g0_mp13_g1_y_a_inva_a_mn12_g0_mp13_g0_t1_y r0 *1 0,0
Ccc_an_inva_y_mn34_g0_mp13_g1_y_a_inva_a_mn12_g0_mp13_g0_t1_y
+ an|inva_y|mn34_g0|mp13_g1|y$2 a|inva_a|mn12_g0|mp13_g0|t1|y 3.3e-18
* device instance cc_an_inva_y_mn34_g0_mp13_g1_y_vdd_vdd_b1_vdd_b2_vdd_b3_vdd_b4_vdd_x1_vdd_x2_vdd_x3 r0 *1 0,0
Ccc_an_inva_y_mn34_g0_mp13_g1_y_vdd_vdd_b1_vdd_b2_vdd_b3_vdd_b4_vdd_x1_vdd_x2_vdd_x3
+ an|inva_y|mn34_g0|mp13_g1|y$2
+ vdd|vdd_b1|vdd_b2|vdd_b3|vdd_b4|vdd_x1|vdd_x2|vdd_x3 2.8673e-17
* device instance cc_an_inva_y_mn34_g0_mp13_g1_y_xo_y r0 *1 0,0
Ccc_an_inva_y_mn34_g0_mp13_g1_y_xo_y an|inva_y|mn34_g0|mp13_g1|y$2 xo|y 3.3e-18
* device instance cc_a_b_b3_invb_a_mn12_g1_mp24_g0_t2_y_a_inva_a_mn12_g0_mp13_g0_ro3_y r0 *1 0,0
Ccc_a_b_b3_invb_a_mn12_g1_mp24_g0_t2_y_a_inva_a_mn12_g0_mp13_g0_ro3_y
+ a|b|b3|invb_a|mn12_g1|mp24_g0|t2|y a|inva_a|mn12_g0|mp13_g0|ro3|y 3.3e-18
* device instance cc_a_b_b3_invb_a_mn12_g1_mp24_g0_t2_y_a_inva_a_mn12_g0_mp13_g0_t1_y r0 *1 0,0
Ccc_a_b_b3_invb_a_mn12_g1_mp24_g0_t2_y_a_inva_a_mn12_g0_mp13_g0_t1_y
+ a|b|b3|invb_a|mn12_g1|mp24_g0|t2|y a|inva_a|mn12_g0|mp13_g0|t1|y 3.869e-18
* device instance cc_a_b_b3_invb_a_mn12_g1_mp24_g0_t2_y_bn_invb_y_mn34_g1_mp24_g1_y r0 *1 0,0
Ccc_a_b_b3_invb_a_mn12_g1_mp24_g0_t2_y_bn_invb_y_mn34_g1_mp24_g1_y
+ a|b|b3|invb_a|mn12_g1|mp24_g0|t2|y bn|invb_y|mn34_g1|mp24_g1|y$2 1.377e-17
* device instance cc_a_b_b3_invb_a_mn12_g1_mp24_g0_t2_y_mid r0 *1 0,0
Ccc_a_b_b3_invb_a_mn12_g1_mp24_g0_t2_y_mid a|b|b3|invb_a|mn12_g1|mp24_g0|t2|y
+ mid$2 8.154e-18
* device instance cc_a_b_invb_a_mn12_g1_mp24_g0_ro2_y_g_vss_m1_mph_g_s1_vss_m1_s2_vss_m1_s3_vss_m1_s4_vss_m1_vss_vss_x1_vss_x2_vss_x3 r0 *1 0,0
Ccc_a_b_invb_a_mn12_g1_mp24_g0_ro2_y_g_vss_m1_mph_g_s1_vss_m1_s2_vss_m1_s3_vss_m1_s4_vss_m1_vss_vss_x1_vss_x2_vss_x3
+ a|b|invb_a|mn12_g1|mp24_g0|ro2|y
+ g_vss_m1|mph_g|s1_vss_m1|s2_vss_m1|s3_vss_m1|s4_vss_m1|vss|vss_x1|vss_x2|vss_x3
+ 4.5279e-17
* device instance cc_a_b_invb_a_mn12_g1_mp24_g0_ro2_y_vdd_vdd_b1_vdd_b2_vdd_b3_vdd_b4_vdd_x1_vdd_x2_vdd_x3 r0 *1 0,0
Ccc_a_b_invb_a_mn12_g1_mp24_g0_ro2_y_vdd_vdd_b1_vdd_b2_vdd_b3_vdd_b4_vdd_x1_vdd_x2_vdd_x3
+ a|b|invb_a|mn12_g1|mp24_g0|ro2|y
+ vdd|vdd_b1|vdd_b2|vdd_b3|vdd_b4|vdd_x1|vdd_x2|vdd_x3 9.558e-18
* device instance cc_a_b_invb_a_mn12_g1_mp24_g0_ro4_y_g_vss_m1_mph_g_s1_vss_m1_s2_vss_m1_s3_vss_m1_s4_vss_m1_vss_vss_x1_vss_x2_vss_x3 r0 *1 0,0
Ccc_a_b_invb_a_mn12_g1_mp24_g0_ro4_y_g_vss_m1_mph_g_s1_vss_m1_s2_vss_m1_s3_vss_m1_s4_vss_m1_vss_vss_x1_vss_x2_vss_x3
+ a|b|invb_a|mn12_g1|mp24_g0|ro4|y
+ g_vss_m1|mph_g|s1_vss_m1|s2_vss_m1|s3_vss_m1|s4_vss_m1|vss|vss_x1|vss_x2|vss_x3
+ 5.4837e-17
* device instance cc_a_b_invb_a_mn12_g1_mp24_g0_ro4_y_vdd_vdd_b1_vdd_b2_vdd_b3_vdd_b4_vdd_x1_vdd_x2_vdd_x3 r0 *1 0,0
Ccc_a_b_invb_a_mn12_g1_mp24_g0_ro4_y_vdd_vdd_b1_vdd_b2_vdd_b3_vdd_b4_vdd_x1_vdd_x2_vdd_x3
+ a|b|invb_a|mn12_g1|mp24_g0|ro4|y
+ vdd|vdd_b1|vdd_b2|vdd_b3|vdd_b4|vdd_x1|vdd_x2|vdd_x3 9.558e-18
* device instance cc_a_g_a_rn1_ro_s4_y_y_a_g_y_mnab_y_mpa_y_mpb_y_n1_s1_a_y r0 *1 0,0
Ccc_a_g_a_rn1_ro_s4_y_y_a_g_y_mnab_y_mpa_y_mpb_y_n1_s1_a_y a|g_a|rn1|ro|s4_y|y
+ a|g_y|mnab_y|mpa_y|mpb_y|n1|s1_a|y$3 1.5977e-17
* device instance cc_a_g_a_rn1_ro_s4_y_y_g_vddr_m1_mnt_g_s1_vddr_m1_s2_vddr_m1_s3_vddr_m1_s4_vddr_m1_vddr_vddr1 r0 *1 0,0
Ccc_a_g_a_rn1_ro_s4_y_y_g_vddr_m1_mnt_g_s1_vddr_m1_s2_vddr_m1_s3_vddr_m1_s4_vddr_m1_vddr_vddr1
+ a|g_a|rn1|ro|s4_y|y
+ g_vddr_m1|mnt_g|s1_vddr_m1|s2_vddr_m1|s3_vddr_m1|s4_vddr_m1|vddr|vddr1
+ 1.5474e-17
* device instance cc_a_g_a_rn2_ro_s4_y_y_a_g_y_mnab_y_mpa_y_mpb_y_n1_s1_a_y r0 *1 0,0
Ccc_a_g_a_rn2_ro_s4_y_y_a_g_y_mnab_y_mpa_y_mpb_y_n1_s1_a_y a|g_a|rn2|ro|s4_y|y
+ a|g_y|mnab_y|mpa_y|mpb_y|n1|s1_a|y$3 1.5977e-17
* device instance cc_a_g_a_rn2_ro_s4_y_y_g_vddr_m1_mnt_g_s1_vddr_m1_s2_vddr_m1_s3_vddr_m1_s4_vddr_m1_vddr_vddr2 r0 *1 0,0
Ccc_a_g_a_rn2_ro_s4_y_y_g_vddr_m1_mnt_g_s1_vddr_m1_s2_vddr_m1_s3_vddr_m1_s4_vddr_m1_vddr_vddr2
+ a|g_a|rn2|ro|s4_y|y
+ g_vddr_m1|mnt_g|s1_vddr_m1|s2_vddr_m1|s3_vddr_m1|s4_vddr_m1|vddr|vddr2
+ 1.5474e-17
* device instance cc_a_g_a_rn3_ro_s4_y_y_a_g_y_mnab_y_mpa_y_mpb_y_n1_s1_a_y r0 *1 0,0
Ccc_a_g_a_rn3_ro_s4_y_y_a_g_y_mnab_y_mpa_y_mpb_y_n1_s1_a_y a|g_a|rn3|ro|s4_y|y
+ a|g_y|mnab_y|mpa_y|mpb_y|n1|s1_a|y$3 1.5977e-17
* device instance cc_a_g_a_rn3_ro_s4_y_y_g_vddr_m1_mnt_g_s1_vddr_m1_s2_vddr_m1_s3_vddr_m1_s4_vddr_m1_vddr_vddr3 r0 *1 0,0
Ccc_a_g_a_rn3_ro_s4_y_y_g_vddr_m1_mnt_g_s1_vddr_m1_s2_vddr_m1_s3_vddr_m1_s4_vddr_m1_vddr_vddr3
+ a|g_a|rn3|ro|s4_y|y
+ g_vddr_m1|mnt_g|s1_vddr_m1|s2_vddr_m1|s3_vddr_m1|s4_vddr_m1|vddr|vddr3
+ 1.5474e-17
* device instance cc_a_g_a_rn4_ro_s4_y_y_a_g_y_mnab_y_mpa_y_mpb_y_n1_s1_a_y r0 *1 0,0
Ccc_a_g_a_rn4_ro_s4_y_y_a_g_y_mnab_y_mpa_y_mpb_y_n1_s1_a_y a|g_a|rn4|ro|s4_y|y
+ a|g_y|mnab_y|mpa_y|mpb_y|n1|s1_a|y$3 1.5977e-17
* device instance cc_a_g_a_rn4_ro_s4_y_y_g_vddr_m1_mnt_g_s1_vddr_m1_s2_vddr_m1_s3_vddr_m1_s4_vddr_m1_vddr_vddr4 r0 *1 0,0
Ccc_a_g_a_rn4_ro_s4_y_y_g_vddr_m1_mnt_g_s1_vddr_m1_s2_vddr_m1_s3_vddr_m1_s4_vddr_m1_vddr_vddr4
+ a|g_a|rn4|ro|s4_y|y
+ g_vddr_m1|mnt_g|s1_vddr_m1|s2_vddr_m1|s3_vddr_m1|s4_vddr_m1|vddr|vddr4
+ 1.5474e-17
* device instance cc_a_g_a_rn4_ro_s4_y_y_g_vss_m1_mph_g_s1_vss_m1_s2_vss_m1_s3_vss_m1_s4_vss_m1_vss_vss_x1_vss_x2_vss_x3 r0 *1 0,0
Ccc_a_g_a_rn4_ro_s4_y_y_g_vss_m1_mph_g_s1_vss_m1_s2_vss_m1_s3_vss_m1_s4_vss_m1_vss_vss_x1_vss_x2_vss_x3
+ a|g_a|rn4|ro|s4_y|y
+ g_vss_m1|mph_g|s1_vss_m1|s2_vss_m1|s3_vss_m1|s4_vss_m1|vss|vss_x1|vss_x2|vss_x3
+ 1.4912e-17
* device instance cc_a_g_y_mnab_y_mpa_y_mpb_y_n1_s1_a_y_g_vss_m1_mph_g_s1_vss_m1_s2_vss_m1_s3_vss_m1_s4_vss_m1_vss_vss_x1_vss_x2_vss_x3 r0 *1 0,0
Ccc_a_g_y_mnab_y_mpa_y_mpb_y_n1_s1_a_y_g_vss_m1_mph_g_s1_vss_m1_s2_vss_m1_s3_vss_m1_s4_vss_m1_vss_vss_x1_vss_x2_vss_x3
+ a|g_y|mnab_y|mpa_y|mpb_y|n1|s1_a|y$3
+ g_vss_m1|mph_g|s1_vss_m1|s2_vss_m1|s3_vss_m1|s4_vss_m1|vss|vss_x1|vss_x2|vss_x3
+ 1.5474e-17
* device instance cc_a_g_y_mnab_y_mpa_y_mpb_y_n1_s1_a_y_ny r0 *1 0,0
Ccc_a_g_y_mnab_y_mpa_y_mpb_y_n1_s1_a_y_ny a|g_y|mnab_y|mpa_y|mpb_y|n1|s1_a|y$3
+ ny$19 1.1511e-17
* device instance cc_a_inva_a_mn12_g0_mp13_g0_ro1_y_a_inva_a_mn12_g0_mp13_g0_t1_y r0 *1 0,0
Ccc_a_inva_a_mn12_g0_mp13_g0_ro1_y_a_inva_a_mn12_g0_mp13_g0_t1_y
+ a|inva_a|mn12_g0|mp13_g0|ro1|y a|inva_a|mn12_g0|mp13_g0|t1|y 3.3e-18
* device instance cc_a_inva_a_mn12_g0_mp13_g0_ro1_y_g_vss_m1_mph_g_s1_vss_m1_s2_vss_m1_s3_vss_m1_s4_vss_m1_vss_vss_x1_vss_x2_vss_x3 r0 *1 0,0
Ccc_a_inva_a_mn12_g0_mp13_g0_ro1_y_g_vss_m1_mph_g_s1_vss_m1_s2_vss_m1_s3_vss_m1_s4_vss_m1_vss_vss_x1_vss_x2_vss_x3
+ a|inva_a|mn12_g0|mp13_g0|ro1|y
+ g_vss_m1|mph_g|s1_vss_m1|s2_vss_m1|s3_vss_m1|s4_vss_m1|vss|vss_x1|vss_x2|vss_x3
+ 6.601e-18
* device instance cc_a_inva_a_mn12_g0_mp13_g0_ro1_y_vdd_vdd_b1_vdd_b2_vdd_b3_vdd_b4_vdd_x1_vdd_x2_vdd_x3 r0 *1 0,0
Ccc_a_inva_a_mn12_g0_mp13_g0_ro1_y_vdd_vdd_b1_vdd_b2_vdd_b3_vdd_b4_vdd_x1_vdd_x2_vdd_x3
+ a|inva_a|mn12_g0|mp13_g0|ro1|y
+ vdd|vdd_b1|vdd_b2|vdd_b3|vdd_b4|vdd_x1|vdd_x2|vdd_x3 4.1531e-17
* device instance cc_a_inva_a_mn12_g0_mp13_g0_ro3_y_g_vss_m1_mph_g_s1_vss_m1_s2_vss_m1_s3_vss_m1_s4_vss_m1_vss_vss_x1_vss_x2_vss_x3 r0 *1 0,0
Ccc_a_inva_a_mn12_g0_mp13_g0_ro3_y_g_vss_m1_mph_g_s1_vss_m1_s2_vss_m1_s3_vss_m1_s4_vss_m1_vss_vss_x1_vss_x2_vss_x3
+ a|inva_a|mn12_g0|mp13_g0|ro3|y
+ g_vss_m1|mph_g|s1_vss_m1|s2_vss_m1|s3_vss_m1|s4_vss_m1|vss|vss_x1|vss_x2|vss_x3
+ 1.6158e-17
* device instance cc_a_inva_a_mn12_g0_mp13_g0_ro3_y_vdd_vdd_b1_vdd_b2_vdd_b3_vdd_b4_vdd_x1_vdd_x2_vdd_x3 r0 *1 0,0
Ccc_a_inva_a_mn12_g0_mp13_g0_ro3_y_vdd_vdd_b1_vdd_b2_vdd_b3_vdd_b4_vdd_x1_vdd_x2_vdd_x3
+ a|inva_a|mn12_g0|mp13_g0|ro3|y
+ vdd|vdd_b1|vdd_b2|vdd_b3|vdd_b4|vdd_x1|vdd_x2|vdd_x3 3.1973e-17
* device instance cc_a_inva_a_mn12_g0_mp13_g0_t1_y_bn_invb_y_mn34_g1_mp24_g1_y r0 *1 0,0
Ccc_a_inva_a_mn12_g0_mp13_g0_t1_y_bn_invb_y_mn34_g1_mp24_g1_y
+ a|inva_a|mn12_g0|mp13_g0|t1|y bn|invb_y|mn34_g1|mp24_g1|y$2 9.901e-18
* device instance cc_a_inva_a_mn12_g0_mp13_g0_t1_y_g_vss_m1_mph_g_s1_vss_m1_s2_vss_m1_s3_vss_m1_s4_vss_m1_vss_vss_x1_vss_x2_vss_x3 r0 *1 0,0
Ccc_a_inva_a_mn12_g0_mp13_g0_t1_y_g_vss_m1_mph_g_s1_vss_m1_s2_vss_m1_s3_vss_m1_s4_vss_m1_vss_vss_x1_vss_x2_vss_x3
+ a|inva_a|mn12_g0|mp13_g0|t1|y
+ g_vss_m1|mph_g|s1_vss_m1|s2_vss_m1|s3_vss_m1|s4_vss_m1|vss|vss_x1|vss_x2|vss_x3
+ 6.601e-18
* device instance cc_a_inva_a_mn12_g0_mp13_g0_t1_y_mid r0 *1 0,0
Ccc_a_inva_a_mn12_g0_mp13_g0_t1_y_mid a|inva_a|mn12_g0|mp13_g0|t1|y mid$2
+ 3.3e-18
* device instance cc_a_inva_a_mn12_g0_mp13_g0_t1_y_vdd_vdd_b1_vdd_b2_vdd_b3_vdd_b4_vdd_x1_vdd_x2_vdd_x3 r0 *1 0,0
Ccc_a_inva_a_mn12_g0_mp13_g0_t1_y_vdd_vdd_b1_vdd_b2_vdd_b3_vdd_b4_vdd_x1_vdd_x2_vdd_x3
+ a|inva_a|mn12_g0|mp13_g0|t1|y
+ vdd|vdd_b1|vdd_b2|vdd_b3|vdd_b4|vdd_x1|vdd_x2|vdd_x3 3.5274e-17
* device instance cc_a_inva_a_mn12_g0_mp13_g0_t1_y_xo_y r0 *1 0,0
Ccc_a_inva_a_mn12_g0_mp13_g0_t1_y_xo_y a|inva_a|mn12_g0|mp13_g0|t1|y xo|y
+ 3.3e-18
* device instance cc_a_n2_s1_y_s2_a_y_g_vss_m1_mph_g_s1_vss_m1_s2_vss_m1_s3_vss_m1_s4_vss_m1_vss_vss_x1_vss_x2_vss_x3 r0 *1 0,0
Ccc_a_n2_s1_y_s2_a_y_g_vss_m1_mph_g_s1_vss_m1_s2_vss_m1_s3_vss_m1_s4_vss_m1_vss_vss_x1_vss_x2_vss_x3
+ a|n2|s1_y|s2_a|y$3
+ g_vss_m1|mph_g|s1_vss_m1|s2_vss_m1|s3_vss_m1|s4_vss_m1|vss|vss_x1|vss_x2|vss_x3
+ 1.5474e-17
* device instance cc_a_n2_s1_y_s2_a_y_ny r0 *1 0,0
Ccc_a_n2_s1_y_s2_a_y_ny a|n2|s1_y|s2_a|y$3 ny$19 1.1511e-17
* device instance cc_a_n3_s2_y_s3_a_y_g_vss_m1_mph_g_s1_vss_m1_s2_vss_m1_s3_vss_m1_s4_vss_m1_vss_vss_x1_vss_x2_vss_x3 r0 *1 0,0
Ccc_a_n3_s2_y_s3_a_y_g_vss_m1_mph_g_s1_vss_m1_s2_vss_m1_s3_vss_m1_s4_vss_m1_vss_vss_x1_vss_x2_vss_x3
+ a|n3|s2_y|s3_a|y$3
+ g_vss_m1|mph_g|s1_vss_m1|s2_vss_m1|s3_vss_m1|s4_vss_m1|vss|vss_x1|vss_x2|vss_x3
+ 1.5474e-17
* device instance cc_a_n3_s2_y_s3_a_y_ny r0 *1 0,0
Ccc_a_n3_s2_y_s3_a_y_ny a|n3|s2_y|s3_a|y$3 ny$19 1.1511e-17
* device instance cc_a_n4_s3_y_s4_a_y_g_vss_m1_mph_g_s1_vss_m1_s2_vss_m1_s3_vss_m1_s4_vss_m1_vss_vss_x1_vss_x2_vss_x3 r0 *1 0,0
Ccc_a_n4_s3_y_s4_a_y_g_vss_m1_mph_g_s1_vss_m1_s2_vss_m1_s3_vss_m1_s4_vss_m1_vss_vss_x1_vss_x2_vss_x3
+ a|n4|s3_y|s4_a|y$3
+ g_vss_m1|mph_g|s1_vss_m1|s2_vss_m1|s3_vss_m1|s4_vss_m1|vss|vss_x1|vss_x2|vss_x3
+ 1.5474e-17
* device instance cc_a_n4_s3_y_s4_a_y_ny r0 *1 0,0
Ccc_a_n4_s3_y_s4_a_y_ny a|n4|s3_y|s4_a|y$3 ny$19 1.1511e-17
* device instance cc_bn_invb_y_mn34_g1_mp24_g1_y_mid r0 *1 0,0
Ccc_bn_invb_y_mn34_g1_mp24_g1_y_mid bn|invb_y|mn34_g1|mp24_g1|y$2 mid$2
+ 9.901e-18
* device instance cc_bn_invb_y_mn34_g1_mp24_g1_y_vdd_vdd_b1_vdd_b2_vdd_b3_vdd_b4_vdd_x1_vdd_x2_vdd_x3 r0 *1 0,0
Ccc_bn_invb_y_mn34_g1_mp24_g1_y_vdd_vdd_b1_vdd_b2_vdd_b3_vdd_b4_vdd_x1_vdd_x2_vdd_x3
+ bn|invb_y|mn34_g1|mp24_g1|y$2
+ vdd|vdd_b1|vdd_b2|vdd_b3|vdd_b4|vdd_x1|vdd_x2|vdd_x3 9.901e-18
* device instance cc_bn_invb_y_mn34_g1_mp24_g1_y_xo_y r0 *1 0,0
Ccc_bn_invb_y_mn34_g1_mp24_g1_y_xo_y bn|invb_y|mn34_g1|mp24_g1|y$2 xo|y
+ 9.901e-18
* device instance cc_g_vddr_m1_mnt_g_s1_vddr_m1_s2_vddr_m1_s3_vddr_m1_s4_vddr_m1_vddr_vddr1_py r0 *1 0,0
Ccc_g_vddr_m1_mnt_g_s1_vddr_m1_s2_vddr_m1_s3_vddr_m1_s4_vddr_m1_vddr_vddr1_py
+ g_vddr_m1|mnt_g|s1_vddr_m1|s2_vddr_m1|s3_vddr_m1|s4_vddr_m1|vddr|vddr1 py$15
+ 1.2471e-17
* device instance cc_g_vddr_m1_mnt_g_s1_vddr_m1_s2_vddr_m1_s3_vddr_m1_s4_vddr_m1_vddr_vddr2_py r0 *1 0,0
Ccc_g_vddr_m1_mnt_g_s1_vddr_m1_s2_vddr_m1_s3_vddr_m1_s4_vddr_m1_vddr_vddr2_py
+ g_vddr_m1|mnt_g|s1_vddr_m1|s2_vddr_m1|s3_vddr_m1|s4_vddr_m1|vddr|vddr2 py$15
+ 1.3064e-17
* device instance cc_g_vddr_m1_mnt_g_s1_vddr_m1_s2_vddr_m1_s3_vddr_m1_s4_vddr_m1_vddr_vddr3_py r0 *1 0,0
Ccc_g_vddr_m1_mnt_g_s1_vddr_m1_s2_vddr_m1_s3_vddr_m1_s4_vddr_m1_vddr_vddr3_py
+ g_vddr_m1|mnt_g|s1_vddr_m1|s2_vddr_m1|s3_vddr_m1|s4_vddr_m1|vddr|vddr3 py$15
+ 1.3658e-17
* device instance cc_g_vddr_m1_mnt_g_s1_vddr_m1_s2_vddr_m1_s3_vddr_m1_s4_vddr_m1_vddr_vddr4_py r0 *1 0,0
Ccc_g_vddr_m1_mnt_g_s1_vddr_m1_s2_vddr_m1_s3_vddr_m1_s4_vddr_m1_vddr_vddr4_py
+ g_vddr_m1|mnt_g|s1_vddr_m1|s2_vddr_m1|s3_vddr_m1|s4_vddr_m1|vddr|vddr4 py$15
+ 1.4252e-17
* device instance cc_g_vss_m1_mph_g_s1_vss_m1_s2_vss_m1_s3_vss_m1_s4_vss_m1_vss_vss_x1_vss_x2_vss_x3_vdd_vdd_b1_vdd_b2_vdd_b3_vdd_b4_vdd_x1_vdd_x2_vdd_x3 r0 *1 0,0
Ccc_g_vss_m1_mph_g_s1_vss_m1_s2_vss_m1_s3_vss_m1_s4_vss_m1_vss_vss_x1_vss_x2_vss_x3_vdd_vdd_b1_vdd_b2_vdd_b3_vdd_b4_vdd_x1_vdd_x2_vdd_x3
+ g_vss_m1|mph_g|s1_vss_m1|s2_vss_m1|s3_vss_m1|s4_vss_m1|vss|vss_x1|vss_x2|vss_x3
+ vdd|vdd_b1|vdd_b2|vdd_b3|vdd_b4|vdd_x1|vdd_x2|vdd_x3 2.3613e-17
* device instance vsubs_dctie r0 *1 0,0
Rvsubs_dctie vsubs 0 1e+12
.ENDS ro_array_core
