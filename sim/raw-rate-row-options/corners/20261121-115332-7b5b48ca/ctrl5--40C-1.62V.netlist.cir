* Ring transient-noise jitter accumulation, klt-sim form -- issue #600
*
* Circuit-body TEMPLATE for make-requests.py: it carries no .lib, .temp,
* .tran, .control or .end card -- `klt sim` owns those (process corner via
* the request's corners.process, temperature via corners.temperature_c,
* analysis via analysis.args = "20p 115n uic"). make-requests.py
* substitutes these tokens:
*
*   DESIGN token   the text of design/ro_ring5.spice, verbatim (ro_ring5,
*                  ro_nand2, ro_stage; the ring is built in place from
*                  ro_nand2 + ro_stage exactly as the committed campaign
*                  deck does)
*   VDD token      the supply of this deck (1.62 / 1.80 / 1.98 V)
*   VTHR token     the half-supply crossing threshold (0.81 / 0.9 / 0.99)
*   RING token     the per-configuration ring instance lines (trnoise
*                  sources in series at every stage input)
*   IC token       the initial-condition card's right-hand side
*
* DERIVED, BYTE-FOR-BYTE IN METHOD, from the committed campaign deck
* sim/ro-ring-jitter-accumulation/testbench/tb_ro_ring5_jitter.spice
* (issue #10): the same starved ring built in place from ro_nand2 +
* ro_stage, the same per-stage series trnoise() injection topology
* (ro -> gA -> nand2 -> n1 -> gB -> stage1 -> ...), the same calibration
* NA=2.0e-3 V rms / NT=2e-10 s (one-sided injected PSD 1.6e-15 V^2/Hz,
* anchored once to sim/ro-stage-noise-mechanism-check/records/
* 20260825-022446-d58d709.md), the same .option seed=1 (common random
* numbers across the grid; single-seed caveat inherited verbatim from the
* committed campaign), the same tstop 115n and TMAX 20p, and the same
* initial-condition pattern. Two deliberate differences, both forced by
* the klt sim contract (the runner owns the deck's single .control block,
* so a caller-side one cannot be submitted):
*
*   1. the committed deck's .control estimator loop (21 rising-crossing
*      times tc2..tc22, tbar, sigma_1/2/4/8) is re-expressed as 21
*      top-level `.meas tran tc<k> when v(ro)=<VTHR> rise=<k>` cards
*      supplied through the request's measurements[]; tbar/sigma_N are
*      recomputed from those 21 times by sim/raw-rate-row-options/reduce.py
*      using the committed formulas VERBATIM (including the 1-k/20
*      divisors), so the arithmetic is identical and auditable.
*   2. .temp is dropped (the request carries temperature_c).
*
* Configurations (make-requests.py):
*
*   ctrl5   the committed ro_ring5 jitter vehicle itself (1 ro_nand2 + 4
*           ro_stage) -- the BASELINE CONTROL: at ss/tt/ff x -40 C x
*           1.62 V it must reproduce committed record
*           sim/ro-ring-jitter-accumulation/records/20260825-060208-54f5715
*           (raw sigma_1 and tbar per corner) before any ring3 result is
*           trusted.
*   ring3   1 ro_nand2 + 2 ro_stage: the 3-inversion ring, the fastest
*           odd-stage-count ring this cell set supports (2 inversions
*           cannot oscillate). Measures whether DR-0002's measured
*           fewer-stages-is-better entropy direction continues below 5
*           stages, and what swing a 3-stage ring still has (DR-0002
*           Sec 2's explicit re-check condition for any count below 5).

.option scale=1u

* ro_ring5 -- GENERATED by design/netlist.py from design/xschem/ro_ring5.sch
* Do not edit by hand: `python3 design/netlist.py --check` fails if this
* file and the schematic disagree. Regenerate with `python3 design/netlist.py`.
** sch_path: ro_ring5.sch
.subckt ro_ring5 en ro vddr vss wstv=0.42 lstv=2 cld=0.5f
*.ipin en
*.opin ro
*.iopin vddr
*.iopin vss
xg ro en n1 vddr vss ro_nand2 wstv=wstv lstv=lstv cld=cld
x1 n1 n2 vddr vss ro_stage wstv=wstv lstv=lstv cld=cld
x2 n2 n3 vddr vss ro_stage wstv=wstv lstv=lstv cld=cld
x3 n3 n4 vddr vss ro_stage wstv=wstv lstv=lstv cld=cld
x4 n4 ro vddr vss ro_stage wstv=wstv lstv=lstv cld=cld
.ends

* expanding   symbol:  ro_nand2.sym # of pins=5
** sym_path: ro_nand2.sym
** sch_path: ro_nand2.sch
.subckt ro_nand2 a en y vddr vss wstv=0.42 lstv=2 cld=0.5f
*.ipin a
*.ipin en
*.opin y
*.iopin vddr
*.iopin vss
XMph py vss vddr vddr sky130_fd_pr__pfet_01v8 L=lstv W=wstv nf=1 ad='int((1 + 1)/2) * wstv / 1 * 0.29'
+ as='int((1 + 2)/2) * wstv / 1 * 0.29' pd='2*int((1 + 1)/2) * (wstv / 1 + 0.29)'
+ ps='2*int((1 + 2)/2) * (wstv / 1 + 0.29)' nrd='0.29 / wstv ' nrs='0.29 / wstv ' sa=0 sb=0 sd=0 mult=1 m=1
XMpa y a py vddr sky130_fd_pr__pfet_01v8 L=0.15 W=0.84 nf=1 ad=0.2436 as=0.2436 pd=2.26 ps=2.26 nrd=0.345238095238095
+ nrs=0.345238095238095 sa=0 sb=0 sd=0 mult=1 m=1
XMpb y en py vddr sky130_fd_pr__pfet_01v8 L=0.15 W=0.84 nf=1 ad=0.2436 as=0.2436 pd=2.26 ps=2.26 nrd=0.345238095238095
+ nrs=0.345238095238095 sa=0 sb=0 sd=0 mult=1 m=1
XMna y a nm vss sky130_fd_pr__nfet_01v8 L=0.15 W=0.84 nf=1 ad=0.2436 as=0.2436 pd=2.26 ps=2.26 nrd=0.345238095238095
+ nrs=0.345238095238095 sa=0 sb=0 sd=0 mult=1 m=1
XMnb nm en ny vss sky130_fd_pr__nfet_01v8 L=0.15 W=0.84 nf=1 ad=0.2436 as=0.2436 pd=2.26 ps=2.26 nrd=0.345238095238095
+ nrs=0.345238095238095 sa=0 sb=0 sd=0 mult=1 m=1
XMnt ny vddr vss vss sky130_fd_pr__nfet_01v8 L=lstv W=wstv nf=1 ad='int((1 + 1)/2) * wstv / 1 * 0.29'
+ as='int((1 + 2)/2) * wstv / 1 * 0.29' pd='2*int((1 + 1)/2) * (wstv / 1 + 0.29)'
+ ps='2*int((1 + 2)/2) * (wstv / 1 + 0.29)' nrd='0.29 / wstv ' nrs='0.29 / wstv ' sa=0 sb=0 sd=0 mult=1 m=1
Cld y vss 'cld' m=1
.ends

* expanding   symbol:  ro_stage.sym # of pins=4
** sym_path: ro_stage.sym
** sch_path: ro_stage.sch
.subckt ro_stage a y vddr vss wstv=0.42 lstv=2 cld=0.5f
*.ipin a
*.opin y
*.iopin vddr
*.iopin vss
XMph py vss vddr vddr sky130_fd_pr__pfet_01v8 L=lstv W=wstv nf=1 ad='int((1 + 1)/2) * wstv / 1 * 0.29'
+ as='int((1 + 2)/2) * wstv / 1 * 0.29' pd='2*int((1 + 1)/2) * (wstv / 1 + 0.29)'
+ ps='2*int((1 + 2)/2) * (wstv / 1 + 0.29)' nrd='0.29 / wstv ' nrs='0.29 / wstv ' sa=0 sb=0 sd=0 mult=1 m=1
XMp y a py vddr sky130_fd_pr__pfet_01v8 L=0.15 W=0.84 nf=1 ad=0.2436 as=0.2436 pd=2.26 ps=2.26 nrd=0.345238095238095
+ nrs=0.345238095238095 sa=0 sb=0 sd=0 mult=1 m=1
XMn y a ny vss sky130_fd_pr__nfet_01v8 L=0.15 W=0.42 nf=1 ad=0.1218 as=0.1218 pd=1.42 ps=1.42 nrd=0.69047619047619
+ nrs=0.69047619047619 sa=0 sb=0 sd=0 mult=1 m=1
XMnt ny vddr vss vss sky130_fd_pr__nfet_01v8 L=lstv W=wstv nf=1 ad='int((1 + 1)/2) * wstv / 1 * 0.29'
+ as='int((1 + 2)/2) * wstv / 1 * 0.29' pd='2*int((1 + 1)/2) * (wstv / 1 + 0.29)'
+ ps='2*int((1 + 2)/2) * (wstv / 1 + 0.29)' nrd='0.29 / wstv ' nrs='0.29 / wstv ' sa=0 sb=0 sd=0 mult=1 m=1
Cld y vss 'cld' m=1
.ends

Vddr vddr 0 dc 1.62
Ven en 0 dc 1.62

xg gA en n1 vddr 0 ro_nand2
VnA gA ro dc 0 trnoise(2.0e-3 2e-10 0 0)
x1 gB n2 vddr 0 ro_stage
VnB gB n1 dc 0 trnoise(2.0e-3 2e-10 0 0)
x2 gC n3 vddr 0 ro_stage
VnC gC n2 dc 0 trnoise(2.0e-3 2e-10 0 0)
x3 gD n4 vddr 0 ro_stage
VnD gD n3 dc 0 trnoise(2.0e-3 2e-10 0 0)
x4 gE ro vddr 0 ro_stage
VnE gE n4 dc 0 trnoise(2.0e-3 2e-10 0 0)

.ic v(ro)=0 v(n1)=1.62 v(n2)=0 v(n3)=1.62 v(n4)=0

.option seed=1
