* Ring swing, buffered-output swing, and per-ring supply current, klt-sim form -- issue #600
*
* Circuit-body TEMPLATE for make-requests.py: no .lib, .temp, .tran, .control
* or .end card -- `klt sim` owns those (process via the request's
* corners.process, temperature via corners.temperature_c, analysis via
* analysis.args = "5p 80n uic"). Tokens (see make-requests.py):
*
*   DESIGN token   the text of design/ro_array_core.spice, verbatim (defines
*                  ro_nand2, ro_stage AND ro_buf; the committed swing deck
*                  includes the same library via --ro-ring5)
*   VDD token      the supply of this deck (1.62 / 1.80 / 1.98 V)
*   RINGA / RINGB  the running / stopped ring instance lines
*   IC token       the running ring's initial-condition right-hand side
*
* DERIVED FROM the committed deterministic deck
* sim/ro-ring5-swing-and-current/testbench/tb_ro_ring5_swing_current.spice
* (issue #13) with the same topology and the same purpose: ring A enabled and
* free-running on its own vddrA, its output driving one ro_buf on the separate
* block supply so the buffer current never contaminates the ring current, and
* ring B identical but held stopped (en = 0) for the static-current figure.
* Deterministic -- no injected sources -- so the swing is the ring's own
* steady-state excursion and every figure replays bit-exactly per build.
* Differences from the committed deck, both forced by the klt sim contract
* (the runner owns the deck's single .control block):
*
*   1. the .control measurements become top-level `.meas` cards supplied
*      through the request's measurements[] (vmax/vmin ring and buffer,
*      tc3/tc11 for the period, tfall3/tc4 for the duty cycle, and the three
*      AVG supply currents); tbar = (tc11 - tc3)/8, the swing fractions, the
*      duty cycle and the sign-flipped currents are recomputed by
*      sim/raw-rate-row-options/reduce.py with the committed formulas.
*   2. .temp is dropped (the request carries temperature_c).
*
* Configurations (make-requests.py):
*
*   sc5   the committed 5-stage geometry itself -- the DETERMINISTIC baseline
*         control: must reproduce the committed records
*         sim/ro-ring5-swing-and-current/records/20260825-085{315,402,449,537}-53f1f7a
*         (loaded tbar, i_ring_run, i_buf, swing fractions) at every point.
*   sc3   the 3-inversion ring (ro_nand2 + 2 ro_stage): its own LOADED period
*         (replacing the ring5-ratio estimate the jitter reduction would
*         otherwise need), its own per-ring supply current for the power-row
*         arithmetic, and -- the question DR-0002 Sec 2 explicitly leaves open
*         for any stage count below five -- whether the ring node's reduced
*         swing still squares back up through ro_buf.

.option scale=1u

* ro_array_core -- GENERATED by design/netlist.py from design/xschem/ro_array_core.sch
* Do not edit by hand: `python3 design/netlist.py --check` fails if this
* file and the schematic disagree. Regenerate with `python3 design/netlist.py`.
** sch_path: ro_array_core.sch
.subckt ro_array_core en1 en2 en3 en4 vddr1 vddr2 vddr3 vddr4 vdd vss xo ro1 ro2 ro3 ro4
*.ipin en1
*.ipin en2
*.ipin en3
*.ipin en4
*.iopin vddr1
*.iopin vddr2
*.iopin vddr3
*.iopin vddr4
*.iopin vdd
*.iopin vss
*.opin xo
*.opin ro1
*.opin ro2
*.opin ro3
*.opin ro4
xr1 en1 rn1 vddr1 vss ro_ring5 wstv=0.42 lstv=2 cld=0.5f
xr2 en2 rn2 vddr2 vss ro_ring5 wstv=0.44 lstv=2 cld=0.5f
xr3 en3 rn3 vddr3 vss ro_ring5 wstv=0.46 lstv=2 cld=0.5f
xr4 en4 rn4 vddr4 vss ro_ring5 wstv=0.48 lstv=2 cld=0.5f
xb1 rn1 ro1 vdd vss ro_buf
xb2 rn2 ro2 vdd vss ro_buf
xb3 rn3 ro3 vdd vss ro_buf
xb4 rn4 ro4 vdd vss ro_buf
xa1 ro1 ro2 t1 vdd vss xor2
xa2 ro3 ro4 t2 vdd vss xor2
xa3 t1 t2 xo vdd vss xor2
.ends

* expanding   symbol:  ro_ring5.sym # of pins=4
** sym_path: ro_ring5.sym
** sch_path: ro_ring5.sch
.subckt ro_ring5 en ro vddr vss wstv=0.42 lstv=2 cld=0.5f
*.ipin en
*.opin ro
*.iopin vddr
*.iopin vss
xg ro en n1 vddr vss ro_nand2 wstv=wstv lstv=lstv cld=cld
x1 n1 n2 vddr vss ro_stage wstv=wstv lstv=lstv cld=cld
x2 n2 n3 vddr vss ro_stage wstv=wstv lstv=lstv cld=cld
x3 n3 n4 vddr vss ro_stage wstv=wstv lstv=lstv cld=cld
x4 n4 ro vddr vss ro_stage wstv=wstv lstv=lstv cld=cld
.ends

* expanding   symbol:  ro_buf.sym # of pins=4
** sym_path: ro_buf.sym
** sch_path: ro_buf.sch
.subckt ro_buf a y vdd vss
*.ipin a
*.opin y
*.iopin vdd
*.iopin vss
XMp y a vdd vdd sky130_fd_pr__pfet_01v8 L=0.15 W=0.84 nf=1 ad=0.2436 as=0.2436 pd=2.26 ps=2.26 nrd=0.345238095238095
+ nrs=0.345238095238095 sa=0 sb=0 sd=0 mult=1 m=1
XMn y a vss vss sky130_fd_pr__nfet_01v8 L=0.15 W=0.42 nf=1 ad=0.1218 as=0.1218 pd=1.42 ps=1.42 nrd=0.69047619047619
+ nrs=0.69047619047619 sa=0 sb=0 sd=0 mult=1 m=1
.ends

* expanding   symbol:  xor2.sym # of pins=5
** sym_path: xor2.sym
** sch_path: xor2.sch
.subckt xor2 a b y vdd vss
*.ipin a
*.ipin b
*.opin y
*.iopin vdd
*.iopin vss
XMpiA an a vdd vdd sky130_fd_pr__pfet_01v8 L=0.15 W=0.84 nf=1 ad=0.2436 as=0.2436 pd=2.26 ps=2.26 nrd=0.345238095238095
+ nrs=0.345238095238095 sa=0 sb=0 sd=0 mult=1 m=1
XMniA an a vss vss sky130_fd_pr__nfet_01v8 L=0.15 W=0.42 nf=1 ad=0.1218 as=0.1218 pd=1.42 ps=1.42 nrd=0.69047619047619
+ nrs=0.69047619047619 sa=0 sb=0 sd=0 mult=1 m=1
XMpiB bn b vdd vdd sky130_fd_pr__pfet_01v8 L=0.15 W=0.84 nf=1 ad=0.2436 as=0.2436 pd=2.26 ps=2.26 nrd=0.345238095238095
+ nrs=0.345238095238095 sa=0 sb=0 sd=0 mult=1 m=1
XMniB bn b vss vss sky130_fd_pr__nfet_01v8 L=0.15 W=0.42 nf=1 ad=0.1218 as=0.1218 pd=1.42 ps=1.42 nrd=0.69047619047619
+ nrs=0.69047619047619 sa=0 sb=0 sd=0 mult=1 m=1
XMp1 mid a vdd vdd sky130_fd_pr__pfet_01v8 L=0.15 W=1.68 nf=1 ad=0.4872 as=0.4872 pd=3.94 ps=3.94 nrd=0.172619047619048
+ nrs=0.172619047619048 sa=0 sb=0 sd=0 mult=1 m=1
XMp2 mid b vdd vdd sky130_fd_pr__pfet_01v8 L=0.15 W=1.68 nf=1 ad=0.4872 as=0.4872 pd=3.94 ps=3.94 nrd=0.172619047619048
+ nrs=0.172619047619048 sa=0 sb=0 sd=0 mult=1 m=1
XMp3 y an mid vdd sky130_fd_pr__pfet_01v8 L=0.15 W=1.68 nf=1 ad=0.4872 as=0.4872 pd=3.94 ps=3.94 nrd=0.172619047619048
+ nrs=0.172619047619048 sa=0 sb=0 sd=0 mult=1 m=1
XMp4 y bn mid vdd sky130_fd_pr__pfet_01v8 L=0.15 W=1.68 nf=1 ad=0.4872 as=0.4872 pd=3.94 ps=3.94 nrd=0.172619047619048
+ nrs=0.172619047619048 sa=0 sb=0 sd=0 mult=1 m=1
XMn1 y a s1 vss sky130_fd_pr__nfet_01v8 L=0.15 W=0.84 nf=1 ad=0.2436 as=0.2436 pd=2.26 ps=2.26 nrd=0.345238095238095
+ nrs=0.345238095238095 sa=0 sb=0 sd=0 mult=1 m=1
XMn2 s1 b vss vss sky130_fd_pr__nfet_01v8 L=0.15 W=0.84 nf=1 ad=0.2436 as=0.2436 pd=2.26 ps=2.26 nrd=0.345238095238095
+ nrs=0.345238095238095 sa=0 sb=0 sd=0 mult=1 m=1
XMn3 y an s2 vss sky130_fd_pr__nfet_01v8 L=0.15 W=0.84 nf=1 ad=0.2436 as=0.2436 pd=2.26 ps=2.26 nrd=0.345238095238095
+ nrs=0.345238095238095 sa=0 sb=0 sd=0 mult=1 m=1
XMn4 s2 bn vss vss sky130_fd_pr__nfet_01v8 L=0.15 W=0.84 nf=1 ad=0.2436 as=0.2436 pd=2.26 ps=2.26 nrd=0.345238095238095
+ nrs=0.345238095238095 sa=0 sb=0 sd=0 mult=1 m=1
.ends

* expanding   symbol:  ro_nand2.sym # of pins=5
** sym_path: ro_nand2.sym
** sch_path: ro_nand2.sch
.subckt ro_nand2 a en y vddr vss wstv=0.42 lstv=2 cld=0.5f
*.ipin a
*.ipin en
*.opin y
*.iopin vddr
*.iopin vss
XMph py vss vddr vddr sky130_fd_pr__pfet_01v8 L=lstv W=wstv nf=1 ad='int((1 + 1)/2) * wstv / 1 * 0.29'
+ as='int((1 + 2)/2) * wstv / 1 * 0.29' pd='2*int((1 + 1)/2) * (wstv / 1 + 0.29)'
+ ps='2*int((1 + 2)/2) * (wstv / 1 + 0.29)' nrd='0.29 / wstv ' nrs='0.29 / wstv ' sa=0 sb=0 sd=0 mult=1 m=1
XMpa y a py vddr sky130_fd_pr__pfet_01v8 L=0.15 W=0.84 nf=1 ad=0.2436 as=0.2436 pd=2.26 ps=2.26 nrd=0.345238095238095
+ nrs=0.345238095238095 sa=0 sb=0 sd=0 mult=1 m=1
XMpb y en py vddr sky130_fd_pr__pfet_01v8 L=0.15 W=0.84 nf=1 ad=0.2436 as=0.2436 pd=2.26 ps=2.26 nrd=0.345238095238095
+ nrs=0.345238095238095 sa=0 sb=0 sd=0 mult=1 m=1
XMna y a nm vss sky130_fd_pr__nfet_01v8 L=0.15 W=0.84 nf=1 ad=0.2436 as=0.2436 pd=2.26 ps=2.26 nrd=0.345238095238095
+ nrs=0.345238095238095 sa=0 sb=0 sd=0 mult=1 m=1
XMnb nm en ny vss sky130_fd_pr__nfet_01v8 L=0.15 W=0.84 nf=1 ad=0.2436 as=0.2436 pd=2.26 ps=2.26 nrd=0.345238095238095
+ nrs=0.345238095238095 sa=0 sb=0 sd=0 mult=1 m=1
XMnt ny vddr vss vss sky130_fd_pr__nfet_01v8 L=lstv W=wstv nf=1 ad='int((1 + 1)/2) * wstv / 1 * 0.29'
+ as='int((1 + 2)/2) * wstv / 1 * 0.29' pd='2*int((1 + 1)/2) * (wstv / 1 + 0.29)'
+ ps='2*int((1 + 2)/2) * (wstv / 1 + 0.29)' nrd='0.29 / wstv ' nrs='0.29 / wstv ' sa=0 sb=0 sd=0 mult=1 m=1
Cld y vss 'cld' m=1
.ends

* expanding   symbol:  ro_stage.sym # of pins=4
** sym_path: ro_stage.sym
** sch_path: ro_stage.sch
.subckt ro_stage a y vddr vss wstv=0.42 lstv=2 cld=0.5f
*.ipin a
*.opin y
*.iopin vddr
*.iopin vss
XMph py vss vddr vddr sky130_fd_pr__pfet_01v8 L=lstv W=wstv nf=1 ad='int((1 + 1)/2) * wstv / 1 * 0.29'
+ as='int((1 + 2)/2) * wstv / 1 * 0.29' pd='2*int((1 + 1)/2) * (wstv / 1 + 0.29)'
+ ps='2*int((1 + 2)/2) * (wstv / 1 + 0.29)' nrd='0.29 / wstv ' nrs='0.29 / wstv ' sa=0 sb=0 sd=0 mult=1 m=1
XMp y a py vddr sky130_fd_pr__pfet_01v8 L=0.15 W=0.84 nf=1 ad=0.2436 as=0.2436 pd=2.26 ps=2.26 nrd=0.345238095238095
+ nrs=0.345238095238095 sa=0 sb=0 sd=0 mult=1 m=1
XMn y a ny vss sky130_fd_pr__nfet_01v8 L=0.15 W=0.42 nf=1 ad=0.1218 as=0.1218 pd=1.42 ps=1.42 nrd=0.69047619047619
+ nrs=0.69047619047619 sa=0 sb=0 sd=0 mult=1 m=1
XMnt ny vddr vss vss sky130_fd_pr__nfet_01v8 L=lstv W=wstv nf=1 ad='int((1 + 1)/2) * wstv / 1 * 0.29'
+ as='int((1 + 2)/2) * wstv / 1 * 0.29' pd='2*int((1 + 1)/2) * (wstv / 1 + 0.29)'
+ ps='2*int((1 + 2)/2) * (wstv / 1 + 0.29)' nrd='0.29 / wstv ' nrs='0.29 / wstv ' sa=0 sb=0 sd=0 mult=1 m=1
Cld y vss 'cld' m=1
.ends

* --- ring A: enabled, free-running ------------------------------------
VddrA vddrA 0 dc 1.62
VenA enA 0 dc 1.62
xgA roA enA a1 vddrA 0 ro_nand2 wstv=0.42 lstv=2 cld=0.5f
x1A a1 a2 vddrA 0 ro_stage wstv=0.42 lstv=2 cld=0.5f
x2A a2 a3 vddrA 0 ro_stage wstv=0.42 lstv=2 cld=0.5f
x3A a3 a4 vddrA 0 ro_stage wstv=0.42 lstv=2 cld=0.5f
x4A a4 roA vddrA 0 ro_stage wstv=0.42 lstv=2 cld=0.5f

* --- ring A's output buffer, on the BLOCK supply, not on vddrA ---------
Vdd vdd 0 dc 1.62
xbA roA robA vdd 0 ro_buf

* --- ring B: identical geometry, held stopped (en = 0) ------------------
VddrB vddrB 0 dc 1.62
VenB enB 0 dc 0
xgB roB enB b1 vddrB 0 ro_nand2 wstv=0.42 lstv=2 cld=0.5f
x1B b1 b2 vddrB 0 ro_stage wstv=0.42 lstv=2 cld=0.5f
x2B b2 b3 vddrB 0 ro_stage wstv=0.42 lstv=2 cld=0.5f
x3B b3 b4 vddrB 0 ro_stage wstv=0.42 lstv=2 cld=0.5f
x4B b4 roB vddrB 0 ro_stage wstv=0.42 lstv=2 cld=0.5f

.ic v(roA)=0 v(a1)=1.62 v(a2)=0 v(a3)=1.62 v(a4)=0

.option seed=1
