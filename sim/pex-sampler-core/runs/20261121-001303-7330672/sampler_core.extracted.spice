* extracted by klt extract --deck sky130
* parasitic model (--parasitics):
* - capacitance: net-to-ground for every net's own (non-coupled) area/perimeter, plus net-to-net for the vertical-overlap coupling `coupling` describes below -- a coupled net pair gets a direct capacitor between their two hub nodes, not just capacitors to the deck's ground/substrate net
* - coupling: vertical overlap (crossover) unconditionally -- where one net's conductor on an adjacent metal level sits directly over another *distinct* net's conductor, that overlap area is charged between the two nets instead of to ground (issue #760) -- plus lateral (same-layer, sidewall) coupling, but only for a net pair naming one of the caller's declared `--critical-net` nets (issue #976): facing-edge length within that layer's own minimum-spacing lookback is charged between the two nets, *additively* (not deducted from either net's substrate fringe term, unlike the vertical case -- a known simplification). Any same-layer pair with neither side named `--critical-net`, and fringe shielding in general, are still not modelled
* - resistance: single lumped series resistance per net, distributed as a star across that net's device terminals (issue #592) -- not a per-segment, distributed RC ladder, *unless* `--distributed-rc` names this net via `--critical-net` (issue #977, Epic #709 Phase 2b): then the net's terminals are ordered along their approximate physical spread and its total R/C is broken into a chain of per-segment resistors (segment length proportional to inter-terminal distance) with a ground capacitor at each terminal node (proportional to its adjacent segment length/2), instead of one star hub -- still an approximation (terminal position is a device-placement proxy, not true per-segment routing geometry), but a strictly finer-grained one than the single-hub star
* - frequency: quasi-static -- one frequency-independent R and C per net; no skin effect, no distributed transmission-line behavior
* - substrate tie: 1e+12 ohm to ground -- the substrate is capacitively floating in transient analysis (DC reference only); see --substrate-tie-ohms
.GLOBAL vsubs

* cell sampler_core
* pin clk
* pin vdd
* pin en1
* pin en2
* pin en3
* pin en4
* pin rst_n
* pin vddr1
* pin vddr2
* pin vddr3
* pin vddr4
* pin vss
.SUBCKT sampler_core en1 en2 en3 en4 vddr1 vddr2 vddr3 vddr4 vdd vss clk rst_n
* device instance $1 r0 *1 12.315,0.21 nfet
X$1 \$17__t1 rst_n__t0 vss__t0 vss__t86 sky130_fd_pr__nfet_01v8 L=0.15 W=0.84
+ AS=0.3948 AD=0.2184 PS=2.62 PD=1.36
* device instance $2 r0 *1 12.985,0.21 nfet
X$2 a|inv_mc_a|mb|mnab_y|mpa_y|mpb_y|nand_m_y|tg_s_a|y__t0
+ a|b|m_east|m_west|nand_m_a|nand_m_a_ext_via|nand_m_a_ext_via2|nand_m_a_stub|tg_d_b|tg_d_b_via|tg_d_b_via2|tg_fbm_b|tg_fbm_b_alt_via|tg_fbm_b_alt_via2__t0
+ \$17__t0 vss__t108 sky130_fd_pr__nfet_01v8 L=0.15 W=0.84 AS=0.2184 AD=0.3948
+ PS=1.36 PD=2.62
* device instance $3 r0 *1 43.175,0.21 nfet
X$3 \$20__t0 rst_n__t22 vss__t84 vss__t87 sky130_fd_pr__nfet_01v8 L=0.15 W=0.84
+ AS=0.3948 AD=0.2184 PS=2.62 PD=1.36
* device instance $4 r0 *1 43.845,0.21 nfet
X$4 a|mnab_y|mpa_y|mpb_y|nand_s2_y|qb|tg_fbs_a|y__t4
+ a|inv_q_y|inv_q_y_via|inv_q_y_via2|nand_s2_a|nand_s2_a_stub|nand_s2_a_via|nand_s2_a_via2|q|y__t32
+ \$20__t1 vss__t109 sky130_fd_pr__nfet_01v8 L=0.15 W=0.84 AS=0.2184 AD=0.3948
+ PS=1.36 PD=2.62
* device instance $5 r0 *1 67.975,0.21 nfet
X$5 \$22__t0 rst_n__t23 vss__t85 vss__t88 sky130_fd_pr__nfet_01v8 L=0.15 W=0.84
+ AS=0.3948 AD=0.2184 PS=2.62 PD=1.36
* device instance $6 r0 *1 68.645,0.21 nfet
X$6 a|inv_mc_a|mb|mnab_y|mpa_y|mpb_y|nand_m_y|tg_s_a|y__t62
+ a|b|m_east|m_west|nand_m_a|nand_m_a_ext_via|nand_m_a_ext_via2|nand_m_a_stub|tg_d_b|tg_d_b_via|tg_d_b_via2|tg_fbm_b|tg_fbm_b_alt_via|tg_fbm_b_alt_via2__t52
+ \$22__t1 vss__t110 sky130_fd_pr__nfet_01v8 L=0.15 W=0.84 AS=0.2184 AD=0.3948
+ PS=1.36 PD=2.62
* device instance $7 r0 *1 98.835,0.21 nfet
X$7 \$25__t0 rst_n__t21 vss__t83 vss__t89 sky130_fd_pr__nfet_01v8 L=0.15 W=0.84
+ AS=0.3948 AD=0.2184 PS=2.62 PD=1.36
* device instance $8 r0 *1 99.505,0.21 nfet
X$8 a|mnab_y|mpa_y|mpb_y|nand_s2_y|qb|tg_fbs_a|y__t42
+ a|inv_q_y|inv_q_y_via|inv_q_y_via2|nand_s2_a|nand_s2_a_stub|nand_s2_a_via|nand_s2_a_via2|q|y__t33
+ \$25__t1 vss__t111 sky130_fd_pr__nfet_01v8 L=0.15 W=0.84 AS=0.2184 AD=0.3948
+ PS=1.36 PD=2.62
* device instance $9 r0 *1 123.635,0.21 nfet
X$9 \$28__t0 rst_n__t20 vss__t82 vss__t90 sky130_fd_pr__nfet_01v8 L=0.15 W=0.84
+ AS=0.3948 AD=0.2184 PS=2.62 PD=1.36
* device instance $10 r0 *1 124.305,0.21 nfet
X$10 a|inv_mc_a|mb|mnab_y|mpa_y|mpb_y|nand_m_y|tg_s_a|y__t63
+ a|b|m_east|m_west|nand_m_a|nand_m_a_ext_via|nand_m_a_ext_via2|nand_m_a_stub|tg_d_b|tg_d_b_via|tg_d_b_via2|tg_fbm_b|tg_fbm_b_alt_via|tg_fbm_b_alt_via2__t53
+ \$28__t1 vss__t112 sky130_fd_pr__nfet_01v8 L=0.15 W=0.84 AS=0.2184 AD=0.3948
+ PS=1.36 PD=2.62
* device instance $11 r0 *1 154.495,0.21 nfet
X$11 \$31__t0 rst_n__t19 vss__t81 vss__t91 sky130_fd_pr__nfet_01v8 L=0.15
+ W=0.84 AS=0.3948 AD=0.2184 PS=2.62 PD=1.36
* device instance $12 r0 *1 155.165,0.21 nfet
X$12 a|mnab_y|mpa_y|mpb_y|nand_s2_y|qb|tg_fbs_a|y__t43
+ a|inv_q_y|inv_q_y_via|inv_q_y_via2|nand_s2_a|nand_s2_a_stub|nand_s2_a_via|nand_s2_a_via2|q|y__t34
+ \$31__t1 vss__t113 sky130_fd_pr__nfet_01v8 L=0.15 W=0.84 AS=0.2184 AD=0.3948
+ PS=1.36 PD=2.62
* device instance $13 r0 *1 179.295,0.21 nfet
X$13 \$34__t0 rst_n__t15 vss__t77 vss__t92 sky130_fd_pr__nfet_01v8 L=0.15
+ W=0.84 AS=0.3948 AD=0.2184 PS=2.62 PD=1.36
* device instance $14 r0 *1 179.965,0.21 nfet
X$14 a|inv_mc_a|mb|mnab_y|mpa_y|mpb_y|nand_m_y|tg_s_a|y__t64
+ a|b|m_east|m_west|nand_m_a|nand_m_a_ext_via|nand_m_a_ext_via2|nand_m_a_stub|tg_d_b|tg_d_b_via|tg_d_b_via2|tg_fbm_b|tg_fbm_b_alt_via|tg_fbm_b_alt_via2__t54
+ \$34__t1 vss__t114 sky130_fd_pr__nfet_01v8 L=0.15 W=0.84 AS=0.2184 AD=0.3948
+ PS=1.36 PD=2.62
* device instance $15 r0 *1 210.155,0.21 nfet
X$15 \$38__t0 rst_n__t17 vss__t79 vss__t93 sky130_fd_pr__nfet_01v8 L=0.15
+ W=0.84 AS=0.3948 AD=0.2184 PS=2.62 PD=1.36
* device instance $16 r0 *1 210.825,0.21 nfet
X$16 a|mnab_y|mpa_y|mpb_y|nand_s2_y|qb|tg_fbs_a|y__t44
+ a|inv_q_y|inv_q_y_via|inv_q_y_via2|nand_s2_a|nand_s2_a_stub|nand_s2_a_via|nand_s2_a_via2|q|y__t3
+ \$38__t1 vss__t115 sky130_fd_pr__nfet_01v8 L=0.15 W=0.84 AS=0.2184 AD=0.3948
+ PS=1.36 PD=2.62
* device instance $17 r0 *1 234.955,0.21 nfet
X$17 \$41__t0 rst_n__t16 vss__t78 vss__t94 sky130_fd_pr__nfet_01v8 L=0.15
+ W=0.84 AS=0.3948 AD=0.2184 PS=2.62 PD=1.36
* device instance $18 r0 *1 235.625,0.21 nfet
X$18 a|inv_mc_a|mb|mnab_y|mpa_y|mpb_y|nand_m_y|tg_s_a|y__t65
+ a|b|m_east|m_west|nand_m_a|nand_m_a_ext_via|nand_m_a_ext_via2|nand_m_a_stub|tg_d_b|tg_d_b_via|tg_d_b_via2|tg_fbm_b|tg_fbm_b_alt_via|tg_fbm_b_alt_via2__t55
+ \$41__t1 vss__t116 sky130_fd_pr__nfet_01v8 L=0.15 W=0.84 AS=0.2184 AD=0.3948
+ PS=1.36 PD=2.62
* device instance $19 r0 *1 265.815,0.21 nfet
X$19 \$44__t0 rst_n__t18 vss__t80 vss__t95 sky130_fd_pr__nfet_01v8 L=0.15
+ W=0.84 AS=0.3948 AD=0.2184 PS=2.62 PD=1.36
* device instance $20 r0 *1 266.485,0.21 nfet
X$20 a|mnab_y|mpa_y|mpb_y|nand_s2_y|qb|tg_fbs_a|y__t45
+ a|inv_q_y|inv_q_y_via|inv_q_y_via2|nand_s2_a|nand_s2_a_stub|nand_s2_a_via|nand_s2_a_via2|q|y__t35
+ \$44__t1 vss__t117 sky130_fd_pr__nfet_01v8 L=0.15 W=0.84 AS=0.2184 AD=0.3948
+ PS=1.36 PD=2.62
* device instance $21 r0 *1 290.615,0.21 nfet
X$21 \$47__t0 rst_n__t14 vss__t76 vss__t96 sky130_fd_pr__nfet_01v8 L=0.15
+ W=0.84 AS=0.3948 AD=0.2184 PS=2.62 PD=1.36
* device instance $22 r0 *1 291.285,0.21 nfet
X$22 a|inv_mc_a|mb|mnab_y|mpa_y|mpb_y|nand_m_y|tg_s_a|y__t66
+ a|b|m_east|m_west|nand_m_a|nand_m_a_ext_via|nand_m_a_ext_via2|nand_m_a_stub|tg_d_b|tg_d_b_via|tg_d_b_via2|tg_fbm_b|tg_fbm_b_alt_via|tg_fbm_b_alt_via2__t56
+ \$47__t1 vss__t118 sky130_fd_pr__nfet_01v8 L=0.15 W=0.84 AS=0.2184 AD=0.3948
+ PS=1.36 PD=2.62
* device instance $23 r0 *1 321.475,0.21 nfet
X$23 \$50__t0 rst_n__t13 vss__t75 vss__t97 sky130_fd_pr__nfet_01v8 L=0.15
+ W=0.84 AS=0.3948 AD=0.2184 PS=2.62 PD=1.36
* device instance $24 r0 *1 322.145,0.21 nfet
X$24 a|mnab_y|mpa_y|mpb_y|nand_s2_y|qb|tg_fbs_a|y__t46
+ a|inv_q_y|inv_q_y_via|inv_q_y_via2|nand_s2_a|nand_s2_a_stub|nand_s2_a_via|nand_s2_a_via2|q|y__t36
+ \$50__t1 vss__t119 sky130_fd_pr__nfet_01v8 L=0.15 W=0.84 AS=0.2184 AD=0.3948
+ PS=1.36 PD=2.62
* device instance $25 r0 *1 0.545,0.21 nfet
X$25
+ clkb|clkb_bridge1|clkb_bridge2|clkb_mid|clkb_w|ctrl|ctrlb|inv_clk_y|tg_d_ctrlb|tg_fbm_ctrl|tg_fbs_ctrlb|tg_s_ctrl|y__t1
+ clk__t1 vss__t1 vss__t130 sky130_fd_pr__nfet_01v8 L=0.15 W=0.42 AS=0.1974
+ AD=0.1974 PS=1.78 PD=1.78
* device instance $26 r0 *1 5.31,0.21 nfet
X$26 a|d|sb_d_stub|tg_d_a|xo|xo_dip|xo_hop|xo_stub|y__t2
+ clkb|clkb_bridge1|clkb_bridge2|clkb_mid|clkb_w|ctrl|ctrlb|inv_clk_y|tg_d_ctrlb|tg_fbm_ctrl|tg_fbs_ctrlb|tg_s_ctrl|y__t2
+ a|b|m_east|m_west|nand_m_a|nand_m_a_ext_via|nand_m_a_ext_via2|nand_m_a_stub|tg_d_b|tg_d_b_via|tg_d_b_via2|tg_fbm_b|tg_fbm_b_alt_via|tg_fbm_b_alt_via2__t2
+ vss__t131 sky130_fd_pr__nfet_01v8 L=0.15 W=0.42 AS=0.1974 AD=0.1974 PS=1.78
+ PD=1.78
* device instance $27 r0 *1 19.835,0.21 nfet
X$27 a|inv_mc_y|inv_mc_y_via|mc|tg_fbm_a|tg_fbm_a_via|y__t0
+ a|inv_mc_a|mb|mnab_y|mpa_y|mpb_y|nand_m_y|tg_s_a|y__t4 vss__t52 vss__t132
+ sky130_fd_pr__nfet_01v8 L=0.15 W=0.42 AS=0.1974 AD=0.1974 PS=1.78 PD=1.78
* device instance $28 r0 *1 24.6,0.21 nfet
X$28 a|inv_mc_y|inv_mc_y_via|mc|tg_fbm_a|tg_fbm_a_via|y__t1 clk__t11
+ a|b|m_east|m_west|nand_m_a|nand_m_a_ext_via|nand_m_a_ext_via2|nand_m_a_stub|tg_d_b|tg_d_b_via|tg_d_b_via2|tg_fbm_b|tg_fbm_b_alt_via|tg_fbm_b_alt_via2__t3
+ vss__t133 sky130_fd_pr__nfet_01v8 L=0.15 W=0.42 AS=0.1974 AD=0.1974 PS=1.78
+ PD=1.78
* device instance $29 r0 *1 29.74,0.21 nfet
X$29 a|inv_mc_a|mb|mnab_y|mpa_y|mpb_y|nand_m_y|tg_s_a|y__t1 clk__t12
+ a|b|inv_q_a|inv_q_a_via|s|tg_fbs_b|tg_fbs_b_via|tg_s_b|tg_s_b_via__t2
+ vss__t134 sky130_fd_pr__nfet_01v8 L=0.15 W=0.42 AS=0.1974 AD=0.1974 PS=1.78
+ PD=1.78
* device instance $30 r0 *1 36.545,0.21 nfet
X$30
+ a|inv_q_y|inv_q_y_via|inv_q_y_via2|nand_s2_a|nand_s2_a_stub|nand_s2_a_via|nand_s2_a_via2|q|y__t02
+ a|b|inv_q_a|inv_q_a_via|s|tg_fbs_b|tg_fbs_b_via|tg_s_b|tg_s_b_via__t0
+ vss__t53 vss__t135 sky130_fd_pr__nfet_01v8 L=0.15 W=0.42 AS=0.1974 AD=0.1974
+ PS=1.78 PD=1.78
* device instance $31 r0 *1 49.03,0.21 nfet
X$31 a|mnab_y|mpa_y|mpb_y|nand_s2_y|qb|tg_fbs_a|y__t0
+ clkb|clkb_bridge1|clkb_bridge2|clkb_mid|clkb_w|ctrl|ctrlb|inv_clk_y|tg_d_ctrlb|tg_fbm_ctrl|tg_fbs_ctrlb|tg_s_ctrl|y__t3
+ a|b|inv_q_a|inv_q_a_via|s|tg_fbs_b|tg_fbs_b_via|tg_s_b|tg_s_b_via__t3
+ vss__t136 sky130_fd_pr__nfet_01v8 L=0.15 W=0.42 AS=0.1974 AD=0.1974 PS=1.78
+ PD=1.78
* device instance $32 r0 *1 56.205,0.21 nfet
X$32
+ clkb|clkb_bridge1|clkb_bridge2|clkb_mid|clkb_w|ctrl|ctrlb|inv_clk_y|tg_d_ctrlb|tg_fbm_ctrl|tg_fbs_ctrlb|tg_s_ctrl|y__t02
+ clk__t13 vss__t54 vss__t137 sky130_fd_pr__nfet_01v8 L=0.15 W=0.42 AS=0.1974
+ AD=0.1974 PS=1.78 PD=1.78
* device instance $33 r0 *1 60.97,0.21 nfet
X$33 vdd__t20
+ clkb|clkb_bridge1|clkb_bridge2|clkb_mid|clkb_w|ctrl|ctrlb|inv_clk_y|tg_d_ctrlb|tg_fbm_ctrl|tg_fbs_ctrlb|tg_s_ctrl|y__t22
+ a|b|m_east|m_west|nand_m_a|nand_m_a_ext_via|nand_m_a_ext_via2|nand_m_a_stub|tg_d_b|tg_d_b_via|tg_d_b_via2|tg_fbm_b|tg_fbm_b_alt_via|tg_fbm_b_alt_via2__t12
+ vss__t138 sky130_fd_pr__nfet_01v8 L=0.15 W=0.42 AS=0.1974 AD=0.1974 PS=1.78
+ PD=1.78
* device instance $34 r0 *1 75.495,0.21 nfet
X$34 a|inv_mc_y|inv_mc_y_via|mc|tg_fbm_a|tg_fbm_a_via|y__t02
+ a|inv_mc_a|mb|mnab_y|mpa_y|mpb_y|nand_m_y|tg_s_a|y__t32 vss__t57 vss__t139
+ sky130_fd_pr__nfet_01v8 L=0.15 W=0.42 AS=0.1974 AD=0.1974 PS=1.78 PD=1.78
* device instance $35 r0 *1 80.26,0.21 nfet
X$35 a|inv_mc_y|inv_mc_y_via|mc|tg_fbm_a|tg_fbm_a_via|y__t12 clk__t14
+ a|b|m_east|m_west|nand_m_a|nand_m_a_ext_via|nand_m_a_ext_via2|nand_m_a_stub|tg_d_b|tg_d_b_via|tg_d_b_via2|tg_fbm_b|tg_fbm_b_alt_via|tg_fbm_b_alt_via2__t22
+ vss__t140 sky130_fd_pr__nfet_01v8 L=0.15 W=0.42 AS=0.1974 AD=0.1974 PS=1.78
+ PD=1.78
* device instance $36 r0 *1 85.4,0.21 nfet
X$36 a|inv_mc_a|mb|mnab_y|mpa_y|mpb_y|nand_m_y|tg_s_a|y__t02 clk__t18
+ a|b|inv_q_a|inv_q_a_via|s|tg_fbs_b|tg_fbs_b_via|tg_s_b|tg_s_b_via__t32
+ vss__t141 sky130_fd_pr__nfet_01v8 L=0.15 W=0.42 AS=0.1974 AD=0.1974 PS=1.78
+ PD=1.78
* device instance $37 r0 *1 92.205,0.21 nfet
X$37
+ a|inv_q_y|inv_q_y_via|inv_q_y_via2|nand_s2_a|nand_s2_a_stub|nand_s2_a_via|nand_s2_a_via2|q|y__t03
+ a|b|inv_q_a|inv_q_a_via|s|tg_fbs_b|tg_fbs_b_via|tg_s_b|tg_s_b_via__t02
+ vss__t60 vss__t142 sky130_fd_pr__nfet_01v8 L=0.15 W=0.42 AS=0.1974 AD=0.1974
+ PS=1.78 PD=1.78
* device instance $38 r0 *1 104.69,0.21 nfet
X$38 a|mnab_y|mpa_y|mpb_y|nand_s2_y|qb|tg_fbs_a|y__t02
+ clkb|clkb_bridge1|clkb_bridge2|clkb_mid|clkb_w|ctrl|ctrlb|inv_clk_y|tg_d_ctrlb|tg_fbm_ctrl|tg_fbs_ctrlb|tg_s_ctrl|y__t32
+ a|b|inv_q_a|inv_q_a_via|s|tg_fbs_b|tg_fbs_b_via|tg_s_b|tg_s_b_via__t22
+ vss__t143 sky130_fd_pr__nfet_01v8 L=0.15 W=0.42 AS=0.1974 AD=0.1974 PS=1.78
+ PD=1.78
* device instance $39 r0 *1 111.865,0.21 nfet
X$39
+ clkb|clkb_bridge1|clkb_bridge2|clkb_mid|clkb_w|ctrl|ctrlb|inv_clk_y|tg_d_ctrlb|tg_fbm_ctrl|tg_fbs_ctrlb|tg_s_ctrl|y__t03
+ clk__t17 vss__t61 vss__t144 sky130_fd_pr__nfet_01v8 L=0.15 W=0.42 AS=0.1974
+ AD=0.1974 PS=1.78 PD=1.78
* device instance $40 r0 *1 116.63,0.21 nfet
X$40 a|d|inva_a|mn12_g0|mp13_g0|ro1|ro1_esc|sr1_d_stub|tg_d_a|y__t2
+ clkb|clkb_bridge1|clkb_bridge2|clkb_mid|clkb_w|ctrl|ctrlb|inv_clk_y|tg_d_ctrlb|tg_fbm_ctrl|tg_fbs_ctrlb|tg_s_ctrl|y__t33
+ a|b|m_east|m_west|nand_m_a|nand_m_a_ext_via|nand_m_a_ext_via2|nand_m_a_stub|tg_d_b|tg_d_b_via|tg_d_b_via2|tg_fbm_b|tg_fbm_b_alt_via|tg_fbm_b_alt_via2__t23
+ vss__t145 sky130_fd_pr__nfet_01v8 L=0.15 W=0.42 AS=0.1974 AD=0.1974 PS=1.78
+ PD=1.78
* device instance $41 r0 *1 131.155,0.21 nfet
X$41 a|inv_mc_y|inv_mc_y_via|mc|tg_fbm_a|tg_fbm_a_via|y__t03
+ a|inv_mc_a|mb|mnab_y|mpa_y|mpb_y|nand_m_y|tg_s_a|y__t33 vss__t56 vss__t146
+ sky130_fd_pr__nfet_01v8 L=0.15 W=0.42 AS=0.1974 AD=0.1974 PS=1.78 PD=1.78
* device instance $42 r0 *1 135.92,0.21 nfet
X$42 a|inv_mc_y|inv_mc_y_via|mc|tg_fbm_a|tg_fbm_a_via|y__t13 clk__t16
+ a|b|m_east|m_west|nand_m_a|nand_m_a_ext_via|nand_m_a_ext_via2|nand_m_a_stub|tg_d_b|tg_d_b_via|tg_d_b_via2|tg_fbm_b|tg_fbm_b_alt_via|tg_fbm_b_alt_via2__t13
+ vss__t147 sky130_fd_pr__nfet_01v8 L=0.15 W=0.42 AS=0.1974 AD=0.1974 PS=1.78
+ PD=1.78
* device instance $43 r0 *1 141.06,0.21 nfet
X$43 a|inv_mc_a|mb|mnab_y|mpa_y|mpb_y|nand_m_y|tg_s_a|y__t03 clk__t15
+ a|b|inv_q_a|inv_q_a_via|s|tg_fbs_b|tg_fbs_b_via|tg_s_b|tg_s_b_via__t33
+ vss__t148 sky130_fd_pr__nfet_01v8 L=0.15 W=0.42 AS=0.1974 AD=0.1974 PS=1.78
+ PD=1.78
* device instance $44 r0 *1 147.865,0.21 nfet
X$44
+ a|inv_q_y|inv_q_y_via|inv_q_y_via2|nand_s2_a|nand_s2_a_stub|nand_s2_a_via|nand_s2_a_via2|q|y__t04
+ a|b|inv_q_a|inv_q_a_via|s|tg_fbs_b|tg_fbs_b_via|tg_s_b|tg_s_b_via__t03
+ vss__t58 vss__t149 sky130_fd_pr__nfet_01v8 L=0.15 W=0.42 AS=0.1974 AD=0.1974
+ PS=1.78 PD=1.78
* device instance $45 r0 *1 160.35,0.21 nfet
X$45 a|mnab_y|mpa_y|mpb_y|nand_s2_y|qb|tg_fbs_a|y__t03
+ clkb|clkb_bridge1|clkb_bridge2|clkb_mid|clkb_w|ctrl|ctrlb|inv_clk_y|tg_d_ctrlb|tg_fbm_ctrl|tg_fbs_ctrlb|tg_s_ctrl|y__t23
+ a|b|inv_q_a|inv_q_a_via|s|tg_fbs_b|tg_fbs_b_via|tg_s_b|tg_s_b_via__t23
+ vss__t150 sky130_fd_pr__nfet_01v8 L=0.15 W=0.42 AS=0.1974 AD=0.1974 PS=1.78
+ PD=1.78
* device instance $46 r0 *1 167.525,0.21 nfet
X$46
+ clkb|clkb_bridge1|clkb_bridge2|clkb_mid|clkb_w|ctrl|ctrlb|inv_clk_y|tg_d_ctrlb|tg_fbm_ctrl|tg_fbs_ctrlb|tg_s_ctrl|y__t04
+ clk__t10 vss__t51 vss__t151 sky130_fd_pr__nfet_01v8 L=0.15 W=0.42 AS=0.1974
+ AD=0.1974 PS=1.78 PD=1.78
* device instance $47 r0 *1 172.29,0.21 nfet
X$47 a|b|d|invb_a|mn12_g1|mp24_g0|ro2|ro2_esc|sr2_d_stub|tg_d_a|y__t1
+ clkb|clkb_bridge1|clkb_bridge2|clkb_mid|clkb_w|ctrl|ctrlb|inv_clk_y|tg_d_ctrlb|tg_fbm_ctrl|tg_fbs_ctrlb|tg_s_ctrl|y__t34
+ a|b|m_east|m_west|nand_m_a|nand_m_a_ext_via|nand_m_a_ext_via2|nand_m_a_stub|tg_d_b|tg_d_b_via|tg_d_b_via2|tg_fbm_b|tg_fbm_b_alt_via|tg_fbm_b_alt_via2__t24
+ vss__t152 sky130_fd_pr__nfet_01v8 L=0.15 W=0.42 AS=0.1974 AD=0.1974 PS=1.78
+ PD=1.78
* device instance $48 r0 *1 186.815,0.21 nfet
X$48 a|inv_mc_y|inv_mc_y_via|mc|tg_fbm_a|tg_fbm_a_via|y__t14
+ a|inv_mc_a|mb|mnab_y|mpa_y|mpb_y|nand_m_y|tg_s_a|y__t34 vss__t45 vss__t153
+ sky130_fd_pr__nfet_01v8 L=0.15 W=0.42 AS=0.1974 AD=0.1974 PS=1.78 PD=1.78
* device instance $49 r0 *1 191.58,0.21 nfet
X$49 a|inv_mc_y|inv_mc_y_via|mc|tg_fbm_a|tg_fbm_a_via|y__t04 clk__t5
+ a|b|m_east|m_west|nand_m_a|nand_m_a_ext_via|nand_m_a_ext_via2|nand_m_a_stub|tg_d_b|tg_d_b_via|tg_d_b_via2|tg_fbm_b|tg_fbm_b_alt_via|tg_fbm_b_alt_via2__t14
+ vss__t154 sky130_fd_pr__nfet_01v8 L=0.15 W=0.42 AS=0.1974 AD=0.1974 PS=1.78
+ PD=1.78
* device instance $50 r0 *1 196.72,0.21 nfet
X$50 a|inv_mc_a|mb|mnab_y|mpa_y|mpb_y|nand_m_y|tg_s_a|y__t04 clk__t4
+ a|b|inv_q_a|inv_q_a_via|s|tg_fbs_b|tg_fbs_b_via|tg_s_b|tg_s_b_via__t34
+ vss__t155 sky130_fd_pr__nfet_01v8 L=0.15 W=0.42 AS=0.1974 AD=0.1974 PS=1.78
+ PD=1.78
* device instance $51 r0 *1 203.525,0.21 nfet
X$51
+ a|inv_q_y|inv_q_y_via|inv_q_y_via2|nand_s2_a|nand_s2_a_stub|nand_s2_a_via|nand_s2_a_via2|q|y__t0
+ a|b|inv_q_a|inv_q_a_via|s|tg_fbs_b|tg_fbs_b_via|tg_s_b|tg_s_b_via__t04
+ vss__t44 vss__t156 sky130_fd_pr__nfet_01v8 L=0.15 W=0.42 AS=0.1974 AD=0.1974
+ PS=1.78 PD=1.78
* device instance $52 r0 *1 216.01,0.21 nfet
X$52 a|mnab_y|mpa_y|mpb_y|nand_s2_y|qb|tg_fbs_a|y__t04
+ clkb|clkb_bridge1|clkb_bridge2|clkb_mid|clkb_w|ctrl|ctrlb|inv_clk_y|tg_d_ctrlb|tg_fbm_ctrl|tg_fbs_ctrlb|tg_s_ctrl|y__t24
+ a|b|inv_q_a|inv_q_a_via|s|tg_fbs_b|tg_fbs_b_via|tg_s_b|tg_s_b_via__t24
+ vss__t157 sky130_fd_pr__nfet_01v8 L=0.15 W=0.42 AS=0.1974 AD=0.1974 PS=1.78
+ PD=1.78
* device instance $53 r0 *1 223.185,0.21 nfet
X$53
+ clkb|clkb_bridge1|clkb_bridge2|clkb_mid|clkb_w|ctrl|ctrlb|inv_clk_y|tg_d_ctrlb|tg_fbm_ctrl|tg_fbs_ctrlb|tg_s_ctrl|y__t05
+ clk__t2 vss__t43 vss__t158 sky130_fd_pr__nfet_01v8 L=0.15 W=0.42 AS=0.1974
+ AD=0.1974 PS=1.78 PD=1.78
* device instance $54 r0 *1 227.95,0.21 nfet
X$54
+ a|d|inva_a|mn12_g0|mp13_g0|ro3|ro3_esc_e|ro3_esc_w|ro3_hop|sr3_d_stub|tg_d_a|y__t1
+ clkb|clkb_bridge1|clkb_bridge2|clkb_mid|clkb_w|ctrl|ctrlb|inv_clk_y|tg_d_ctrlb|tg_fbm_ctrl|tg_fbs_ctrlb|tg_s_ctrl|y__t25
+ a|b|m_east|m_west|nand_m_a|nand_m_a_ext_via|nand_m_a_ext_via2|nand_m_a_stub|tg_d_b|tg_d_b_via|tg_d_b_via2|tg_fbm_b|tg_fbm_b_alt_via|tg_fbm_b_alt_via2__t15
+ vss__t159 sky130_fd_pr__nfet_01v8 L=0.15 W=0.42 AS=0.1974 AD=0.1974 PS=1.78
+ PD=1.78
* device instance $55 r0 *1 242.475,0.21 nfet
X$55 a|inv_mc_y|inv_mc_y_via|mc|tg_fbm_a|tg_fbm_a_via|y__t05
+ a|inv_mc_a|mb|mnab_y|mpa_y|mpb_y|nand_m_y|tg_s_a|y__t35 vss__t42 vss__t160
+ sky130_fd_pr__nfet_01v8 L=0.15 W=0.42 AS=0.1974 AD=0.1974 PS=1.78 PD=1.78
* device instance $56 r0 *1 247.24,0.21 nfet
X$56 a|inv_mc_y|inv_mc_y_via|mc|tg_fbm_a|tg_fbm_a_via|y__t15 clk__t3
+ a|b|m_east|m_west|nand_m_a|nand_m_a_ext_via|nand_m_a_ext_via2|nand_m_a_stub|tg_d_b|tg_d_b_via|tg_d_b_via2|tg_fbm_b|tg_fbm_b_alt_via|tg_fbm_b_alt_via2__t25
+ vss__t161 sky130_fd_pr__nfet_01v8 L=0.15 W=0.42 AS=0.1974 AD=0.1974 PS=1.78
+ PD=1.78
* device instance $57 r0 *1 252.38,0.21 nfet
X$57 a|inv_mc_a|mb|mnab_y|mpa_y|mpb_y|nand_m_y|tg_s_a|y__t05 clk__t6
+ a|b|inv_q_a|inv_q_a_via|s|tg_fbs_b|tg_fbs_b_via|tg_s_b|tg_s_b_via__t25
+ vss__t162 sky130_fd_pr__nfet_01v8 L=0.15 W=0.42 AS=0.1974 AD=0.1974 PS=1.78
+ PD=1.78
* device instance $58 r0 *1 259.185,0.21 nfet
X$58
+ a|inv_q_y|inv_q_y_via|inv_q_y_via2|nand_s2_a|nand_s2_a_stub|nand_s2_a_via|nand_s2_a_via2|q|y__t05
+ a|b|inv_q_a|inv_q_a_via|s|tg_fbs_b|tg_fbs_b_via|tg_s_b|tg_s_b_via__t05
+ vss__t47 vss__t163 sky130_fd_pr__nfet_01v8 L=0.15 W=0.42 AS=0.1974 AD=0.1974
+ PS=1.78 PD=1.78
* device instance $59 r0 *1 271.67,0.21 nfet
X$59 a|mnab_y|mpa_y|mpb_y|nand_s2_y|qb|tg_fbs_a|y__t05
+ clkb|clkb_bridge1|clkb_bridge2|clkb_mid|clkb_w|ctrl|ctrlb|inv_clk_y|tg_d_ctrlb|tg_fbm_ctrl|tg_fbs_ctrlb|tg_s_ctrl|y__t35
+ a|b|inv_q_a|inv_q_a_via|s|tg_fbs_b|tg_fbs_b_via|tg_s_b|tg_s_b_via__t35
+ vss__t164 sky130_fd_pr__nfet_01v8 L=0.15 W=0.42 AS=0.1974 AD=0.1974 PS=1.78
+ PD=1.78
* device instance $60 r0 *1 278.845,0.21 nfet
X$60
+ clkb|clkb_bridge1|clkb_bridge2|clkb_mid|clkb_w|ctrl|ctrlb|inv_clk_y|tg_d_ctrlb|tg_fbm_ctrl|tg_fbs_ctrlb|tg_s_ctrl|y__t06
+ clk__t7 vss__t48 vss__t165 sky130_fd_pr__nfet_01v8 L=0.15 W=0.42 AS=0.1974
+ AD=0.1974 PS=1.78 PD=1.78
* device instance $61 r0 *1 283.61,0.21 nfet
X$61 a|b|d|invb_a|mn12_g1|mp24_g0|ro4|ro4_esc|sr4_d_stub|tg_d_a|y__t2
+ clkb|clkb_bridge1|clkb_bridge2|clkb_mid|clkb_w|ctrl|ctrlb|inv_clk_y|tg_d_ctrlb|tg_fbm_ctrl|tg_fbs_ctrlb|tg_s_ctrl|y__t26
+ a|b|m_east|m_west|nand_m_a|nand_m_a_ext_via|nand_m_a_ext_via2|nand_m_a_stub|tg_d_b|tg_d_b_via|tg_d_b_via2|tg_fbm_b|tg_fbm_b_alt_via|tg_fbm_b_alt_via2__t16
+ vss__t166 sky130_fd_pr__nfet_01v8 L=0.15 W=0.42 AS=0.1974 AD=0.1974 PS=1.78
+ PD=1.78
* device instance $62 r0 *1 298.135,0.21 nfet
X$62 a|inv_mc_y|inv_mc_y_via|mc|tg_fbm_a|tg_fbm_a_via|y__t06
+ a|inv_mc_a|mb|mnab_y|mpa_y|mpb_y|nand_m_y|tg_s_a|y__t36 vss__t49 vss__t167
+ sky130_fd_pr__nfet_01v8 L=0.15 W=0.42 AS=0.1974 AD=0.1974 PS=1.78 PD=1.78
* device instance $63 r0 *1 302.9,0.21 nfet
X$63 a|inv_mc_y|inv_mc_y_via|mc|tg_fbm_a|tg_fbm_a_via|y__t16 clk__t8
+ a|b|m_east|m_west|nand_m_a|nand_m_a_ext_via|nand_m_a_ext_via2|nand_m_a_stub|tg_d_b|tg_d_b_via|tg_d_b_via2|tg_fbm_b|tg_fbm_b_alt_via|tg_fbm_b_alt_via2__t26
+ vss__t168 sky130_fd_pr__nfet_01v8 L=0.15 W=0.42 AS=0.1974 AD=0.1974 PS=1.78
+ PD=1.78
* device instance $64 r0 *1 308.04,0.21 nfet
X$64 a|inv_mc_a|mb|mnab_y|mpa_y|mpb_y|nand_m_y|tg_s_a|y__t06 clk__t9
+ a|b|inv_q_a|inv_q_a_via|s|tg_fbs_b|tg_fbs_b_via|tg_s_b|tg_s_b_via__t26
+ vss__t169 sky130_fd_pr__nfet_01v8 L=0.15 W=0.42 AS=0.1974 AD=0.1974 PS=1.78
+ PD=1.78
* device instance $65 r0 *1 314.845,0.21 nfet
X$65
+ a|inv_q_y|inv_q_y_via|inv_q_y_via2|nand_s2_a|nand_s2_a_stub|nand_s2_a_via|nand_s2_a_via2|q|y__t06
+ a|b|inv_q_a|inv_q_a_via|s|tg_fbs_b|tg_fbs_b_via|tg_s_b|tg_s_b_via__t06
+ vss__t50 vss__t170 sky130_fd_pr__nfet_01v8 L=0.15 W=0.42 AS=0.1974 AD=0.1974
+ PS=1.78 PD=1.78
* device instance $66 r0 *1 327.33,0.21 nfet
X$66 a|mnab_y|mpa_y|mpb_y|nand_s2_y|qb|tg_fbs_a|y__t06
+ clkb|clkb_bridge1|clkb_bridge2|clkb_mid|clkb_w|ctrl|ctrlb|inv_clk_y|tg_d_ctrlb|tg_fbm_ctrl|tg_fbs_ctrlb|tg_s_ctrl|y__t36
+ a|b|inv_q_a|inv_q_a_via|s|tg_fbs_b|tg_fbs_b_via|tg_s_b|tg_s_b_via__t36
+ vss__t171 sky130_fd_pr__nfet_01v8 L=0.15 W=0.42 AS=0.1974 AD=0.1974 PS=1.78
+ PD=1.78
* device instance $67 r0 *1 3.61,23.845 nfet
X$67 ny__t0 vddr1__t0 vss__t2 vss__t198 sky130_fd_pr__nfet_01v8 L=2 W=0.42
+ AS=0.1764 AD=0.1764 PS=1.68 PD=1.68
* device instance $68 r0 *1 3.445,41.54 nfet
X$68 an|inva_y|mn34_g0|mp13_g1|y__t1
+ a|d|inva_a|mn12_g0|mp13_g0|ro1|ro1_esc|sr1_d_stub|tg_d_a|y__t5 vss__t64
+ vss__t192 sky130_fd_pr__nfet_01v8 L=0.15 W=0.42 AS=0.1974 AD=0.1974 PS=1.78
+ PD=1.78
* device instance $69 r0 *1 5.975,23.845 nfet
X$69 \$75__t0 en1__t1 ny__t1 vss__t98 sky130_fd_pr__nfet_01v8 L=0.15 W=0.84
+ AS=0.3948 AD=0.2184 PS=2.62 PD=1.36
* device instance $70 r0 *1 6.645,23.845 nfet
X$70 a|g_y|mnab_y|mpa_y|mpb_y|n1|s1_a|y__t4 a|g_a|rn1|ro|s4_y|y__t5 \$75__t1
+ vss__t120 sky130_fd_pr__nfet_01v8 L=0.15 W=0.84 AS=0.2184 AD=0.3948 PS=1.36
+ PD=2.62
* device instance $71 r0 *1 7.78,39.22 nfet
X$71 \$136__t0 an|inva_y|mn34_g0|mp13_g1|y__t3
+ a|inva_a|mn12_g0|mp13_g0|t1|y__t6 vss__t102 sky130_fd_pr__nfet_01v8 L=0.15
+ W=0.84 AS=0.3948 AD=0.2184 PS=2.62 PD=1.36
* device instance $72 r0 *1 8.45,39.22 nfet
X$72 vss__t69 bn|invb_y|mn34_g1|mp24_g1|y__t3 \$136__t1 vss__t124
+ sky130_fd_pr__nfet_01v8 L=0.15 W=0.84 AS=0.2184 AD=0.3948 PS=1.36 PD=2.62
* device instance $73 r0 *1 12.91,23.845 nfet
X$73 ny__t02 vddr1__t11 vss__t38 vss__t199 sky130_fd_pr__nfet_01v8 L=2 W=0.42
+ AS=0.1764 AD=0.1764 PS=1.68 PD=1.68
* device instance $74 r0 *1 14.78,39.22 nfet
X$74 \$138__t0 a|d|inva_a|mn12_g0|mp13_g0|ro1|ro1_esc|sr1_d_stub|tg_d_a|y__t7
+ a|inva_a|mn12_g0|mp13_g0|t1|y__t7 vss__t103 sky130_fd_pr__nfet_01v8 L=0.15
+ W=0.84 AS=0.3948 AD=0.2184 PS=2.62 PD=1.36
* device instance $75 r0 *1 15.45,39.22 nfet
X$75 vss__t70 a|b|d|invb_a|mn12_g1|mp24_g0|ro2|ro2_esc|sr2_d_stub|tg_d_a|y__t7
+ \$138__t1 vss__t125 sky130_fd_pr__nfet_01v8 L=0.15 W=0.84 AS=0.2184 AD=0.3948
+ PS=1.36 PD=2.62
* device instance $76 r0 *1 15.275,23.845 nfet
X$76 a|n2|s1_y|s2_a|y__t02 a|g_y|mnab_y|mpa_y|mpb_y|n1|s1_a|y__t1 ny__t12
+ vss__t172 sky130_fd_pr__nfet_01v8 L=0.15 W=0.42 AS=0.1974 AD=0.1974 PS=1.78
+ PD=1.78
* device instance $77 r0 *1 21.085,23.845 nfet
X$77 ny__t03 vddr1__t14 vss__t41 vss__t200 sky130_fd_pr__nfet_01v8 L=2 W=0.42
+ AS=0.1764 AD=0.1764 PS=1.68 PD=1.68
* device instance $78 r0 *1 21.62,41.54 nfet
X$78 bn|invb_y|mn34_g1|mp24_g1|y__t1
+ a|b|d|invb_a|mn12_g1|mp24_g0|ro2|ro2_esc|sr2_d_stub|tg_d_a|y__t5 vss__t65
+ vss__t193 sky130_fd_pr__nfet_01v8 L=0.15 W=0.42 AS=0.1974 AD=0.1974 PS=1.78
+ PD=1.78
* device instance $79 r0 *1 23.45,23.845 nfet
X$79 a|n3|s2_y|s3_a|y__t0 a|n2|s1_y|s2_a|y__t22 ny__t13 vss__t173
+ sky130_fd_pr__nfet_01v8 L=0.15 W=0.42 AS=0.1974 AD=0.1974 PS=1.78 PD=1.78
* device instance $80 r0 *1 29.26,23.845 nfet
X$80 ny__t04 vddr1__t12 vss__t39 vss__t201 sky130_fd_pr__nfet_01v8 L=2 W=0.42
+ AS=0.1764 AD=0.1764 PS=1.68 PD=1.68
* device instance $81 r0 *1 31.625,23.845 nfet
X$81 a|n4|s3_y|s4_a|y__t03 a|n3|s2_y|s3_a|y__t2 ny__t14 vss__t174
+ sky130_fd_pr__nfet_01v8 L=0.15 W=0.42 AS=0.1974 AD=0.1974 PS=1.78 PD=1.78
* device instance $82 r0 *1 32.415,41.54 nfet
X$82 an|inva_y|mn34_g0|mp13_g1|y__t12
+ a|d|inva_a|mn12_g0|mp13_g0|ro3|ro3_esc_e|ro3_esc_w|ro3_hop|sr3_d_stub|tg_d_a|y__t5
+ vss__t67 vss__t194 sky130_fd_pr__nfet_01v8 L=0.15 W=0.42 AS=0.1974 AD=0.1974
+ PS=1.78 PD=1.78
* device instance $83 r0 *1 37.435,23.845 nfet
X$83 ny__t05 vddr1__t13 vss__t40 vss__t202 sky130_fd_pr__nfet_01v8 L=2 W=0.42
+ AS=0.1764 AD=0.1764 PS=1.68 PD=1.68
* device instance $84 r0 *1 36.75,39.22 nfet
X$84 \$139__t0 an|inva_y|mn34_g0|mp13_g1|y__t32
+ a|b|b3|invb_a|mn12_g1|mp24_g0|t2|y__t7 vss__t104 sky130_fd_pr__nfet_01v8
+ L=0.15 W=0.84 AS=0.3948 AD=0.2184 PS=2.62 PD=1.36
* device instance $85 r0 *1 37.42,39.22 nfet
X$85 vss__t74 bn|invb_y|mn34_g1|mp24_g1|y__t32 \$139__t1 vss__t126
+ sky130_fd_pr__nfet_01v8 L=0.15 W=0.84 AS=0.2184 AD=0.3948 PS=1.36 PD=2.62
* device instance $86 r0 *1 39.8,23.845 nfet
X$86 a|g_a|rn1|ro|s4_y|y__t0 a|n4|s3_y|s4_a|y__t23 ny__t15 vss__t175
+ sky130_fd_pr__nfet_01v8 L=0.15 W=0.42 AS=0.1974 AD=0.1974 PS=1.78 PD=1.78
* device instance $87 r0 *1 43.75,39.22 nfet
X$87 \$141__t0
+ a|d|inva_a|mn12_g0|mp13_g0|ro3|ro3_esc_e|ro3_esc_w|ro3_hop|sr3_d_stub|tg_d_a|y__t7
+ a|b|b3|invb_a|mn12_g1|mp24_g0|t2|y__t6 vss__t105 sky130_fd_pr__nfet_01v8
+ L=0.15 W=0.84 AS=0.3948 AD=0.2184 PS=2.62 PD=1.36
* device instance $88 r0 *1 44.42,39.22 nfet
X$88 vss__t73 a|b|d|invb_a|mn12_g1|mp24_g0|ro4|ro4_esc|sr4_d_stub|tg_d_a|y__t7
+ \$141__t1 vss__t127 sky130_fd_pr__nfet_01v8 L=0.15 W=0.84 AS=0.2184 AD=0.3948
+ PS=1.36 PD=2.62
* device instance $89 r0 *1 48.86,23.845 nfet
X$89 a|d|inva_a|mn12_g0|mp13_g0|ro1|ro1_esc|sr1_d_stub|tg_d_a|y__t1
+ a|g_a|rn1|ro|s4_y|y__t2 vss__t59 vss__t176 sky130_fd_pr__nfet_01v8 L=0.15
+ W=0.42 AS=0.1974 AD=0.1974 PS=1.78 PD=1.78
* device instance $90 r0 *1 50.59,41.54 nfet
X$90 bn|invb_y|mn34_g1|mp24_g1|y__t12
+ a|b|d|invb_a|mn12_g1|mp24_g0|ro4|ro4_esc|sr4_d_stub|tg_d_a|y__t5 vss__t68
+ vss__t195 sky130_fd_pr__nfet_01v8 L=0.15 W=0.42 AS=0.1974 AD=0.1974 PS=1.78
+ PD=1.78
* device instance $91 r0 *1 58.91,23.845 nfet
X$91 ny__t06 vddr2__t0 vss__t3 vss__t203 sky130_fd_pr__nfet_01v8 L=2 W=0.44
+ AS=0.1848 AD=0.1848 PS=1.72 PD=1.72
* device instance $92 r0 *1 61.275,23.845 nfet
X$92 \$81__t0 en2__t1 ny__t16 vss__t99 sky130_fd_pr__nfet_01v8 L=0.15 W=0.84
+ AS=0.3948 AD=0.2184 PS=2.62 PD=1.36
* device instance $93 r0 *1 61.945,23.845 nfet
X$93 a|g_y|mnab_y|mpa_y|mpb_y|n1|s1_a|y__t42 a|g_a|rn2|ro|s4_y|y__t5 \$81__t1
+ vss__t121 sky130_fd_pr__nfet_01v8 L=0.15 W=0.84 AS=0.2184 AD=0.3948 PS=1.36
+ PD=2.62
* device instance $94 r0 *1 61.385,41.54 nfet
X$94 an|inva_y|mn34_g0|mp13_g1|y__t13 a|inva_a|mn12_g0|mp13_g0|t1|y__t3
+ vss__t62 vss__t196 sky130_fd_pr__nfet_01v8 L=0.15 W=0.42 AS=0.1974 AD=0.1974
+ PS=1.78 PD=1.78
* device instance $95 r0 *1 65.72,39.22 nfet
X$95 \$142__t0 an|inva_y|mn34_g0|mp13_g1|y__t33
+ a|d|sb_d_stub|tg_d_a|xo|xo_dip|xo_hop|xo_stub|y__t5 vss__t106
+ sky130_fd_pr__nfet_01v8 L=0.15 W=0.84 AS=0.3948 AD=0.2184 PS=2.62 PD=1.36
* device instance $96 r0 *1 66.39,39.22 nfet
X$96 vss__t71 bn|invb_y|mn34_g1|mp24_g1|y__t33 \$142__t1 vss__t128
+ sky130_fd_pr__nfet_01v8 L=0.15 W=0.84 AS=0.2184 AD=0.3948 PS=1.36 PD=2.62
* device instance $97 r0 *1 68.21,23.845 nfet
X$97 ny__t07 vddr2__t14 vss__t37 vss__t204 sky130_fd_pr__nfet_01v8 L=2 W=0.44
+ AS=0.1848 AD=0.1848 PS=1.72 PD=1.72
* device instance $98 r0 *1 70.575,23.845 nfet
X$98 a|n2|s1_y|s2_a|y__t0 a|g_y|mnab_y|mpa_y|mpb_y|n1|s1_a|y__t12 ny__t17
+ vss__t177 sky130_fd_pr__nfet_01v8 L=0.15 W=0.42 AS=0.1974 AD=0.1974 PS=1.78
+ PD=1.78
* device instance $99 r0 *1 72.72,39.22 nfet
X$99 \$145__t0 a|inva_a|mn12_g0|mp13_g0|t1|y__t5
+ a|d|sb_d_stub|tg_d_a|xo|xo_dip|xo_hop|xo_stub|y__t4 vss__t107
+ sky130_fd_pr__nfet_01v8 L=0.15 W=0.84 AS=0.3948 AD=0.2184 PS=2.62 PD=1.36
* device instance $100 r0 *1 73.39,39.22 nfet
X$100 vss__t72 a|b|b3|invb_a|mn12_g1|mp24_g0|t2|y__t5 \$145__t1 vss__t129
+ sky130_fd_pr__nfet_01v8 L=0.15 W=0.84 AS=0.2184 AD=0.3948 PS=1.36 PD=2.62
* device instance $101 r0 *1 76.385,23.845 nfet
X$101 ny__t08 vddr2__t11 vss__t34 vss__t205 sky130_fd_pr__nfet_01v8 L=2 W=0.44
+ AS=0.1848 AD=0.1848 PS=1.72 PD=1.72
* device instance $102 r0 *1 78.75,23.845 nfet
X$102 a|n3|s2_y|s3_a|y__t02 a|n2|s1_y|s2_a|y__t2 ny__t18 vss__t178
+ sky130_fd_pr__nfet_01v8 L=0.15 W=0.42 AS=0.1974 AD=0.1974 PS=1.78 PD=1.78
* device instance $103 r0 *1 79.56,41.54 nfet
X$103 bn|invb_y|mn34_g1|mp24_g1|y__t13 a|b|b3|invb_a|mn12_g1|mp24_g0|t2|y__t3
+ vss__t63 vss__t197 sky130_fd_pr__nfet_01v8 L=0.15 W=0.42 AS=0.1974 AD=0.1974
+ PS=1.78 PD=1.78
* device instance $104 r0 *1 84.56,23.845 nfet
X$104 ny__t09 vddr2__t13 vss__t36 vss__t206 sky130_fd_pr__nfet_01v8 L=2 W=0.44
+ AS=0.1848 AD=0.1848 PS=1.72 PD=1.72
* device instance $105 r0 *1 86.925,23.845 nfet
X$105 a|n4|s3_y|s4_a|y__t0 a|n3|s2_y|s3_a|y__t22 ny__t19 vss__t179
+ sky130_fd_pr__nfet_01v8 L=0.15 W=0.42 AS=0.1974 AD=0.1974 PS=1.78 PD=1.78
* device instance $106 r0 *1 92.735,23.845 nfet
X$106 ny__t010 vddr2__t12 vss__t35 vss__t207 sky130_fd_pr__nfet_01v8 L=2 W=0.44
+ AS=0.1848 AD=0.1848 PS=1.72 PD=1.72
* device instance $107 r0 *1 95.1,23.845 nfet
X$107 a|g_a|rn2|ro|s4_y|y__t0 a|n4|s3_y|s4_a|y__t2 ny__t110 vss__t180
+ sky130_fd_pr__nfet_01v8 L=0.15 W=0.42 AS=0.1974 AD=0.1974 PS=1.78 PD=1.78
* device instance $108 r0 *1 104.16,23.845 nfet
X$108 a|b|d|invb_a|mn12_g1|mp24_g0|ro2|ro2_esc|sr2_d_stub|tg_d_a|y__t2
+ a|g_a|rn2|ro|s4_y|y__t2 vss__t55 vss__t181 sky130_fd_pr__nfet_01v8 L=0.15
+ W=0.42 AS=0.1974 AD=0.1974 PS=1.78 PD=1.78
* device instance $109 r0 *1 114.21,23.845 nfet
X$109 ny__t011 vddr3__t0 vss__t4 vss__t208 sky130_fd_pr__nfet_01v8 L=2 W=0.46
+ AS=0.1932 AD=0.1932 PS=1.76 PD=1.76
* device instance $110 r0 *1 116.575,23.845 nfet
X$110 \$87__t0 en3__t1 ny__t111 vss__t100 sky130_fd_pr__nfet_01v8 L=0.15 W=0.84
+ AS=0.3948 AD=0.2184 PS=2.62 PD=1.36
* device instance $111 r0 *1 117.245,23.845 nfet
X$111 a|g_y|mnab_y|mpa_y|mpb_y|n1|s1_a|y__t43 a|g_a|rn3|ro|s4_y|y__t5 \$87__t1
+ vss__t122 sky130_fd_pr__nfet_01v8 L=0.15 W=0.84 AS=0.2184 AD=0.3948 PS=1.36
+ PD=2.62
* device instance $112 r0 *1 123.51,23.845 nfet
X$112 ny__t012 vddr3__t12 vss__t31 vss__t209 sky130_fd_pr__nfet_01v8 L=2 W=0.46
+ AS=0.1932 AD=0.1932 PS=1.76 PD=1.76
* device instance $113 r0 *1 125.875,23.845 nfet
X$113 a|n2|s1_y|s2_a|y__t03 a|g_y|mnab_y|mpa_y|mpb_y|n1|s1_a|y__t13 ny__t112
+ vss__t182 sky130_fd_pr__nfet_01v8 L=0.15 W=0.42 AS=0.1974 AD=0.1974 PS=1.78
+ PD=1.78
* device instance $114 r0 *1 131.685,23.845 nfet
X$114 ny__t013 vddr3__t11 vss__t30 vss__t210 sky130_fd_pr__nfet_01v8 L=2 W=0.46
+ AS=0.1932 AD=0.1932 PS=1.76 PD=1.76
* device instance $115 r0 *1 134.05,23.845 nfet
X$115 a|n3|s2_y|s3_a|y__t03 a|n2|s1_y|s2_a|y__t23 ny__t113 vss__t183
+ sky130_fd_pr__nfet_01v8 L=0.15 W=0.42 AS=0.1974 AD=0.1974 PS=1.78 PD=1.78
* device instance $116 r0 *1 139.86,23.845 nfet
X$116 ny__t014 vddr3__t14 vss__t33 vss__t211 sky130_fd_pr__nfet_01v8 L=2 W=0.46
+ AS=0.1932 AD=0.1932 PS=1.76 PD=1.76
* device instance $117 r0 *1 142.225,23.845 nfet
X$117 a|n4|s3_y|s4_a|y__t04 a|n3|s2_y|s3_a|y__t23 ny__t114 vss__t184
+ sky130_fd_pr__nfet_01v8 L=0.15 W=0.42 AS=0.1974 AD=0.1974 PS=1.78 PD=1.78
* device instance $118 r0 *1 148.035,23.845 nfet
X$118 ny__t015 vddr3__t13 vss__t32 vss__t212 sky130_fd_pr__nfet_01v8 L=2 W=0.46
+ AS=0.1932 AD=0.1932 PS=1.76 PD=1.76
* device instance $119 r0 *1 150.4,23.845 nfet
X$119 a|g_a|rn3|ro|s4_y|y__t0 a|n4|s3_y|s4_a|y__t24 ny__t115 vss__t185
+ sky130_fd_pr__nfet_01v8 L=0.15 W=0.42 AS=0.1974 AD=0.1974 PS=1.78 PD=1.78
* device instance $120 r0 *1 159.46,23.845 nfet
X$120
+ a|d|inva_a|mn12_g0|mp13_g0|ro3|ro3_esc_e|ro3_esc_w|ro3_hop|sr3_d_stub|tg_d_a|y__t2
+ a|g_a|rn3|ro|s4_y|y__t2 vss__t66 vss__t186 sky130_fd_pr__nfet_01v8 L=0.15
+ W=0.42 AS=0.1974 AD=0.1974 PS=1.78 PD=1.78
* device instance $121 r0 *1 169.51,23.845 nfet
X$121 ny__t016 vddr4__t0 vss__t5 vss__t213 sky130_fd_pr__nfet_01v8 L=2 W=0.48
+ AS=0.2016 AD=0.2016 PS=1.8 PD=1.8
* device instance $122 r0 *1 171.875,23.845 nfet
X$122 \$93__t0 en4__t1 ny__t116 vss__t101 sky130_fd_pr__nfet_01v8 L=0.15 W=0.84
+ AS=0.3948 AD=0.2184 PS=2.62 PD=1.36
* device instance $123 r0 *1 172.545,23.845 nfet
X$123 a|g_y|mnab_y|mpa_y|mpb_y|n1|s1_a|y__t44 a|g_a|rn4|ro|s4_y|y__t5 \$93__t1
+ vss__t123 sky130_fd_pr__nfet_01v8 L=0.15 W=0.84 AS=0.2184 AD=0.3948 PS=1.36
+ PD=2.62
* device instance $124 r0 *1 178.81,23.845 nfet
X$124 ny__t017 vddr4__t11 vss__t26 vss__t214 sky130_fd_pr__nfet_01v8 L=2 W=0.48
+ AS=0.2016 AD=0.2016 PS=1.8 PD=1.8
* device instance $125 r0 *1 181.175,23.845 nfet
X$125 a|n2|s1_y|s2_a|y__t04 a|g_y|mnab_y|mpa_y|mpb_y|n1|s1_a|y__t14 ny__t117
+ vss__t187 sky130_fd_pr__nfet_01v8 L=0.15 W=0.42 AS=0.1974 AD=0.1974 PS=1.78
+ PD=1.78
* device instance $126 r0 *1 186.985,23.845 nfet
X$126 ny__t018 vddr4__t12 vss__t27 vss__t215 sky130_fd_pr__nfet_01v8 L=2 W=0.48
+ AS=0.2016 AD=0.2016 PS=1.8 PD=1.8
* device instance $127 r0 *1 189.35,23.845 nfet
X$127 a|n3|s2_y|s3_a|y__t04 a|n2|s1_y|s2_a|y__t24 ny__t118 vss__t188
+ sky130_fd_pr__nfet_01v8 L=0.15 W=0.42 AS=0.1974 AD=0.1974 PS=1.78 PD=1.78
* device instance $128 r0 *1 195.16,23.845 nfet
X$128 ny__t019 vddr4__t13 vss__t28 vss__t216 sky130_fd_pr__nfet_01v8 L=2 W=0.48
+ AS=0.2016 AD=0.2016 PS=1.8 PD=1.8
* device instance $129 r0 *1 197.525,23.845 nfet
X$129 a|n4|s3_y|s4_a|y__t02 a|n3|s2_y|s3_a|y__t24 ny__t119 vss__t189
+ sky130_fd_pr__nfet_01v8 L=0.15 W=0.42 AS=0.1974 AD=0.1974 PS=1.78 PD=1.78
* device instance $130 r0 *1 203.335,23.845 nfet
X$130 ny__t020 vddr4__t14 vss__t29 vss__t217 sky130_fd_pr__nfet_01v8 L=2 W=0.48
+ AS=0.2016 AD=0.2016 PS=1.8 PD=1.8
* device instance $131 r0 *1 205.7,23.845 nfet
X$131 a|g_a|rn4|ro|s4_y|y__t0 a|n4|s3_y|s4_a|y__t22 ny__t120 vss__t190
+ sky130_fd_pr__nfet_01v8 L=0.15 W=0.42 AS=0.1974 AD=0.1974 PS=1.78 PD=1.78
* device instance $132 r0 *1 214.76,23.845 nfet
X$132 a|b|d|invb_a|mn12_g1|mp24_g0|ro4|ro4_esc|sr4_d_stub|tg_d_a|y__t1
+ a|g_a|rn4|ro|s4_y|y__t2 vss__t46 vss__t191 sky130_fd_pr__nfet_01v8 L=0.15
+ W=0.42 AS=0.1974 AD=0.1974 PS=1.78 PD=1.78
* device instance $133 r0 *1 0.545,3.53 pfet
X$133
+ clkb|clkb_bridge1|clkb_bridge2|clkb_mid|clkb_w|ctrl|ctrlb|inv_clk_y|tg_d_ctrlb|tg_fbm_ctrl|tg_fbs_ctrlb|tg_s_ctrl|y__t0
+ clk__t0 vdd__t0 vdd__t1 sky130_fd_pr__pfet_01v8 L=0.15 W=0.84 AS=0.3948
+ AD=0.3948 PS=2.62 PD=2.62
* device instance $134 r0 *1 5.31,3.53 pfet
X$134 a|d|sb_d_stub|tg_d_a|xo|xo_dip|xo_hop|xo_stub|y__t3 clk__t22
+ a|b|m_east|m_west|nand_m_a|nand_m_a_ext_via|nand_m_a_ext_via2|nand_m_a_stub|tg_d_b|tg_d_b_via|tg_d_b_via2|tg_fbm_b|tg_fbm_b_alt_via|tg_fbm_b_alt_via2__t4
+ vdd__t65 sky130_fd_pr__pfet_01v8 L=0.15 W=0.84 AS=0.3948 AD=0.3948 PS=2.62
+ PD=2.62
* device instance $135 r0 *1 19.835,3.53 pfet
X$135 a|inv_mc_y|inv_mc_y_via|mc|tg_fbm_a|tg_fbm_a_via|y__t2
+ a|inv_mc_a|mb|mnab_y|mpa_y|mpb_y|nand_m_y|tg_s_a|y__t5 vdd__t129 vdd__t66
+ sky130_fd_pr__pfet_01v8 L=0.15 W=0.84 AS=0.3948 AD=0.3948 PS=2.62 PD=2.62
* device instance $136 r0 *1 24.6,3.53 pfet
X$136 a|inv_mc_y|inv_mc_y_via|mc|tg_fbm_a|tg_fbm_a_via|y__t3
+ clkb|clkb_bridge1|clkb_bridge2|clkb_mid|clkb_w|ctrl|ctrlb|inv_clk_y|tg_d_ctrlb|tg_fbm_ctrl|tg_fbs_ctrlb|tg_s_ctrl|y__t4
+ a|b|m_east|m_west|nand_m_a|nand_m_a_ext_via|nand_m_a_ext_via2|nand_m_a_stub|tg_d_b|tg_d_b_via|tg_d_b_via2|tg_fbm_b|tg_fbm_b_alt_via|tg_fbm_b_alt_via2__t5
+ vdd__t67 sky130_fd_pr__pfet_01v8 L=0.15 W=0.84 AS=0.3948 AD=0.3948 PS=2.62
+ PD=2.62
* device instance $137 r0 *1 29.74,3.53 pfet
X$137 a|inv_mc_a|mb|mnab_y|mpa_y|mpb_y|nand_m_y|tg_s_a|y__t2
+ clkb|clkb_bridge1|clkb_bridge2|clkb_mid|clkb_w|ctrl|ctrlb|inv_clk_y|tg_d_ctrlb|tg_fbm_ctrl|tg_fbs_ctrlb|tg_s_ctrl|y__t5
+ a|b|inv_q_a|inv_q_a_via|s|tg_fbs_b|tg_fbs_b_via|tg_s_b|tg_s_b_via__t4
+ vdd__t68 sky130_fd_pr__pfet_01v8 L=0.15 W=0.84 AS=0.3948 AD=0.3948 PS=2.62
+ PD=2.62
* device instance $138 r0 *1 36.545,3.53 pfet
X$138
+ a|inv_q_y|inv_q_y_via|inv_q_y_via2|nand_s2_a|nand_s2_a_stub|nand_s2_a_via|nand_s2_a_via2|q|y__t12
+ a|b|inv_q_a|inv_q_a_via|s|tg_fbs_b|tg_fbs_b_via|tg_s_b|tg_s_b_via__t1
+ vdd__t130 vdd__t69 sky130_fd_pr__pfet_01v8 L=0.15 W=0.84 AS=0.3948 AD=0.3948
+ PS=2.62 PD=2.62
* device instance $139 r0 *1 49.03,3.53 pfet
X$139 a|mnab_y|mpa_y|mpb_y|nand_s2_y|qb|tg_fbs_a|y__t1 clk__t23
+ a|b|inv_q_a|inv_q_a_via|s|tg_fbs_b|tg_fbs_b_via|tg_s_b|tg_s_b_via__t5
+ vdd__t70 sky130_fd_pr__pfet_01v8 L=0.15 W=0.84 AS=0.3948 AD=0.3948 PS=2.62
+ PD=2.62
* device instance $140 r0 *1 56.205,3.53 pfet
X$140
+ clkb|clkb_bridge1|clkb_bridge2|clkb_mid|clkb_w|ctrl|ctrlb|inv_clk_y|tg_d_ctrlb|tg_fbm_ctrl|tg_fbs_ctrlb|tg_s_ctrl|y__t12
+ clk__t24 vdd__t131 vdd__t71 sky130_fd_pr__pfet_01v8 L=0.15 W=0.84 AS=0.3948
+ AD=0.3948 PS=2.62 PD=2.62
* device instance $141 r0 *1 60.97,3.53 pfet
X$141 vdd__t27 clk__t25
+ a|b|m_east|m_west|nand_m_a|nand_m_a_ext_via|nand_m_a_ext_via2|nand_m_a_stub|tg_d_b|tg_d_b_via|tg_d_b_via2|tg_fbm_b|tg_fbm_b_alt_via|tg_fbm_b_alt_via2__t32
+ vdd__t72 sky130_fd_pr__pfet_01v8 L=0.15 W=0.84 AS=0.3948 AD=0.3948 PS=2.62
+ PD=2.62
* device instance $142 r0 *1 75.495,3.53 pfet
X$142 a|inv_mc_y|inv_mc_y_via|mc|tg_fbm_a|tg_fbm_a_via|y__t22
+ a|inv_mc_a|mb|mnab_y|mpa_y|mpb_y|nand_m_y|tg_s_a|y__t42 vdd__t132 vdd__t73
+ sky130_fd_pr__pfet_01v8 L=0.15 W=0.84 AS=0.3948 AD=0.3948 PS=2.62 PD=2.62
* device instance $143 r0 *1 80.26,3.53 pfet
X$143 a|inv_mc_y|inv_mc_y_via|mc|tg_fbm_a|tg_fbm_a_via|y__t32
+ clkb|clkb_bridge1|clkb_bridge2|clkb_mid|clkb_w|ctrl|ctrlb|inv_clk_y|tg_d_ctrlb|tg_fbm_ctrl|tg_fbs_ctrlb|tg_s_ctrl|y__t52
+ a|b|m_east|m_west|nand_m_a|nand_m_a_ext_via|nand_m_a_ext_via2|nand_m_a_stub|tg_d_b|tg_d_b_via|tg_d_b_via2|tg_fbm_b|tg_fbm_b_alt_via|tg_fbm_b_alt_via2__t42
+ vdd__t85 sky130_fd_pr__pfet_01v8 L=0.15 W=0.84 AS=0.3948 AD=0.3948 PS=2.62
+ PD=2.62
* device instance $144 r0 *1 85.4,3.53 pfet
X$144 a|inv_mc_a|mb|mnab_y|mpa_y|mpb_y|nand_m_y|tg_s_a|y__t12
+ clkb|clkb_bridge1|clkb_bridge2|clkb_mid|clkb_w|ctrl|ctrlb|inv_clk_y|tg_d_ctrlb|tg_fbm_ctrl|tg_fbs_ctrlb|tg_s_ctrl|y__t42
+ a|b|inv_q_a|inv_q_a_via|s|tg_fbs_b|tg_fbs_b_via|tg_s_b|tg_s_b_via__t52
+ vdd__t84 sky130_fd_pr__pfet_01v8 L=0.15 W=0.84 AS=0.3948 AD=0.3948 PS=2.62
+ PD=2.62
* device instance $145 r0 *1 92.205,3.53 pfet
X$145
+ a|inv_q_y|inv_q_y_via|inv_q_y_via2|nand_s2_a|nand_s2_a_stub|nand_s2_a_via|nand_s2_a_via2|q|y__t13
+ a|b|inv_q_a|inv_q_a_via|s|tg_fbs_b|tg_fbs_b_via|tg_s_b|tg_s_b_via__t12
+ vdd__t137 vdd__t83 sky130_fd_pr__pfet_01v8 L=0.15 W=0.84 AS=0.3948 AD=0.3948
+ PS=2.62 PD=2.62
* device instance $146 r0 *1 104.69,3.53 pfet
X$146 a|mnab_y|mpa_y|mpb_y|nand_s2_y|qb|tg_fbs_a|y__t22 clk__t30
+ a|b|inv_q_a|inv_q_a_via|s|tg_fbs_b|tg_fbs_b_via|tg_s_b|tg_s_b_via__t42
+ vdd__t82 sky130_fd_pr__pfet_01v8 L=0.15 W=0.84 AS=0.3948 AD=0.3948 PS=2.62
+ PD=2.62
* device instance $147 r0 *1 111.865,3.53 pfet
X$147
+ clkb|clkb_bridge1|clkb_bridge2|clkb_mid|clkb_w|ctrl|ctrlb|inv_clk_y|tg_d_ctrlb|tg_fbm_ctrl|tg_fbs_ctrlb|tg_s_ctrl|y__t13
+ clk__t29 vdd__t136 vdd__t81 sky130_fd_pr__pfet_01v8 L=0.15 W=0.84 AS=0.3948
+ AD=0.3948 PS=2.62 PD=2.62
* device instance $148 r0 *1 116.63,3.53 pfet
X$148 a|d|inva_a|mn12_g0|mp13_g0|ro1|ro1_esc|sr1_d_stub|tg_d_a|y__t4 clk__t28
+ a|b|m_east|m_west|nand_m_a|nand_m_a_ext_via|nand_m_a_ext_via2|nand_m_a_stub|tg_d_b|tg_d_b_via|tg_d_b_via2|tg_fbm_b|tg_fbm_b_alt_via|tg_fbm_b_alt_via2__t43
+ vdd__t80 sky130_fd_pr__pfet_01v8 L=0.15 W=0.84 AS=0.3948 AD=0.3948 PS=2.62
+ PD=2.62
* device instance $149 r0 *1 131.155,3.53 pfet
X$149 a|inv_mc_y|inv_mc_y_via|mc|tg_fbm_a|tg_fbm_a_via|y__t33
+ a|inv_mc_a|mb|mnab_y|mpa_y|mpb_y|nand_m_y|tg_s_a|y__t43 vdd__t135 vdd__t79
+ sky130_fd_pr__pfet_01v8 L=0.15 W=0.84 AS=0.3948 AD=0.3948 PS=2.62 PD=2.62
* device instance $150 r0 *1 135.92,3.53 pfet
X$150 a|inv_mc_y|inv_mc_y_via|mc|tg_fbm_a|tg_fbm_a_via|y__t23
+ clkb|clkb_bridge1|clkb_bridge2|clkb_mid|clkb_w|ctrl|ctrlb|inv_clk_y|tg_d_ctrlb|tg_fbm_ctrl|tg_fbs_ctrlb|tg_s_ctrl|y__t43
+ a|b|m_east|m_west|nand_m_a|nand_m_a_ext_via|nand_m_a_ext_via2|nand_m_a_stub|tg_d_b|tg_d_b_via|tg_d_b_via2|tg_fbm_b|tg_fbm_b_alt_via|tg_fbm_b_alt_via2__t33
+ vdd__t78 sky130_fd_pr__pfet_01v8 L=0.15 W=0.84 AS=0.3948 AD=0.3948 PS=2.62
+ PD=2.62
* device instance $151 r0 *1 141.06,3.53 pfet
X$151 a|inv_mc_a|mb|mnab_y|mpa_y|mpb_y|nand_m_y|tg_s_a|y__t23
+ clkb|clkb_bridge1|clkb_bridge2|clkb_mid|clkb_w|ctrl|ctrlb|inv_clk_y|tg_d_ctrlb|tg_fbm_ctrl|tg_fbs_ctrlb|tg_s_ctrl|y__t53
+ a|b|inv_q_a|inv_q_a_via|s|tg_fbs_b|tg_fbs_b_via|tg_s_b|tg_s_b_via__t53
+ vdd__t100 sky130_fd_pr__pfet_01v8 L=0.15 W=0.84 AS=0.3948 AD=0.3948 PS=2.62
+ PD=2.62
* device instance $152 r0 *1 147.865,3.53 pfet
X$152
+ a|inv_q_y|inv_q_y_via|inv_q_y_via2|nand_s2_a|nand_s2_a_stub|nand_s2_a_via|nand_s2_a_via2|q|y__t14
+ a|b|inv_q_a|inv_q_a_via|s|tg_fbs_b|tg_fbs_b_via|tg_s_b|tg_s_b_via__t13
+ vdd__t143 vdd__t98 sky130_fd_pr__pfet_01v8 L=0.15 W=0.84 AS=0.3948 AD=0.3948
+ PS=2.62 PD=2.62
* device instance $153 r0 *1 160.35,3.53 pfet
X$153 a|mnab_y|mpa_y|mpb_y|nand_s2_y|qb|tg_fbs_a|y__t23 clk__t34
+ a|b|inv_q_a|inv_q_a_via|s|tg_fbs_b|tg_fbs_b_via|tg_s_b|tg_s_b_via__t43
+ vdd__t97 sky130_fd_pr__pfet_01v8 L=0.15 W=0.84 AS=0.3948 AD=0.3948 PS=2.62
+ PD=2.62
* device instance $154 r0 *1 167.525,3.53 pfet
X$154
+ clkb|clkb_bridge1|clkb_bridge2|clkb_mid|clkb_w|ctrl|ctrlb|inv_clk_y|tg_d_ctrlb|tg_fbm_ctrl|tg_fbs_ctrlb|tg_s_ctrl|y__t14
+ clk__t27 vdd__t133 vdd__t75 sky130_fd_pr__pfet_01v8 L=0.15 W=0.84 AS=0.3948
+ AD=0.3948 PS=2.62 PD=2.62
* device instance $155 r0 *1 172.29,3.53 pfet
X$155 a|b|d|invb_a|mn12_g1|mp24_g0|ro2|ro2_esc|sr2_d_stub|tg_d_a|y__t4 clk__t35
+ a|b|m_east|m_west|nand_m_a|nand_m_a_ext_via|nand_m_a_ext_via2|nand_m_a_stub|tg_d_b|tg_d_b_via|tg_d_b_via2|tg_fbm_b|tg_fbm_b_alt_via|tg_fbm_b_alt_via2__t44
+ vdd__t106 sky130_fd_pr__pfet_01v8 L=0.15 W=0.84 AS=0.3948 AD=0.3948 PS=2.62
+ PD=2.62
* device instance $156 r0 *1 186.815,3.53 pfet
X$156 a|inv_mc_y|inv_mc_y_via|mc|tg_fbm_a|tg_fbm_a_via|y__t34
+ a|inv_mc_a|mb|mnab_y|mpa_y|mpb_y|nand_m_y|tg_s_a|y__t44 vdd__t146 vdd__t105
+ sky130_fd_pr__pfet_01v8 L=0.15 W=0.84 AS=0.3948 AD=0.3948 PS=2.62 PD=2.62
* device instance $157 r0 *1 191.58,3.53 pfet
X$157 a|inv_mc_y|inv_mc_y_via|mc|tg_fbm_a|tg_fbm_a_via|y__t24
+ clkb|clkb_bridge1|clkb_bridge2|clkb_mid|clkb_w|ctrl|ctrlb|inv_clk_y|tg_d_ctrlb|tg_fbm_ctrl|tg_fbs_ctrlb|tg_s_ctrl|y__t54
+ a|b|m_east|m_west|nand_m_a|nand_m_a_ext_via|nand_m_a_ext_via2|nand_m_a_stub|tg_d_b|tg_d_b_via|tg_d_b_via2|tg_fbm_b|tg_fbm_b_alt_via|tg_fbm_b_alt_via2__t34
+ vdd__t104 sky130_fd_pr__pfet_01v8 L=0.15 W=0.84 AS=0.3948 AD=0.3948 PS=2.62
+ PD=2.62
* device instance $158 r0 *1 196.72,3.53 pfet
X$158 a|inv_mc_a|mb|mnab_y|mpa_y|mpb_y|nand_m_y|tg_s_a|y__t24
+ clkb|clkb_bridge1|clkb_bridge2|clkb_mid|clkb_w|ctrl|ctrlb|inv_clk_y|tg_d_ctrlb|tg_fbm_ctrl|tg_fbs_ctrlb|tg_s_ctrl|y__t44
+ a|b|inv_q_a|inv_q_a_via|s|tg_fbs_b|tg_fbs_b_via|tg_s_b|tg_s_b_via__t54
+ vdd__t101 sky130_fd_pr__pfet_01v8 L=0.15 W=0.84 AS=0.3948 AD=0.3948 PS=2.62
+ PD=2.62
* device instance $159 r0 *1 203.525,3.53 pfet
X$159
+ a|inv_q_y|inv_q_y_via|inv_q_y_via2|nand_s2_a|nand_s2_a_stub|nand_s2_a_via|nand_s2_a_via2|q|y__t1
+ a|b|inv_q_a|inv_q_a_via|s|tg_fbs_b|tg_fbs_b_via|tg_s_b|tg_s_b_via__t14
+ vdd__t144 vdd__t99 sky130_fd_pr__pfet_01v8 L=0.15 W=0.84 AS=0.3948 AD=0.3948
+ PS=2.62 PD=2.62
* device instance $160 r0 *1 216.01,3.53 pfet
X$160 a|mnab_y|mpa_y|mpb_y|nand_s2_y|qb|tg_fbs_a|y__t24 clk__t33
+ a|b|inv_q_a|inv_q_a_via|s|tg_fbs_b|tg_fbs_b_via|tg_s_b|tg_s_b_via__t44
+ vdd__t93 sky130_fd_pr__pfet_01v8 L=0.15 W=0.84 AS=0.3948 AD=0.3948 PS=2.62
+ PD=2.62
* device instance $161 r0 *1 223.185,3.53 pfet
X$161
+ clkb|clkb_bridge1|clkb_bridge2|clkb_mid|clkb_w|ctrl|ctrlb|inv_clk_y|tg_d_ctrlb|tg_fbm_ctrl|tg_fbs_ctrlb|tg_s_ctrl|y__t15
+ clk__t32 vdd__t139 vdd__t90 sky130_fd_pr__pfet_01v8 L=0.15 W=0.84 AS=0.3948
+ AD=0.3948 PS=2.62 PD=2.62
* device instance $162 r0 *1 227.95,3.53 pfet
X$162
+ a|d|inva_a|mn12_g0|mp13_g0|ro3|ro3_esc_e|ro3_esc_w|ro3_hop|sr3_d_stub|tg_d_a|y__t4
+ clk__t31
+ a|b|m_east|m_west|nand_m_a|nand_m_a_ext_via|nand_m_a_ext_via2|nand_m_a_stub|tg_d_b|tg_d_b_via|tg_d_b_via2|tg_fbm_b|tg_fbm_b_alt_via|tg_fbm_b_alt_via2__t45
+ vdd__t89 sky130_fd_pr__pfet_01v8 L=0.15 W=0.84 AS=0.3948 AD=0.3948 PS=2.62
+ PD=2.62
* device instance $163 r0 *1 242.475,3.53 pfet
X$163 a|inv_mc_y|inv_mc_y_via|mc|tg_fbm_a|tg_fbm_a_via|y__t35
+ a|inv_mc_a|mb|mnab_y|mpa_y|mpb_y|nand_m_y|tg_s_a|y__t45 vdd__t138 vdd__t87
+ sky130_fd_pr__pfet_01v8 L=0.15 W=0.84 AS=0.3948 AD=0.3948 PS=2.62 PD=2.62
* device instance $164 r0 *1 247.24,3.53 pfet
X$164 a|inv_mc_y|inv_mc_y_via|mc|tg_fbm_a|tg_fbm_a_via|y__t25
+ clkb|clkb_bridge1|clkb_bridge2|clkb_mid|clkb_w|ctrl|ctrlb|inv_clk_y|tg_d_ctrlb|tg_fbm_ctrl|tg_fbs_ctrlb|tg_s_ctrl|y__t55
+ a|b|m_east|m_west|nand_m_a|nand_m_a_ext_via|nand_m_a_ext_via2|nand_m_a_stub|tg_d_b|tg_d_b_via|tg_d_b_via2|tg_fbm_b|tg_fbm_b_alt_via|tg_fbm_b_alt_via2__t35
+ vdd__t86 sky130_fd_pr__pfet_01v8 L=0.15 W=0.84 AS=0.3948 AD=0.3948 PS=2.62
+ PD=2.62
* device instance $165 r0 *1 252.38,3.53 pfet
X$165 a|inv_mc_a|mb|mnab_y|mpa_y|mpb_y|nand_m_y|tg_s_a|y__t25
+ clkb|clkb_bridge1|clkb_bridge2|clkb_mid|clkb_w|ctrl|ctrlb|inv_clk_y|tg_d_ctrlb|tg_fbm_ctrl|tg_fbs_ctrlb|tg_s_ctrl|y__t45
+ a|b|inv_q_a|inv_q_a_via|s|tg_fbs_b|tg_fbs_b_via|tg_s_b|tg_s_b_via__t45
+ vdd__t54 sky130_fd_pr__pfet_01v8 L=0.15 W=0.84 AS=0.3948 AD=0.3948 PS=2.62
+ PD=2.62
* device instance $166 r0 *1 259.185,3.53 pfet
X$166
+ a|inv_q_y|inv_q_y_via|inv_q_y_via2|nand_s2_a|nand_s2_a_stub|nand_s2_a_via|nand_s2_a_via2|q|y__t15
+ a|b|inv_q_a|inv_q_a_via|s|tg_fbs_b|tg_fbs_b_via|tg_s_b|tg_s_b_via__t15
+ vdd__t116 vdd__t46 sky130_fd_pr__pfet_01v8 L=0.15 W=0.84 AS=0.3948 AD=0.3948
+ PS=2.62 PD=2.62
* device instance $167 r0 *1 271.67,3.53 pfet
X$167 a|mnab_y|mpa_y|mpb_y|nand_s2_y|qb|tg_fbs_a|y__t25 clk__t26
+ a|b|inv_q_a|inv_q_a_via|s|tg_fbs_b|tg_fbs_b_via|tg_s_b|tg_s_b_via__t55
+ vdd__t74 sky130_fd_pr__pfet_01v8 L=0.15 W=0.84 AS=0.3948 AD=0.3948 PS=2.62
+ PD=2.62
* device instance $168 r0 *1 278.845,3.53 pfet
X$168
+ clkb|clkb_bridge1|clkb_bridge2|clkb_mid|clkb_w|ctrl|ctrlb|inv_clk_y|tg_d_ctrlb|tg_fbm_ctrl|tg_fbs_ctrlb|tg_s_ctrl|y__t16
+ clk__t21 vdd__t115 vdd__t45 sky130_fd_pr__pfet_01v8 L=0.15 W=0.84 AS=0.3948
+ AD=0.3948 PS=2.62 PD=2.62
* device instance $169 r0 *1 283.61,3.53 pfet
X$169 a|b|d|invb_a|mn12_g1|mp24_g0|ro4|ro4_esc|sr4_d_stub|tg_d_a|y__t3 clk__t20
+ a|b|m_east|m_west|nand_m_a|nand_m_a_ext_via|nand_m_a_ext_via2|nand_m_a_stub|tg_d_b|tg_d_b_via|tg_d_b_via2|tg_fbm_b|tg_fbm_b_alt_via|tg_fbm_b_alt_via2__t46
+ vdd__t44 sky130_fd_pr__pfet_01v8 L=0.15 W=0.84 AS=0.3948 AD=0.3948 PS=2.62
+ PD=2.62
* device instance $170 r0 *1 298.135,3.53 pfet
X$170 a|inv_mc_y|inv_mc_y_via|mc|tg_fbm_a|tg_fbm_a_via|y__t36
+ a|inv_mc_a|mb|mnab_y|mpa_y|mpb_y|nand_m_y|tg_s_a|y__t46 vdd__t114 vdd__t43
+ sky130_fd_pr__pfet_01v8 L=0.15 W=0.84 AS=0.3948 AD=0.3948 PS=2.62 PD=2.62
* device instance $171 r0 *1 302.9,3.53 pfet
X$171 a|inv_mc_y|inv_mc_y_via|mc|tg_fbm_a|tg_fbm_a_via|y__t26
+ clkb|clkb_bridge1|clkb_bridge2|clkb_mid|clkb_w|ctrl|ctrlb|inv_clk_y|tg_d_ctrlb|tg_fbm_ctrl|tg_fbs_ctrlb|tg_s_ctrl|y__t56
+ a|b|m_east|m_west|nand_m_a|nand_m_a_ext_via|nand_m_a_ext_via2|nand_m_a_stub|tg_d_b|tg_d_b_via|tg_d_b_via2|tg_fbm_b|tg_fbm_b_alt_via|tg_fbm_b_alt_via2__t36
+ vdd__t42 sky130_fd_pr__pfet_01v8 L=0.15 W=0.84 AS=0.3948 AD=0.3948 PS=2.62
+ PD=2.62
* device instance $172 r0 *1 308.04,3.53 pfet
X$172 a|inv_mc_a|mb|mnab_y|mpa_y|mpb_y|nand_m_y|tg_s_a|y__t16
+ clkb|clkb_bridge1|clkb_bridge2|clkb_mid|clkb_w|ctrl|ctrlb|inv_clk_y|tg_d_ctrlb|tg_fbm_ctrl|tg_fbs_ctrlb|tg_s_ctrl|y__t46
+ a|b|inv_q_a|inv_q_a_via|s|tg_fbs_b|tg_fbs_b_via|tg_s_b|tg_s_b_via__t56
+ vdd__t41 sky130_fd_pr__pfet_01v8 L=0.15 W=0.84 AS=0.3948 AD=0.3948 PS=2.62
+ PD=2.62
* device instance $173 r0 *1 314.845,3.53 pfet
X$173
+ a|inv_q_y|inv_q_y_via|inv_q_y_via2|nand_s2_a|nand_s2_a_stub|nand_s2_a_via|nand_s2_a_via2|q|y__t16
+ a|b|inv_q_a|inv_q_a_via|s|tg_fbs_b|tg_fbs_b_via|tg_s_b|tg_s_b_via__t16
+ vdd__t113 vdd__t40 sky130_fd_pr__pfet_01v8 L=0.15 W=0.84 AS=0.3948 AD=0.3948
+ PS=2.62 PD=2.62
* device instance $174 r0 *1 327.33,3.53 pfet
X$174 a|mnab_y|mpa_y|mpb_y|nand_s2_y|qb|tg_fbs_a|y__t16 clk__t19
+ a|b|inv_q_a|inv_q_a_via|s|tg_fbs_b|tg_fbs_b_via|tg_s_b|tg_s_b_via__t46
+ vdd__t39 sky130_fd_pr__pfet_01v8 L=0.15 W=0.84 AS=0.3948 AD=0.3948 PS=2.62
+ PD=2.62
* device instance $175 r0 *1 5.775,27.375 pfet
X$175 a|g_y|mnab_y|mpa_y|mpb_y|n1|s1_a|y__t0 en1__t0
+ mpa_py|mpb_py|mph_py|py__t2 vddr1__t19 sky130_fd_pr__pfet_01v8 L=0.15 W=0.84
+ AS=0.3948 AD=0.3948 PS=2.62 PD=2.62
* device instance $176 r0 *1 7.065,27.375 pfet
X$176 mpa_py|mpb_py|mph_py|py__t1 a|g_a|rn1|ro|s4_y|y__t4
+ a|g_y|mnab_y|mpa_y|mpb_y|n1|s1_a|y__t3 vddr1__t20 sky130_fd_pr__pfet_01v8
+ L=0.15 W=0.84 AS=0.3948 AD=0.3948 PS=2.62 PD=2.62
* device instance $177 r0 *1 12.115,3.74 pfet
X$177 a|inv_mc_a|mb|mnab_y|mpa_y|mpb_y|nand_m_y|tg_s_a|y__t3 rst_n__t10
+ vdd__t142 vdd__t95 sky130_fd_pr__pfet_01v8 L=0.15 W=0.84 AS=0.3948 AD=0.3948
+ PS=2.62 PD=2.62
* device instance $178 r0 *1 13.405,3.74 pfet
X$178 vdd__t33
+ a|b|m_east|m_west|nand_m_a|nand_m_a_ext_via|nand_m_a_ext_via2|nand_m_a_stub|tg_d_b|tg_d_b_via|tg_d_b_via2|tg_fbm_b|tg_fbm_b_alt_via|tg_fbm_b_alt_via2__t1
+ a|inv_mc_a|mb|mnab_y|mpa_y|mpb_y|nand_m_y|tg_s_a|y__t6 vdd__t108
+ sky130_fd_pr__pfet_01v8 L=0.15 W=0.84 AS=0.3948 AD=0.3948 PS=2.62 PD=2.62
* device instance $179 r0 *1 15.075,27.375 pfet
X$179 a|n2|s1_y|s2_a|y__t12 a|g_y|mnab_y|mpa_y|mpb_y|n1|s1_a|y__t2 py__t1
+ vddr1__t18 sky130_fd_pr__pfet_01v8 L=0.15 W=0.84 AS=0.3948 AD=0.3948 PS=2.62
+ PD=2.62
* device instance $180 r0 *1 23.25,27.375 pfet
X$180 a|n3|s2_y|s3_a|y__t1 a|n2|s1_y|s2_a|y__t32 py__t12 vddr1__t17
+ sky130_fd_pr__pfet_01v8 L=0.15 W=0.84 AS=0.3948 AD=0.3948 PS=2.62 PD=2.62
* device instance $181 r0 *1 31.425,27.375 pfet
X$181 a|n4|s3_y|s4_a|y__t13 a|n3|s2_y|s3_a|y__t3 py__t13 vddr1__t15
+ sky130_fd_pr__pfet_01v8 L=0.15 W=0.84 AS=0.3948 AD=0.3948 PS=2.62 PD=2.62
* device instance $182 r0 *1 39.6,27.375 pfet
X$182 a|g_a|rn1|ro|s4_y|y__t1 a|n4|s3_y|s4_a|y__t33 py__t14 vddr1__t16
+ sky130_fd_pr__pfet_01v8 L=0.15 W=0.84 AS=0.3948 AD=0.3948 PS=2.62 PD=2.62
* device instance $183 r0 *1 42.975,3.74 pfet
X$183 a|mnab_y|mpa_y|mpb_y|nand_s2_y|qb|tg_fbs_a|y__t2 rst_n__t11 vdd__t145
+ vdd__t102 sky130_fd_pr__pfet_01v8 L=0.15 W=0.84 AS=0.3948 AD=0.3948 PS=2.62
+ PD=2.62
* device instance $184 r0 *1 44.265,3.74 pfet
X$184 vdd__t32
+ a|inv_q_y|inv_q_y_via|inv_q_y_via2|nand_s2_a|nand_s2_a_stub|nand_s2_a_via|nand_s2_a_via2|q|y__t22
+ a|mnab_y|mpa_y|mpb_y|nand_s2_y|qb|tg_fbs_a|y__t3 vdd__t103
+ sky130_fd_pr__pfet_01v8 L=0.15 W=0.84 AS=0.3948 AD=0.3948 PS=2.62 PD=2.62
* device instance $185 r0 *1 48.86,27.165 pfet
X$185 a|d|inva_a|mn12_g0|mp13_g0|ro1|ro1_esc|sr1_d_stub|tg_d_a|y__t3
+ a|g_a|rn1|ro|s4_y|y__t3 vdd__t111 vdd__t36 sky130_fd_pr__pfet_01v8 L=0.15
+ W=0.84 AS=0.3948 AD=0.3948 PS=2.62 PD=2.62
* device instance $186 r0 *1 61.075,27.375 pfet
X$186 a|g_y|mnab_y|mpa_y|mpb_y|n1|s1_a|y__t02 en2__t0
+ mpa_py|mpb_py|mph_py|py__t22 vddr2__t16 sky130_fd_pr__pfet_01v8 L=0.15 W=0.84
+ AS=0.3948 AD=0.3948 PS=2.62 PD=2.62
* device instance $187 r0 *1 62.365,27.375 pfet
X$187 mpa_py|mpb_py|mph_py|py__t12 a|g_a|rn2|ro|s4_y|y__t4
+ a|g_y|mnab_y|mpa_y|mpb_y|n1|s1_a|y__t32 vddr2__t17 sky130_fd_pr__pfet_01v8
+ L=0.15 W=0.84 AS=0.3948 AD=0.3948 PS=2.62 PD=2.62
* device instance $188 r0 *1 67.775,3.74 pfet
X$188 a|inv_mc_a|mb|mnab_y|mpa_y|mpb_y|nand_m_y|tg_s_a|y__t22 rst_n__t12
+ vdd__t147 vdd__t107 sky130_fd_pr__pfet_01v8 L=0.15 W=0.84 AS=0.3948 AD=0.3948
+ PS=2.62 PD=2.62
* device instance $189 r0 *1 69.065,3.74 pfet
X$189 vdd__t31
+ a|b|m_east|m_west|nand_m_a|nand_m_a_ext_via|nand_m_a_ext_via2|nand_m_a_stub|tg_d_b|tg_d_b_via|tg_d_b_via2|tg_fbm_b|tg_fbm_b_alt_via|tg_fbm_b_alt_via2__t02
+ a|inv_mc_a|mb|mnab_y|mpa_y|mpb_y|nand_m_y|tg_s_a|y__t52 vdd__t96
+ sky130_fd_pr__pfet_01v8 L=0.15 W=0.84 AS=0.3948 AD=0.3948 PS=2.62 PD=2.62
* device instance $190 r0 *1 70.375,27.375 pfet
X$190 a|n2|s1_y|s2_a|y__t1 a|g_y|mnab_y|mpa_y|mpb_y|n1|s1_a|y__t22 py__t15
+ vddr2__t18 sky130_fd_pr__pfet_01v8 L=0.15 W=0.84 AS=0.3948 AD=0.3948 PS=2.62
+ PD=2.62
* device instance $191 r0 *1 78.55,27.375 pfet
X$191 a|n3|s2_y|s3_a|y__t12 a|n2|s1_y|s2_a|y__t3 py__t16 vddr2__t19
+ sky130_fd_pr__pfet_01v8 L=0.15 W=0.84 AS=0.3948 AD=0.3948 PS=2.62 PD=2.62
* device instance $192 r0 *1 86.725,27.375 pfet
X$192 a|n4|s3_y|s4_a|y__t1 a|n3|s2_y|s3_a|y__t32 py__t17 vddr2__t20
+ sky130_fd_pr__pfet_01v8 L=0.15 W=0.84 AS=0.3948 AD=0.3948 PS=2.62 PD=2.62
* device instance $193 r0 *1 94.9,27.375 pfet
X$193 a|g_a|rn2|ro|s4_y|y__t1 a|n4|s3_y|s4_a|y__t3 py__t18 vddr2__t15
+ sky130_fd_pr__pfet_01v8 L=0.15 W=0.84 AS=0.3948 AD=0.3948 PS=2.62 PD=2.62
* device instance $194 r0 *1 98.635,3.74 pfet
X$194 a|mnab_y|mpa_y|mpb_y|nand_s2_y|qb|tg_fbs_a|y__t12 rst_n__t7 vdd__t134
+ vdd__t77 sky130_fd_pr__pfet_01v8 L=0.15 W=0.84 AS=0.3948 AD=0.3948 PS=2.62
+ PD=2.62
* device instance $195 r0 *1 99.925,3.74 pfet
X$195 vdd__t28
+ a|inv_q_y|inv_q_y_via|inv_q_y_via2|nand_s2_a|nand_s2_a_stub|nand_s2_a_via|nand_s2_a_via2|q|y__t23
+ a|mnab_y|mpa_y|mpb_y|nand_s2_y|qb|tg_fbs_a|y__t32 vdd__t76
+ sky130_fd_pr__pfet_01v8 L=0.15 W=0.84 AS=0.3948 AD=0.3948 PS=2.62 PD=2.62
* device instance $196 r0 *1 104.16,27.165 pfet
X$196 a|b|d|invb_a|mn12_g1|mp24_g0|ro2|ro2_esc|sr2_d_stub|tg_d_a|y__t3
+ a|g_a|rn2|ro|s4_y|y__t3 vdd__t109 vdd__t34 sky130_fd_pr__pfet_01v8 L=0.15
+ W=0.84 AS=0.3948 AD=0.3948 PS=2.62 PD=2.62
* device instance $197 r0 *1 116.375,27.375 pfet
X$197 a|g_y|mnab_y|mpa_y|mpb_y|n1|s1_a|y__t03 en3__t0
+ mpa_py|mpb_py|mph_py|py__t23 vddr3__t17 sky130_fd_pr__pfet_01v8 L=0.15 W=0.84
+ AS=0.3948 AD=0.3948 PS=2.62 PD=2.62
* device instance $198 r0 *1 117.665,27.375 pfet
X$198 mpa_py|mpb_py|mph_py|py__t13 a|g_a|rn3|ro|s4_y|y__t3
+ a|g_y|mnab_y|mpa_y|mpb_y|n1|s1_a|y__t33 vddr3__t16 sky130_fd_pr__pfet_01v8
+ L=0.15 W=0.84 AS=0.3948 AD=0.3948 PS=2.62 PD=2.62
* device instance $199 r0 *1 123.435,3.74 pfet
X$199 a|inv_mc_a|mb|mnab_y|mpa_y|mpb_y|nand_m_y|tg_s_a|y__t13 rst_n__t9
+ vdd__t141 vdd__t94 sky130_fd_pr__pfet_01v8 L=0.15 W=0.84 AS=0.3948 AD=0.3948
+ PS=2.62 PD=2.62
* device instance $200 r0 *1 124.725,3.74 pfet
X$200 vdd__t30
+ a|b|m_east|m_west|nand_m_a|nand_m_a_ext_via|nand_m_a_ext_via2|nand_m_a_stub|tg_d_b|tg_d_b_via|tg_d_b_via2|tg_fbm_b|tg_fbm_b_alt_via|tg_fbm_b_alt_via2__t03
+ a|inv_mc_a|mb|mnab_y|mpa_y|mpb_y|nand_m_y|tg_s_a|y__t53 vdd__t92
+ sky130_fd_pr__pfet_01v8 L=0.15 W=0.84 AS=0.3948 AD=0.3948 PS=2.62 PD=2.62
* device instance $201 r0 *1 125.675,27.375 pfet
X$201 a|n2|s1_y|s2_a|y__t13 a|g_y|mnab_y|mpa_y|mpb_y|n1|s1_a|y__t23 py__t19
+ vddr3__t15 sky130_fd_pr__pfet_01v8 L=0.15 W=0.84 AS=0.3948 AD=0.3948 PS=2.62
+ PD=2.62
* device instance $202 r0 *1 133.85,27.375 pfet
X$202 a|n3|s2_y|s3_a|y__t13 a|n2|s1_y|s2_a|y__t33 py__t110 vddr3__t18
+ sky130_fd_pr__pfet_01v8 L=0.15 W=0.84 AS=0.3948 AD=0.3948 PS=2.62 PD=2.62
* device instance $203 r0 *1 142.025,27.375 pfet
X$203 a|n4|s3_y|s4_a|y__t14 a|n3|s2_y|s3_a|y__t33 py__t111 vddr3__t20
+ sky130_fd_pr__pfet_01v8 L=0.15 W=0.84 AS=0.3948 AD=0.3948 PS=2.62 PD=2.62
* device instance $204 r0 *1 150.2,27.375 pfet
X$204 a|g_a|rn3|ro|s4_y|y__t1 a|n4|s3_y|s4_a|y__t34 py__t112 vddr3__t19
+ sky130_fd_pr__pfet_01v8 L=0.15 W=0.84 AS=0.3948 AD=0.3948 PS=2.62 PD=2.62
* device instance $205 r0 *1 154.295,3.74 pfet
X$205 a|mnab_y|mpa_y|mpb_y|nand_s2_y|qb|tg_fbs_a|y__t13 rst_n__t8 vdd__t140
+ vdd__t91 sky130_fd_pr__pfet_01v8 L=0.15 W=0.84 AS=0.3948 AD=0.3948 PS=2.62
+ PD=2.62
* device instance $206 r0 *1 155.585,3.74 pfet
X$206 vdd__t29
+ a|inv_q_y|inv_q_y_via|inv_q_y_via2|nand_s2_a|nand_s2_a_stub|nand_s2_a_via|nand_s2_a_via2|q|y__t24
+ a|mnab_y|mpa_y|mpb_y|nand_s2_y|qb|tg_fbs_a|y__t33 vdd__t88
+ sky130_fd_pr__pfet_01v8 L=0.15 W=0.84 AS=0.3948 AD=0.3948 PS=2.62 PD=2.62
* device instance $207 r0 *1 159.46,27.165 pfet
X$207
+ a|d|inva_a|mn12_g0|mp13_g0|ro3|ro3_esc_e|ro3_esc_w|ro3_hop|sr3_d_stub|tg_d_a|y__t3
+ a|g_a|rn3|ro|s4_y|y__t4 vdd__t126 vdd__t62 sky130_fd_pr__pfet_01v8 L=0.15
+ W=0.84 AS=0.3948 AD=0.3948 PS=2.62 PD=2.62
* device instance $208 r0 *1 171.675,27.375 pfet
X$208 a|g_y|mnab_y|mpa_y|mpb_y|n1|s1_a|y__t04 en4__t0
+ mpa_py|mpb_py|mph_py|py__t24 vddr4__t16 sky130_fd_pr__pfet_01v8 L=0.15 W=0.84
+ AS=0.3948 AD=0.3948 PS=2.62 PD=2.62
* device instance $209 r0 *1 172.965,27.375 pfet
X$209 mpa_py|mpb_py|mph_py|py__t14 a|g_a|rn4|ro|s4_y|y__t3
+ a|g_y|mnab_y|mpa_y|mpb_y|n1|s1_a|y__t34 vddr4__t15 sky130_fd_pr__pfet_01v8
+ L=0.15 W=0.84 AS=0.3948 AD=0.3948 PS=2.62 PD=2.62
* device instance $210 r0 *1 179.095,3.74 pfet
X$210 a|inv_mc_a|mb|mnab_y|mpa_y|mpb_y|nand_m_y|tg_s_a|y__t14 rst_n__t1
+ vdd__t112 vdd__t38 sky130_fd_pr__pfet_01v8 L=0.15 W=0.84 AS=0.3948 AD=0.3948
+ PS=2.62 PD=2.62
* device instance $211 r0 *1 180.385,3.74 pfet
X$211 vdd__t21
+ a|b|m_east|m_west|nand_m_a|nand_m_a_ext_via|nand_m_a_ext_via2|nand_m_a_stub|tg_d_b|tg_d_b_via|tg_d_b_via2|tg_fbm_b|tg_fbm_b_alt_via|tg_fbm_b_alt_via2__t04
+ a|inv_mc_a|mb|mnab_y|mpa_y|mpb_y|nand_m_y|tg_s_a|y__t54 vdd__t37
+ sky130_fd_pr__pfet_01v8 L=0.15 W=0.84 AS=0.3948 AD=0.3948 PS=2.62 PD=2.62
* device instance $212 r0 *1 180.975,27.375 pfet
X$212 a|n2|s1_y|s2_a|y__t14 a|g_y|mnab_y|mpa_y|mpb_y|n1|s1_a|y__t24 py__t113
+ vddr4__t17 sky130_fd_pr__pfet_01v8 L=0.15 W=0.84 AS=0.3948 AD=0.3948 PS=2.62
+ PD=2.62
* device instance $213 r0 *1 189.15,27.375 pfet
X$213 a|n3|s2_y|s3_a|y__t14 a|n2|s1_y|s2_a|y__t34 py__t114 vddr4__t20
+ sky130_fd_pr__pfet_01v8 L=0.15 W=0.84 AS=0.3948 AD=0.3948 PS=2.62 PD=2.62
* device instance $214 r0 *1 197.325,27.375 pfet
X$214 a|n4|s3_y|s4_a|y__t12 a|n3|s2_y|s3_a|y__t34 py__t115 vddr4__t19
+ sky130_fd_pr__pfet_01v8 L=0.15 W=0.84 AS=0.3948 AD=0.3948 PS=2.62 PD=2.62
* device instance $215 r0 *1 205.5,27.375 pfet
X$215 a|g_a|rn4|ro|s4_y|y__t1 a|n4|s3_y|s4_a|y__t32 py__t116 vddr4__t18
+ sky130_fd_pr__pfet_01v8 L=0.15 W=0.84 AS=0.3948 AD=0.3948 PS=2.62 PD=2.62
* device instance $216 r0 *1 209.955,3.74 pfet
X$216 a|mnab_y|mpa_y|mpb_y|nand_s2_y|qb|tg_fbs_a|y__t14 rst_n__t3 vdd__t119
+ vdd__t51 sky130_fd_pr__pfet_01v8 L=0.15 W=0.84 AS=0.3948 AD=0.3948 PS=2.62
+ PD=2.62
* device instance $217 r0 *1 211.245,3.74 pfet
X$217 vdd__t23
+ a|inv_q_y|inv_q_y_via|inv_q_y_via2|nand_s2_a|nand_s2_a_stub|nand_s2_a_via|nand_s2_a_via2|q|y__t2
+ a|mnab_y|mpa_y|mpb_y|nand_s2_y|qb|tg_fbs_a|y__t34 vdd__t50
+ sky130_fd_pr__pfet_01v8 L=0.15 W=0.84 AS=0.3948 AD=0.3948 PS=2.62 PD=2.62
* device instance $218 r0 *1 214.76,27.165 pfet
X$218 a|b|d|invb_a|mn12_g1|mp24_g0|ro4|ro4_esc|sr4_d_stub|tg_d_a|y__t4
+ a|g_a|rn4|ro|s4_y|y__t4 vdd__t118 vdd__t49 sky130_fd_pr__pfet_01v8 L=0.15
+ W=0.84 AS=0.3948 AD=0.3948 PS=2.62 PD=2.62
* device instance $219 r0 *1 234.755,3.74 pfet
X$219 a|inv_mc_a|mb|mnab_y|mpa_y|mpb_y|nand_m_y|tg_s_a|y__t15 rst_n__t2
+ vdd__t117 vdd__t48 sky130_fd_pr__pfet_01v8 L=0.15 W=0.84 AS=0.3948 AD=0.3948
+ PS=2.62 PD=2.62
* device instance $220 r0 *1 236.045,3.74 pfet
X$220 vdd__t22
+ a|b|m_east|m_west|nand_m_a|nand_m_a_ext_via|nand_m_a_ext_via2|nand_m_a_stub|tg_d_b|tg_d_b_via|tg_d_b_via2|tg_fbm_b|tg_fbm_b_alt_via|tg_fbm_b_alt_via2__t05
+ a|inv_mc_a|mb|mnab_y|mpa_y|mpb_y|nand_m_y|tg_s_a|y__t55 vdd__t47
+ sky130_fd_pr__pfet_01v8 L=0.15 W=0.84 AS=0.3948 AD=0.3948 PS=2.62 PD=2.62
* device instance $221 r0 *1 265.615,3.74 pfet
X$221 a|mnab_y|mpa_y|mpb_y|nand_s2_y|qb|tg_fbs_a|y__t15 rst_n__t4 vdd__t120
+ vdd__t52 sky130_fd_pr__pfet_01v8 L=0.15 W=0.84 AS=0.3948 AD=0.3948 PS=2.62
+ PD=2.62
* device instance $222 r0 *1 266.905,3.74 pfet
X$222 vdd__t24
+ a|inv_q_y|inv_q_y_via|inv_q_y_via2|nand_s2_a|nand_s2_a_stub|nand_s2_a_via|nand_s2_a_via2|q|y__t25
+ a|mnab_y|mpa_y|mpb_y|nand_s2_y|qb|tg_fbs_a|y__t35 vdd__t55
+ sky130_fd_pr__pfet_01v8 L=0.15 W=0.84 AS=0.3948 AD=0.3948 PS=2.62 PD=2.62
* device instance $223 r0 *1 290.415,3.74 pfet
X$223 a|inv_mc_a|mb|mnab_y|mpa_y|mpb_y|nand_m_y|tg_s_a|y__t26 rst_n__t5
+ vdd__t123 vdd__t57 sky130_fd_pr__pfet_01v8 L=0.15 W=0.84 AS=0.3948 AD=0.3948
+ PS=2.62 PD=2.62
* device instance $224 r0 *1 291.705,3.74 pfet
X$224 vdd__t25
+ a|b|m_east|m_west|nand_m_a|nand_m_a_ext_via|nand_m_a_ext_via2|nand_m_a_stub|tg_d_b|tg_d_b_via|tg_d_b_via2|tg_fbm_b|tg_fbm_b_alt_via|tg_fbm_b_alt_via2__t06
+ a|inv_mc_a|mb|mnab_y|mpa_y|mpb_y|nand_m_y|tg_s_a|y__t56 vdd__t59
+ sky130_fd_pr__pfet_01v8 L=0.15 W=0.84 AS=0.3948 AD=0.3948 PS=2.62 PD=2.62
* device instance $225 r0 *1 321.275,3.74 pfet
X$225 a|mnab_y|mpa_y|mpb_y|nand_s2_y|qb|tg_fbs_a|y__t26 rst_n__t6 vdd__t125
+ vdd__t60 sky130_fd_pr__pfet_01v8 L=0.15 W=0.84 AS=0.3948 AD=0.3948 PS=2.62
+ PD=2.62
* device instance $226 r0 *1 322.565,3.74 pfet
X$226 vdd__t26
+ a|inv_q_y|inv_q_y_via|inv_q_y_via2|nand_s2_a|nand_s2_a_stub|nand_s2_a_via|nand_s2_a_via2|q|y__t26
+ a|mnab_y|mpa_y|mpb_y|nand_s2_y|qb|tg_fbs_a|y__t36 vdd__t61
+ sky130_fd_pr__pfet_01v8 L=0.15 W=0.84 AS=0.3948 AD=0.3948 PS=2.62 PD=2.62
* device instance $227 r0 *1 3.61,27.375 pfet
X$227 mpa_py|mpb_py|mph_py|py__t0 vss__t6 vddr1__t1 vddr1__t2
+ sky130_fd_pr__pfet_01v8 L=2 W=0.42 AS=0.1764 AD=0.1764 PS=1.68 PD=1.68
* device instance $228 r0 *1 3.445,44.86 pfet
X$228 an|inva_y|mn34_g0|mp13_g1|y__t2
+ a|d|inva_a|mn12_g0|mp13_g0|ro1|ro1_esc|sr1_d_stub|tg_d_a|y__t6 vdd__t121
+ vdd__t53 sky130_fd_pr__pfet_01v8 L=0.15 W=0.84 AS=0.3948 AD=0.3948 PS=2.62
+ PD=2.62
* device instance $229 r0 *1 7.43,49.22 pfet
X$229 mid__t1 a|d|inva_a|mn12_g0|mp13_g0|ro1|ro1_esc|sr1_d_stub|tg_d_a|y__t0
+ vdd__t2 vdd__t3 sky130_fd_pr__pfet_01v8 L=0.15 W=1.68 AS=0.7896 AD=0.4368
+ PS=4.3 PD=2.2
* device instance $230 r0 *1 8.1,49.22 pfet
X$230 a|inva_a|mn12_g0|mp13_g0|t1|y__t0 an|inva_y|mn34_g0|mp13_g1|y__t0 mid__t0
+ vdd__t4 sky130_fd_pr__pfet_01v8 L=0.15 W=1.68 AS=0.4368 AD=0.7896 PS=2.2
+ PD=4.3
* device instance $231 r0 *1 12.91,27.375 pfet
X$231 py__t0 vss__t25 vddr1__t10 vddr1__t6 sky130_fd_pr__pfet_01v8 L=2 W=0.42
+ AS=0.1764 AD=0.1764 PS=1.68 PD=1.68
* device instance $232 r0 *1 14.58,49.22 pfet
X$232 mid__t2 bn|invb_y|mn34_g1|mp24_g1|y__t0 a|inva_a|mn12_g0|mp13_g0|t1|y__t2
+ vdd__t13 sky130_fd_pr__pfet_01v8 L=0.15 W=1.68 AS=0.7896 AD=0.4368 PS=4.3
+ PD=2.2
* device instance $233 r0 *1 15.25,49.22 pfet
X$233 vdd__t6 a|b|d|invb_a|mn12_g1|mp24_g0|ro2|ro2_esc|sr2_d_stub|tg_d_a|y__t0
+ mid__t3 vdd__t10 sky130_fd_pr__pfet_01v8 L=0.15 W=1.68 AS=0.4368 AD=0.7896
+ PS=2.2 PD=4.3
* device instance $234 r0 *1 21.085,27.375 pfet
X$234 py__t02 vss__t24 vddr1__t9 vddr1__t5 sky130_fd_pr__pfet_01v8 L=2 W=0.42
+ AS=0.1764 AD=0.1764 PS=1.68 PD=1.68
* device instance $235 r0 *1 21.62,44.86 pfet
X$235 bn|invb_y|mn34_g1|mp24_g1|y__t2
+ a|b|d|invb_a|mn12_g1|mp24_g0|ro2|ro2_esc|sr2_d_stub|tg_d_a|y__t6 vdd__t122
+ vdd__t56 sky130_fd_pr__pfet_01v8 L=0.15 W=0.84 AS=0.3948 AD=0.3948 PS=2.62
+ PD=2.62
* device instance $236 r0 *1 29.26,27.375 pfet
X$236 py__t03 vss__t23 vddr1__t8 vddr1__t4 sky130_fd_pr__pfet_01v8 L=2 W=0.42
+ AS=0.1764 AD=0.1764 PS=1.68 PD=1.68
* device instance $237 r0 *1 32.415,44.86 pfet
X$237 an|inva_y|mn34_g0|mp13_g1|y__t22
+ a|d|inva_a|mn12_g0|mp13_g0|ro3|ro3_esc_e|ro3_esc_w|ro3_hop|sr3_d_stub|tg_d_a|y__t6
+ vdd__t124 vdd__t58 sky130_fd_pr__pfet_01v8 L=0.15 W=0.84 AS=0.3948 AD=0.3948
+ PS=2.62 PD=2.62
* device instance $238 r0 *1 36.4,49.22 pfet
X$238 mid__t02
+ a|d|inva_a|mn12_g0|mp13_g0|ro3|ro3_esc_e|ro3_esc_w|ro3_hop|sr3_d_stub|tg_d_a|y__t0
+ vdd__t18 vdd__t14 sky130_fd_pr__pfet_01v8 L=0.15 W=1.68 AS=0.7896 AD=0.4368
+ PS=4.3 PD=2.2
* device instance $239 r0 *1 37.07,49.22 pfet
X$239 a|b|b3|invb_a|mn12_g1|mp24_g0|t2|y__t0 an|inva_y|mn34_g0|mp13_g1|y__t02
+ mid__t32 vdd__t12 sky130_fd_pr__pfet_01v8 L=0.15 W=1.68 AS=0.4368 AD=0.7896
+ PS=2.2 PD=4.3
* device instance $240 r0 *1 37.435,27.375 pfet
X$240 py__t04 vss__t22 vddr1__t7 vddr1__t3 sky130_fd_pr__pfet_01v8 L=2 W=0.42
+ AS=0.1764 AD=0.1764 PS=1.68 PD=1.68
* device instance $241 r0 *1 43.55,49.22 pfet
X$241 mid__t12 bn|invb_y|mn34_g1|mp24_g1|y__t02
+ a|b|b3|invb_a|mn12_g1|mp24_g0|t2|y__t2 vdd__t16 sky130_fd_pr__pfet_01v8
+ L=0.15 W=1.68 AS=0.7896 AD=0.4368 PS=4.3 PD=2.2
* device instance $242 r0 *1 44.22,49.22 pfet
X$242 vdd__t5 a|b|d|invb_a|mn12_g1|mp24_g0|ro4|ro4_esc|sr4_d_stub|tg_d_a|y__t0
+ mid__t22 vdd__t8 sky130_fd_pr__pfet_01v8 L=0.15 W=1.68 AS=0.4368 AD=0.7896
+ PS=2.2 PD=4.3
* device instance $243 r0 *1 50.59,44.86 pfet
X$243 bn|invb_y|mn34_g1|mp24_g1|y__t22
+ a|b|d|invb_a|mn12_g1|mp24_g0|ro4|ro4_esc|sr4_d_stub|tg_d_a|y__t6 vdd__t127
+ vdd__t63 sky130_fd_pr__pfet_01v8 L=0.15 W=0.84 AS=0.3948 AD=0.3948 PS=2.62
+ PD=2.62
* device instance $244 r0 *1 58.91,27.375 pfet
X$244 mpa_py|mpb_py|mph_py|py__t02 vss__t7 vddr2__t1 vddr2__t2
+ sky130_fd_pr__pfet_01v8 L=2 W=0.44 AS=0.1848 AD=0.1848 PS=1.72 PD=1.72
* device instance $245 r0 *1 61.385,44.86 pfet
X$245 an|inva_y|mn34_g0|mp13_g1|y__t23 a|inva_a|mn12_g0|mp13_g0|t1|y__t4
+ vdd__t128 vdd__t64 sky130_fd_pr__pfet_01v8 L=0.15 W=0.84 AS=0.3948 AD=0.3948
+ PS=2.62 PD=2.62
* device instance $246 r0 *1 65.37,49.22 pfet
X$246 mid__t13 a|inva_a|mn12_g0|mp13_g0|t1|y__t1 vdd__t19 vdd__t17
+ sky130_fd_pr__pfet_01v8 L=0.15 W=1.68 AS=0.7896 AD=0.4368 PS=4.3 PD=2.2
* device instance $247 r0 *1 66.04,49.22 pfet
X$247 a|d|sb_d_stub|tg_d_a|xo|xo_dip|xo_hop|xo_stub|y__t0
+ an|inva_y|mn34_g0|mp13_g1|y__t03 mid__t23 vdd__t9 sky130_fd_pr__pfet_01v8
+ L=0.15 W=1.68 AS=0.4368 AD=0.7896 PS=2.2 PD=4.3
* device instance $248 r0 *1 68.21,27.375 pfet
X$248 py__t05 vss__t20 vddr2__t9 vddr2__t5 sky130_fd_pr__pfet_01v8 L=2 W=0.44
+ AS=0.1848 AD=0.1848 PS=1.72 PD=1.72
* device instance $249 r0 *1 72.52,49.22 pfet
X$249 mid__t03 bn|invb_y|mn34_g1|mp24_g1|y__t03
+ a|d|sb_d_stub|tg_d_a|xo|xo_dip|xo_hop|xo_stub|y__t1 vdd__t15
+ sky130_fd_pr__pfet_01v8 L=0.15 W=1.68 AS=0.7896 AD=0.4368 PS=4.3 PD=2.2
* device instance $250 r0 *1 73.19,49.22 pfet
X$250 vdd__t7 a|b|b3|invb_a|mn12_g1|mp24_g0|t2|y__t1 mid__t33 vdd__t11
+ sky130_fd_pr__pfet_01v8 L=0.15 W=1.68 AS=0.4368 AD=0.7896 PS=2.2 PD=4.3
* device instance $251 r0 *1 76.385,27.375 pfet
X$251 py__t06 vss__t21 vddr2__t10 vddr2__t6 sky130_fd_pr__pfet_01v8 L=2 W=0.44
+ AS=0.1848 AD=0.1848 PS=1.72 PD=1.72
* device instance $252 r0 *1 79.56,44.86 pfet
X$252 bn|invb_y|mn34_g1|mp24_g1|y__t23 a|b|b3|invb_a|mn12_g1|mp24_g0|t2|y__t4
+ vdd__t110 vdd__t35 sky130_fd_pr__pfet_01v8 L=0.15 W=0.84 AS=0.3948 AD=0.3948
+ PS=2.62 PD=2.62
* device instance $253 r0 *1 84.56,27.375 pfet
X$253 py__t07 vss__t18 vddr2__t7 vddr2__t3 sky130_fd_pr__pfet_01v8 L=2 W=0.44
+ AS=0.1848 AD=0.1848 PS=1.72 PD=1.72
* device instance $254 r0 *1 92.735,27.375 pfet
X$254 py__t08 vss__t19 vddr2__t8 vddr2__t4 sky130_fd_pr__pfet_01v8 L=2 W=0.44
+ AS=0.1848 AD=0.1848 PS=1.72 PD=1.72
* device instance $255 r0 *1 114.21,27.375 pfet
X$255 mpa_py|mpb_py|mph_py|py__t03 vss__t8 vddr3__t1 vddr3__t2
+ sky130_fd_pr__pfet_01v8 L=2 W=0.46 AS=0.1932 AD=0.1932 PS=1.76 PD=1.76
* device instance $256 r0 *1 123.51,27.375 pfet
X$256 py__t09 vss__t17 vddr3__t10 vddr3__t6 sky130_fd_pr__pfet_01v8 L=2 W=0.46
+ AS=0.1932 AD=0.1932 PS=1.76 PD=1.76
* device instance $257 r0 *1 131.685,27.375 pfet
X$257 py__t010 vss__t16 vddr3__t9 vddr3__t5 sky130_fd_pr__pfet_01v8 L=2 W=0.46
+ AS=0.1932 AD=0.1932 PS=1.76 PD=1.76
* device instance $258 r0 *1 139.86,27.375 pfet
X$258 py__t011 vss__t15 vddr3__t8 vddr3__t4 sky130_fd_pr__pfet_01v8 L=2 W=0.46
+ AS=0.1932 AD=0.1932 PS=1.76 PD=1.76
* device instance $259 r0 *1 148.035,27.375 pfet
X$259 py__t012 vss__t14 vddr3__t7 vddr3__t3 sky130_fd_pr__pfet_01v8 L=2 W=0.46
+ AS=0.1932 AD=0.1932 PS=1.76 PD=1.76
* device instance $260 r0 *1 169.51,27.375 pfet
X$260 mpa_py|mpb_py|mph_py|py__t04 vss__t9 vddr4__t1 vddr4__t2
+ sky130_fd_pr__pfet_01v8 L=2 W=0.48 AS=0.2016 AD=0.2016 PS=1.8 PD=1.8
* device instance $261 r0 *1 178.81,27.375 pfet
X$261 py__t013 vss__t13 vddr4__t10 vddr4__t6 sky130_fd_pr__pfet_01v8 L=2 W=0.48
+ AS=0.2016 AD=0.2016 PS=1.8 PD=1.8
* device instance $262 r0 *1 186.985,27.375 pfet
X$262 py__t014 vss__t10 vddr4__t7 vddr4__t3 sky130_fd_pr__pfet_01v8 L=2 W=0.48
+ AS=0.2016 AD=0.2016 PS=1.8 PD=1.8
* device instance $263 r0 *1 195.16,27.375 pfet
X$263 py__t015 vss__t11 vddr4__t8 vddr4__t4 sky130_fd_pr__pfet_01v8 L=2 W=0.48
+ AS=0.2016 AD=0.2016 PS=1.8 PD=1.8
* device instance $264 r0 *1 203.335,27.375 pfet
X$264 py__t016 vss__t12 vddr4__t9 vddr4__t5 sky130_fd_pr__pfet_01v8 L=2 W=0.48
+ AS=0.2016 AD=0.2016 PS=1.8 PD=1.8
* device instance _136_t0 r0 *1 0,0
R_136_t0 \$136__t0 \$136 12.8
* device instance _136_t1 r0 *1 0,0
R_136_t1 \$136__t1 \$136 12.8
* device instance _136 r0 *1 0,0
C_136 \$136 vsubs 1.15618e-16
* device instance _138_t0 r0 *1 0,0
R_138_t0 \$138__t0 \$138 12.8
* device instance _138_t1 r0 *1 0,0
R_138_t1 \$138__t1 \$138 12.8
* device instance _138 r0 *1 0,0
C_138 \$138 vsubs 1.15618e-16
* device instance _139_t0 r0 *1 0,0
R_139_t0 \$139__t0 \$139 12.8
* device instance _139_t1 r0 *1 0,0
R_139_t1 \$139__t1 \$139 12.8
* device instance _139 r0 *1 0,0
C_139 \$139 vsubs 1.15618e-16
* device instance _141_t0 r0 *1 0,0
R_141_t0 \$141__t0 \$141 12.8
* device instance _141_t1 r0 *1 0,0
R_141_t1 \$141__t1 \$141 12.8
* device instance _141 r0 *1 0,0
C_141 \$141 vsubs 1.15618e-16
* device instance _142_t0 r0 *1 0,0
R_142_t0 \$142__t0 \$142 12.8
* device instance _142_t1 r0 *1 0,0
R_142_t1 \$142__t1 \$142 12.8
* device instance _142 r0 *1 0,0
C_142 \$142 vsubs 1.15618e-16
* device instance _145_t0 r0 *1 0,0
R_145_t0 \$145__t0 \$145 12.8
* device instance _145_t1 r0 *1 0,0
R_145_t1 \$145__t1 \$145 12.8
* device instance _145 r0 *1 0,0
C_145 \$145 vsubs 1.15618e-16
* device instance _17_t0 r0 *1 0,0
R_17_t0 \$17__t0 \$17 12.8
* device instance _17_t1 r0 *1 0,0
R_17_t1 \$17__t1 \$17 12.8
* device instance _17 r0 *1 0,0
C_17 \$17 vsubs 1.15618e-16
* device instance _20_t0 r0 *1 0,0
R_20_t0 \$20__t0 \$20 12.8
* device instance _20_t1 r0 *1 0,0
R_20_t1 \$20__t1 \$20 12.8
* device instance _20 r0 *1 0,0
C_20 \$20 vsubs 1.15618e-16
* device instance _22_t0 r0 *1 0,0
R_22_t0 \$22__t0 \$22 12.8
* device instance _22_t1 r0 *1 0,0
R_22_t1 \$22__t1 \$22 12.8
* device instance _22 r0 *1 0,0
C_22 \$22 vsubs 1.15618e-16
* device instance _25_t0 r0 *1 0,0
R_25_t0 \$25__t0 \$25 12.8
* device instance _25_t1 r0 *1 0,0
R_25_t1 \$25__t1 \$25 12.8
* device instance _25 r0 *1 0,0
C_25 \$25 vsubs 1.15618e-16
* device instance _28_t0 r0 *1 0,0
R_28_t0 \$28__t0 \$28 12.8
* device instance _28_t1 r0 *1 0,0
R_28_t1 \$28__t1 \$28 12.8
* device instance _28 r0 *1 0,0
C_28 \$28 vsubs 1.15618e-16
* device instance _31_t0 r0 *1 0,0
R_31_t0 \$31__t0 \$31 12.8
* device instance _31_t1 r0 *1 0,0
R_31_t1 \$31__t1 \$31 12.8
* device instance _31 r0 *1 0,0
C_31 \$31 vsubs 1.15618e-16
* device instance _34_t0 r0 *1 0,0
R_34_t0 \$34__t0 \$34 12.8
* device instance _34_t1 r0 *1 0,0
R_34_t1 \$34__t1 \$34 12.8
* device instance _34 r0 *1 0,0
C_34 \$34 vsubs 1.15618e-16
* device instance _38_t0 r0 *1 0,0
R_38_t0 \$38__t0 \$38 12.8
* device instance _38_t1 r0 *1 0,0
R_38_t1 \$38__t1 \$38 12.8
* device instance _38 r0 *1 0,0
C_38 \$38 vsubs 1.15618e-16
* device instance _41_t0 r0 *1 0,0
R_41_t0 \$41__t0 \$41 12.8
* device instance _41_t1 r0 *1 0,0
R_41_t1 \$41__t1 \$41 12.8
* device instance _41 r0 *1 0,0
C_41 \$41 vsubs 1.15618e-16
* device instance _44_t0 r0 *1 0,0
R_44_t0 \$44__t0 \$44 12.8
* device instance _44_t1 r0 *1 0,0
R_44_t1 \$44__t1 \$44 12.8
* device instance _44 r0 *1 0,0
C_44 \$44 vsubs 1.15618e-16
* device instance _47_t0 r0 *1 0,0
R_47_t0 \$47__t0 \$47 12.8
* device instance _47_t1 r0 *1 0,0
R_47_t1 \$47__t1 \$47 12.8
* device instance _47 r0 *1 0,0
C_47 \$47 vsubs 1.15618e-16
* device instance _50_t0 r0 *1 0,0
R_50_t0 \$50__t0 \$50 12.8
* device instance _50_t1 r0 *1 0,0
R_50_t1 \$50__t1 \$50 12.8
* device instance _50 r0 *1 0,0
C_50 \$50 vsubs 1.15618e-16
* device instance _75_t0 r0 *1 0,0
R_75_t0 \$75__t0 \$75 12.8
* device instance _75_t1 r0 *1 0,0
R_75_t1 \$75__t1 \$75 12.8
* device instance _75 r0 *1 0,0
C_75 \$75 vsubs 1.15618e-16
* device instance _81_t0 r0 *1 0,0
R_81_t0 \$81__t0 \$81 12.8
* device instance _81_t1 r0 *1 0,0
R_81_t1 \$81__t1 \$81 12.8
* device instance _81 r0 *1 0,0
C_81 \$81 vsubs 1.15618e-16
* device instance _87_t0 r0 *1 0,0
R_87_t0 \$87__t0 \$87 12.8
* device instance _87_t1 r0 *1 0,0
R_87_t1 \$87__t1 \$87 12.8
* device instance _87 r0 *1 0,0
C_87 \$87 vsubs 1.15618e-16
* device instance _93_t0 r0 *1 0,0
R_93_t0 \$93__t0 \$93 12.8
* device instance _93_t1 r0 *1 0,0
R_93_t1 \$93__t1 \$93 12.8
* device instance _93 r0 *1 0,0
C_93 \$93 vsubs 1.15618e-16
* device instance a_b_b3_invb_a_mn12_g1_mp24_g0_t2_y_t0 r0 *1 0,0
Ra_b_b3_invb_a_mn12_g1_mp24_g0_t2_y_t0 a|b|b3|invb_a|mn12_g1|mp24_g0|t2|y__t0
+ a|b|b3|invb_a|mn12_g1|mp24_g0|t2|y 365.147059317
* device instance a_b_b3_invb_a_mn12_g1_mp24_g0_t2_y_t1 r0 *1 0,0
Ra_b_b3_invb_a_mn12_g1_mp24_g0_t2_y_t1 a|b|b3|invb_a|mn12_g1|mp24_g0|t2|y__t1
+ a|b|b3|invb_a|mn12_g1|mp24_g0|t2|y 262.189506994
* device instance a_b_b3_invb_a_mn12_g1_mp24_g0_t2_y_t2 r0 *1 0,0
Ra_b_b3_invb_a_mn12_g1_mp24_g0_t2_y_t2 a|b|b3|invb_a|mn12_g1|mp24_g0|t2|y__t2
+ a|b|b3|invb_a|mn12_g1|mp24_g0|t2|y 261.640036466
* device instance a_b_b3_invb_a_mn12_g1_mp24_g0_t2_y_t3 r0 *1 0,0
Ra_b_b3_invb_a_mn12_g1_mp24_g0_t2_y_t3 a|b|b3|invb_a|mn12_g1|mp24_g0|t2|y__t3
+ a|b|b3|invb_a|mn12_g1|mp24_g0|t2|y 355.553016331
* device instance a_b_b3_invb_a_mn12_g1_mp24_g0_t2_y_t4 r0 *1 0,0
Ra_b_b3_invb_a_mn12_g1_mp24_g0_t2_y_t4 a|b|b3|invb_a|mn12_g1|mp24_g0|t2|y__t4
+ a|b|b3|invb_a|mn12_g1|mp24_g0|t2|y 353.565554468
* device instance a_b_b3_invb_a_mn12_g1_mp24_g0_t2_y_t5 r0 *1 0,0
Ra_b_b3_invb_a_mn12_g1_mp24_g0_t2_y_t5 a|b|b3|invb_a|mn12_g1|mp24_g0|t2|y__t5
+ a|b|b3|invb_a|mn12_g1|mp24_g0|t2|y 262.652066885
* device instance a_b_b3_invb_a_mn12_g1_mp24_g0_t2_y_t6 r0 *1 0,0
Ra_b_b3_invb_a_mn12_g1_mp24_g0_t2_y_t6 a|b|b3|invb_a|mn12_g1|mp24_g0|t2|y__t6
+ a|b|b3|invb_a|mn12_g1|mp24_g0|t2|y 255.751454042
* device instance a_b_b3_invb_a_mn12_g1_mp24_g0_t2_y_t7 r0 *1 0,0
Ra_b_b3_invb_a_mn12_g1_mp24_g0_t2_y_t7 a|b|b3|invb_a|mn12_g1|mp24_g0|t2|y__t7
+ a|b|b3|invb_a|mn12_g1|mp24_g0|t2|y 368.408605498
* device instance a_b_b3_invb_a_mn12_g1_mp24_g0_t2_y r0 *1 0,0
Ca_b_b3_invb_a_mn12_g1_mp24_g0_t2_y a|b|b3|invb_a|mn12_g1|mp24_g0|t2|y vsubs
+ 9.920674e-15
* device instance a_b_d_invb_a_mn12_g1_mp24_g0_ro2_ro2_esc_sr2_d_stub_tg_d_a_y_t0 r0 *1 0,0
Ra_b_d_invb_a_mn12_g1_mp24_g0_ro2_ro2_esc_sr2_d_stub_tg_d_a_y_t0
+ a|b|d|invb_a|mn12_g1|mp24_g0|ro2|ro2_esc|sr2_d_stub|tg_d_a|y__t0
+ a|b|d|invb_a|mn12_g1|mp24_g0|ro2|ro2_esc|sr2_d_stub|tg_d_a|y 216.494321684
* device instance a_b_d_invb_a_mn12_g1_mp24_g0_ro2_ro2_esc_sr2_d_stub_tg_d_a_y_t1 r0 *1 0,0
Ra_b_d_invb_a_mn12_g1_mp24_g0_ro2_ro2_esc_sr2_d_stub_tg_d_a_y_t1
+ a|b|d|invb_a|mn12_g1|mp24_g0|ro2|ro2_esc|sr2_d_stub|tg_d_a|y__t1
+ a|b|d|invb_a|mn12_g1|mp24_g0|ro2|ro2_esc|sr2_d_stub|tg_d_a|y 320.249896298
* device instance a_b_d_invb_a_mn12_g1_mp24_g0_ro2_ro2_esc_sr2_d_stub_tg_d_a_y_t2 r0 *1 0,0
Ra_b_d_invb_a_mn12_g1_mp24_g0_ro2_ro2_esc_sr2_d_stub_tg_d_a_y_t2
+ a|b|d|invb_a|mn12_g1|mp24_g0|ro2|ro2_esc|sr2_d_stub|tg_d_a|y__t2
+ a|b|d|invb_a|mn12_g1|mp24_g0|ro2|ro2_esc|sr2_d_stub|tg_d_a|y 85.6658729142
* device instance a_b_d_invb_a_mn12_g1_mp24_g0_ro2_ro2_esc_sr2_d_stub_tg_d_a_y_t3 r0 *1 0,0
Ra_b_d_invb_a_mn12_g1_mp24_g0_ro2_ro2_esc_sr2_d_stub_tg_d_a_y_t3
+ a|b|d|invb_a|mn12_g1|mp24_g0|ro2|ro2_esc|sr2_d_stub|tg_d_a|y__t3
+ a|b|d|invb_a|mn12_g1|mp24_g0|ro2|ro2_esc|sr2_d_stub|tg_d_a|y 84.3381163958
* device instance a_b_d_invb_a_mn12_g1_mp24_g0_ro2_ro2_esc_sr2_d_stub_tg_d_a_y_t4 r0 *1 0,0
Ra_b_d_invb_a_mn12_g1_mp24_g0_ro2_ro2_esc_sr2_d_stub_tg_d_a_y_t4
+ a|b|d|invb_a|mn12_g1|mp24_g0|ro2|ro2_esc|sr2_d_stub|tg_d_a|y__t4
+ a|b|d|invb_a|mn12_g1|mp24_g0|ro2|ro2_esc|sr2_d_stub|tg_d_a|y 317.275632425
* device instance a_b_d_invb_a_mn12_g1_mp24_g0_ro2_ro2_esc_sr2_d_stub_tg_d_a_y_t5 r0 *1 0,0
Ra_b_d_invb_a_mn12_g1_mp24_g0_ro2_ro2_esc_sr2_d_stub_tg_d_a_y_t5
+ a|b|d|invb_a|mn12_g1|mp24_g0|ro2|ro2_esc|sr2_d_stub|tg_d_a|y__t5
+ a|b|d|invb_a|mn12_g1|mp24_g0|ro2|ro2_esc|sr2_d_stub|tg_d_a|y 189.781520613
* device instance a_b_d_invb_a_mn12_g1_mp24_g0_ro2_ro2_esc_sr2_d_stub_tg_d_a_y_t6 r0 *1 0,0
Ra_b_d_invb_a_mn12_g1_mp24_g0_ro2_ro2_esc_sr2_d_stub_tg_d_a_y_t6
+ a|b|d|invb_a|mn12_g1|mp24_g0|ro2|ro2_esc|sr2_d_stub|tg_d_a|y__t6
+ a|b|d|invb_a|mn12_g1|mp24_g0|ro2|ro2_esc|sr2_d_stub|tg_d_a|y 192.462793663
* device instance a_b_d_invb_a_mn12_g1_mp24_g0_ro2_ro2_esc_sr2_d_stub_tg_d_a_y_t7 r0 *1 0,0
Ra_b_d_invb_a_mn12_g1_mp24_g0_ro2_ro2_esc_sr2_d_stub_tg_d_a_y_t7
+ a|b|d|invb_a|mn12_g1|mp24_g0|ro2|ro2_esc|sr2_d_stub|tg_d_a|y__t7
+ a|b|d|invb_a|mn12_g1|mp24_g0|ro2|ro2_esc|sr2_d_stub|tg_d_a|y 208.080146007
* device instance a_b_d_invb_a_mn12_g1_mp24_g0_ro2_ro2_esc_sr2_d_stub_tg_d_a_y r0 *1 0,0
Ca_b_d_invb_a_mn12_g1_mp24_g0_ro2_ro2_esc_sr2_d_stub_tg_d_a_y
+ a|b|d|invb_a|mn12_g1|mp24_g0|ro2|ro2_esc|sr2_d_stub|tg_d_a|y vsubs
+ 3.0572758e-14
* device instance a_b_d_invb_a_mn12_g1_mp24_g0_ro4_ro4_esc_sr4_d_stub_tg_d_a_y_t0 r0 *1 0,0
Ra_b_d_invb_a_mn12_g1_mp24_g0_ro4_ro4_esc_sr4_d_stub_tg_d_a_y_t0
+ a|b|d|invb_a|mn12_g1|mp24_g0|ro4|ro4_esc|sr4_d_stub|tg_d_a|y__t0
+ a|b|d|invb_a|mn12_g1|mp24_g0|ro4|ro4_esc|sr4_d_stub|tg_d_a|y 205.723925466
* device instance a_b_d_invb_a_mn12_g1_mp24_g0_ro4_ro4_esc_sr4_d_stub_tg_d_a_y_t1 r0 *1 0,0
Ra_b_d_invb_a_mn12_g1_mp24_g0_ro4_ro4_esc_sr4_d_stub_tg_d_a_y_t1
+ a|b|d|invb_a|mn12_g1|mp24_g0|ro4|ro4_esc|sr4_d_stub|tg_d_a|y__t1
+ a|b|d|invb_a|mn12_g1|mp24_g0|ro4|ro4_esc|sr4_d_stub|tg_d_a|y 129.163840733
* device instance a_b_d_invb_a_mn12_g1_mp24_g0_ro4_ro4_esc_sr4_d_stub_tg_d_a_y_t2 r0 *1 0,0
Ra_b_d_invb_a_mn12_g1_mp24_g0_ro4_ro4_esc_sr4_d_stub_tg_d_a_y_t2
+ a|b|d|invb_a|mn12_g1|mp24_g0|ro4|ro4_esc|sr4_d_stub|tg_d_a|y__t2
+ a|b|d|invb_a|mn12_g1|mp24_g0|ro4|ro4_esc|sr4_d_stub|tg_d_a|y 268.066515532
* device instance a_b_d_invb_a_mn12_g1_mp24_g0_ro4_ro4_esc_sr4_d_stub_tg_d_a_y_t3 r0 *1 0,0
Ra_b_d_invb_a_mn12_g1_mp24_g0_ro4_ro4_esc_sr4_d_stub_tg_d_a_y_t3
+ a|b|d|invb_a|mn12_g1|mp24_g0|ro4|ro4_esc|sr4_d_stub|tg_d_a|y__t3
+ a|b|d|invb_a|mn12_g1|mp24_g0|ro4|ro4_esc|sr4_d_stub|tg_d_a|y 266.814463552
* device instance a_b_d_invb_a_mn12_g1_mp24_g0_ro4_ro4_esc_sr4_d_stub_tg_d_a_y_t4 r0 *1 0,0
Ra_b_d_invb_a_mn12_g1_mp24_g0_ro4_ro4_esc_sr4_d_stub_tg_d_a_y_t4
+ a|b|d|invb_a|mn12_g1|mp24_g0|ro4|ro4_esc|sr4_d_stub|tg_d_a|y__t4
+ a|b|d|invb_a|mn12_g1|mp24_g0|ro4|ro4_esc|sr4_d_stub|tg_d_a|y 128.854861846
* device instance a_b_d_invb_a_mn12_g1_mp24_g0_ro4_ro4_esc_sr4_d_stub_tg_d_a_y_t5 r0 *1 0,0
Ra_b_d_invb_a_mn12_g1_mp24_g0_ro4_ro4_esc_sr4_d_stub_tg_d_a_y_t5
+ a|b|d|invb_a|mn12_g1|mp24_g0|ro4|ro4_esc|sr4_d_stub|tg_d_a|y__t5
+ a|b|d|invb_a|mn12_g1|mp24_g0|ro4|ro4_esc|sr4_d_stub|tg_d_a|y 191.117467432
* device instance a_b_d_invb_a_mn12_g1_mp24_g0_ro4_ro4_esc_sr4_d_stub_tg_d_a_y_t6 r0 *1 0,0
Ra_b_d_invb_a_mn12_g1_mp24_g0_ro4_ro4_esc_sr4_d_stub_tg_d_a_y_t6
+ a|b|d|invb_a|mn12_g1|mp24_g0|ro4|ro4_esc|sr4_d_stub|tg_d_a|y__t6
+ a|b|d|invb_a|mn12_g1|mp24_g0|ro4|ro4_esc|sr4_d_stub|tg_d_a|y 192.062141784
* device instance a_b_d_invb_a_mn12_g1_mp24_g0_ro4_ro4_esc_sr4_d_stub_tg_d_a_y_t7 r0 *1 0,0
Ra_b_d_invb_a_mn12_g1_mp24_g0_ro4_ro4_esc_sr4_d_stub_tg_d_a_y_t7
+ a|b|d|invb_a|mn12_g1|mp24_g0|ro4|ro4_esc|sr4_d_stub|tg_d_a|y__t7
+ a|b|d|invb_a|mn12_g1|mp24_g0|ro4|ro4_esc|sr4_d_stub|tg_d_a|y 202.481983655
* device instance a_b_d_invb_a_mn12_g1_mp24_g0_ro4_ro4_esc_sr4_d_stub_tg_d_a_y r0 *1 0,0
Ca_b_d_invb_a_mn12_g1_mp24_g0_ro4_ro4_esc_sr4_d_stub_tg_d_a_y
+ a|b|d|invb_a|mn12_g1|mp24_g0|ro4|ro4_esc|sr4_d_stub|tg_d_a|y vsubs
+ 2.7927101e-14
* device instance a_b_inv_q_a_inv_q_a_via_s_tg_fbs_b_tg_fbs_b_via_tg_s_b_tg_s_b_via_t0 r0 *1 0,0
Ra_b_inv_q_a_inv_q_a_via_s_tg_fbs_b_tg_fbs_b_via_tg_s_b_tg_s_b_via_t0
+ a|b|inv_q_a|inv_q_a_via|s|tg_fbs_b|tg_fbs_b_via|tg_s_b|tg_s_b_via__t0
+ a|b|inv_q_a|inv_q_a_via|s|tg_fbs_b|tg_fbs_b_via|tg_s_b|tg_s_b_via
+ 58.0186433859
* device instance a_b_inv_q_a_inv_q_a_via_s_tg_fbs_b_tg_fbs_b_via_tg_s_b_tg_s_b_via_t1 r0 *1 0,0
Ra_b_inv_q_a_inv_q_a_via_s_tg_fbs_b_tg_fbs_b_via_tg_s_b_tg_s_b_via_t1
+ a|b|inv_q_a|inv_q_a_via|s|tg_fbs_b|tg_fbs_b_via|tg_s_b|tg_s_b_via__t1
+ a|b|inv_q_a|inv_q_a_via|s|tg_fbs_b|tg_fbs_b_via|tg_s_b|tg_s_b_via
+ 58.0186433859
* device instance a_b_inv_q_a_inv_q_a_via_s_tg_fbs_b_tg_fbs_b_via_tg_s_b_tg_s_b_via_t2 r0 *1 0,0
Ra_b_inv_q_a_inv_q_a_via_s_tg_fbs_b_tg_fbs_b_via_tg_s_b_tg_s_b_via_t2
+ a|b|inv_q_a|inv_q_a_via|s|tg_fbs_b|tg_fbs_b_via|tg_s_b|tg_s_b_via__t2
+ a|b|inv_q_a|inv_q_a_via|s|tg_fbs_b|tg_fbs_b_via|tg_s_b|tg_s_b_via
+ 204.040461511
* device instance a_b_inv_q_a_inv_q_a_via_s_tg_fbs_b_tg_fbs_b_via_tg_s_b_tg_s_b_via_t3 r0 *1 0,0
Ra_b_inv_q_a_inv_q_a_via_s_tg_fbs_b_tg_fbs_b_via_tg_s_b_tg_s_b_via_t3
+ a|b|inv_q_a|inv_q_a_via|s|tg_fbs_b|tg_fbs_b_via|tg_s_b|tg_s_b_via__t3
+ a|b|inv_q_a|inv_q_a_via|s|tg_fbs_b|tg_fbs_b_via|tg_s_b|tg_s_b_via
+ 247.027895104
* device instance a_b_inv_q_a_inv_q_a_via_s_tg_fbs_b_tg_fbs_b_via_tg_s_b_tg_s_b_via_t4 r0 *1 0,0
Ra_b_inv_q_a_inv_q_a_via_s_tg_fbs_b_tg_fbs_b_via_tg_s_b_tg_s_b_via_t4
+ a|b|inv_q_a|inv_q_a_via|s|tg_fbs_b|tg_fbs_b_via|tg_s_b|tg_s_b_via__t4
+ a|b|inv_q_a|inv_q_a_via|s|tg_fbs_b|tg_fbs_b_via|tg_s_b|tg_s_b_via
+ 204.040461511
* device instance a_b_inv_q_a_inv_q_a_via_s_tg_fbs_b_tg_fbs_b_via_tg_s_b_tg_s_b_via_t5 r0 *1 0,0
Ra_b_inv_q_a_inv_q_a_via_s_tg_fbs_b_tg_fbs_b_via_tg_s_b_tg_s_b_via_t5
+ a|b|inv_q_a|inv_q_a_via|s|tg_fbs_b|tg_fbs_b_via|tg_s_b|tg_s_b_via__t5
+ a|b|inv_q_a|inv_q_a_via|s|tg_fbs_b|tg_fbs_b_via|tg_s_b|tg_s_b_via
+ 247.027895104
* device instance a_b_inv_q_a_inv_q_a_via_s_tg_fbs_b_tg_fbs_b_via_tg_s_b_tg_s_b_via r0 *1 0,0
Ca_b_inv_q_a_inv_q_a_via_s_tg_fbs_b_tg_fbs_b_via_tg_s_b_tg_s_b_via
+ a|b|inv_q_a|inv_q_a_via|s|tg_fbs_b|tg_fbs_b_via|tg_s_b|tg_s_b_via vsubs
+ 3.84792e-15
* device instance a_b_inv_q_a_inv_q_a_via_s_tg_fbs_b_tg_fbs_b_via_tg_s_b_tg_s_b_via_dup1_t0 r0 *1 0,0
Ra_b_inv_q_a_inv_q_a_via_s_tg_fbs_b_tg_fbs_b_via_tg_s_b_tg_s_b_via_dup1_t0
+ a|b|inv_q_a|inv_q_a_via|s|tg_fbs_b|tg_fbs_b_via|tg_s_b|tg_s_b_via__t02
+ a|b|inv_q_a|inv_q_a_via|s|tg_fbs_b|tg_fbs_b_via|tg_s_b|tg_s_b_via$1
+ 58.0186433859
* device instance a_b_inv_q_a_inv_q_a_via_s_tg_fbs_b_tg_fbs_b_via_tg_s_b_tg_s_b_via_dup1_t1 r0 *1 0,0
Ra_b_inv_q_a_inv_q_a_via_s_tg_fbs_b_tg_fbs_b_via_tg_s_b_tg_s_b_via_dup1_t1
+ a|b|inv_q_a|inv_q_a_via|s|tg_fbs_b|tg_fbs_b_via|tg_s_b|tg_s_b_via__t12
+ a|b|inv_q_a|inv_q_a_via|s|tg_fbs_b|tg_fbs_b_via|tg_s_b|tg_s_b_via$1
+ 58.0186433859
* device instance a_b_inv_q_a_inv_q_a_via_s_tg_fbs_b_tg_fbs_b_via_tg_s_b_tg_s_b_via_dup1_t2 r0 *1 0,0
Ra_b_inv_q_a_inv_q_a_via_s_tg_fbs_b_tg_fbs_b_via_tg_s_b_tg_s_b_via_dup1_t2
+ a|b|inv_q_a|inv_q_a_via|s|tg_fbs_b|tg_fbs_b_via|tg_s_b|tg_s_b_via__t22
+ a|b|inv_q_a|inv_q_a_via|s|tg_fbs_b|tg_fbs_b_via|tg_s_b|tg_s_b_via$1
+ 247.027895104
* device instance a_b_inv_q_a_inv_q_a_via_s_tg_fbs_b_tg_fbs_b_via_tg_s_b_tg_s_b_via_dup1_t3 r0 *1 0,0
Ra_b_inv_q_a_inv_q_a_via_s_tg_fbs_b_tg_fbs_b_via_tg_s_b_tg_s_b_via_dup1_t3
+ a|b|inv_q_a|inv_q_a_via|s|tg_fbs_b|tg_fbs_b_via|tg_s_b|tg_s_b_via__t32
+ a|b|inv_q_a|inv_q_a_via|s|tg_fbs_b|tg_fbs_b_via|tg_s_b|tg_s_b_via$1
+ 204.040461511
* device instance a_b_inv_q_a_inv_q_a_via_s_tg_fbs_b_tg_fbs_b_via_tg_s_b_tg_s_b_via_dup1_t4 r0 *1 0,0
Ra_b_inv_q_a_inv_q_a_via_s_tg_fbs_b_tg_fbs_b_via_tg_s_b_tg_s_b_via_dup1_t4
+ a|b|inv_q_a|inv_q_a_via|s|tg_fbs_b|tg_fbs_b_via|tg_s_b|tg_s_b_via__t42
+ a|b|inv_q_a|inv_q_a_via|s|tg_fbs_b|tg_fbs_b_via|tg_s_b|tg_s_b_via$1
+ 247.027895104
* device instance a_b_inv_q_a_inv_q_a_via_s_tg_fbs_b_tg_fbs_b_via_tg_s_b_tg_s_b_via_dup1_t5 r0 *1 0,0
Ra_b_inv_q_a_inv_q_a_via_s_tg_fbs_b_tg_fbs_b_via_tg_s_b_tg_s_b_via_dup1_t5
+ a|b|inv_q_a|inv_q_a_via|s|tg_fbs_b|tg_fbs_b_via|tg_s_b|tg_s_b_via__t52
+ a|b|inv_q_a|inv_q_a_via|s|tg_fbs_b|tg_fbs_b_via|tg_s_b|tg_s_b_via$1
+ 204.040461511
* device instance a_b_inv_q_a_inv_q_a_via_s_tg_fbs_b_tg_fbs_b_via_tg_s_b_tg_s_b_via_dup1 r0 *1 0,0
Ca_b_inv_q_a_inv_q_a_via_s_tg_fbs_b_tg_fbs_b_via_tg_s_b_tg_s_b_via_dup1
+ a|b|inv_q_a|inv_q_a_via|s|tg_fbs_b|tg_fbs_b_via|tg_s_b|tg_s_b_via$1 vsubs
+ 3.84792e-15
* device instance a_b_inv_q_a_inv_q_a_via_s_tg_fbs_b_tg_fbs_b_via_tg_s_b_tg_s_b_via_dup2_t0 r0 *1 0,0
Ra_b_inv_q_a_inv_q_a_via_s_tg_fbs_b_tg_fbs_b_via_tg_s_b_tg_s_b_via_dup2_t0
+ a|b|inv_q_a|inv_q_a_via|s|tg_fbs_b|tg_fbs_b_via|tg_s_b|tg_s_b_via__t03
+ a|b|inv_q_a|inv_q_a_via|s|tg_fbs_b|tg_fbs_b_via|tg_s_b|tg_s_b_via$2
+ 58.0186433859
* device instance a_b_inv_q_a_inv_q_a_via_s_tg_fbs_b_tg_fbs_b_via_tg_s_b_tg_s_b_via_dup2_t1 r0 *1 0,0
Ra_b_inv_q_a_inv_q_a_via_s_tg_fbs_b_tg_fbs_b_via_tg_s_b_tg_s_b_via_dup2_t1
+ a|b|inv_q_a|inv_q_a_via|s|tg_fbs_b|tg_fbs_b_via|tg_s_b|tg_s_b_via__t13
+ a|b|inv_q_a|inv_q_a_via|s|tg_fbs_b|tg_fbs_b_via|tg_s_b|tg_s_b_via$2
+ 58.0186433859
* device instance a_b_inv_q_a_inv_q_a_via_s_tg_fbs_b_tg_fbs_b_via_tg_s_b_tg_s_b_via_dup2_t2 r0 *1 0,0
Ra_b_inv_q_a_inv_q_a_via_s_tg_fbs_b_tg_fbs_b_via_tg_s_b_tg_s_b_via_dup2_t2
+ a|b|inv_q_a|inv_q_a_via|s|tg_fbs_b|tg_fbs_b_via|tg_s_b|tg_s_b_via__t23
+ a|b|inv_q_a|inv_q_a_via|s|tg_fbs_b|tg_fbs_b_via|tg_s_b|tg_s_b_via$2
+ 247.027895104
* device instance a_b_inv_q_a_inv_q_a_via_s_tg_fbs_b_tg_fbs_b_via_tg_s_b_tg_s_b_via_dup2_t3 r0 *1 0,0
Ra_b_inv_q_a_inv_q_a_via_s_tg_fbs_b_tg_fbs_b_via_tg_s_b_tg_s_b_via_dup2_t3
+ a|b|inv_q_a|inv_q_a_via|s|tg_fbs_b|tg_fbs_b_via|tg_s_b|tg_s_b_via__t33
+ a|b|inv_q_a|inv_q_a_via|s|tg_fbs_b|tg_fbs_b_via|tg_s_b|tg_s_b_via$2
+ 204.040461511
* device instance a_b_inv_q_a_inv_q_a_via_s_tg_fbs_b_tg_fbs_b_via_tg_s_b_tg_s_b_via_dup2_t4 r0 *1 0,0
Ra_b_inv_q_a_inv_q_a_via_s_tg_fbs_b_tg_fbs_b_via_tg_s_b_tg_s_b_via_dup2_t4
+ a|b|inv_q_a|inv_q_a_via|s|tg_fbs_b|tg_fbs_b_via|tg_s_b|tg_s_b_via__t43
+ a|b|inv_q_a|inv_q_a_via|s|tg_fbs_b|tg_fbs_b_via|tg_s_b|tg_s_b_via$2
+ 247.027895104
* device instance a_b_inv_q_a_inv_q_a_via_s_tg_fbs_b_tg_fbs_b_via_tg_s_b_tg_s_b_via_dup2_t5 r0 *1 0,0
Ra_b_inv_q_a_inv_q_a_via_s_tg_fbs_b_tg_fbs_b_via_tg_s_b_tg_s_b_via_dup2_t5
+ a|b|inv_q_a|inv_q_a_via|s|tg_fbs_b|tg_fbs_b_via|tg_s_b|tg_s_b_via__t53
+ a|b|inv_q_a|inv_q_a_via|s|tg_fbs_b|tg_fbs_b_via|tg_s_b|tg_s_b_via$2
+ 204.040461511
* device instance a_b_inv_q_a_inv_q_a_via_s_tg_fbs_b_tg_fbs_b_via_tg_s_b_tg_s_b_via_dup2 r0 *1 0,0
Ca_b_inv_q_a_inv_q_a_via_s_tg_fbs_b_tg_fbs_b_via_tg_s_b_tg_s_b_via_dup2
+ a|b|inv_q_a|inv_q_a_via|s|tg_fbs_b|tg_fbs_b_via|tg_s_b|tg_s_b_via$2 vsubs
+ 3.84792e-15
* device instance a_b_inv_q_a_inv_q_a_via_s_tg_fbs_b_tg_fbs_b_via_tg_s_b_tg_s_b_via_dup3_t0 r0 *1 0,0
Ra_b_inv_q_a_inv_q_a_via_s_tg_fbs_b_tg_fbs_b_via_tg_s_b_tg_s_b_via_dup3_t0
+ a|b|inv_q_a|inv_q_a_via|s|tg_fbs_b|tg_fbs_b_via|tg_s_b|tg_s_b_via__t04
+ a|b|inv_q_a|inv_q_a_via|s|tg_fbs_b|tg_fbs_b_via|tg_s_b|tg_s_b_via$3
+ 58.0186433859
* device instance a_b_inv_q_a_inv_q_a_via_s_tg_fbs_b_tg_fbs_b_via_tg_s_b_tg_s_b_via_dup3_t1 r0 *1 0,0
Ra_b_inv_q_a_inv_q_a_via_s_tg_fbs_b_tg_fbs_b_via_tg_s_b_tg_s_b_via_dup3_t1
+ a|b|inv_q_a|inv_q_a_via|s|tg_fbs_b|tg_fbs_b_via|tg_s_b|tg_s_b_via__t14
+ a|b|inv_q_a|inv_q_a_via|s|tg_fbs_b|tg_fbs_b_via|tg_s_b|tg_s_b_via$3
+ 58.0186433859
* device instance a_b_inv_q_a_inv_q_a_via_s_tg_fbs_b_tg_fbs_b_via_tg_s_b_tg_s_b_via_dup3_t2 r0 *1 0,0
Ra_b_inv_q_a_inv_q_a_via_s_tg_fbs_b_tg_fbs_b_via_tg_s_b_tg_s_b_via_dup3_t2
+ a|b|inv_q_a|inv_q_a_via|s|tg_fbs_b|tg_fbs_b_via|tg_s_b|tg_s_b_via__t24
+ a|b|inv_q_a|inv_q_a_via|s|tg_fbs_b|tg_fbs_b_via|tg_s_b|tg_s_b_via$3
+ 247.027895104
* device instance a_b_inv_q_a_inv_q_a_via_s_tg_fbs_b_tg_fbs_b_via_tg_s_b_tg_s_b_via_dup3_t3 r0 *1 0,0
Ra_b_inv_q_a_inv_q_a_via_s_tg_fbs_b_tg_fbs_b_via_tg_s_b_tg_s_b_via_dup3_t3
+ a|b|inv_q_a|inv_q_a_via|s|tg_fbs_b|tg_fbs_b_via|tg_s_b|tg_s_b_via__t34
+ a|b|inv_q_a|inv_q_a_via|s|tg_fbs_b|tg_fbs_b_via|tg_s_b|tg_s_b_via$3
+ 204.040461511
* device instance a_b_inv_q_a_inv_q_a_via_s_tg_fbs_b_tg_fbs_b_via_tg_s_b_tg_s_b_via_dup3_t4 r0 *1 0,0
Ra_b_inv_q_a_inv_q_a_via_s_tg_fbs_b_tg_fbs_b_via_tg_s_b_tg_s_b_via_dup3_t4
+ a|b|inv_q_a|inv_q_a_via|s|tg_fbs_b|tg_fbs_b_via|tg_s_b|tg_s_b_via__t44
+ a|b|inv_q_a|inv_q_a_via|s|tg_fbs_b|tg_fbs_b_via|tg_s_b|tg_s_b_via$3
+ 247.027895104
* device instance a_b_inv_q_a_inv_q_a_via_s_tg_fbs_b_tg_fbs_b_via_tg_s_b_tg_s_b_via_dup3_t5 r0 *1 0,0
Ra_b_inv_q_a_inv_q_a_via_s_tg_fbs_b_tg_fbs_b_via_tg_s_b_tg_s_b_via_dup3_t5
+ a|b|inv_q_a|inv_q_a_via|s|tg_fbs_b|tg_fbs_b_via|tg_s_b|tg_s_b_via__t54
+ a|b|inv_q_a|inv_q_a_via|s|tg_fbs_b|tg_fbs_b_via|tg_s_b|tg_s_b_via$3
+ 204.040461511
* device instance a_b_inv_q_a_inv_q_a_via_s_tg_fbs_b_tg_fbs_b_via_tg_s_b_tg_s_b_via_dup3 r0 *1 0,0
Ca_b_inv_q_a_inv_q_a_via_s_tg_fbs_b_tg_fbs_b_via_tg_s_b_tg_s_b_via_dup3
+ a|b|inv_q_a|inv_q_a_via|s|tg_fbs_b|tg_fbs_b_via|tg_s_b|tg_s_b_via$3 vsubs
+ 3.84792e-15
* device instance a_b_inv_q_a_inv_q_a_via_s_tg_fbs_b_tg_fbs_b_via_tg_s_b_tg_s_b_via_dup4_t0 r0 *1 0,0
Ra_b_inv_q_a_inv_q_a_via_s_tg_fbs_b_tg_fbs_b_via_tg_s_b_tg_s_b_via_dup4_t0
+ a|b|inv_q_a|inv_q_a_via|s|tg_fbs_b|tg_fbs_b_via|tg_s_b|tg_s_b_via__t05
+ a|b|inv_q_a|inv_q_a_via|s|tg_fbs_b|tg_fbs_b_via|tg_s_b|tg_s_b_via$4
+ 58.0186433859
* device instance a_b_inv_q_a_inv_q_a_via_s_tg_fbs_b_tg_fbs_b_via_tg_s_b_tg_s_b_via_dup4_t1 r0 *1 0,0
Ra_b_inv_q_a_inv_q_a_via_s_tg_fbs_b_tg_fbs_b_via_tg_s_b_tg_s_b_via_dup4_t1
+ a|b|inv_q_a|inv_q_a_via|s|tg_fbs_b|tg_fbs_b_via|tg_s_b|tg_s_b_via__t15
+ a|b|inv_q_a|inv_q_a_via|s|tg_fbs_b|tg_fbs_b_via|tg_s_b|tg_s_b_via$4
+ 58.0186433859
* device instance a_b_inv_q_a_inv_q_a_via_s_tg_fbs_b_tg_fbs_b_via_tg_s_b_tg_s_b_via_dup4_t2 r0 *1 0,0
Ra_b_inv_q_a_inv_q_a_via_s_tg_fbs_b_tg_fbs_b_via_tg_s_b_tg_s_b_via_dup4_t2
+ a|b|inv_q_a|inv_q_a_via|s|tg_fbs_b|tg_fbs_b_via|tg_s_b|tg_s_b_via__t25
+ a|b|inv_q_a|inv_q_a_via|s|tg_fbs_b|tg_fbs_b_via|tg_s_b|tg_s_b_via$4
+ 204.040461511
* device instance a_b_inv_q_a_inv_q_a_via_s_tg_fbs_b_tg_fbs_b_via_tg_s_b_tg_s_b_via_dup4_t3 r0 *1 0,0
Ra_b_inv_q_a_inv_q_a_via_s_tg_fbs_b_tg_fbs_b_via_tg_s_b_tg_s_b_via_dup4_t3
+ a|b|inv_q_a|inv_q_a_via|s|tg_fbs_b|tg_fbs_b_via|tg_s_b|tg_s_b_via__t35
+ a|b|inv_q_a|inv_q_a_via|s|tg_fbs_b|tg_fbs_b_via|tg_s_b|tg_s_b_via$4
+ 247.027895104
* device instance a_b_inv_q_a_inv_q_a_via_s_tg_fbs_b_tg_fbs_b_via_tg_s_b_tg_s_b_via_dup4_t4 r0 *1 0,0
Ra_b_inv_q_a_inv_q_a_via_s_tg_fbs_b_tg_fbs_b_via_tg_s_b_tg_s_b_via_dup4_t4
+ a|b|inv_q_a|inv_q_a_via|s|tg_fbs_b|tg_fbs_b_via|tg_s_b|tg_s_b_via__t45
+ a|b|inv_q_a|inv_q_a_via|s|tg_fbs_b|tg_fbs_b_via|tg_s_b|tg_s_b_via$4
+ 204.040461511
* device instance a_b_inv_q_a_inv_q_a_via_s_tg_fbs_b_tg_fbs_b_via_tg_s_b_tg_s_b_via_dup4_t5 r0 *1 0,0
Ra_b_inv_q_a_inv_q_a_via_s_tg_fbs_b_tg_fbs_b_via_tg_s_b_tg_s_b_via_dup4_t5
+ a|b|inv_q_a|inv_q_a_via|s|tg_fbs_b|tg_fbs_b_via|tg_s_b|tg_s_b_via__t55
+ a|b|inv_q_a|inv_q_a_via|s|tg_fbs_b|tg_fbs_b_via|tg_s_b|tg_s_b_via$4
+ 247.027895104
* device instance a_b_inv_q_a_inv_q_a_via_s_tg_fbs_b_tg_fbs_b_via_tg_s_b_tg_s_b_via_dup4 r0 *1 0,0
Ca_b_inv_q_a_inv_q_a_via_s_tg_fbs_b_tg_fbs_b_via_tg_s_b_tg_s_b_via_dup4
+ a|b|inv_q_a|inv_q_a_via|s|tg_fbs_b|tg_fbs_b_via|tg_s_b|tg_s_b_via$4 vsubs
+ 3.84792e-15
* device instance a_b_inv_q_a_inv_q_a_via_s_tg_fbs_b_tg_fbs_b_via_tg_s_b_tg_s_b_via_dup5_t0 r0 *1 0,0
Ra_b_inv_q_a_inv_q_a_via_s_tg_fbs_b_tg_fbs_b_via_tg_s_b_tg_s_b_via_dup5_t0
+ a|b|inv_q_a|inv_q_a_via|s|tg_fbs_b|tg_fbs_b_via|tg_s_b|tg_s_b_via__t06
+ a|b|inv_q_a|inv_q_a_via|s|tg_fbs_b|tg_fbs_b_via|tg_s_b|tg_s_b_via$5
+ 58.0186433859
* device instance a_b_inv_q_a_inv_q_a_via_s_tg_fbs_b_tg_fbs_b_via_tg_s_b_tg_s_b_via_dup5_t1 r0 *1 0,0
Ra_b_inv_q_a_inv_q_a_via_s_tg_fbs_b_tg_fbs_b_via_tg_s_b_tg_s_b_via_dup5_t1
+ a|b|inv_q_a|inv_q_a_via|s|tg_fbs_b|tg_fbs_b_via|tg_s_b|tg_s_b_via__t16
+ a|b|inv_q_a|inv_q_a_via|s|tg_fbs_b|tg_fbs_b_via|tg_s_b|tg_s_b_via$5
+ 58.0186433859
* device instance a_b_inv_q_a_inv_q_a_via_s_tg_fbs_b_tg_fbs_b_via_tg_s_b_tg_s_b_via_dup5_t2 r0 *1 0,0
Ra_b_inv_q_a_inv_q_a_via_s_tg_fbs_b_tg_fbs_b_via_tg_s_b_tg_s_b_via_dup5_t2
+ a|b|inv_q_a|inv_q_a_via|s|tg_fbs_b|tg_fbs_b_via|tg_s_b|tg_s_b_via__t26
+ a|b|inv_q_a|inv_q_a_via|s|tg_fbs_b|tg_fbs_b_via|tg_s_b|tg_s_b_via$5
+ 204.040461511
* device instance a_b_inv_q_a_inv_q_a_via_s_tg_fbs_b_tg_fbs_b_via_tg_s_b_tg_s_b_via_dup5_t3 r0 *1 0,0
Ra_b_inv_q_a_inv_q_a_via_s_tg_fbs_b_tg_fbs_b_via_tg_s_b_tg_s_b_via_dup5_t3
+ a|b|inv_q_a|inv_q_a_via|s|tg_fbs_b|tg_fbs_b_via|tg_s_b|tg_s_b_via__t36
+ a|b|inv_q_a|inv_q_a_via|s|tg_fbs_b|tg_fbs_b_via|tg_s_b|tg_s_b_via$5
+ 247.027895104
* device instance a_b_inv_q_a_inv_q_a_via_s_tg_fbs_b_tg_fbs_b_via_tg_s_b_tg_s_b_via_dup5_t4 r0 *1 0,0
Ra_b_inv_q_a_inv_q_a_via_s_tg_fbs_b_tg_fbs_b_via_tg_s_b_tg_s_b_via_dup5_t4
+ a|b|inv_q_a|inv_q_a_via|s|tg_fbs_b|tg_fbs_b_via|tg_s_b|tg_s_b_via__t46
+ a|b|inv_q_a|inv_q_a_via|s|tg_fbs_b|tg_fbs_b_via|tg_s_b|tg_s_b_via$5
+ 247.027895104
* device instance a_b_inv_q_a_inv_q_a_via_s_tg_fbs_b_tg_fbs_b_via_tg_s_b_tg_s_b_via_dup5_t5 r0 *1 0,0
Ra_b_inv_q_a_inv_q_a_via_s_tg_fbs_b_tg_fbs_b_via_tg_s_b_tg_s_b_via_dup5_t5
+ a|b|inv_q_a|inv_q_a_via|s|tg_fbs_b|tg_fbs_b_via|tg_s_b|tg_s_b_via__t56
+ a|b|inv_q_a|inv_q_a_via|s|tg_fbs_b|tg_fbs_b_via|tg_s_b|tg_s_b_via$5
+ 204.040461511
* device instance a_b_inv_q_a_inv_q_a_via_s_tg_fbs_b_tg_fbs_b_via_tg_s_b_tg_s_b_via_dup5 r0 *1 0,0
Ca_b_inv_q_a_inv_q_a_via_s_tg_fbs_b_tg_fbs_b_via_tg_s_b_tg_s_b_via_dup5
+ a|b|inv_q_a|inv_q_a_via|s|tg_fbs_b|tg_fbs_b_via|tg_s_b|tg_s_b_via$5 vsubs
+ 3.84792e-15
* device instance a_b_m_east_m_west_nand_m_a_nand_m_a_ext_via_nand_m_a_ext_via2_nand_m_a_stub_tg_d_b_tg_d_b_via_tg_d_b_via2_tg_fbm_b_tg_fbm_b_alt_via_tg_fbm_b_alt_via2_t0 r0 *1 0,0
Ra_b_m_east_m_west_nand_m_a_nand_m_a_ext_via_nand_m_a_ext_via2_nand_m_a_stub_tg_d_b_tg_d_b_via_tg_d_b_via2_tg_fbm_b_tg_fbm_b_alt_via_tg_fbm_b_alt_via2_t0
+ a|b|m_east|m_west|nand_m_a|nand_m_a_ext_via|nand_m_a_ext_via2|nand_m_a_stub|tg_d_b|tg_d_b_via|tg_d_b_via2|tg_fbm_b|tg_fbm_b_alt_via|tg_fbm_b_alt_via2__t0
+ a|b|m_east|m_west|nand_m_a|nand_m_a_ext_via|nand_m_a_ext_via2|nand_m_a_stub|tg_d_b|tg_d_b_via|tg_d_b_via2|tg_fbm_b|tg_fbm_b_alt_via|tg_fbm_b_alt_via2
+ 54.9450724763
* device instance a_b_m_east_m_west_nand_m_a_nand_m_a_ext_via_nand_m_a_ext_via2_nand_m_a_stub_tg_d_b_tg_d_b_via_tg_d_b_via2_tg_fbm_b_tg_fbm_b_alt_via_tg_fbm_b_alt_via2_t1 r0 *1 0,0
Ra_b_m_east_m_west_nand_m_a_nand_m_a_ext_via_nand_m_a_ext_via2_nand_m_a_stub_tg_d_b_tg_d_b_via_tg_d_b_via2_tg_fbm_b_tg_fbm_b_alt_via_tg_fbm_b_alt_via2_t1
+ a|b|m_east|m_west|nand_m_a|nand_m_a_ext_via|nand_m_a_ext_via2|nand_m_a_stub|tg_d_b|tg_d_b_via|tg_d_b_via2|tg_fbm_b|tg_fbm_b_alt_via|tg_fbm_b_alt_via2__t1
+ a|b|m_east|m_west|nand_m_a|nand_m_a_ext_via|nand_m_a_ext_via2|nand_m_a_stub|tg_d_b|tg_d_b_via|tg_d_b_via2|tg_fbm_b|tg_fbm_b_alt_via|tg_fbm_b_alt_via2
+ 52.0483618499
* device instance a_b_m_east_m_west_nand_m_a_nand_m_a_ext_via_nand_m_a_ext_via2_nand_m_a_stub_tg_d_b_tg_d_b_via_tg_d_b_via2_tg_fbm_b_tg_fbm_b_alt_via_tg_fbm_b_alt_via2_t2 r0 *1 0,0
Ra_b_m_east_m_west_nand_m_a_nand_m_a_ext_via_nand_m_a_ext_via2_nand_m_a_stub_tg_d_b_tg_d_b_via_tg_d_b_via2_tg_fbm_b_tg_fbm_b_alt_via_tg_fbm_b_alt_via2_t2
+ a|b|m_east|m_west|nand_m_a|nand_m_a_ext_via|nand_m_a_ext_via2|nand_m_a_stub|tg_d_b|tg_d_b_via|tg_d_b_via2|tg_fbm_b|tg_fbm_b_alt_via|tg_fbm_b_alt_via2__t2
+ a|b|m_east|m_west|nand_m_a|nand_m_a_ext_via|nand_m_a_ext_via2|nand_m_a_stub|tg_d_b|tg_d_b_via|tg_d_b_via2|tg_fbm_b|tg_fbm_b_alt_via|tg_fbm_b_alt_via2
+ 231.43816252
* device instance a_b_m_east_m_west_nand_m_a_nand_m_a_ext_via_nand_m_a_ext_via2_nand_m_a_stub_tg_d_b_tg_d_b_via_tg_d_b_via2_tg_fbm_b_tg_fbm_b_alt_via_tg_fbm_b_alt_via2_t3 r0 *1 0,0
Ra_b_m_east_m_west_nand_m_a_nand_m_a_ext_via_nand_m_a_ext_via2_nand_m_a_stub_tg_d_b_tg_d_b_via_tg_d_b_via2_tg_fbm_b_tg_fbm_b_alt_via_tg_fbm_b_alt_via2_t3
+ a|b|m_east|m_west|nand_m_a|nand_m_a_ext_via|nand_m_a_ext_via2|nand_m_a_stub|tg_d_b|tg_d_b_via|tg_d_b_via2|tg_fbm_b|tg_fbm_b_alt_via|tg_fbm_b_alt_via2__t3
+ a|b|m_east|m_west|nand_m_a|nand_m_a_ext_via|nand_m_a_ext_via2|nand_m_a_stub|tg_d_b|tg_d_b_via|tg_d_b_via2|tg_fbm_b|tg_fbm_b_alt_via|tg_fbm_b_alt_via2
+ 260.45877702
* device instance a_b_m_east_m_west_nand_m_a_nand_m_a_ext_via_nand_m_a_ext_via2_nand_m_a_stub_tg_d_b_tg_d_b_via_tg_d_b_via2_tg_fbm_b_tg_fbm_b_alt_via_tg_fbm_b_alt_via2_t4 r0 *1 0,0
Ra_b_m_east_m_west_nand_m_a_nand_m_a_ext_via_nand_m_a_ext_via2_nand_m_a_stub_tg_d_b_tg_d_b_via_tg_d_b_via2_tg_fbm_b_tg_fbm_b_alt_via_tg_fbm_b_alt_via2_t4
+ a|b|m_east|m_west|nand_m_a|nand_m_a_ext_via|nand_m_a_ext_via2|nand_m_a_stub|tg_d_b|tg_d_b_via|tg_d_b_via2|tg_fbm_b|tg_fbm_b_alt_via|tg_fbm_b_alt_via2__t4
+ a|b|m_east|m_west|nand_m_a|nand_m_a_ext_via|nand_m_a_ext_via2|nand_m_a_stub|tg_d_b|tg_d_b_via|tg_d_b_via2|tg_fbm_b|tg_fbm_b_alt_via|tg_fbm_b_alt_via2
+ 231.121281915
* device instance a_b_m_east_m_west_nand_m_a_nand_m_a_ext_via_nand_m_a_ext_via2_nand_m_a_stub_tg_d_b_tg_d_b_via_tg_d_b_via2_tg_fbm_b_tg_fbm_b_alt_via_tg_fbm_b_alt_via2_t5 r0 *1 0,0
Ra_b_m_east_m_west_nand_m_a_nand_m_a_ext_via_nand_m_a_ext_via2_nand_m_a_stub_tg_d_b_tg_d_b_via_tg_d_b_via2_tg_fbm_b_tg_fbm_b_alt_via_tg_fbm_b_alt_via2_t5
+ a|b|m_east|m_west|nand_m_a|nand_m_a_ext_via|nand_m_a_ext_via2|nand_m_a_stub|tg_d_b|tg_d_b_via|tg_d_b_via2|tg_fbm_b|tg_fbm_b_alt_via|tg_fbm_b_alt_via2__t5
+ a|b|m_east|m_west|nand_m_a|nand_m_a_ext_via|nand_m_a_ext_via2|nand_m_a_stub|tg_d_b|tg_d_b_via|tg_d_b_via2|tg_fbm_b|tg_fbm_b_alt_via|tg_fbm_b_alt_via2
+ 260.17724422
* device instance a_b_m_east_m_west_nand_m_a_nand_m_a_ext_via_nand_m_a_ext_via2_nand_m_a_stub_tg_d_b_tg_d_b_via_tg_d_b_via2_tg_fbm_b_tg_fbm_b_alt_via_tg_fbm_b_alt_via2 r0 *1 0,0
Ca_b_m_east_m_west_nand_m_a_nand_m_a_ext_via_nand_m_a_ext_via2_nand_m_a_stub_tg_d_b_tg_d_b_via_tg_d_b_via2_tg_fbm_b_tg_fbm_b_alt_via_tg_fbm_b_alt_via2
+ a|b|m_east|m_west|nand_m_a|nand_m_a_ext_via|nand_m_a_ext_via2|nand_m_a_stub|tg_d_b|tg_d_b_via|tg_d_b_via2|tg_fbm_b|tg_fbm_b_alt_via|tg_fbm_b_alt_via2
+ vsubs 3.815311e-15
* device instance a_b_m_east_m_west_nand_m_a_nand_m_a_ext_via_nand_m_a_ext_via2_nand_m_a_stub_tg_d_b_tg_d_b_via_tg_d_b_via2_tg_fbm_b_tg_fbm_b_alt_via_tg_fbm_b_alt_via2_dup1_t0 r0 *1 0,0
Ra_b_m_east_m_west_nand_m_a_nand_m_a_ext_via_nand_m_a_ext_via2_nand_m_a_stub_tg_d_b_tg_d_b_via_tg_d_b_via2_tg_fbm_b_tg_fbm_b_alt_via_tg_fbm_b_alt_via2_dup1_t0
+ a|b|m_east|m_west|nand_m_a|nand_m_a_ext_via|nand_m_a_ext_via2|nand_m_a_stub|tg_d_b|tg_d_b_via|tg_d_b_via2|tg_fbm_b|tg_fbm_b_alt_via|tg_fbm_b_alt_via2__t02
+ a|b|m_east|m_west|nand_m_a|nand_m_a_ext_via|nand_m_a_ext_via2|nand_m_a_stub|tg_d_b|tg_d_b_via|tg_d_b_via2|tg_fbm_b|tg_fbm_b_alt_via|tg_fbm_b_alt_via2$1
+ 52.0483618499
* device instance a_b_m_east_m_west_nand_m_a_nand_m_a_ext_via_nand_m_a_ext_via2_nand_m_a_stub_tg_d_b_tg_d_b_via_tg_d_b_via2_tg_fbm_b_tg_fbm_b_alt_via_tg_fbm_b_alt_via2_dup1_t1 r0 *1 0,0
Ra_b_m_east_m_west_nand_m_a_nand_m_a_ext_via_nand_m_a_ext_via2_nand_m_a_stub_tg_d_b_tg_d_b_via_tg_d_b_via2_tg_fbm_b_tg_fbm_b_alt_via_tg_fbm_b_alt_via2_dup1_t1
+ a|b|m_east|m_west|nand_m_a|nand_m_a_ext_via|nand_m_a_ext_via2|nand_m_a_stub|tg_d_b|tg_d_b_via|tg_d_b_via2|tg_fbm_b|tg_fbm_b_alt_via|tg_fbm_b_alt_via2__t12
+ a|b|m_east|m_west|nand_m_a|nand_m_a_ext_via|nand_m_a_ext_via2|nand_m_a_stub|tg_d_b|tg_d_b_via|tg_d_b_via2|tg_fbm_b|tg_fbm_b_alt_via|tg_fbm_b_alt_via2$1
+ 231.43816252
* device instance a_b_m_east_m_west_nand_m_a_nand_m_a_ext_via_nand_m_a_ext_via2_nand_m_a_stub_tg_d_b_tg_d_b_via_tg_d_b_via2_tg_fbm_b_tg_fbm_b_alt_via_tg_fbm_b_alt_via2_dup1_t2 r0 *1 0,0
Ra_b_m_east_m_west_nand_m_a_nand_m_a_ext_via_nand_m_a_ext_via2_nand_m_a_stub_tg_d_b_tg_d_b_via_tg_d_b_via2_tg_fbm_b_tg_fbm_b_alt_via_tg_fbm_b_alt_via2_dup1_t2
+ a|b|m_east|m_west|nand_m_a|nand_m_a_ext_via|nand_m_a_ext_via2|nand_m_a_stub|tg_d_b|tg_d_b_via|tg_d_b_via2|tg_fbm_b|tg_fbm_b_alt_via|tg_fbm_b_alt_via2__t22
+ a|b|m_east|m_west|nand_m_a|nand_m_a_ext_via|nand_m_a_ext_via2|nand_m_a_stub|tg_d_b|tg_d_b_via|tg_d_b_via2|tg_fbm_b|tg_fbm_b_alt_via|tg_fbm_b_alt_via2$1
+ 260.45877702
* device instance a_b_m_east_m_west_nand_m_a_nand_m_a_ext_via_nand_m_a_ext_via2_nand_m_a_stub_tg_d_b_tg_d_b_via_tg_d_b_via2_tg_fbm_b_tg_fbm_b_alt_via_tg_fbm_b_alt_via2_dup1_t3 r0 *1 0,0
Ra_b_m_east_m_west_nand_m_a_nand_m_a_ext_via_nand_m_a_ext_via2_nand_m_a_stub_tg_d_b_tg_d_b_via_tg_d_b_via2_tg_fbm_b_tg_fbm_b_alt_via_tg_fbm_b_alt_via2_dup1_t3
+ a|b|m_east|m_west|nand_m_a|nand_m_a_ext_via|nand_m_a_ext_via2|nand_m_a_stub|tg_d_b|tg_d_b_via|tg_d_b_via2|tg_fbm_b|tg_fbm_b_alt_via|tg_fbm_b_alt_via2__t32
+ a|b|m_east|m_west|nand_m_a|nand_m_a_ext_via|nand_m_a_ext_via2|nand_m_a_stub|tg_d_b|tg_d_b_via|tg_d_b_via2|tg_fbm_b|tg_fbm_b_alt_via|tg_fbm_b_alt_via2$1
+ 231.121281915
* device instance a_b_m_east_m_west_nand_m_a_nand_m_a_ext_via_nand_m_a_ext_via2_nand_m_a_stub_tg_d_b_tg_d_b_via_tg_d_b_via2_tg_fbm_b_tg_fbm_b_alt_via_tg_fbm_b_alt_via2_dup1_t4 r0 *1 0,0
Ra_b_m_east_m_west_nand_m_a_nand_m_a_ext_via_nand_m_a_ext_via2_nand_m_a_stub_tg_d_b_tg_d_b_via_tg_d_b_via2_tg_fbm_b_tg_fbm_b_alt_via_tg_fbm_b_alt_via2_dup1_t4
+ a|b|m_east|m_west|nand_m_a|nand_m_a_ext_via|nand_m_a_ext_via2|nand_m_a_stub|tg_d_b|tg_d_b_via|tg_d_b_via2|tg_fbm_b|tg_fbm_b_alt_via|tg_fbm_b_alt_via2__t42
+ a|b|m_east|m_west|nand_m_a|nand_m_a_ext_via|nand_m_a_ext_via2|nand_m_a_stub|tg_d_b|tg_d_b_via|tg_d_b_via2|tg_fbm_b|tg_fbm_b_alt_via|tg_fbm_b_alt_via2$1
+ 260.17724422
* device instance a_b_m_east_m_west_nand_m_a_nand_m_a_ext_via_nand_m_a_ext_via2_nand_m_a_stub_tg_d_b_tg_d_b_via_tg_d_b_via2_tg_fbm_b_tg_fbm_b_alt_via_tg_fbm_b_alt_via2_dup1_t5 r0 *1 0,0
Ra_b_m_east_m_west_nand_m_a_nand_m_a_ext_via_nand_m_a_ext_via2_nand_m_a_stub_tg_d_b_tg_d_b_via_tg_d_b_via2_tg_fbm_b_tg_fbm_b_alt_via_tg_fbm_b_alt_via2_dup1_t5
+ a|b|m_east|m_west|nand_m_a|nand_m_a_ext_via|nand_m_a_ext_via2|nand_m_a_stub|tg_d_b|tg_d_b_via|tg_d_b_via2|tg_fbm_b|tg_fbm_b_alt_via|tg_fbm_b_alt_via2__t52
+ a|b|m_east|m_west|nand_m_a|nand_m_a_ext_via|nand_m_a_ext_via2|nand_m_a_stub|tg_d_b|tg_d_b_via|tg_d_b_via2|tg_fbm_b|tg_fbm_b_alt_via|tg_fbm_b_alt_via2$1
+ 54.9450724763
* device instance a_b_m_east_m_west_nand_m_a_nand_m_a_ext_via_nand_m_a_ext_via2_nand_m_a_stub_tg_d_b_tg_d_b_via_tg_d_b_via2_tg_fbm_b_tg_fbm_b_alt_via_tg_fbm_b_alt_via2_dup1 r0 *1 0,0
Ca_b_m_east_m_west_nand_m_a_nand_m_a_ext_via_nand_m_a_ext_via2_nand_m_a_stub_tg_d_b_tg_d_b_via_tg_d_b_via2_tg_fbm_b_tg_fbm_b_alt_via_tg_fbm_b_alt_via2_dup1
+ a|b|m_east|m_west|nand_m_a|nand_m_a_ext_via|nand_m_a_ext_via2|nand_m_a_stub|tg_d_b|tg_d_b_via|tg_d_b_via2|tg_fbm_b|tg_fbm_b_alt_via|tg_fbm_b_alt_via2$1
+ vsubs 3.815311e-15
* device instance a_b_m_east_m_west_nand_m_a_nand_m_a_ext_via_nand_m_a_ext_via2_nand_m_a_stub_tg_d_b_tg_d_b_via_tg_d_b_via2_tg_fbm_b_tg_fbm_b_alt_via_tg_fbm_b_alt_via2_dup2_t0 r0 *1 0,0
Ra_b_m_east_m_west_nand_m_a_nand_m_a_ext_via_nand_m_a_ext_via2_nand_m_a_stub_tg_d_b_tg_d_b_via_tg_d_b_via2_tg_fbm_b_tg_fbm_b_alt_via_tg_fbm_b_alt_via2_dup2_t0
+ a|b|m_east|m_west|nand_m_a|nand_m_a_ext_via|nand_m_a_ext_via2|nand_m_a_stub|tg_d_b|tg_d_b_via|tg_d_b_via2|tg_fbm_b|tg_fbm_b_alt_via|tg_fbm_b_alt_via2__t03
+ a|b|m_east|m_west|nand_m_a|nand_m_a_ext_via|nand_m_a_ext_via2|nand_m_a_stub|tg_d_b|tg_d_b_via|tg_d_b_via2|tg_fbm_b|tg_fbm_b_alt_via|tg_fbm_b_alt_via2$2
+ 52.0483618499
* device instance a_b_m_east_m_west_nand_m_a_nand_m_a_ext_via_nand_m_a_ext_via2_nand_m_a_stub_tg_d_b_tg_d_b_via_tg_d_b_via2_tg_fbm_b_tg_fbm_b_alt_via_tg_fbm_b_alt_via2_dup2_t1 r0 *1 0,0
Ra_b_m_east_m_west_nand_m_a_nand_m_a_ext_via_nand_m_a_ext_via2_nand_m_a_stub_tg_d_b_tg_d_b_via_tg_d_b_via2_tg_fbm_b_tg_fbm_b_alt_via_tg_fbm_b_alt_via2_dup2_t1
+ a|b|m_east|m_west|nand_m_a|nand_m_a_ext_via|nand_m_a_ext_via2|nand_m_a_stub|tg_d_b|tg_d_b_via|tg_d_b_via2|tg_fbm_b|tg_fbm_b_alt_via|tg_fbm_b_alt_via2__t13
+ a|b|m_east|m_west|nand_m_a|nand_m_a_ext_via|nand_m_a_ext_via2|nand_m_a_stub|tg_d_b|tg_d_b_via|tg_d_b_via2|tg_fbm_b|tg_fbm_b_alt_via|tg_fbm_b_alt_via2$2
+ 260.45877702
* device instance a_b_m_east_m_west_nand_m_a_nand_m_a_ext_via_nand_m_a_ext_via2_nand_m_a_stub_tg_d_b_tg_d_b_via_tg_d_b_via2_tg_fbm_b_tg_fbm_b_alt_via_tg_fbm_b_alt_via2_dup2_t2 r0 *1 0,0
Ra_b_m_east_m_west_nand_m_a_nand_m_a_ext_via_nand_m_a_ext_via2_nand_m_a_stub_tg_d_b_tg_d_b_via_tg_d_b_via2_tg_fbm_b_tg_fbm_b_alt_via_tg_fbm_b_alt_via2_dup2_t2
+ a|b|m_east|m_west|nand_m_a|nand_m_a_ext_via|nand_m_a_ext_via2|nand_m_a_stub|tg_d_b|tg_d_b_via|tg_d_b_via2|tg_fbm_b|tg_fbm_b_alt_via|tg_fbm_b_alt_via2__t23
+ a|b|m_east|m_west|nand_m_a|nand_m_a_ext_via|nand_m_a_ext_via2|nand_m_a_stub|tg_d_b|tg_d_b_via|tg_d_b_via2|tg_fbm_b|tg_fbm_b_alt_via|tg_fbm_b_alt_via2$2
+ 231.43816252
* device instance a_b_m_east_m_west_nand_m_a_nand_m_a_ext_via_nand_m_a_ext_via2_nand_m_a_stub_tg_d_b_tg_d_b_via_tg_d_b_via2_tg_fbm_b_tg_fbm_b_alt_via_tg_fbm_b_alt_via2_dup2_t3 r0 *1 0,0
Ra_b_m_east_m_west_nand_m_a_nand_m_a_ext_via_nand_m_a_ext_via2_nand_m_a_stub_tg_d_b_tg_d_b_via_tg_d_b_via2_tg_fbm_b_tg_fbm_b_alt_via_tg_fbm_b_alt_via2_dup2_t3
+ a|b|m_east|m_west|nand_m_a|nand_m_a_ext_via|nand_m_a_ext_via2|nand_m_a_stub|tg_d_b|tg_d_b_via|tg_d_b_via2|tg_fbm_b|tg_fbm_b_alt_via|tg_fbm_b_alt_via2__t33
+ a|b|m_east|m_west|nand_m_a|nand_m_a_ext_via|nand_m_a_ext_via2|nand_m_a_stub|tg_d_b|tg_d_b_via|tg_d_b_via2|tg_fbm_b|tg_fbm_b_alt_via|tg_fbm_b_alt_via2$2
+ 260.17724422
* device instance a_b_m_east_m_west_nand_m_a_nand_m_a_ext_via_nand_m_a_ext_via2_nand_m_a_stub_tg_d_b_tg_d_b_via_tg_d_b_via2_tg_fbm_b_tg_fbm_b_alt_via_tg_fbm_b_alt_via2_dup2_t4 r0 *1 0,0
Ra_b_m_east_m_west_nand_m_a_nand_m_a_ext_via_nand_m_a_ext_via2_nand_m_a_stub_tg_d_b_tg_d_b_via_tg_d_b_via2_tg_fbm_b_tg_fbm_b_alt_via_tg_fbm_b_alt_via2_dup2_t4
+ a|b|m_east|m_west|nand_m_a|nand_m_a_ext_via|nand_m_a_ext_via2|nand_m_a_stub|tg_d_b|tg_d_b_via|tg_d_b_via2|tg_fbm_b|tg_fbm_b_alt_via|tg_fbm_b_alt_via2__t43
+ a|b|m_east|m_west|nand_m_a|nand_m_a_ext_via|nand_m_a_ext_via2|nand_m_a_stub|tg_d_b|tg_d_b_via|tg_d_b_via2|tg_fbm_b|tg_fbm_b_alt_via|tg_fbm_b_alt_via2$2
+ 231.121281915
* device instance a_b_m_east_m_west_nand_m_a_nand_m_a_ext_via_nand_m_a_ext_via2_nand_m_a_stub_tg_d_b_tg_d_b_via_tg_d_b_via2_tg_fbm_b_tg_fbm_b_alt_via_tg_fbm_b_alt_via2_dup2_t5 r0 *1 0,0
Ra_b_m_east_m_west_nand_m_a_nand_m_a_ext_via_nand_m_a_ext_via2_nand_m_a_stub_tg_d_b_tg_d_b_via_tg_d_b_via2_tg_fbm_b_tg_fbm_b_alt_via_tg_fbm_b_alt_via2_dup2_t5
+ a|b|m_east|m_west|nand_m_a|nand_m_a_ext_via|nand_m_a_ext_via2|nand_m_a_stub|tg_d_b|tg_d_b_via|tg_d_b_via2|tg_fbm_b|tg_fbm_b_alt_via|tg_fbm_b_alt_via2__t53
+ a|b|m_east|m_west|nand_m_a|nand_m_a_ext_via|nand_m_a_ext_via2|nand_m_a_stub|tg_d_b|tg_d_b_via|tg_d_b_via2|tg_fbm_b|tg_fbm_b_alt_via|tg_fbm_b_alt_via2$2
+ 54.9450724763
* device instance a_b_m_east_m_west_nand_m_a_nand_m_a_ext_via_nand_m_a_ext_via2_nand_m_a_stub_tg_d_b_tg_d_b_via_tg_d_b_via2_tg_fbm_b_tg_fbm_b_alt_via_tg_fbm_b_alt_via2_dup2 r0 *1 0,0
Ca_b_m_east_m_west_nand_m_a_nand_m_a_ext_via_nand_m_a_ext_via2_nand_m_a_stub_tg_d_b_tg_d_b_via_tg_d_b_via2_tg_fbm_b_tg_fbm_b_alt_via_tg_fbm_b_alt_via2_dup2
+ a|b|m_east|m_west|nand_m_a|nand_m_a_ext_via|nand_m_a_ext_via2|nand_m_a_stub|tg_d_b|tg_d_b_via|tg_d_b_via2|tg_fbm_b|tg_fbm_b_alt_via|tg_fbm_b_alt_via2$2
+ vsubs 3.815311e-15
* device instance a_b_m_east_m_west_nand_m_a_nand_m_a_ext_via_nand_m_a_ext_via2_nand_m_a_stub_tg_d_b_tg_d_b_via_tg_d_b_via2_tg_fbm_b_tg_fbm_b_alt_via_tg_fbm_b_alt_via2_dup3_t0 r0 *1 0,0
Ra_b_m_east_m_west_nand_m_a_nand_m_a_ext_via_nand_m_a_ext_via2_nand_m_a_stub_tg_d_b_tg_d_b_via_tg_d_b_via2_tg_fbm_b_tg_fbm_b_alt_via_tg_fbm_b_alt_via2_dup3_t0
+ a|b|m_east|m_west|nand_m_a|nand_m_a_ext_via|nand_m_a_ext_via2|nand_m_a_stub|tg_d_b|tg_d_b_via|tg_d_b_via2|tg_fbm_b|tg_fbm_b_alt_via|tg_fbm_b_alt_via2__t04
+ a|b|m_east|m_west|nand_m_a|nand_m_a_ext_via|nand_m_a_ext_via2|nand_m_a_stub|tg_d_b|tg_d_b_via|tg_d_b_via2|tg_fbm_b|tg_fbm_b_alt_via|tg_fbm_b_alt_via2$3
+ 52.0483618499
* device instance a_b_m_east_m_west_nand_m_a_nand_m_a_ext_via_nand_m_a_ext_via2_nand_m_a_stub_tg_d_b_tg_d_b_via_tg_d_b_via2_tg_fbm_b_tg_fbm_b_alt_via_tg_fbm_b_alt_via2_dup3_t1 r0 *1 0,0
Ra_b_m_east_m_west_nand_m_a_nand_m_a_ext_via_nand_m_a_ext_via2_nand_m_a_stub_tg_d_b_tg_d_b_via_tg_d_b_via2_tg_fbm_b_tg_fbm_b_alt_via_tg_fbm_b_alt_via2_dup3_t1
+ a|b|m_east|m_west|nand_m_a|nand_m_a_ext_via|nand_m_a_ext_via2|nand_m_a_stub|tg_d_b|tg_d_b_via|tg_d_b_via2|tg_fbm_b|tg_fbm_b_alt_via|tg_fbm_b_alt_via2__t14
+ a|b|m_east|m_west|nand_m_a|nand_m_a_ext_via|nand_m_a_ext_via2|nand_m_a_stub|tg_d_b|tg_d_b_via|tg_d_b_via2|tg_fbm_b|tg_fbm_b_alt_via|tg_fbm_b_alt_via2$3
+ 260.45877702
* device instance a_b_m_east_m_west_nand_m_a_nand_m_a_ext_via_nand_m_a_ext_via2_nand_m_a_stub_tg_d_b_tg_d_b_via_tg_d_b_via2_tg_fbm_b_tg_fbm_b_alt_via_tg_fbm_b_alt_via2_dup3_t2 r0 *1 0,0
Ra_b_m_east_m_west_nand_m_a_nand_m_a_ext_via_nand_m_a_ext_via2_nand_m_a_stub_tg_d_b_tg_d_b_via_tg_d_b_via2_tg_fbm_b_tg_fbm_b_alt_via_tg_fbm_b_alt_via2_dup3_t2
+ a|b|m_east|m_west|nand_m_a|nand_m_a_ext_via|nand_m_a_ext_via2|nand_m_a_stub|tg_d_b|tg_d_b_via|tg_d_b_via2|tg_fbm_b|tg_fbm_b_alt_via|tg_fbm_b_alt_via2__t24
+ a|b|m_east|m_west|nand_m_a|nand_m_a_ext_via|nand_m_a_ext_via2|nand_m_a_stub|tg_d_b|tg_d_b_via|tg_d_b_via2|tg_fbm_b|tg_fbm_b_alt_via|tg_fbm_b_alt_via2$3
+ 231.43816252
* device instance a_b_m_east_m_west_nand_m_a_nand_m_a_ext_via_nand_m_a_ext_via2_nand_m_a_stub_tg_d_b_tg_d_b_via_tg_d_b_via2_tg_fbm_b_tg_fbm_b_alt_via_tg_fbm_b_alt_via2_dup3_t3 r0 *1 0,0
Ra_b_m_east_m_west_nand_m_a_nand_m_a_ext_via_nand_m_a_ext_via2_nand_m_a_stub_tg_d_b_tg_d_b_via_tg_d_b_via2_tg_fbm_b_tg_fbm_b_alt_via_tg_fbm_b_alt_via2_dup3_t3
+ a|b|m_east|m_west|nand_m_a|nand_m_a_ext_via|nand_m_a_ext_via2|nand_m_a_stub|tg_d_b|tg_d_b_via|tg_d_b_via2|tg_fbm_b|tg_fbm_b_alt_via|tg_fbm_b_alt_via2__t34
+ a|b|m_east|m_west|nand_m_a|nand_m_a_ext_via|nand_m_a_ext_via2|nand_m_a_stub|tg_d_b|tg_d_b_via|tg_d_b_via2|tg_fbm_b|tg_fbm_b_alt_via|tg_fbm_b_alt_via2$3
+ 260.17724422
* device instance a_b_m_east_m_west_nand_m_a_nand_m_a_ext_via_nand_m_a_ext_via2_nand_m_a_stub_tg_d_b_tg_d_b_via_tg_d_b_via2_tg_fbm_b_tg_fbm_b_alt_via_tg_fbm_b_alt_via2_dup3_t4 r0 *1 0,0
Ra_b_m_east_m_west_nand_m_a_nand_m_a_ext_via_nand_m_a_ext_via2_nand_m_a_stub_tg_d_b_tg_d_b_via_tg_d_b_via2_tg_fbm_b_tg_fbm_b_alt_via_tg_fbm_b_alt_via2_dup3_t4
+ a|b|m_east|m_west|nand_m_a|nand_m_a_ext_via|nand_m_a_ext_via2|nand_m_a_stub|tg_d_b|tg_d_b_via|tg_d_b_via2|tg_fbm_b|tg_fbm_b_alt_via|tg_fbm_b_alt_via2__t44
+ a|b|m_east|m_west|nand_m_a|nand_m_a_ext_via|nand_m_a_ext_via2|nand_m_a_stub|tg_d_b|tg_d_b_via|tg_d_b_via2|tg_fbm_b|tg_fbm_b_alt_via|tg_fbm_b_alt_via2$3
+ 231.121281915
* device instance a_b_m_east_m_west_nand_m_a_nand_m_a_ext_via_nand_m_a_ext_via2_nand_m_a_stub_tg_d_b_tg_d_b_via_tg_d_b_via2_tg_fbm_b_tg_fbm_b_alt_via_tg_fbm_b_alt_via2_dup3_t5 r0 *1 0,0
Ra_b_m_east_m_west_nand_m_a_nand_m_a_ext_via_nand_m_a_ext_via2_nand_m_a_stub_tg_d_b_tg_d_b_via_tg_d_b_via2_tg_fbm_b_tg_fbm_b_alt_via_tg_fbm_b_alt_via2_dup3_t5
+ a|b|m_east|m_west|nand_m_a|nand_m_a_ext_via|nand_m_a_ext_via2|nand_m_a_stub|tg_d_b|tg_d_b_via|tg_d_b_via2|tg_fbm_b|tg_fbm_b_alt_via|tg_fbm_b_alt_via2__t54
+ a|b|m_east|m_west|nand_m_a|nand_m_a_ext_via|nand_m_a_ext_via2|nand_m_a_stub|tg_d_b|tg_d_b_via|tg_d_b_via2|tg_fbm_b|tg_fbm_b_alt_via|tg_fbm_b_alt_via2$3
+ 54.9450724763
* device instance a_b_m_east_m_west_nand_m_a_nand_m_a_ext_via_nand_m_a_ext_via2_nand_m_a_stub_tg_d_b_tg_d_b_via_tg_d_b_via2_tg_fbm_b_tg_fbm_b_alt_via_tg_fbm_b_alt_via2_dup3 r0 *1 0,0
Ca_b_m_east_m_west_nand_m_a_nand_m_a_ext_via_nand_m_a_ext_via2_nand_m_a_stub_tg_d_b_tg_d_b_via_tg_d_b_via2_tg_fbm_b_tg_fbm_b_alt_via_tg_fbm_b_alt_via2_dup3
+ a|b|m_east|m_west|nand_m_a|nand_m_a_ext_via|nand_m_a_ext_via2|nand_m_a_stub|tg_d_b|tg_d_b_via|tg_d_b_via2|tg_fbm_b|tg_fbm_b_alt_via|tg_fbm_b_alt_via2$3
+ vsubs 3.815311e-15
* device instance a_b_m_east_m_west_nand_m_a_nand_m_a_ext_via_nand_m_a_ext_via2_nand_m_a_stub_tg_d_b_tg_d_b_via_tg_d_b_via2_tg_fbm_b_tg_fbm_b_alt_via_tg_fbm_b_alt_via2_dup4_t0 r0 *1 0,0
Ra_b_m_east_m_west_nand_m_a_nand_m_a_ext_via_nand_m_a_ext_via2_nand_m_a_stub_tg_d_b_tg_d_b_via_tg_d_b_via2_tg_fbm_b_tg_fbm_b_alt_via_tg_fbm_b_alt_via2_dup4_t0
+ a|b|m_east|m_west|nand_m_a|nand_m_a_ext_via|nand_m_a_ext_via2|nand_m_a_stub|tg_d_b|tg_d_b_via|tg_d_b_via2|tg_fbm_b|tg_fbm_b_alt_via|tg_fbm_b_alt_via2__t05
+ a|b|m_east|m_west|nand_m_a|nand_m_a_ext_via|nand_m_a_ext_via2|nand_m_a_stub|tg_d_b|tg_d_b_via|tg_d_b_via2|tg_fbm_b|tg_fbm_b_alt_via|tg_fbm_b_alt_via2$4
+ 52.0483618499
* device instance a_b_m_east_m_west_nand_m_a_nand_m_a_ext_via_nand_m_a_ext_via2_nand_m_a_stub_tg_d_b_tg_d_b_via_tg_d_b_via2_tg_fbm_b_tg_fbm_b_alt_via_tg_fbm_b_alt_via2_dup4_t1 r0 *1 0,0
Ra_b_m_east_m_west_nand_m_a_nand_m_a_ext_via_nand_m_a_ext_via2_nand_m_a_stub_tg_d_b_tg_d_b_via_tg_d_b_via2_tg_fbm_b_tg_fbm_b_alt_via_tg_fbm_b_alt_via2_dup4_t1
+ a|b|m_east|m_west|nand_m_a|nand_m_a_ext_via|nand_m_a_ext_via2|nand_m_a_stub|tg_d_b|tg_d_b_via|tg_d_b_via2|tg_fbm_b|tg_fbm_b_alt_via|tg_fbm_b_alt_via2__t15
+ a|b|m_east|m_west|nand_m_a|nand_m_a_ext_via|nand_m_a_ext_via2|nand_m_a_stub|tg_d_b|tg_d_b_via|tg_d_b_via2|tg_fbm_b|tg_fbm_b_alt_via|tg_fbm_b_alt_via2$4
+ 231.43816252
* device instance a_b_m_east_m_west_nand_m_a_nand_m_a_ext_via_nand_m_a_ext_via2_nand_m_a_stub_tg_d_b_tg_d_b_via_tg_d_b_via2_tg_fbm_b_tg_fbm_b_alt_via_tg_fbm_b_alt_via2_dup4_t2 r0 *1 0,0
Ra_b_m_east_m_west_nand_m_a_nand_m_a_ext_via_nand_m_a_ext_via2_nand_m_a_stub_tg_d_b_tg_d_b_via_tg_d_b_via2_tg_fbm_b_tg_fbm_b_alt_via_tg_fbm_b_alt_via2_dup4_t2
+ a|b|m_east|m_west|nand_m_a|nand_m_a_ext_via|nand_m_a_ext_via2|nand_m_a_stub|tg_d_b|tg_d_b_via|tg_d_b_via2|tg_fbm_b|tg_fbm_b_alt_via|tg_fbm_b_alt_via2__t25
+ a|b|m_east|m_west|nand_m_a|nand_m_a_ext_via|nand_m_a_ext_via2|nand_m_a_stub|tg_d_b|tg_d_b_via|tg_d_b_via2|tg_fbm_b|tg_fbm_b_alt_via|tg_fbm_b_alt_via2$4
+ 260.45877702
* device instance a_b_m_east_m_west_nand_m_a_nand_m_a_ext_via_nand_m_a_ext_via2_nand_m_a_stub_tg_d_b_tg_d_b_via_tg_d_b_via2_tg_fbm_b_tg_fbm_b_alt_via_tg_fbm_b_alt_via2_dup4_t3 r0 *1 0,0
Ra_b_m_east_m_west_nand_m_a_nand_m_a_ext_via_nand_m_a_ext_via2_nand_m_a_stub_tg_d_b_tg_d_b_via_tg_d_b_via2_tg_fbm_b_tg_fbm_b_alt_via_tg_fbm_b_alt_via2_dup4_t3
+ a|b|m_east|m_west|nand_m_a|nand_m_a_ext_via|nand_m_a_ext_via2|nand_m_a_stub|tg_d_b|tg_d_b_via|tg_d_b_via2|tg_fbm_b|tg_fbm_b_alt_via|tg_fbm_b_alt_via2__t35
+ a|b|m_east|m_west|nand_m_a|nand_m_a_ext_via|nand_m_a_ext_via2|nand_m_a_stub|tg_d_b|tg_d_b_via|tg_d_b_via2|tg_fbm_b|tg_fbm_b_alt_via|tg_fbm_b_alt_via2$4
+ 260.17724422
* device instance a_b_m_east_m_west_nand_m_a_nand_m_a_ext_via_nand_m_a_ext_via2_nand_m_a_stub_tg_d_b_tg_d_b_via_tg_d_b_via2_tg_fbm_b_tg_fbm_b_alt_via_tg_fbm_b_alt_via2_dup4_t4 r0 *1 0,0
Ra_b_m_east_m_west_nand_m_a_nand_m_a_ext_via_nand_m_a_ext_via2_nand_m_a_stub_tg_d_b_tg_d_b_via_tg_d_b_via2_tg_fbm_b_tg_fbm_b_alt_via_tg_fbm_b_alt_via2_dup4_t4
+ a|b|m_east|m_west|nand_m_a|nand_m_a_ext_via|nand_m_a_ext_via2|nand_m_a_stub|tg_d_b|tg_d_b_via|tg_d_b_via2|tg_fbm_b|tg_fbm_b_alt_via|tg_fbm_b_alt_via2__t45
+ a|b|m_east|m_west|nand_m_a|nand_m_a_ext_via|nand_m_a_ext_via2|nand_m_a_stub|tg_d_b|tg_d_b_via|tg_d_b_via2|tg_fbm_b|tg_fbm_b_alt_via|tg_fbm_b_alt_via2$4
+ 231.121281915
* device instance a_b_m_east_m_west_nand_m_a_nand_m_a_ext_via_nand_m_a_ext_via2_nand_m_a_stub_tg_d_b_tg_d_b_via_tg_d_b_via2_tg_fbm_b_tg_fbm_b_alt_via_tg_fbm_b_alt_via2_dup4_t5 r0 *1 0,0
Ra_b_m_east_m_west_nand_m_a_nand_m_a_ext_via_nand_m_a_ext_via2_nand_m_a_stub_tg_d_b_tg_d_b_via_tg_d_b_via2_tg_fbm_b_tg_fbm_b_alt_via_tg_fbm_b_alt_via2_dup4_t5
+ a|b|m_east|m_west|nand_m_a|nand_m_a_ext_via|nand_m_a_ext_via2|nand_m_a_stub|tg_d_b|tg_d_b_via|tg_d_b_via2|tg_fbm_b|tg_fbm_b_alt_via|tg_fbm_b_alt_via2__t55
+ a|b|m_east|m_west|nand_m_a|nand_m_a_ext_via|nand_m_a_ext_via2|nand_m_a_stub|tg_d_b|tg_d_b_via|tg_d_b_via2|tg_fbm_b|tg_fbm_b_alt_via|tg_fbm_b_alt_via2$4
+ 54.9450724763
* device instance a_b_m_east_m_west_nand_m_a_nand_m_a_ext_via_nand_m_a_ext_via2_nand_m_a_stub_tg_d_b_tg_d_b_via_tg_d_b_via2_tg_fbm_b_tg_fbm_b_alt_via_tg_fbm_b_alt_via2_dup4 r0 *1 0,0
Ca_b_m_east_m_west_nand_m_a_nand_m_a_ext_via_nand_m_a_ext_via2_nand_m_a_stub_tg_d_b_tg_d_b_via_tg_d_b_via2_tg_fbm_b_tg_fbm_b_alt_via_tg_fbm_b_alt_via2_dup4
+ a|b|m_east|m_west|nand_m_a|nand_m_a_ext_via|nand_m_a_ext_via2|nand_m_a_stub|tg_d_b|tg_d_b_via|tg_d_b_via2|tg_fbm_b|tg_fbm_b_alt_via|tg_fbm_b_alt_via2$4
+ vsubs 3.815311e-15
* device instance a_b_m_east_m_west_nand_m_a_nand_m_a_ext_via_nand_m_a_ext_via2_nand_m_a_stub_tg_d_b_tg_d_b_via_tg_d_b_via2_tg_fbm_b_tg_fbm_b_alt_via_tg_fbm_b_alt_via2_dup5_t0 r0 *1 0,0
Ra_b_m_east_m_west_nand_m_a_nand_m_a_ext_via_nand_m_a_ext_via2_nand_m_a_stub_tg_d_b_tg_d_b_via_tg_d_b_via2_tg_fbm_b_tg_fbm_b_alt_via_tg_fbm_b_alt_via2_dup5_t0
+ a|b|m_east|m_west|nand_m_a|nand_m_a_ext_via|nand_m_a_ext_via2|nand_m_a_stub|tg_d_b|tg_d_b_via|tg_d_b_via2|tg_fbm_b|tg_fbm_b_alt_via|tg_fbm_b_alt_via2__t06
+ a|b|m_east|m_west|nand_m_a|nand_m_a_ext_via|nand_m_a_ext_via2|nand_m_a_stub|tg_d_b|tg_d_b_via|tg_d_b_via2|tg_fbm_b|tg_fbm_b_alt_via|tg_fbm_b_alt_via2$5
+ 52.0483618499
* device instance a_b_m_east_m_west_nand_m_a_nand_m_a_ext_via_nand_m_a_ext_via2_nand_m_a_stub_tg_d_b_tg_d_b_via_tg_d_b_via2_tg_fbm_b_tg_fbm_b_alt_via_tg_fbm_b_alt_via2_dup5_t1 r0 *1 0,0
Ra_b_m_east_m_west_nand_m_a_nand_m_a_ext_via_nand_m_a_ext_via2_nand_m_a_stub_tg_d_b_tg_d_b_via_tg_d_b_via2_tg_fbm_b_tg_fbm_b_alt_via_tg_fbm_b_alt_via2_dup5_t1
+ a|b|m_east|m_west|nand_m_a|nand_m_a_ext_via|nand_m_a_ext_via2|nand_m_a_stub|tg_d_b|tg_d_b_via|tg_d_b_via2|tg_fbm_b|tg_fbm_b_alt_via|tg_fbm_b_alt_via2__t16
+ a|b|m_east|m_west|nand_m_a|nand_m_a_ext_via|nand_m_a_ext_via2|nand_m_a_stub|tg_d_b|tg_d_b_via|tg_d_b_via2|tg_fbm_b|tg_fbm_b_alt_via|tg_fbm_b_alt_via2$5
+ 231.43816252
* device instance a_b_m_east_m_west_nand_m_a_nand_m_a_ext_via_nand_m_a_ext_via2_nand_m_a_stub_tg_d_b_tg_d_b_via_tg_d_b_via2_tg_fbm_b_tg_fbm_b_alt_via_tg_fbm_b_alt_via2_dup5_t2 r0 *1 0,0
Ra_b_m_east_m_west_nand_m_a_nand_m_a_ext_via_nand_m_a_ext_via2_nand_m_a_stub_tg_d_b_tg_d_b_via_tg_d_b_via2_tg_fbm_b_tg_fbm_b_alt_via_tg_fbm_b_alt_via2_dup5_t2
+ a|b|m_east|m_west|nand_m_a|nand_m_a_ext_via|nand_m_a_ext_via2|nand_m_a_stub|tg_d_b|tg_d_b_via|tg_d_b_via2|tg_fbm_b|tg_fbm_b_alt_via|tg_fbm_b_alt_via2__t26
+ a|b|m_east|m_west|nand_m_a|nand_m_a_ext_via|nand_m_a_ext_via2|nand_m_a_stub|tg_d_b|tg_d_b_via|tg_d_b_via2|tg_fbm_b|tg_fbm_b_alt_via|tg_fbm_b_alt_via2$5
+ 260.45877702
* device instance a_b_m_east_m_west_nand_m_a_nand_m_a_ext_via_nand_m_a_ext_via2_nand_m_a_stub_tg_d_b_tg_d_b_via_tg_d_b_via2_tg_fbm_b_tg_fbm_b_alt_via_tg_fbm_b_alt_via2_dup5_t3 r0 *1 0,0
Ra_b_m_east_m_west_nand_m_a_nand_m_a_ext_via_nand_m_a_ext_via2_nand_m_a_stub_tg_d_b_tg_d_b_via_tg_d_b_via2_tg_fbm_b_tg_fbm_b_alt_via_tg_fbm_b_alt_via2_dup5_t3
+ a|b|m_east|m_west|nand_m_a|nand_m_a_ext_via|nand_m_a_ext_via2|nand_m_a_stub|tg_d_b|tg_d_b_via|tg_d_b_via2|tg_fbm_b|tg_fbm_b_alt_via|tg_fbm_b_alt_via2__t36
+ a|b|m_east|m_west|nand_m_a|nand_m_a_ext_via|nand_m_a_ext_via2|nand_m_a_stub|tg_d_b|tg_d_b_via|tg_d_b_via2|tg_fbm_b|tg_fbm_b_alt_via|tg_fbm_b_alt_via2$5
+ 260.17724422
* device instance a_b_m_east_m_west_nand_m_a_nand_m_a_ext_via_nand_m_a_ext_via2_nand_m_a_stub_tg_d_b_tg_d_b_via_tg_d_b_via2_tg_fbm_b_tg_fbm_b_alt_via_tg_fbm_b_alt_via2_dup5_t4 r0 *1 0,0
Ra_b_m_east_m_west_nand_m_a_nand_m_a_ext_via_nand_m_a_ext_via2_nand_m_a_stub_tg_d_b_tg_d_b_via_tg_d_b_via2_tg_fbm_b_tg_fbm_b_alt_via_tg_fbm_b_alt_via2_dup5_t4
+ a|b|m_east|m_west|nand_m_a|nand_m_a_ext_via|nand_m_a_ext_via2|nand_m_a_stub|tg_d_b|tg_d_b_via|tg_d_b_via2|tg_fbm_b|tg_fbm_b_alt_via|tg_fbm_b_alt_via2__t46
+ a|b|m_east|m_west|nand_m_a|nand_m_a_ext_via|nand_m_a_ext_via2|nand_m_a_stub|tg_d_b|tg_d_b_via|tg_d_b_via2|tg_fbm_b|tg_fbm_b_alt_via|tg_fbm_b_alt_via2$5
+ 231.121281915
* device instance a_b_m_east_m_west_nand_m_a_nand_m_a_ext_via_nand_m_a_ext_via2_nand_m_a_stub_tg_d_b_tg_d_b_via_tg_d_b_via2_tg_fbm_b_tg_fbm_b_alt_via_tg_fbm_b_alt_via2_dup5_t5 r0 *1 0,0
Ra_b_m_east_m_west_nand_m_a_nand_m_a_ext_via_nand_m_a_ext_via2_nand_m_a_stub_tg_d_b_tg_d_b_via_tg_d_b_via2_tg_fbm_b_tg_fbm_b_alt_via_tg_fbm_b_alt_via2_dup5_t5
+ a|b|m_east|m_west|nand_m_a|nand_m_a_ext_via|nand_m_a_ext_via2|nand_m_a_stub|tg_d_b|tg_d_b_via|tg_d_b_via2|tg_fbm_b|tg_fbm_b_alt_via|tg_fbm_b_alt_via2__t56
+ a|b|m_east|m_west|nand_m_a|nand_m_a_ext_via|nand_m_a_ext_via2|nand_m_a_stub|tg_d_b|tg_d_b_via|tg_d_b_via2|tg_fbm_b|tg_fbm_b_alt_via|tg_fbm_b_alt_via2$5
+ 54.9450724763
* device instance a_b_m_east_m_west_nand_m_a_nand_m_a_ext_via_nand_m_a_ext_via2_nand_m_a_stub_tg_d_b_tg_d_b_via_tg_d_b_via2_tg_fbm_b_tg_fbm_b_alt_via_tg_fbm_b_alt_via2_dup5 r0 *1 0,0
Ca_b_m_east_m_west_nand_m_a_nand_m_a_ext_via_nand_m_a_ext_via2_nand_m_a_stub_tg_d_b_tg_d_b_via_tg_d_b_via2_tg_fbm_b_tg_fbm_b_alt_via_tg_fbm_b_alt_via2_dup5
+ a|b|m_east|m_west|nand_m_a|nand_m_a_ext_via|nand_m_a_ext_via2|nand_m_a_stub|tg_d_b|tg_d_b_via|tg_d_b_via2|tg_fbm_b|tg_fbm_b_alt_via|tg_fbm_b_alt_via2$5
+ vsubs 3.815311e-15
* device instance a_d_inva_a_mn12_g0_mp13_g0_ro1_ro1_esc_sr1_d_stub_tg_d_a_y_t0 r0 *1 0,0
Ra_d_inva_a_mn12_g0_mp13_g0_ro1_ro1_esc_sr1_d_stub_tg_d_a_y_t0
+ a|d|inva_a|mn12_g0|mp13_g0|ro1|ro1_esc|sr1_d_stub|tg_d_a|y__t0
+ a|d|inva_a|mn12_g0|mp13_g0|ro1|ro1_esc|sr1_d_stub|tg_d_a|y 203.930270332
* device instance a_d_inva_a_mn12_g0_mp13_g0_ro1_ro1_esc_sr1_d_stub_tg_d_a_y_t1 r0 *1 0,0
Ra_d_inva_a_mn12_g0_mp13_g0_ro1_ro1_esc_sr1_d_stub_tg_d_a_y_t1
+ a|d|inva_a|mn12_g0|mp13_g0|ro1|ro1_esc|sr1_d_stub|tg_d_a|y__t1
+ a|d|inva_a|mn12_g0|mp13_g0|ro1|ro1_esc|sr1_d_stub|tg_d_a|y 29.5063859798
* device instance a_d_inva_a_mn12_g0_mp13_g0_ro1_ro1_esc_sr1_d_stub_tg_d_a_y_t2 r0 *1 0,0
Ra_d_inva_a_mn12_g0_mp13_g0_ro1_ro1_esc_sr1_d_stub_tg_d_a_y_t2
+ a|d|inva_a|mn12_g0|mp13_g0|ro1|ro1_esc|sr1_d_stub|tg_d_a|y__t2
+ a|d|inva_a|mn12_g0|mp13_g0|ro1|ro1_esc|sr1_d_stub|tg_d_a|y 367.101929822
* device instance a_d_inva_a_mn12_g0_mp13_g0_ro1_ro1_esc_sr1_d_stub_tg_d_a_y_t3 r0 *1 0,0
Ra_d_inva_a_mn12_g0_mp13_g0_ro1_ro1_esc_sr1_d_stub_tg_d_a_y_t3
+ a|d|inva_a|mn12_g0|mp13_g0|ro1|ro1_esc|sr1_d_stub|tg_d_a|y__t3
+ a|d|inva_a|mn12_g0|mp13_g0|ro1|ro1_esc|sr1_d_stub|tg_d_a|y 19.7379773081
* device instance a_d_inva_a_mn12_g0_mp13_g0_ro1_ro1_esc_sr1_d_stub_tg_d_a_y_t4 r0 *1 0,0
Ra_d_inva_a_mn12_g0_mp13_g0_ro1_ro1_esc_sr1_d_stub_tg_d_a_y_t4
+ a|d|inva_a|mn12_g0|mp13_g0|ro1|ro1_esc|sr1_d_stub|tg_d_a|y__t4
+ a|d|inva_a|mn12_g0|mp13_g0|ro1|ro1_esc|sr1_d_stub|tg_d_a|y 361.556234155
* device instance a_d_inva_a_mn12_g0_mp13_g0_ro1_ro1_esc_sr1_d_stub_tg_d_a_y_t5 r0 *1 0,0
Ra_d_inva_a_mn12_g0_mp13_g0_ro1_ro1_esc_sr1_d_stub_tg_d_a_y_t5
+ a|d|inva_a|mn12_g0|mp13_g0|ro1|ro1_esc|sr1_d_stub|tg_d_a|y__t5
+ a|d|inva_a|mn12_g0|mp13_g0|ro1|ro1_esc|sr1_d_stub|tg_d_a|y 207.194872448
* device instance a_d_inva_a_mn12_g0_mp13_g0_ro1_ro1_esc_sr1_d_stub_tg_d_a_y_t6 r0 *1 0,0
Ra_d_inva_a_mn12_g0_mp13_g0_ro1_ro1_esc_sr1_d_stub_tg_d_a_y_t6
+ a|d|inva_a|mn12_g0|mp13_g0|ro1|ro1_esc|sr1_d_stub|tg_d_a|y__t6
+ a|d|inva_a|mn12_g0|mp13_g0|ro1|ro1_esc|sr1_d_stub|tg_d_a|y 212.400276086
* device instance a_d_inva_a_mn12_g0_mp13_g0_ro1_ro1_esc_sr1_d_stub_tg_d_a_y_t7 r0 *1 0,0
Ra_d_inva_a_mn12_g0_mp13_g0_ro1_ro1_esc_sr1_d_stub_tg_d_a_y_t7
+ a|d|inva_a|mn12_g0|mp13_g0|ro1|ro1_esc|sr1_d_stub|tg_d_a|y__t7
+ a|d|inva_a|mn12_g0|mp13_g0|ro1|ro1_esc|sr1_d_stub|tg_d_a|y 152.44815387
* device instance a_d_inva_a_mn12_g0_mp13_g0_ro1_ro1_esc_sr1_d_stub_tg_d_a_y r0 *1 0,0
Ca_d_inva_a_mn12_g0_mp13_g0_ro1_ro1_esc_sr1_d_stub_tg_d_a_y
+ a|d|inva_a|mn12_g0|mp13_g0|ro1|ro1_esc|sr1_d_stub|tg_d_a|y vsubs 2.4036736e-14
* device instance a_d_inva_a_mn12_g0_mp13_g0_ro3_ro3_esc_e_ro3_esc_w_ro3_hop_sr3_d_stub_tg_d_a_y_t0 r0 *1 0,0
Ra_d_inva_a_mn12_g0_mp13_g0_ro3_ro3_esc_e_ro3_esc_w_ro3_hop_sr3_d_stub_tg_d_a_y_t0
+ a|d|inva_a|mn12_g0|mp13_g0|ro3|ro3_esc_e|ro3_esc_w|ro3_hop|sr3_d_stub|tg_d_a|y__t0
+ a|d|inva_a|mn12_g0|mp13_g0|ro3|ro3_esc_e|ro3_esc_w|ro3_hop|sr3_d_stub|tg_d_a|y
+ 216.863594477
* device instance a_d_inva_a_mn12_g0_mp13_g0_ro3_ro3_esc_e_ro3_esc_w_ro3_hop_sr3_d_stub_tg_d_a_y_t1 r0 *1 0,0
Ra_d_inva_a_mn12_g0_mp13_g0_ro3_ro3_esc_e_ro3_esc_w_ro3_hop_sr3_d_stub_tg_d_a_y_t1
+ a|d|inva_a|mn12_g0|mp13_g0|ro3|ro3_esc_e|ro3_esc_w|ro3_hop|sr3_d_stub|tg_d_a|y__t1
+ a|d|inva_a|mn12_g0|mp13_g0|ro3|ro3_esc_e|ro3_esc_w|ro3_hop|sr3_d_stub|tg_d_a|y
+ 311.131159709
* device instance a_d_inva_a_mn12_g0_mp13_g0_ro3_ro3_esc_e_ro3_esc_w_ro3_hop_sr3_d_stub_tg_d_a_y_t2 r0 *1 0,0
Ra_d_inva_a_mn12_g0_mp13_g0_ro3_ro3_esc_e_ro3_esc_w_ro3_hop_sr3_d_stub_tg_d_a_y_t2
+ a|d|inva_a|mn12_g0|mp13_g0|ro3|ro3_esc_e|ro3_esc_w|ro3_hop|sr3_d_stub|tg_d_a|y__t2
+ a|d|inva_a|mn12_g0|mp13_g0|ro3|ro3_esc_e|ro3_esc_w|ro3_hop|sr3_d_stub|tg_d_a|y
+ 119.497189701
* device instance a_d_inva_a_mn12_g0_mp13_g0_ro3_ro3_esc_e_ro3_esc_w_ro3_hop_sr3_d_stub_tg_d_a_y_t3 r0 *1 0,0
Ra_d_inva_a_mn12_g0_mp13_g0_ro3_ro3_esc_e_ro3_esc_w_ro3_hop_sr3_d_stub_tg_d_a_y_t3
+ a|d|inva_a|mn12_g0|mp13_g0|ro3|ro3_esc_e|ro3_esc_w|ro3_hop|sr3_d_stub|tg_d_a|y__t3
+ a|d|inva_a|mn12_g0|mp13_g0|ro3|ro3_esc_e|ro3_esc_w|ro3_hop|sr3_d_stub|tg_d_a|y
+ 118.862759007
* device instance a_d_inva_a_mn12_g0_mp13_g0_ro3_ro3_esc_e_ro3_esc_w_ro3_hop_sr3_d_stub_tg_d_a_y_t4 r0 *1 0,0
Ra_d_inva_a_mn12_g0_mp13_g0_ro3_ro3_esc_e_ro3_esc_w_ro3_hop_sr3_d_stub_tg_d_a_y_t4
+ a|d|inva_a|mn12_g0|mp13_g0|ro3|ro3_esc_e|ro3_esc_w|ro3_hop|sr3_d_stub|tg_d_a|y__t4
+ a|d|inva_a|mn12_g0|mp13_g0|ro3|ro3_esc_e|ro3_esc_w|ro3_hop|sr3_d_stub|tg_d_a|y
+ 309.082945607
* device instance a_d_inva_a_mn12_g0_mp13_g0_ro3_ro3_esc_e_ro3_esc_w_ro3_hop_sr3_d_stub_tg_d_a_y_t5 r0 *1 0,0
Ra_d_inva_a_mn12_g0_mp13_g0_ro3_ro3_esc_e_ro3_esc_w_ro3_hop_sr3_d_stub_tg_d_a_y_t5
+ a|d|inva_a|mn12_g0|mp13_g0|ro3|ro3_esc_e|ro3_esc_w|ro3_hop|sr3_d_stub|tg_d_a|y__t5
+ a|d|inva_a|mn12_g0|mp13_g0|ro3|ro3_esc_e|ro3_esc_w|ro3_hop|sr3_d_stub|tg_d_a|y
+ 223.118022039
* device instance a_d_inva_a_mn12_g0_mp13_g0_ro3_ro3_esc_e_ro3_esc_w_ro3_hop_sr3_d_stub_tg_d_a_y_t6 r0 *1 0,0
Ra_d_inva_a_mn12_g0_mp13_g0_ro3_ro3_esc_e_ro3_esc_w_ro3_hop_sr3_d_stub_tg_d_a_y_t6
+ a|d|inva_a|mn12_g0|mp13_g0|ro3|ro3_esc_e|ro3_esc_w|ro3_hop|sr3_d_stub|tg_d_a|y__t6
+ a|d|inva_a|mn12_g0|mp13_g0|ro3|ro3_esc_e|ro3_esc_w|ro3_hop|sr3_d_stub|tg_d_a|y
+ 224.651464544
* device instance a_d_inva_a_mn12_g0_mp13_g0_ro3_ro3_esc_e_ro3_esc_w_ro3_hop_sr3_d_stub_tg_d_a_y_t7 r0 *1 0,0
Ra_d_inva_a_mn12_g0_mp13_g0_ro3_ro3_esc_e_ro3_esc_w_ro3_hop_sr3_d_stub_tg_d_a_y_t7
+ a|d|inva_a|mn12_g0|mp13_g0|ro3|ro3_esc_e|ro3_esc_w|ro3_hop|sr3_d_stub|tg_d_a|y__t7
+ a|d|inva_a|mn12_g0|mp13_g0|ro3|ro3_esc_e|ro3_esc_w|ro3_hop|sr3_d_stub|tg_d_a|y
+ 192.262264916
* device instance a_d_inva_a_mn12_g0_mp13_g0_ro3_ro3_esc_e_ro3_esc_w_ro3_hop_sr3_d_stub_tg_d_a_y r0 *1 0,0
Ca_d_inva_a_mn12_g0_mp13_g0_ro3_ro3_esc_e_ro3_esc_w_ro3_hop_sr3_d_stub_tg_d_a_y
+ a|d|inva_a|mn12_g0|mp13_g0|ro3|ro3_esc_e|ro3_esc_w|ro3_hop|sr3_d_stub|tg_d_a|y
+ vsubs 4.2078303e-14
* device instance a_d_sb_d_stub_tg_d_a_xo_xo_dip_xo_hop_xo_stub_y_t0 r0 *1 0,0
Ra_d_sb_d_stub_tg_d_a_xo_xo_dip_xo_hop_xo_stub_y_t0
+ a|d|sb_d_stub|tg_d_a|xo|xo_dip|xo_hop|xo_stub|y__t0
+ a|d|sb_d_stub|tg_d_a|xo|xo_dip|xo_hop|xo_stub|y 307.790416322
* device instance a_d_sb_d_stub_tg_d_a_xo_xo_dip_xo_hop_xo_stub_y_t1 r0 *1 0,0
Ra_d_sb_d_stub_tg_d_a_xo_xo_dip_xo_hop_xo_stub_y_t1
+ a|d|sb_d_stub|tg_d_a|xo|xo_dip|xo_hop|xo_stub|y__t1
+ a|d|sb_d_stub|tg_d_a|xo|xo_dip|xo_hop|xo_stub|y 364.058398999
* device instance a_d_sb_d_stub_tg_d_a_xo_xo_dip_xo_hop_xo_stub_y_t2 r0 *1 0,0
Ra_d_sb_d_stub_tg_d_a_xo_xo_dip_xo_hop_xo_stub_y_t2
+ a|d|sb_d_stub|tg_d_a|xo|xo_dip|xo_hop|xo_stub|y__t2
+ a|d|sb_d_stub|tg_d_a|xo|xo_dip|xo_hop|xo_stub|y 608.652030264
* device instance a_d_sb_d_stub_tg_d_a_xo_xo_dip_xo_hop_xo_stub_y_t3 r0 *1 0,0
Ra_d_sb_d_stub_tg_d_a_xo_xo_dip_xo_hop_xo_stub_y_t3
+ a|d|sb_d_stub|tg_d_a|xo|xo_dip|xo_hop|xo_stub|y__t3
+ a|d|sb_d_stub|tg_d_a|xo|xo_dip|xo_hop|xo_stub|y 587.22764335
* device instance a_d_sb_d_stub_tg_d_a_xo_xo_dip_xo_hop_xo_stub_y_t4 r0 *1 0,0
Ra_d_sb_d_stub_tg_d_a_xo_xo_dip_xo_hop_xo_stub_y_t4
+ a|d|sb_d_stub|tg_d_a|xo|xo_dip|xo_hop|xo_stub|y__t4
+ a|d|sb_d_stub|tg_d_a|xo|xo_dip|xo_hop|xo_stub|y 308.710311397
* device instance a_d_sb_d_stub_tg_d_a_xo_xo_dip_xo_hop_xo_stub_y_t5 r0 *1 0,0
Ra_d_sb_d_stub_tg_d_a_xo_xo_dip_xo_hop_xo_stub_y_t5
+ a|d|sb_d_stub|tg_d_a|xo|xo_dip|xo_hop|xo_stub|y__t5
+ a|d|sb_d_stub|tg_d_a|xo|xo_dip|xo_hop|xo_stub|y 233.622899669
* device instance a_d_sb_d_stub_tg_d_a_xo_xo_dip_xo_hop_xo_stub_y r0 *1 0,0
Ca_d_sb_d_stub_tg_d_a_xo_xo_dip_xo_hop_xo_stub_y
+ a|d|sb_d_stub|tg_d_a|xo|xo_dip|xo_hop|xo_stub|y vsubs 1.4282284e-14
* device instance a_g_a_rn1_ro_s4_y_y_t0 r0 *1 0,0
Ra_g_a_rn1_ro_s4_y_y_t0 a|g_a|rn1|ro|s4_y|y__t0 a|g_a|rn1|ro|s4_y|y
+ 91.0773794482
* device instance a_g_a_rn1_ro_s4_y_y_t1 r0 *1 0,0
Ra_g_a_rn1_ro_s4_y_y_t1 a|g_a|rn1|ro|s4_y|y__t1 a|g_a|rn1|ro|s4_y|y
+ 89.0742914481
* device instance a_g_a_rn1_ro_s4_y_y_t2 r0 *1 0,0
Ra_g_a_rn1_ro_s4_y_y_t2 a|g_a|rn1|ro|s4_y|y__t2 a|g_a|rn1|ro|s4_y|y 190.86668654
* device instance a_g_a_rn1_ro_s4_y_y_t3 r0 *1 0,0
Ra_g_a_rn1_ro_s4_y_y_t3 a|g_a|rn1|ro|s4_y|y__t3 a|g_a|rn1|ro|s4_y|y
+ 190.715682399
* device instance a_g_a_rn1_ro_s4_y_y_t4 r0 *1 0,0
Ra_g_a_rn1_ro_s4_y_y_t4 a|g_a|rn1|ro|s4_y|y__t4 a|g_a|rn1|ro|s4_y|y
+ 276.185998913
* device instance a_g_a_rn1_ro_s4_y_y_t5 r0 *1 0,0
Ra_g_a_rn1_ro_s4_y_y_t5 a|g_a|rn1|ro|s4_y|y__t5 a|g_a|rn1|ro|s4_y|y
+ 280.795661251
* device instance a_g_a_rn1_ro_s4_y_y r0 *1 0,0
Ca_g_a_rn1_ro_s4_y_y a|g_a|rn1|ro|s4_y|y vsubs 6.402999e-15
* device instance a_g_a_rn2_ro_s4_y_y_t0 r0 *1 0,0
Ra_g_a_rn2_ro_s4_y_y_t0 a|g_a|rn2|ro|s4_y|y__t0 a|g_a|rn2|ro|s4_y|y
+ 91.0773794482
* device instance a_g_a_rn2_ro_s4_y_y_t1 r0 *1 0,0
Ra_g_a_rn2_ro_s4_y_y_t1 a|g_a|rn2|ro|s4_y|y__t1 a|g_a|rn2|ro|s4_y|y
+ 89.0742914481
* device instance a_g_a_rn2_ro_s4_y_y_t2 r0 *1 0,0
Ra_g_a_rn2_ro_s4_y_y_t2 a|g_a|rn2|ro|s4_y|y__t2 a|g_a|rn2|ro|s4_y|y 190.86668654
* device instance a_g_a_rn2_ro_s4_y_y_t3 r0 *1 0,0
Ra_g_a_rn2_ro_s4_y_y_t3 a|g_a|rn2|ro|s4_y|y__t3 a|g_a|rn2|ro|s4_y|y
+ 190.715682399
* device instance a_g_a_rn2_ro_s4_y_y_t4 r0 *1 0,0
Ra_g_a_rn2_ro_s4_y_y_t4 a|g_a|rn2|ro|s4_y|y__t4 a|g_a|rn2|ro|s4_y|y
+ 276.185998913
* device instance a_g_a_rn2_ro_s4_y_y_t5 r0 *1 0,0
Ra_g_a_rn2_ro_s4_y_y_t5 a|g_a|rn2|ro|s4_y|y__t5 a|g_a|rn2|ro|s4_y|y
+ 280.795661251
* device instance a_g_a_rn2_ro_s4_y_y r0 *1 0,0
Ca_g_a_rn2_ro_s4_y_y a|g_a|rn2|ro|s4_y|y vsubs 6.402999e-15
* device instance a_g_a_rn3_ro_s4_y_y_t0 r0 *1 0,0
Ra_g_a_rn3_ro_s4_y_y_t0 a|g_a|rn3|ro|s4_y|y__t0 a|g_a|rn3|ro|s4_y|y
+ 91.0773794482
* device instance a_g_a_rn3_ro_s4_y_y_t1 r0 *1 0,0
Ra_g_a_rn3_ro_s4_y_y_t1 a|g_a|rn3|ro|s4_y|y__t1 a|g_a|rn3|ro|s4_y|y
+ 89.0742914481
* device instance a_g_a_rn3_ro_s4_y_y_t2 r0 *1 0,0
Ra_g_a_rn3_ro_s4_y_y_t2 a|g_a|rn3|ro|s4_y|y__t2 a|g_a|rn3|ro|s4_y|y 190.86668654
* device instance a_g_a_rn3_ro_s4_y_y_t3 r0 *1 0,0
Ra_g_a_rn3_ro_s4_y_y_t3 a|g_a|rn3|ro|s4_y|y__t3 a|g_a|rn3|ro|s4_y|y
+ 276.185998913
* device instance a_g_a_rn3_ro_s4_y_y_t4 r0 *1 0,0
Ra_g_a_rn3_ro_s4_y_y_t4 a|g_a|rn3|ro|s4_y|y__t4 a|g_a|rn3|ro|s4_y|y
+ 190.715682399
* device instance a_g_a_rn3_ro_s4_y_y_t5 r0 *1 0,0
Ra_g_a_rn3_ro_s4_y_y_t5 a|g_a|rn3|ro|s4_y|y__t5 a|g_a|rn3|ro|s4_y|y
+ 280.795661251
* device instance a_g_a_rn3_ro_s4_y_y r0 *1 0,0
Ca_g_a_rn3_ro_s4_y_y a|g_a|rn3|ro|s4_y|y vsubs 6.402999e-15
* device instance a_g_a_rn4_ro_s4_y_y_t0 r0 *1 0,0
Ra_g_a_rn4_ro_s4_y_y_t0 a|g_a|rn4|ro|s4_y|y__t0 a|g_a|rn4|ro|s4_y|y
+ 91.0773794482
* device instance a_g_a_rn4_ro_s4_y_y_t1 r0 *1 0,0
Ra_g_a_rn4_ro_s4_y_y_t1 a|g_a|rn4|ro|s4_y|y__t1 a|g_a|rn4|ro|s4_y|y
+ 89.0742914481
* device instance a_g_a_rn4_ro_s4_y_y_t2 r0 *1 0,0
Ra_g_a_rn4_ro_s4_y_y_t2 a|g_a|rn4|ro|s4_y|y__t2 a|g_a|rn4|ro|s4_y|y 190.86668654
* device instance a_g_a_rn4_ro_s4_y_y_t3 r0 *1 0,0
Ra_g_a_rn4_ro_s4_y_y_t3 a|g_a|rn4|ro|s4_y|y__t3 a|g_a|rn4|ro|s4_y|y
+ 276.185998913
* device instance a_g_a_rn4_ro_s4_y_y_t4 r0 *1 0,0
Ra_g_a_rn4_ro_s4_y_y_t4 a|g_a|rn4|ro|s4_y|y__t4 a|g_a|rn4|ro|s4_y|y
+ 190.715682399
* device instance a_g_a_rn4_ro_s4_y_y_t5 r0 *1 0,0
Ra_g_a_rn4_ro_s4_y_y_t5 a|g_a|rn4|ro|s4_y|y__t5 a|g_a|rn4|ro|s4_y|y
+ 280.795661251
* device instance a_g_a_rn4_ro_s4_y_y r0 *1 0,0
Ca_g_a_rn4_ro_s4_y_y a|g_a|rn4|ro|s4_y|y vsubs 6.399383e-15
* device instance a_g_y_mnab_y_mpa_y_mpb_y_n1_s1_a_y_t0 r0 *1 0,0
Ra_g_y_mnab_y_mpa_y_mpb_y_n1_s1_a_y_t0 a|g_y|mnab_y|mpa_y|mpb_y|n1|s1_a|y__t0
+ a|g_y|mnab_y|mpa_y|mpb_y|n1|s1_a|y 83.1989635875
* device instance a_g_y_mnab_y_mpa_y_mpb_y_n1_s1_a_y_t1 r0 *1 0,0
Ra_g_y_mnab_y_mpa_y_mpb_y_n1_s1_a_y_t1 a|g_y|mnab_y|mpa_y|mpb_y|n1|s1_a|y__t1
+ a|g_y|mnab_y|mpa_y|mpb_y|n1|s1_a|y 107.491339147
* device instance a_g_y_mnab_y_mpa_y_mpb_y_n1_s1_a_y_t2 r0 *1 0,0
Ra_g_y_mnab_y_mpa_y_mpb_y_n1_s1_a_y_t2 a|g_y|mnab_y|mpa_y|mpb_y|n1|s1_a|y__t2
+ a|g_y|mnab_y|mpa_y|mpb_y|n1|s1_a|y 99.6782748034
* device instance a_g_y_mnab_y_mpa_y_mpb_y_n1_s1_a_y_t3 r0 *1 0,0
Ra_g_y_mnab_y_mpa_y_mpb_y_n1_s1_a_y_t3 a|g_y|mnab_y|mpa_y|mpb_y|n1|s1_a|y__t3
+ a|g_y|mnab_y|mpa_y|mpb_y|n1|s1_a|y 60.7011664601
* device instance a_g_y_mnab_y_mpa_y_mpb_y_n1_s1_a_y_t4 r0 *1 0,0
Ra_g_y_mnab_y_mpa_y_mpb_y_n1_s1_a_y_t4 a|g_y|mnab_y|mpa_y|mpb_y|n1|s1_a|y__t4
+ a|g_y|mnab_y|mpa_y|mpb_y|n1|s1_a|y 74.101756002
* device instance a_g_y_mnab_y_mpa_y_mpb_y_n1_s1_a_y r0 *1 0,0
Ca_g_y_mnab_y_mpa_y_mpb_y_n1_s1_a_y a|g_y|mnab_y|mpa_y|mpb_y|n1|s1_a|y vsubs
+ 2.632209e-15
* device instance a_g_y_mnab_y_mpa_y_mpb_y_n1_s1_a_y_dup1_t0 r0 *1 0,0
Ra_g_y_mnab_y_mpa_y_mpb_y_n1_s1_a_y_dup1_t0
+ a|g_y|mnab_y|mpa_y|mpb_y|n1|s1_a|y__t02 a|g_y|mnab_y|mpa_y|mpb_y|n1|s1_a|y$1
+ 83.1989635875
* device instance a_g_y_mnab_y_mpa_y_mpb_y_n1_s1_a_y_dup1_t1 r0 *1 0,0
Ra_g_y_mnab_y_mpa_y_mpb_y_n1_s1_a_y_dup1_t1
+ a|g_y|mnab_y|mpa_y|mpb_y|n1|s1_a|y__t12 a|g_y|mnab_y|mpa_y|mpb_y|n1|s1_a|y$1
+ 107.491339147
* device instance a_g_y_mnab_y_mpa_y_mpb_y_n1_s1_a_y_dup1_t2 r0 *1 0,0
Ra_g_y_mnab_y_mpa_y_mpb_y_n1_s1_a_y_dup1_t2
+ a|g_y|mnab_y|mpa_y|mpb_y|n1|s1_a|y__t22 a|g_y|mnab_y|mpa_y|mpb_y|n1|s1_a|y$1
+ 99.6782748034
* device instance a_g_y_mnab_y_mpa_y_mpb_y_n1_s1_a_y_dup1_t3 r0 *1 0,0
Ra_g_y_mnab_y_mpa_y_mpb_y_n1_s1_a_y_dup1_t3
+ a|g_y|mnab_y|mpa_y|mpb_y|n1|s1_a|y__t32 a|g_y|mnab_y|mpa_y|mpb_y|n1|s1_a|y$1
+ 60.7011664601
* device instance a_g_y_mnab_y_mpa_y_mpb_y_n1_s1_a_y_dup1_t4 r0 *1 0,0
Ra_g_y_mnab_y_mpa_y_mpb_y_n1_s1_a_y_dup1_t4
+ a|g_y|mnab_y|mpa_y|mpb_y|n1|s1_a|y__t42 a|g_y|mnab_y|mpa_y|mpb_y|n1|s1_a|y$1
+ 74.101756002
* device instance a_g_y_mnab_y_mpa_y_mpb_y_n1_s1_a_y_dup1 r0 *1 0,0
Ca_g_y_mnab_y_mpa_y_mpb_y_n1_s1_a_y_dup1 a|g_y|mnab_y|mpa_y|mpb_y|n1|s1_a|y$1
+ vsubs 2.632209e-15
* device instance a_g_y_mnab_y_mpa_y_mpb_y_n1_s1_a_y_dup2_t0 r0 *1 0,0
Ra_g_y_mnab_y_mpa_y_mpb_y_n1_s1_a_y_dup2_t0
+ a|g_y|mnab_y|mpa_y|mpb_y|n1|s1_a|y__t03 a|g_y|mnab_y|mpa_y|mpb_y|n1|s1_a|y$2
+ 83.1989635875
* device instance a_g_y_mnab_y_mpa_y_mpb_y_n1_s1_a_y_dup2_t1 r0 *1 0,0
Ra_g_y_mnab_y_mpa_y_mpb_y_n1_s1_a_y_dup2_t1
+ a|g_y|mnab_y|mpa_y|mpb_y|n1|s1_a|y__t13 a|g_y|mnab_y|mpa_y|mpb_y|n1|s1_a|y$2
+ 107.491339147
* device instance a_g_y_mnab_y_mpa_y_mpb_y_n1_s1_a_y_dup2_t2 r0 *1 0,0
Ra_g_y_mnab_y_mpa_y_mpb_y_n1_s1_a_y_dup2_t2
+ a|g_y|mnab_y|mpa_y|mpb_y|n1|s1_a|y__t23 a|g_y|mnab_y|mpa_y|mpb_y|n1|s1_a|y$2
+ 99.6782748034
* device instance a_g_y_mnab_y_mpa_y_mpb_y_n1_s1_a_y_dup2_t3 r0 *1 0,0
Ra_g_y_mnab_y_mpa_y_mpb_y_n1_s1_a_y_dup2_t3
+ a|g_y|mnab_y|mpa_y|mpb_y|n1|s1_a|y__t33 a|g_y|mnab_y|mpa_y|mpb_y|n1|s1_a|y$2
+ 60.7011664601
* device instance a_g_y_mnab_y_mpa_y_mpb_y_n1_s1_a_y_dup2_t4 r0 *1 0,0
Ra_g_y_mnab_y_mpa_y_mpb_y_n1_s1_a_y_dup2_t4
+ a|g_y|mnab_y|mpa_y|mpb_y|n1|s1_a|y__t43 a|g_y|mnab_y|mpa_y|mpb_y|n1|s1_a|y$2
+ 74.101756002
* device instance a_g_y_mnab_y_mpa_y_mpb_y_n1_s1_a_y_dup2 r0 *1 0,0
Ca_g_y_mnab_y_mpa_y_mpb_y_n1_s1_a_y_dup2 a|g_y|mnab_y|mpa_y|mpb_y|n1|s1_a|y$2
+ vsubs 2.632209e-15
* device instance a_g_y_mnab_y_mpa_y_mpb_y_n1_s1_a_y_dup3_t0 r0 *1 0,0
Ra_g_y_mnab_y_mpa_y_mpb_y_n1_s1_a_y_dup3_t0
+ a|g_y|mnab_y|mpa_y|mpb_y|n1|s1_a|y__t04 a|g_y|mnab_y|mpa_y|mpb_y|n1|s1_a|y$3
+ 83.1989635875
* device instance a_g_y_mnab_y_mpa_y_mpb_y_n1_s1_a_y_dup3_t1 r0 *1 0,0
Ra_g_y_mnab_y_mpa_y_mpb_y_n1_s1_a_y_dup3_t1
+ a|g_y|mnab_y|mpa_y|mpb_y|n1|s1_a|y__t14 a|g_y|mnab_y|mpa_y|mpb_y|n1|s1_a|y$3
+ 107.491339147
* device instance a_g_y_mnab_y_mpa_y_mpb_y_n1_s1_a_y_dup3_t2 r0 *1 0,0
Ra_g_y_mnab_y_mpa_y_mpb_y_n1_s1_a_y_dup3_t2
+ a|g_y|mnab_y|mpa_y|mpb_y|n1|s1_a|y__t24 a|g_y|mnab_y|mpa_y|mpb_y|n1|s1_a|y$3
+ 99.6782748034
* device instance a_g_y_mnab_y_mpa_y_mpb_y_n1_s1_a_y_dup3_t3 r0 *1 0,0
Ra_g_y_mnab_y_mpa_y_mpb_y_n1_s1_a_y_dup3_t3
+ a|g_y|mnab_y|mpa_y|mpb_y|n1|s1_a|y__t34 a|g_y|mnab_y|mpa_y|mpb_y|n1|s1_a|y$3
+ 60.7011664601
* device instance a_g_y_mnab_y_mpa_y_mpb_y_n1_s1_a_y_dup3_t4 r0 *1 0,0
Ra_g_y_mnab_y_mpa_y_mpb_y_n1_s1_a_y_dup3_t4
+ a|g_y|mnab_y|mpa_y|mpb_y|n1|s1_a|y__t44 a|g_y|mnab_y|mpa_y|mpb_y|n1|s1_a|y$3
+ 74.101756002
* device instance a_g_y_mnab_y_mpa_y_mpb_y_n1_s1_a_y_dup3 r0 *1 0,0
Ca_g_y_mnab_y_mpa_y_mpb_y_n1_s1_a_y_dup3 a|g_y|mnab_y|mpa_y|mpb_y|n1|s1_a|y$3
+ vsubs 2.632209e-15
* device instance a_inv_mc_a_mb_mnab_y_mpa_y_mpb_y_nand_m_y_tg_s_a_y_t0 r0 *1 0,0
Ra_inv_mc_a_mb_mnab_y_mpa_y_mpb_y_nand_m_y_tg_s_a_y_t0
+ a|inv_mc_a|mb|mnab_y|mpa_y|mpb_y|nand_m_y|tg_s_a|y__t0
+ a|inv_mc_a|mb|mnab_y|mpa_y|mpb_y|nand_m_y|tg_s_a|y 128.808394178
* device instance a_inv_mc_a_mb_mnab_y_mpa_y_mpb_y_nand_m_y_tg_s_a_y_t1 r0 *1 0,0
Ra_inv_mc_a_mb_mnab_y_mpa_y_mpb_y_nand_m_y_tg_s_a_y_t1
+ a|inv_mc_a|mb|mnab_y|mpa_y|mpb_y|nand_m_y|tg_s_a|y__t1
+ a|inv_mc_a|mb|mnab_y|mpa_y|mpb_y|nand_m_y|tg_s_a|y 189.921079219
* device instance a_inv_mc_a_mb_mnab_y_mpa_y_mpb_y_nand_m_y_tg_s_a_y_t2 r0 *1 0,0
Ra_inv_mc_a_mb_mnab_y_mpa_y_mpb_y_nand_m_y_tg_s_a_y_t2
+ a|inv_mc_a|mb|mnab_y|mpa_y|mpb_y|nand_m_y|tg_s_a|y__t2
+ a|inv_mc_a|mb|mnab_y|mpa_y|mpb_y|nand_m_y|tg_s_a|y 188.133983991
* device instance a_inv_mc_a_mb_mnab_y_mpa_y_mpb_y_nand_m_y_tg_s_a_y_t3 r0 *1 0,0
Ra_inv_mc_a_mb_mnab_y_mpa_y_mpb_y_nand_m_y_tg_s_a_y_t3
+ a|inv_mc_a|mb|mnab_y|mpa_y|mpb_y|nand_m_y|tg_s_a|y__t3
+ a|inv_mc_a|mb|mnab_y|mpa_y|mpb_y|nand_m_y|tg_s_a|y 142.710836615
* device instance a_inv_mc_a_mb_mnab_y_mpa_y_mpb_y_nand_m_y_tg_s_a_y_t4 r0 *1 0,0
Ra_inv_mc_a_mb_mnab_y_mpa_y_mpb_y_nand_m_y_tg_s_a_y_t4
+ a|inv_mc_a|mb|mnab_y|mpa_y|mpb_y|nand_m_y|tg_s_a|y__t4
+ a|inv_mc_a|mb|mnab_y|mpa_y|mpb_y|nand_m_y|tg_s_a|y 36.3529298905
* device instance a_inv_mc_a_mb_mnab_y_mpa_y_mpb_y_nand_m_y_tg_s_a_y_t5 r0 *1 0,0
Ra_inv_mc_a_mb_mnab_y_mpa_y_mpb_y_nand_m_y_tg_s_a_y_t5
+ a|inv_mc_a|mb|mnab_y|mpa_y|mpb_y|nand_m_y|tg_s_a|y__t5
+ a|inv_mc_a|mb|mnab_y|mpa_y|mpb_y|nand_m_y|tg_s_a|y 25.4148600674
* device instance a_inv_mc_a_mb_mnab_y_mpa_y_mpb_y_nand_m_y_tg_s_a_y_t6 r0 *1 0,0
Ra_inv_mc_a_mb_mnab_y_mpa_y_mpb_y_nand_m_y_tg_s_a_y_t6
+ a|inv_mc_a|mb|mnab_y|mpa_y|mpb_y|nand_m_y|tg_s_a|y__t6
+ a|inv_mc_a|mb|mnab_y|mpa_y|mpb_y|nand_m_y|tg_s_a|y 119.440616038
* device instance a_inv_mc_a_mb_mnab_y_mpa_y_mpb_y_nand_m_y_tg_s_a_y r0 *1 0,0
Ca_inv_mc_a_mb_mnab_y_mpa_y_mpb_y_nand_m_y_tg_s_a_y
+ a|inv_mc_a|mb|mnab_y|mpa_y|mpb_y|nand_m_y|tg_s_a|y vsubs 4.01273e-15
* device instance a_inv_mc_a_mb_mnab_y_mpa_y_mpb_y_nand_m_y_tg_s_a_y_dup1_t0 r0 *1 0,0
Ra_inv_mc_a_mb_mnab_y_mpa_y_mpb_y_nand_m_y_tg_s_a_y_dup1_t0
+ a|inv_mc_a|mb|mnab_y|mpa_y|mpb_y|nand_m_y|tg_s_a|y__t02
+ a|inv_mc_a|mb|mnab_y|mpa_y|mpb_y|nand_m_y|tg_s_a|y$1 189.921079219
* device instance a_inv_mc_a_mb_mnab_y_mpa_y_mpb_y_nand_m_y_tg_s_a_y_dup1_t1 r0 *1 0,0
Ra_inv_mc_a_mb_mnab_y_mpa_y_mpb_y_nand_m_y_tg_s_a_y_dup1_t1
+ a|inv_mc_a|mb|mnab_y|mpa_y|mpb_y|nand_m_y|tg_s_a|y__t12
+ a|inv_mc_a|mb|mnab_y|mpa_y|mpb_y|nand_m_y|tg_s_a|y$1 188.133983991
* device instance a_inv_mc_a_mb_mnab_y_mpa_y_mpb_y_nand_m_y_tg_s_a_y_dup1_t2 r0 *1 0,0
Ra_inv_mc_a_mb_mnab_y_mpa_y_mpb_y_nand_m_y_tg_s_a_y_dup1_t2
+ a|inv_mc_a|mb|mnab_y|mpa_y|mpb_y|nand_m_y|tg_s_a|y__t22
+ a|inv_mc_a|mb|mnab_y|mpa_y|mpb_y|nand_m_y|tg_s_a|y$1 142.710836615
* device instance a_inv_mc_a_mb_mnab_y_mpa_y_mpb_y_nand_m_y_tg_s_a_y_dup1_t3 r0 *1 0,0
Ra_inv_mc_a_mb_mnab_y_mpa_y_mpb_y_nand_m_y_tg_s_a_y_dup1_t3
+ a|inv_mc_a|mb|mnab_y|mpa_y|mpb_y|nand_m_y|tg_s_a|y__t32
+ a|inv_mc_a|mb|mnab_y|mpa_y|mpb_y|nand_m_y|tg_s_a|y$1 36.3529298905
* device instance a_inv_mc_a_mb_mnab_y_mpa_y_mpb_y_nand_m_y_tg_s_a_y_dup1_t4 r0 *1 0,0
Ra_inv_mc_a_mb_mnab_y_mpa_y_mpb_y_nand_m_y_tg_s_a_y_dup1_t4
+ a|inv_mc_a|mb|mnab_y|mpa_y|mpb_y|nand_m_y|tg_s_a|y__t42
+ a|inv_mc_a|mb|mnab_y|mpa_y|mpb_y|nand_m_y|tg_s_a|y$1 25.4148600674
* device instance a_inv_mc_a_mb_mnab_y_mpa_y_mpb_y_nand_m_y_tg_s_a_y_dup1_t5 r0 *1 0,0
Ra_inv_mc_a_mb_mnab_y_mpa_y_mpb_y_nand_m_y_tg_s_a_y_dup1_t5
+ a|inv_mc_a|mb|mnab_y|mpa_y|mpb_y|nand_m_y|tg_s_a|y__t52
+ a|inv_mc_a|mb|mnab_y|mpa_y|mpb_y|nand_m_y|tg_s_a|y$1 119.440616038
* device instance a_inv_mc_a_mb_mnab_y_mpa_y_mpb_y_nand_m_y_tg_s_a_y_dup1_t6 r0 *1 0,0
Ra_inv_mc_a_mb_mnab_y_mpa_y_mpb_y_nand_m_y_tg_s_a_y_dup1_t6
+ a|inv_mc_a|mb|mnab_y|mpa_y|mpb_y|nand_m_y|tg_s_a|y__t62
+ a|inv_mc_a|mb|mnab_y|mpa_y|mpb_y|nand_m_y|tg_s_a|y$1 128.808394178
* device instance a_inv_mc_a_mb_mnab_y_mpa_y_mpb_y_nand_m_y_tg_s_a_y_dup1 r0 *1 0,0
Ca_inv_mc_a_mb_mnab_y_mpa_y_mpb_y_nand_m_y_tg_s_a_y_dup1
+ a|inv_mc_a|mb|mnab_y|mpa_y|mpb_y|nand_m_y|tg_s_a|y$1 vsubs 4.01273e-15
* device instance a_inv_mc_a_mb_mnab_y_mpa_y_mpb_y_nand_m_y_tg_s_a_y_dup2_t0 r0 *1 0,0
Ra_inv_mc_a_mb_mnab_y_mpa_y_mpb_y_nand_m_y_tg_s_a_y_dup2_t0
+ a|inv_mc_a|mb|mnab_y|mpa_y|mpb_y|nand_m_y|tg_s_a|y__t03
+ a|inv_mc_a|mb|mnab_y|mpa_y|mpb_y|nand_m_y|tg_s_a|y$2 189.921079219
* device instance a_inv_mc_a_mb_mnab_y_mpa_y_mpb_y_nand_m_y_tg_s_a_y_dup2_t1 r0 *1 0,0
Ra_inv_mc_a_mb_mnab_y_mpa_y_mpb_y_nand_m_y_tg_s_a_y_dup2_t1
+ a|inv_mc_a|mb|mnab_y|mpa_y|mpb_y|nand_m_y|tg_s_a|y__t13
+ a|inv_mc_a|mb|mnab_y|mpa_y|mpb_y|nand_m_y|tg_s_a|y$2 142.710836615
* device instance a_inv_mc_a_mb_mnab_y_mpa_y_mpb_y_nand_m_y_tg_s_a_y_dup2_t2 r0 *1 0,0
Ra_inv_mc_a_mb_mnab_y_mpa_y_mpb_y_nand_m_y_tg_s_a_y_dup2_t2
+ a|inv_mc_a|mb|mnab_y|mpa_y|mpb_y|nand_m_y|tg_s_a|y__t23
+ a|inv_mc_a|mb|mnab_y|mpa_y|mpb_y|nand_m_y|tg_s_a|y$2 188.133983991
* device instance a_inv_mc_a_mb_mnab_y_mpa_y_mpb_y_nand_m_y_tg_s_a_y_dup2_t3 r0 *1 0,0
Ra_inv_mc_a_mb_mnab_y_mpa_y_mpb_y_nand_m_y_tg_s_a_y_dup2_t3
+ a|inv_mc_a|mb|mnab_y|mpa_y|mpb_y|nand_m_y|tg_s_a|y__t33
+ a|inv_mc_a|mb|mnab_y|mpa_y|mpb_y|nand_m_y|tg_s_a|y$2 36.3529298905
* device instance a_inv_mc_a_mb_mnab_y_mpa_y_mpb_y_nand_m_y_tg_s_a_y_dup2_t4 r0 *1 0,0
Ra_inv_mc_a_mb_mnab_y_mpa_y_mpb_y_nand_m_y_tg_s_a_y_dup2_t4
+ a|inv_mc_a|mb|mnab_y|mpa_y|mpb_y|nand_m_y|tg_s_a|y__t43
+ a|inv_mc_a|mb|mnab_y|mpa_y|mpb_y|nand_m_y|tg_s_a|y$2 25.4148600674
* device instance a_inv_mc_a_mb_mnab_y_mpa_y_mpb_y_nand_m_y_tg_s_a_y_dup2_t5 r0 *1 0,0
Ra_inv_mc_a_mb_mnab_y_mpa_y_mpb_y_nand_m_y_tg_s_a_y_dup2_t5
+ a|inv_mc_a|mb|mnab_y|mpa_y|mpb_y|nand_m_y|tg_s_a|y__t53
+ a|inv_mc_a|mb|mnab_y|mpa_y|mpb_y|nand_m_y|tg_s_a|y$2 119.440616038
* device instance a_inv_mc_a_mb_mnab_y_mpa_y_mpb_y_nand_m_y_tg_s_a_y_dup2_t6 r0 *1 0,0
Ra_inv_mc_a_mb_mnab_y_mpa_y_mpb_y_nand_m_y_tg_s_a_y_dup2_t6
+ a|inv_mc_a|mb|mnab_y|mpa_y|mpb_y|nand_m_y|tg_s_a|y__t63
+ a|inv_mc_a|mb|mnab_y|mpa_y|mpb_y|nand_m_y|tg_s_a|y$2 128.808394178
* device instance a_inv_mc_a_mb_mnab_y_mpa_y_mpb_y_nand_m_y_tg_s_a_y_dup2 r0 *1 0,0
Ca_inv_mc_a_mb_mnab_y_mpa_y_mpb_y_nand_m_y_tg_s_a_y_dup2
+ a|inv_mc_a|mb|mnab_y|mpa_y|mpb_y|nand_m_y|tg_s_a|y$2 vsubs 4.01273e-15
* device instance a_inv_mc_a_mb_mnab_y_mpa_y_mpb_y_nand_m_y_tg_s_a_y_dup3_t0 r0 *1 0,0
Ra_inv_mc_a_mb_mnab_y_mpa_y_mpb_y_nand_m_y_tg_s_a_y_dup3_t0
+ a|inv_mc_a|mb|mnab_y|mpa_y|mpb_y|nand_m_y|tg_s_a|y__t04
+ a|inv_mc_a|mb|mnab_y|mpa_y|mpb_y|nand_m_y|tg_s_a|y$3 189.921079219
* device instance a_inv_mc_a_mb_mnab_y_mpa_y_mpb_y_nand_m_y_tg_s_a_y_dup3_t1 r0 *1 0,0
Ra_inv_mc_a_mb_mnab_y_mpa_y_mpb_y_nand_m_y_tg_s_a_y_dup3_t1
+ a|inv_mc_a|mb|mnab_y|mpa_y|mpb_y|nand_m_y|tg_s_a|y__t14
+ a|inv_mc_a|mb|mnab_y|mpa_y|mpb_y|nand_m_y|tg_s_a|y$3 142.710836615
* device instance a_inv_mc_a_mb_mnab_y_mpa_y_mpb_y_nand_m_y_tg_s_a_y_dup3_t2 r0 *1 0,0
Ra_inv_mc_a_mb_mnab_y_mpa_y_mpb_y_nand_m_y_tg_s_a_y_dup3_t2
+ a|inv_mc_a|mb|mnab_y|mpa_y|mpb_y|nand_m_y|tg_s_a|y__t24
+ a|inv_mc_a|mb|mnab_y|mpa_y|mpb_y|nand_m_y|tg_s_a|y$3 188.133983991
* device instance a_inv_mc_a_mb_mnab_y_mpa_y_mpb_y_nand_m_y_tg_s_a_y_dup3_t3 r0 *1 0,0
Ra_inv_mc_a_mb_mnab_y_mpa_y_mpb_y_nand_m_y_tg_s_a_y_dup3_t3
+ a|inv_mc_a|mb|mnab_y|mpa_y|mpb_y|nand_m_y|tg_s_a|y__t34
+ a|inv_mc_a|mb|mnab_y|mpa_y|mpb_y|nand_m_y|tg_s_a|y$3 36.3529298905
* device instance a_inv_mc_a_mb_mnab_y_mpa_y_mpb_y_nand_m_y_tg_s_a_y_dup3_t4 r0 *1 0,0
Ra_inv_mc_a_mb_mnab_y_mpa_y_mpb_y_nand_m_y_tg_s_a_y_dup3_t4
+ a|inv_mc_a|mb|mnab_y|mpa_y|mpb_y|nand_m_y|tg_s_a|y__t44
+ a|inv_mc_a|mb|mnab_y|mpa_y|mpb_y|nand_m_y|tg_s_a|y$3 25.4148600674
* device instance a_inv_mc_a_mb_mnab_y_mpa_y_mpb_y_nand_m_y_tg_s_a_y_dup3_t5 r0 *1 0,0
Ra_inv_mc_a_mb_mnab_y_mpa_y_mpb_y_nand_m_y_tg_s_a_y_dup3_t5
+ a|inv_mc_a|mb|mnab_y|mpa_y|mpb_y|nand_m_y|tg_s_a|y__t54
+ a|inv_mc_a|mb|mnab_y|mpa_y|mpb_y|nand_m_y|tg_s_a|y$3 119.440616038
* device instance a_inv_mc_a_mb_mnab_y_mpa_y_mpb_y_nand_m_y_tg_s_a_y_dup3_t6 r0 *1 0,0
Ra_inv_mc_a_mb_mnab_y_mpa_y_mpb_y_nand_m_y_tg_s_a_y_dup3_t6
+ a|inv_mc_a|mb|mnab_y|mpa_y|mpb_y|nand_m_y|tg_s_a|y__t64
+ a|inv_mc_a|mb|mnab_y|mpa_y|mpb_y|nand_m_y|tg_s_a|y$3 128.808394178
* device instance a_inv_mc_a_mb_mnab_y_mpa_y_mpb_y_nand_m_y_tg_s_a_y_dup3 r0 *1 0,0
Ca_inv_mc_a_mb_mnab_y_mpa_y_mpb_y_nand_m_y_tg_s_a_y_dup3
+ a|inv_mc_a|mb|mnab_y|mpa_y|mpb_y|nand_m_y|tg_s_a|y$3 vsubs 4.01273e-15
* device instance a_inv_mc_a_mb_mnab_y_mpa_y_mpb_y_nand_m_y_tg_s_a_y_dup4_t0 r0 *1 0,0
Ra_inv_mc_a_mb_mnab_y_mpa_y_mpb_y_nand_m_y_tg_s_a_y_dup4_t0
+ a|inv_mc_a|mb|mnab_y|mpa_y|mpb_y|nand_m_y|tg_s_a|y__t05
+ a|inv_mc_a|mb|mnab_y|mpa_y|mpb_y|nand_m_y|tg_s_a|y$4 189.921079219
* device instance a_inv_mc_a_mb_mnab_y_mpa_y_mpb_y_nand_m_y_tg_s_a_y_dup4_t1 r0 *1 0,0
Ra_inv_mc_a_mb_mnab_y_mpa_y_mpb_y_nand_m_y_tg_s_a_y_dup4_t1
+ a|inv_mc_a|mb|mnab_y|mpa_y|mpb_y|nand_m_y|tg_s_a|y__t15
+ a|inv_mc_a|mb|mnab_y|mpa_y|mpb_y|nand_m_y|tg_s_a|y$4 142.710836615
* device instance a_inv_mc_a_mb_mnab_y_mpa_y_mpb_y_nand_m_y_tg_s_a_y_dup4_t2 r0 *1 0,0
Ra_inv_mc_a_mb_mnab_y_mpa_y_mpb_y_nand_m_y_tg_s_a_y_dup4_t2
+ a|inv_mc_a|mb|mnab_y|mpa_y|mpb_y|nand_m_y|tg_s_a|y__t25
+ a|inv_mc_a|mb|mnab_y|mpa_y|mpb_y|nand_m_y|tg_s_a|y$4 188.133983991
* device instance a_inv_mc_a_mb_mnab_y_mpa_y_mpb_y_nand_m_y_tg_s_a_y_dup4_t3 r0 *1 0,0
Ra_inv_mc_a_mb_mnab_y_mpa_y_mpb_y_nand_m_y_tg_s_a_y_dup4_t3
+ a|inv_mc_a|mb|mnab_y|mpa_y|mpb_y|nand_m_y|tg_s_a|y__t35
+ a|inv_mc_a|mb|mnab_y|mpa_y|mpb_y|nand_m_y|tg_s_a|y$4 36.3529298905
* device instance a_inv_mc_a_mb_mnab_y_mpa_y_mpb_y_nand_m_y_tg_s_a_y_dup4_t4 r0 *1 0,0
Ra_inv_mc_a_mb_mnab_y_mpa_y_mpb_y_nand_m_y_tg_s_a_y_dup4_t4
+ a|inv_mc_a|mb|mnab_y|mpa_y|mpb_y|nand_m_y|tg_s_a|y__t45
+ a|inv_mc_a|mb|mnab_y|mpa_y|mpb_y|nand_m_y|tg_s_a|y$4 25.4148600674
* device instance a_inv_mc_a_mb_mnab_y_mpa_y_mpb_y_nand_m_y_tg_s_a_y_dup4_t5 r0 *1 0,0
Ra_inv_mc_a_mb_mnab_y_mpa_y_mpb_y_nand_m_y_tg_s_a_y_dup4_t5
+ a|inv_mc_a|mb|mnab_y|mpa_y|mpb_y|nand_m_y|tg_s_a|y__t55
+ a|inv_mc_a|mb|mnab_y|mpa_y|mpb_y|nand_m_y|tg_s_a|y$4 119.440616038
* device instance a_inv_mc_a_mb_mnab_y_mpa_y_mpb_y_nand_m_y_tg_s_a_y_dup4_t6 r0 *1 0,0
Ra_inv_mc_a_mb_mnab_y_mpa_y_mpb_y_nand_m_y_tg_s_a_y_dup4_t6
+ a|inv_mc_a|mb|mnab_y|mpa_y|mpb_y|nand_m_y|tg_s_a|y__t65
+ a|inv_mc_a|mb|mnab_y|mpa_y|mpb_y|nand_m_y|tg_s_a|y$4 128.808394178
* device instance a_inv_mc_a_mb_mnab_y_mpa_y_mpb_y_nand_m_y_tg_s_a_y_dup4 r0 *1 0,0
Ca_inv_mc_a_mb_mnab_y_mpa_y_mpb_y_nand_m_y_tg_s_a_y_dup4
+ a|inv_mc_a|mb|mnab_y|mpa_y|mpb_y|nand_m_y|tg_s_a|y$4 vsubs 4.01273e-15
* device instance a_inv_mc_a_mb_mnab_y_mpa_y_mpb_y_nand_m_y_tg_s_a_y_dup5_t0 r0 *1 0,0
Ra_inv_mc_a_mb_mnab_y_mpa_y_mpb_y_nand_m_y_tg_s_a_y_dup5_t0
+ a|inv_mc_a|mb|mnab_y|mpa_y|mpb_y|nand_m_y|tg_s_a|y__t06
+ a|inv_mc_a|mb|mnab_y|mpa_y|mpb_y|nand_m_y|tg_s_a|y$5 189.921079219
* device instance a_inv_mc_a_mb_mnab_y_mpa_y_mpb_y_nand_m_y_tg_s_a_y_dup5_t1 r0 *1 0,0
Ra_inv_mc_a_mb_mnab_y_mpa_y_mpb_y_nand_m_y_tg_s_a_y_dup5_t1
+ a|inv_mc_a|mb|mnab_y|mpa_y|mpb_y|nand_m_y|tg_s_a|y__t16
+ a|inv_mc_a|mb|mnab_y|mpa_y|mpb_y|nand_m_y|tg_s_a|y$5 188.133983991
* device instance a_inv_mc_a_mb_mnab_y_mpa_y_mpb_y_nand_m_y_tg_s_a_y_dup5_t2 r0 *1 0,0
Ra_inv_mc_a_mb_mnab_y_mpa_y_mpb_y_nand_m_y_tg_s_a_y_dup5_t2
+ a|inv_mc_a|mb|mnab_y|mpa_y|mpb_y|nand_m_y|tg_s_a|y__t26
+ a|inv_mc_a|mb|mnab_y|mpa_y|mpb_y|nand_m_y|tg_s_a|y$5 142.710836615
* device instance a_inv_mc_a_mb_mnab_y_mpa_y_mpb_y_nand_m_y_tg_s_a_y_dup5_t3 r0 *1 0,0
Ra_inv_mc_a_mb_mnab_y_mpa_y_mpb_y_nand_m_y_tg_s_a_y_dup5_t3
+ a|inv_mc_a|mb|mnab_y|mpa_y|mpb_y|nand_m_y|tg_s_a|y__t36
+ a|inv_mc_a|mb|mnab_y|mpa_y|mpb_y|nand_m_y|tg_s_a|y$5 36.3529298905
* device instance a_inv_mc_a_mb_mnab_y_mpa_y_mpb_y_nand_m_y_tg_s_a_y_dup5_t4 r0 *1 0,0
Ra_inv_mc_a_mb_mnab_y_mpa_y_mpb_y_nand_m_y_tg_s_a_y_dup5_t4
+ a|inv_mc_a|mb|mnab_y|mpa_y|mpb_y|nand_m_y|tg_s_a|y__t46
+ a|inv_mc_a|mb|mnab_y|mpa_y|mpb_y|nand_m_y|tg_s_a|y$5 25.4148600674
* device instance a_inv_mc_a_mb_mnab_y_mpa_y_mpb_y_nand_m_y_tg_s_a_y_dup5_t5 r0 *1 0,0
Ra_inv_mc_a_mb_mnab_y_mpa_y_mpb_y_nand_m_y_tg_s_a_y_dup5_t5
+ a|inv_mc_a|mb|mnab_y|mpa_y|mpb_y|nand_m_y|tg_s_a|y__t56
+ a|inv_mc_a|mb|mnab_y|mpa_y|mpb_y|nand_m_y|tg_s_a|y$5 119.440616038
* device instance a_inv_mc_a_mb_mnab_y_mpa_y_mpb_y_nand_m_y_tg_s_a_y_dup5_t6 r0 *1 0,0
Ra_inv_mc_a_mb_mnab_y_mpa_y_mpb_y_nand_m_y_tg_s_a_y_dup5_t6
+ a|inv_mc_a|mb|mnab_y|mpa_y|mpb_y|nand_m_y|tg_s_a|y__t66
+ a|inv_mc_a|mb|mnab_y|mpa_y|mpb_y|nand_m_y|tg_s_a|y$5 128.808394178
* device instance a_inv_mc_a_mb_mnab_y_mpa_y_mpb_y_nand_m_y_tg_s_a_y_dup5 r0 *1 0,0
Ca_inv_mc_a_mb_mnab_y_mpa_y_mpb_y_nand_m_y_tg_s_a_y_dup5
+ a|inv_mc_a|mb|mnab_y|mpa_y|mpb_y|nand_m_y|tg_s_a|y$5 vsubs 4.01273e-15
* device instance a_inv_mc_y_inv_mc_y_via_mc_tg_fbm_a_tg_fbm_a_via_y_t0 r0 *1 0,0
Ra_inv_mc_y_inv_mc_y_via_mc_tg_fbm_a_tg_fbm_a_via_y_t0
+ a|inv_mc_y|inv_mc_y_via|mc|tg_fbm_a|tg_fbm_a_via|y__t0
+ a|inv_mc_y|inv_mc_y_via|mc|tg_fbm_a|tg_fbm_a_via|y 208.313425
* device instance a_inv_mc_y_inv_mc_y_via_mc_tg_fbm_a_tg_fbm_a_via_y_t1 r0 *1 0,0
Ra_inv_mc_y_inv_mc_y_via_mc_tg_fbm_a_tg_fbm_a_via_y_t1
+ a|inv_mc_y|inv_mc_y_via|mc|tg_fbm_a|tg_fbm_a_via|y__t1
+ a|inv_mc_y|inv_mc_y_via|mc|tg_fbm_a|tg_fbm_a_via|y 208.313425
* device instance a_inv_mc_y_inv_mc_y_via_mc_tg_fbm_a_tg_fbm_a_via_y_t2 r0 *1 0,0
Ra_inv_mc_y_inv_mc_y_via_mc_tg_fbm_a_tg_fbm_a_via_y_t2
+ a|inv_mc_y|inv_mc_y_via|mc|tg_fbm_a|tg_fbm_a_via|y__t2
+ a|inv_mc_y|inv_mc_y_via|mc|tg_fbm_a|tg_fbm_a_via|y 208.313425
* device instance a_inv_mc_y_inv_mc_y_via_mc_tg_fbm_a_tg_fbm_a_via_y_t3 r0 *1 0,0
Ra_inv_mc_y_inv_mc_y_via_mc_tg_fbm_a_tg_fbm_a_via_y_t3
+ a|inv_mc_y|inv_mc_y_via|mc|tg_fbm_a|tg_fbm_a_via|y__t3
+ a|inv_mc_y|inv_mc_y_via|mc|tg_fbm_a|tg_fbm_a_via|y 208.313425
* device instance a_inv_mc_y_inv_mc_y_via_mc_tg_fbm_a_tg_fbm_a_via_y r0 *1 0,0
Ca_inv_mc_y_inv_mc_y_via_mc_tg_fbm_a_tg_fbm_a_via_y
+ a|inv_mc_y|inv_mc_y_via|mc|tg_fbm_a|tg_fbm_a_via|y vsubs 1.955756e-15
* device instance a_inv_mc_y_inv_mc_y_via_mc_tg_fbm_a_tg_fbm_a_via_y_dup1_t0 r0 *1 0,0
Ra_inv_mc_y_inv_mc_y_via_mc_tg_fbm_a_tg_fbm_a_via_y_dup1_t0
+ a|inv_mc_y|inv_mc_y_via|mc|tg_fbm_a|tg_fbm_a_via|y__t02
+ a|inv_mc_y|inv_mc_y_via|mc|tg_fbm_a|tg_fbm_a_via|y$1 208.313425
* device instance a_inv_mc_y_inv_mc_y_via_mc_tg_fbm_a_tg_fbm_a_via_y_dup1_t1 r0 *1 0,0
Ra_inv_mc_y_inv_mc_y_via_mc_tg_fbm_a_tg_fbm_a_via_y_dup1_t1
+ a|inv_mc_y|inv_mc_y_via|mc|tg_fbm_a|tg_fbm_a_via|y__t12
+ a|inv_mc_y|inv_mc_y_via|mc|tg_fbm_a|tg_fbm_a_via|y$1 208.313425
* device instance a_inv_mc_y_inv_mc_y_via_mc_tg_fbm_a_tg_fbm_a_via_y_dup1_t2 r0 *1 0,0
Ra_inv_mc_y_inv_mc_y_via_mc_tg_fbm_a_tg_fbm_a_via_y_dup1_t2
+ a|inv_mc_y|inv_mc_y_via|mc|tg_fbm_a|tg_fbm_a_via|y__t22
+ a|inv_mc_y|inv_mc_y_via|mc|tg_fbm_a|tg_fbm_a_via|y$1 208.313425
* device instance a_inv_mc_y_inv_mc_y_via_mc_tg_fbm_a_tg_fbm_a_via_y_dup1_t3 r0 *1 0,0
Ra_inv_mc_y_inv_mc_y_via_mc_tg_fbm_a_tg_fbm_a_via_y_dup1_t3
+ a|inv_mc_y|inv_mc_y_via|mc|tg_fbm_a|tg_fbm_a_via|y__t32
+ a|inv_mc_y|inv_mc_y_via|mc|tg_fbm_a|tg_fbm_a_via|y$1 208.313425
* device instance a_inv_mc_y_inv_mc_y_via_mc_tg_fbm_a_tg_fbm_a_via_y_dup1 r0 *1 0,0
Ca_inv_mc_y_inv_mc_y_via_mc_tg_fbm_a_tg_fbm_a_via_y_dup1
+ a|inv_mc_y|inv_mc_y_via|mc|tg_fbm_a|tg_fbm_a_via|y$1 vsubs 1.955756e-15
* device instance a_inv_mc_y_inv_mc_y_via_mc_tg_fbm_a_tg_fbm_a_via_y_dup2_t0 r0 *1 0,0
Ra_inv_mc_y_inv_mc_y_via_mc_tg_fbm_a_tg_fbm_a_via_y_dup2_t0
+ a|inv_mc_y|inv_mc_y_via|mc|tg_fbm_a|tg_fbm_a_via|y__t03
+ a|inv_mc_y|inv_mc_y_via|mc|tg_fbm_a|tg_fbm_a_via|y$2 208.313425
* device instance a_inv_mc_y_inv_mc_y_via_mc_tg_fbm_a_tg_fbm_a_via_y_dup2_t1 r0 *1 0,0
Ra_inv_mc_y_inv_mc_y_via_mc_tg_fbm_a_tg_fbm_a_via_y_dup2_t1
+ a|inv_mc_y|inv_mc_y_via|mc|tg_fbm_a|tg_fbm_a_via|y__t13
+ a|inv_mc_y|inv_mc_y_via|mc|tg_fbm_a|tg_fbm_a_via|y$2 208.313425
* device instance a_inv_mc_y_inv_mc_y_via_mc_tg_fbm_a_tg_fbm_a_via_y_dup2_t2 r0 *1 0,0
Ra_inv_mc_y_inv_mc_y_via_mc_tg_fbm_a_tg_fbm_a_via_y_dup2_t2
+ a|inv_mc_y|inv_mc_y_via|mc|tg_fbm_a|tg_fbm_a_via|y__t23
+ a|inv_mc_y|inv_mc_y_via|mc|tg_fbm_a|tg_fbm_a_via|y$2 208.313425
* device instance a_inv_mc_y_inv_mc_y_via_mc_tg_fbm_a_tg_fbm_a_via_y_dup2_t3 r0 *1 0,0
Ra_inv_mc_y_inv_mc_y_via_mc_tg_fbm_a_tg_fbm_a_via_y_dup2_t3
+ a|inv_mc_y|inv_mc_y_via|mc|tg_fbm_a|tg_fbm_a_via|y__t33
+ a|inv_mc_y|inv_mc_y_via|mc|tg_fbm_a|tg_fbm_a_via|y$2 208.313425
* device instance a_inv_mc_y_inv_mc_y_via_mc_tg_fbm_a_tg_fbm_a_via_y_dup2 r0 *1 0,0
Ca_inv_mc_y_inv_mc_y_via_mc_tg_fbm_a_tg_fbm_a_via_y_dup2
+ a|inv_mc_y|inv_mc_y_via|mc|tg_fbm_a|tg_fbm_a_via|y$2 vsubs 1.955756e-15
* device instance a_inv_mc_y_inv_mc_y_via_mc_tg_fbm_a_tg_fbm_a_via_y_dup3_t0 r0 *1 0,0
Ra_inv_mc_y_inv_mc_y_via_mc_tg_fbm_a_tg_fbm_a_via_y_dup3_t0
+ a|inv_mc_y|inv_mc_y_via|mc|tg_fbm_a|tg_fbm_a_via|y__t04
+ a|inv_mc_y|inv_mc_y_via|mc|tg_fbm_a|tg_fbm_a_via|y$3 208.313425
* device instance a_inv_mc_y_inv_mc_y_via_mc_tg_fbm_a_tg_fbm_a_via_y_dup3_t1 r0 *1 0,0
Ra_inv_mc_y_inv_mc_y_via_mc_tg_fbm_a_tg_fbm_a_via_y_dup3_t1
+ a|inv_mc_y|inv_mc_y_via|mc|tg_fbm_a|tg_fbm_a_via|y__t14
+ a|inv_mc_y|inv_mc_y_via|mc|tg_fbm_a|tg_fbm_a_via|y$3 208.313425
* device instance a_inv_mc_y_inv_mc_y_via_mc_tg_fbm_a_tg_fbm_a_via_y_dup3_t2 r0 *1 0,0
Ra_inv_mc_y_inv_mc_y_via_mc_tg_fbm_a_tg_fbm_a_via_y_dup3_t2
+ a|inv_mc_y|inv_mc_y_via|mc|tg_fbm_a|tg_fbm_a_via|y__t24
+ a|inv_mc_y|inv_mc_y_via|mc|tg_fbm_a|tg_fbm_a_via|y$3 208.313425
* device instance a_inv_mc_y_inv_mc_y_via_mc_tg_fbm_a_tg_fbm_a_via_y_dup3_t3 r0 *1 0,0
Ra_inv_mc_y_inv_mc_y_via_mc_tg_fbm_a_tg_fbm_a_via_y_dup3_t3
+ a|inv_mc_y|inv_mc_y_via|mc|tg_fbm_a|tg_fbm_a_via|y__t34
+ a|inv_mc_y|inv_mc_y_via|mc|tg_fbm_a|tg_fbm_a_via|y$3 208.313425
* device instance a_inv_mc_y_inv_mc_y_via_mc_tg_fbm_a_tg_fbm_a_via_y_dup3 r0 *1 0,0
Ca_inv_mc_y_inv_mc_y_via_mc_tg_fbm_a_tg_fbm_a_via_y_dup3
+ a|inv_mc_y|inv_mc_y_via|mc|tg_fbm_a|tg_fbm_a_via|y$3 vsubs 1.955756e-15
* device instance a_inv_mc_y_inv_mc_y_via_mc_tg_fbm_a_tg_fbm_a_via_y_dup4_t0 r0 *1 0,0
Ra_inv_mc_y_inv_mc_y_via_mc_tg_fbm_a_tg_fbm_a_via_y_dup4_t0
+ a|inv_mc_y|inv_mc_y_via|mc|tg_fbm_a|tg_fbm_a_via|y__t05
+ a|inv_mc_y|inv_mc_y_via|mc|tg_fbm_a|tg_fbm_a_via|y$4 208.313425
* device instance a_inv_mc_y_inv_mc_y_via_mc_tg_fbm_a_tg_fbm_a_via_y_dup4_t1 r0 *1 0,0
Ra_inv_mc_y_inv_mc_y_via_mc_tg_fbm_a_tg_fbm_a_via_y_dup4_t1
+ a|inv_mc_y|inv_mc_y_via|mc|tg_fbm_a|tg_fbm_a_via|y__t15
+ a|inv_mc_y|inv_mc_y_via|mc|tg_fbm_a|tg_fbm_a_via|y$4 208.313425
* device instance a_inv_mc_y_inv_mc_y_via_mc_tg_fbm_a_tg_fbm_a_via_y_dup4_t2 r0 *1 0,0
Ra_inv_mc_y_inv_mc_y_via_mc_tg_fbm_a_tg_fbm_a_via_y_dup4_t2
+ a|inv_mc_y|inv_mc_y_via|mc|tg_fbm_a|tg_fbm_a_via|y__t25
+ a|inv_mc_y|inv_mc_y_via|mc|tg_fbm_a|tg_fbm_a_via|y$4 208.313425
* device instance a_inv_mc_y_inv_mc_y_via_mc_tg_fbm_a_tg_fbm_a_via_y_dup4_t3 r0 *1 0,0
Ra_inv_mc_y_inv_mc_y_via_mc_tg_fbm_a_tg_fbm_a_via_y_dup4_t3
+ a|inv_mc_y|inv_mc_y_via|mc|tg_fbm_a|tg_fbm_a_via|y__t35
+ a|inv_mc_y|inv_mc_y_via|mc|tg_fbm_a|tg_fbm_a_via|y$4 208.313425
* device instance a_inv_mc_y_inv_mc_y_via_mc_tg_fbm_a_tg_fbm_a_via_y_dup4 r0 *1 0,0
Ca_inv_mc_y_inv_mc_y_via_mc_tg_fbm_a_tg_fbm_a_via_y_dup4
+ a|inv_mc_y|inv_mc_y_via|mc|tg_fbm_a|tg_fbm_a_via|y$4 vsubs 1.955756e-15
* device instance a_inv_mc_y_inv_mc_y_via_mc_tg_fbm_a_tg_fbm_a_via_y_dup5_t0 r0 *1 0,0
Ra_inv_mc_y_inv_mc_y_via_mc_tg_fbm_a_tg_fbm_a_via_y_dup5_t0
+ a|inv_mc_y|inv_mc_y_via|mc|tg_fbm_a|tg_fbm_a_via|y__t06
+ a|inv_mc_y|inv_mc_y_via|mc|tg_fbm_a|tg_fbm_a_via|y$5 208.313425
* device instance a_inv_mc_y_inv_mc_y_via_mc_tg_fbm_a_tg_fbm_a_via_y_dup5_t1 r0 *1 0,0
Ra_inv_mc_y_inv_mc_y_via_mc_tg_fbm_a_tg_fbm_a_via_y_dup5_t1
+ a|inv_mc_y|inv_mc_y_via|mc|tg_fbm_a|tg_fbm_a_via|y__t16
+ a|inv_mc_y|inv_mc_y_via|mc|tg_fbm_a|tg_fbm_a_via|y$5 208.313425
* device instance a_inv_mc_y_inv_mc_y_via_mc_tg_fbm_a_tg_fbm_a_via_y_dup5_t2 r0 *1 0,0
Ra_inv_mc_y_inv_mc_y_via_mc_tg_fbm_a_tg_fbm_a_via_y_dup5_t2
+ a|inv_mc_y|inv_mc_y_via|mc|tg_fbm_a|tg_fbm_a_via|y__t26
+ a|inv_mc_y|inv_mc_y_via|mc|tg_fbm_a|tg_fbm_a_via|y$5 208.313425
* device instance a_inv_mc_y_inv_mc_y_via_mc_tg_fbm_a_tg_fbm_a_via_y_dup5_t3 r0 *1 0,0
Ra_inv_mc_y_inv_mc_y_via_mc_tg_fbm_a_tg_fbm_a_via_y_dup5_t3
+ a|inv_mc_y|inv_mc_y_via|mc|tg_fbm_a|tg_fbm_a_via|y__t36
+ a|inv_mc_y|inv_mc_y_via|mc|tg_fbm_a|tg_fbm_a_via|y$5 208.313425
* device instance a_inv_mc_y_inv_mc_y_via_mc_tg_fbm_a_tg_fbm_a_via_y_dup5 r0 *1 0,0
Ca_inv_mc_y_inv_mc_y_via_mc_tg_fbm_a_tg_fbm_a_via_y_dup5
+ a|inv_mc_y|inv_mc_y_via|mc|tg_fbm_a|tg_fbm_a_via|y$5 vsubs 1.955756e-15
* device instance a_inv_q_y_inv_q_y_via_inv_q_y_via2_nand_s2_a_nand_s2_a_stub_nand_s2_a_via_nand_s2_a_via2_q_y_t0 r0 *1 0,0
Ra_inv_q_y_inv_q_y_via_inv_q_y_via2_nand_s2_a_nand_s2_a_stub_nand_s2_a_via_nand_s2_a_via2_q_y_t0
+ a|inv_q_y|inv_q_y_via|inv_q_y_via2|nand_s2_a|nand_s2_a_stub|nand_s2_a_via|nand_s2_a_via2|q|y__t0
+ a|inv_q_y|inv_q_y_via|inv_q_y_via2|nand_s2_a|nand_s2_a_stub|nand_s2_a_via|nand_s2_a_via2|q|y
+ 204.258816542
* device instance a_inv_q_y_inv_q_y_via_inv_q_y_via2_nand_s2_a_nand_s2_a_stub_nand_s2_a_via_nand_s2_a_via2_q_y_t1 r0 *1 0,0
Ra_inv_q_y_inv_q_y_via_inv_q_y_via2_nand_s2_a_nand_s2_a_stub_nand_s2_a_via_nand_s2_a_via2_q_y_t1
+ a|inv_q_y|inv_q_y_via|inv_q_y_via2|nand_s2_a|nand_s2_a_stub|nand_s2_a_via|nand_s2_a_via2|q|y__t1
+ a|inv_q_y|inv_q_y_via|inv_q_y_via2|nand_s2_a|nand_s2_a_stub|nand_s2_a_via|nand_s2_a_via2|q|y
+ 202.157775401
* device instance a_inv_q_y_inv_q_y_via_inv_q_y_via2_nand_s2_a_nand_s2_a_stub_nand_s2_a_via_nand_s2_a_via2_q_y_t2 r0 *1 0,0
Ra_inv_q_y_inv_q_y_via_inv_q_y_via2_nand_s2_a_nand_s2_a_stub_nand_s2_a_via_nand_s2_a_via2_q_y_t2
+ a|inv_q_y|inv_q_y_via|inv_q_y_via2|nand_s2_a|nand_s2_a_stub|nand_s2_a_via|nand_s2_a_via2|q|y__t2
+ a|inv_q_y|inv_q_y_via|inv_q_y_via2|nand_s2_a|nand_s2_a_stub|nand_s2_a_via|nand_s2_a_via2|q|y
+ 215.871984609
* device instance a_inv_q_y_inv_q_y_via_inv_q_y_via2_nand_s2_a_nand_s2_a_stub_nand_s2_a_via_nand_s2_a_via2_q_y_t3 r0 *1 0,0
Ra_inv_q_y_inv_q_y_via_inv_q_y_via2_nand_s2_a_nand_s2_a_stub_nand_s2_a_via_nand_s2_a_via2_q_y_t3
+ a|inv_q_y|inv_q_y_via|inv_q_y_via2|nand_s2_a|nand_s2_a_stub|nand_s2_a_via|nand_s2_a_via2|q|y__t3
+ a|inv_q_y|inv_q_y_via|inv_q_y_via2|nand_s2_a|nand_s2_a_stub|nand_s2_a_via|nand_s2_a_via2|q|y
+ 194.850123448
* device instance a_inv_q_y_inv_q_y_via_inv_q_y_via2_nand_s2_a_nand_s2_a_stub_nand_s2_a_via_nand_s2_a_via2_q_y r0 *1 0,0
Ca_inv_q_y_inv_q_y_via_inv_q_y_via2_nand_s2_a_nand_s2_a_stub_nand_s2_a_via_nand_s2_a_via2_q_y
+ a|inv_q_y|inv_q_y_via|inv_q_y_via2|nand_s2_a|nand_s2_a_stub|nand_s2_a_via|nand_s2_a_via2|q|y
+ vsubs 2.217373e-15
* device instance a_inv_q_y_inv_q_y_via_inv_q_y_via2_nand_s2_a_nand_s2_a_stub_nand_s2_a_via_nand_s2_a_via2_q_y_dup1_t0 r0 *1 0,0
Ra_inv_q_y_inv_q_y_via_inv_q_y_via2_nand_s2_a_nand_s2_a_stub_nand_s2_a_via_nand_s2_a_via2_q_y_dup1_t0
+ a|inv_q_y|inv_q_y_via|inv_q_y_via2|nand_s2_a|nand_s2_a_stub|nand_s2_a_via|nand_s2_a_via2|q|y__t02
+ a|inv_q_y|inv_q_y_via|inv_q_y_via2|nand_s2_a|nand_s2_a_stub|nand_s2_a_via|nand_s2_a_via2|q|y$1
+ 204.258816542
* device instance a_inv_q_y_inv_q_y_via_inv_q_y_via2_nand_s2_a_nand_s2_a_stub_nand_s2_a_via_nand_s2_a_via2_q_y_dup1_t1 r0 *1 0,0
Ra_inv_q_y_inv_q_y_via_inv_q_y_via2_nand_s2_a_nand_s2_a_stub_nand_s2_a_via_nand_s2_a_via2_q_y_dup1_t1
+ a|inv_q_y|inv_q_y_via|inv_q_y_via2|nand_s2_a|nand_s2_a_stub|nand_s2_a_via|nand_s2_a_via2|q|y__t12
+ a|inv_q_y|inv_q_y_via|inv_q_y_via2|nand_s2_a|nand_s2_a_stub|nand_s2_a_via|nand_s2_a_via2|q|y$1
+ 202.157775401
* device instance a_inv_q_y_inv_q_y_via_inv_q_y_via2_nand_s2_a_nand_s2_a_stub_nand_s2_a_via_nand_s2_a_via2_q_y_dup1_t2 r0 *1 0,0
Ra_inv_q_y_inv_q_y_via_inv_q_y_via2_nand_s2_a_nand_s2_a_stub_nand_s2_a_via_nand_s2_a_via2_q_y_dup1_t2
+ a|inv_q_y|inv_q_y_via|inv_q_y_via2|nand_s2_a|nand_s2_a_stub|nand_s2_a_via|nand_s2_a_via2|q|y__t22
+ a|inv_q_y|inv_q_y_via|inv_q_y_via2|nand_s2_a|nand_s2_a_stub|nand_s2_a_via|nand_s2_a_via2|q|y$1
+ 215.871984609
* device instance a_inv_q_y_inv_q_y_via_inv_q_y_via2_nand_s2_a_nand_s2_a_stub_nand_s2_a_via_nand_s2_a_via2_q_y_dup1_t3 r0 *1 0,0
Ra_inv_q_y_inv_q_y_via_inv_q_y_via2_nand_s2_a_nand_s2_a_stub_nand_s2_a_via_nand_s2_a_via2_q_y_dup1_t3
+ a|inv_q_y|inv_q_y_via|inv_q_y_via2|nand_s2_a|nand_s2_a_stub|nand_s2_a_via|nand_s2_a_via2|q|y__t32
+ a|inv_q_y|inv_q_y_via|inv_q_y_via2|nand_s2_a|nand_s2_a_stub|nand_s2_a_via|nand_s2_a_via2|q|y$1
+ 194.850123448
* device instance a_inv_q_y_inv_q_y_via_inv_q_y_via2_nand_s2_a_nand_s2_a_stub_nand_s2_a_via_nand_s2_a_via2_q_y_dup1 r0 *1 0,0
Ca_inv_q_y_inv_q_y_via_inv_q_y_via2_nand_s2_a_nand_s2_a_stub_nand_s2_a_via_nand_s2_a_via2_q_y_dup1
+ a|inv_q_y|inv_q_y_via|inv_q_y_via2|nand_s2_a|nand_s2_a_stub|nand_s2_a_via|nand_s2_a_via2|q|y$1
+ vsubs 2.217373e-15
* device instance a_inv_q_y_inv_q_y_via_inv_q_y_via2_nand_s2_a_nand_s2_a_stub_nand_s2_a_via_nand_s2_a_via2_q_y_dup2_t0 r0 *1 0,0
Ra_inv_q_y_inv_q_y_via_inv_q_y_via2_nand_s2_a_nand_s2_a_stub_nand_s2_a_via_nand_s2_a_via2_q_y_dup2_t0
+ a|inv_q_y|inv_q_y_via|inv_q_y_via2|nand_s2_a|nand_s2_a_stub|nand_s2_a_via|nand_s2_a_via2|q|y__t03
+ a|inv_q_y|inv_q_y_via|inv_q_y_via2|nand_s2_a|nand_s2_a_stub|nand_s2_a_via|nand_s2_a_via2|q|y$2
+ 204.258816542
* device instance a_inv_q_y_inv_q_y_via_inv_q_y_via2_nand_s2_a_nand_s2_a_stub_nand_s2_a_via_nand_s2_a_via2_q_y_dup2_t1 r0 *1 0,0
Ra_inv_q_y_inv_q_y_via_inv_q_y_via2_nand_s2_a_nand_s2_a_stub_nand_s2_a_via_nand_s2_a_via2_q_y_dup2_t1
+ a|inv_q_y|inv_q_y_via|inv_q_y_via2|nand_s2_a|nand_s2_a_stub|nand_s2_a_via|nand_s2_a_via2|q|y__t13
+ a|inv_q_y|inv_q_y_via|inv_q_y_via2|nand_s2_a|nand_s2_a_stub|nand_s2_a_via|nand_s2_a_via2|q|y$2
+ 202.157775401
* device instance a_inv_q_y_inv_q_y_via_inv_q_y_via2_nand_s2_a_nand_s2_a_stub_nand_s2_a_via_nand_s2_a_via2_q_y_dup2_t2 r0 *1 0,0
Ra_inv_q_y_inv_q_y_via_inv_q_y_via2_nand_s2_a_nand_s2_a_stub_nand_s2_a_via_nand_s2_a_via2_q_y_dup2_t2
+ a|inv_q_y|inv_q_y_via|inv_q_y_via2|nand_s2_a|nand_s2_a_stub|nand_s2_a_via|nand_s2_a_via2|q|y__t23
+ a|inv_q_y|inv_q_y_via|inv_q_y_via2|nand_s2_a|nand_s2_a_stub|nand_s2_a_via|nand_s2_a_via2|q|y$2
+ 215.871984609
* device instance a_inv_q_y_inv_q_y_via_inv_q_y_via2_nand_s2_a_nand_s2_a_stub_nand_s2_a_via_nand_s2_a_via2_q_y_dup2_t3 r0 *1 0,0
Ra_inv_q_y_inv_q_y_via_inv_q_y_via2_nand_s2_a_nand_s2_a_stub_nand_s2_a_via_nand_s2_a_via2_q_y_dup2_t3
+ a|inv_q_y|inv_q_y_via|inv_q_y_via2|nand_s2_a|nand_s2_a_stub|nand_s2_a_via|nand_s2_a_via2|q|y__t33
+ a|inv_q_y|inv_q_y_via|inv_q_y_via2|nand_s2_a|nand_s2_a_stub|nand_s2_a_via|nand_s2_a_via2|q|y$2
+ 194.850123448
* device instance a_inv_q_y_inv_q_y_via_inv_q_y_via2_nand_s2_a_nand_s2_a_stub_nand_s2_a_via_nand_s2_a_via2_q_y_dup2 r0 *1 0,0
Ca_inv_q_y_inv_q_y_via_inv_q_y_via2_nand_s2_a_nand_s2_a_stub_nand_s2_a_via_nand_s2_a_via2_q_y_dup2
+ a|inv_q_y|inv_q_y_via|inv_q_y_via2|nand_s2_a|nand_s2_a_stub|nand_s2_a_via|nand_s2_a_via2|q|y$2
+ vsubs 2.217373e-15
* device instance a_inv_q_y_inv_q_y_via_inv_q_y_via2_nand_s2_a_nand_s2_a_stub_nand_s2_a_via_nand_s2_a_via2_q_y_dup3_t0 r0 *1 0,0
Ra_inv_q_y_inv_q_y_via_inv_q_y_via2_nand_s2_a_nand_s2_a_stub_nand_s2_a_via_nand_s2_a_via2_q_y_dup3_t0
+ a|inv_q_y|inv_q_y_via|inv_q_y_via2|nand_s2_a|nand_s2_a_stub|nand_s2_a_via|nand_s2_a_via2|q|y__t04
+ a|inv_q_y|inv_q_y_via|inv_q_y_via2|nand_s2_a|nand_s2_a_stub|nand_s2_a_via|nand_s2_a_via2|q|y$3
+ 204.258816542
* device instance a_inv_q_y_inv_q_y_via_inv_q_y_via2_nand_s2_a_nand_s2_a_stub_nand_s2_a_via_nand_s2_a_via2_q_y_dup3_t1 r0 *1 0,0
Ra_inv_q_y_inv_q_y_via_inv_q_y_via2_nand_s2_a_nand_s2_a_stub_nand_s2_a_via_nand_s2_a_via2_q_y_dup3_t1
+ a|inv_q_y|inv_q_y_via|inv_q_y_via2|nand_s2_a|nand_s2_a_stub|nand_s2_a_via|nand_s2_a_via2|q|y__t14
+ a|inv_q_y|inv_q_y_via|inv_q_y_via2|nand_s2_a|nand_s2_a_stub|nand_s2_a_via|nand_s2_a_via2|q|y$3
+ 202.157775401
* device instance a_inv_q_y_inv_q_y_via_inv_q_y_via2_nand_s2_a_nand_s2_a_stub_nand_s2_a_via_nand_s2_a_via2_q_y_dup3_t2 r0 *1 0,0
Ra_inv_q_y_inv_q_y_via_inv_q_y_via2_nand_s2_a_nand_s2_a_stub_nand_s2_a_via_nand_s2_a_via2_q_y_dup3_t2
+ a|inv_q_y|inv_q_y_via|inv_q_y_via2|nand_s2_a|nand_s2_a_stub|nand_s2_a_via|nand_s2_a_via2|q|y__t24
+ a|inv_q_y|inv_q_y_via|inv_q_y_via2|nand_s2_a|nand_s2_a_stub|nand_s2_a_via|nand_s2_a_via2|q|y$3
+ 215.871984609
* device instance a_inv_q_y_inv_q_y_via_inv_q_y_via2_nand_s2_a_nand_s2_a_stub_nand_s2_a_via_nand_s2_a_via2_q_y_dup3_t3 r0 *1 0,0
Ra_inv_q_y_inv_q_y_via_inv_q_y_via2_nand_s2_a_nand_s2_a_stub_nand_s2_a_via_nand_s2_a_via2_q_y_dup3_t3
+ a|inv_q_y|inv_q_y_via|inv_q_y_via2|nand_s2_a|nand_s2_a_stub|nand_s2_a_via|nand_s2_a_via2|q|y__t34
+ a|inv_q_y|inv_q_y_via|inv_q_y_via2|nand_s2_a|nand_s2_a_stub|nand_s2_a_via|nand_s2_a_via2|q|y$3
+ 194.850123448
* device instance a_inv_q_y_inv_q_y_via_inv_q_y_via2_nand_s2_a_nand_s2_a_stub_nand_s2_a_via_nand_s2_a_via2_q_y_dup3 r0 *1 0,0
Ca_inv_q_y_inv_q_y_via_inv_q_y_via2_nand_s2_a_nand_s2_a_stub_nand_s2_a_via_nand_s2_a_via2_q_y_dup3
+ a|inv_q_y|inv_q_y_via|inv_q_y_via2|nand_s2_a|nand_s2_a_stub|nand_s2_a_via|nand_s2_a_via2|q|y$3
+ vsubs 2.217373e-15
* device instance a_inv_q_y_inv_q_y_via_inv_q_y_via2_nand_s2_a_nand_s2_a_stub_nand_s2_a_via_nand_s2_a_via2_q_y_dup4_t0 r0 *1 0,0
Ra_inv_q_y_inv_q_y_via_inv_q_y_via2_nand_s2_a_nand_s2_a_stub_nand_s2_a_via_nand_s2_a_via2_q_y_dup4_t0
+ a|inv_q_y|inv_q_y_via|inv_q_y_via2|nand_s2_a|nand_s2_a_stub|nand_s2_a_via|nand_s2_a_via2|q|y__t05
+ a|inv_q_y|inv_q_y_via|inv_q_y_via2|nand_s2_a|nand_s2_a_stub|nand_s2_a_via|nand_s2_a_via2|q|y$4
+ 204.258816542
* device instance a_inv_q_y_inv_q_y_via_inv_q_y_via2_nand_s2_a_nand_s2_a_stub_nand_s2_a_via_nand_s2_a_via2_q_y_dup4_t1 r0 *1 0,0
Ra_inv_q_y_inv_q_y_via_inv_q_y_via2_nand_s2_a_nand_s2_a_stub_nand_s2_a_via_nand_s2_a_via2_q_y_dup4_t1
+ a|inv_q_y|inv_q_y_via|inv_q_y_via2|nand_s2_a|nand_s2_a_stub|nand_s2_a_via|nand_s2_a_via2|q|y__t15
+ a|inv_q_y|inv_q_y_via|inv_q_y_via2|nand_s2_a|nand_s2_a_stub|nand_s2_a_via|nand_s2_a_via2|q|y$4
+ 202.157775401
* device instance a_inv_q_y_inv_q_y_via_inv_q_y_via2_nand_s2_a_nand_s2_a_stub_nand_s2_a_via_nand_s2_a_via2_q_y_dup4_t2 r0 *1 0,0
Ra_inv_q_y_inv_q_y_via_inv_q_y_via2_nand_s2_a_nand_s2_a_stub_nand_s2_a_via_nand_s2_a_via2_q_y_dup4_t2
+ a|inv_q_y|inv_q_y_via|inv_q_y_via2|nand_s2_a|nand_s2_a_stub|nand_s2_a_via|nand_s2_a_via2|q|y__t25
+ a|inv_q_y|inv_q_y_via|inv_q_y_via2|nand_s2_a|nand_s2_a_stub|nand_s2_a_via|nand_s2_a_via2|q|y$4
+ 215.871984609
* device instance a_inv_q_y_inv_q_y_via_inv_q_y_via2_nand_s2_a_nand_s2_a_stub_nand_s2_a_via_nand_s2_a_via2_q_y_dup4_t3 r0 *1 0,0
Ra_inv_q_y_inv_q_y_via_inv_q_y_via2_nand_s2_a_nand_s2_a_stub_nand_s2_a_via_nand_s2_a_via2_q_y_dup4_t3
+ a|inv_q_y|inv_q_y_via|inv_q_y_via2|nand_s2_a|nand_s2_a_stub|nand_s2_a_via|nand_s2_a_via2|q|y__t35
+ a|inv_q_y|inv_q_y_via|inv_q_y_via2|nand_s2_a|nand_s2_a_stub|nand_s2_a_via|nand_s2_a_via2|q|y$4
+ 194.850123448
* device instance a_inv_q_y_inv_q_y_via_inv_q_y_via2_nand_s2_a_nand_s2_a_stub_nand_s2_a_via_nand_s2_a_via2_q_y_dup4 r0 *1 0,0
Ca_inv_q_y_inv_q_y_via_inv_q_y_via2_nand_s2_a_nand_s2_a_stub_nand_s2_a_via_nand_s2_a_via2_q_y_dup4
+ a|inv_q_y|inv_q_y_via|inv_q_y_via2|nand_s2_a|nand_s2_a_stub|nand_s2_a_via|nand_s2_a_via2|q|y$4
+ vsubs 2.217373e-15
* device instance a_inv_q_y_inv_q_y_via_inv_q_y_via2_nand_s2_a_nand_s2_a_stub_nand_s2_a_via_nand_s2_a_via2_q_y_dup5_t0 r0 *1 0,0
Ra_inv_q_y_inv_q_y_via_inv_q_y_via2_nand_s2_a_nand_s2_a_stub_nand_s2_a_via_nand_s2_a_via2_q_y_dup5_t0
+ a|inv_q_y|inv_q_y_via|inv_q_y_via2|nand_s2_a|nand_s2_a_stub|nand_s2_a_via|nand_s2_a_via2|q|y__t06
+ a|inv_q_y|inv_q_y_via|inv_q_y_via2|nand_s2_a|nand_s2_a_stub|nand_s2_a_via|nand_s2_a_via2|q|y$5
+ 204.258816542
* device instance a_inv_q_y_inv_q_y_via_inv_q_y_via2_nand_s2_a_nand_s2_a_stub_nand_s2_a_via_nand_s2_a_via2_q_y_dup5_t1 r0 *1 0,0
Ra_inv_q_y_inv_q_y_via_inv_q_y_via2_nand_s2_a_nand_s2_a_stub_nand_s2_a_via_nand_s2_a_via2_q_y_dup5_t1
+ a|inv_q_y|inv_q_y_via|inv_q_y_via2|nand_s2_a|nand_s2_a_stub|nand_s2_a_via|nand_s2_a_via2|q|y__t16
+ a|inv_q_y|inv_q_y_via|inv_q_y_via2|nand_s2_a|nand_s2_a_stub|nand_s2_a_via|nand_s2_a_via2|q|y$5
+ 202.157775401
* device instance a_inv_q_y_inv_q_y_via_inv_q_y_via2_nand_s2_a_nand_s2_a_stub_nand_s2_a_via_nand_s2_a_via2_q_y_dup5_t2 r0 *1 0,0
Ra_inv_q_y_inv_q_y_via_inv_q_y_via2_nand_s2_a_nand_s2_a_stub_nand_s2_a_via_nand_s2_a_via2_q_y_dup5_t2
+ a|inv_q_y|inv_q_y_via|inv_q_y_via2|nand_s2_a|nand_s2_a_stub|nand_s2_a_via|nand_s2_a_via2|q|y__t26
+ a|inv_q_y|inv_q_y_via|inv_q_y_via2|nand_s2_a|nand_s2_a_stub|nand_s2_a_via|nand_s2_a_via2|q|y$5
+ 215.871984609
* device instance a_inv_q_y_inv_q_y_via_inv_q_y_via2_nand_s2_a_nand_s2_a_stub_nand_s2_a_via_nand_s2_a_via2_q_y_dup5_t3 r0 *1 0,0
Ra_inv_q_y_inv_q_y_via_inv_q_y_via2_nand_s2_a_nand_s2_a_stub_nand_s2_a_via_nand_s2_a_via2_q_y_dup5_t3
+ a|inv_q_y|inv_q_y_via|inv_q_y_via2|nand_s2_a|nand_s2_a_stub|nand_s2_a_via|nand_s2_a_via2|q|y__t36
+ a|inv_q_y|inv_q_y_via|inv_q_y_via2|nand_s2_a|nand_s2_a_stub|nand_s2_a_via|nand_s2_a_via2|q|y$5
+ 194.850123448
* device instance a_inv_q_y_inv_q_y_via_inv_q_y_via2_nand_s2_a_nand_s2_a_stub_nand_s2_a_via_nand_s2_a_via2_q_y_dup5 r0 *1 0,0
Ca_inv_q_y_inv_q_y_via_inv_q_y_via2_nand_s2_a_nand_s2_a_stub_nand_s2_a_via_nand_s2_a_via2_q_y_dup5
+ a|inv_q_y|inv_q_y_via|inv_q_y_via2|nand_s2_a|nand_s2_a_stub|nand_s2_a_via|nand_s2_a_via2|q|y$5
+ vsubs 2.217373e-15
* device instance a_inva_a_mn12_g0_mp13_g0_t1_y_t0 r0 *1 0,0
Ra_inva_a_mn12_g0_mp13_g0_t1_y_t0 a|inva_a|mn12_g0|mp13_g0|t1|y__t0
+ a|inva_a|mn12_g0|mp13_g0|t1|y 351.554644839
* device instance a_inva_a_mn12_g0_mp13_g0_t1_y_t1 r0 *1 0,0
Ra_inva_a_mn12_g0_mp13_g0_t1_y_t1 a|inva_a|mn12_g0|mp13_g0|t1|y__t1
+ a|inva_a|mn12_g0|mp13_g0|t1|y 317.053673396
* device instance a_inva_a_mn12_g0_mp13_g0_t1_y_t2 r0 *1 0,0
Ra_inva_a_mn12_g0_mp13_g0_t1_y_t2 a|inva_a|mn12_g0|mp13_g0|t1|y__t2
+ a|inva_a|mn12_g0|mp13_g0|t1|y 278.545833214
* device instance a_inva_a_mn12_g0_mp13_g0_t1_y_t3 r0 *1 0,0
Ra_inva_a_mn12_g0_mp13_g0_t1_y_t3 a|inva_a|mn12_g0|mp13_g0|t1|y__t3
+ a|inva_a|mn12_g0|mp13_g0|t1|y 266.957733013
* device instance a_inva_a_mn12_g0_mp13_g0_t1_y_t4 r0 *1 0,0
Ra_inva_a_mn12_g0_mp13_g0_t1_y_t4 a|inva_a|mn12_g0|mp13_g0|t1|y__t4
+ a|inva_a|mn12_g0|mp13_g0|t1|y 265.700413539
* device instance a_inva_a_mn12_g0_mp13_g0_t1_y_t5 r0 *1 0,0
Ra_inva_a_mn12_g0_mp13_g0_t1_y_t5 a|inva_a|mn12_g0|mp13_g0|t1|y__t5
+ a|inva_a|mn12_g0|mp13_g0|t1|y 399.388267495
* device instance a_inva_a_mn12_g0_mp13_g0_t1_y_t6 r0 *1 0,0
Ra_inva_a_mn12_g0_mp13_g0_t1_y_t6 a|inva_a|mn12_g0|mp13_g0|t1|y__t6
+ a|inva_a|mn12_g0|mp13_g0|t1|y 354.227187154
* device instance a_inva_a_mn12_g0_mp13_g0_t1_y_t7 r0 *1 0,0
Ra_inva_a_mn12_g0_mp13_g0_t1_y_t7 a|inva_a|mn12_g0|mp13_g0|t1|y__t7
+ a|inva_a|mn12_g0|mp13_g0|t1|y 275.08484735
* device instance a_inva_a_mn12_g0_mp13_g0_t1_y r0 *1 0,0
Ca_inva_a_mn12_g0_mp13_g0_t1_y a|inva_a|mn12_g0|mp13_g0|t1|y vsubs 1.2916904e-14
* device instance a_mnab_y_mpa_y_mpb_y_nand_s2_y_qb_tg_fbs_a_y_t0 r0 *1 0,0
Ra_mnab_y_mpa_y_mpb_y_nand_s2_y_qb_tg_fbs_a_y_t0
+ a|mnab_y|mpa_y|mpb_y|nand_s2_y|qb|tg_fbs_a|y__t0
+ a|mnab_y|mpa_y|mpb_y|nand_s2_y|qb|tg_fbs_a|y 120.815827453
* device instance a_mnab_y_mpa_y_mpb_y_nand_s2_y_qb_tg_fbs_a_y_t1 r0 *1 0,0
Ra_mnab_y_mpa_y_mpb_y_nand_s2_y_qb_tg_fbs_a_y_t1
+ a|mnab_y|mpa_y|mpb_y|nand_s2_y|qb|tg_fbs_a|y__t1
+ a|mnab_y|mpa_y|mpb_y|nand_s2_y|qb|tg_fbs_a|y 108.750076347
* device instance a_mnab_y_mpa_y_mpb_y_nand_s2_y_qb_tg_fbs_a_y_t2 r0 *1 0,0
Ra_mnab_y_mpa_y_mpb_y_nand_s2_y_qb_tg_fbs_a_y_t2
+ a|mnab_y|mpa_y|mpb_y|nand_s2_y|qb|tg_fbs_a|y__t2
+ a|mnab_y|mpa_y|mpb_y|nand_s2_y|qb|tg_fbs_a|y 101.428926114
* device instance a_mnab_y_mpa_y_mpb_y_nand_s2_y_qb_tg_fbs_a_y_t3 r0 *1 0,0
Ra_mnab_y_mpa_y_mpb_y_nand_s2_y_qb_tg_fbs_a_y_t3
+ a|mnab_y|mpa_y|mpb_y|nand_s2_y|qb|tg_fbs_a|y__t3
+ a|mnab_y|mpa_y|mpb_y|nand_s2_y|qb|tg_fbs_a|y 67.6227277536
* device instance a_mnab_y_mpa_y_mpb_y_nand_s2_y_qb_tg_fbs_a_y_t4 r0 *1 0,0
Ra_mnab_y_mpa_y_mpb_y_nand_s2_y_qb_tg_fbs_a_y_t4
+ a|mnab_y|mpa_y|mpb_y|nand_s2_y|qb|tg_fbs_a|y__t4
+ a|mnab_y|mpa_y|mpb_y|nand_s2_y|qb|tg_fbs_a|y 90.9332423319
* device instance a_mnab_y_mpa_y_mpb_y_nand_s2_y_qb_tg_fbs_a_y r0 *1 0,0
Ca_mnab_y_mpa_y_mpb_y_nand_s2_y_qb_tg_fbs_a_y
+ a|mnab_y|mpa_y|mpb_y|nand_s2_y|qb|tg_fbs_a|y vsubs 2.242968e-15
* device instance a_mnab_y_mpa_y_mpb_y_nand_s2_y_qb_tg_fbs_a_y_dup1_t0 r0 *1 0,0
Ra_mnab_y_mpa_y_mpb_y_nand_s2_y_qb_tg_fbs_a_y_dup1_t0
+ a|mnab_y|mpa_y|mpb_y|nand_s2_y|qb|tg_fbs_a|y__t02
+ a|mnab_y|mpa_y|mpb_y|nand_s2_y|qb|tg_fbs_a|y$1 120.815827453
* device instance a_mnab_y_mpa_y_mpb_y_nand_s2_y_qb_tg_fbs_a_y_dup1_t1 r0 *1 0,0
Ra_mnab_y_mpa_y_mpb_y_nand_s2_y_qb_tg_fbs_a_y_dup1_t1
+ a|mnab_y|mpa_y|mpb_y|nand_s2_y|qb|tg_fbs_a|y__t12
+ a|mnab_y|mpa_y|mpb_y|nand_s2_y|qb|tg_fbs_a|y$1 101.428926114
* device instance a_mnab_y_mpa_y_mpb_y_nand_s2_y_qb_tg_fbs_a_y_dup1_t2 r0 *1 0,0
Ra_mnab_y_mpa_y_mpb_y_nand_s2_y_qb_tg_fbs_a_y_dup1_t2
+ a|mnab_y|mpa_y|mpb_y|nand_s2_y|qb|tg_fbs_a|y__t22
+ a|mnab_y|mpa_y|mpb_y|nand_s2_y|qb|tg_fbs_a|y$1 108.750076347
* device instance a_mnab_y_mpa_y_mpb_y_nand_s2_y_qb_tg_fbs_a_y_dup1_t3 r0 *1 0,0
Ra_mnab_y_mpa_y_mpb_y_nand_s2_y_qb_tg_fbs_a_y_dup1_t3
+ a|mnab_y|mpa_y|mpb_y|nand_s2_y|qb|tg_fbs_a|y__t32
+ a|mnab_y|mpa_y|mpb_y|nand_s2_y|qb|tg_fbs_a|y$1 67.6227277536
* device instance a_mnab_y_mpa_y_mpb_y_nand_s2_y_qb_tg_fbs_a_y_dup1_t4 r0 *1 0,0
Ra_mnab_y_mpa_y_mpb_y_nand_s2_y_qb_tg_fbs_a_y_dup1_t4
+ a|mnab_y|mpa_y|mpb_y|nand_s2_y|qb|tg_fbs_a|y__t42
+ a|mnab_y|mpa_y|mpb_y|nand_s2_y|qb|tg_fbs_a|y$1 90.9332423319
* device instance a_mnab_y_mpa_y_mpb_y_nand_s2_y_qb_tg_fbs_a_y_dup1 r0 *1 0,0
Ca_mnab_y_mpa_y_mpb_y_nand_s2_y_qb_tg_fbs_a_y_dup1
+ a|mnab_y|mpa_y|mpb_y|nand_s2_y|qb|tg_fbs_a|y$1 vsubs 2.242968e-15
* device instance a_mnab_y_mpa_y_mpb_y_nand_s2_y_qb_tg_fbs_a_y_dup2_t0 r0 *1 0,0
Ra_mnab_y_mpa_y_mpb_y_nand_s2_y_qb_tg_fbs_a_y_dup2_t0
+ a|mnab_y|mpa_y|mpb_y|nand_s2_y|qb|tg_fbs_a|y__t03
+ a|mnab_y|mpa_y|mpb_y|nand_s2_y|qb|tg_fbs_a|y$2 120.815827453
* device instance a_mnab_y_mpa_y_mpb_y_nand_s2_y_qb_tg_fbs_a_y_dup2_t1 r0 *1 0,0
Ra_mnab_y_mpa_y_mpb_y_nand_s2_y_qb_tg_fbs_a_y_dup2_t1
+ a|mnab_y|mpa_y|mpb_y|nand_s2_y|qb|tg_fbs_a|y__t13
+ a|mnab_y|mpa_y|mpb_y|nand_s2_y|qb|tg_fbs_a|y$2 101.428926114
* device instance a_mnab_y_mpa_y_mpb_y_nand_s2_y_qb_tg_fbs_a_y_dup2_t2 r0 *1 0,0
Ra_mnab_y_mpa_y_mpb_y_nand_s2_y_qb_tg_fbs_a_y_dup2_t2
+ a|mnab_y|mpa_y|mpb_y|nand_s2_y|qb|tg_fbs_a|y__t23
+ a|mnab_y|mpa_y|mpb_y|nand_s2_y|qb|tg_fbs_a|y$2 108.750076347
* device instance a_mnab_y_mpa_y_mpb_y_nand_s2_y_qb_tg_fbs_a_y_dup2_t3 r0 *1 0,0
Ra_mnab_y_mpa_y_mpb_y_nand_s2_y_qb_tg_fbs_a_y_dup2_t3
+ a|mnab_y|mpa_y|mpb_y|nand_s2_y|qb|tg_fbs_a|y__t33
+ a|mnab_y|mpa_y|mpb_y|nand_s2_y|qb|tg_fbs_a|y$2 67.6227277536
* device instance a_mnab_y_mpa_y_mpb_y_nand_s2_y_qb_tg_fbs_a_y_dup2_t4 r0 *1 0,0
Ra_mnab_y_mpa_y_mpb_y_nand_s2_y_qb_tg_fbs_a_y_dup2_t4
+ a|mnab_y|mpa_y|mpb_y|nand_s2_y|qb|tg_fbs_a|y__t43
+ a|mnab_y|mpa_y|mpb_y|nand_s2_y|qb|tg_fbs_a|y$2 90.9332423319
* device instance a_mnab_y_mpa_y_mpb_y_nand_s2_y_qb_tg_fbs_a_y_dup2 r0 *1 0,0
Ca_mnab_y_mpa_y_mpb_y_nand_s2_y_qb_tg_fbs_a_y_dup2
+ a|mnab_y|mpa_y|mpb_y|nand_s2_y|qb|tg_fbs_a|y$2 vsubs 2.242968e-15
* device instance a_mnab_y_mpa_y_mpb_y_nand_s2_y_qb_tg_fbs_a_y_dup3_t0 r0 *1 0,0
Ra_mnab_y_mpa_y_mpb_y_nand_s2_y_qb_tg_fbs_a_y_dup3_t0
+ a|mnab_y|mpa_y|mpb_y|nand_s2_y|qb|tg_fbs_a|y__t04
+ a|mnab_y|mpa_y|mpb_y|nand_s2_y|qb|tg_fbs_a|y$3 120.815827453
* device instance a_mnab_y_mpa_y_mpb_y_nand_s2_y_qb_tg_fbs_a_y_dup3_t1 r0 *1 0,0
Ra_mnab_y_mpa_y_mpb_y_nand_s2_y_qb_tg_fbs_a_y_dup3_t1
+ a|mnab_y|mpa_y|mpb_y|nand_s2_y|qb|tg_fbs_a|y__t14
+ a|mnab_y|mpa_y|mpb_y|nand_s2_y|qb|tg_fbs_a|y$3 101.428926114
* device instance a_mnab_y_mpa_y_mpb_y_nand_s2_y_qb_tg_fbs_a_y_dup3_t2 r0 *1 0,0
Ra_mnab_y_mpa_y_mpb_y_nand_s2_y_qb_tg_fbs_a_y_dup3_t2
+ a|mnab_y|mpa_y|mpb_y|nand_s2_y|qb|tg_fbs_a|y__t24
+ a|mnab_y|mpa_y|mpb_y|nand_s2_y|qb|tg_fbs_a|y$3 108.750076347
* device instance a_mnab_y_mpa_y_mpb_y_nand_s2_y_qb_tg_fbs_a_y_dup3_t3 r0 *1 0,0
Ra_mnab_y_mpa_y_mpb_y_nand_s2_y_qb_tg_fbs_a_y_dup3_t3
+ a|mnab_y|mpa_y|mpb_y|nand_s2_y|qb|tg_fbs_a|y__t34
+ a|mnab_y|mpa_y|mpb_y|nand_s2_y|qb|tg_fbs_a|y$3 67.6227277536
* device instance a_mnab_y_mpa_y_mpb_y_nand_s2_y_qb_tg_fbs_a_y_dup3_t4 r0 *1 0,0
Ra_mnab_y_mpa_y_mpb_y_nand_s2_y_qb_tg_fbs_a_y_dup3_t4
+ a|mnab_y|mpa_y|mpb_y|nand_s2_y|qb|tg_fbs_a|y__t44
+ a|mnab_y|mpa_y|mpb_y|nand_s2_y|qb|tg_fbs_a|y$3 90.9332423319
* device instance a_mnab_y_mpa_y_mpb_y_nand_s2_y_qb_tg_fbs_a_y_dup3 r0 *1 0,0
Ca_mnab_y_mpa_y_mpb_y_nand_s2_y_qb_tg_fbs_a_y_dup3
+ a|mnab_y|mpa_y|mpb_y|nand_s2_y|qb|tg_fbs_a|y$3 vsubs 2.242968e-15
* device instance a_mnab_y_mpa_y_mpb_y_nand_s2_y_qb_tg_fbs_a_y_dup4_t0 r0 *1 0,0
Ra_mnab_y_mpa_y_mpb_y_nand_s2_y_qb_tg_fbs_a_y_dup4_t0
+ a|mnab_y|mpa_y|mpb_y|nand_s2_y|qb|tg_fbs_a|y__t05
+ a|mnab_y|mpa_y|mpb_y|nand_s2_y|qb|tg_fbs_a|y$4 120.815827453
* device instance a_mnab_y_mpa_y_mpb_y_nand_s2_y_qb_tg_fbs_a_y_dup4_t1 r0 *1 0,0
Ra_mnab_y_mpa_y_mpb_y_nand_s2_y_qb_tg_fbs_a_y_dup4_t1
+ a|mnab_y|mpa_y|mpb_y|nand_s2_y|qb|tg_fbs_a|y__t15
+ a|mnab_y|mpa_y|mpb_y|nand_s2_y|qb|tg_fbs_a|y$4 101.428926114
* device instance a_mnab_y_mpa_y_mpb_y_nand_s2_y_qb_tg_fbs_a_y_dup4_t2 r0 *1 0,0
Ra_mnab_y_mpa_y_mpb_y_nand_s2_y_qb_tg_fbs_a_y_dup4_t2
+ a|mnab_y|mpa_y|mpb_y|nand_s2_y|qb|tg_fbs_a|y__t25
+ a|mnab_y|mpa_y|mpb_y|nand_s2_y|qb|tg_fbs_a|y$4 108.750076347
* device instance a_mnab_y_mpa_y_mpb_y_nand_s2_y_qb_tg_fbs_a_y_dup4_t3 r0 *1 0,0
Ra_mnab_y_mpa_y_mpb_y_nand_s2_y_qb_tg_fbs_a_y_dup4_t3
+ a|mnab_y|mpa_y|mpb_y|nand_s2_y|qb|tg_fbs_a|y__t35
+ a|mnab_y|mpa_y|mpb_y|nand_s2_y|qb|tg_fbs_a|y$4 67.6227277536
* device instance a_mnab_y_mpa_y_mpb_y_nand_s2_y_qb_tg_fbs_a_y_dup4_t4 r0 *1 0,0
Ra_mnab_y_mpa_y_mpb_y_nand_s2_y_qb_tg_fbs_a_y_dup4_t4
+ a|mnab_y|mpa_y|mpb_y|nand_s2_y|qb|tg_fbs_a|y__t45
+ a|mnab_y|mpa_y|mpb_y|nand_s2_y|qb|tg_fbs_a|y$4 90.9332423319
* device instance a_mnab_y_mpa_y_mpb_y_nand_s2_y_qb_tg_fbs_a_y_dup4 r0 *1 0,0
Ca_mnab_y_mpa_y_mpb_y_nand_s2_y_qb_tg_fbs_a_y_dup4
+ a|mnab_y|mpa_y|mpb_y|nand_s2_y|qb|tg_fbs_a|y$4 vsubs 2.242968e-15
* device instance a_mnab_y_mpa_y_mpb_y_nand_s2_y_qb_tg_fbs_a_y_dup5_t0 r0 *1 0,0
Ra_mnab_y_mpa_y_mpb_y_nand_s2_y_qb_tg_fbs_a_y_dup5_t0
+ a|mnab_y|mpa_y|mpb_y|nand_s2_y|qb|tg_fbs_a|y__t06
+ a|mnab_y|mpa_y|mpb_y|nand_s2_y|qb|tg_fbs_a|y$5 120.815827453
* device instance a_mnab_y_mpa_y_mpb_y_nand_s2_y_qb_tg_fbs_a_y_dup5_t1 r0 *1 0,0
Ra_mnab_y_mpa_y_mpb_y_nand_s2_y_qb_tg_fbs_a_y_dup5_t1
+ a|mnab_y|mpa_y|mpb_y|nand_s2_y|qb|tg_fbs_a|y__t16
+ a|mnab_y|mpa_y|mpb_y|nand_s2_y|qb|tg_fbs_a|y$5 108.750076347
* device instance a_mnab_y_mpa_y_mpb_y_nand_s2_y_qb_tg_fbs_a_y_dup5_t2 r0 *1 0,0
Ra_mnab_y_mpa_y_mpb_y_nand_s2_y_qb_tg_fbs_a_y_dup5_t2
+ a|mnab_y|mpa_y|mpb_y|nand_s2_y|qb|tg_fbs_a|y__t26
+ a|mnab_y|mpa_y|mpb_y|nand_s2_y|qb|tg_fbs_a|y$5 101.428926114
* device instance a_mnab_y_mpa_y_mpb_y_nand_s2_y_qb_tg_fbs_a_y_dup5_t3 r0 *1 0,0
Ra_mnab_y_mpa_y_mpb_y_nand_s2_y_qb_tg_fbs_a_y_dup5_t3
+ a|mnab_y|mpa_y|mpb_y|nand_s2_y|qb|tg_fbs_a|y__t36
+ a|mnab_y|mpa_y|mpb_y|nand_s2_y|qb|tg_fbs_a|y$5 67.6227277536
* device instance a_mnab_y_mpa_y_mpb_y_nand_s2_y_qb_tg_fbs_a_y_dup5_t4 r0 *1 0,0
Ra_mnab_y_mpa_y_mpb_y_nand_s2_y_qb_tg_fbs_a_y_dup5_t4
+ a|mnab_y|mpa_y|mpb_y|nand_s2_y|qb|tg_fbs_a|y__t46
+ a|mnab_y|mpa_y|mpb_y|nand_s2_y|qb|tg_fbs_a|y$5 90.9332423319
* device instance a_mnab_y_mpa_y_mpb_y_nand_s2_y_qb_tg_fbs_a_y_dup5 r0 *1 0,0
Ca_mnab_y_mpa_y_mpb_y_nand_s2_y_qb_tg_fbs_a_y_dup5
+ a|mnab_y|mpa_y|mpb_y|nand_s2_y|qb|tg_fbs_a|y$5 vsubs 2.242968e-15
* device instance a_n2_s1_y_s2_a_y_t0 r0 *1 0,0
Ra_n2_s1_y_s2_a_y_t0 a|n2|s1_y|s2_a|y__t0 a|n2|s1_y|s2_a|y 184.787796322
* device instance a_n2_s1_y_s2_a_y_t1 r0 *1 0,0
Ra_n2_s1_y_s2_a_y_t1 a|n2|s1_y|s2_a|y__t1 a|n2|s1_y|s2_a|y 192.568303678
* device instance a_n2_s1_y_s2_a_y_t2 r0 *1 0,0
Ra_n2_s1_y_s2_a_y_t2 a|n2|s1_y|s2_a|y__t2 a|n2|s1_y|s2_a|y 192.568303678
* device instance a_n2_s1_y_s2_a_y_t3 r0 *1 0,0
Ra_n2_s1_y_s2_a_y_t3 a|n2|s1_y|s2_a|y__t3 a|n2|s1_y|s2_a|y 184.787796322
* device instance a_n2_s1_y_s2_a_y r0 *1 0,0
Ca_n2_s1_y_s2_a_y a|n2|s1_y|s2_a|y vsubs 2.529995e-15
* device instance a_n2_s1_y_s2_a_y_dup1_t0 r0 *1 0,0
Ra_n2_s1_y_s2_a_y_dup1_t0 a|n2|s1_y|s2_a|y__t02 a|n2|s1_y|s2_a|y$1 184.787796322
* device instance a_n2_s1_y_s2_a_y_dup1_t1 r0 *1 0,0
Ra_n2_s1_y_s2_a_y_dup1_t1 a|n2|s1_y|s2_a|y__t12 a|n2|s1_y|s2_a|y$1 192.568303678
* device instance a_n2_s1_y_s2_a_y_dup1_t2 r0 *1 0,0
Ra_n2_s1_y_s2_a_y_dup1_t2 a|n2|s1_y|s2_a|y__t22 a|n2|s1_y|s2_a|y$1 192.568303678
* device instance a_n2_s1_y_s2_a_y_dup1_t3 r0 *1 0,0
Ra_n2_s1_y_s2_a_y_dup1_t3 a|n2|s1_y|s2_a|y__t32 a|n2|s1_y|s2_a|y$1 184.787796322
* device instance a_n2_s1_y_s2_a_y_dup1 r0 *1 0,0
Ca_n2_s1_y_s2_a_y_dup1 a|n2|s1_y|s2_a|y$1 vsubs 2.529995e-15
* device instance a_n2_s1_y_s2_a_y_dup2_t0 r0 *1 0,0
Ra_n2_s1_y_s2_a_y_dup2_t0 a|n2|s1_y|s2_a|y__t03 a|n2|s1_y|s2_a|y$2 184.787796322
* device instance a_n2_s1_y_s2_a_y_dup2_t1 r0 *1 0,0
Ra_n2_s1_y_s2_a_y_dup2_t1 a|n2|s1_y|s2_a|y__t13 a|n2|s1_y|s2_a|y$2 192.568303678
* device instance a_n2_s1_y_s2_a_y_dup2_t2 r0 *1 0,0
Ra_n2_s1_y_s2_a_y_dup2_t2 a|n2|s1_y|s2_a|y__t23 a|n2|s1_y|s2_a|y$2 192.568303678
* device instance a_n2_s1_y_s2_a_y_dup2_t3 r0 *1 0,0
Ra_n2_s1_y_s2_a_y_dup2_t3 a|n2|s1_y|s2_a|y__t33 a|n2|s1_y|s2_a|y$2 184.787796322
* device instance a_n2_s1_y_s2_a_y_dup2 r0 *1 0,0
Ca_n2_s1_y_s2_a_y_dup2 a|n2|s1_y|s2_a|y$2 vsubs 2.529995e-15
* device instance a_n2_s1_y_s2_a_y_dup3_t0 r0 *1 0,0
Ra_n2_s1_y_s2_a_y_dup3_t0 a|n2|s1_y|s2_a|y__t04 a|n2|s1_y|s2_a|y$3 184.787796322
* device instance a_n2_s1_y_s2_a_y_dup3_t1 r0 *1 0,0
Ra_n2_s1_y_s2_a_y_dup3_t1 a|n2|s1_y|s2_a|y__t14 a|n2|s1_y|s2_a|y$3 192.568303678
* device instance a_n2_s1_y_s2_a_y_dup3_t2 r0 *1 0,0
Ra_n2_s1_y_s2_a_y_dup3_t2 a|n2|s1_y|s2_a|y__t24 a|n2|s1_y|s2_a|y$3 192.568303678
* device instance a_n2_s1_y_s2_a_y_dup3_t3 r0 *1 0,0
Ra_n2_s1_y_s2_a_y_dup3_t3 a|n2|s1_y|s2_a|y__t34 a|n2|s1_y|s2_a|y$3 184.787796322
* device instance a_n2_s1_y_s2_a_y_dup3 r0 *1 0,0
Ca_n2_s1_y_s2_a_y_dup3 a|n2|s1_y|s2_a|y$3 vsubs 2.529995e-15
* device instance a_n3_s2_y_s3_a_y_t0 r0 *1 0,0
Ra_n3_s2_y_s3_a_y_t0 a|n3|s2_y|s3_a|y__t0 a|n3|s2_y|s3_a|y 184.787796322
* device instance a_n3_s2_y_s3_a_y_t1 r0 *1 0,0
Ra_n3_s2_y_s3_a_y_t1 a|n3|s2_y|s3_a|y__t1 a|n3|s2_y|s3_a|y 192.568303678
* device instance a_n3_s2_y_s3_a_y_t2 r0 *1 0,0
Ra_n3_s2_y_s3_a_y_t2 a|n3|s2_y|s3_a|y__t2 a|n3|s2_y|s3_a|y 192.568303678
* device instance a_n3_s2_y_s3_a_y_t3 r0 *1 0,0
Ra_n3_s2_y_s3_a_y_t3 a|n3|s2_y|s3_a|y__t3 a|n3|s2_y|s3_a|y 184.787796322
* device instance a_n3_s2_y_s3_a_y r0 *1 0,0
Ca_n3_s2_y_s3_a_y a|n3|s2_y|s3_a|y vsubs 2.529995e-15
* device instance a_n3_s2_y_s3_a_y_dup1_t0 r0 *1 0,0
Ra_n3_s2_y_s3_a_y_dup1_t0 a|n3|s2_y|s3_a|y__t02 a|n3|s2_y|s3_a|y$1 184.787796322
* device instance a_n3_s2_y_s3_a_y_dup1_t1 r0 *1 0,0
Ra_n3_s2_y_s3_a_y_dup1_t1 a|n3|s2_y|s3_a|y__t12 a|n3|s2_y|s3_a|y$1 192.568303678
* device instance a_n3_s2_y_s3_a_y_dup1_t2 r0 *1 0,0
Ra_n3_s2_y_s3_a_y_dup1_t2 a|n3|s2_y|s3_a|y__t22 a|n3|s2_y|s3_a|y$1 192.568303678
* device instance a_n3_s2_y_s3_a_y_dup1_t3 r0 *1 0,0
Ra_n3_s2_y_s3_a_y_dup1_t3 a|n3|s2_y|s3_a|y__t32 a|n3|s2_y|s3_a|y$1 184.787796322
* device instance a_n3_s2_y_s3_a_y_dup1 r0 *1 0,0
Ca_n3_s2_y_s3_a_y_dup1 a|n3|s2_y|s3_a|y$1 vsubs 2.529995e-15
* device instance a_n3_s2_y_s3_a_y_dup2_t0 r0 *1 0,0
Ra_n3_s2_y_s3_a_y_dup2_t0 a|n3|s2_y|s3_a|y__t03 a|n3|s2_y|s3_a|y$2 184.787796322
* device instance a_n3_s2_y_s3_a_y_dup2_t1 r0 *1 0,0
Ra_n3_s2_y_s3_a_y_dup2_t1 a|n3|s2_y|s3_a|y__t13 a|n3|s2_y|s3_a|y$2 192.568303678
* device instance a_n3_s2_y_s3_a_y_dup2_t2 r0 *1 0,0
Ra_n3_s2_y_s3_a_y_dup2_t2 a|n3|s2_y|s3_a|y__t23 a|n3|s2_y|s3_a|y$2 192.568303678
* device instance a_n3_s2_y_s3_a_y_dup2_t3 r0 *1 0,0
Ra_n3_s2_y_s3_a_y_dup2_t3 a|n3|s2_y|s3_a|y__t33 a|n3|s2_y|s3_a|y$2 184.787796322
* device instance a_n3_s2_y_s3_a_y_dup2 r0 *1 0,0
Ca_n3_s2_y_s3_a_y_dup2 a|n3|s2_y|s3_a|y$2 vsubs 2.529995e-15
* device instance a_n3_s2_y_s3_a_y_dup3_t0 r0 *1 0,0
Ra_n3_s2_y_s3_a_y_dup3_t0 a|n3|s2_y|s3_a|y__t04 a|n3|s2_y|s3_a|y$3 184.787796322
* device instance a_n3_s2_y_s3_a_y_dup3_t1 r0 *1 0,0
Ra_n3_s2_y_s3_a_y_dup3_t1 a|n3|s2_y|s3_a|y__t14 a|n3|s2_y|s3_a|y$3 192.568303678
* device instance a_n3_s2_y_s3_a_y_dup3_t2 r0 *1 0,0
Ra_n3_s2_y_s3_a_y_dup3_t2 a|n3|s2_y|s3_a|y__t24 a|n3|s2_y|s3_a|y$3 192.568303678
* device instance a_n3_s2_y_s3_a_y_dup3_t3 r0 *1 0,0
Ra_n3_s2_y_s3_a_y_dup3_t3 a|n3|s2_y|s3_a|y__t34 a|n3|s2_y|s3_a|y$3 184.787796322
* device instance a_n3_s2_y_s3_a_y_dup3 r0 *1 0,0
Ca_n3_s2_y_s3_a_y_dup3 a|n3|s2_y|s3_a|y$3 vsubs 2.529995e-15
* device instance a_n4_s3_y_s4_a_y_t0 r0 *1 0,0
Ra_n4_s3_y_s4_a_y_t0 a|n4|s3_y|s4_a|y__t0 a|n4|s3_y|s4_a|y 184.787796322
* device instance a_n4_s3_y_s4_a_y_t1 r0 *1 0,0
Ra_n4_s3_y_s4_a_y_t1 a|n4|s3_y|s4_a|y__t1 a|n4|s3_y|s4_a|y 192.568303678
* device instance a_n4_s3_y_s4_a_y_t2 r0 *1 0,0
Ra_n4_s3_y_s4_a_y_t2 a|n4|s3_y|s4_a|y__t2 a|n4|s3_y|s4_a|y 192.568303678
* device instance a_n4_s3_y_s4_a_y_t3 r0 *1 0,0
Ra_n4_s3_y_s4_a_y_t3 a|n4|s3_y|s4_a|y__t3 a|n4|s3_y|s4_a|y 184.787796322
* device instance a_n4_s3_y_s4_a_y r0 *1 0,0
Ca_n4_s3_y_s4_a_y a|n4|s3_y|s4_a|y vsubs 2.529995e-15
* device instance a_n4_s3_y_s4_a_y_dup1_t0 r0 *1 0,0
Ra_n4_s3_y_s4_a_y_dup1_t0 a|n4|s3_y|s4_a|y__t02 a|n4|s3_y|s4_a|y$1 184.787796322
* device instance a_n4_s3_y_s4_a_y_dup1_t1 r0 *1 0,0
Ra_n4_s3_y_s4_a_y_dup1_t1 a|n4|s3_y|s4_a|y__t12 a|n4|s3_y|s4_a|y$1 192.568303678
* device instance a_n4_s3_y_s4_a_y_dup1_t2 r0 *1 0,0
Ra_n4_s3_y_s4_a_y_dup1_t2 a|n4|s3_y|s4_a|y__t22 a|n4|s3_y|s4_a|y$1 192.568303678
* device instance a_n4_s3_y_s4_a_y_dup1_t3 r0 *1 0,0
Ra_n4_s3_y_s4_a_y_dup1_t3 a|n4|s3_y|s4_a|y__t32 a|n4|s3_y|s4_a|y$1 184.787796322
* device instance a_n4_s3_y_s4_a_y_dup1 r0 *1 0,0
Ca_n4_s3_y_s4_a_y_dup1 a|n4|s3_y|s4_a|y$1 vsubs 2.529995e-15
* device instance a_n4_s3_y_s4_a_y_dup2_t0 r0 *1 0,0
Ra_n4_s3_y_s4_a_y_dup2_t0 a|n4|s3_y|s4_a|y__t03 a|n4|s3_y|s4_a|y$2 184.787796322
* device instance a_n4_s3_y_s4_a_y_dup2_t1 r0 *1 0,0
Ra_n4_s3_y_s4_a_y_dup2_t1 a|n4|s3_y|s4_a|y__t13 a|n4|s3_y|s4_a|y$2 192.568303678
* device instance a_n4_s3_y_s4_a_y_dup2_t2 r0 *1 0,0
Ra_n4_s3_y_s4_a_y_dup2_t2 a|n4|s3_y|s4_a|y__t23 a|n4|s3_y|s4_a|y$2 192.568303678
* device instance a_n4_s3_y_s4_a_y_dup2_t3 r0 *1 0,0
Ra_n4_s3_y_s4_a_y_dup2_t3 a|n4|s3_y|s4_a|y__t33 a|n4|s3_y|s4_a|y$2 184.787796322
* device instance a_n4_s3_y_s4_a_y_dup2 r0 *1 0,0
Ca_n4_s3_y_s4_a_y_dup2 a|n4|s3_y|s4_a|y$2 vsubs 2.529995e-15
* device instance a_n4_s3_y_s4_a_y_dup3_t0 r0 *1 0,0
Ra_n4_s3_y_s4_a_y_dup3_t0 a|n4|s3_y|s4_a|y__t04 a|n4|s3_y|s4_a|y$3 184.787796322
* device instance a_n4_s3_y_s4_a_y_dup3_t1 r0 *1 0,0
Ra_n4_s3_y_s4_a_y_dup3_t1 a|n4|s3_y|s4_a|y__t14 a|n4|s3_y|s4_a|y$3 192.568303678
* device instance a_n4_s3_y_s4_a_y_dup3_t2 r0 *1 0,0
Ra_n4_s3_y_s4_a_y_dup3_t2 a|n4|s3_y|s4_a|y__t24 a|n4|s3_y|s4_a|y$3 192.568303678
* device instance a_n4_s3_y_s4_a_y_dup3_t3 r0 *1 0,0
Ra_n4_s3_y_s4_a_y_dup3_t3 a|n4|s3_y|s4_a|y__t34 a|n4|s3_y|s4_a|y$3 184.787796322
* device instance a_n4_s3_y_s4_a_y_dup3 r0 *1 0,0
Ca_n4_s3_y_s4_a_y_dup3 a|n4|s3_y|s4_a|y$3 vsubs 2.529995e-15
* device instance an_inva_y_mn34_g0_mp13_g1_y_t0 r0 *1 0,0
Ran_inva_y_mn34_g0_mp13_g1_y_t0 an|inva_y|mn34_g0|mp13_g1|y__t0
+ an|inva_y|mn34_g0|mp13_g1|y 230.258451211
* device instance an_inva_y_mn34_g0_mp13_g1_y_t1 r0 *1 0,0
Ran_inva_y_mn34_g0_mp13_g1_y_t1 an|inva_y|mn34_g0|mp13_g1|y__t1
+ an|inva_y|mn34_g0|mp13_g1|y 119.633507818
* device instance an_inva_y_mn34_g0_mp13_g1_y_t2 r0 *1 0,0
Ran_inva_y_mn34_g0_mp13_g1_y_t2 an|inva_y|mn34_g0|mp13_g1|y__t2
+ an|inva_y|mn34_g0|mp13_g1|y 96.6767800657
* device instance an_inva_y_mn34_g0_mp13_g1_y_t3 r0 *1 0,0
Ran_inva_y_mn34_g0_mp13_g1_y_t3 an|inva_y|mn34_g0|mp13_g1|y__t3
+ an|inva_y|mn34_g0|mp13_g1|y 189.611560905
* device instance an_inva_y_mn34_g0_mp13_g1_y r0 *1 0,0
Can_inva_y_mn34_g0_mp13_g1_y an|inva_y|mn34_g0|mp13_g1|y vsubs 2.183901e-15
* device instance an_inva_y_mn34_g0_mp13_g1_y_dup1_t0 r0 *1 0,0
Ran_inva_y_mn34_g0_mp13_g1_y_dup1_t0 an|inva_y|mn34_g0|mp13_g1|y__t02
+ an|inva_y|mn34_g0|mp13_g1|y$1 230.258451211
* device instance an_inva_y_mn34_g0_mp13_g1_y_dup1_t1 r0 *1 0,0
Ran_inva_y_mn34_g0_mp13_g1_y_dup1_t1 an|inva_y|mn34_g0|mp13_g1|y__t12
+ an|inva_y|mn34_g0|mp13_g1|y$1 119.633507818
* device instance an_inva_y_mn34_g0_mp13_g1_y_dup1_t2 r0 *1 0,0
Ran_inva_y_mn34_g0_mp13_g1_y_dup1_t2 an|inva_y|mn34_g0|mp13_g1|y__t22
+ an|inva_y|mn34_g0|mp13_g1|y$1 96.6767800657
* device instance an_inva_y_mn34_g0_mp13_g1_y_dup1_t3 r0 *1 0,0
Ran_inva_y_mn34_g0_mp13_g1_y_dup1_t3 an|inva_y|mn34_g0|mp13_g1|y__t32
+ an|inva_y|mn34_g0|mp13_g1|y$1 189.611560905
* device instance an_inva_y_mn34_g0_mp13_g1_y_dup1 r0 *1 0,0
Can_inva_y_mn34_g0_mp13_g1_y_dup1 an|inva_y|mn34_g0|mp13_g1|y$1 vsubs
+ 2.183901e-15
* device instance an_inva_y_mn34_g0_mp13_g1_y_dup2_t0 r0 *1 0,0
Ran_inva_y_mn34_g0_mp13_g1_y_dup2_t0 an|inva_y|mn34_g0|mp13_g1|y__t03
+ an|inva_y|mn34_g0|mp13_g1|y$2 230.258451211
* device instance an_inva_y_mn34_g0_mp13_g1_y_dup2_t1 r0 *1 0,0
Ran_inva_y_mn34_g0_mp13_g1_y_dup2_t1 an|inva_y|mn34_g0|mp13_g1|y__t13
+ an|inva_y|mn34_g0|mp13_g1|y$2 119.633507818
* device instance an_inva_y_mn34_g0_mp13_g1_y_dup2_t2 r0 *1 0,0
Ran_inva_y_mn34_g0_mp13_g1_y_dup2_t2 an|inva_y|mn34_g0|mp13_g1|y__t23
+ an|inva_y|mn34_g0|mp13_g1|y$2 96.6767800657
* device instance an_inva_y_mn34_g0_mp13_g1_y_dup2_t3 r0 *1 0,0
Ran_inva_y_mn34_g0_mp13_g1_y_dup2_t3 an|inva_y|mn34_g0|mp13_g1|y__t33
+ an|inva_y|mn34_g0|mp13_g1|y$2 189.611560905
* device instance an_inva_y_mn34_g0_mp13_g1_y_dup2 r0 *1 0,0
Can_inva_y_mn34_g0_mp13_g1_y_dup2 an|inva_y|mn34_g0|mp13_g1|y$2 vsubs
+ 2.183901e-15
* device instance bn_invb_y_mn34_g1_mp24_g1_y_t0 r0 *1 0,0
Rbn_invb_y_mn34_g1_mp24_g1_y_t0 bn|invb_y|mn34_g1|mp24_g1|y__t0
+ bn|invb_y|mn34_g1|mp24_g1|y 150.090536447
* device instance bn_invb_y_mn34_g1_mp24_g1_y_t1 r0 *1 0,0
Rbn_invb_y_mn34_g1_mp24_g1_y_t1 bn|invb_y|mn34_g1|mp24_g1|y__t1
+ bn|invb_y|mn34_g1|mp24_g1|y 140.899097172
* device instance bn_invb_y_mn34_g1_mp24_g1_y_t2 r0 *1 0,0
Rbn_invb_y_mn34_g1_mp24_g1_y_t2 bn|invb_y|mn34_g1|mp24_g1|y__t2
+ bn|invb_y|mn34_g1|mp24_g1|y 132.774766529
* device instance bn_invb_y_mn34_g1_mp24_g1_y_t3 r0 *1 0,0
Rbn_invb_y_mn34_g1_mp24_g1_y_t3 bn|invb_y|mn34_g1|mp24_g1|y__t3
+ bn|invb_y|mn34_g1|mp24_g1|y 237.698599852
* device instance bn_invb_y_mn34_g1_mp24_g1_y r0 *1 0,0
Cbn_invb_y_mn34_g1_mp24_g1_y bn|invb_y|mn34_g1|mp24_g1|y vsubs 5.127304e-15
* device instance bn_invb_y_mn34_g1_mp24_g1_y_dup1_t0 r0 *1 0,0
Rbn_invb_y_mn34_g1_mp24_g1_y_dup1_t0 bn|invb_y|mn34_g1|mp24_g1|y__t02
+ bn|invb_y|mn34_g1|mp24_g1|y$1 150.090536447
* device instance bn_invb_y_mn34_g1_mp24_g1_y_dup1_t1 r0 *1 0,0
Rbn_invb_y_mn34_g1_mp24_g1_y_dup1_t1 bn|invb_y|mn34_g1|mp24_g1|y__t12
+ bn|invb_y|mn34_g1|mp24_g1|y$1 140.899097172
* device instance bn_invb_y_mn34_g1_mp24_g1_y_dup1_t2 r0 *1 0,0
Rbn_invb_y_mn34_g1_mp24_g1_y_dup1_t2 bn|invb_y|mn34_g1|mp24_g1|y__t22
+ bn|invb_y|mn34_g1|mp24_g1|y$1 132.774766529
* device instance bn_invb_y_mn34_g1_mp24_g1_y_dup1_t3 r0 *1 0,0
Rbn_invb_y_mn34_g1_mp24_g1_y_dup1_t3 bn|invb_y|mn34_g1|mp24_g1|y__t32
+ bn|invb_y|mn34_g1|mp24_g1|y$1 237.698599852
* device instance bn_invb_y_mn34_g1_mp24_g1_y_dup1 r0 *1 0,0
Cbn_invb_y_mn34_g1_mp24_g1_y_dup1 bn|invb_y|mn34_g1|mp24_g1|y$1 vsubs
+ 5.127304e-15
* device instance bn_invb_y_mn34_g1_mp24_g1_y_dup2_t0 r0 *1 0,0
Rbn_invb_y_mn34_g1_mp24_g1_y_dup2_t0 bn|invb_y|mn34_g1|mp24_g1|y__t03
+ bn|invb_y|mn34_g1|mp24_g1|y$2 150.090536447
* device instance bn_invb_y_mn34_g1_mp24_g1_y_dup2_t1 r0 *1 0,0
Rbn_invb_y_mn34_g1_mp24_g1_y_dup2_t1 bn|invb_y|mn34_g1|mp24_g1|y__t13
+ bn|invb_y|mn34_g1|mp24_g1|y$2 140.899097172
* device instance bn_invb_y_mn34_g1_mp24_g1_y_dup2_t2 r0 *1 0,0
Rbn_invb_y_mn34_g1_mp24_g1_y_dup2_t2 bn|invb_y|mn34_g1|mp24_g1|y__t23
+ bn|invb_y|mn34_g1|mp24_g1|y$2 132.774766529
* device instance bn_invb_y_mn34_g1_mp24_g1_y_dup2_t3 r0 *1 0,0
Rbn_invb_y_mn34_g1_mp24_g1_y_dup2_t3 bn|invb_y|mn34_g1|mp24_g1|y__t33
+ bn|invb_y|mn34_g1|mp24_g1|y$2 237.698599852
* device instance bn_invb_y_mn34_g1_mp24_g1_y_dup2 r0 *1 0,0
Cbn_invb_y_mn34_g1_mp24_g1_y_dup2 bn|invb_y|mn34_g1|mp24_g1|y$2 vsubs
+ 5.126559e-15
* device instance clk_t0 r0 *1 0,0
Rclk_t0 clk__t0 clk 249.920032745
* device instance clk_t1 r0 *1 0,0
Rclk_t1 clk__t1 clk 249.920032745
* device instance clk_t2 r0 *1 0,0
Rclk_t2 clk__t2 clk 104.742257905
* device instance clk_t3 r0 *1 0,0
Rclk_t3 clk__t3 clk 143.047467336
* device instance clk_t4 r0 *1 0,0
Rclk_t4 clk__t4 clk 62.6120011073
* device instance clk_t5 r0 *1 0,0
Rclk_t5 clk__t5 clk 54.433549777
* device instance clk_t6 r0 *1 0,0
Rclk_t6 clk__t6 clk 151.232996457
* device instance clk_t7 r0 *1 0,0
Rclk_t7 clk__t7 clk 193.380689268
* device instance clk_t8 r0 *1 0,0
Rclk_t8 clk__t8 clk 231.691848918
* device instance clk_t9 r0 *1 0,0
Rclk_t9 clk__t9 clk 239.878186015
* device instance clk_t10 r0 *1 0,0
Rclk_t10 clk__t10 clk 16.2714035763
* device instance clk_t11 r0 *1 0,0
Rclk_t11 clk__t11 clk 211.60841636
* device instance clk_t12 r0 *1 0,0
Rclk_t12 clk__t12 clk 203.422229172
* device instance clk_t13 r0 *1 0,0
Rclk_t13 clk__t13 clk 161.273989417
* device instance clk_t14 r0 *1 0,0
Rclk_t14 clk__t14 clk 122.966594337
* device instance clk_t15 r0 *1 0,0
Rclk_t15 clk__t15 clk 26.2311746155
* device instance clk_t16 r0 *1 0,0
Rclk_t16 clk__t16 clk 34.3862348214
* device instance clk_t17 r0 *1 0,0
Rclk_t17 clk__t17 clk 72.6467131495
* device instance clk_t18 r0 *1 0,0
Rclk_t18 clk__t18 clk 114.781770045
* device instance clk_t19 r0 *1 0,0
Rclk_t19 clk__t19 clk 270.601118079
* device instance clk_t20 r0 *1 0,0
Rclk_t20 clk__t20 clk 200.969568847
* device instance clk_t21 r0 *1 0,0
Rclk_t21 clk__t21 clk 193.380689268
* device instance clk_t22 r0 *1 0,0
Rclk_t22 clk__t22 clk 242.330908573
* device instance clk_t23 r0 *1 0,0
Rclk_t23 clk__t23 clk 172.70069969
* device instance clk_t24 r0 *1 0,0
Rclk_t24 clk__t24 clk 161.273989417
* device instance clk_t25 r0 *1 0,0
Rclk_t25 clk__t25 clk 153.6854976
* device instance clk_t26 r0 *1 0,0
Rclk_t26 clk__t26 clk 181.953680017
* device instance clk_t27 r0 *1 0,0
Rclk_t27 clk__t27 clk 16.2714035763
* device instance clk_t28 r0 *1 0,0
Rclk_t28 clk__t28 clk 65.0627656138
* device instance clk_t29 r0 *1 0,0
Rclk_t29 clk__t29 clk 72.6467131495
* device instance clk_t30 r0 *1 0,0
Rclk_t30 clk__t30 clk 84.0683151501
* device instance clk_t31 r0 *1 0,0
Rclk_t31 clk__t31 clk 112.32956505
* device instance clk_t32 r0 *1 0,0
Rclk_t32 clk__t32 clk 104.742257905
* device instance clk_t33 r0 *1 0,0
Rclk_t33 clk__t33 clk 93.3182008577
* device instance clk_t34 r0 *1 0,0
Rclk_t34 clk__t34 clk 5.32915798525
* device instance clk_t35 r0 *1 0,0
Rclk_t35 clk__t35 clk 23.7920814541
* device instance clk r0 *1 0,0
Cclk clk vsubs 4.5960391e-14
* device instance clkb_clkb_bridge1_clkb_bridge2_clkb_mid_clkb_w_ctrl_ctrlb_inv_clk_y_tg_d_ctrlb_tg_fbm_ctrl_tg_fbs_ctrlb_tg_s_ctrl_y_t0 r0 *1 0,0
Rclkb_clkb_bridge1_clkb_bridge2_clkb_mid_clkb_w_ctrl_ctrlb_inv_clk_y_tg_d_ctrlb_tg_fbm_ctrl_tg_fbs_ctrlb_tg_s_ctrl_y_t0
+ clkb|clkb_bridge1|clkb_bridge2|clkb_mid|clkb_w|ctrl|ctrlb|inv_clk_y|tg_d_ctrlb|tg_fbm_ctrl|tg_fbs_ctrlb|tg_s_ctrl|y__t0
+ clkb|clkb_bridge1|clkb_bridge2|clkb_mid|clkb_w|ctrl|ctrlb|inv_clk_y|tg_d_ctrlb|tg_fbm_ctrl|tg_fbs_ctrlb|tg_s_ctrl|y
+ 161.077076378
* device instance clkb_clkb_bridge1_clkb_bridge2_clkb_mid_clkb_w_ctrl_ctrlb_inv_clk_y_tg_d_ctrlb_tg_fbm_ctrl_tg_fbs_ctrlb_tg_s_ctrl_y_t1 r0 *1 0,0
Rclkb_clkb_bridge1_clkb_bridge2_clkb_mid_clkb_w_ctrl_ctrlb_inv_clk_y_tg_d_ctrlb_tg_fbm_ctrl_tg_fbs_ctrlb_tg_s_ctrl_y_t1
+ clkb|clkb_bridge1|clkb_bridge2|clkb_mid|clkb_w|ctrl|ctrlb|inv_clk_y|tg_d_ctrlb|tg_fbm_ctrl|tg_fbs_ctrlb|tg_s_ctrl|y__t1
+ clkb|clkb_bridge1|clkb_bridge2|clkb_mid|clkb_w|ctrl|ctrlb|inv_clk_y|tg_d_ctrlb|tg_fbm_ctrl|tg_fbs_ctrlb|tg_s_ctrl|y
+ 161.077076378
* device instance clkb_clkb_bridge1_clkb_bridge2_clkb_mid_clkb_w_ctrl_ctrlb_inv_clk_y_tg_d_ctrlb_tg_fbm_ctrl_tg_fbs_ctrlb_tg_s_ctrl_y_t2 r0 *1 0,0
Rclkb_clkb_bridge1_clkb_bridge2_clkb_mid_clkb_w_ctrl_ctrlb_inv_clk_y_tg_d_ctrlb_tg_fbm_ctrl_tg_fbs_ctrlb_tg_s_ctrl_y_t2
+ clkb|clkb_bridge1|clkb_bridge2|clkb_mid|clkb_w|ctrl|ctrlb|inv_clk_y|tg_d_ctrlb|tg_fbm_ctrl|tg_fbs_ctrlb|tg_s_ctrl|y__t2
+ clkb|clkb_bridge1|clkb_bridge2|clkb_mid|clkb_w|ctrl|ctrlb|inv_clk_y|tg_d_ctrlb|tg_fbm_ctrl|tg_fbs_ctrlb|tg_s_ctrl|y
+ 118.278697376
* device instance clkb_clkb_bridge1_clkb_bridge2_clkb_mid_clkb_w_ctrl_ctrlb_inv_clk_y_tg_d_ctrlb_tg_fbm_ctrl_tg_fbs_ctrlb_tg_s_ctrl_y_t3 r0 *1 0,0
Rclkb_clkb_bridge1_clkb_bridge2_clkb_mid_clkb_w_ctrl_ctrlb_inv_clk_y_tg_d_ctrlb_tg_fbm_ctrl_tg_fbs_ctrlb_tg_s_ctrl_y_t3
+ clkb|clkb_bridge1|clkb_bridge2|clkb_mid|clkb_w|ctrl|ctrlb|inv_clk_y|tg_d_ctrlb|tg_fbm_ctrl|tg_fbs_ctrlb|tg_s_ctrl|y__t3
+ clkb|clkb_bridge1|clkb_bridge2|clkb_mid|clkb_w|ctrl|ctrlb|inv_clk_y|tg_d_ctrlb|tg_fbm_ctrl|tg_fbs_ctrlb|tg_s_ctrl|y
+ 278.105871595
* device instance clkb_clkb_bridge1_clkb_bridge2_clkb_mid_clkb_w_ctrl_ctrlb_inv_clk_y_tg_d_ctrlb_tg_fbm_ctrl_tg_fbs_ctrlb_tg_s_ctrl_y_t4 r0 *1 0,0
Rclkb_clkb_bridge1_clkb_bridge2_clkb_mid_clkb_w_ctrl_ctrlb_inv_clk_y_tg_d_ctrlb_tg_fbm_ctrl_tg_fbs_ctrlb_tg_s_ctrl_y_t4
+ clkb|clkb_bridge1|clkb_bridge2|clkb_mid|clkb_w|ctrl|ctrlb|inv_clk_y|tg_d_ctrlb|tg_fbm_ctrl|tg_fbs_ctrlb|tg_s_ctrl|y__t4
+ clkb|clkb_bridge1|clkb_bridge2|clkb_mid|clkb_w|ctrl|ctrlb|inv_clk_y|tg_d_ctrlb|tg_fbm_ctrl|tg_fbs_ctrlb|tg_s_ctrl|y
+ 58.9091767475
* device instance clkb_clkb_bridge1_clkb_bridge2_clkb_mid_clkb_w_ctrl_ctrlb_inv_clk_y_tg_d_ctrlb_tg_fbm_ctrl_tg_fbs_ctrlb_tg_s_ctrl_y_t5 r0 *1 0,0
Rclkb_clkb_bridge1_clkb_bridge2_clkb_mid_clkb_w_ctrl_ctrlb_inv_clk_y_tg_d_ctrlb_tg_fbm_ctrl_tg_fbs_ctrlb_tg_s_ctrl_y_t5
+ clkb|clkb_bridge1|clkb_bridge2|clkb_mid|clkb_w|ctrl|ctrlb|inv_clk_y|tg_d_ctrlb|tg_fbm_ctrl|tg_fbs_ctrlb|tg_s_ctrl|y__t5
+ clkb|clkb_bridge1|clkb_bridge2|clkb_mid|clkb_w|ctrl|ctrlb|inv_clk_y|tg_d_ctrlb|tg_fbm_ctrl|tg_fbs_ctrlb|tg_s_ctrl|y
+ 104.491501524
* device instance clkb_clkb_bridge1_clkb_bridge2_clkb_mid_clkb_w_ctrl_ctrlb_inv_clk_y_tg_d_ctrlb_tg_fbm_ctrl_tg_fbs_ctrlb_tg_s_ctrl_y r0 *1 0,0
Cclkb_clkb_bridge1_clkb_bridge2_clkb_mid_clkb_w_ctrl_ctrlb_inv_clk_y_tg_d_ctrlb_tg_fbm_ctrl_tg_fbs_ctrlb_tg_s_ctrl_y
+ clkb|clkb_bridge1|clkb_bridge2|clkb_mid|clkb_w|ctrl|ctrlb|inv_clk_y|tg_d_ctrlb|tg_fbm_ctrl|tg_fbs_ctrlb|tg_s_ctrl|y
+ vsubs 6.706821e-15
* device instance clkb_clkb_bridge1_clkb_bridge2_clkb_mid_clkb_w_ctrl_ctrlb_inv_clk_y_tg_d_ctrlb_tg_fbm_ctrl_tg_fbs_ctrlb_tg_s_ctrl_y_dup1_t0 r0 *1 0,0
Rclkb_clkb_bridge1_clkb_bridge2_clkb_mid_clkb_w_ctrl_ctrlb_inv_clk_y_tg_d_ctrlb_tg_fbm_ctrl_tg_fbs_ctrlb_tg_s_ctrl_y_dup1_t0
+ clkb|clkb_bridge1|clkb_bridge2|clkb_mid|clkb_w|ctrl|ctrlb|inv_clk_y|tg_d_ctrlb|tg_fbm_ctrl|tg_fbs_ctrlb|tg_s_ctrl|y__t02
+ clkb|clkb_bridge1|clkb_bridge2|clkb_mid|clkb_w|ctrl|ctrlb|inv_clk_y|tg_d_ctrlb|tg_fbm_ctrl|tg_fbs_ctrlb|tg_s_ctrl|y$1
+ 161.077076378
* device instance clkb_clkb_bridge1_clkb_bridge2_clkb_mid_clkb_w_ctrl_ctrlb_inv_clk_y_tg_d_ctrlb_tg_fbm_ctrl_tg_fbs_ctrlb_tg_s_ctrl_y_dup1_t1 r0 *1 0,0
Rclkb_clkb_bridge1_clkb_bridge2_clkb_mid_clkb_w_ctrl_ctrlb_inv_clk_y_tg_d_ctrlb_tg_fbm_ctrl_tg_fbs_ctrlb_tg_s_ctrl_y_dup1_t1
+ clkb|clkb_bridge1|clkb_bridge2|clkb_mid|clkb_w|ctrl|ctrlb|inv_clk_y|tg_d_ctrlb|tg_fbm_ctrl|tg_fbs_ctrlb|tg_s_ctrl|y__t12
+ clkb|clkb_bridge1|clkb_bridge2|clkb_mid|clkb_w|ctrl|ctrlb|inv_clk_y|tg_d_ctrlb|tg_fbm_ctrl|tg_fbs_ctrlb|tg_s_ctrl|y$1
+ 161.077076378
* device instance clkb_clkb_bridge1_clkb_bridge2_clkb_mid_clkb_w_ctrl_ctrlb_inv_clk_y_tg_d_ctrlb_tg_fbm_ctrl_tg_fbs_ctrlb_tg_s_ctrl_y_dup1_t2 r0 *1 0,0
Rclkb_clkb_bridge1_clkb_bridge2_clkb_mid_clkb_w_ctrl_ctrlb_inv_clk_y_tg_d_ctrlb_tg_fbm_ctrl_tg_fbs_ctrlb_tg_s_ctrl_y_dup1_t2
+ clkb|clkb_bridge1|clkb_bridge2|clkb_mid|clkb_w|ctrl|ctrlb|inv_clk_y|tg_d_ctrlb|tg_fbm_ctrl|tg_fbs_ctrlb|tg_s_ctrl|y__t22
+ clkb|clkb_bridge1|clkb_bridge2|clkb_mid|clkb_w|ctrl|ctrlb|inv_clk_y|tg_d_ctrlb|tg_fbm_ctrl|tg_fbs_ctrlb|tg_s_ctrl|y$1
+ 118.278697376
* device instance clkb_clkb_bridge1_clkb_bridge2_clkb_mid_clkb_w_ctrl_ctrlb_inv_clk_y_tg_d_ctrlb_tg_fbm_ctrl_tg_fbs_ctrlb_tg_s_ctrl_y_dup1_t3 r0 *1 0,0
Rclkb_clkb_bridge1_clkb_bridge2_clkb_mid_clkb_w_ctrl_ctrlb_inv_clk_y_tg_d_ctrlb_tg_fbm_ctrl_tg_fbs_ctrlb_tg_s_ctrl_y_dup1_t3
+ clkb|clkb_bridge1|clkb_bridge2|clkb_mid|clkb_w|ctrl|ctrlb|inv_clk_y|tg_d_ctrlb|tg_fbm_ctrl|tg_fbs_ctrlb|tg_s_ctrl|y__t32
+ clkb|clkb_bridge1|clkb_bridge2|clkb_mid|clkb_w|ctrl|ctrlb|inv_clk_y|tg_d_ctrlb|tg_fbm_ctrl|tg_fbs_ctrlb|tg_s_ctrl|y$1
+ 278.105871595
* device instance clkb_clkb_bridge1_clkb_bridge2_clkb_mid_clkb_w_ctrl_ctrlb_inv_clk_y_tg_d_ctrlb_tg_fbm_ctrl_tg_fbs_ctrlb_tg_s_ctrl_y_dup1_t4 r0 *1 0,0
Rclkb_clkb_bridge1_clkb_bridge2_clkb_mid_clkb_w_ctrl_ctrlb_inv_clk_y_tg_d_ctrlb_tg_fbm_ctrl_tg_fbs_ctrlb_tg_s_ctrl_y_dup1_t4
+ clkb|clkb_bridge1|clkb_bridge2|clkb_mid|clkb_w|ctrl|ctrlb|inv_clk_y|tg_d_ctrlb|tg_fbm_ctrl|tg_fbs_ctrlb|tg_s_ctrl|y__t42
+ clkb|clkb_bridge1|clkb_bridge2|clkb_mid|clkb_w|ctrl|ctrlb|inv_clk_y|tg_d_ctrlb|tg_fbm_ctrl|tg_fbs_ctrlb|tg_s_ctrl|y$1
+ 104.491501524
* device instance clkb_clkb_bridge1_clkb_bridge2_clkb_mid_clkb_w_ctrl_ctrlb_inv_clk_y_tg_d_ctrlb_tg_fbm_ctrl_tg_fbs_ctrlb_tg_s_ctrl_y_dup1_t5 r0 *1 0,0
Rclkb_clkb_bridge1_clkb_bridge2_clkb_mid_clkb_w_ctrl_ctrlb_inv_clk_y_tg_d_ctrlb_tg_fbm_ctrl_tg_fbs_ctrlb_tg_s_ctrl_y_dup1_t5
+ clkb|clkb_bridge1|clkb_bridge2|clkb_mid|clkb_w|ctrl|ctrlb|inv_clk_y|tg_d_ctrlb|tg_fbm_ctrl|tg_fbs_ctrlb|tg_s_ctrl|y__t52
+ clkb|clkb_bridge1|clkb_bridge2|clkb_mid|clkb_w|ctrl|ctrlb|inv_clk_y|tg_d_ctrlb|tg_fbm_ctrl|tg_fbs_ctrlb|tg_s_ctrl|y$1
+ 58.9091767475
* device instance clkb_clkb_bridge1_clkb_bridge2_clkb_mid_clkb_w_ctrl_ctrlb_inv_clk_y_tg_d_ctrlb_tg_fbm_ctrl_tg_fbs_ctrlb_tg_s_ctrl_y_dup1 r0 *1 0,0
Cclkb_clkb_bridge1_clkb_bridge2_clkb_mid_clkb_w_ctrl_ctrlb_inv_clk_y_tg_d_ctrlb_tg_fbm_ctrl_tg_fbs_ctrlb_tg_s_ctrl_y_dup1
+ clkb|clkb_bridge1|clkb_bridge2|clkb_mid|clkb_w|ctrl|ctrlb|inv_clk_y|tg_d_ctrlb|tg_fbm_ctrl|tg_fbs_ctrlb|tg_s_ctrl|y$1
+ vsubs 6.706821e-15
* device instance clkb_clkb_bridge1_clkb_bridge2_clkb_mid_clkb_w_ctrl_ctrlb_inv_clk_y_tg_d_ctrlb_tg_fbm_ctrl_tg_fbs_ctrlb_tg_s_ctrl_y_dup2_t0 r0 *1 0,0
Rclkb_clkb_bridge1_clkb_bridge2_clkb_mid_clkb_w_ctrl_ctrlb_inv_clk_y_tg_d_ctrlb_tg_fbm_ctrl_tg_fbs_ctrlb_tg_s_ctrl_y_dup2_t0
+ clkb|clkb_bridge1|clkb_bridge2|clkb_mid|clkb_w|ctrl|ctrlb|inv_clk_y|tg_d_ctrlb|tg_fbm_ctrl|tg_fbs_ctrlb|tg_s_ctrl|y__t03
+ clkb|clkb_bridge1|clkb_bridge2|clkb_mid|clkb_w|ctrl|ctrlb|inv_clk_y|tg_d_ctrlb|tg_fbm_ctrl|tg_fbs_ctrlb|tg_s_ctrl|y$2
+ 161.077076378
* device instance clkb_clkb_bridge1_clkb_bridge2_clkb_mid_clkb_w_ctrl_ctrlb_inv_clk_y_tg_d_ctrlb_tg_fbm_ctrl_tg_fbs_ctrlb_tg_s_ctrl_y_dup2_t1 r0 *1 0,0
Rclkb_clkb_bridge1_clkb_bridge2_clkb_mid_clkb_w_ctrl_ctrlb_inv_clk_y_tg_d_ctrlb_tg_fbm_ctrl_tg_fbs_ctrlb_tg_s_ctrl_y_dup2_t1
+ clkb|clkb_bridge1|clkb_bridge2|clkb_mid|clkb_w|ctrl|ctrlb|inv_clk_y|tg_d_ctrlb|tg_fbm_ctrl|tg_fbs_ctrlb|tg_s_ctrl|y__t13
+ clkb|clkb_bridge1|clkb_bridge2|clkb_mid|clkb_w|ctrl|ctrlb|inv_clk_y|tg_d_ctrlb|tg_fbm_ctrl|tg_fbs_ctrlb|tg_s_ctrl|y$2
+ 161.077076378
* device instance clkb_clkb_bridge1_clkb_bridge2_clkb_mid_clkb_w_ctrl_ctrlb_inv_clk_y_tg_d_ctrlb_tg_fbm_ctrl_tg_fbs_ctrlb_tg_s_ctrl_y_dup2_t2 r0 *1 0,0
Rclkb_clkb_bridge1_clkb_bridge2_clkb_mid_clkb_w_ctrl_ctrlb_inv_clk_y_tg_d_ctrlb_tg_fbm_ctrl_tg_fbs_ctrlb_tg_s_ctrl_y_dup2_t2
+ clkb|clkb_bridge1|clkb_bridge2|clkb_mid|clkb_w|ctrl|ctrlb|inv_clk_y|tg_d_ctrlb|tg_fbm_ctrl|tg_fbs_ctrlb|tg_s_ctrl|y__t23
+ clkb|clkb_bridge1|clkb_bridge2|clkb_mid|clkb_w|ctrl|ctrlb|inv_clk_y|tg_d_ctrlb|tg_fbm_ctrl|tg_fbs_ctrlb|tg_s_ctrl|y$2
+ 278.105871595
* device instance clkb_clkb_bridge1_clkb_bridge2_clkb_mid_clkb_w_ctrl_ctrlb_inv_clk_y_tg_d_ctrlb_tg_fbm_ctrl_tg_fbs_ctrlb_tg_s_ctrl_y_dup2_t3 r0 *1 0,0
Rclkb_clkb_bridge1_clkb_bridge2_clkb_mid_clkb_w_ctrl_ctrlb_inv_clk_y_tg_d_ctrlb_tg_fbm_ctrl_tg_fbs_ctrlb_tg_s_ctrl_y_dup2_t3
+ clkb|clkb_bridge1|clkb_bridge2|clkb_mid|clkb_w|ctrl|ctrlb|inv_clk_y|tg_d_ctrlb|tg_fbm_ctrl|tg_fbs_ctrlb|tg_s_ctrl|y__t33
+ clkb|clkb_bridge1|clkb_bridge2|clkb_mid|clkb_w|ctrl|ctrlb|inv_clk_y|tg_d_ctrlb|tg_fbm_ctrl|tg_fbs_ctrlb|tg_s_ctrl|y$2
+ 118.278697376
* device instance clkb_clkb_bridge1_clkb_bridge2_clkb_mid_clkb_w_ctrl_ctrlb_inv_clk_y_tg_d_ctrlb_tg_fbm_ctrl_tg_fbs_ctrlb_tg_s_ctrl_y_dup2_t4 r0 *1 0,0
Rclkb_clkb_bridge1_clkb_bridge2_clkb_mid_clkb_w_ctrl_ctrlb_inv_clk_y_tg_d_ctrlb_tg_fbm_ctrl_tg_fbs_ctrlb_tg_s_ctrl_y_dup2_t4
+ clkb|clkb_bridge1|clkb_bridge2|clkb_mid|clkb_w|ctrl|ctrlb|inv_clk_y|tg_d_ctrlb|tg_fbm_ctrl|tg_fbs_ctrlb|tg_s_ctrl|y__t43
+ clkb|clkb_bridge1|clkb_bridge2|clkb_mid|clkb_w|ctrl|ctrlb|inv_clk_y|tg_d_ctrlb|tg_fbm_ctrl|tg_fbs_ctrlb|tg_s_ctrl|y$2
+ 58.9091767475
* device instance clkb_clkb_bridge1_clkb_bridge2_clkb_mid_clkb_w_ctrl_ctrlb_inv_clk_y_tg_d_ctrlb_tg_fbm_ctrl_tg_fbs_ctrlb_tg_s_ctrl_y_dup2_t5 r0 *1 0,0
Rclkb_clkb_bridge1_clkb_bridge2_clkb_mid_clkb_w_ctrl_ctrlb_inv_clk_y_tg_d_ctrlb_tg_fbm_ctrl_tg_fbs_ctrlb_tg_s_ctrl_y_dup2_t5
+ clkb|clkb_bridge1|clkb_bridge2|clkb_mid|clkb_w|ctrl|ctrlb|inv_clk_y|tg_d_ctrlb|tg_fbm_ctrl|tg_fbs_ctrlb|tg_s_ctrl|y__t53
+ clkb|clkb_bridge1|clkb_bridge2|clkb_mid|clkb_w|ctrl|ctrlb|inv_clk_y|tg_d_ctrlb|tg_fbm_ctrl|tg_fbs_ctrlb|tg_s_ctrl|y$2
+ 104.491501524
* device instance clkb_clkb_bridge1_clkb_bridge2_clkb_mid_clkb_w_ctrl_ctrlb_inv_clk_y_tg_d_ctrlb_tg_fbm_ctrl_tg_fbs_ctrlb_tg_s_ctrl_y_dup2 r0 *1 0,0
Cclkb_clkb_bridge1_clkb_bridge2_clkb_mid_clkb_w_ctrl_ctrlb_inv_clk_y_tg_d_ctrlb_tg_fbm_ctrl_tg_fbs_ctrlb_tg_s_ctrl_y_dup2
+ clkb|clkb_bridge1|clkb_bridge2|clkb_mid|clkb_w|ctrl|ctrlb|inv_clk_y|tg_d_ctrlb|tg_fbm_ctrl|tg_fbs_ctrlb|tg_s_ctrl|y$2
+ vsubs 6.706821e-15
* device instance clkb_clkb_bridge1_clkb_bridge2_clkb_mid_clkb_w_ctrl_ctrlb_inv_clk_y_tg_d_ctrlb_tg_fbm_ctrl_tg_fbs_ctrlb_tg_s_ctrl_y_dup3_t0 r0 *1 0,0
Rclkb_clkb_bridge1_clkb_bridge2_clkb_mid_clkb_w_ctrl_ctrlb_inv_clk_y_tg_d_ctrlb_tg_fbm_ctrl_tg_fbs_ctrlb_tg_s_ctrl_y_dup3_t0
+ clkb|clkb_bridge1|clkb_bridge2|clkb_mid|clkb_w|ctrl|ctrlb|inv_clk_y|tg_d_ctrlb|tg_fbm_ctrl|tg_fbs_ctrlb|tg_s_ctrl|y__t04
+ clkb|clkb_bridge1|clkb_bridge2|clkb_mid|clkb_w|ctrl|ctrlb|inv_clk_y|tg_d_ctrlb|tg_fbm_ctrl|tg_fbs_ctrlb|tg_s_ctrl|y$3
+ 161.077076378
* device instance clkb_clkb_bridge1_clkb_bridge2_clkb_mid_clkb_w_ctrl_ctrlb_inv_clk_y_tg_d_ctrlb_tg_fbm_ctrl_tg_fbs_ctrlb_tg_s_ctrl_y_dup3_t1 r0 *1 0,0
Rclkb_clkb_bridge1_clkb_bridge2_clkb_mid_clkb_w_ctrl_ctrlb_inv_clk_y_tg_d_ctrlb_tg_fbm_ctrl_tg_fbs_ctrlb_tg_s_ctrl_y_dup3_t1
+ clkb|clkb_bridge1|clkb_bridge2|clkb_mid|clkb_w|ctrl|ctrlb|inv_clk_y|tg_d_ctrlb|tg_fbm_ctrl|tg_fbs_ctrlb|tg_s_ctrl|y__t14
+ clkb|clkb_bridge1|clkb_bridge2|clkb_mid|clkb_w|ctrl|ctrlb|inv_clk_y|tg_d_ctrlb|tg_fbm_ctrl|tg_fbs_ctrlb|tg_s_ctrl|y$3
+ 161.077076378
* device instance clkb_clkb_bridge1_clkb_bridge2_clkb_mid_clkb_w_ctrl_ctrlb_inv_clk_y_tg_d_ctrlb_tg_fbm_ctrl_tg_fbs_ctrlb_tg_s_ctrl_y_dup3_t2 r0 *1 0,0
Rclkb_clkb_bridge1_clkb_bridge2_clkb_mid_clkb_w_ctrl_ctrlb_inv_clk_y_tg_d_ctrlb_tg_fbm_ctrl_tg_fbs_ctrlb_tg_s_ctrl_y_dup3_t2
+ clkb|clkb_bridge1|clkb_bridge2|clkb_mid|clkb_w|ctrl|ctrlb|inv_clk_y|tg_d_ctrlb|tg_fbm_ctrl|tg_fbs_ctrlb|tg_s_ctrl|y__t24
+ clkb|clkb_bridge1|clkb_bridge2|clkb_mid|clkb_w|ctrl|ctrlb|inv_clk_y|tg_d_ctrlb|tg_fbm_ctrl|tg_fbs_ctrlb|tg_s_ctrl|y$3
+ 278.105871595
* device instance clkb_clkb_bridge1_clkb_bridge2_clkb_mid_clkb_w_ctrl_ctrlb_inv_clk_y_tg_d_ctrlb_tg_fbm_ctrl_tg_fbs_ctrlb_tg_s_ctrl_y_dup3_t3 r0 *1 0,0
Rclkb_clkb_bridge1_clkb_bridge2_clkb_mid_clkb_w_ctrl_ctrlb_inv_clk_y_tg_d_ctrlb_tg_fbm_ctrl_tg_fbs_ctrlb_tg_s_ctrl_y_dup3_t3
+ clkb|clkb_bridge1|clkb_bridge2|clkb_mid|clkb_w|ctrl|ctrlb|inv_clk_y|tg_d_ctrlb|tg_fbm_ctrl|tg_fbs_ctrlb|tg_s_ctrl|y__t34
+ clkb|clkb_bridge1|clkb_bridge2|clkb_mid|clkb_w|ctrl|ctrlb|inv_clk_y|tg_d_ctrlb|tg_fbm_ctrl|tg_fbs_ctrlb|tg_s_ctrl|y$3
+ 118.278697376
* device instance clkb_clkb_bridge1_clkb_bridge2_clkb_mid_clkb_w_ctrl_ctrlb_inv_clk_y_tg_d_ctrlb_tg_fbm_ctrl_tg_fbs_ctrlb_tg_s_ctrl_y_dup3_t4 r0 *1 0,0
Rclkb_clkb_bridge1_clkb_bridge2_clkb_mid_clkb_w_ctrl_ctrlb_inv_clk_y_tg_d_ctrlb_tg_fbm_ctrl_tg_fbs_ctrlb_tg_s_ctrl_y_dup3_t4
+ clkb|clkb_bridge1|clkb_bridge2|clkb_mid|clkb_w|ctrl|ctrlb|inv_clk_y|tg_d_ctrlb|tg_fbm_ctrl|tg_fbs_ctrlb|tg_s_ctrl|y__t44
+ clkb|clkb_bridge1|clkb_bridge2|clkb_mid|clkb_w|ctrl|ctrlb|inv_clk_y|tg_d_ctrlb|tg_fbm_ctrl|tg_fbs_ctrlb|tg_s_ctrl|y$3
+ 104.491501524
* device instance clkb_clkb_bridge1_clkb_bridge2_clkb_mid_clkb_w_ctrl_ctrlb_inv_clk_y_tg_d_ctrlb_tg_fbm_ctrl_tg_fbs_ctrlb_tg_s_ctrl_y_dup3_t5 r0 *1 0,0
Rclkb_clkb_bridge1_clkb_bridge2_clkb_mid_clkb_w_ctrl_ctrlb_inv_clk_y_tg_d_ctrlb_tg_fbm_ctrl_tg_fbs_ctrlb_tg_s_ctrl_y_dup3_t5
+ clkb|clkb_bridge1|clkb_bridge2|clkb_mid|clkb_w|ctrl|ctrlb|inv_clk_y|tg_d_ctrlb|tg_fbm_ctrl|tg_fbs_ctrlb|tg_s_ctrl|y__t54
+ clkb|clkb_bridge1|clkb_bridge2|clkb_mid|clkb_w|ctrl|ctrlb|inv_clk_y|tg_d_ctrlb|tg_fbm_ctrl|tg_fbs_ctrlb|tg_s_ctrl|y$3
+ 58.9091767475
* device instance clkb_clkb_bridge1_clkb_bridge2_clkb_mid_clkb_w_ctrl_ctrlb_inv_clk_y_tg_d_ctrlb_tg_fbm_ctrl_tg_fbs_ctrlb_tg_s_ctrl_y_dup3 r0 *1 0,0
Cclkb_clkb_bridge1_clkb_bridge2_clkb_mid_clkb_w_ctrl_ctrlb_inv_clk_y_tg_d_ctrlb_tg_fbm_ctrl_tg_fbs_ctrlb_tg_s_ctrl_y_dup3
+ clkb|clkb_bridge1|clkb_bridge2|clkb_mid|clkb_w|ctrl|ctrlb|inv_clk_y|tg_d_ctrlb|tg_fbm_ctrl|tg_fbs_ctrlb|tg_s_ctrl|y$3
+ vsubs 6.706821e-15
* device instance clkb_clkb_bridge1_clkb_bridge2_clkb_mid_clkb_w_ctrl_ctrlb_inv_clk_y_tg_d_ctrlb_tg_fbm_ctrl_tg_fbs_ctrlb_tg_s_ctrl_y_dup4_t0 r0 *1 0,0
Rclkb_clkb_bridge1_clkb_bridge2_clkb_mid_clkb_w_ctrl_ctrlb_inv_clk_y_tg_d_ctrlb_tg_fbm_ctrl_tg_fbs_ctrlb_tg_s_ctrl_y_dup4_t0
+ clkb|clkb_bridge1|clkb_bridge2|clkb_mid|clkb_w|ctrl|ctrlb|inv_clk_y|tg_d_ctrlb|tg_fbm_ctrl|tg_fbs_ctrlb|tg_s_ctrl|y__t05
+ clkb|clkb_bridge1|clkb_bridge2|clkb_mid|clkb_w|ctrl|ctrlb|inv_clk_y|tg_d_ctrlb|tg_fbm_ctrl|tg_fbs_ctrlb|tg_s_ctrl|y$4
+ 161.077076378
* device instance clkb_clkb_bridge1_clkb_bridge2_clkb_mid_clkb_w_ctrl_ctrlb_inv_clk_y_tg_d_ctrlb_tg_fbm_ctrl_tg_fbs_ctrlb_tg_s_ctrl_y_dup4_t1 r0 *1 0,0
Rclkb_clkb_bridge1_clkb_bridge2_clkb_mid_clkb_w_ctrl_ctrlb_inv_clk_y_tg_d_ctrlb_tg_fbm_ctrl_tg_fbs_ctrlb_tg_s_ctrl_y_dup4_t1
+ clkb|clkb_bridge1|clkb_bridge2|clkb_mid|clkb_w|ctrl|ctrlb|inv_clk_y|tg_d_ctrlb|tg_fbm_ctrl|tg_fbs_ctrlb|tg_s_ctrl|y__t15
+ clkb|clkb_bridge1|clkb_bridge2|clkb_mid|clkb_w|ctrl|ctrlb|inv_clk_y|tg_d_ctrlb|tg_fbm_ctrl|tg_fbs_ctrlb|tg_s_ctrl|y$4
+ 161.077076378
* device instance clkb_clkb_bridge1_clkb_bridge2_clkb_mid_clkb_w_ctrl_ctrlb_inv_clk_y_tg_d_ctrlb_tg_fbm_ctrl_tg_fbs_ctrlb_tg_s_ctrl_y_dup4_t2 r0 *1 0,0
Rclkb_clkb_bridge1_clkb_bridge2_clkb_mid_clkb_w_ctrl_ctrlb_inv_clk_y_tg_d_ctrlb_tg_fbm_ctrl_tg_fbs_ctrlb_tg_s_ctrl_y_dup4_t2
+ clkb|clkb_bridge1|clkb_bridge2|clkb_mid|clkb_w|ctrl|ctrlb|inv_clk_y|tg_d_ctrlb|tg_fbm_ctrl|tg_fbs_ctrlb|tg_s_ctrl|y__t25
+ clkb|clkb_bridge1|clkb_bridge2|clkb_mid|clkb_w|ctrl|ctrlb|inv_clk_y|tg_d_ctrlb|tg_fbm_ctrl|tg_fbs_ctrlb|tg_s_ctrl|y$4
+ 118.278697376
* device instance clkb_clkb_bridge1_clkb_bridge2_clkb_mid_clkb_w_ctrl_ctrlb_inv_clk_y_tg_d_ctrlb_tg_fbm_ctrl_tg_fbs_ctrlb_tg_s_ctrl_y_dup4_t3 r0 *1 0,0
Rclkb_clkb_bridge1_clkb_bridge2_clkb_mid_clkb_w_ctrl_ctrlb_inv_clk_y_tg_d_ctrlb_tg_fbm_ctrl_tg_fbs_ctrlb_tg_s_ctrl_y_dup4_t3
+ clkb|clkb_bridge1|clkb_bridge2|clkb_mid|clkb_w|ctrl|ctrlb|inv_clk_y|tg_d_ctrlb|tg_fbm_ctrl|tg_fbs_ctrlb|tg_s_ctrl|y__t35
+ clkb|clkb_bridge1|clkb_bridge2|clkb_mid|clkb_w|ctrl|ctrlb|inv_clk_y|tg_d_ctrlb|tg_fbm_ctrl|tg_fbs_ctrlb|tg_s_ctrl|y$4
+ 278.105871595
* device instance clkb_clkb_bridge1_clkb_bridge2_clkb_mid_clkb_w_ctrl_ctrlb_inv_clk_y_tg_d_ctrlb_tg_fbm_ctrl_tg_fbs_ctrlb_tg_s_ctrl_y_dup4_t4 r0 *1 0,0
Rclkb_clkb_bridge1_clkb_bridge2_clkb_mid_clkb_w_ctrl_ctrlb_inv_clk_y_tg_d_ctrlb_tg_fbm_ctrl_tg_fbs_ctrlb_tg_s_ctrl_y_dup4_t4
+ clkb|clkb_bridge1|clkb_bridge2|clkb_mid|clkb_w|ctrl|ctrlb|inv_clk_y|tg_d_ctrlb|tg_fbm_ctrl|tg_fbs_ctrlb|tg_s_ctrl|y__t45
+ clkb|clkb_bridge1|clkb_bridge2|clkb_mid|clkb_w|ctrl|ctrlb|inv_clk_y|tg_d_ctrlb|tg_fbm_ctrl|tg_fbs_ctrlb|tg_s_ctrl|y$4
+ 104.491501524
* device instance clkb_clkb_bridge1_clkb_bridge2_clkb_mid_clkb_w_ctrl_ctrlb_inv_clk_y_tg_d_ctrlb_tg_fbm_ctrl_tg_fbs_ctrlb_tg_s_ctrl_y_dup4_t5 r0 *1 0,0
Rclkb_clkb_bridge1_clkb_bridge2_clkb_mid_clkb_w_ctrl_ctrlb_inv_clk_y_tg_d_ctrlb_tg_fbm_ctrl_tg_fbs_ctrlb_tg_s_ctrl_y_dup4_t5
+ clkb|clkb_bridge1|clkb_bridge2|clkb_mid|clkb_w|ctrl|ctrlb|inv_clk_y|tg_d_ctrlb|tg_fbm_ctrl|tg_fbs_ctrlb|tg_s_ctrl|y__t55
+ clkb|clkb_bridge1|clkb_bridge2|clkb_mid|clkb_w|ctrl|ctrlb|inv_clk_y|tg_d_ctrlb|tg_fbm_ctrl|tg_fbs_ctrlb|tg_s_ctrl|y$4
+ 58.9091767475
* device instance clkb_clkb_bridge1_clkb_bridge2_clkb_mid_clkb_w_ctrl_ctrlb_inv_clk_y_tg_d_ctrlb_tg_fbm_ctrl_tg_fbs_ctrlb_tg_s_ctrl_y_dup4 r0 *1 0,0
Cclkb_clkb_bridge1_clkb_bridge2_clkb_mid_clkb_w_ctrl_ctrlb_inv_clk_y_tg_d_ctrlb_tg_fbm_ctrl_tg_fbs_ctrlb_tg_s_ctrl_y_dup4
+ clkb|clkb_bridge1|clkb_bridge2|clkb_mid|clkb_w|ctrl|ctrlb|inv_clk_y|tg_d_ctrlb|tg_fbm_ctrl|tg_fbs_ctrlb|tg_s_ctrl|y$4
+ vsubs 6.706821e-15
* device instance clkb_clkb_bridge1_clkb_bridge2_clkb_mid_clkb_w_ctrl_ctrlb_inv_clk_y_tg_d_ctrlb_tg_fbm_ctrl_tg_fbs_ctrlb_tg_s_ctrl_y_dup5_t0 r0 *1 0,0
Rclkb_clkb_bridge1_clkb_bridge2_clkb_mid_clkb_w_ctrl_ctrlb_inv_clk_y_tg_d_ctrlb_tg_fbm_ctrl_tg_fbs_ctrlb_tg_s_ctrl_y_dup5_t0
+ clkb|clkb_bridge1|clkb_bridge2|clkb_mid|clkb_w|ctrl|ctrlb|inv_clk_y|tg_d_ctrlb|tg_fbm_ctrl|tg_fbs_ctrlb|tg_s_ctrl|y__t06
+ clkb|clkb_bridge1|clkb_bridge2|clkb_mid|clkb_w|ctrl|ctrlb|inv_clk_y|tg_d_ctrlb|tg_fbm_ctrl|tg_fbs_ctrlb|tg_s_ctrl|y$5
+ 161.077076378
* device instance clkb_clkb_bridge1_clkb_bridge2_clkb_mid_clkb_w_ctrl_ctrlb_inv_clk_y_tg_d_ctrlb_tg_fbm_ctrl_tg_fbs_ctrlb_tg_s_ctrl_y_dup5_t1 r0 *1 0,0
Rclkb_clkb_bridge1_clkb_bridge2_clkb_mid_clkb_w_ctrl_ctrlb_inv_clk_y_tg_d_ctrlb_tg_fbm_ctrl_tg_fbs_ctrlb_tg_s_ctrl_y_dup5_t1
+ clkb|clkb_bridge1|clkb_bridge2|clkb_mid|clkb_w|ctrl|ctrlb|inv_clk_y|tg_d_ctrlb|tg_fbm_ctrl|tg_fbs_ctrlb|tg_s_ctrl|y__t16
+ clkb|clkb_bridge1|clkb_bridge2|clkb_mid|clkb_w|ctrl|ctrlb|inv_clk_y|tg_d_ctrlb|tg_fbm_ctrl|tg_fbs_ctrlb|tg_s_ctrl|y$5
+ 161.077076378
* device instance clkb_clkb_bridge1_clkb_bridge2_clkb_mid_clkb_w_ctrl_ctrlb_inv_clk_y_tg_d_ctrlb_tg_fbm_ctrl_tg_fbs_ctrlb_tg_s_ctrl_y_dup5_t2 r0 *1 0,0
Rclkb_clkb_bridge1_clkb_bridge2_clkb_mid_clkb_w_ctrl_ctrlb_inv_clk_y_tg_d_ctrlb_tg_fbm_ctrl_tg_fbs_ctrlb_tg_s_ctrl_y_dup5_t2
+ clkb|clkb_bridge1|clkb_bridge2|clkb_mid|clkb_w|ctrl|ctrlb|inv_clk_y|tg_d_ctrlb|tg_fbm_ctrl|tg_fbs_ctrlb|tg_s_ctrl|y__t26
+ clkb|clkb_bridge1|clkb_bridge2|clkb_mid|clkb_w|ctrl|ctrlb|inv_clk_y|tg_d_ctrlb|tg_fbm_ctrl|tg_fbs_ctrlb|tg_s_ctrl|y$5
+ 118.278697376
* device instance clkb_clkb_bridge1_clkb_bridge2_clkb_mid_clkb_w_ctrl_ctrlb_inv_clk_y_tg_d_ctrlb_tg_fbm_ctrl_tg_fbs_ctrlb_tg_s_ctrl_y_dup5_t3 r0 *1 0,0
Rclkb_clkb_bridge1_clkb_bridge2_clkb_mid_clkb_w_ctrl_ctrlb_inv_clk_y_tg_d_ctrlb_tg_fbm_ctrl_tg_fbs_ctrlb_tg_s_ctrl_y_dup5_t3
+ clkb|clkb_bridge1|clkb_bridge2|clkb_mid|clkb_w|ctrl|ctrlb|inv_clk_y|tg_d_ctrlb|tg_fbm_ctrl|tg_fbs_ctrlb|tg_s_ctrl|y__t36
+ clkb|clkb_bridge1|clkb_bridge2|clkb_mid|clkb_w|ctrl|ctrlb|inv_clk_y|tg_d_ctrlb|tg_fbm_ctrl|tg_fbs_ctrlb|tg_s_ctrl|y$5
+ 278.105871595
* device instance clkb_clkb_bridge1_clkb_bridge2_clkb_mid_clkb_w_ctrl_ctrlb_inv_clk_y_tg_d_ctrlb_tg_fbm_ctrl_tg_fbs_ctrlb_tg_s_ctrl_y_dup5_t4 r0 *1 0,0
Rclkb_clkb_bridge1_clkb_bridge2_clkb_mid_clkb_w_ctrl_ctrlb_inv_clk_y_tg_d_ctrlb_tg_fbm_ctrl_tg_fbs_ctrlb_tg_s_ctrl_y_dup5_t4
+ clkb|clkb_bridge1|clkb_bridge2|clkb_mid|clkb_w|ctrl|ctrlb|inv_clk_y|tg_d_ctrlb|tg_fbm_ctrl|tg_fbs_ctrlb|tg_s_ctrl|y__t46
+ clkb|clkb_bridge1|clkb_bridge2|clkb_mid|clkb_w|ctrl|ctrlb|inv_clk_y|tg_d_ctrlb|tg_fbm_ctrl|tg_fbs_ctrlb|tg_s_ctrl|y$5
+ 104.491501524
* device instance clkb_clkb_bridge1_clkb_bridge2_clkb_mid_clkb_w_ctrl_ctrlb_inv_clk_y_tg_d_ctrlb_tg_fbm_ctrl_tg_fbs_ctrlb_tg_s_ctrl_y_dup5_t5 r0 *1 0,0
Rclkb_clkb_bridge1_clkb_bridge2_clkb_mid_clkb_w_ctrl_ctrlb_inv_clk_y_tg_d_ctrlb_tg_fbm_ctrl_tg_fbs_ctrlb_tg_s_ctrl_y_dup5_t5
+ clkb|clkb_bridge1|clkb_bridge2|clkb_mid|clkb_w|ctrl|ctrlb|inv_clk_y|tg_d_ctrlb|tg_fbm_ctrl|tg_fbs_ctrlb|tg_s_ctrl|y__t56
+ clkb|clkb_bridge1|clkb_bridge2|clkb_mid|clkb_w|ctrl|ctrlb|inv_clk_y|tg_d_ctrlb|tg_fbm_ctrl|tg_fbs_ctrlb|tg_s_ctrl|y$5
+ 58.9091767475
* device instance clkb_clkb_bridge1_clkb_bridge2_clkb_mid_clkb_w_ctrl_ctrlb_inv_clk_y_tg_d_ctrlb_tg_fbm_ctrl_tg_fbs_ctrlb_tg_s_ctrl_y_dup5 r0 *1 0,0
Cclkb_clkb_bridge1_clkb_bridge2_clkb_mid_clkb_w_ctrl_ctrlb_inv_clk_y_tg_d_ctrlb_tg_fbm_ctrl_tg_fbs_ctrlb_tg_s_ctrl_y_dup5
+ clkb|clkb_bridge1|clkb_bridge2|clkb_mid|clkb_w|ctrl|ctrlb|inv_clk_y|tg_d_ctrlb|tg_fbm_ctrl|tg_fbs_ctrlb|tg_s_ctrl|y$5
+ vsubs 6.706821e-15
* device instance en1_t0 r0 *1 0,0
Ren1_t0 en1__t0 en1 166.9848
* device instance en1_t1 r0 *1 0,0
Ren1_t1 en1__t1 en1 166.9848
* device instance en1 r0 *1 0,0
Cen1 en1 vsubs 5.93421e-16
* device instance en2_t0 r0 *1 0,0
Ren2_t0 en2__t0 en2 166.9848
* device instance en2_t1 r0 *1 0,0
Ren2_t1 en2__t1 en2 166.9848
* device instance en2 r0 *1 0,0
Cen2 en2 vsubs 5.93421e-16
* device instance en3_t0 r0 *1 0,0
Ren3_t0 en3__t0 en3 166.9848
* device instance en3_t1 r0 *1 0,0
Ren3_t1 en3__t1 en3 166.9848
* device instance en3 r0 *1 0,0
Cen3 en3 vsubs 5.93421e-16
* device instance en4_t0 r0 *1 0,0
Ren4_t0 en4__t0 en4 166.9848
* device instance en4_t1 r0 *1 0,0
Ren4_t1 en4__t1 en4 166.9848
* device instance en4 r0 *1 0,0
Cen4 en4 vsubs 5.93421e-16
* device instance mid_t0 r0 *1 0,0
Rmid_t0 mid__t0 mid 149.893184895
* device instance mid_t1 r0 *1 0,0
Rmid_t1 mid__t1 mid 180.889615105
* device instance mid_t2 r0 *1 0,0
Rmid_t2 mid__t2 mid 149.893184895
* device instance mid_t3 r0 *1 0,0
Rmid_t3 mid__t3 mid 180.889615105
* device instance mid r0 *1 0,0
Cmid mid vsubs 1.103314e-15
* device instance mid_dup1_t0 r0 *1 0,0
Rmid_dup1_t0 mid__t02 mid$1 180.889615105
* device instance mid_dup1_t1 r0 *1 0,0
Rmid_dup1_t1 mid__t12 mid$1 149.893184895
* device instance mid_dup1_t2 r0 *1 0,0
Rmid_dup1_t2 mid__t22 mid$1 180.889615105
* device instance mid_dup1_t3 r0 *1 0,0
Rmid_dup1_t3 mid__t32 mid$1 149.893184895
* device instance mid_dup1 r0 *1 0,0
Cmid_dup1 mid$1 vsubs 1.101742e-15
* device instance mid_dup2_t0 r0 *1 0,0
Rmid_dup2_t0 mid__t03 mid$2 149.893184895
* device instance mid_dup2_t1 r0 *1 0,0
Rmid_dup2_t1 mid__t13 mid$2 180.889615105
* device instance mid_dup2_t2 r0 *1 0,0
Rmid_dup2_t2 mid__t23 mid$2 149.893184895
* device instance mid_dup2_t3 r0 *1 0,0
Rmid_dup2_t3 mid__t33 mid$2 180.889615105
* device instance mid_dup2 r0 *1 0,0
Cmid_dup2 mid$2 vsubs 1.101742e-15
* device instance mpa_py_mpb_py_mph_py_py_t0 r0 *1 0,0
Rmpa_py_mpb_py_mph_py_py_t0 mpa_py|mpb_py|mph_py|py__t0 mpa_py|mpb_py|mph_py|py
+ 33.64835
* device instance mpa_py_mpb_py_mph_py_py_t1 r0 *1 0,0
Rmpa_py_mpb_py_mph_py_py_t1 mpa_py|mpb_py|mph_py|py__t1 mpa_py|mpb_py|mph_py|py
+ 28.4095054715
* device instance mpa_py_mpb_py_mph_py_py_t2 r0 *1 0,0
Rmpa_py_mpb_py_mph_py_py_t2 mpa_py|mpb_py|mph_py|py__t2 mpa_py|mpb_py|mph_py|py
+ 5.23884452847
* device instance mpa_py_mpb_py_mph_py_py r0 *1 0,0
Cmpa_py_mpb_py_mph_py_py mpa_py|mpb_py|mph_py|py vsubs 7.94002e-16
* device instance mpa_py_mpb_py_mph_py_py_dup1_t0 r0 *1 0,0
Rmpa_py_mpb_py_mph_py_py_dup1_t0 mpa_py|mpb_py|mph_py|py__t02
+ mpa_py|mpb_py|mph_py|py$1 33.9531
* device instance mpa_py_mpb_py_mph_py_py_dup1_t1 r0 *1 0,0
Rmpa_py_mpb_py_mph_py_py_dup1_t1 mpa_py|mpb_py|mph_py|py__t12
+ mpa_py|mpb_py|mph_py|py$1 28.6668077402
* device instance mpa_py_mpb_py_mph_py_py_dup1_t2 r0 *1 0,0
Rmpa_py_mpb_py_mph_py_py_dup1_t2 mpa_py|mpb_py|mph_py|py__t22
+ mpa_py|mpb_py|mph_py|py$1 5.28629225979
* device instance mpa_py_mpb_py_mph_py_py_dup1 r0 *1 0,0
Cmpa_py_mpb_py_mph_py_py_dup1 mpa_py|mpb_py|mph_py|py$1 vsubs 7.95941e-16
* device instance mpa_py_mpb_py_mph_py_py_dup2_t0 r0 *1 0,0
Rmpa_py_mpb_py_mph_py_py_dup2_t0 mpa_py|mpb_py|mph_py|py__t03
+ mpa_py|mpb_py|mph_py|py$2 34.25785
* device instance mpa_py_mpb_py_mph_py_py_dup2_t1 r0 *1 0,0
Rmpa_py_mpb_py_mph_py_py_dup2_t1 mpa_py|mpb_py|mph_py|py__t13
+ mpa_py|mpb_py|mph_py|py$2 28.9241100089
* device instance mpa_py_mpb_py_mph_py_py_dup2_t2 r0 *1 0,0
Rmpa_py_mpb_py_mph_py_py_dup2_t2 mpa_py|mpb_py|mph_py|py__t23
+ mpa_py|mpb_py|mph_py|py$2 5.3337399911
* device instance mpa_py_mpb_py_mph_py_py_dup2 r0 *1 0,0
Cmpa_py_mpb_py_mph_py_py_dup2 mpa_py|mpb_py|mph_py|py$2 vsubs 7.9788e-16
* device instance mpa_py_mpb_py_mph_py_py_dup3_t0 r0 *1 0,0
Rmpa_py_mpb_py_mph_py_py_dup3_t0 mpa_py|mpb_py|mph_py|py__t04
+ mpa_py|mpb_py|mph_py|py$3 34.5626
* device instance mpa_py_mpb_py_mph_py_py_dup3_t1 r0 *1 0,0
Rmpa_py_mpb_py_mph_py_py_dup3_t1 mpa_py|mpb_py|mph_py|py__t14
+ mpa_py|mpb_py|mph_py|py$3 29.1814122776
* device instance mpa_py_mpb_py_mph_py_py_dup3_t2 r0 *1 0,0
Rmpa_py_mpb_py_mph_py_py_dup3_t2 mpa_py|mpb_py|mph_py|py__t24
+ mpa_py|mpb_py|mph_py|py$3 5.38118772242
* device instance mpa_py_mpb_py_mph_py_py_dup3 r0 *1 0,0
Cmpa_py_mpb_py_mph_py_py_dup3 mpa_py|mpb_py|mph_py|py$3 vsubs 7.99818e-16
* device instance ny_t0 r0 *1 0,0
Rny_t0 ny__t0 ny 44.45845
* device instance ny_t1 r0 *1 0,0
Rny_t1 ny__t1 ny 44.45845
* device instance ny r0 *1 0,0
Cny ny vsubs 2.11758e-16
* device instance ny_dup1_t0 r0 *1 0,0
Rny_dup1_t0 ny__t02 ny$1 41.7022
* device instance ny_dup1_t1 r0 *1 0,0
Rny_dup1_t1 ny__t12 ny$1 41.7022
* device instance ny_dup1 r0 *1 0,0
Cny_dup1 ny$1 vsubs 1.70111e-16
* device instance ny_dup2_t0 r0 *1 0,0
Rny_dup2_t0 ny__t03 ny$2 41.7022
* device instance ny_dup2_t1 r0 *1 0,0
Rny_dup2_t1 ny__t13 ny$2 41.7022
* device instance ny_dup2 r0 *1 0,0
Cny_dup2 ny$2 vsubs 1.70111e-16
* device instance ny_dup3_t0 r0 *1 0,0
Rny_dup3_t0 ny__t04 ny$3 41.7022
* device instance ny_dup3_t1 r0 *1 0,0
Rny_dup3_t1 ny__t14 ny$3 41.7022
* device instance ny_dup3 r0 *1 0,0
Cny_dup3 ny$3 vsubs 1.70111e-16
* device instance ny_dup4_t0 r0 *1 0,0
Rny_dup4_t0 ny__t05 ny$4 41.7022
* device instance ny_dup4_t1 r0 *1 0,0
Rny_dup4_t1 ny__t15 ny$4 41.7022
* device instance ny_dup4 r0 *1 0,0
Cny_dup4 ny$4 vsubs 1.70111e-16
* device instance ny_dup5_t0 r0 *1 0,0
Rny_dup5_t0 ny__t06 ny$5 44.6445
* device instance ny_dup5_t1 r0 *1 0,0
Rny_dup5_t1 ny__t16 ny$5 44.6445
* device instance ny_dup5 r0 *1 0,0
Cny_dup5 ny$5 vsubs 2.13697e-16
* device instance ny_dup6_t0 r0 *1 0,0
Rny_dup6_t0 ny__t07 ny$6 41.76295
* device instance ny_dup6_t1 r0 *1 0,0
Rny_dup6_t1 ny__t17 ny$6 41.76295
* device instance ny_dup6 r0 *1 0,0
Cny_dup6 ny$6 vsubs 1.7205e-16
* device instance ny_dup7_t0 r0 *1 0,0
Rny_dup7_t0 ny__t08 ny$7 41.76295
* device instance ny_dup7_t1 r0 *1 0,0
Rny_dup7_t1 ny__t18 ny$7 41.76295
* device instance ny_dup7 r0 *1 0,0
Cny_dup7 ny$7 vsubs 1.7205e-16
* device instance ny_dup8_t0 r0 *1 0,0
Rny_dup8_t0 ny__t09 ny$8 41.76295
* device instance ny_dup8_t1 r0 *1 0,0
Rny_dup8_t1 ny__t19 ny$8 41.76295
* device instance ny_dup8 r0 *1 0,0
Cny_dup8 ny$8 vsubs 1.7205e-16
* device instance ny_dup9_t0 r0 *1 0,0
Rny_dup9_t0 ny__t010 ny$9 41.76295
* device instance ny_dup9_t1 r0 *1 0,0
Rny_dup9_t1 ny__t110 ny$9 41.76295
* device instance ny_dup9 r0 *1 0,0
Cny_dup9 ny$9 vsubs 1.7205e-16
* device instance ny_dup10_t0 r0 *1 0,0
Rny_dup10_t0 ny__t011 ny$10 44.8339
* device instance ny_dup10_t1 r0 *1 0,0
Rny_dup10_t1 ny__t111 ny$10 44.8339
* device instance ny_dup10 r0 *1 0,0
Cny_dup10 ny$10 vsubs 2.15636e-16
* device instance ny_dup11_t0 r0 *1 0,0
Rny_dup11_t0 ny__t012 ny$11 41.8333
* device instance ny_dup11_t1 r0 *1 0,0
Rny_dup11_t1 ny__t112 ny$11 41.8333
* device instance ny_dup11 r0 *1 0,0
Cny_dup11 ny$11 vsubs 1.73989e-16
* device instance ny_dup12_t0 r0 *1 0,0
Rny_dup12_t0 ny__t013 ny$12 41.8333
* device instance ny_dup12_t1 r0 *1 0,0
Rny_dup12_t1 ny__t113 ny$12 41.8333
* device instance ny_dup12 r0 *1 0,0
Cny_dup12 ny$12 vsubs 1.73989e-16
* device instance ny_dup13_t0 r0 *1 0,0
Rny_dup13_t0 ny__t014 ny$13 41.8333
* device instance ny_dup13_t1 r0 *1 0,0
Rny_dup13_t1 ny__t114 ny$13 41.8333
* device instance ny_dup13 r0 *1 0,0
Cny_dup13 ny$13 vsubs 1.73989e-16
* device instance ny_dup14_t0 r0 *1 0,0
Rny_dup14_t0 ny__t015 ny$14 41.8333
* device instance ny_dup14_t1 r0 *1 0,0
Rny_dup14_t1 ny__t115 ny$14 41.8333
* device instance ny_dup14 r0 *1 0,0
Cny_dup14 ny$14 vsubs 1.73989e-16
* device instance ny_dup15_t0 r0 *1 0,0
Rny_dup15_t0 ny__t016 ny$15 45.02655
* device instance ny_dup15_t1 r0 *1 0,0
Rny_dup15_t1 ny__t116 ny$15 45.02655
* device instance ny_dup15 r0 *1 0,0
Cny_dup15 ny$15 vsubs 2.17575e-16
* device instance ny_dup16_t0 r0 *1 0,0
Rny_dup16_t0 ny__t017 ny$16 41.9128
* device instance ny_dup16_t1 r0 *1 0,0
Rny_dup16_t1 ny__t117 ny$16 41.9128
* device instance ny_dup16 r0 *1 0,0
Cny_dup16 ny$16 vsubs 1.75928e-16
* device instance ny_dup17_t0 r0 *1 0,0
Rny_dup17_t0 ny__t018 ny$17 41.9128
* device instance ny_dup17_t1 r0 *1 0,0
Rny_dup17_t1 ny__t118 ny$17 41.9128
* device instance ny_dup17 r0 *1 0,0
Cny_dup17 ny$17 vsubs 1.75928e-16
* device instance ny_dup18_t0 r0 *1 0,0
Rny_dup18_t0 ny__t019 ny$18 41.9128
* device instance ny_dup18_t1 r0 *1 0,0
Rny_dup18_t1 ny__t119 ny$18 41.9128
* device instance ny_dup18 r0 *1 0,0
Cny_dup18 ny$18 vsubs 1.75928e-16
* device instance ny_dup19_t0 r0 *1 0,0
Rny_dup19_t0 ny__t020 ny$19 41.9128
* device instance ny_dup19_t1 r0 *1 0,0
Rny_dup19_t1 ny__t120 ny$19 41.9128
* device instance ny_dup19 r0 *1 0,0
Cny_dup19 ny$19 vsubs 1.75928e-16
* device instance py_t0 r0 *1 0,0
Rpy_t0 py__t0 py 37.6683
* device instance py_t1 r0 *1 0,0
Rpy_t1 py__t1 py 37.6683
* device instance py r0 *1 0,0
Cpy py vsubs 1.9321e-16
* device instance py_dup1_t0 r0 *1 0,0
Rpy_dup1_t0 py__t02 py$1 37.6683
* device instance py_dup1_t1 r0 *1 0,0
Rpy_dup1_t1 py__t12 py$1 37.6683
* device instance py_dup1 r0 *1 0,0
Cpy_dup1 py$1 vsubs 1.9321e-16
* device instance py_dup2_t0 r0 *1 0,0
Rpy_dup2_t0 py__t03 py$2 37.6683
* device instance py_dup2_t1 r0 *1 0,0
Rpy_dup2_t1 py__t13 py$2 37.6683
* device instance py_dup2 r0 *1 0,0
Cpy_dup2 py$2 vsubs 1.9321e-16
* device instance py_dup3_t0 r0 *1 0,0
Rpy_dup3_t0 py__t04 py$3 37.6683
* device instance py_dup3_t1 r0 *1 0,0
Rpy_dup3_t1 py__t14 py$3 37.6683
* device instance py_dup3 r0 *1 0,0
Cpy_dup3 py$3 vsubs 1.9321e-16
* device instance py_dup4_t0 r0 *1 0,0
Rpy_dup4_t0 py__t05 py$4 37.875
* device instance py_dup4_t1 r0 *1 0,0
Rpy_dup4_t1 py__t15 py$4 37.875
* device instance py_dup4 r0 *1 0,0
Cpy_dup4 py$4 vsubs 1.95101e-16
* device instance py_dup5_t0 r0 *1 0,0
Rpy_dup5_t0 py__t06 py$5 37.875
* device instance py_dup5_t1 r0 *1 0,0
Rpy_dup5_t1 py__t16 py$5 37.875
* device instance py_dup5 r0 *1 0,0
Cpy_dup5 py$5 vsubs 1.95101e-16
* device instance py_dup6_t0 r0 *1 0,0
Rpy_dup6_t0 py__t07 py$6 37.875
* device instance py_dup6_t1 r0 *1 0,0
Rpy_dup6_t1 py__t17 py$6 37.875
* device instance py_dup6 r0 *1 0,0
Cpy_dup6 py$6 vsubs 1.95101e-16
* device instance py_dup7_t0 r0 *1 0,0
Rpy_dup7_t0 py__t08 py$7 37.875
* device instance py_dup7_t1 r0 *1 0,0
Rpy_dup7_t1 py__t18 py$7 37.875
* device instance py_dup7 r0 *1 0,0
Cpy_dup7 py$7 vsubs 1.95101e-16
* device instance py_dup8_t0 r0 *1 0,0
Rpy_dup8_t0 py__t09 py$8 38.0848
* device instance py_dup8_t1 r0 *1 0,0
Rpy_dup8_t1 py__t19 py$8 38.0848
* device instance py_dup8 r0 *1 0,0
Cpy_dup8 py$8 vsubs 1.96992e-16
* device instance py_dup9_t0 r0 *1 0,0
Rpy_dup9_t0 py__t010 py$9 38.0848
* device instance py_dup9_t1 r0 *1 0,0
Rpy_dup9_t1 py__t110 py$9 38.0848
* device instance py_dup9 r0 *1 0,0
Cpy_dup9 py$9 vsubs 1.96992e-16
* device instance py_dup10_t0 r0 *1 0,0
Rpy_dup10_t0 py__t011 py$10 38.0848
* device instance py_dup10_t1 r0 *1 0,0
Rpy_dup10_t1 py__t111 py$10 38.0848
* device instance py_dup10 r0 *1 0,0
Cpy_dup10 py$10 vsubs 1.96992e-16
* device instance py_dup11_t0 r0 *1 0,0
Rpy_dup11_t0 py__t012 py$11 38.0848
* device instance py_dup11_t1 r0 *1 0,0
Rpy_dup11_t1 py__t112 py$11 38.0848
* device instance py_dup11 r0 *1 0,0
Cpy_dup11 py$11 vsubs 1.96992e-16
* device instance py_dup12_t0 r0 *1 0,0
Rpy_dup12_t0 py__t013 py$12 38.29745
* device instance py_dup12_t1 r0 *1 0,0
Rpy_dup12_t1 py__t113 py$12 38.29745
* device instance py_dup12 r0 *1 0,0
Cpy_dup12 py$12 vsubs 1.98882e-16
* device instance py_dup13_t0 r0 *1 0,0
Rpy_dup13_t0 py__t014 py$13 38.29745
* device instance py_dup13_t1 r0 *1 0,0
Rpy_dup13_t1 py__t114 py$13 38.29745
* device instance py_dup13 r0 *1 0,0
Cpy_dup13 py$13 vsubs 1.98882e-16
* device instance py_dup14_t0 r0 *1 0,0
Rpy_dup14_t0 py__t015 py$14 38.29745
* device instance py_dup14_t1 r0 *1 0,0
Rpy_dup14_t1 py__t115 py$14 38.29745
* device instance py_dup14 r0 *1 0,0
Cpy_dup14 py$14 vsubs 1.98882e-16
* device instance py_dup15_t0 r0 *1 0,0
Rpy_dup15_t0 py__t016 py$15 38.29745
* device instance py_dup15_t1 r0 *1 0,0
Rpy_dup15_t1 py__t116 py$15 38.29745
* device instance py_dup15 r0 *1 0,0
Cpy_dup15 py$15 vsubs 1.98882e-16
* device instance rst_n_t0 r0 *1 0,0
Rrst_n_t0 rst_n__t0 rst_n 323.491673565
* device instance rst_n_t1 r0 *1 0,0
Rrst_n_t1 rst_n__t1 rst_n 26.0191735327
* device instance rst_n_t2 r0 *1 0,0
Rrst_n_t2 rst_n__t2 rst_n 142.351578801
* device instance rst_n_t3 r0 *1 0,0
Rrst_n_t3 rst_n__t3 rst_n 90.4496268852
* device instance rst_n_t4 r0 *1 0,0
Rrst_n_t4 rst_n__t4 rst_n 206.955327804
* device instance rst_n_t5 r0 *1 0,0
Rrst_n_t5 rst_n__t5 rst_n 258.878212757
* device instance rst_n_t6 r0 *1 0,0
Rrst_n_t6 rst_n__t6 rst_n 323.491673565
* device instance rst_n_t7 r0 *1 0,0
Rrst_n_t7 rst_n__t7 rst_n 142.770224381
* device instance rst_n_t8 r0 *1 0,0
Rrst_n_t8 rst_n__t8 rst_n 26.4337806245
* device instance rst_n_t9 r0 *1 0,0
Rrst_n_t9 rst_n__t9 rst_n 90.8680650868
* device instance rst_n_t10 r0 *1 0,0
Rrst_n_t10 rst_n__t10 rst_n 323.910432599
* device instance rst_n_t11 r0 *1 0,0
Rrst_n_t11 rst_n__t11 rst_n 259.296956477
* device instance rst_n_t12 r0 *1 0,0
Rrst_n_t12 rst_n__t12 rst_n 207.374047487
* device instance rst_n_t13 r0 *1 0,0
Rrst_n_t13 rst_n__t13 rst_n 323.910432599
* device instance rst_n_t14 r0 *1 0,0
Rrst_n_t14 rst_n__t14 rst_n 259.296956477
* device instance rst_n_t15 r0 *1 0,0
Rrst_n_t15 rst_n__t15 rst_n 26.4337806245
* device instance rst_n_t16 r0 *1 0,0
Rrst_n_t16 rst_n__t16 rst_n 142.770224381
* device instance rst_n_t17 r0 *1 0,0
Rrst_n_t17 rst_n__t17 rst_n 90.8680650868
* device instance rst_n_t18 r0 *1 0,0
Rrst_n_t18 rst_n__t18 rst_n 207.374047487
* device instance rst_n_t19 r0 *1 0,0
Rrst_n_t19 rst_n__t19 rst_n 26.0191735327
* device instance rst_n_t20 r0 *1 0,0
Rrst_n_t20 rst_n__t20 rst_n 90.4496268852
* device instance rst_n_t21 r0 *1 0,0
Rrst_n_t21 rst_n__t21 rst_n 142.351578801
* device instance rst_n_t22 r0 *1 0,0
Rrst_n_t22 rst_n__t22 rst_n 258.878212757
* device instance rst_n_t23 r0 *1 0,0
Rrst_n_t23 rst_n__t23 rst_n 206.955327804
* device instance rst_n r0 *1 0,0
Crst_n rst_n vsubs 4.62094e-14
* device instance vdd_t0 r0 *1 0,0
Rvdd_t0 vdd__t0 vdd 199.379097957
* device instance vdd_t1 r0 *1 0,0
Rvdd_t1 vdd__t1 vdd 199.379097957
* device instance vdd_t2 r0 *1 0,0
Rvdd_t2 vdd__t2 vdd 195.754325088
* device instance vdd_t3 r0 *1 0,0
Rvdd_t3 vdd__t3 vdd 195.754325088
* device instance vdd_t4 r0 *1 0,0
Rvdd_t4 vdd__t4 vdd 194.806008197
* device instance vdd_t5 r0 *1 0,0
Rvdd_t5 vdd__t5 vdd 144.389272993
* device instance vdd_t6 r0 *1 0,0
Rvdd_t6 vdd__t6 vdd 184.709123581
* device instance vdd_t7 r0 *1 0,0
Rvdd_t7 vdd__t7 vdd 105.826071495
* device instance vdd_t8 r0 *1 0,0
Rvdd_t8 vdd__t8 vdd 144.389272993
* device instance vdd_t9 r0 *1 0,0
Rvdd_t9 vdd__t9 vdd 115.083225548
* device instance vdd_t10 r0 *1 0,0
Rvdd_t10 vdd__t10 vdd 184.709123581
* device instance vdd_t11 r0 *1 0,0
Rvdd_t11 vdd__t11 vdd 105.826071495
* device instance vdd_t12 r0 *1 0,0
Rvdd_t12 vdd__t12 vdd 154.229433314
* device instance vdd_t13 r0 *1 0,0
Rvdd_t13 vdd__t13 vdd 185.653364652
* device instance vdd_t14 r0 *1 0,0
Rvdd_t14 vdd__t14 vdd 155.155953188
* device instance vdd_t15 r0 *1 0,0
Rvdd_t15 vdd__t15 vdd 106.683749361
* device instance vdd_t16 r0 *1 0,0
Rvdd_t16 vdd__t16 vdd 145.307434003
* device instance vdd_t17 r0 *1 0,0
Rvdd_t17 vdd__t17 vdd 115.961533537
* device instance vdd_t18 r0 *1 0,0
Rvdd_t18 vdd__t18 vdd 155.155953188
* device instance vdd_t19 r0 *1 0,0
Rvdd_t19 vdd__t19 vdd 115.961533537
* device instance vdd_t20 r0 *1 0,0
Rvdd_t20 vdd__t20 vdd 111.857992531
* device instance vdd_t21 r0 *1 0,0
Rvdd_t21 vdd__t21 vdd 66.9345041695
* device instance vdd_t22 r0 *1 0,0
Rvdd_t22 vdd__t22 vdd 147.77215987
* device instance vdd_t23 r0 *1 0,0
Rvdd_t23 vdd__t23 vdd 111.591513481
* device instance vdd_t24 r0 *1 0,0
Rvdd_t24 vdd__t24 vdd 192.919902574
* device instance vdd_t25 r0 *1 0,0
Rvdd_t25 vdd__t25 vdd 229.251293073
* device instance vdd_t26 r0 *1 0,0
Rvdd_t26 vdd__t26 vdd 274.493483523
* device instance vdd_t27 r0 *1 0,0
Rvdd_t27 vdd__t27 vdd 111.094200011
* device instance vdd_t28 r0 *1 0,0
Rvdd_t28 vdd__t28 vdd 54.8753341791
* device instance vdd_t29 r0 *1 0,0
Rvdd_t29 vdd__t29 vdd 32.4099322992
* device instance vdd_t30 r0 *1 0,0
Rvdd_t30 vdd__t30 vdd 22.0681948318
* device instance vdd_t31 r0 *1 0,0
Rvdd_t31 vdd__t31 vdd 99.2821401703
* device instance vdd_t32 r0 *1 0,0
Rvdd_t32 vdd__t32 vdd 135.408129925
* device instance vdd_t33 r0 *1 0,0
Rvdd_t33 vdd__t33 vdd 180.527123307
* device instance vdd_t34 r0 *1 0,0
Rvdd_t34 vdd__t34 vdd 50.6289880062
* device instance vdd_t35 r0 *1 0,0
Rvdd_t35 vdd__t35 vdd 94.5364382134
* device instance vdd_t36 r0 *1 0,0
Rvdd_t36 vdd__t36 vdd 129.364285422
* device instance vdd_t37 r0 *1 0,0
Rvdd_t37 vdd__t37 vdd 66.9345041695
* device instance vdd_t38 r0 *1 0,0
Rvdd_t38 vdd__t38 vdd 65.0877333413
* device instance vdd_t39 r0 *1 0,0
Rvdd_t39 vdd__t39 vdd 281.497725624
* device instance vdd_t40 r0 *1 0,0
Rvdd_t40 vdd__t40 vdd 263.19051248
* device instance vdd_t41 r0 *1 0,0
Rvdd_t41 vdd__t41 vdd 253.213795035
* device instance vdd_t42 r0 *1 0,0
Rvdd_t42 vdd__t42 vdd 245.679024247
* device instance vdd_t43 r0 *1 0,0
Rvdd_t43 vdd__t43 vdd 238.694743029
* device instance vdd_t44 r0 *1 0,0
Rvdd_t44 vdd__t44 vdd 217.410127964
* device instance vdd_t45 r0 *1 0,0
Rvdd_t45 vdd__t45 vdd 210.429651108
* device instance vdd_t46 r0 *1 0,0
Rvdd_t46 vdd__t46 vdd 181.642843201
* device instance vdd_t47 r0 *1 0,0
Rvdd_t47 vdd__t47 vdd 147.77215987
* device instance vdd_t48 r0 *1 0,0
Rvdd_t48 vdd__t48 vdd 145.887237544
* device instance vdd_t49 r0 *1 0,0
Rvdd_t49 vdd__t49 vdd 117.440287729
* device instance vdd_t50 r0 *1 0,0
Rvdd_t50 vdd__t50 vdd 111.591513481
* device instance vdd_t51 r0 *1 0,0
Rvdd_t51 vdd__t51 vdd 109.713882395
* device instance vdd_t52 r0 *1 0,0
Rvdd_t52 vdd__t52 vdd 191.03101471
* device instance vdd_t53 r0 *1 0,0
Rvdd_t53 vdd__t53 vdd 199.841951886
* device instance vdd_t54 r0 *1 0,0
Rvdd_t54 vdd__t54 vdd 171.685423591
* device instance vdd_t55 r0 *1 0,0
Rvdd_t55 vdd__t55 vdd 192.919902574
* device instance vdd_t56 r0 *1 0,0
Rvdd_t56 vdd__t56 vdd 173.963932166
* device instance vdd_t57 r0 *1 0,0
Rvdd_t57 vdd__t57 vdd 227.360770328
* device instance vdd_t58 r0 *1 0,0
Rvdd_t58 vdd__t58 vdd 158.721308733
* device instance vdd_t59 r0 *1 0,0
Rvdd_t59 vdd__t59 vdd 229.251293073
* device instance vdd_t60 r0 *1 0,0
Rvdd_t60 vdd__t60 vdd 272.601764358
* device instance vdd_t61 r0 *1 0,0
Rvdd_t61 vdd__t61 vdd 274.493483523
* device instance vdd_t62 r0 *1 0,0
Rvdd_t62 vdd__t62 vdd 39.7784955254
* device instance vdd_t63 r0 *1 0,0
Rvdd_t63 vdd__t63 vdd 133.380085495
* device instance vdd_t64 r0 *1 0,0
Rvdd_t64 vdd__t64 vdd 118.609423695
* device instance vdd_t65 r0 *1 0,0
Rvdd_t65 vdd__t65 vdd 192.4019557
* device instance vdd_t66 r0 *1 0,0
Rvdd_t66 vdd__t66 vdd 171.144142002
* device instance vdd_t67 r0 *1 0,0
Rvdd_t67 vdd__t67 vdd 164.174547743
* device instance vdd_t68 r0 *1 0,0
Rvdd_t68 vdd__t68 vdd 156.659270308
* device instance vdd_t69 r0 *1 0,0
Rvdd_t69 vdd__t69 vdd 146.714813776
* device instance vdd_t70 r0 *1 0,0
Rvdd_t70 vdd__t70 vdd 128.489769494
* device instance vdd_t71 r0 *1 0,0
Rvdd_t71 vdd__t71 vdd 118.031461301
* device instance vdd_t72 r0 *1 0,0
Rvdd_t72 vdd__t72 vdd 111.094200011
* device instance vdd_t73 r0 *1 0,0
Rvdd_t73 vdd__t73 vdd 90.0053799802
* device instance vdd_t74 r0 *1 0,0
Rvdd_t74 vdd__t74 vdd 199.920930071
* device instance vdd_t75 r0 *1 0,0
Rvdd_t75 vdd__t75 vdd 48.7822759146
* device instance vdd_t76 r0 *1 0,0
Rvdd_t76 vdd__t76 vdd 54.8753341791
* device instance vdd_t77 r0 *1 0,0
Rvdd_t77 vdd__t77 vdd 56.7026726466
* device instance vdd_t78 r0 *1 0,0
Rvdd_t78 vdd__t78 vdd 15.0253180015
* device instance vdd_t79 r0 *1 0,0
Rvdd_t79 vdd__t79 vdd 16.576497459
* device instance vdd_t80 r0 *1 0,0
Rvdd_t80 vdd__t80 vdd 32.0700912684
* device instance vdd_t81 r0 *1 0,0
Rvdd_t81 vdd__t81 vdd 38.3925483746
* device instance vdd_t82 r0 *1 0,0
Rvdd_t82 vdd__t82 vdd 48.2656097053
* device instance vdd_t83 r0 *1 0,0
Rvdd_t83 vdd__t83 vdd 65.937219529
* device instance vdd_t84 r0 *1 0,0
Rvdd_t84 vdd__t84 vdd 75.7022143666
* device instance vdd_t85 r0 *1 0,0
Rvdd_t85 vdd__t85 vdd 83.1140227299
* device instance vdd_t86 r0 *1 0,0
Rvdd_t86 vdd__t86 vdd 164.167235681
* device instance vdd_t87 r0 *1 0,0
Rvdd_t87 vdd__t87 vdd 157.200147042
* device instance vdd_t88 r0 *1 0,0
Rvdd_t88 vdd__t88 vdd 32.4099322992
* device instance vdd_t89 r0 *1 0,0
Rvdd_t89 vdd__t89 vdd 135.982028175
* device instance vdd_t90 r0 *1 0,0
Rvdd_t90 vdd__t90 vdd 129.029430267
* device instance vdd_t91 r0 *1 0,0
Rvdd_t91 vdd__t91 vdd 30.7340878871
* device instance vdd_t92 r0 *1 0,0
Rvdd_t92 vdd__t92 vdd 22.0681948318
* device instance vdd_t93 r0 *1 0,0
Rvdd_t93 vdd__t93 vdd 118.57043387
* device instance vdd_t94 r0 *1 0,0
Rvdd_t94 vdd__t94 vdd 23.5138415327
* device instance vdd_t95 r0 *1 0,0
Rvdd_t95 vdd__t95 vdd 182.415345968
* device instance vdd_t96 r0 *1 0,0
Rvdd_t96 vdd__t96 vdd 99.2821401703
* device instance vdd_t97 r0 *1 0,0
Rvdd_t97 vdd__t97 vdd 38.8931620555
* device instance vdd_t98 r0 *1 0,0
Rvdd_t98 vdd__t98 vdd 23.0945451551
* device instance vdd_t99 r0 *1 0,0
Rvdd_t99 vdd__t99 vdd 100.409959026
* device instance vdd_t100 r0 *1 0,0
Rvdd_t100 vdd__t100 vdd 16.813218181
* device instance vdd_t101 r0 *1 0,0
Rvdd_t101 vdd__t101 vdd 90.5411735628
* device instance vdd_t102 r0 *1 0,0
Rvdd_t102 vdd__t102 vdd 137.291524761
* device instance vdd_t103 r0 *1 0,0
Rvdd_t103 vdd__t103 vdd 135.408129925
* device instance vdd_t104 r0 *1 0,0
Rvdd_t104 vdd__t104 vdd 83.1068008449
* device instance vdd_t105 r0 *1 0,0
Rvdd_t105 vdd__t105 vdd 76.234853378
* device instance vdd_t106 r0 *1 0,0
Rvdd_t106 vdd__t106 vdd 55.4817176261
* device instance vdd_t107 r0 *1 0,0
Rvdd_t107 vdd__t107 vdd 101.156063657
* device instance vdd_t108 r0 *1 0,0
Rvdd_t108 vdd__t108 vdd 180.527123307
* device instance vdd_t109 r0 *1 0,0
Rvdd_t109 vdd__t109 vdd 50.6289880062
* device instance vdd_t110 r0 *1 0,0
Rvdd_t110 vdd__t110 vdd 94.5364382134
* device instance vdd_t111 r0 *1 0,0
Rvdd_t111 vdd__t111 vdd 129.364285422
* device instance vdd_t112 r0 *1 0,0
Rvdd_t112 vdd__t112 vdd 65.0877333413
* device instance vdd_t113 r0 *1 0,0
Rvdd_t113 vdd__t113 vdd 263.19051248
* device instance vdd_t114 r0 *1 0,0
Rvdd_t114 vdd__t114 vdd 238.694743029
* device instance vdd_t115 r0 *1 0,0
Rvdd_t115 vdd__t115 vdd 210.429651108
* device instance vdd_t116 r0 *1 0,0
Rvdd_t116 vdd__t116 vdd 181.642843201
* device instance vdd_t117 r0 *1 0,0
Rvdd_t117 vdd__t117 vdd 145.887237544
* device instance vdd_t118 r0 *1 0,0
Rvdd_t118 vdd__t118 vdd 117.440287729
* device instance vdd_t119 r0 *1 0,0
Rvdd_t119 vdd__t119 vdd 109.713882395
* device instance vdd_t120 r0 *1 0,0
Rvdd_t120 vdd__t120 vdd 191.03101471
* device instance vdd_t121 r0 *1 0,0
Rvdd_t121 vdd__t121 vdd 199.841951886
* device instance vdd_t122 r0 *1 0,0
Rvdd_t122 vdd__t122 vdd 173.963932166
* device instance vdd_t123 r0 *1 0,0
Rvdd_t123 vdd__t123 vdd 227.360770328
* device instance vdd_t124 r0 *1 0,0
Rvdd_t124 vdd__t124 vdd 158.721308733
* device instance vdd_t125 r0 *1 0,0
Rvdd_t125 vdd__t125 vdd 272.601764358
* device instance vdd_t126 r0 *1 0,0
Rvdd_t126 vdd__t126 vdd 39.7784955254
* device instance vdd_t127 r0 *1 0,0
Rvdd_t127 vdd__t127 vdd 133.380085495
* device instance vdd_t128 r0 *1 0,0
Rvdd_t128 vdd__t128 vdd 118.609423695
* device instance vdd_t129 r0 *1 0,0
Rvdd_t129 vdd__t129 vdd 171.144142002
* device instance vdd_t130 r0 *1 0,0
Rvdd_t130 vdd__t130 vdd 146.714813776
* device instance vdd_t131 r0 *1 0,0
Rvdd_t131 vdd__t131 vdd 118.031461301
* device instance vdd_t132 r0 *1 0,0
Rvdd_t132 vdd__t132 vdd 90.0053799802
* device instance vdd_t133 r0 *1 0,0
Rvdd_t133 vdd__t133 vdd 48.7822759146
* device instance vdd_t134 r0 *1 0,0
Rvdd_t134 vdd__t134 vdd 56.7026726466
* device instance vdd_t135 r0 *1 0,0
Rvdd_t135 vdd__t135 vdd 16.576497459
* device instance vdd_t136 r0 *1 0,0
Rvdd_t136 vdd__t136 vdd 38.3925483746
* device instance vdd_t137 r0 *1 0,0
Rvdd_t137 vdd__t137 vdd 65.937219529
* device instance vdd_t138 r0 *1 0,0
Rvdd_t138 vdd__t138 vdd 157.200147042
* device instance vdd_t139 r0 *1 0,0
Rvdd_t139 vdd__t139 vdd 129.029430267
* device instance vdd_t140 r0 *1 0,0
Rvdd_t140 vdd__t140 vdd 30.7340878871
* device instance vdd_t141 r0 *1 0,0
Rvdd_t141 vdd__t141 vdd 23.5138415327
* device instance vdd_t142 r0 *1 0,0
Rvdd_t142 vdd__t142 vdd 182.415345968
* device instance vdd_t143 r0 *1 0,0
Rvdd_t143 vdd__t143 vdd 23.0945451551
* device instance vdd_t144 r0 *1 0,0
Rvdd_t144 vdd__t144 vdd 100.409959026
* device instance vdd_t145 r0 *1 0,0
Rvdd_t145 vdd__t145 vdd 137.291524761
* device instance vdd_t146 r0 *1 0,0
Rvdd_t146 vdd__t146 vdd 76.234853378
* device instance vdd_t147 r0 *1 0,0
Rvdd_t147 vdd__t147 vdd 101.156063657
* device instance vdd r0 *1 0,0
Cvdd vdd vsubs 1.3113907e-13
* device instance vddr1_t0 r0 *1 0,0
Rvddr1_t0 vddr1__t0 vddr1 118.269225677
* device instance vddr1_t1 r0 *1 0,0
Rvddr1_t1 vddr1__t1 vddr1 116.975276743
* device instance vddr1_t2 r0 *1 0,0
Rvddr1_t2 vddr1__t2 vddr1 116.975276743
* device instance vddr1_t3 r0 *1 0,0
Rvddr1_t3 vddr1__t3 vddr1 114.300635543
* device instance vddr1_t4 r0 *1 0,0
Rvddr1_t4 vddr1__t4 vddr1 58.611096784
* device instance vddr1_t5 r0 *1 0,0
Rvddr1_t5 vddr1__t5 vddr1 6.26137502177
* device instance vddr1_t6 r0 *1 0,0
Rvddr1_t6 vddr1__t6 vddr1 53.632711459
* device instance vddr1_t7 r0 *1 0,0
Rvddr1_t7 vddr1__t7 vddr1 114.300635543
* device instance vddr1_t8 r0 *1 0,0
Rvddr1_t8 vddr1__t8 vddr1 58.611096784
* device instance vddr1_t9 r0 *1 0,0
Rvddr1_t9 vddr1__t9 vddr1 6.26137502177
* device instance vddr1_t10 r0 *1 0,0
Rvddr1_t10 vddr1__t10 vddr1 53.632711459
* device instance vddr1_t11 r0 *1 0,0
Rvddr1_t11 vddr1__t11 vddr1 56.3991321881
* device instance vddr1_t12 r0 *1 0,0
Rvddr1_t12 vddr1__t12 vddr1 61.1527189857
* device instance vddr1_t13 r0 *1 0,0
Rvddr1_t13 vddr1__t13 vddr1 115.624520145
* device instance vddr1_t14 r0 *1 0,0
Rvddr1_t14 vddr1__t14 vddr1 18.5364287362
* device instance vddr1_t15 r0 *1 0,0
Rvddr1_t15 vddr1__t15 vddr1 73.3391059075
* device instance vddr1_t16 r0 *1 0,0
Rvddr1_t16 vddr1__t16 vddr1 129.068896839
* device instance vddr1_t17 r0 *1 0,0
Rvddr1_t17 vddr1__t17 vddr1 18.2150363615
* device instance vddr1_t18 r0 *1 0,0
Rvddr1_t18 vddr1__t18 vddr1 38.9649767653
* device instance vddr1_t19 r0 *1 0,0
Rvddr1_t19 vddr1__t19 vddr1 102.210881433
* device instance vddr1_t20 r0 *1 0,0
Rvddr1_t20 vddr1__t20 vddr1 93.4166858584
* device instance vddr1 r0 *1 0,0
Cvddr1 vddr1 vsubs 1.2359482e-14
* device instance vddr2_t0 r0 *1 0,0
Rvddr2_t0 vddr2__t0 vddr2 118.503071075
* device instance vddr2_t1 r0 *1 0,0
Rvddr2_t1 vddr2__t1 vddr2 117.206563707
* device instance vddr2_t2 r0 *1 0,0
Rvddr2_t2 vddr2__t2 vddr2 117.206563707
* device instance vddr2_t3 r0 *1 0,0
Rvddr2_t3 vddr2__t3 vddr2 58.7269843714
* device instance vddr2_t4 r0 *1 0,0
Rvddr2_t4 vddr2__t4 vddr2 114.526634128
* device instance vddr2_t5 r0 *1 0,0
Rvddr2_t5 vddr2__t5 vddr2 53.7387556363
* device instance vddr2_t6 r0 *1 0,0
Rvddr2_t6 vddr2__t6 vddr2 6.27375519694
* device instance vddr2_t7 r0 *1 0,0
Rvddr2_t7 vddr2__t7 vddr2 58.7269843714
* device instance vddr2_t8 r0 *1 0,0
Rvddr2_t8 vddr2__t8 vddr2 114.526634128
* device instance vddr2_t9 r0 *1 0,0
Rvddr2_t9 vddr2__t9 vddr2 53.7387556363
* device instance vddr2_t10 r0 *1 0,0
Rvddr2_t10 vddr2__t10 vddr2 6.27375519694
* device instance vddr2_t11 r0 *1 0,0
Rvddr2_t11 vddr2__t11 vddr2 18.5730795093
* device instance vddr2_t12 r0 *1 0,0
Rvddr2_t12 vddr2__t12 vddr2 115.853136353
* device instance vddr2_t13 r0 *1 0,0
Rvddr2_t13 vddr2__t13 vddr2 61.2736319434
* device instance vddr2_t14 r0 *1 0,0
Rvddr2_t14 vddr2__t14 vddr2 56.510646214
* device instance vddr2_t15 r0 *1 0,0
Rvddr2_t15 vddr2__t15 vddr2 129.324095665
* device instance vddr2_t16 r0 *1 0,0
Rvddr2_t16 vddr2__t16 vddr2 102.412975799
* device instance vddr2_t17 r0 *1 0,0
Rvddr2_t17 vddr2__t17 vddr2 93.6013920819
* device instance vddr2_t18 r0 *1 0,0
Rvddr2_t18 vddr2__t18 vddr2 39.0420194654
* device instance vddr2_t19 r0 *1 0,0
Rvddr2_t19 vddr2__t19 vddr2 18.2510516681
* device instance vddr2_t20 r0 *1 0,0
Rvddr2_t20 vddr2__t20 vddr2 73.4841141485
* device instance vddr2 r0 *1 0,0
Cvddr2 vddr2 vsubs 1.2368661e-14
* device instance vddr3_t0 r0 *1 0,0
Rvddr3_t0 vddr3__t0 vddr3 118.736924229
* device instance vddr3_t1 r0 *1 0,0
Rvddr3_t1 vddr3__t1 vddr3 117.437858342
* device instance vddr3_t2 r0 *1 0,0
Rvddr3_t2 vddr3__t2 vddr3 117.437858342
* device instance vddr3_t3 r0 *1 0,0
Rvddr3_t3 vddr3__t3 vddr3 114.752640208
* device instance vddr3_t4 r0 *1 0,0
Rvddr3_t4 vddr3__t4 vddr3 58.8428758027
* device instance vddr3_t5 r0 *1 0,0
Rvddr3_t5 vddr3__t5 vddr3 6.28613578275
* device instance vddr3_t6 r0 *1 0,0
Rvddr3_t6 vddr3__t6 vddr3 53.844803331
* device instance vddr3_t7 r0 *1 0,0
Rvddr3_t7 vddr3__t7 vddr3 114.752640208
* device instance vddr3_t8 r0 *1 0,0
Rvddr3_t8 vddr3__t8 vddr3 58.8428758027
* device instance vddr3_t9 r0 *1 0,0
Rvddr3_t9 vddr3__t9 vddr3 6.28613578275
* device instance vddr3_t10 r0 *1 0,0
Rvddr3_t10 vddr3__t10 vddr3 53.844803331
* device instance vddr3_t11 r0 *1 0,0
Rvddr3_t11 vddr3__t11 vddr3 18.609731498
* device instance vddr3_t12 r0 *1 0,0
Rvddr3_t12 vddr3__t12 vddr3 56.6221639387
* device instance vddr3_t13 r0 *1 0,0
Rvddr3_t13 vddr3__t13 vddr3 116.081760144
* device instance vddr3_t14 r0 *1 0,0
Rvddr3_t14 vddr3__t14 vddr3 61.3945489118
* device instance vddr3_t15 r0 *1 0,0
Rvddr3_t15 vddr3__t15 vddr3 39.119064721
* device instance vddr3_t16 r0 *1 0,0
Rvddr3_t16 vddr3__t16 vddr3 93.7861044322
* device instance vddr3_t17 r0 *1 0,0
Rvddr3_t17 vddr3__t17 vddr3 102.615076869
* device instance vddr3_t18 r0 *1 0,0
Rvddr3_t18 vddr3__t18 vddr3 18.2870681693
* device instance vddr3_t19 r0 *1 0,0
Rvddr3_t19 vddr3__t19 vddr3 129.579302955
* device instance vddr3_t20 r0 *1 0,0
Rvddr3_t20 vddr3__t20 vddr3 73.6291271993
* device instance vddr3 r0 *1 0,0
Cvddr3 vddr3 vsubs 1.2373945e-14
* device instance vddr4_t0 r0 *1 0,0
Rvddr4_t0 vddr4__t0 vddr4 118.97076187
* device instance vddr4_t1 r0 *1 0,0
Rvddr4_t1 vddr4__t1 vddr4 117.669137634
* device instance vddr4_t2 r0 *1 0,0
Rvddr4_t2 vddr4__t2 vddr4 117.669137634
* device instance vddr4_t3 r0 *1 0,0
Rvddr4_t3 vddr4__t3 vddr4 6.29851554728
* device instance vddr4_t4 r0 *1 0,0
Rvddr4_t4 vddr4__t4 vddr4 58.9587595461
* device instance vddr4_t5 r0 *1 0,0
Rvddr4_t5 vddr4__t5 vddr4 114.978631296
* device instance vddr4_t6 r0 *1 0,0
Rvddr4_t6 vddr4__t6 vddr4 53.9508439908
* device instance vddr4_t7 r0 *1 0,0
Rvddr4_t7 vddr4__t7 vddr4 6.29851554728
* device instance vddr4_t8 r0 *1 0,0
Rvddr4_t8 vddr4__t8 vddr4 58.9587595461
* device instance vddr4_t9 r0 *1 0,0
Rvddr4_t9 vddr4__t9 vddr4 114.978631296
* device instance vddr4_t10 r0 *1 0,0
Rvddr4_t10 vddr4__t10 vddr4 53.9508439908
* device instance vddr4_t11 r0 *1 0,0
Rvddr4_t11 vddr4__t11 vddr4 56.7336742656
* device instance vddr4_t12 r0 *1 0,0
Rvddr4_t12 vddr4__t12 vddr4 18.6463810553
* device instance vddr4_t13 r0 *1 0,0
Rvddr4_t13 vddr4__t13 vddr4 61.5154578588
* device instance vddr4_t14 r0 *1 0,0
Rvddr4_t14 vddr4__t14 vddr4 116.310368768
* device instance vddr4_t15 r0 *1 0,0
Rvddr4_t15 vddr4__t15 vddr4 93.9708045291
* device instance vddr4_t16 r0 *1 0,0
Rvddr4_t16 vddr4__t16 vddr4 102.817164532
* device instance vddr4_t17 r0 *1 0,0
Rvddr4_t17 vddr4__t17 vddr4 39.1961048656
* device instance vddr4_t18 r0 *1 0,0
Rvddr4_t18 vddr4__t18 vddr4 129.834493316
* device instance vddr4_t19 r0 *1 0,0
Rvddr4_t19 vddr4__t19 vddr4 73.7741306304
* device instance vddr4_t20 r0 *1 0,0
Rvddr4_t20 vddr4__t20 vddr4 18.3230822812
* device instance vddr4 r0 *1 0,0
Cvddr4 vddr4 vsubs 1.2379228e-14
* device instance vss_t0 r0 *1 0,0
Rvss_t0 vss__t0 vss 158.517357859
* device instance vss_t1 r0 *1 0,0
Rvss_t1 vss__t1 vss 175.131478242
* device instance vss_t2 r0 *1 0,0
Rvss_t2 vss__t2 vss 169.681619998
* device instance vss_t3 r0 *1 0,0
Rvss_t3 vss__t3 vss 91.2187892815
* device instance vss_t4 r0 *1 0,0
Rvss_t4 vss__t4 vss 16.2128185547
* device instance vss_t5 r0 *1 0,0
Rvss_t5 vss__t5 vss 67.9545146977
* device instance vss_t6 r0 *1 0,0
Rvss_t6 vss__t6 vss 170.08670469
* device instance vss_t7 r0 *1 0,0
Rvss_t7 vss__t7 vss 91.9701172386
* device instance vss_t8 r0 *1 0,0
Rvss_t8 vss__t8 vss 20.0122570541
* device instance vss_t9 r0 *1 0,0
Rvss_t9 vss__t9 vss 68.9597782386
* device instance vss_t10 r0 *1 0,0
Rvss_t10 vss__t10 vss 93.3417136752
* device instance vss_t11 r0 *1 0,0
Rvss_t11 vss__t11 vss 104.830715731
* device instance vss_t12 r0 *1 0,0
Rvss_t12 vss__t12 vss 116.350986098
* device instance vss_t13 r0 *1 0,0
Rvss_t13 vss__t13 vss 81.8971404844
* device instance vss_t14 r0 *1 0,0
Rvss_t14 vss__t14 vss 39.8751452892
* device instance vss_t15 r0 *1 0,0
Rvss_t15 vss__t15 vss 29.6135808827
* device instance vss_t16 r0 *1 0,0
Rvss_t16 vss__t16 vss 20.8607451934
* device instance vss_t17 r0 *1 0,0
Rvss_t17 vss__t17 vss 16.2679674153
* device instance vss_t18 r0 *1 0,0
Rvss_t18 vss__t18 vss 56.3686260218
* device instance vss_t19 r0 *1 0,0
Rvss_t19 vss__t19 vss 45.3373474369
* device instance vss_t20 r0 *1 0,0
Rvss_t20 vss__t20 vss 78.96280468
* device instance vss_t21 r0 *1 0,0
Rvss_t21 vss__t21 vss 67.6064973433
* device instance vss_t22 r0 *1 0,0
Rvss_t22 vss__t22 vss 122.204318861
* device instance vss_t23 r0 *1 0,0
Rvss_t23 vss__t23 vss 133.756691202
* device instance vss_t24 r0 *1 0,0
Rvss_t24 vss__t24 vss 145.324047875
* device instance vss_t25 r0 *1 0,0
Rvss_t25 vss__t25 vss 156.903074848
* device instance vss_t26 r0 *1 0,0
Rvss_t26 vss__t26 vss 81.0524933152
* device instance vss_t27 r0 *1 0,0
Rvss_t27 vss__t27 vss 92.601514917
* device instance vss_t28 r0 *1 0,0
Rvss_t28 vss__t28 vss 104.172184453
* device instance vss_t29 r0 *1 0,0
Rvss_t29 vss__t29 vss 115.758010604
* device instance vss_t30 r0 *1 0,0
Rvss_t30 vss__t30 vss 17.2492244206
* device instance vss_t31 r0 *1 0,0
Rvss_t31 vss__t31 vss 11.2699519482
* device instance vss_t32 r0 *1 0,0
Rvss_t32 vss__t32 vss 38.1102645613
* device instance vss_t33 r0 *1 0,0
Rvss_t33 vss__t33 vss 27.190609147
* device instance vss_t34 r0 *1 0,0
Rvss_t34 vss__t34 vss 66.5808045619
* device instance vss_t35 r0 *1 0,0
Rvss_t35 vss__t35 vss 43.7931515845
* device instance vss_t36 r0 *1 0,0
Rvss_t36 vss__t36 vss 55.1342638717
* device instance vss_t37 r0 *1 0,0
Rvss_t37 vss__t37 vss 78.0864237626
* device instance vss_t38 r0 *1 0,0
Rvss_t38 vss__t38 vss 156.463861482
* device instance vss_t39 r0 *1 0,0
Rvss_t39 vss__t39 vss 133.241200439
* device instance vss_t40 r0 *1 0,0
Rvss_t40 vss__t40 vss 121.639880801
* device instance vss_t41 r0 *1 0,0
Rvss_t41 vss__t41 vss 144.849728836
* device instance vss_t42 r0 *1 0,0
Rvss_t42 vss__t42 vss 172.451509133
* device instance vss_t43 r0 *1 0,0
Rvss_t43 vss__t43 vss 145.249854559
* device instance vss_t44 r0 *1 0,0
Rvss_t44 vss__t44 vss 117.660031198
* device instance vss_t45 r0 *1 0,0
Rvss_t45 vss__t45 vss 94.403879193
* device instance vss_t46 r0 *1 0,0
Rvss_t46 vss__t46 vss 131.967640458
* device instance vss_t47 r0 *1 0,0
Rvss_t47 vss__t47 vss 196.077940963
* device instance vss_t48 r0 *1 0,0
Rvss_t48 vss__t48 vss 223.923931745
* device instance vss_t49 r0 *1 0,0
Rvss_t49 vss__t49 vss 251.28085447
* device instance vss_t50 r0 *1 0,0
Rvss_t50 vss__t50 vss 274.998816632
* device instance vss_t51 r0 *1 0,0
Rvss_t51 vss__t51 vss 68.0310775774
* device instance vss_t52 r0 *1 0,0
Rvss_t52 vss__t52 vss 147.920539394
* device instance vss_t53 r0 *1 0,0
Rvss_t53 vss__t53 vss 124.444928877
* device instance vss_t54 r0 *1 0,0
Rvss_t54 vss__t54 vss 97.0308442053
* device instance vss_t55 r0 *1 0,0
Rvss_t55 vss__t55 vss 28.3607470238
* device instance vss_t56 r0 *1 0,0
Rvss_t56 vss__t56 vss 25.6861059133
* device instance vss_t57 r0 *1 0,0
Rvss_t57 vss__t57 vss 70.5873493836
* device instance vss_t58 r0 *1 0,0
Rvss_t58 vss__t58 vss 42.6183197278
* device instance vss_t59 r0 *1 0,0
Rvss_t59 vss__t59 vss 105.44300743
* device instance vss_t60 r0 *1 0,0
Rvss_t60 vss__t60 vss 48.6196836371
* device instance vss_t61 r0 *1 0,0
Rvss_t61 vss__t61 vss 27.0933388292
* device instance vss_t62 r0 *1 0,0
Rvss_t62 vss__t62 vss 94.3054077082
* device instance vss_t63 r0 *1 0,0
Rvss_t63 vss__t63 vss 71.1218590148
* device instance vss_t64 r0 *1 0,0
Rvss_t64 vss__t64 vss 173.407427918
* device instance vss_t65 r0 *1 0,0
Rvss_t65 vss__t65 vss 148.190798106
* device instance vss_t66 r0 *1 0,0
Rvss_t66 vss__t66 vss 53.8832881561
* device instance vss_t67 r0 *1 0,0
Rvss_t67 vss__t67 vss 133.33610751
* device instance vss_t68 r0 *1 0,0
Rvss_t68 vss__t68 vss 108.655926265
* device instance vss_t69 r0 *1 0,0
Rvss_t69 vss__t69 vss 165.751613704
* device instance vss_t70 r0 *1 0,0
Rvss_t70 vss__t70 vss 155.99253298
* device instance vss_t71 r0 *1 0,0
Rvss_t71 vss__t71 vss 86.4526290855
* device instance vss_t72 r0 *1 0,0
Rvss_t72 vss__t72 vss 77.3330703637
* device instance vss_t73 r0 *1 0,0
Rvss_t73 vss__t73 vss 115.990222151
* device instance vss_t74 r0 *1 0,0
Rvss_t74 vss__t74 vss 125.580738319
* device instance vss_t75 r0 *1 0,0
Rvss_t75 vss__t75 vss 284.413399839
* device instance vss_t76 r0 *1 0,0
Rvss_t76 vss__t76 vss 240.612692169
* device instance vss_t77 r0 *1 0,0
Rvss_t77 vss__t77 vss 84.0383186388
* device instance vss_t78 r0 *1 0,0
Rvss_t78 vss__t78 vss 161.836016398
* device instance vss_t79 r0 *1 0,0
Rvss_t79 vss__t79 vss 126.943765637
* device instance vss_t80 r0 *1 0,0
Rvss_t80 vss__t80 vss 205.463606773
* device instance vss_t81 r0 *1 0,0
Rvss_t81 vss__t81 vss 50.8847696828
* device instance vss_t82 r0 *1 0,0
Rvss_t82 vss__t82 vss 22.5631562854
* device instance vss_t83 r0 *1 0,0
Rvss_t83 vss__t83 vss 40.4835048251
* device instance vss_t84 r0 *1 0,0
Rvss_t84 vss__t84 vss 115.168063133
* device instance vss_t85 r0 *1 0,0
Rvss_t85 vss__t85 vss 80.8137814311
* device instance vss_t86 r0 *1 0,0
Rvss_t86 vss__t86 vss 158.517357859
* device instance vss_t87 r0 *1 0,0
Rvss_t87 vss__t87 vss 115.168063133
* device instance vss_t88 r0 *1 0,0
Rvss_t88 vss__t88 vss 80.8137814311
* device instance vss_t89 r0 *1 0,0
Rvss_t89 vss__t89 vss 40.4835048251
* device instance vss_t90 r0 *1 0,0
Rvss_t90 vss__t90 vss 22.5631562854
* device instance vss_t91 r0 *1 0,0
Rvss_t91 vss__t91 vss 50.8847696828
* device instance vss_t92 r0 *1 0,0
Rvss_t92 vss__t92 vss 84.0383186388
* device instance vss_t93 r0 *1 0,0
Rvss_t93 vss__t93 vss 126.943765637
* device instance vss_t94 r0 *1 0,0
Rvss_t94 vss__t94 vss 161.836016398
* device instance vss_t95 r0 *1 0,0
Rvss_t95 vss__t95 vss 205.463606773
* device instance vss_t96 r0 *1 0,0
Rvss_t96 vss__t96 vss 240.612692169
* device instance vss_t97 r0 *1 0,0
Rvss_t97 vss__t97 vss 284.413399839
* device instance vss_t98 r0 *1 0,0
Rvss_t98 vss__t98 vss 166.319859515
* device instance vss_t99 r0 *1 0,0
Rvss_t99 vss__t99 vss 87.875896764
* device instance vss_t100 r0 *1 0,0
Rvss_t100 vss__t100 vss 13.9650782301
* device instance vss_t101 r0 *1 0,0
Rvss_t101 vss__t101 vss 71.2800547325
* device instance vss_t102 r0 *1 0,0
Rvss_t102 vss__t102 vss 166.687020726
* device instance vss_t103 r0 *1 0,0
Rvss_t103 vss__t103 vss 156.925456138
* device instance vss_t104 r0 *1 0,0
Rvss_t104 vss__t104 vss 126.501783818
* device instance vss_t105 r0 *1 0,0
Rvss_t105 vss__t105 vss 116.905406689
* device instance vss_t106 r0 *1 0,0
Rvss_t106 vss__t106 vss 87.3352768824
* device instance vss_t107 r0 *1 0,0
Rvss_t107 vss__t107 vss 78.1969327405
* device instance vss_t108 r0 *1 0,0
Rvss_t108 vss__t108 vss 157.572588233
* device instance vss_t109 r0 *1 0,0
Rvss_t109 vss__t109 vss 114.232116913
* device instance vss_t110 r0 *1 0,0
Rvss_t110 vss__t110 vss 79.8974742314
* device instance vss_t111 r0 *1 0,0
Rvss_t111 vss__t111 vss 39.6935666193
* device instance vss_t112 r0 *1 0,0
Rvss_t112 vss__t112 vss 22.6540601315
* device instance vss_t113 r0 *1 0,0
Rvss_t113 vss__t113 vss 51.7425951536
* device instance vss_t114 r0 *1 0,0
Rvss_t114 vss__t114 vss 84.9583469592
* device instance vss_t115 r0 *1 0,0
Rvss_t115 vss__t115 vss 127.883256532
* device instance vss_t116 r0 *1 0,0
Rvss_t116 vss__t116 vss 162.781292602
* device instance vss_t117 r0 *1 0,0
Rvss_t117 vss__t117 vss 206.412384984
* device instance vss_t118 r0 *1 0,0
Rvss_t118 vss__t118 vss 241.56301859
* device instance vss_t119 r0 *1 0,0
Rvss_t119 vss__t119 vss 285.364910727
* device instance vss_t120 r0 *1 0,0
Rvss_t120 vss__t120 vss 165.367534333
* device instance vss_t121 r0 *1 0,0
Rvss_t121 vss__t121 vss 86.9292311506
* device instance vss_t122 r0 *1 0,0
Rvss_t122 vss__t122 vss 13.4139353073
* device instance vss_t123 r0 *1 0,0
Rvss_t123 vss__t123 vss 72.2229098502
* device instance vss_t124 r0 *1 0,0
Rvss_t124 vss__t124 vss 165.751613704
* device instance vss_t125 r0 *1 0,0
Rvss_t125 vss__t125 vss 155.99253298
* device instance vss_t126 r0 *1 0,0
Rvss_t126 vss__t126 vss 125.580738319
* device instance vss_t127 r0 *1 0,0
Rvss_t127 vss__t127 vss 115.990222151
* device instance vss_t128 r0 *1 0,0
Rvss_t128 vss__t128 vss 86.4526290855
* device instance vss_t129 r0 *1 0,0
Rvss_t129 vss__t129 vss 77.3330703637
* device instance vss_t130 r0 *1 0,0
Rvss_t130 vss__t130 vss 175.131478242
* device instance vss_t131 r0 *1 0,0
Rvss_t131 vss__t131 vss 168.401702611
* device instance vss_t132 r0 *1 0,0
Rvss_t132 vss__t132 vss 147.920539394
* device instance vss_t133 r0 *1 0,0
Rvss_t133 vss__t133 vss 141.215016234
* device instance vss_t134 r0 *1 0,0
Rvss_t134 vss__t134 vss 133.991121922
* device instance vss_t135 r0 *1 0,0
Rvss_t135 vss__t135 vss 124.444928877
* device instance vss_t136 r0 *1 0,0
Rvss_t136 vss__t136 vss 107.000091142
* device instance vss_t137 r0 *1 0,0
Rvss_t137 vss__t137 vss 97.0308442053
* device instance vss_t138 r0 *1 0,0
Rvss_t138 vss__t138 vss 90.4412911426
* device instance vss_t139 r0 *1 0,0
Rvss_t139 vss__t139 vss 70.5873493836
* device instance vss_t140 r0 *1 0,0
Rvss_t140 vss__t140 vss 64.1896593947
* device instance vss_t141 r0 *1 0,0
Rvss_t141 vss__t141 vss 57.3891863046
* device instance vss_t142 r0 *1 0,0
Rvss_t142 vss__t142 vss 48.6196836371
* device instance vss_t143 r0 *1 0,0
Rvss_t143 vss__t143 vss 33.8682051091
* device instance vss_t144 r0 *1 0,0
Rvss_t144 vss__t144 vss 27.0933388292
* device instance vss_t145 r0 *1 0,0
Rvss_t145 vss__t145 vss 23.9840586713
* device instance vss_t146 r0 *1 0,0
Rvss_t146 vss__t146 vss 25.6861059133
* device instance vss_t147 r0 *1 0,0
Rvss_t147 vss__t147 vss 29.564474666
* device instance vss_t148 r0 *1 0,0
Rvss_t148 vss__t148 vss 34.7639307491
* device instance vss_t149 r0 *1 0,0
Rvss_t149 vss__t149 vss 42.6183197278
* device instance vss_t150 r0 *1 0,0
Rvss_t150 vss__t150 vss 58.4825217993
* device instance vss_t151 r0 *1 0,0
Rvss_t151 vss__t151 vss 68.0310775774
* device instance vss_t152 r0 *1 0,0
Rvss_t152 vss__t152 vss 74.4711838422
* device instance vss_t153 r0 *1 0,0
Rvss_t153 vss__t153 vss 94.403879193
* device instance vss_t154 r0 *1 0,0
Rvss_t154 vss__t154 vss 101.00949548
* device instance vss_t155 r0 *1 0,0
Rvss_t155 vss__t155 vss 108.160331376
* device instance vss_t156 r0 *1 0,0
Rvss_t156 vss__t156 vss 117.660031198
* device instance vss_t157 r0 *1 0,0
Rvss_t157 vss__t157 vss 135.160902706
* device instance vss_t158 r0 *1 0,0
Rvss_t158 vss__t158 vss 145.249854559
* device instance vss_t159 r0 *1 0,0
Rvss_t159 vss__t159 vss 151.959842067
* device instance vss_t160 r0 *1 0,0
Rvss_t160 vss__t160 vss 172.451509133
* device instance vss_t161 r0 *1 0,0
Rvss_t161 vss__t161 vss 179.183962501
* device instance vss_t162 r0 *1 0,0
Rvss_t162 vss__t162 vss 186.450792198
* device instance vss_t163 r0 *1 0,0
Rvss_t163 vss__t163 vss 196.077940963
* device instance vss_t164 r0 *1 0,0
Rvss_t164 vss__t164 vss 213.756515949
* device instance vss_t165 r0 *1 0,0
Rvss_t165 vss__t165 vss 223.923931745
* device instance vss_t166 r0 *1 0,0
Rvss_t166 vss__t166 vss 230.678876807
* device instance vss_t167 r0 *1 0,0
Rvss_t167 vss__t167 vss 251.28085447
* device instance vss_t168 r0 *1 0,0
Rvss_t168 vss__t168 vss 258.042595096
* device instance vss_t169 r0 *1 0,0
Rvss_t169 vss__t169 vss 265.337997212
* device instance vss_t170 r0 *1 0,0
Rvss_t170 vss__t170 vss 274.998816632
* device instance vss_t171 r0 *1 0,0
Rvss_t171 vss__t171 vss 292.729125347
* device instance vss_t172 r0 *1 0,0
Rvss_t172 vss__t172 vss 153.103430601
* device instance vss_t173 r0 *1 0,0
Rvss_t173 vss__t173 vss 141.490783538
* device instance vss_t174 r0 *1 0,0
Rvss_t174 vss__t174 vss 129.884151253
* device instance vss_t175 r0 *1 0,0
Rvss_t175 vss__t175 vss 118.285304344
* device instance vss_t176 r0 *1 0,0
Rvss_t176 vss__t176 vss 105.44300743
* device instance vss_t177 r0 *1 0,0
Rvss_t177 vss__t177 vss 74.7534099449
* device instance vss_t178 r0 *1 0,0
Rvss_t178 vss__t178 vss 63.2618655165
* device instance vss_t179 r0 *1 0,0
Rvss_t179 vss__t179 vss 51.8394108315
* device instance vss_t180 r0 *1 0,0
Rvss_t180 vss__t180 vss 40.5444812341
* device instance vss_t181 r0 *1 0,0
Rvss_t181 vss__t181 vss 28.3607470238
* device instance vss_t182 r0 *1 0,0
Rvss_t182 vss__t182 vss 12.1842828946
* device instance vss_t183 r0 *1 0,0
Rvss_t183 vss__t183 vss 19.9363498668
* device instance vss_t184 r0 *1 0,0
Rvss_t184 vss__t184 vss 30.294040649
* device instance vss_t185 r0 *1 0,0
Rvss_t185 vss__t185 vss 41.3433103192
* device instance vss_t186 r0 *1 0,0
Rvss_t186 vss__t186 vss 53.8832881561
* device instance vss_t187 r0 *1 0,0
Rvss_t187 vss__t187 vss 84.3908396434
* device instance vss_t188 r0 *1 0,0
Rvss_t188 vss__t188 vss 95.9469909804
* device instance vss_t189 r0 *1 0,0
Rvss_t189 vss__t189 vss 107.522583196
* device instance vss_t190 r0 *1 0,0
Rvss_t190 vss__t190 vss 119.111948488
* device instance vss_t191 r0 *1 0,0
Rvss_t191 vss__t191 vss 131.967640458
* device instance vss_t192 r0 *1 0,0
Rvss_t192 vss__t192 vss 173.407427918
* device instance vss_t193 r0 *1 0,0
Rvss_t193 vss__t193 vss 148.190798106
* device instance vss_t194 r0 *1 0,0
Rvss_t194 vss__t194 vss 133.33610751
* device instance vss_t195 r0 *1 0,0
Rvss_t195 vss__t195 vss 108.655926265
* device instance vss_t196 r0 *1 0,0
Rvss_t196 vss__t196 vss 94.3054077082
* device instance vss_t197 r0 *1 0,0
Rvss_t197 vss__t197 vss 71.1218590148
* device instance vss_t198 r0 *1 0,0
Rvss_t198 vss__t198 vss 169.681619998
* device instance vss_t199 r0 *1 0,0
Rvss_t199 vss__t199 vss 156.463861482
* device instance vss_t200 r0 *1 0,0
Rvss_t200 vss__t200 vss 144.849728836
* device instance vss_t201 r0 *1 0,0
Rvss_t201 vss__t201 vss 133.241200439
* device instance vss_t202 r0 *1 0,0
Rvss_t202 vss__t202 vss 121.639880801
* device instance vss_t203 r0 *1 0,0
Rvss_t203 vss__t203 vss 91.2187892815
* device instance vss_t204 r0 *1 0,0
Rvss_t204 vss__t204 vss 78.0864237626
* device instance vss_t205 r0 *1 0,0
Rvss_t205 vss__t205 vss 66.5808045619
* device instance vss_t206 r0 *1 0,0
Rvss_t206 vss__t206 vss 55.1342638717
* device instance vss_t207 r0 *1 0,0
Rvss_t207 vss__t207 vss 43.7931515845
* device instance vss_t208 r0 *1 0,0
Rvss_t208 vss__t208 vss 16.2128185547
* device instance vss_t209 r0 *1 0,0
Rvss_t209 vss__t209 vss 11.2699519482
* device instance vss_t210 r0 *1 0,0
Rvss_t210 vss__t210 vss 17.2492244206
* device instance vss_t211 r0 *1 0,0
Rvss_t211 vss__t211 vss 27.190609147
* device instance vss_t212 r0 *1 0,0
Rvss_t212 vss__t212 vss 38.1102645613
* device instance vss_t213 r0 *1 0,0
Rvss_t213 vss__t213 vss 67.9545146977
* device instance vss_t214 r0 *1 0,0
Rvss_t214 vss__t214 vss 81.0524933152
* device instance vss_t215 r0 *1 0,0
Rvss_t215 vss__t215 vss 92.601514917
* device instance vss_t216 r0 *1 0,0
Rvss_t216 vss__t216 vss 104.172184453
* device instance vss_t217 r0 *1 0,0
Rvss_t217 vss__t217 vss 115.758010604
* device instance vss r0 *1 0,0
Cvss vss vsubs 1.79269212e-13
* device instance cc_a_b_b3_invb_a_mn12_g1_mp24_g0_t2_y_a_d_inva_a_mn12_g0_mp13_g0_ro3_ro3_esc_e_ro3_esc_w_ro3_hop_sr3_d_stub_tg_d_a_y r0 *1 0,0
Ccc_a_b_b3_invb_a_mn12_g1_mp24_g0_t2_y_a_d_inva_a_mn12_g0_mp13_g0_ro3_ro3_esc_e_ro3_esc_w_ro3_hop_sr3_d_stub_tg_d_a_y
+ a|b|b3|invb_a|mn12_g1|mp24_g0|t2|y
+ a|d|inva_a|mn12_g0|mp13_g0|ro3|ro3_esc_e|ro3_esc_w|ro3_hop|sr3_d_stub|tg_d_a|y
+ 3.3e-18
* device instance cc_a_b_b3_invb_a_mn12_g1_mp24_g0_t2_y_a_d_sb_d_stub_tg_d_a_xo_xo_dip_xo_hop_xo_stub_y r0 *1 0,0
Ccc_a_b_b3_invb_a_mn12_g1_mp24_g0_t2_y_a_d_sb_d_stub_tg_d_a_xo_xo_dip_xo_hop_xo_stub_y
+ a|b|b3|invb_a|mn12_g1|mp24_g0|t2|y
+ a|d|sb_d_stub|tg_d_a|xo|xo_dip|xo_hop|xo_stub|y 3.869e-18
* device instance cc_a_b_b3_invb_a_mn12_g1_mp24_g0_t2_y_a_inva_a_mn12_g0_mp13_g0_t1_y r0 *1 0,0
Ccc_a_b_b3_invb_a_mn12_g1_mp24_g0_t2_y_a_inva_a_mn12_g0_mp13_g0_t1_y
+ a|b|b3|invb_a|mn12_g1|mp24_g0|t2|y a|inva_a|mn12_g0|mp13_g0|t1|y 3.869e-18
* device instance cc_a_b_b3_invb_a_mn12_g1_mp24_g0_t2_y_an_inva_y_mn34_g0_mp13_g1_y r0 *1 0,0
Ccc_a_b_b3_invb_a_mn12_g1_mp24_g0_t2_y_an_inva_y_mn34_g0_mp13_g1_y
+ a|b|b3|invb_a|mn12_g1|mp24_g0|t2|y an|inva_y|mn34_g0|mp13_g1|y$2 3.3e-18
* device instance cc_a_b_b3_invb_a_mn12_g1_mp24_g0_t2_y_bn_invb_y_mn34_g1_mp24_g1_y r0 *1 0,0
Ccc_a_b_b3_invb_a_mn12_g1_mp24_g0_t2_y_bn_invb_y_mn34_g1_mp24_g1_y
+ a|b|b3|invb_a|mn12_g1|mp24_g0|t2|y bn|invb_y|mn34_g1|mp24_g1|y$2 1.377e-17
* device instance cc_a_b_b3_invb_a_mn12_g1_mp24_g0_t2_y_mid r0 *1 0,0
Ccc_a_b_b3_invb_a_mn12_g1_mp24_g0_t2_y_mid a|b|b3|invb_a|mn12_g1|mp24_g0|t2|y
+ mid$2 8.154e-18
* device instance cc_a_b_d_invb_a_mn12_g1_mp24_g0_ro2_ro2_esc_sr2_d_stub_tg_d_a_y_a_b_m_east_m_west_nand_m_a_nand_m_a_ext_via_nand_m_a_ext_via2_nand_m_a_stub_tg_d_b_tg_d_b_via_tg_d_b_via2_tg_fbm_b_tg_fbm_b_alt_via_tg_fbm_b_alt_via2 r0 *1 0,0
Ccc_a_b_d_invb_a_mn12_g1_mp24_g0_ro2_ro2_esc_sr2_d_stub_tg_d_a_y_a_b_m_east_m_west_nand_m_a_nand_m_a_ext_via_nand_m_a_ext_via2_nand_m_a_stub_tg_d_b_tg_d_b_via_tg_d_b_via2_tg_fbm_b_tg_fbm_b_alt_via_tg_fbm_b_alt_via2
+ a|b|d|invb_a|mn12_g1|mp24_g0|ro2|ro2_esc|sr2_d_stub|tg_d_a|y
+ a|b|m_east|m_west|nand_m_a|nand_m_a_ext_via|nand_m_a_ext_via2|nand_m_a_stub|tg_d_b|tg_d_b_via|tg_d_b_via2|tg_fbm_b|tg_fbm_b_alt_via|tg_fbm_b_alt_via2$5
+ 3.869e-18
* device instance cc_a_b_d_invb_a_mn12_g1_mp24_g0_ro2_ro2_esc_sr2_d_stub_tg_d_a_y_a_d_inva_a_mn12_g0_mp13_g0_ro1_ro1_esc_sr1_d_stub_tg_d_a_y r0 *1 0,0
Ccc_a_b_d_invb_a_mn12_g1_mp24_g0_ro2_ro2_esc_sr2_d_stub_tg_d_a_y_a_d_inva_a_mn12_g0_mp13_g0_ro1_ro1_esc_sr1_d_stub_tg_d_a_y
+ a|b|d|invb_a|mn12_g1|mp24_g0|ro2|ro2_esc|sr2_d_stub|tg_d_a|y
+ a|d|inva_a|mn12_g0|mp13_g0|ro1|ro1_esc|sr1_d_stub|tg_d_a|y 3.869e-18
* device instance cc_a_b_d_invb_a_mn12_g1_mp24_g0_ro2_ro2_esc_sr2_d_stub_tg_d_a_y_a_d_inva_a_mn12_g0_mp13_g0_ro3_ro3_esc_e_ro3_esc_w_ro3_hop_sr3_d_stub_tg_d_a_y r0 *1 0,0
Ccc_a_b_d_invb_a_mn12_g1_mp24_g0_ro2_ro2_esc_sr2_d_stub_tg_d_a_y_a_d_inva_a_mn12_g0_mp13_g0_ro3_ro3_esc_e_ro3_esc_w_ro3_hop_sr3_d_stub_tg_d_a_y
+ a|b|d|invb_a|mn12_g1|mp24_g0|ro2|ro2_esc|sr2_d_stub|tg_d_a|y
+ a|d|inva_a|mn12_g0|mp13_g0|ro3|ro3_esc_e|ro3_esc_w|ro3_hop|sr3_d_stub|tg_d_a|y
+ 7.737e-18
* device instance cc_a_b_d_invb_a_mn12_g1_mp24_g0_ro2_ro2_esc_sr2_d_stub_tg_d_a_y_clkb_clkb_bridge1_clkb_bridge2_clkb_mid_clkb_w_ctrl_ctrlb_inv_clk_y_tg_d_ctrlb_tg_fbm_ctrl_tg_fbs_ctrlb_tg_s_ctrl_y r0 *1 0,0
Ccc_a_b_d_invb_a_mn12_g1_mp24_g0_ro2_ro2_esc_sr2_d_stub_tg_d_a_y_clkb_clkb_bridge1_clkb_bridge2_clkb_mid_clkb_w_ctrl_ctrlb_inv_clk_y_tg_d_ctrlb_tg_fbm_ctrl_tg_fbs_ctrlb_tg_s_ctrl_y
+ a|b|d|invb_a|mn12_g1|mp24_g0|ro2|ro2_esc|sr2_d_stub|tg_d_a|y
+ clkb|clkb_bridge1|clkb_bridge2|clkb_mid|clkb_w|ctrl|ctrlb|inv_clk_y|tg_d_ctrlb|tg_fbm_ctrl|tg_fbs_ctrlb|tg_s_ctrl|y$5
+ 8.337e-18
* device instance cc_a_b_d_invb_a_mn12_g1_mp24_g0_ro2_ro2_esc_sr2_d_stub_tg_d_a_y_rst_n r0 *1 0,0
Ccc_a_b_d_invb_a_mn12_g1_mp24_g0_ro2_ro2_esc_sr2_d_stub_tg_d_a_y_rst_n
+ a|b|d|invb_a|mn12_g1|mp24_g0|ro2|ro2_esc|sr2_d_stub|tg_d_a|y rst_n 3.869e-18
* device instance cc_a_b_d_invb_a_mn12_g1_mp24_g0_ro2_ro2_esc_sr2_d_stub_tg_d_a_y_vdd r0 *1 0,0
Ccc_a_b_d_invb_a_mn12_g1_mp24_g0_ro2_ro2_esc_sr2_d_stub_tg_d_a_y_vdd
+ a|b|d|invb_a|mn12_g1|mp24_g0|ro2|ro2_esc|sr2_d_stub|tg_d_a|y vdd 2.2984e-17
* device instance cc_a_b_d_invb_a_mn12_g1_mp24_g0_ro2_ro2_esc_sr2_d_stub_tg_d_a_y_vddr1 r0 *1 0,0
Ccc_a_b_d_invb_a_mn12_g1_mp24_g0_ro2_ro2_esc_sr2_d_stub_tg_d_a_y_vddr1
+ a|b|d|invb_a|mn12_g1|mp24_g0|ro2|ro2_esc|sr2_d_stub|tg_d_a|y vddr1 1.6358e-17
* device instance cc_a_b_d_invb_a_mn12_g1_mp24_g0_ro2_ro2_esc_sr2_d_stub_tg_d_a_y_vss r0 *1 0,0
Ccc_a_b_d_invb_a_mn12_g1_mp24_g0_ro2_ro2_esc_sr2_d_stub_tg_d_a_y_vss
+ a|b|d|invb_a|mn12_g1|mp24_g0|ro2|ro2_esc|sr2_d_stub|tg_d_a|y vss 4.5279e-17
* device instance cc_a_b_d_invb_a_mn12_g1_mp24_g0_ro4_ro4_esc_sr4_d_stub_tg_d_a_y_a_b_m_east_m_west_nand_m_a_nand_m_a_ext_via_nand_m_a_ext_via2_nand_m_a_stub_tg_d_b_tg_d_b_via_tg_d_b_via2_tg_fbm_b_tg_fbm_b_alt_via_tg_fbm_b_alt_via2 r0 *1 0,0
Ccc_a_b_d_invb_a_mn12_g1_mp24_g0_ro4_ro4_esc_sr4_d_stub_tg_d_a_y_a_b_m_east_m_west_nand_m_a_nand_m_a_ext_via_nand_m_a_ext_via2_nand_m_a_stub_tg_d_b_tg_d_b_via_tg_d_b_via2_tg_fbm_b_tg_fbm_b_alt_via_tg_fbm_b_alt_via2
+ a|b|d|invb_a|mn12_g1|mp24_g0|ro4|ro4_esc|sr4_d_stub|tg_d_a|y
+ a|b|m_east|m_west|nand_m_a|nand_m_a_ext_via|nand_m_a_ext_via2|nand_m_a_stub|tg_d_b|tg_d_b_via|tg_d_b_via2|tg_fbm_b|tg_fbm_b_alt_via|tg_fbm_b_alt_via2$5
+ 3.869e-18
* device instance cc_a_b_d_invb_a_mn12_g1_mp24_g0_ro4_ro4_esc_sr4_d_stub_tg_d_a_y_clkb_clkb_bridge1_clkb_bridge2_clkb_mid_clkb_w_ctrl_ctrlb_inv_clk_y_tg_d_ctrlb_tg_fbm_ctrl_tg_fbs_ctrlb_tg_s_ctrl_y r0 *1 0,0
Ccc_a_b_d_invb_a_mn12_g1_mp24_g0_ro4_ro4_esc_sr4_d_stub_tg_d_a_y_clkb_clkb_bridge1_clkb_bridge2_clkb_mid_clkb_w_ctrl_ctrlb_inv_clk_y_tg_d_ctrlb_tg_fbm_ctrl_tg_fbs_ctrlb_tg_s_ctrl_y
+ a|b|d|invb_a|mn12_g1|mp24_g0|ro4|ro4_esc|sr4_d_stub|tg_d_a|y
+ clkb|clkb_bridge1|clkb_bridge2|clkb_mid|clkb_w|ctrl|ctrlb|inv_clk_y|tg_d_ctrlb|tg_fbm_ctrl|tg_fbs_ctrlb|tg_s_ctrl|y$5
+ 8.337e-18
* device instance cc_a_b_d_invb_a_mn12_g1_mp24_g0_ro4_ro4_esc_sr4_d_stub_tg_d_a_y_rst_n r0 *1 0,0
Ccc_a_b_d_invb_a_mn12_g1_mp24_g0_ro4_ro4_esc_sr4_d_stub_tg_d_a_y_rst_n
+ a|b|d|invb_a|mn12_g1|mp24_g0|ro4|ro4_esc|sr4_d_stub|tg_d_a|y rst_n 3.869e-18
* device instance cc_a_b_d_invb_a_mn12_g1_mp24_g0_ro4_ro4_esc_sr4_d_stub_tg_d_a_y_vdd r0 *1 0,0
Ccc_a_b_d_invb_a_mn12_g1_mp24_g0_ro4_ro4_esc_sr4_d_stub_tg_d_a_y_vdd
+ a|b|d|invb_a|mn12_g1|mp24_g0|ro4|ro4_esc|sr4_d_stub|tg_d_a|y vdd 1.3426e-17
* device instance cc_a_b_d_invb_a_mn12_g1_mp24_g0_ro4_ro4_esc_sr4_d_stub_tg_d_a_y_vss r0 *1 0,0
Ccc_a_b_d_invb_a_mn12_g1_mp24_g0_ro4_ro4_esc_sr4_d_stub_tg_d_a_y_vss
+ a|b|d|invb_a|mn12_g1|mp24_g0|ro4|ro4_esc|sr4_d_stub|tg_d_a|y vss 7.3577e-17
* device instance cc_a_b_inv_q_a_inv_q_a_via_s_tg_fbs_b_tg_fbs_b_via_tg_s_b_tg_s_b_via_a_inv_mc_a_mb_mnab_y_mpa_y_mpb_y_nand_m_y_tg_s_a_y r0 *1 0,0
Ccc_a_b_inv_q_a_inv_q_a_via_s_tg_fbs_b_tg_fbs_b_via_tg_s_b_tg_s_b_via_a_inv_mc_a_mb_mnab_y_mpa_y_mpb_y_nand_m_y_tg_s_a_y
+ a|b|inv_q_a|inv_q_a_via|s|tg_fbs_b|tg_fbs_b_via|tg_s_b|tg_s_b_via$5
+ a|inv_mc_a|mb|mnab_y|mpa_y|mpb_y|nand_m_y|tg_s_a|y$5 9.1937e-17
* device instance cc_a_b_inv_q_a_inv_q_a_via_s_tg_fbs_b_tg_fbs_b_via_tg_s_b_tg_s_b_via_a_mnab_y_mpa_y_mpb_y_nand_s2_y_qb_tg_fbs_a_y r0 *1 0,0
Ccc_a_b_inv_q_a_inv_q_a_via_s_tg_fbs_b_tg_fbs_b_via_tg_s_b_tg_s_b_via_a_mnab_y_mpa_y_mpb_y_nand_s2_y_qb_tg_fbs_a_y
+ a|b|inv_q_a|inv_q_a_via|s|tg_fbs_b|tg_fbs_b_via|tg_s_b|tg_s_b_via$5
+ a|mnab_y|mpa_y|mpb_y|nand_s2_y|qb|tg_fbs_a|y$5 2.00754e-16
* device instance cc_a_b_inv_q_a_inv_q_a_via_s_tg_fbs_b_tg_fbs_b_via_tg_s_b_tg_s_b_via_clkb_clkb_bridge1_clkb_bridge2_clkb_mid_clkb_w_ctrl_ctrlb_inv_clk_y_tg_d_ctrlb_tg_fbm_ctrl_tg_fbs_ctrlb_tg_s_ctrl_y r0 *1 0,0
Ccc_a_b_inv_q_a_inv_q_a_via_s_tg_fbs_b_tg_fbs_b_via_tg_s_b_tg_s_b_via_clkb_clkb_bridge1_clkb_bridge2_clkb_mid_clkb_w_ctrl_ctrlb_inv_clk_y_tg_d_ctrlb_tg_fbm_ctrl_tg_fbs_ctrlb_tg_s_ctrl_y
+ a|b|inv_q_a|inv_q_a_via|s|tg_fbs_b|tg_fbs_b_via|tg_s_b|tg_s_b_via$5
+ clkb|clkb_bridge1|clkb_bridge2|clkb_mid|clkb_w|ctrl|ctrlb|inv_clk_y|tg_d_ctrlb|tg_fbm_ctrl|tg_fbs_ctrlb|tg_s_ctrl|y$5
+ 9.3033e-17
* device instance cc_a_b_m_east_m_west_nand_m_a_nand_m_a_ext_via_nand_m_a_ext_via2_nand_m_a_stub_tg_d_b_tg_d_b_via_tg_d_b_via2_tg_fbm_b_tg_fbm_b_alt_via_tg_fbm_b_alt_via2_a_d_inva_a_mn12_g0_mp13_g0_ro1_ro1_esc_sr1_d_stub_tg_d_a_y r0 *1 0,0
Ccc_a_b_m_east_m_west_nand_m_a_nand_m_a_ext_via_nand_m_a_ext_via2_nand_m_a_stub_tg_d_b_tg_d_b_via_tg_d_b_via2_tg_fbm_b_tg_fbm_b_alt_via_tg_fbm_b_alt_via2_a_d_inva_a_mn12_g0_mp13_g0_ro1_ro1_esc_sr1_d_stub_tg_d_a_y
+ a|b|m_east|m_west|nand_m_a|nand_m_a_ext_via|nand_m_a_ext_via2|nand_m_a_stub|tg_d_b|tg_d_b_via|tg_d_b_via2|tg_fbm_b|tg_fbm_b_alt_via|tg_fbm_b_alt_via2$5
+ a|d|inva_a|mn12_g0|mp13_g0|ro1|ro1_esc|sr1_d_stub|tg_d_a|y 3.869e-18
* device instance cc_a_b_m_east_m_west_nand_m_a_nand_m_a_ext_via_nand_m_a_ext_via2_nand_m_a_stub_tg_d_b_tg_d_b_via_tg_d_b_via2_tg_fbm_b_tg_fbm_b_alt_via_tg_fbm_b_alt_via2_a_d_inva_a_mn12_g0_mp13_g0_ro3_ro3_esc_e_ro3_esc_w_ro3_hop_sr3_d_stub_tg_d_a_y r0 *1 0,0
Ccc_a_b_m_east_m_west_nand_m_a_nand_m_a_ext_via_nand_m_a_ext_via2_nand_m_a_stub_tg_d_b_tg_d_b_via_tg_d_b_via2_tg_fbm_b_tg_fbm_b_alt_via_tg_fbm_b_alt_via2_a_d_inva_a_mn12_g0_mp13_g0_ro3_ro3_esc_e_ro3_esc_w_ro3_hop_sr3_d_stub_tg_d_a_y
+ a|b|m_east|m_west|nand_m_a|nand_m_a_ext_via|nand_m_a_ext_via2|nand_m_a_stub|tg_d_b|tg_d_b_via|tg_d_b_via2|tg_fbm_b|tg_fbm_b_alt_via|tg_fbm_b_alt_via2$5
+ a|d|inva_a|mn12_g0|mp13_g0|ro3|ro3_esc_e|ro3_esc_w|ro3_hop|sr3_d_stub|tg_d_a|y
+ 3.869e-18
* device instance cc_a_b_m_east_m_west_nand_m_a_nand_m_a_ext_via_nand_m_a_ext_via2_nand_m_a_stub_tg_d_b_tg_d_b_via_tg_d_b_via2_tg_fbm_b_tg_fbm_b_alt_via_tg_fbm_b_alt_via2_a_d_sb_d_stub_tg_d_a_xo_xo_dip_xo_hop_xo_stub_y r0 *1 0,0
Ccc_a_b_m_east_m_west_nand_m_a_nand_m_a_ext_via_nand_m_a_ext_via2_nand_m_a_stub_tg_d_b_tg_d_b_via_tg_d_b_via2_tg_fbm_b_tg_fbm_b_alt_via_tg_fbm_b_alt_via2_a_d_sb_d_stub_tg_d_a_xo_xo_dip_xo_hop_xo_stub_y
+ a|b|m_east|m_west|nand_m_a|nand_m_a_ext_via|nand_m_a_ext_via2|nand_m_a_stub|tg_d_b|tg_d_b_via|tg_d_b_via2|tg_fbm_b|tg_fbm_b_alt_via|tg_fbm_b_alt_via2$5
+ a|d|sb_d_stub|tg_d_a|xo|xo_dip|xo_hop|xo_stub|y 3.869e-18
* device instance cc_a_b_m_east_m_west_nand_m_a_nand_m_a_ext_via_nand_m_a_ext_via2_nand_m_a_stub_tg_d_b_tg_d_b_via_tg_d_b_via2_tg_fbm_b_tg_fbm_b_alt_via_tg_fbm_b_alt_via2_a_inv_mc_a_mb_mnab_y_mpa_y_mpb_y_nand_m_y_tg_s_a_y r0 *1 0,0
Ccc_a_b_m_east_m_west_nand_m_a_nand_m_a_ext_via_nand_m_a_ext_via2_nand_m_a_stub_tg_d_b_tg_d_b_via_tg_d_b_via2_tg_fbm_b_tg_fbm_b_alt_via_tg_fbm_b_alt_via2_a_inv_mc_a_mb_mnab_y_mpa_y_mpb_y_nand_m_y_tg_s_a_y
+ a|b|m_east|m_west|nand_m_a|nand_m_a_ext_via|nand_m_a_ext_via2|nand_m_a_stub|tg_d_b|tg_d_b_via|tg_d_b_via2|tg_fbm_b|tg_fbm_b_alt_via|tg_fbm_b_alt_via2$5
+ a|inv_mc_a|mb|mnab_y|mpa_y|mpb_y|nand_m_y|tg_s_a|y$5 2.11008e-16
* device instance cc_a_b_m_east_m_west_nand_m_a_nand_m_a_ext_via_nand_m_a_ext_via2_nand_m_a_stub_tg_d_b_tg_d_b_via_tg_d_b_via2_tg_fbm_b_tg_fbm_b_alt_via_tg_fbm_b_alt_via2_clkb_clkb_bridge1_clkb_bridge2_clkb_mid_clkb_w_ctrl_ctrlb_inv_clk_y_tg_d_ctrlb_tg_fbm_ctrl_tg_fbs_ctrlb_tg_s_ctrl_y r0 *1 0,0
Ccc_a_b_m_east_m_west_nand_m_a_nand_m_a_ext_via_nand_m_a_ext_via2_nand_m_a_stub_tg_d_b_tg_d_b_via_tg_d_b_via2_tg_fbm_b_tg_fbm_b_alt_via_tg_fbm_b_alt_via2_clkb_clkb_bridge1_clkb_bridge2_clkb_mid_clkb_w_ctrl_ctrlb_inv_clk_y_tg_d_ctrlb_tg_fbm_ctrl_tg_fbs_ctrlb_tg_s_ctrl_y
+ a|b|m_east|m_west|nand_m_a|nand_m_a_ext_via|nand_m_a_ext_via2|nand_m_a_stub|tg_d_b|tg_d_b_via|tg_d_b_via2|tg_fbm_b|tg_fbm_b_alt_via|tg_fbm_b_alt_via2$5
+ clkb|clkb_bridge1|clkb_bridge2|clkb_mid|clkb_w|ctrl|ctrlb|inv_clk_y|tg_d_ctrlb|tg_fbm_ctrl|tg_fbs_ctrlb|tg_s_ctrl|y$5
+ 1.00039e-16
* device instance cc_a_b_m_east_m_west_nand_m_a_nand_m_a_ext_via_nand_m_a_ext_via2_nand_m_a_stub_tg_d_b_tg_d_b_via_tg_d_b_via2_tg_fbm_b_tg_fbm_b_alt_via_tg_fbm_b_alt_via2_vdd r0 *1 0,0
Ccc_a_b_m_east_m_west_nand_m_a_nand_m_a_ext_via_nand_m_a_ext_via2_nand_m_a_stub_tg_d_b_tg_d_b_via_tg_d_b_via2_tg_fbm_b_tg_fbm_b_alt_via_tg_fbm_b_alt_via2_vdd
+ a|b|m_east|m_west|nand_m_a|nand_m_a_ext_via|nand_m_a_ext_via2|nand_m_a_stub|tg_d_b|tg_d_b_via|tg_d_b_via2|tg_fbm_b|tg_fbm_b_alt_via|tg_fbm_b_alt_via2$5
+ vdd 3.869e-18
* device instance cc_a_d_inva_a_mn12_g0_mp13_g0_ro1_ro1_esc_sr1_d_stub_tg_d_a_y_a_d_inva_a_mn12_g0_mp13_g0_ro3_ro3_esc_e_ro3_esc_w_ro3_hop_sr3_d_stub_tg_d_a_y r0 *1 0,0
Ccc_a_d_inva_a_mn12_g0_mp13_g0_ro1_ro1_esc_sr1_d_stub_tg_d_a_y_a_d_inva_a_mn12_g0_mp13_g0_ro3_ro3_esc_e_ro3_esc_w_ro3_hop_sr3_d_stub_tg_d_a_y
+ a|d|inva_a|mn12_g0|mp13_g0|ro1|ro1_esc|sr1_d_stub|tg_d_a|y
+ a|d|inva_a|mn12_g0|mp13_g0|ro3|ro3_esc_e|ro3_esc_w|ro3_hop|sr3_d_stub|tg_d_a|y
+ 3.869e-18
* device instance cc_a_d_inva_a_mn12_g0_mp13_g0_ro1_ro1_esc_sr1_d_stub_tg_d_a_y_a_inva_a_mn12_g0_mp13_g0_t1_y r0 *1 0,0
Ccc_a_d_inva_a_mn12_g0_mp13_g0_ro1_ro1_esc_sr1_d_stub_tg_d_a_y_a_inva_a_mn12_g0_mp13_g0_t1_y
+ a|d|inva_a|mn12_g0|mp13_g0|ro1|ro1_esc|sr1_d_stub|tg_d_a|y
+ a|inva_a|mn12_g0|mp13_g0|t1|y 3.3e-18
* device instance cc_a_d_inva_a_mn12_g0_mp13_g0_ro1_ro1_esc_sr1_d_stub_tg_d_a_y_clkb_clkb_bridge1_clkb_bridge2_clkb_mid_clkb_w_ctrl_ctrlb_inv_clk_y_tg_d_ctrlb_tg_fbm_ctrl_tg_fbs_ctrlb_tg_s_ctrl_y r0 *1 0,0
Ccc_a_d_inva_a_mn12_g0_mp13_g0_ro1_ro1_esc_sr1_d_stub_tg_d_a_y_clkb_clkb_bridge1_clkb_bridge2_clkb_mid_clkb_w_ctrl_ctrlb_inv_clk_y_tg_d_ctrlb_tg_fbm_ctrl_tg_fbs_ctrlb_tg_s_ctrl_y
+ a|d|inva_a|mn12_g0|mp13_g0|ro1|ro1_esc|sr1_d_stub|tg_d_a|y
+ clkb|clkb_bridge1|clkb_bridge2|clkb_mid|clkb_w|ctrl|ctrlb|inv_clk_y|tg_d_ctrlb|tg_fbm_ctrl|tg_fbs_ctrlb|tg_s_ctrl|y$5
+ 8.337e-18
* device instance cc_a_d_inva_a_mn12_g0_mp13_g0_ro1_ro1_esc_sr1_d_stub_tg_d_a_y_rst_n r0 *1 0,0
Ccc_a_d_inva_a_mn12_g0_mp13_g0_ro1_ro1_esc_sr1_d_stub_tg_d_a_y_rst_n
+ a|d|inva_a|mn12_g0|mp13_g0|ro1|ro1_esc|sr1_d_stub|tg_d_a|y rst_n 3.869e-18
* device instance cc_a_d_inva_a_mn12_g0_mp13_g0_ro1_ro1_esc_sr1_d_stub_tg_d_a_y_vdd r0 *1 0,0
Ccc_a_d_inva_a_mn12_g0_mp13_g0_ro1_ro1_esc_sr1_d_stub_tg_d_a_y_vdd
+ a|d|inva_a|mn12_g0|mp13_g0|ro1|ro1_esc|sr1_d_stub|tg_d_a|y vdd 4.5399e-17
* device instance cc_a_d_inva_a_mn12_g0_mp13_g0_ro1_ro1_esc_sr1_d_stub_tg_d_a_y_vss r0 *1 0,0
Ccc_a_d_inva_a_mn12_g0_mp13_g0_ro1_ro1_esc_sr1_d_stub_tg_d_a_y_vss
+ a|d|inva_a|mn12_g0|mp13_g0|ro1|ro1_esc|sr1_d_stub|tg_d_a|y vss 6.601e-18
* device instance cc_a_d_inva_a_mn12_g0_mp13_g0_ro3_ro3_esc_e_ro3_esc_w_ro3_hop_sr3_d_stub_tg_d_a_y_clkb_clkb_bridge1_clkb_bridge2_clkb_mid_clkb_w_ctrl_ctrlb_inv_clk_y_tg_d_ctrlb_tg_fbm_ctrl_tg_fbs_ctrlb_tg_s_ctrl_y r0 *1 0,0
Ccc_a_d_inva_a_mn12_g0_mp13_g0_ro3_ro3_esc_e_ro3_esc_w_ro3_hop_sr3_d_stub_tg_d_a_y_clkb_clkb_bridge1_clkb_bridge2_clkb_mid_clkb_w_ctrl_ctrlb_inv_clk_y_tg_d_ctrlb_tg_fbm_ctrl_tg_fbs_ctrlb_tg_s_ctrl_y
+ a|d|inva_a|mn12_g0|mp13_g0|ro3|ro3_esc_e|ro3_esc_w|ro3_hop|sr3_d_stub|tg_d_a|y
+ clkb|clkb_bridge1|clkb_bridge2|clkb_mid|clkb_w|ctrl|ctrlb|inv_clk_y|tg_d_ctrlb|tg_fbm_ctrl|tg_fbs_ctrlb|tg_s_ctrl|y$5
+ 8.337e-18
* device instance cc_a_d_inva_a_mn12_g0_mp13_g0_ro3_ro3_esc_e_ro3_esc_w_ro3_hop_sr3_d_stub_tg_d_a_y_rst_n r0 *1 0,0
Ccc_a_d_inva_a_mn12_g0_mp13_g0_ro3_ro3_esc_e_ro3_esc_w_ro3_hop_sr3_d_stub_tg_d_a_y_rst_n
+ a|d|inva_a|mn12_g0|mp13_g0|ro3|ro3_esc_e|ro3_esc_w|ro3_hop|sr3_d_stub|tg_d_a|y
+ rst_n 3.869e-18
* device instance cc_a_d_inva_a_mn12_g0_mp13_g0_ro3_ro3_esc_e_ro3_esc_w_ro3_hop_sr3_d_stub_tg_d_a_y_vdd r0 *1 0,0
Ccc_a_d_inva_a_mn12_g0_mp13_g0_ro3_ro3_esc_e_ro3_esc_w_ro3_hop_sr3_d_stub_tg_d_a_y_vdd
+ a|d|inva_a|mn12_g0|mp13_g0|ro3|ro3_esc_e|ro3_esc_w|ro3_hop|sr3_d_stub|tg_d_a|y
+ vdd 4.9268e-17
* device instance cc_a_d_inva_a_mn12_g0_mp13_g0_ro3_ro3_esc_e_ro3_esc_w_ro3_hop_sr3_d_stub_tg_d_a_y_vddr1 r0 *1 0,0
Ccc_a_d_inva_a_mn12_g0_mp13_g0_ro3_ro3_esc_e_ro3_esc_w_ro3_hop_sr3_d_stub_tg_d_a_y_vddr1
+ a|d|inva_a|mn12_g0|mp13_g0|ro3|ro3_esc_e|ro3_esc_w|ro3_hop|sr3_d_stub|tg_d_a|y
+ vddr1 3.869e-18
* device instance cc_a_d_inva_a_mn12_g0_mp13_g0_ro3_ro3_esc_e_ro3_esc_w_ro3_hop_sr3_d_stub_tg_d_a_y_vss r0 *1 0,0
Ccc_a_d_inva_a_mn12_g0_mp13_g0_ro3_ro3_esc_e_ro3_esc_w_ro3_hop_sr3_d_stub_tg_d_a_y_vss
+ a|d|inva_a|mn12_g0|mp13_g0|ro3|ro3_esc_e|ro3_esc_w|ro3_hop|sr3_d_stub|tg_d_a|y
+ vss 2.3895e-17
* device instance cc_a_d_sb_d_stub_tg_d_a_xo_xo_dip_xo_hop_xo_stub_y_a_inva_a_mn12_g0_mp13_g0_t1_y r0 *1 0,0
Ccc_a_d_sb_d_stub_tg_d_a_xo_xo_dip_xo_hop_xo_stub_y_a_inva_a_mn12_g0_mp13_g0_t1_y
+ a|d|sb_d_stub|tg_d_a|xo|xo_dip|xo_hop|xo_stub|y a|inva_a|mn12_g0|mp13_g0|t1|y
+ 1.1037e-17
* device instance cc_a_d_sb_d_stub_tg_d_a_xo_xo_dip_xo_hop_xo_stub_y_an_inva_y_mn34_g0_mp13_g1_y r0 *1 0,0
Ccc_a_d_sb_d_stub_tg_d_a_xo_xo_dip_xo_hop_xo_stub_y_an_inva_y_mn34_g0_mp13_g1_y
+ a|d|sb_d_stub|tg_d_a|xo|xo_dip|xo_hop|xo_stub|y an|inva_y|mn34_g0|mp13_g1|y$2
+ 3.3e-18
* device instance cc_a_d_sb_d_stub_tg_d_a_xo_xo_dip_xo_hop_xo_stub_y_bn_invb_y_mn34_g1_mp24_g1_y r0 *1 0,0
Ccc_a_d_sb_d_stub_tg_d_a_xo_xo_dip_xo_hop_xo_stub_y_bn_invb_y_mn34_g1_mp24_g1_y
+ a|d|sb_d_stub|tg_d_a|xo|xo_dip|xo_hop|xo_stub|y bn|invb_y|mn34_g1|mp24_g1|y$2
+ 9.901e-18
* device instance cc_a_d_sb_d_stub_tg_d_a_xo_xo_dip_xo_hop_xo_stub_y_clkb_clkb_bridge1_clkb_bridge2_clkb_mid_clkb_w_ctrl_ctrlb_inv_clk_y_tg_d_ctrlb_tg_fbm_ctrl_tg_fbs_ctrlb_tg_s_ctrl_y r0 *1 0,0
Ccc_a_d_sb_d_stub_tg_d_a_xo_xo_dip_xo_hop_xo_stub_y_clkb_clkb_bridge1_clkb_bridge2_clkb_mid_clkb_w_ctrl_ctrlb_inv_clk_y_tg_d_ctrlb_tg_fbm_ctrl_tg_fbs_ctrlb_tg_s_ctrl_y
+ a|d|sb_d_stub|tg_d_a|xo|xo_dip|xo_hop|xo_stub|y
+ clkb|clkb_bridge1|clkb_bridge2|clkb_mid|clkb_w|ctrl|ctrlb|inv_clk_y|tg_d_ctrlb|tg_fbm_ctrl|tg_fbs_ctrlb|tg_s_ctrl|y$5
+ 8.337e-18
* device instance cc_a_d_sb_d_stub_tg_d_a_xo_xo_dip_xo_hop_xo_stub_y_mid r0 *1 0,0
Ccc_a_d_sb_d_stub_tg_d_a_xo_xo_dip_xo_hop_xo_stub_y_mid
+ a|d|sb_d_stub|tg_d_a|xo|xo_dip|xo_hop|xo_stub|y mid$2 8.154e-18
* device instance cc_a_d_sb_d_stub_tg_d_a_xo_xo_dip_xo_hop_xo_stub_y_vdd r0 *1 0,0
Ccc_a_d_sb_d_stub_tg_d_a_xo_xo_dip_xo_hop_xo_stub_y_vdd
+ a|d|sb_d_stub|tg_d_a|xo|xo_dip|xo_hop|xo_stub|y vdd 3.869e-18
* device instance cc_a_g_a_rn1_ro_s4_y_y_a_g_y_mnab_y_mpa_y_mpb_y_n1_s1_a_y r0 *1 0,0
Ccc_a_g_a_rn1_ro_s4_y_y_a_g_y_mnab_y_mpa_y_mpb_y_n1_s1_a_y a|g_a|rn1|ro|s4_y|y
+ a|g_y|mnab_y|mpa_y|mpb_y|n1|s1_a|y$3 1.5977e-17
* device instance cc_a_g_a_rn1_ro_s4_y_y_vddr1 r0 *1 0,0
Ccc_a_g_a_rn1_ro_s4_y_y_vddr1 a|g_a|rn1|ro|s4_y|y vddr1 1.5474e-17
* device instance cc_a_g_a_rn2_ro_s4_y_y_a_g_y_mnab_y_mpa_y_mpb_y_n1_s1_a_y r0 *1 0,0
Ccc_a_g_a_rn2_ro_s4_y_y_a_g_y_mnab_y_mpa_y_mpb_y_n1_s1_a_y a|g_a|rn2|ro|s4_y|y
+ a|g_y|mnab_y|mpa_y|mpb_y|n1|s1_a|y$3 1.5977e-17
* device instance cc_a_g_a_rn2_ro_s4_y_y_vddr2 r0 *1 0,0
Ccc_a_g_a_rn2_ro_s4_y_y_vddr2 a|g_a|rn2|ro|s4_y|y vddr2 1.5474e-17
* device instance cc_a_g_a_rn3_ro_s4_y_y_a_g_y_mnab_y_mpa_y_mpb_y_n1_s1_a_y r0 *1 0,0
Ccc_a_g_a_rn3_ro_s4_y_y_a_g_y_mnab_y_mpa_y_mpb_y_n1_s1_a_y a|g_a|rn3|ro|s4_y|y
+ a|g_y|mnab_y|mpa_y|mpb_y|n1|s1_a|y$3 1.5977e-17
* device instance cc_a_g_a_rn3_ro_s4_y_y_vddr3 r0 *1 0,0
Ccc_a_g_a_rn3_ro_s4_y_y_vddr3 a|g_a|rn3|ro|s4_y|y vddr3 1.5474e-17
* device instance cc_a_g_a_rn4_ro_s4_y_y_a_g_y_mnab_y_mpa_y_mpb_y_n1_s1_a_y r0 *1 0,0
Ccc_a_g_a_rn4_ro_s4_y_y_a_g_y_mnab_y_mpa_y_mpb_y_n1_s1_a_y a|g_a|rn4|ro|s4_y|y
+ a|g_y|mnab_y|mpa_y|mpb_y|n1|s1_a|y$3 1.5977e-17
* device instance cc_a_g_a_rn4_ro_s4_y_y_vdd r0 *1 0,0
Ccc_a_g_a_rn4_ro_s4_y_y_vdd a|g_a|rn4|ro|s4_y|y vdd 3.869e-18
* device instance cc_a_g_a_rn4_ro_s4_y_y_vddr4 r0 *1 0,0
Ccc_a_g_a_rn4_ro_s4_y_y_vddr4 a|g_a|rn4|ro|s4_y|y vddr4 1.5474e-17
* device instance cc_a_g_a_rn4_ro_s4_y_y_vss r0 *1 0,0
Ccc_a_g_a_rn4_ro_s4_y_y_vss a|g_a|rn4|ro|s4_y|y vss 1.4912e-17
* device instance cc_a_g_y_mnab_y_mpa_y_mpb_y_n1_s1_a_y_ny r0 *1 0,0
Ccc_a_g_y_mnab_y_mpa_y_mpb_y_n1_s1_a_y_ny a|g_y|mnab_y|mpa_y|mpb_y|n1|s1_a|y$3
+ ny$19 1.1511e-17
* device instance cc_a_g_y_mnab_y_mpa_y_mpb_y_n1_s1_a_y_vss r0 *1 0,0
Ccc_a_g_y_mnab_y_mpa_y_mpb_y_n1_s1_a_y_vss a|g_y|mnab_y|mpa_y|mpb_y|n1|s1_a|y$3
+ vss 1.5474e-17
* device instance cc_a_inv_mc_a_mb_mnab_y_mpa_y_mpb_y_nand_m_y_tg_s_a_y_a_inv_mc_y_inv_mc_y_via_mc_tg_fbm_a_tg_fbm_a_via_y r0 *1 0,0
Ccc_a_inv_mc_a_mb_mnab_y_mpa_y_mpb_y_nand_m_y_tg_s_a_y_a_inv_mc_y_inv_mc_y_via_mc_tg_fbm_a_tg_fbm_a_via_y
+ a|inv_mc_a|mb|mnab_y|mpa_y|mpb_y|nand_m_y|tg_s_a|y$5
+ a|inv_mc_y|inv_mc_y_via|mc|tg_fbm_a|tg_fbm_a_via|y$5 1.37451e-16
* device instance cc_a_inv_mc_a_mb_mnab_y_mpa_y_mpb_y_nand_m_y_tg_s_a_y_clkb_clkb_bridge1_clkb_bridge2_clkb_mid_clkb_w_ctrl_ctrlb_inv_clk_y_tg_d_ctrlb_tg_fbm_ctrl_tg_fbs_ctrlb_tg_s_ctrl_y r0 *1 0,0
Ccc_a_inv_mc_a_mb_mnab_y_mpa_y_mpb_y_nand_m_y_tg_s_a_y_clkb_clkb_bridge1_clkb_bridge2_clkb_mid_clkb_w_ctrl_ctrlb_inv_clk_y_tg_d_ctrlb_tg_fbm_ctrl_tg_fbs_ctrlb_tg_s_ctrl_y
+ a|inv_mc_a|mb|mnab_y|mpa_y|mpb_y|nand_m_y|tg_s_a|y$5
+ clkb|clkb_bridge1|clkb_bridge2|clkb_mid|clkb_w|ctrl|ctrlb|inv_clk_y|tg_d_ctrlb|tg_fbm_ctrl|tg_fbs_ctrlb|tg_s_ctrl|y$5
+ 7.6194e-17
* device instance cc_a_inv_mc_a_mb_mnab_y_mpa_y_mpb_y_nand_m_y_tg_s_a_y_rst_n r0 *1 0,0
Ccc_a_inv_mc_a_mb_mnab_y_mpa_y_mpb_y_nand_m_y_tg_s_a_y_rst_n
+ a|inv_mc_a|mb|mnab_y|mpa_y|mpb_y|nand_m_y|tg_s_a|y$5 rst_n 9.2845e-17
* device instance cc_a_inv_mc_y_inv_mc_y_via_mc_tg_fbm_a_tg_fbm_a_via_y_clkb_clkb_bridge1_clkb_bridge2_clkb_mid_clkb_w_ctrl_ctrlb_inv_clk_y_tg_d_ctrlb_tg_fbm_ctrl_tg_fbs_ctrlb_tg_s_ctrl_y r0 *1 0,0
Ccc_a_inv_mc_y_inv_mc_y_via_mc_tg_fbm_a_tg_fbm_a_via_y_clkb_clkb_bridge1_clkb_bridge2_clkb_mid_clkb_w_ctrl_ctrlb_inv_clk_y_tg_d_ctrlb_tg_fbm_ctrl_tg_fbs_ctrlb_tg_s_ctrl_y
+ a|inv_mc_y|inv_mc_y_via|mc|tg_fbm_a|tg_fbm_a_via|y$5
+ clkb|clkb_bridge1|clkb_bridge2|clkb_mid|clkb_w|ctrl|ctrlb|inv_clk_y|tg_d_ctrlb|tg_fbm_ctrl|tg_fbs_ctrlb|tg_s_ctrl|y$5
+ 1.23251e-16
* device instance cc_a_inv_q_y_inv_q_y_via_inv_q_y_via2_nand_s2_a_nand_s2_a_stub_nand_s2_a_via_nand_s2_a_via2_q_y_a_mnab_y_mpa_y_mpb_y_nand_s2_y_qb_tg_fbs_a_y r0 *1 0,0
Ccc_a_inv_q_y_inv_q_y_via_inv_q_y_via2_nand_s2_a_nand_s2_a_stub_nand_s2_a_via_nand_s2_a_via2_q_y_a_mnab_y_mpa_y_mpb_y_nand_s2_y_qb_tg_fbs_a_y
+ a|inv_q_y|inv_q_y_via|inv_q_y_via2|nand_s2_a|nand_s2_a_stub|nand_s2_a_via|nand_s2_a_via2|q|y$5
+ a|mnab_y|mpa_y|mpb_y|nand_s2_y|qb|tg_fbs_a|y$5 1.76851e-16
* device instance cc_a_inv_q_y_inv_q_y_via_inv_q_y_via2_nand_s2_a_nand_s2_a_stub_nand_s2_a_via_nand_s2_a_via2_q_y_clkb_clkb_bridge1_clkb_bridge2_clkb_mid_clkb_w_ctrl_ctrlb_inv_clk_y_tg_d_ctrlb_tg_fbm_ctrl_tg_fbs_ctrlb_tg_s_ctrl_y r0 *1 0,0
Ccc_a_inv_q_y_inv_q_y_via_inv_q_y_via2_nand_s2_a_nand_s2_a_stub_nand_s2_a_via_nand_s2_a_via2_q_y_clkb_clkb_bridge1_clkb_bridge2_clkb_mid_clkb_w_ctrl_ctrlb_inv_clk_y_tg_d_ctrlb_tg_fbm_ctrl_tg_fbs_ctrlb_tg_s_ctrl_y
+ a|inv_q_y|inv_q_y_via|inv_q_y_via2|nand_s2_a|nand_s2_a_stub|nand_s2_a_via|nand_s2_a_via2|q|y$5
+ clkb|clkb_bridge1|clkb_bridge2|clkb_mid|clkb_w|ctrl|ctrlb|inv_clk_y|tg_d_ctrlb|tg_fbm_ctrl|tg_fbs_ctrlb|tg_s_ctrl|y$5
+ 5.002e-17
* device instance cc_a_inva_a_mn12_g0_mp13_g0_t1_y_an_inva_y_mn34_g0_mp13_g1_y r0 *1 0,0
Ccc_a_inva_a_mn12_g0_mp13_g0_t1_y_an_inva_y_mn34_g0_mp13_g1_y
+ a|inva_a|mn12_g0|mp13_g0|t1|y an|inva_y|mn34_g0|mp13_g1|y$2 3.3e-18
* device instance cc_a_inva_a_mn12_g0_mp13_g0_t1_y_bn_invb_y_mn34_g1_mp24_g1_y r0 *1 0,0
Ccc_a_inva_a_mn12_g0_mp13_g0_t1_y_bn_invb_y_mn34_g1_mp24_g1_y
+ a|inva_a|mn12_g0|mp13_g0|t1|y bn|invb_y|mn34_g1|mp24_g1|y$2 9.901e-18
* device instance cc_a_inva_a_mn12_g0_mp13_g0_t1_y_mid r0 *1 0,0
Ccc_a_inva_a_mn12_g0_mp13_g0_t1_y_mid a|inva_a|mn12_g0|mp13_g0|t1|y mid$2
+ 3.3e-18
* device instance cc_a_inva_a_mn12_g0_mp13_g0_t1_y_vdd r0 *1 0,0
Ccc_a_inva_a_mn12_g0_mp13_g0_t1_y_vdd a|inva_a|mn12_g0|mp13_g0|t1|y vdd
+ 3.5274e-17
* device instance cc_a_inva_a_mn12_g0_mp13_g0_t1_y_vss r0 *1 0,0
Ccc_a_inva_a_mn12_g0_mp13_g0_t1_y_vss a|inva_a|mn12_g0|mp13_g0|t1|y vss
+ 6.601e-18
* device instance cc_a_mnab_y_mpa_y_mpb_y_nand_s2_y_qb_tg_fbs_a_y_clk r0 *1 0,0
Ccc_a_mnab_y_mpa_y_mpb_y_nand_s2_y_qb_tg_fbs_a_y_clk
+ a|mnab_y|mpa_y|mpb_y|nand_s2_y|qb|tg_fbs_a|y$5 clk 2.3211e-17
* device instance cc_a_mnab_y_mpa_y_mpb_y_nand_s2_y_qb_tg_fbs_a_y_clkb_clkb_bridge1_clkb_bridge2_clkb_mid_clkb_w_ctrl_ctrlb_inv_clk_y_tg_d_ctrlb_tg_fbm_ctrl_tg_fbs_ctrlb_tg_s_ctrl_y r0 *1 0,0
Ccc_a_mnab_y_mpa_y_mpb_y_nand_s2_y_qb_tg_fbs_a_y_clkb_clkb_bridge1_clkb_bridge2_clkb_mid_clkb_w_ctrl_ctrlb_inv_clk_y_tg_d_ctrlb_tg_fbm_ctrl_tg_fbs_ctrlb_tg_s_ctrl_y
+ a|mnab_y|mpa_y|mpb_y|nand_s2_y|qb|tg_fbs_a|y$5
+ clkb|clkb_bridge1|clkb_bridge2|clkb_mid|clkb_w|ctrl|ctrlb|inv_clk_y|tg_d_ctrlb|tg_fbm_ctrl|tg_fbs_ctrlb|tg_s_ctrl|y$5
+ 4.8089e-17
* device instance cc_a_n2_s1_y_s2_a_y_ny r0 *1 0,0
Ccc_a_n2_s1_y_s2_a_y_ny a|n2|s1_y|s2_a|y$3 ny$19 1.1511e-17
* device instance cc_a_n2_s1_y_s2_a_y_vss r0 *1 0,0
Ccc_a_n2_s1_y_s2_a_y_vss a|n2|s1_y|s2_a|y$3 vss 1.5474e-17
* device instance cc_a_n3_s2_y_s3_a_y_ny r0 *1 0,0
Ccc_a_n3_s2_y_s3_a_y_ny a|n3|s2_y|s3_a|y$3 ny$19 1.1511e-17
* device instance cc_a_n3_s2_y_s3_a_y_vss r0 *1 0,0
Ccc_a_n3_s2_y_s3_a_y_vss a|n3|s2_y|s3_a|y$3 vss 1.5474e-17
* device instance cc_a_n4_s3_y_s4_a_y_ny r0 *1 0,0
Ccc_a_n4_s3_y_s4_a_y_ny a|n4|s3_y|s4_a|y$3 ny$19 1.1511e-17
* device instance cc_a_n4_s3_y_s4_a_y_vss r0 *1 0,0
Ccc_a_n4_s3_y_s4_a_y_vss a|n4|s3_y|s4_a|y$3 vss 1.5474e-17
* device instance cc_an_inva_y_mn34_g0_mp13_g1_y_vdd r0 *1 0,0
Ccc_an_inva_y_mn34_g0_mp13_g1_y_vdd an|inva_y|mn34_g0|mp13_g1|y$2 vdd 2.8673e-17
* device instance cc_bn_invb_y_mn34_g1_mp24_g1_y_mid r0 *1 0,0
Ccc_bn_invb_y_mn34_g1_mp24_g1_y_mid bn|invb_y|mn34_g1|mp24_g1|y$2 mid$2
+ 9.901e-18
* device instance cc_bn_invb_y_mn34_g1_mp24_g1_y_vdd r0 *1 0,0
Ccc_bn_invb_y_mn34_g1_mp24_g1_y_vdd bn|invb_y|mn34_g1|mp24_g1|y$2 vdd 9.901e-18
* device instance cc_clk_clkb_clkb_bridge1_clkb_bridge2_clkb_mid_clkb_w_ctrl_ctrlb_inv_clk_y_tg_d_ctrlb_tg_fbm_ctrl_tg_fbs_ctrlb_tg_s_ctrl_y r0 *1 0,0
Ccc_clk_clkb_clkb_bridge1_clkb_bridge2_clkb_mid_clkb_w_ctrl_ctrlb_inv_clk_y_tg_d_ctrlb_tg_fbm_ctrl_tg_fbs_ctrlb_tg_s_ctrl_y
+ clk
+ clkb|clkb_bridge1|clkb_bridge2|clkb_mid|clkb_w|ctrl|ctrlb|inv_clk_y|tg_d_ctrlb|tg_fbm_ctrl|tg_fbs_ctrlb|tg_s_ctrl|y$5
+ 2.75805e-16
* device instance cc_clk_vss r0 *1 0,0
Ccc_clk_vss clk vss 1.16057e-16
* device instance cc_clkb_clkb_bridge1_clkb_bridge2_clkb_mid_clkb_w_ctrl_ctrlb_inv_clk_y_tg_d_ctrlb_tg_fbm_ctrl_tg_fbs_ctrlb_tg_s_ctrl_y_rst_n r0 *1 0,0
Ccc_clkb_clkb_bridge1_clkb_bridge2_clkb_mid_clkb_w_ctrl_ctrlb_inv_clk_y_tg_d_ctrlb_tg_fbm_ctrl_tg_fbs_ctrlb_tg_s_ctrl_y_rst_n
+ clkb|clkb_bridge1|clkb_bridge2|clkb_mid|clkb_w|ctrl|ctrlb|inv_clk_y|tg_d_ctrlb|tg_fbm_ctrl|tg_fbs_ctrlb|tg_s_ctrl|y$5
+ rst_n 1.83763e-16
* device instance cc_clkb_clkb_bridge1_clkb_bridge2_clkb_mid_clkb_w_ctrl_ctrlb_inv_clk_y_tg_d_ctrlb_tg_fbm_ctrl_tg_fbs_ctrlb_tg_s_ctrl_y_vdd r0 *1 0,0
Ccc_clkb_clkb_bridge1_clkb_bridge2_clkb_mid_clkb_w_ctrl_ctrlb_inv_clk_y_tg_d_ctrlb_tg_fbm_ctrl_tg_fbs_ctrlb_tg_s_ctrl_y_vdd
+ clkb|clkb_bridge1|clkb_bridge2|clkb_mid|clkb_w|ctrl|ctrlb|inv_clk_y|tg_d_ctrlb|tg_fbm_ctrl|tg_fbs_ctrlb|tg_s_ctrl|y$5
+ vdd 8.337e-18
* device instance cc_clkb_clkb_bridge1_clkb_bridge2_clkb_mid_clkb_w_ctrl_ctrlb_inv_clk_y_tg_d_ctrlb_tg_fbm_ctrl_tg_fbs_ctrlb_tg_s_ctrl_y_vss r0 *1 0,0
Ccc_clkb_clkb_bridge1_clkb_bridge2_clkb_mid_clkb_w_ctrl_ctrlb_inv_clk_y_tg_d_ctrlb_tg_fbm_ctrl_tg_fbs_ctrlb_tg_s_ctrl_y_vss
+ clkb|clkb_bridge1|clkb_bridge2|clkb_mid|clkb_w|ctrl|ctrlb|inv_clk_y|tg_d_ctrlb|tg_fbm_ctrl|tg_fbs_ctrlb|tg_s_ctrl|y$5
+ vss 6.13699e-16
* device instance cc_py_vddr1 r0 *1 0,0
Ccc_py_vddr1 py$15 vddr1 1.2471e-17
* device instance cc_py_vddr2 r0 *1 0,0
Ccc_py_vddr2 py$15 vddr2 1.3064e-17
* device instance cc_py_vddr3 r0 *1 0,0
Ccc_py_vddr3 py$15 vddr3 1.3658e-17
* device instance cc_py_vddr4 r0 *1 0,0
Ccc_py_vddr4 py$15 vddr4 1.4252e-17
* device instance cc_rst_n_vdd r0 *1 0,0
Ccc_rst_n_vdd rst_n vdd 1.00582e-16
* device instance cc_rst_n_vss r0 *1 0,0
Ccc_rst_n_vss rst_n vss 3.869e-18
* device instance cc_vdd_vss r0 *1 0,0
Ccc_vdd_vss vdd vss 7.7757e-17
* device instance vsubs_dctie r0 *1 0,0
Rvsubs_dctie vsubs 0 1e+12
.ENDS sampler_core
