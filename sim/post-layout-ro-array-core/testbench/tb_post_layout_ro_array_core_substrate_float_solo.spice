* Post-layout ro_array_core (whole array, real inter-ring wiring), FLOATING
* substrate, rings 2-4 PRESENT BUT STOPPED (en2/en3/en4 held at 0 for the
* whole run) -- the array-scale sibling of
* sim/post-layout-ro-ring5/testbench/tb_post_layout_substrate_float_solo.spice.
*
* Purpose: separate LOADING (the floating node's own capacitance/impedance,
* present even with no other ring switching) from COUPLING (ring 1's period
* moving because rings 2-4 are actually driving the same shared node), the
* same three-way decomposition DR-0005 finding 3 used at ring scope:
*
*   loading  = t(this deck)                         - t(tied, sibling deck)
*   coupling = t(substrate_float, all 4 running)     - t(this deck)
*
* Same array GDS extraction as the other two decks in this directory (real
* physical ring-to-ring proximity, not four separately-placed leaf cells),
* so this is the strongest available bound on the substrate mechanism this
* repo has produced -- still not the physical answer (the extractor emits
* no substrate or tap resistance at all; klayout-tools#1503), but bracketing
* the terminals of a real, physically-placed layout's own shared node
* rather than a hand-tied approximation of one.
*
* With en2/en3/en4 held at 0, ro_nand2's own defined-output-on-disable state
* (design/README.md; DR-0003) pins ring2/3/4's node ro_ring5 outputs high --
* a defined, non-switching state, not a floating one -- so rn2/rn3/rn4 (and
* therefore ro2/ro3/ro4 and the XOR tree downstream of them) settle and stay
* put; only ring 1 free-runs.
*
* This file is a TEMPLATE: sim/bin/corner-run.py substitutes @@PDK_LIB@@,
* @@CORNER@@, @@PEX_LIB@@, @@TEMP@@ and @@VDD@@. As committed it is not a
* runnable deck. Invoke with
* `--pex-lib layout/pex-array/ro_array_core_pex.spice`.

.option scale=1u
.lib "@@PDK_LIB@@" @@CORNER@@

.include "@@PEX_LIB@@"

.temp @@TEMP@@

* --- substrate return node: FLOATING (see header) -- no Vsub source ----

Vddrp1 pvddr1 0 dc @@VDD@@
Vddrp2 pvddr2 0 dc @@VDD@@
Vddrp3 pvddr3 0 dc @@VDD@@
Vddrp4 pvddr4 0 dc @@VDD@@
Vddp pvdd 0 dc @@VDD@@
Venp1 pen1 0 PULSE(0 @@VDD@@ 5n 100p 100p 1u 2u)
* rings 2-4: held at 0 for the whole run -- present, but never released.
Venp2 pen2 0 dc 0
Venp3 pen3 0 dc 0
Venp4 pen4 0 dc 0
xarr pen1 pen2 pen3 pen4 pvddr1 pvddr2 pvddr3 pvddr4 pvdd 0 pxo pro1 pro2 pro3 pro4 ro_array_core_pex

.ic v(pro1)=0
.ic v(pro2)=0
.ic v(pro3)=0
.ic v(pro4)=0

.save v(pro1) v(xarr.vsubs)
.save i(Vddrp1)

.tran @@TMAX@@ 800n uic

.control
run

meas tran pt1a when v(pro1)=0.5*@@VDD@@ rise=3
meas tran pt1b when v(pro1)=0.5*@@VDD@@ rise=13
let p_tr1 = (pt1b - pt1a)/10

meas tran vsub_max MAX v(xarr.vsubs) from=100n to=800n
meas tran vsub_min MIN v(xarr.vsubs) from=100n to=800n
let vsub_swing_frac = (vsub_max - vsub_min) / @@VDD@@

print p_tr1
print vsub_swing_frac
.endc
.end
