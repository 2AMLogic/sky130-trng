* ro-vth-drift-sensitivity: array deck at Vdd=1.8 V, generated by sim/ro-vth-drift-sensitivity/campaign.py
* source testbench: sim/ro-array-core-combining/testbench/tb_ro_array_core.spice
* design netlist: design/ro_array_core.spice (wrapped)
* --- vth-drift gate-offset wrappers v1 (sim/ro-vth-drift-sensitivity/aging.py) ---
.global vth_dvn vth_dvp
.subckt vth_wrap_nfet d g s b L=1 W=1 nf=1 ad=1 as=1 pd=1 ps=1 nrd=1 nrs=1 sa=1 sb=1 sd=1 mult=1 m=1
Esh g gd vth_dvn 0 1
Xdev d gd s b sky130_fd_pr__nfet_01v8 L=L W=W nf=nf ad=ad as=as pd=pd ps=ps nrd=nrd nrs=nrs sa=sa sb=sb sd=sd mult=mult m=m
.ends
.subckt vth_wrap_pfet d g s b L=1 W=1 nf=1 ad=1 as=1 pd=1 ps=1 nrd=1 nrs=1 sa=1 sb=1 sd=1 mult=1 m=1
Esh g gd vth_dvp 0 -1
Xdev d gd s b sky130_fd_pr__pfet_01v8 L=L W=W nf=nf ad=ad as=as pd=pd ps=ps nrd=nrd nrs=nrs sa=sa sb=sb sd=sd mult=mult m=m
.ends
* --- end wrappers ---
* ro_array_core -- GENERATED by design/netlist.py from design/xschem/ro_array_core.sch
* Do not edit by hand: `python3 design/netlist.py --check` fails if this
* file and the schematic disagree. Regenerate with `python3 design/netlist.py`.
** sch_path: ro_array_core.sch
.subckt ro_array_core en1 en2 en3 en4 vddr1 vddr2 vddr3 vddr4 vdd vss xo ro1 ro2 ro3 ro4
*.ipin en1
*.ipin en2
*.ipin en3
*.ipin en4
*.iopin vddr1
*.iopin vddr2
*.iopin vddr3
*.iopin vddr4
*.iopin vdd
*.iopin vss
*.opin xo
*.opin ro1
*.opin ro2
*.opin ro3
*.opin ro4
xr1 en1 rn1 vddr1 vss ro_ring5 wstv=0.42 lstv=2 cld=0.5f
xr2 en2 rn2 vddr2 vss ro_ring5 wstv=0.44 lstv=2 cld=0.5f
xr3 en3 rn3 vddr3 vss ro_ring5 wstv=0.46 lstv=2 cld=0.5f
xr4 en4 rn4 vddr4 vss ro_ring5 wstv=0.48 lstv=2 cld=0.5f
xb1 rn1 ro1 vdd vss ro_buf
xb2 rn2 ro2 vdd vss ro_buf
xb3 rn3 ro3 vdd vss ro_buf
xb4 rn4 ro4 vdd vss ro_buf
xa1 ro1 ro2 t1 vdd vss xor2
xa2 ro3 ro4 t2 vdd vss xor2
xa3 t1 t2 xo vdd vss xor2
.ends

* expanding   symbol:  ro_ring5.sym # of pins=4
** sym_path: ro_ring5.sym
** sch_path: ro_ring5.sch
.subckt ro_ring5 en ro vddr vss wstv=0.42 lstv=2 cld=0.5f
*.ipin en
*.opin ro
*.iopin vddr
*.iopin vss
xg ro en n1 vddr vss ro_nand2 wstv=wstv lstv=lstv cld=cld
x1 n1 n2 vddr vss ro_stage wstv=wstv lstv=lstv cld=cld
x2 n2 n3 vddr vss ro_stage wstv=wstv lstv=lstv cld=cld
x3 n3 n4 vddr vss ro_stage wstv=wstv lstv=lstv cld=cld
x4 n4 ro vddr vss ro_stage wstv=wstv lstv=lstv cld=cld
.ends

* expanding   symbol:  ro_buf.sym # of pins=4
** sym_path: ro_buf.sym
** sch_path: ro_buf.sch
.subckt ro_buf a y vdd vss
*.ipin a
*.opin y
*.iopin vdd
*.iopin vss
XMp y a vdd vdd vth_wrap_pfet L=0.15 W=0.84 nf=1 ad=0.2436 as=0.2436 pd=2.26 ps=2.26 nrd=0.345238095238095
+ nrs=0.345238095238095 sa=0 sb=0 sd=0 mult=1 m=1
XMn y a vss vss vth_wrap_nfet L=0.15 W=0.42 nf=1 ad=0.1218 as=0.1218 pd=1.42 ps=1.42 nrd=0.69047619047619
+ nrs=0.69047619047619 sa=0 sb=0 sd=0 mult=1 m=1
.ends

* expanding   symbol:  xor2.sym # of pins=5
** sym_path: xor2.sym
** sch_path: xor2.sch
.subckt xor2 a b y vdd vss
*.ipin a
*.ipin b
*.opin y
*.iopin vdd
*.iopin vss
XMpiA an a vdd vdd vth_wrap_pfet L=0.15 W=0.84 nf=1 ad=0.2436 as=0.2436 pd=2.26 ps=2.26 nrd=0.345238095238095
+ nrs=0.345238095238095 sa=0 sb=0 sd=0 mult=1 m=1
XMniA an a vss vss vth_wrap_nfet L=0.15 W=0.42 nf=1 ad=0.1218 as=0.1218 pd=1.42 ps=1.42 nrd=0.69047619047619
+ nrs=0.69047619047619 sa=0 sb=0 sd=0 mult=1 m=1
XMpiB bn b vdd vdd vth_wrap_pfet L=0.15 W=0.84 nf=1 ad=0.2436 as=0.2436 pd=2.26 ps=2.26 nrd=0.345238095238095
+ nrs=0.345238095238095 sa=0 sb=0 sd=0 mult=1 m=1
XMniB bn b vss vss vth_wrap_nfet L=0.15 W=0.42 nf=1 ad=0.1218 as=0.1218 pd=1.42 ps=1.42 nrd=0.69047619047619
+ nrs=0.69047619047619 sa=0 sb=0 sd=0 mult=1 m=1
XMp1 mid a vdd vdd vth_wrap_pfet L=0.15 W=1.68 nf=1 ad=0.4872 as=0.4872 pd=3.94 ps=3.94 nrd=0.172619047619048
+ nrs=0.172619047619048 sa=0 sb=0 sd=0 mult=1 m=1
XMp2 mid b vdd vdd vth_wrap_pfet L=0.15 W=1.68 nf=1 ad=0.4872 as=0.4872 pd=3.94 ps=3.94 nrd=0.172619047619048
+ nrs=0.172619047619048 sa=0 sb=0 sd=0 mult=1 m=1
XMp3 y an mid vdd vth_wrap_pfet L=0.15 W=1.68 nf=1 ad=0.4872 as=0.4872 pd=3.94 ps=3.94 nrd=0.172619047619048
+ nrs=0.172619047619048 sa=0 sb=0 sd=0 mult=1 m=1
XMp4 y bn mid vdd vth_wrap_pfet L=0.15 W=1.68 nf=1 ad=0.4872 as=0.4872 pd=3.94 ps=3.94 nrd=0.172619047619048
+ nrs=0.172619047619048 sa=0 sb=0 sd=0 mult=1 m=1
XMn1 y a s1 vss vth_wrap_nfet L=0.15 W=0.84 nf=1 ad=0.2436 as=0.2436 pd=2.26 ps=2.26 nrd=0.345238095238095
+ nrs=0.345238095238095 sa=0 sb=0 sd=0 mult=1 m=1
XMn2 s1 b vss vss vth_wrap_nfet L=0.15 W=0.84 nf=1 ad=0.2436 as=0.2436 pd=2.26 ps=2.26 nrd=0.345238095238095
+ nrs=0.345238095238095 sa=0 sb=0 sd=0 mult=1 m=1
XMn3 y an s2 vss vth_wrap_nfet L=0.15 W=0.84 nf=1 ad=0.2436 as=0.2436 pd=2.26 ps=2.26 nrd=0.345238095238095
+ nrs=0.345238095238095 sa=0 sb=0 sd=0 mult=1 m=1
XMn4 s2 bn vss vss vth_wrap_nfet L=0.15 W=0.84 nf=1 ad=0.2436 as=0.2436 pd=2.26 ps=2.26 nrd=0.345238095238095
+ nrs=0.345238095238095 sa=0 sb=0 sd=0 mult=1 m=1
.ends

* expanding   symbol:  ro_nand2.sym # of pins=5
** sym_path: ro_nand2.sym
** sch_path: ro_nand2.sch
.subckt ro_nand2 a en y vddr vss wstv=0.42 lstv=2 cld=0.5f
*.ipin a
*.ipin en
*.opin y
*.iopin vddr
*.iopin vss
XMph py vss vddr vddr vth_wrap_pfet L=lstv W=wstv nf=1 ad='int((1 + 1)/2) * wstv / 1 * 0.29'
+ as='int((1 + 2)/2) * wstv / 1 * 0.29' pd='2*int((1 + 1)/2) * (wstv / 1 + 0.29)'
+ ps='2*int((1 + 2)/2) * (wstv / 1 + 0.29)' nrd='0.29 / wstv ' nrs='0.29 / wstv ' sa=0 sb=0 sd=0 mult=1 m=1
XMpa y a py vddr vth_wrap_pfet L=0.15 W=0.84 nf=1 ad=0.2436 as=0.2436 pd=2.26 ps=2.26 nrd=0.345238095238095
+ nrs=0.345238095238095 sa=0 sb=0 sd=0 mult=1 m=1
XMpb y en py vddr vth_wrap_pfet L=0.15 W=0.84 nf=1 ad=0.2436 as=0.2436 pd=2.26 ps=2.26 nrd=0.345238095238095
+ nrs=0.345238095238095 sa=0 sb=0 sd=0 mult=1 m=1
XMna y a nm vss vth_wrap_nfet L=0.15 W=0.84 nf=1 ad=0.2436 as=0.2436 pd=2.26 ps=2.26 nrd=0.345238095238095
+ nrs=0.345238095238095 sa=0 sb=0 sd=0 mult=1 m=1
XMnb nm en ny vss vth_wrap_nfet L=0.15 W=0.84 nf=1 ad=0.2436 as=0.2436 pd=2.26 ps=2.26 nrd=0.345238095238095
+ nrs=0.345238095238095 sa=0 sb=0 sd=0 mult=1 m=1
XMnt ny vddr vss vss vth_wrap_nfet L=lstv W=wstv nf=1 ad='int((1 + 1)/2) * wstv / 1 * 0.29'
+ as='int((1 + 2)/2) * wstv / 1 * 0.29' pd='2*int((1 + 1)/2) * (wstv / 1 + 0.29)'
+ ps='2*int((1 + 2)/2) * (wstv / 1 + 0.29)' nrd='0.29 / wstv ' nrs='0.29 / wstv ' sa=0 sb=0 sd=0 mult=1 m=1
Cld y vss 'cld' m=1
.ends

* expanding   symbol:  ro_stage.sym # of pins=4
** sym_path: ro_stage.sym
** sch_path: ro_stage.sch
.subckt ro_stage a y vddr vss wstv=0.42 lstv=2 cld=0.5f
*.ipin a
*.opin y
*.iopin vddr
*.iopin vss
XMph py vss vddr vddr vth_wrap_pfet L=lstv W=wstv nf=1 ad='int((1 + 1)/2) * wstv / 1 * 0.29'
+ as='int((1 + 2)/2) * wstv / 1 * 0.29' pd='2*int((1 + 1)/2) * (wstv / 1 + 0.29)'
+ ps='2*int((1 + 2)/2) * (wstv / 1 + 0.29)' nrd='0.29 / wstv ' nrs='0.29 / wstv ' sa=0 sb=0 sd=0 mult=1 m=1
XMp y a py vddr vth_wrap_pfet L=0.15 W=0.84 nf=1 ad=0.2436 as=0.2436 pd=2.26 ps=2.26 nrd=0.345238095238095
+ nrs=0.345238095238095 sa=0 sb=0 sd=0 mult=1 m=1
XMn y a ny vss vth_wrap_nfet L=0.15 W=0.42 nf=1 ad=0.1218 as=0.1218 pd=1.42 ps=1.42 nrd=0.69047619047619
+ nrs=0.69047619047619 sa=0 sb=0 sd=0 mult=1 m=1
XMnt ny vddr vss vss vth_wrap_nfet L=lstv W=wstv nf=1 ad='int((1 + 1)/2) * wstv / 1 * 0.29'
+ as='int((1 + 2)/2) * wstv / 1 * 0.29' pd='2*int((1 + 1)/2) * (wstv / 1 + 0.29)'
+ ps='2*int((1 + 2)/2) * (wstv / 1 + 0.29)' nrd='0.29 / wstv ' nrs='0.29 / wstv ' sa=0 sb=0 sd=0 mult=1 m=1
Cld y vss 'cld' m=1
.ends

* ro_array_core as rebuilt -- combining fidelity, frequency ladder, array current
*
* Purpose: this is the assembled-block measurement for issue #13's rebuild.
* It drives the COMMITTED design/ro_array_core.spice -- the netlist
* design/netlist.py exports from design/xschem/ro_array_core.sch and guards
* with --check -- so what it measures is the schematic as drawn, N = 4
* five-stage rings and all, not a hand-built approximation of it.
*
* Three things it establishes, none of which #10's campaign could:
*
*   1. COMBINING FIDELITY, in two separate senses that must not be
*      conflated.
*
*      (a) EDGE RETENTION -- a bandwidth measure. The XOR tree's ceiling on
*      N (sim/xor-combining-bandwidth/) is derived from a single gate driven
*      by a periodic square wave. The real combining node is driven by the
*      superposition of 4 skewed rings, whose inter-edge gaps are spread,
*      not uniform: even when the MEAN gap is comfortably above the gate's
*      minimum pulse width, the rings beat against each other and edge pairs
*      pass through near-coincidence, where they are swallowed. This deck
*      measures the realized rising-edge rate at a node and divides it by
*      the ideal rate sum(1/T_i) over the rings feeding it, taken from the
*      SAME run's per-ring periods.
*
*      Because the tree is BALANCED, one run gives that ratio at two array
*      sizes for free: xdut.t1 combines 2 rings and xo combines all 4. No
*      separate N-sweep deck is needed, and both numbers come from identical
*      rings under identical conditions.
*
*      (b) VALUE FIDELITY -- a bias measure, and the one that actually
*      reaches the sampler. A swallowed pulse is a swallowed PAIR of edges,
*      and two missed toggles leave the node's parity unchanged, so the
*      sampled value still tracks the ideal XOR of all four rings except
*      inside the short swallowed window itself. Systematic bias at the
*      combining node is what would destroy raw min-entropy, so this deck
*      measures the time-average level of each combining node directly. A
*      node whose mean sits at 0.5 x Vdd is combining without a DC error,
*      however many edges it dropped.
*
*      Reporting only (a) would overstate the damage; reporting only (b)
*      would hide that the tree is filtering at all. Both are recorded.
*
*   2. THE FREQUENCY LADDER, realized. ro_array_core.sch skews the rings by
*      starve-device width, wstv = 0.42 um to 0.48 um in 0.02 um steps. What
*      that ladder does to the actual oscillation frequencies is a device
*      fact, not a design intent, and integer frequency ratios are the ones
*      that mutually injection lock. This deck reports all four periods
*      from one run so the realized ratios can be read off directly.
*
*   3. ARRAY SUPPLY CURRENT. Four separate vddr sources plus the block vdd,
*      each measured separately, summed into a total. design/README.md's
*      power rows had no sky130 measurement at all behind them.
*
* Start-up is by ENABLE RELEASE, not by .ic. A deterministic transient of a
* ring started at its own DC operating point sits at the metastable point
* and never oscillates, and the rings' internal nodes are inside a subckt
* here (unlike #10's in-place ring decks, which could .ic them from the top
* level). So all four enables are held at 0 through the DC operating point
* and released together at t = 5 ns: with en = 0 the ro_nand2 pins its own
* output high, which is a defined state, and releasing it starts the ring.
* That is also how the block is actually meant to be brought up.
*
* Measurement window is 60 ns to 200 ns, i.e. 55 ns after release -- more
* than ten periods of the slowest ring measured anywhere in the grid.
*
* Edge retention uses rising crossings 2 through 50 at xo rather than a
* whole-vector transition count: it is a rate over 48 intervals, it needs no
* vector-length arithmetic, and crossing 50 stays reachable inside the
* window even if the tree were swallowing half the edges. Crossing 1 is
* discarded as start-up.
*
* PVT: three (temp, supply) points, each bundling the tt/ss/ff process axis:
*   -40 degC / 1.62 V   the entropy-binding corner (ss). Slowest rings, so
*                       the widest edge spacing -- where retention should be
*                       highest and where the entropy requirement binds.
*    27 degC / 1.80 V   nominal
*   -40 degC / 1.98 V   the fastest rings measured anywhere in #10's grid
*                       (ff) -- the narrowest edge spacing, and also the
*                       corner sim/ro-array-operating-point/ found BINDS the
*                       combining bound. This is the hardest test of the
*                       combining tree, and where retention is expected to
*                       be WORST.
*
* This file is a TEMPLATE: sim/bin/corner-run.py substitutes x,
* tt, @@DESIGN@@ (pointed at design/ro_array_core.spice via
* --ro-ring5), 0, 1.8 and 5p. As committed it is not a
* runnable deck.

.option scale=1u

* per-ring supplies, one source per ring so each current is separable
Vddr1 vddr1 0 dc 1.8
Vddr2 vddr2 0 dc 1.8
Vddr3 vddr3 0 dc 1.8
Vddr4 vddr4 0 dc 1.8
* block supply: combining tree + the four ring output buffers
Vdd vdd 0 dc 1.8

* enables: held low through the DC solution, released together at 5 ns
Ven1 en1 0 PULSE(0 1.8 5n 100p 100p 1u 2u)
Ven2 en2 0 PULSE(0 1.8 5n 100p 100p 1u 2u)
Ven3 en3 0 PULSE(0 1.8 5n 100p 100p 1u 2u)
Ven4 en4 0 PULSE(0 1.8 5n 100p 100p 1u 2u)

xdut en1 en2 en3 en4 vddr1 vddr2 vddr3 vddr4 vdd 0 xo ro1 ro2 ro3 ro4 ro_array_core

* shift knobs (volts), swept by klt sim supply_v alter; see aging.py
Vdvn vth_dvn 0 dc 0
Vdvp vth_dvp 0 dc 0
