* raw_bit digitization -- noise-injected, assembled ro_array_core + sampler_dff
*
* Purpose: issue #21. Every other sim/ record in this repo measures ring
* period/swing/jitter statistics (sigma_1, T_0) or deterministic (noise-off)
* currents; none of them actually digitizes a bit. This deck drives all
* four rings of the committed N = 4 array (design/xschem/ro_array_core.sch,
* DR-0003's operating point) with per-stage injected transient noise, feeds
* the combined XOR-tree output through the committed sampler_dff, and reads
* back a run of raw bits -- the first raw-bitstream evidence this repo has.
*
* METHOD: rings built IN PLACE, not through the committed ro_ring5 subckt
* -----------------------------------------------------------------------
* design/sampler_core.spice's ro_ring5 subckt hides its internal per-stage
* nodes inside a .subckt boundary, so a top-level trnoise() source cannot
* be inserted in series with them without editing that GENERATED,
* --check-guarded file (design/README.md: "Do not edit by hand"). This
* deck instead follows sim/ro-ring-jitter-accumulation/testbench/
* tb_ro_ring5_jitter.spice's own precedent exactly: it builds each ring
* from the SAME primitives (ro_nand2, ro_stage), in place at the top
* level, with an explicit trnoise() voltage source in series with every
* stage's input (5 sources per ring, matching that testbench's own
* topology and this repo's only prior working noise-injection pattern).
* Everything downstream of the four ring outputs -- ro_buf, the xor2
* combining tree, sampler_dff -- is pulled unmodified from
* design/sampler_core.spice via @@RO_RING5@@ (corner-run.py's
* --ro-ring5 override points this at sampler_core.spice for this deck;
* see this file's own template-placeholder note at the bottom). This
* deck never redefines ro_nand2/ro_stage/ro_buf/xor2/sampler_dff -- it
* only skips instantiating sampler_core.spice's own ro_ring5/ro_array_core/
* sampler_core wrapper subckts, which is why no duplicate-subckt error
* results from combining the two.
*
* THE OPEN TECHNICAL QUESTION THIS DECK RESOLVES (issue #21 curation)
* ---------------------------------------------------------------------
* "How to inject seeded transient noise into a .tran run of the assembled
* ring array in ngspice (trannoise vs. an explicit injected noise source)."
* This checkout's ngspice-46 build has NO device-level transient-noise
* option at all (confirmed by tb_ro_ring5_jitter.spice's own header during
* issue #10 -- a purely deterministic .tran of a ring, zero injected
* sources, converges to a bit-exact repeating period with zero seed
* sensitivity). There is therefore no "trannoise vs explicit source"
* choice to make on THIS build: explicit per-stage trnoise() voltage
* sources are the only mechanism this ngspice offers, and this repo
* already validated that exact mechanism in issue #10's own campaign.
* This deck's only genuinely new contribution is applying that mechanism
* to all FOUR rings of the assembled array simultaneously (rather than one
* ring in isolation) and running the injected array through the real
* digitizing sampler (sampler_dff) instead of stopping at a jitter
* estimator -- i.e. closing the gap from "the noise mechanism exists and
* is measurable" (issue #9/#10) to "here is an actual bit".
*
* START-UP: `.ic` + `uic`, NOT AN ENABLE/RESET-RELEASE TRANSIENT
* ---------------------------------------------------------------------
* This is the single most expensive lesson of this deck's own development,
* and worth stating plainly since it contradicts the enable-release method
* `sim/ro-array-core-combining/testbench/tb_ro_array_core.spice` uses for
* the same assembled array: a `trnoise()` source in THIS ngspice-46 build
* cannot coexist with ANY transient control-signal breakpoint (a `PULSE`
* or `PWL` edge on `en`/`rst_n`, timed to release the array from a held-off
* state) anywhere else in the same circuit, regardless of how that edge is
* shaped. Every variant tried failed identically
* (`ngspice: "Timestep too small... trouble with node vclk#branch"`, always
* reported against `clk`'s own branch regardless of which OTHER signal
* was actually transitioning, which was the first sign this was a
* solver/breakpoint interaction rather than a modeling error in this
* deck's own circuit): releasing enable and reset together in one 200 ps
* edge; releasing them separated and slowed to 2-10 ns each; switching the
* integration method to `gear`; relaxing `trtol`/`itl4`. Removing the
* `trnoise()` sources entirely (`--noise-amp 0`, i.e. literal `trnoise(0
* ...)` still instantiated) did NOT fail -- confirming the interaction is
* between the mere PRESENCE of a `trnoise()`-bearing source and a later
* breakpoint elsewhere in the circuit, not a value the noise source
* injects. `tb_ro_array_core.spice` avoids this because it never
* instantiates `trnoise()` at all (it is a deterministic, noise-off
* combining-fidelity check); every OTHER `trnoise()` deck already
* committed in this repo (`tb_ro_ring5_jitter.spice`,
* `tb_ro_ring11_jitter.spice`, `tb_ro_ring5_swing_current.spice`) avoids it
* from the opposite direction -- none of them has ANY transient
* control-signal edge at all (every supply/enable is a bare `dc` source),
* which is now understood to be why, not merely a stylistic match to
* `.ic`/`uic`.
*
* This deck's fix: hold `en1..en4` and `rst_n` at `dc @@VDD@@` for the
* ENTIRE run (rings always enabled, sampler never reset -- no transient
* edge on any control signal except the sample clock itself, which is
* unavoidable) and give the four rings' own internal nodes explicit `.ic`
* values, exactly `tb_ro_ring5_jitter.spice`'s own per-ring `.ic` ladder,
* to kick each ring out of its symmetric DC operating point and into
* oscillation from `t = 0` under `uic`.
*
* The six `sampler_dff` instances need the SAME treatment, for the same
* reason: each is a transmission-gate master/slave latch built from
* cross-coupled keeper structures (the `mb`/`qb` pairs), and `uic`'s
* implicit 0 V on every one of those internal nodes is a symmetric,
* not-necessarily-consistent starting point for a bistable feedback
* network -- exactly the ring's own problem, one level down. This was NOT
* obvious up front: an earlier version of this deck left the samplers at
* their `uic` default and found (in this deck's own development) that
* `raw_bit` read a constant ~`@@VDD@@` at every one of 24 samples despite
* `v(xo)` -- `raw_bit`'s own `D` input -- reading near 0 V at those same
* instants. Giving the RINGS an asymmetry-breaking `.ic` was not enough to
* unstick a flip-flop whose OWN internal nodes had no comparable kick. The
* fix (below, at the sampler instances) gives each one an explicit `.ic`
* matching a valid, physically-consistent state for the topology -- the
* exact reset-state operating point ngspice's own DC solver produced for
* `sampler_dff` when `rst_n` was still driven low (measured directly during
* this deck's development, before the enable/reset-release method above
* was abandoned) -- so every instance starts as if a reset pulse had just
* released at `t = 0`, even though `rst_n` itself never moves for the rest
* of the run. One real consequence: this deck has no start-up RESET
* SEQUENCE, only a reset-shaped INITIAL CONDITION -- `raw_valid`/`raw_bit`
* start from that state and evolve under `D`/`clk` from `t = 0`, not
* through an observable reset-release event. That is an acceptable
* simplification for a min-entropy point-estimate campaign (this issue's
* scope), not a claim that this is how `trng_top`/`digital/`'s own reset
* sequencing should be modeled.
*
* WHY Ts = 100 ns, NOT DR-0003's Ts = 20 us -- A MEASURED, DISCLOSED
* COMPUTE-BUDGET DEVIATION (read this before citing any H below)
* ---------------------------------------------------------------------
* DR-0003 specifies a 50 kHz sample clock (Ts = 20 us) precisely so ~4000
* periods of the slowest ring elapse between samples, which is what the
* array's sizing law assumes when it promises H0 = 0.5 bit/sample at that
* corner. `sim/ro-array-core-combining/`'s own measured per-ring periods
* for this exact assembled array (buffer-loaded, N = 4) run 2.0-3.6 ns
* across the tt/ss/ff corners -- so running DR-0003's literal Ts on a
* deck that also carries 4 rings x 5 series trnoise() sources, the
* combining tree and the sampler was benchmarked directly ahead of
* committing this deck at ~46 s fixed ngspice/PDK-library startup cost
* plus ~0.12 s of wall clock per additional simulated nanosecond (measured
* on this campaign's development machine, ngspice-46, sky130A c6d73a35,
* TMAX = 5p, this exact 4-ring + combiner + sampler circuit -- see this
* issue's PR description for the raw calibration runs, and note the
* shared-machine caveat there: observed wall clock on a contended host
* ran several times slower than this per-run figure alone predicts). One
* raw bit at the literal Ts = 20 us therefore costs tens of minutes of
* wall clock by itself, before any second bit; a "run of raw bits" (this
* issue's own acceptance-criteria phrase) of even a few dozen bits per PVT
* corner would cost hours per corner, times three corners -- genuinely
* outside this issue's practical simulation budget on the available
* hardware.
*
* This deck instead runs at Ts = 100 ns -- 200x shorter than DR-0003's
* operating point -- solely to make a non-degenerate, multi-bit raw
* sequence computationally tractable within that budget. At the measured
* 2.0-3.6 ns ring periods above, ~28-50 ring periods elapse per sample at
* this Ts -- still comfortably enough for the four rings' own frequency
* ladder, DR-0003's wstv = 0.42/0.44/0.46/0.48 skew, to sweep the
* combining tree through many relative phases between samples, with the
* injected per-stage noise perturbing exactly where in that sweep any
* given sample lands.
*
* CONSEQUENCE FOR WHAT THIS RECORD MAY BE CITED FOR: because the sizing
* law's own Q_ring = sigma_1^2 * Ts / T0^3 is LINEAR in Ts, a min-entropy
* point estimate read off THIS Ts is a measurement of a shorter-window,
* HIGHER-rate hypothetical sampler, not of the real 50 kHz design point.
* It is real, noise-driven, digitized evidence from the literal committed
* array (same N = 4, same devices, same per-corner PVT), which is exactly
* what acceptance criterion (a) asks for and what this repo's README has
* had zero of until now -- but it is NOT a substitute for a future,
* better-resourced campaign that runs the literal Ts = 20 us and would be
* needed before this evidence could support any claim about the actual
* DR-0003 operating point's H. sim/raw-bit-min-entropy/analysis/
* raw-bit-entropy.py's own record output repeats this caveat in machine-
* readable form so no downstream consumer can miss it.
*
* WHAT THIS DECK DOES NOT CLAIM: an SP 800-90B validation result of any
* kind. See spec/porting-plan.md's own citation of gf180-trng's DR-0004
* three-tier claim-discipline carryover -- this is Tier 2 at best (a
* labelled, bounded, simulation-derived DESIGN ESTIMATE), never Tier 3
* (validation, which is deferred to measured silicon per this repo's own
* CLAUDE.md standing caveat).
*
* trnoise() calibration: identical to tb_ro_ring5_jitter.spice's own
* anchor (NA = @@NA@@ V rms, NT = 2e-10 s), i.e. the same fixed injection
* level anchored to sim/ro-stage-noise-mechanism-check/'s measured
* near-oscillation-band noise density. CAVEAT: same fixed-injection-level
* caveat as every other campaign in this repo (good to ~1.5-2x, not
* re-measured per corner).
*
* Single seed per corner (@@SEED@@), held across the whole continuous run
* -- every bit below shares ONE noise realization per corner, exactly the
* "one seed per PVT point" limitation sim/README.md's own campaign summary
* already discloses for this repo's other transient-noise decks. This is
* NOT the same as N independent Monte-Carlo draws; the standard error the
* reduction script reports is the sample-count-limited MCV interval over
* CORRELATED-noise-trajectory bits, not N independent trials. Read the
* reduction record's own caveats before citing the SE.
*
* Digitization: v(raw_bit) is measured 1/4 of the way through each Ts
* window, i.e. `k*Ts + 0.25*Ts` -- inside `clk`'s HIGH plateau (the
* master's LATCHED, not transparent, phase; see the `clk` waveform note
* above), comfortably clear of both the rising edge that just captured a
* new value and the falling edge that starts the next transparent window
* -- via a `meas tran bit$&k find v(raw_bit) at=<time>` loop, one
* measurement per sample, printed as `bitK = <volts>` -- the generic
* `NAME = VALUE` capture sim/bin/corner-run.py already performs for every
* deck, so no harness change is needed to pull these back into the
* record's JSON. sim/raw-bit-min-entropy/analysis/raw-bit-entropy.py
* thresholds each at 0.5 x Vdd to recover the 0/1 sequence.
*
* This file is a TEMPLATE: sim/bin/corner-run.py substitutes @@PDK_LIB@@,
* @@CORNER@@, @@RO_RING5@@ (pointed at design/sampler_core.spice via
* --ro-ring5, for its ro_nand2/ro_stage/ro_buf/xor2/sampler_dff
* primitives), @@TEMP@@, @@VDD@@, @@SEED@@, @@NA@@ and @@TMAX@@. As
* committed here it is not a runnable deck.

.option scale=1u
.lib "@@PDK_LIB@@" @@CORNER@@

.include "@@RO_RING5@@"

.temp @@TEMP@@
.option seed=@@SEED@@

Vdd vdd 0 dc @@VDD@@
Vddr1 vddr1 0 dc @@VDD@@
Vddr2 vddr2 0 dc @@VDD@@
Vddr3 vddr3 0 dc @@VDD@@
Vddr4 vddr4 0 dc @@VDD@@

* enables + reset: held at their ACTIVE state for the entire run -- no
* transient edge on either, ever (see this file's own header for why any
* control-signal breakpoint here is fatal once trnoise() sources are also
* present in this ngspice build). Rings start oscillating from t = 0 via
* their own .ic below, not via an enable-release event.
Ven1 en1 0 dc @@VDD@@
Ven2 en2 0 dc @@VDD@@
Ven3 en3 0 dc @@VDD@@
Ven4 en4 0 dc @@VDD@@
Vrstn rst_n 0 dc @@VDD@@

* --- ring 1, wstv = 0.42 (DR-0003 ladder) ---
xg1 gA1 en1 n11 vddr1 0 ro_nand2 wstv=0.42
VnA1 gA1 ro1raw 0 dc 0 trnoise(@@NA@@ 2e-10 0 0)
x11 gB1 n21 vddr1 0 ro_stage wstv=0.42
VnB1 gB1 n11 0 dc 0 trnoise(@@NA@@ 2e-10 0 0)
x21 gC1 n31 vddr1 0 ro_stage wstv=0.42
VnC1 gC1 n21 0 dc 0 trnoise(@@NA@@ 2e-10 0 0)
x31 gD1 n41 vddr1 0 ro_stage wstv=0.42
VnD1 gD1 n31 0 dc 0 trnoise(@@NA@@ 2e-10 0 0)
x41 gE1 ro1raw vddr1 0 ro_stage wstv=0.42
VnE1 gE1 n41 0 dc 0 trnoise(@@NA@@ 2e-10 0 0)
.ic v(ro1raw)=0 v(n11)=@@VDD@@ v(n21)=0 v(n31)=@@VDD@@ v(n41)=0

* --- ring 2, wstv = 0.44 ---
xg2 gA2 en2 n12 vddr2 0 ro_nand2 wstv=0.44
VnA2 gA2 ro2raw 0 dc 0 trnoise(@@NA@@ 2e-10 0 0)
x12 gB2 n22 vddr2 0 ro_stage wstv=0.44
VnB2 gB2 n12 0 dc 0 trnoise(@@NA@@ 2e-10 0 0)
x22 gC2 n32 vddr2 0 ro_stage wstv=0.44
VnC2 gC2 n22 0 dc 0 trnoise(@@NA@@ 2e-10 0 0)
x32 gD2 n42 vddr2 0 ro_stage wstv=0.44
VnD2 gD2 n32 0 dc 0 trnoise(@@NA@@ 2e-10 0 0)
x42 gE2 ro2raw vddr2 0 ro_stage wstv=0.44
VnE2 gE2 n42 0 dc 0 trnoise(@@NA@@ 2e-10 0 0)
.ic v(ro2raw)=0 v(n12)=@@VDD@@ v(n22)=0 v(n32)=@@VDD@@ v(n42)=0

* --- ring 3, wstv = 0.46 ---
xg3 gA3 en3 n13 vddr3 0 ro_nand2 wstv=0.46
VnA3 gA3 ro3raw 0 dc 0 trnoise(@@NA@@ 2e-10 0 0)
x13 gB3 n23 vddr3 0 ro_stage wstv=0.46
VnB3 gB3 n13 0 dc 0 trnoise(@@NA@@ 2e-10 0 0)
x23 gC3 n33 vddr3 0 ro_stage wstv=0.46
VnC3 gC3 n23 0 dc 0 trnoise(@@NA@@ 2e-10 0 0)
x33 gD3 n43 vddr3 0 ro_stage wstv=0.46
VnD3 gD3 n33 0 dc 0 trnoise(@@NA@@ 2e-10 0 0)
x43 gE3 ro3raw vddr3 0 ro_stage wstv=0.46
VnE3 gE3 n43 0 dc 0 trnoise(@@NA@@ 2e-10 0 0)
.ic v(ro3raw)=0 v(n13)=@@VDD@@ v(n23)=0 v(n33)=@@VDD@@ v(n43)=0

* --- ring 4, wstv = 0.48 ---
xg4 gA4 en4 n14 vddr4 0 ro_nand2 wstv=0.48
VnA4 gA4 ro4raw 0 dc 0 trnoise(@@NA@@ 2e-10 0 0)
x14 gB4 n24 vddr4 0 ro_stage wstv=0.48
VnB4 gB4 n14 0 dc 0 trnoise(@@NA@@ 2e-10 0 0)
x24 gC4 n34 vddr4 0 ro_stage wstv=0.48
VnC4 gC4 n24 0 dc 0 trnoise(@@NA@@ 2e-10 0 0)
x34 gD4 n44 vddr4 0 ro_stage wstv=0.48
VnD4 gD4 n34 0 dc 0 trnoise(@@NA@@ 2e-10 0 0)
x44 gE4 ro4raw vddr4 0 ro_stage wstv=0.48
VnE4 gE4 n44 0 dc 0 trnoise(@@NA@@ 2e-10 0 0)
.ic v(ro4raw)=0 v(n14)=@@VDD@@ v(n24)=0 v(n34)=@@VDD@@ v(n44)=0

* --- buffers + XOR combining tree, exactly as design/ro_array_core.spice wires them ---
xb1 ro1raw ro1 vdd 0 ro_buf
xb2 ro2raw ro2 vdd 0 ro_buf
xb3 ro3raw ro3 vdd 0 ro_buf
xb4 ro4raw ro4 vdd 0 ro_buf
xa1 ro1 ro2 t1 vdd 0 xor2
xa2 ro3 ro4 t2 vdd 0 xor2
xa3 t1 t2 xo vdd 0 xor2

* --- sample clock: Ts = 100 ns (see header -- a disclosed, measured
* compute-budget deviation from DR-0003's Ts = 20 us), a proper ~50% duty
* cycle square wave -- an earlier draft of this line used PW = 99.8n (so
* TR+PW+TF summed to exactly one whole period, i.e. clk sat at @@VDD@@
* essentially the ENTIRE period with only an instantaneous ~200 ps return
* to 0 V once per cycle). That gave sampler_dff's master stage almost no
* time to track a fast-moving D before the transparent window closed
* again, and was the actual root cause of a THIRD failure mode found
* during this deck's own development (after the two above): raw_bit
* stayed within a few hundred mV of 0 V for an entire 500 ns diagnostic
* window despite v(xo) -- its own D input -- genuinely toggling ~900 times
* over that same window (confirmed by a raw v(xo)/v(raw_bit)/v(clk)
* `wrdata` dump). PW = 49.8n below gives clk a real ~50 ns transparent
* phase and a real ~50 ns latched phase each period.
Vclk clk 0 PULSE(0 @@VDD@@ 0 100p 100p 49.8n 100n)

* --- the committed sampler_dff, unmodified, at every tap design/sampler_core.spice defines ---
xsb xo clk rst_n raw_bit vdd 0 sampler_dff
xsv vdd clk rst_n raw_valid vdd 0 sampler_dff
xsr1 ro1 clk rst_n ring_bit1 vdd 0 sampler_dff
xsr2 ro2 clk rst_n ring_bit2 vdd 0 sampler_dff
xsr3 ro3 clk rst_n ring_bit3 vdd 0 sampler_dff
xsr4 ro4 clk rst_n ring_bit4 vdd 0 sampler_dff

* The six sampler_dff instances also need explicit .ic values for their own
* internal nodes -- see this file's own header ("START-UP" section) for why
* and for what was tried before landing here. Values below are the
* reset-state operating point ngspice's own DC solver produced for
* sampler_dff at rst_n = 0, i.e. every instance starts as if a reset pulse
* had just released at t = 0, even though rst_n itself never moves.
.ic v(xsb.m)=0 v(xsb.mb)=@@VDD@@ v(xsb.mmid)=0 v(xsb.mc)=0 v(xsb.s)=@@VDD@@
+ v(xsb.qb)=@@VDD@@ v(xsb.s2mid)=0 v(xsb.clkb)=@@VDD@@
+ v(xsv.m)=0 v(xsv.mb)=@@VDD@@ v(xsv.mmid)=0 v(xsv.mc)=0 v(xsv.s)=@@VDD@@
+ v(xsv.qb)=@@VDD@@ v(xsv.s2mid)=0 v(xsv.clkb)=@@VDD@@
+ v(xsr1.m)=0 v(xsr1.mb)=@@VDD@@ v(xsr1.mmid)=0 v(xsr1.mc)=0 v(xsr1.s)=@@VDD@@
+ v(xsr1.qb)=@@VDD@@ v(xsr1.s2mid)=0 v(xsr1.clkb)=@@VDD@@
+ v(xsr2.m)=0 v(xsr2.mb)=@@VDD@@ v(xsr2.mmid)=0 v(xsr2.mc)=0 v(xsr2.s)=@@VDD@@
+ v(xsr2.qb)=@@VDD@@ v(xsr2.s2mid)=0 v(xsr2.clkb)=@@VDD@@
+ v(xsr3.m)=0 v(xsr3.mb)=@@VDD@@ v(xsr3.mmid)=0 v(xsr3.mc)=0 v(xsr3.s)=@@VDD@@
+ v(xsr3.qb)=@@VDD@@ v(xsr3.s2mid)=0 v(xsr3.clkb)=@@VDD@@
+ v(xsr4.m)=0 v(xsr4.mb)=@@VDD@@ v(xsr4.mmid)=0 v(xsr4.mc)=0 v(xsr4.s)=@@VDD@@
+ v(xsr4.qb)=@@VDD@@ v(xsr4.s2mid)=0 v(xsr4.clkb)=@@VDD@@
+ v(raw_bit)=0 v(raw_valid)=0
+ v(ring_bit1)=0 v(ring_bit2)=0 v(ring_bit3)=0 v(ring_bit4)=0

* 24 raw bits x Ts = 100 ns = 2.4 us, plus a little tail room -- NBITS/TSTOP
* are deliberately deck literals, not @@...@@ substitutions:
* sim/bin/corner-run.py's template placeholders (see its module docstring)
* are the PVT/tool axes that vary per invocation; the bit count and stop
* time are a property of THIS deck's own compute-budget choice (see
* header) and are identical on every corner, so hardcoding them keeps
* corner-run.py's fixed substitution set untouched, per this issue's
* curation guidance to extend it only if it cannot already drive this run
* (it can).
.tran @@TMAX@@ 2.5u uic

* Restrict what ngspice keeps in memory across the run to only the nodes
* this deck's own .control block actually measures: with 4 rings' worth of
* internal per-stage nodes plus 6 sampler_dff instances' internal nodes,
* the DEFAULT "save everything" behavior over a 2.5 us / few-picosecond-step
* transient was observed to exhaust available memory during this deck's own
* development (`ngspice: "memory required... is more than memory
* available"`) on a heavily-loaded shared host -- unrelated to this
* circuit's own correctness (an isolated, less memory-pressured re-run of
* the identical deck got much further before hitting the same generic
* error). Saving only what is read below is a real reduction in this
* deck's memory footprint regardless of host contention, not a workaround
* for a modeling bug.
.save v(raw_bit) v(raw_valid) v(ro1)

.control
run
let nbits = 24
let ts = 100n
let k = 0
while k < nbits
  let tmeas = k * ts + 0.25 * ts
  meas tran bit$&k find v(raw_bit) at=$&tmeas
  meas tran valid$&k find v(raw_valid) at=$&tmeas
  let k = k + 1
end
* health check: confirm ring 1 actually oscillated (swing near full rail),
* not stuck at a rail from a wiring error
meas tran ro1_max MAX v(ro1) from=1u to=2.5u
meas tran ro1_min MIN v(ro1) from=1u to=2.5u
let ro1_swing_frac = (ro1_max - ro1_min) / @@VDD@@
print ro1_swing_frac
.endc
.end
