* Post-layout sampler_dff: the SETUP-TIME bracket -- how far ahead of the
* sampling clock edge the data input must settle for the bit to be captured
* -- extracted parasitics vs. the pre-layout netlist, in ONE deck.
*
* Purpose. The companion deck in this slug
* (tb_post_layout_sampler_dff.spice) measures what the sampler does AFTER
* the edge (clk -> q delay, output levels, reset/idle/active currents). This
* one measures the window BEFORE it. For a TRNG that is the more
* consequential of the two: the raw bit is whatever the combining node
* happens to be doing inside this window, so the window's width is a
* property of the digitizer that any later raw-bit or min-entropy claim
* rests on. sim/raw-bit-min-entropy/ digitizes through this exact cell and
* has never measured it.
*
* Method: a LADDER, not a bisection. Twenty-four DFFs run in one transient
* -- twelve post-layout, twelve pre-layout -- sharing one clock whose single
* rising edge is at 50 ns, each fed by its OWN d source whose 0 -> 1
* transition is centred a different distance ahead of that edge:
*
*     3200, 800, 260, 215, 180, 150, 125, 105, 88, 73, 60, 45 ps
*
* ("centred": each PWL edge takes 100 ps, and the offset is measured
* between the two signals' 50% crossings, so a rung's label IS the setup
* time it offers.) After the run, v(q) is read in a settled window after the
* edge: an instance that captured reads ~Vdd, one that did not reads ~0.
* The setup time is bracketed between the smallest rung that captured and
* the largest that did not, per side, per corner, from one transient.
*
* Why these twelve rungs. The two wide anchors (3200 and 800 ps) exist to
* show the ladder saturating -- a run where even they fail to capture is a
* broken deck, not a fast cell. The other ten are spaced ~1.2x apart across
* 45..260 ps, which is the band the boundary actually falls in: a scouting
* run of an earlier, purely geometric (factor-of-two) version of this deck
* put it between 50 and 100 ps at both tt/27 degC/1.8 V and
* ff/125 degC/1.98 V, and between 100 and 200 ps at ss/-40 degC/1.62 V.
* The factor-of-two ladder was too coarse to separate the post-layout cell
* from its own pre-layout control at any of the three -- both sides landed
* in the same rung -- which is the whole point of running them in one deck,
* hence this spacing.
*
* Deliberately NOT a metastability measurement.
* spec/porting-plan.md carries DR-0011's judgment that full resolution-time
* statistics are "not credibly reproducible in a general-purpose transient
* solver", and that judgment is tool-general rather than PDK-specific. What
* is measured here is a DETERMINISTIC timing property -- captured or not
* captured, at a stated offset -- and nothing about resolution time,
* failure probability, or the shape of the boundary is claimed. A rung that
* lands close enough to the boundary to read back an intermediate level is
* reported as exactly that: an intermediate level at a stated offset.
*
* Topology, parasitic scope, substrate tie, stimulus idealization and the
* pre-layout-control-in-the-same-deck argument are all identical to the
* companion deck -- see tb_post_layout_sampler_dff.spice's header, which
* states them in full, including why an ideal PWL stimulus makes every
* post-layout figure here a FLOOR on the real cost rather than the whole of
* it.
*
* The waveform (ns):
*
*    0 .. 10   rst_n = 0, clk = 0, every d = 0    reset; all q = 0
*   10         rst_n 0 -> 1                       released, master
*                                                 transparent (clk = 0)
*   46.8 .. 50.055                                each d rises, one rung
*                                                 each -- see the ladder
*   50        clk 0 -> 1                          THE sampling edge; the
*                                                 slave captures whatever
*                                                 the master settled to
*   50 .. 56  clk held high                       master opaque, so a d
*                                                 that arrived too late
*                                                 cannot leak through after
*                                                 the fact; q read over
*                                                 54 .. 56 ns
*
* PVT: the same four (temp, supply) points as every post-layout campaign in
* this repo, each bundling tt/ss/ff into one record.
*
* This file is a TEMPLATE: sim/bin/corner-run.py substitutes @@PDK_LIB@@,
* @@CORNER@@, @@RO_RING5@@ (design/sampler_core.spice), @@PEX_LIB@@
* (layout/pex/sampler_dff_pex.spice), @@TEMP@@, @@VDD@@ and @@TMAX@@. As
* committed it is not a runnable deck.

.option scale=1u
.lib "@@PDK_LIB@@" @@CORNER@@

.include "@@RO_RING5@@"
.include "@@PEX_LIB@@"

.temp @@TEMP@@

* --- substrate return node: hard tie (see the companion deck's header) --
Vsub vsubs 0 dc 0

*-----------------------------------------------------------------------
* The post-layout sampler_dff, assembled from extracted leaf cells.
* Identical to the companion deck's subcircuit; every port assignment is
* annotated there with the design/sampler_core.spice device it reproduces.
*-----------------------------------------------------------------------
.subckt sampler_dff_pex d clk rst_n q vdd vss
xinv_clk clk    clkb   vdd vss           sampler_inv_pex
xtg_d    d      m      clk  clkb vdd vss sampler_tg_pex
xnand_m  m      rst_n  mb   vdd  vss     sampler_nand2_pex
xinv_mc  mb     mc     vdd vss           sampler_inv_pex
xtg_fbm  mc     m      clkb clk  vdd vss sampler_tg_pex
xtg_s    mb     s      clkb clk  vdd vss sampler_tg_pex
xinv_q   s      q      vdd vss           sampler_inv_pex
xnand_s2 q      rst_n  qb   vdd  vss     sampler_nand2_pex
xtg_fbs  qb     s      clk  clkb vdd vss sampler_tg_pex
.ends

* --- shared clock and reset --------------------------------------------
* One rising edge, at 50 ns, held high to the end of the run.
Vclk clk 0 PWL(0 0  50n 0  50.1n @@VDD@@)
Vrstn rst_n 0 PWL(0 0  10n 0  10.1n @@VDD@@)

* --- the setup ladder: one d source per rung ----------------------------
* Each edge takes 100 ps and its 50% crossing precedes the clock's 50%
* crossing (50.05 ns) by exactly the rung's offset.
Vd1 d1 0 PWL(0 0  46.8n 0  46.9n @@VDD@@)
Vd2 d2 0 PWL(0 0  49.2n 0  49.3n @@VDD@@)
Vd3 d3 0 PWL(0 0  49.74n 0  49.84n @@VDD@@)
Vd4 d4 0 PWL(0 0  49.785n 0  49.885n @@VDD@@)
Vd5 d5 0 PWL(0 0  49.82n 0  49.92n @@VDD@@)
Vd6 d6 0 PWL(0 0  49.85n 0  49.95n @@VDD@@)
Vd7 d7 0 PWL(0 0  49.875n 0  49.975n @@VDD@@)
Vd8 d8 0 PWL(0 0  49.895n 0  49.995n @@VDD@@)
Vd9 d9 0 PWL(0 0  49.912n 0  50.012n @@VDD@@)
Vd10 d10 0 PWL(0 0  49.927n 0  50.027n @@VDD@@)
Vd11 d11 0 PWL(0 0  49.94n 0  50.04n @@VDD@@)
Vd12 d12 0 PWL(0 0  49.955n 0  50.055n @@VDD@@)

* --- twelve post-layout DFFs, one per rung ------------------------------
* One shared supply source on each side: this deck measures timing, not
* current (the companion deck owns the per-cell current measurements).
Vddp vddp 0 dc @@VDD@@
xp1 d1 clk rst_n qp1 vddp 0 sampler_dff_pex
xp2 d2 clk rst_n qp2 vddp 0 sampler_dff_pex
xp3 d3 clk rst_n qp3 vddp 0 sampler_dff_pex
xp4 d4 clk rst_n qp4 vddp 0 sampler_dff_pex
xp5 d5 clk rst_n qp5 vddp 0 sampler_dff_pex
xp6 d6 clk rst_n qp6 vddp 0 sampler_dff_pex
xp7 d7 clk rst_n qp7 vddp 0 sampler_dff_pex
xp8 d8 clk rst_n qp8 vddp 0 sampler_dff_pex
xp9 d9 clk rst_n qp9 vddp 0 sampler_dff_pex
xp10 d10 clk rst_n qp10 vddp 0 sampler_dff_pex
xp11 d11 clk rst_n qp11 vddp 0 sampler_dff_pex
xp12 d12 clk rst_n qp12 vddp 0 sampler_dff_pex

* --- twelve pre-layout control DFFs, the same ladder --------------------
Vddq vddq 0 dc @@VDD@@
xq1 d1 clk rst_n qq1 vddq 0 sampler_dff
xq2 d2 clk rst_n qq2 vddq 0 sampler_dff
xq3 d3 clk rst_n qq3 vddq 0 sampler_dff
xq4 d4 clk rst_n qq4 vddq 0 sampler_dff
xq5 d5 clk rst_n qq5 vddq 0 sampler_dff
xq6 d6 clk rst_n qq6 vddq 0 sampler_dff
xq7 d7 clk rst_n qq7 vddq 0 sampler_dff
xq8 d8 clk rst_n qq8 vddq 0 sampler_dff
xq9 d9 clk rst_n qq9 vddq 0 sampler_dff
xq10 d10 clk rst_n qq10 vddq 0 sampler_dff
xq11 d11 clk rst_n qq11 vddq 0 sampler_dff
xq12 d12 clk rst_n qq12 vddq 0 sampler_dff

* --- output load: one inverter per DFF, matched per side ----------------
Vddl vddl 0 dc @@VDD@@
xlp1 qp1 qpb1 vddl 0 sampler_inv_pex
xlp2 qp2 qpb2 vddl 0 sampler_inv_pex
xlp3 qp3 qpb3 vddl 0 sampler_inv_pex
xlp4 qp4 qpb4 vddl 0 sampler_inv_pex
xlp5 qp5 qpb5 vddl 0 sampler_inv_pex
xlp6 qp6 qpb6 vddl 0 sampler_inv_pex
xlp7 qp7 qpb7 vddl 0 sampler_inv_pex
xlp8 qp8 qpb8 vddl 0 sampler_inv_pex
xlp9 qp9 qpb9 vddl 0 sampler_inv_pex
xlp10 qp10 qpb10 vddl 0 sampler_inv_pex
xlp11 qp11 qpb11 vddl 0 sampler_inv_pex
xlp12 qp12 qpb12 vddl 0 sampler_inv_pex
xlq1 qq1 qqb1 vddl 0 ro_buf
xlq2 qq2 qqb2 vddl 0 ro_buf
xlq3 qq3 qqb3 vddl 0 ro_buf
xlq4 qq4 qqb4 vddl 0 ro_buf
xlq5 qq5 qqb5 vddl 0 ro_buf
xlq6 qq6 qqb6 vddl 0 ro_buf
xlq7 qq7 qqb7 vddl 0 ro_buf
xlq8 qq8 qqb8 vddl 0 ro_buf
xlq9 qq9 qqb9 vddl 0 ro_buf
xlq10 qq10 qqb10 vddl 0 ro_buf
xlq11 qq11 qqb11 vddl 0 ro_buf
xlq12 qq12 qqb12 vddl 0 ro_buf

.tran @@TMAX@@ 56n

.control
run

* --- captured level per rung, as a fraction of Vdd ---------------------
* Read in a settled window well after the edge. ~1 means the rung's setup
* time was sufficient, ~0 means it was not; anything in between means the
* rung sits close to the boundary and is reported as such, NOT as a
* metastability statistic (see the header).
meas tran vp1 AVG v(qp1) from=54n to=56n
meas tran vp2 AVG v(qp2) from=54n to=56n
meas tran vp3 AVG v(qp3) from=54n to=56n
meas tran vp4 AVG v(qp4) from=54n to=56n
meas tran vp5 AVG v(qp5) from=54n to=56n
meas tran vp6 AVG v(qp6) from=54n to=56n
meas tran vp7 AVG v(qp7) from=54n to=56n
meas tran vp8 AVG v(qp8) from=54n to=56n
meas tran vp9 AVG v(qp9) from=54n to=56n
meas tran vp10 AVG v(qp10) from=54n to=56n
meas tran vp11 AVG v(qp11) from=54n to=56n
meas tran vp12 AVG v(qp12) from=54n to=56n
meas tran vq1 AVG v(qq1) from=54n to=56n
meas tran vq2 AVG v(qq2) from=54n to=56n
meas tran vq3 AVG v(qq3) from=54n to=56n
meas tran vq4 AVG v(qq4) from=54n to=56n
meas tran vq5 AVG v(qq5) from=54n to=56n
meas tran vq6 AVG v(qq6) from=54n to=56n
meas tran vq7 AVG v(qq7) from=54n to=56n
meas tran vq8 AVG v(qq8) from=54n to=56n
meas tran vq9 AVG v(qq9) from=54n to=56n
meas tran vq10 AVG v(qq10) from=54n to=56n
meas tran vq11 AVG v(qq11) from=54n to=56n
meas tran vq12 AVG v(qq12) from=54n to=56n

* Named by the rung's own setup offset in picoseconds, so a record reads
* as the ladder it is.
let cap_pex_3200ps = vp1 / @@VDD@@
let cap_pex_800ps = vp2 / @@VDD@@
let cap_pex_260ps = vp3 / @@VDD@@
let cap_pex_215ps = vp4 / @@VDD@@
let cap_pex_180ps = vp5 / @@VDD@@
let cap_pex_150ps = vp6 / @@VDD@@
let cap_pex_125ps = vp7 / @@VDD@@
let cap_pex_105ps = vp8 / @@VDD@@
let cap_pex_88ps = vp9 / @@VDD@@
let cap_pex_73ps = vp10 / @@VDD@@
let cap_pex_60ps = vp11 / @@VDD@@
let cap_pex_45ps = vp12 / @@VDD@@
let cap_pre_3200ps = vq1 / @@VDD@@
let cap_pre_800ps = vq2 / @@VDD@@
let cap_pre_260ps = vq3 / @@VDD@@
let cap_pre_215ps = vq4 / @@VDD@@
let cap_pre_180ps = vq5 / @@VDD@@
let cap_pre_150ps = vq6 / @@VDD@@
let cap_pre_125ps = vq7 / @@VDD@@
let cap_pre_105ps = vq8 / @@VDD@@
let cap_pre_88ps = vq9 / @@VDD@@
let cap_pre_73ps = vq10 / @@VDD@@
let cap_pre_60ps = vq11 / @@VDD@@
let cap_pre_45ps = vq12 / @@VDD@@

print cap_pex_3200ps
print cap_pex_800ps
print cap_pex_260ps
print cap_pex_215ps
print cap_pex_180ps
print cap_pex_150ps
print cap_pex_125ps
print cap_pex_105ps
print cap_pex_88ps
print cap_pex_73ps
print cap_pex_60ps
print cap_pex_45ps
print cap_pre_3200ps
print cap_pre_800ps
print cap_pre_260ps
print cap_pre_215ps
print cap_pre_180ps
print cap_pre_150ps
print cap_pre_125ps
print cap_pre_105ps
print cap_pre_88ps
print cap_pre_73ps
print cap_pre_60ps
print cap_pre_45ps
.endc
.end
