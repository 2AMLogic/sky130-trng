* Post-layout ro_ring5: the four-ring wstv frequency ladder, extracted
* parasitics vs. the pre-layout netlist, in ONE deck.
*
* Purpose (issue #22, acceptance criterion 2). Every ro_ring5 number this
* repo has recorded so far comes from design/*.spice -- xschem's own
* schematic export, with no physical interconnect in it at all. This deck
* re-runs the same measurement against layout/pex/ro_ring5_pex.spice, the
* `klt extract --parasitics` netlist of the composed, DRC-clean and
* LVS-clean cells under layout/ (layout/bin/pex-netlist.py builds it from
* the committed GDS; layout/pex/README.md states exactly what its parasitic
* model contains).
*
* Why both rings are in ONE deck rather than compared across two records.
* The quantity of interest is a RATIO -- how much slower is the same ring
* once its own intra-cell parasitics are present -- and a ratio taken
* across two runs silently inherits every difference between them (corner
* section, temperature, solver settings, ngspice build, the estimator's own
* start-up transient). Running the pre-layout ring as a same-deck control
* at the same corner, same temperature, same supply, same timestep and the
* same measurement code makes the parasitic contribution the ONLY thing
* that differs between the two numbers this deck prints.
*
* Topology. Eight five-stage rings, built in place exactly as
* design/xschem/ro_ring5.sch wires one (ro_nand2 + 4 x ro_stage), on eight
* independent supply sources so each ring's own supply current is
* separately measurable:
*
*   p1..p4  POST-LAYOUT, wstv = 0.42 / 0.44 / 0.46 / 0.48 um -- one
*           physical cell per ring, the four distinct DRC/LVS-clean
*           layout cells under layout/ro_{stage,nand2}[_wstv0p4x]/.
*   q1..q4  PRE-LAYOUT control, the identical ladder from
*           design/ro_array_core.spice's parameterized .subckt.
*
* Every ring drives its own output buffer -- a post-layout ro_buf_pex for
* p1..p4, a pre-layout ro_buf for q1..q4 -- on one block supply per side,
* so no buffer's current contaminates a ring's own vddr.
* design/xschem/ro_array_core.sch wires a per-ring output buffer this way,
* and buffering ALL four rings rather than one is what makes the four
* periods a comparable ladder (see the buffer block below).
*
* The substrate tie. layout/pex/ro_ring5_pex.spice declares the
* extractor's substrate return node `vsubs` .global, and every
* net-to-substrate capacitance in every post-layout cell returns to it
* (see layout/bin/pex-netlist.py's docstring, and klayout-tools#1503 for
* why the extractor's own per-instance scoping cannot be used as-is). This
* deck ties it HARD to 0 -- the physically-motivated choice, since every
* composed cell carries its own psub guard ring tied to vss and vss is 0
* here. The complementary bound (vsubs left floating on the extractor's own
* 1 TOhm dc tie, which makes the shared substrate node an inter-ring
* coupling path) is measured by this slug's sibling testbench,
* tb_post_layout_substrate_float.spice.
*
* PVT: this deck is run at the same four (temp, supply) points
* sim/ro-ring5-swing-and-current/ used, each bundling the tt/ss/ff process
* axis into one record:
*   -40 degC / 1.62 V   the measured entropy-binding corner (ss)
*    27 degC / 1.80 V   nominal
*   125 degC / 1.98 V   the worst five-stage ring swing in #10's grid
*   -40 degC / 1.98 V   the fastest ring measured anywhere in that grid
*
* tstop is 160 ns, twice that deck's 80 ns, because the post-layout rings
* are slower and the period estimator needs 11 rising edges of the SLOWEST
* ring (wstv = 0.42, post-layout, ss / -40 degC / 1.62 V) to fit inside the
* window with start-up discarded.
*
* This file is a TEMPLATE: sim/bin/corner-run.py substitutes @@PDK_LIB@@,
* @@CORNER@@, @@RO_RING5@@, @@PEX_LIB@@, @@TEMP@@, @@VDD@@ and @@TMAX@@. As
* committed it is not a runnable deck.

.option scale=1u
.lib "@@PDK_LIB@@" @@CORNER@@

* pre-layout subcircuit library (ro_nand2 / ro_stage / ro_buf)
.include "@@RO_RING5@@"
* post-layout subcircuit library (ro_*_pex_*), generated from layout/
.include "@@PEX_LIB@@"

.temp @@TEMP@@

* --- substrate return node: hard tie (see header) ----------------------
Vsub vsubs 0 dc 0

* --- post-layout rings, one physical cell per wstv ---------------------
Vddrp1 vddrp1 0 dc @@VDD@@
Venp1 enp1 0 dc @@VDD@@
xgp1 p1o enp1 p1a vddrp1 0 ro_nand2_pex_wstv0p42
x1p1 p1a p1b vddrp1 0 ro_stage_pex_wstv0p42
x2p1 p1b p1c vddrp1 0 ro_stage_pex_wstv0p42
x3p1 p1c p1d vddrp1 0 ro_stage_pex_wstv0p42
x4p1 p1d p1o vddrp1 0 ro_stage_pex_wstv0p42

Vddrp2 vddrp2 0 dc @@VDD@@
Venp2 enp2 0 dc @@VDD@@
xgp2 p2o enp2 p2a vddrp2 0 ro_nand2_pex_wstv0p44
x1p2 p2a p2b vddrp2 0 ro_stage_pex_wstv0p44
x2p2 p2b p2c vddrp2 0 ro_stage_pex_wstv0p44
x3p2 p2c p2d vddrp2 0 ro_stage_pex_wstv0p44
x4p2 p2d p2o vddrp2 0 ro_stage_pex_wstv0p44

Vddrp3 vddrp3 0 dc @@VDD@@
Venp3 enp3 0 dc @@VDD@@
xgp3 p3o enp3 p3a vddrp3 0 ro_nand2_pex_wstv0p46
x1p3 p3a p3b vddrp3 0 ro_stage_pex_wstv0p46
x2p3 p3b p3c vddrp3 0 ro_stage_pex_wstv0p46
x3p3 p3c p3d vddrp3 0 ro_stage_pex_wstv0p46
x4p3 p3d p3o vddrp3 0 ro_stage_pex_wstv0p46

Vddrp4 vddrp4 0 dc @@VDD@@
Venp4 enp4 0 dc @@VDD@@
xgp4 p4o enp4 p4a vddrp4 0 ro_nand2_pex_wstv0p48
x1p4 p4a p4b vddrp4 0 ro_stage_pex_wstv0p48
x2p4 p4b p4c vddrp4 0 ro_stage_pex_wstv0p48
x3p4 p4c p4d vddrp4 0 ro_stage_pex_wstv0p48
x4p4 p4d p4o vddrp4 0 ro_stage_pex_wstv0p48

* --- pre-layout control rings, identical ladder ------------------------
Vddrq1 vddrq1 0 dc @@VDD@@
Venq1 enq1 0 dc @@VDD@@
xgq1 q1o enq1 q1a vddrq1 0 ro_nand2 wstv=0.42 lstv=2 cld=0.5f
x1q1 q1a q1b vddrq1 0 ro_stage wstv=0.42 lstv=2 cld=0.5f
x2q1 q1b q1c vddrq1 0 ro_stage wstv=0.42 lstv=2 cld=0.5f
x3q1 q1c q1d vddrq1 0 ro_stage wstv=0.42 lstv=2 cld=0.5f
x4q1 q1d q1o vddrq1 0 ro_stage wstv=0.42 lstv=2 cld=0.5f

Vddrq2 vddrq2 0 dc @@VDD@@
Venq2 enq2 0 dc @@VDD@@
xgq2 q2o enq2 q2a vddrq2 0 ro_nand2 wstv=0.44 lstv=2 cld=0.5f
x1q2 q2a q2b vddrq2 0 ro_stage wstv=0.44 lstv=2 cld=0.5f
x2q2 q2b q2c vddrq2 0 ro_stage wstv=0.44 lstv=2 cld=0.5f
x3q2 q2c q2d vddrq2 0 ro_stage wstv=0.44 lstv=2 cld=0.5f
x4q2 q2d q2o vddrq2 0 ro_stage wstv=0.44 lstv=2 cld=0.5f

Vddrq3 vddrq3 0 dc @@VDD@@
Venq3 enq3 0 dc @@VDD@@
xgq3 q3o enq3 q3a vddrq3 0 ro_nand2 wstv=0.46 lstv=2 cld=0.5f
x1q3 q3a q3b vddrq3 0 ro_stage wstv=0.46 lstv=2 cld=0.5f
x2q3 q3b q3c vddrq3 0 ro_stage wstv=0.46 lstv=2 cld=0.5f
x3q3 q3c q3d vddrq3 0 ro_stage wstv=0.46 lstv=2 cld=0.5f
x4q3 q3d q3o vddrq3 0 ro_stage wstv=0.46 lstv=2 cld=0.5f

Vddrq4 vddrq4 0 dc @@VDD@@
Venq4 enq4 0 dc @@VDD@@
xgq4 q4o enq4 q4a vddrq4 0 ro_nand2 wstv=0.48 lstv=2 cld=0.5f
x1q4 q4a q4b vddrq4 0 ro_stage wstv=0.48 lstv=2 cld=0.5f
x2q4 q4b q4c vddrq4 0 ro_stage wstv=0.48 lstv=2 cld=0.5f
x3q4 q4c q4d vddrq4 0 ro_stage wstv=0.48 lstv=2 cld=0.5f
x4q4 q4d q4o vddrq4 0 ro_stage wstv=0.48 lstv=2 cld=0.5f

* --- output buffers: one per ring, on a block supply per side ----------
* EVERY ring is buffered, post-layout and pre-layout alike. This is not
* decoration: design/xschem/ro_array_core.sch buffers all four rings, and
* an earlier revision of this deck that buffered only ring 1 made its own
* ladder metric meaningless -- the buffered ring ran ~18% slower than its
* unbuffered neighbours purely from the extra load, which reads as ladder
* span rather than as the loading it is. See sim/post-layout-ro-ring5's
* entry in sim/README.md.
Vddp vddp 0 dc @@VDD@@
xbp1 p1o p1ob vddp 0 ro_buf_pex
xbp2 p2o p2ob vddp 0 ro_buf_pex
xbp3 p3o p3ob vddp 0 ro_buf_pex
xbp4 p4o p4ob vddp 0 ro_buf_pex
Vddq vddq 0 dc @@VDD@@
xbq1 q1o q1ob vddq 0 ro_buf
xbq2 q2o q2ob vddq 0 ro_buf
xbq3 q3o q3ob vddq 0 ro_buf
xbq4 q4o q4ob vddq 0 ro_buf

.ic v(p1o)=0 v(p1a)=@@VDD@@ v(p1b)=0 v(p1c)=@@VDD@@ v(p1d)=0
.ic v(p2o)=0 v(p2a)=@@VDD@@ v(p2b)=0 v(p2c)=@@VDD@@ v(p2d)=0
.ic v(p3o)=0 v(p3a)=@@VDD@@ v(p3b)=0 v(p3c)=@@VDD@@ v(p3d)=0
.ic v(p4o)=0 v(p4a)=@@VDD@@ v(p4b)=0 v(p4c)=@@VDD@@ v(p4d)=0
.ic v(q1o)=0 v(q1a)=@@VDD@@ v(q1b)=0 v(q1c)=@@VDD@@ v(q1d)=0
.ic v(q2o)=0 v(q2a)=@@VDD@@ v(q2b)=0 v(q2c)=@@VDD@@ v(q2d)=0
.ic v(q3o)=0 v(q3a)=@@VDD@@ v(q3b)=0 v(q3c)=@@VDD@@ v(q3d)=0
.ic v(q4o)=0 v(q4a)=@@VDD@@ v(q4b)=0 v(q4c)=@@VDD@@ v(q4d)=0

.tran @@TMAX@@ 160n uic

.control
run

* Period of every ring, from 8 whole periods with the first two rising
* edges discarded as start-up -- the same estimator
* sim/ro-ring5-swing-and-current/ uses, so the two campaigns' periods are
* directly comparable.
meas tran tp1a when v(p1o)=0.5*@@VDD@@ rise=3
meas tran tp1b when v(p1o)=0.5*@@VDD@@ rise=11
let t_pex_wstv0p42 = (tp1b - tp1a)/8
meas tran tp2a when v(p2o)=0.5*@@VDD@@ rise=3
meas tran tp2b when v(p2o)=0.5*@@VDD@@ rise=11
let t_pex_wstv0p44 = (tp2b - tp2a)/8
meas tran tp3a when v(p3o)=0.5*@@VDD@@ rise=3
meas tran tp3b when v(p3o)=0.5*@@VDD@@ rise=11
let t_pex_wstv0p46 = (tp3b - tp3a)/8
meas tran tp4a when v(p4o)=0.5*@@VDD@@ rise=3
meas tran tp4b when v(p4o)=0.5*@@VDD@@ rise=11
let t_pex_wstv0p48 = (tp4b - tp4a)/8

meas tran tq1a when v(q1o)=0.5*@@VDD@@ rise=3
meas tran tq1b when v(q1o)=0.5*@@VDD@@ rise=11
let t_pre_wstv0p42 = (tq1b - tq1a)/8
meas tran tq2a when v(q2o)=0.5*@@VDD@@ rise=3
meas tran tq2b when v(q2o)=0.5*@@VDD@@ rise=11
let t_pre_wstv0p44 = (tq2b - tq2a)/8
meas tran tq3a when v(q3o)=0.5*@@VDD@@ rise=3
meas tran tq3b when v(q3o)=0.5*@@VDD@@ rise=11
let t_pre_wstv0p46 = (tq3b - tq3a)/8
meas tran tq4a when v(q4o)=0.5*@@VDD@@ rise=3
meas tran tq4b when v(q4o)=0.5*@@VDD@@ rise=11
let t_pre_wstv0p48 = (tq4b - tq4a)/8

* The headline ratio: same ring, same corner, parasitics on vs. off.
let slowdown_wstv0p42 = t_pex_wstv0p42 / t_pre_wstv0p42
let slowdown_wstv0p44 = t_pex_wstv0p44 / t_pre_wstv0p44
let slowdown_wstv0p46 = t_pex_wstv0p46 / t_pre_wstv0p46
let slowdown_wstv0p48 = t_pex_wstv0p48 / t_pre_wstv0p48

* Ladder span (DR-0003 section 8's skew_span, re-measured post-layout).
* Stated as slowest/fastest ring under the ladder's expected monotone
* ordering; the four periods above are printed individually so a reader
* can confirm that ordering rather than take it on trust.
let skew_span_pex = t_pex_wstv0p42 / t_pex_wstv0p48
let skew_span_pre = t_pre_wstv0p42 / t_pre_wstv0p48

* Swing, ring node and buffered output, post-layout and pre-layout.
* Steady-state window: 20 ns of start-up discarded.
meas tran vmaxp MAX v(p1o) from=20n to=160n
meas tran vminp MIN v(p1o) from=20n to=160n
meas tran vmaxpb MAX v(p1ob) from=20n to=160n
meas tran vminpb MIN v(p1ob) from=20n to=160n
meas tran vmaxq MAX v(q1o) from=20n to=160n
meas tran vminq MIN v(q1o) from=20n to=160n
meas tran vmaxqb MAX v(q1ob) from=20n to=160n
meas tran vminqb MIN v(q1ob) from=20n to=160n
let swing_frac_pex_ring = (vmaxp - vminp) / @@VDD@@
let swing_frac_pex_buf = (vmaxpb - vminpb) / @@VDD@@
let swing_frac_pre_ring = (vmaxq - vminq) / @@VDD@@
let swing_frac_pre_buf = (vmaxqb - vminqb) / @@VDD@@

* Per-ring supply current, running. i(Vsrc) is negative for current
* delivered by the source, so the printed figures are sign-flipped to read
* as consumed current.
meas tran ip1raw AVG i(Vddrp1) from=20n to=160n
meas tran ip4raw AVG i(Vddrp4) from=20n to=160n
meas tran iq1raw AVG i(Vddrq1) from=20n to=160n
meas tran iq4raw AVG i(Vddrq4) from=20n to=160n
let i_pex_wstv0p42 = -ip1raw
let i_pex_wstv0p48 = -ip4raw
let i_pre_wstv0p42 = -iq1raw
let i_pre_wstv0p48 = -iq4raw

print t_pex_wstv0p42
print t_pex_wstv0p44
print t_pex_wstv0p46
print t_pex_wstv0p48
print t_pre_wstv0p42
print t_pre_wstv0p44
print t_pre_wstv0p46
print t_pre_wstv0p48
print slowdown_wstv0p42
print slowdown_wstv0p44
print slowdown_wstv0p46
print slowdown_wstv0p48
print skew_span_pex
print skew_span_pre
print swing_frac_pex_ring
print swing_frac_pex_buf
print swing_frac_pre_ring
print swing_frac_pre_buf
print i_pex_wstv0p42
print i_pex_wstv0p48
print i_pre_wstv0p42
print i_pre_wstv0p48
.endc
.end
