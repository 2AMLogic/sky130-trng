* klt sim -- generated corner deck, do not edit
.lib /opt/pdk/sky130A/libs.tech/combined/sky130.lib.spice ss
.include /var/tmp/eda-job-klt-sim-4ec1825cfa41/inputs/netlist.cir
.temp -40.0
.meas tran rdata_k0_b0 FIND v(bus_rdata_0_) AT=470.0n
.meas tran rdata_k0_b1 FIND v(bus_rdata_1_) AT=470.0n
.meas tran rdata_k0_b2 FIND v(bus_rdata_2_) AT=470.0n
.meas tran rdata_k0_b3 FIND v(bus_rdata_3_) AT=470.0n
.meas tran rdata_k0_b4 FIND v(bus_rdata_4_) AT=470.0n
.meas tran rdata_k0_b5 FIND v(bus_rdata_5_) AT=470.0n
.meas tran rdata_k0_b6 FIND v(bus_rdata_6_) AT=470.0n
.meas tran rdata_k0_b7 FIND v(bus_rdata_7_) AT=470.0n
.meas tran rdata_k0_b8 FIND v(bus_rdata_8_) AT=470.0n
.meas tran rdata_k0_b9 FIND v(bus_rdata_9_) AT=470.0n
.meas tran rdata_k0_b10 FIND v(bus_rdata_10_) AT=470.0n
.meas tran rdata_k0_b11 FIND v(bus_rdata_11_) AT=470.0n
.meas tran rdata_k0_b12 FIND v(bus_rdata_12_) AT=470.0n
.meas tran rdata_k0_b13 FIND v(bus_rdata_13_) AT=470.0n
.meas tran rdata_k0_b14 FIND v(bus_rdata_14_) AT=470.0n
.meas tran rdata_k0_b15 FIND v(bus_rdata_15_) AT=470.0n
.meas tran rdata_k0_b16 FIND v(bus_rdata_16_) AT=470.0n
.meas tran rdata_k0_b17 FIND v(bus_rdata_17_) AT=470.0n
.meas tran rdata_k0_b18 FIND v(bus_rdata_18_) AT=470.0n
.meas tran rdata_k0_b19 FIND v(bus_rdata_19_) AT=470.0n
.meas tran rdata_k0_b20 FIND v(bus_rdata_20_) AT=470.0n
.meas tran rdata_k0_b21 FIND v(bus_rdata_21_) AT=470.0n
.meas tran rdata_k0_b22 FIND v(bus_rdata_22_) AT=470.0n
.meas tran rdata_k0_b23 FIND v(bus_rdata_23_) AT=470.0n
.meas tran rdata_k0_b24 FIND v(bus_rdata_24_) AT=470.0n
.meas tran rdata_k0_b25 FIND v(bus_rdata_25_) AT=470.0n
.meas tran rdata_k0_b26 FIND v(bus_rdata_26_) AT=470.0n
.meas tran rdata_k0_b27 FIND v(bus_rdata_27_) AT=470.0n
.meas tran rdata_k0_b28 FIND v(bus_rdata_28_) AT=470.0n
.meas tran rdata_k0_b29 FIND v(bus_rdata_29_) AT=470.0n
.meas tran rdata_k0_b30 FIND v(bus_rdata_30_) AT=470.0n
.meas tran rdata_k0_b31 FIND v(bus_rdata_31_) AT=470.0n
.meas tran rdata_k1_b0 FIND v(bus_rdata_0_) AT=570.0n
.meas tran rdata_k1_b1 FIND v(bus_rdata_1_) AT=570.0n
.meas tran rdata_k1_b2 FIND v(bus_rdata_2_) AT=570.0n
.meas tran rdata_k1_b3 FIND v(bus_rdata_3_) AT=570.0n
.meas tran rdata_k1_b4 FIND v(bus_rdata_4_) AT=570.0n
.meas tran rdata_k1_b5 FIND v(bus_rdata_5_) AT=570.0n
.meas tran rdata_k1_b6 FIND v(bus_rdata_6_) AT=570.0n
.meas tran rdata_k1_b7 FIND v(bus_rdata_7_) AT=570.0n
.meas tran rdata_k1_b8 FIND v(bus_rdata_8_) AT=570.0n
.meas tran rdata_k1_b9 FIND v(bus_rdata_9_) AT=570.0n
.meas tran rdata_k1_b10 FIND v(bus_rdata_10_) AT=570.0n
.meas tran rdata_k1_b11 FIND v(bus_rdata_11_) AT=570.0n
.meas tran rdata_k1_b12 FIND v(bus_rdata_12_) AT=570.0n
.meas tran rdata_k1_b13 FIND v(bus_rdata_13_) AT=570.0n
.meas tran rdata_k1_b14 FIND v(bus_rdata_14_) AT=570.0n
.meas tran rdata_k1_b15 FIND v(bus_rdata_15_) AT=570.0n
.meas tran rdata_k1_b16 FIND v(bus_rdata_16_) AT=570.0n
.meas tran rdata_k1_b17 FIND v(bus_rdata_17_) AT=570.0n
.meas tran rdata_k1_b18 FIND v(bus_rdata_18_) AT=570.0n
.meas tran rdata_k1_b19 FIND v(bus_rdata_19_) AT=570.0n
.meas tran rdata_k1_b20 FIND v(bus_rdata_20_) AT=570.0n
.meas tran rdata_k1_b21 FIND v(bus_rdata_21_) AT=570.0n
.meas tran rdata_k1_b22 FIND v(bus_rdata_22_) AT=570.0n
.meas tran rdata_k1_b23 FIND v(bus_rdata_23_) AT=570.0n
.meas tran rdata_k1_b24 FIND v(bus_rdata_24_) AT=570.0n
.meas tran rdata_k1_b25 FIND v(bus_rdata_25_) AT=570.0n
.meas tran rdata_k1_b26 FIND v(bus_rdata_26_) AT=570.0n
.meas tran rdata_k1_b27 FIND v(bus_rdata_27_) AT=570.0n
.meas tran rdata_k1_b28 FIND v(bus_rdata_28_) AT=570.0n
.meas tran rdata_k1_b29 FIND v(bus_rdata_29_) AT=570.0n
.meas tran rdata_k1_b30 FIND v(bus_rdata_30_) AT=570.0n
.meas tran rdata_k1_b31 FIND v(bus_rdata_31_) AT=570.0n
.meas tran rdata_k2_b0 FIND v(bus_rdata_0_) AT=670.0n
.meas tran rdata_k2_b1 FIND v(bus_rdata_1_) AT=670.0n
.meas tran rdata_k2_b2 FIND v(bus_rdata_2_) AT=670.0n
.meas tran rdata_k2_b3 FIND v(bus_rdata_3_) AT=670.0n
.meas tran rdata_k2_b4 FIND v(bus_rdata_4_) AT=670.0n
.meas tran rdata_k2_b5 FIND v(bus_rdata_5_) AT=670.0n
.meas tran rdata_k2_b6 FIND v(bus_rdata_6_) AT=670.0n
.meas tran rdata_k2_b7 FIND v(bus_rdata_7_) AT=670.0n
.meas tran rdata_k2_b8 FIND v(bus_rdata_8_) AT=670.0n
.meas tran rdata_k2_b9 FIND v(bus_rdata_9_) AT=670.0n
.meas tran rdata_k2_b10 FIND v(bus_rdata_10_) AT=670.0n
.meas tran rdata_k2_b11 FIND v(bus_rdata_11_) AT=670.0n
.meas tran rdata_k2_b12 FIND v(bus_rdata_12_) AT=670.0n
.meas tran rdata_k2_b13 FIND v(bus_rdata_13_) AT=670.0n
.meas tran rdata_k2_b14 FIND v(bus_rdata_14_) AT=670.0n
.meas tran rdata_k2_b15 FIND v(bus_rdata_15_) AT=670.0n
.meas tran rdata_k2_b16 FIND v(bus_rdata_16_) AT=670.0n
.meas tran rdata_k2_b17 FIND v(bus_rdata_17_) AT=670.0n
.meas tran rdata_k2_b18 FIND v(bus_rdata_18_) AT=670.0n
.meas tran rdata_k2_b19 FIND v(bus_rdata_19_) AT=670.0n
.meas tran rdata_k2_b20 FIND v(bus_rdata_20_) AT=670.0n
.meas tran rdata_k2_b21 FIND v(bus_rdata_21_) AT=670.0n
.meas tran rdata_k2_b22 FIND v(bus_rdata_22_) AT=670.0n
.meas tran rdata_k2_b23 FIND v(bus_rdata_23_) AT=670.0n
.meas tran rdata_k2_b24 FIND v(bus_rdata_24_) AT=670.0n
.meas tran rdata_k2_b25 FIND v(bus_rdata_25_) AT=670.0n
.meas tran rdata_k2_b26 FIND v(bus_rdata_26_) AT=670.0n
.meas tran rdata_k2_b27 FIND v(bus_rdata_27_) AT=670.0n
.meas tran rdata_k2_b28 FIND v(bus_rdata_28_) AT=670.0n
.meas tran rdata_k2_b29 FIND v(bus_rdata_29_) AT=670.0n
.meas tran rdata_k2_b30 FIND v(bus_rdata_30_) AT=670.0n
.meas tran rdata_k2_b31 FIND v(bus_rdata_31_) AT=670.0n
.meas tran rdata_k36_b0 FIND v(bus_rdata_0_) AT=4070.0n
.meas tran rdata_k36_b1 FIND v(bus_rdata_1_) AT=4070.0n
.meas tran rdata_k36_b2 FIND v(bus_rdata_2_) AT=4070.0n
.meas tran rdata_k36_b3 FIND v(bus_rdata_3_) AT=4070.0n
.meas tran rdata_k36_b4 FIND v(bus_rdata_4_) AT=4070.0n
.meas tran rdata_k36_b5 FIND v(bus_rdata_5_) AT=4070.0n
.meas tran rdata_k36_b6 FIND v(bus_rdata_6_) AT=4070.0n
.meas tran rdata_k36_b7 FIND v(bus_rdata_7_) AT=4070.0n
.meas tran rdata_k36_b8 FIND v(bus_rdata_8_) AT=4070.0n
.meas tran rdata_k36_b9 FIND v(bus_rdata_9_) AT=4070.0n
.meas tran rdata_k36_b10 FIND v(bus_rdata_10_) AT=4070.0n
.meas tran rdata_k36_b11 FIND v(bus_rdata_11_) AT=4070.0n
.meas tran rdata_k36_b12 FIND v(bus_rdata_12_) AT=4070.0n
.meas tran rdata_k36_b13 FIND v(bus_rdata_13_) AT=4070.0n
.meas tran rdata_k36_b14 FIND v(bus_rdata_14_) AT=4070.0n
.meas tran rdata_k36_b15 FIND v(bus_rdata_15_) AT=4070.0n
.meas tran rdata_k36_b16 FIND v(bus_rdata_16_) AT=4070.0n
.meas tran rdata_k36_b17 FIND v(bus_rdata_17_) AT=4070.0n
.meas tran rdata_k36_b18 FIND v(bus_rdata_18_) AT=4070.0n
.meas tran rdata_k36_b19 FIND v(bus_rdata_19_) AT=4070.0n
.meas tran rdata_k36_b20 FIND v(bus_rdata_20_) AT=4070.0n
.meas tran rdata_k36_b21 FIND v(bus_rdata_21_) AT=4070.0n
.meas tran rdata_k36_b22 FIND v(bus_rdata_22_) AT=4070.0n
.meas tran rdata_k36_b23 FIND v(bus_rdata_23_) AT=4070.0n
.meas tran rdata_k36_b24 FIND v(bus_rdata_24_) AT=4070.0n
.meas tran rdata_k36_b25 FIND v(bus_rdata_25_) AT=4070.0n
.meas tran rdata_k36_b26 FIND v(bus_rdata_26_) AT=4070.0n
.meas tran rdata_k36_b27 FIND v(bus_rdata_27_) AT=4070.0n
.meas tran rdata_k36_b28 FIND v(bus_rdata_28_) AT=4070.0n
.meas tran rdata_k36_b29 FIND v(bus_rdata_29_) AT=4070.0n
.meas tran rdata_k36_b30 FIND v(bus_rdata_30_) AT=4070.0n
.meas tran rdata_k36_b31 FIND v(bus_rdata_31_) AT=4070.0n
.meas tran rdata_k37_b0 FIND v(bus_rdata_0_) AT=4170.0n
.meas tran rdata_k37_b1 FIND v(bus_rdata_1_) AT=4170.0n
.meas tran rdata_k37_b2 FIND v(bus_rdata_2_) AT=4170.0n
.meas tran rdata_k37_b3 FIND v(bus_rdata_3_) AT=4170.0n
.meas tran rdata_k37_b4 FIND v(bus_rdata_4_) AT=4170.0n
.meas tran rdata_k37_b5 FIND v(bus_rdata_5_) AT=4170.0n
.meas tran rdata_k37_b6 FIND v(bus_rdata_6_) AT=4170.0n
.meas tran rdata_k37_b7 FIND v(bus_rdata_7_) AT=4170.0n
.meas tran rdata_k37_b8 FIND v(bus_rdata_8_) AT=4170.0n
.meas tran rdata_k37_b9 FIND v(bus_rdata_9_) AT=4170.0n
.meas tran rdata_k37_b10 FIND v(bus_rdata_10_) AT=4170.0n
.meas tran rdata_k37_b11 FIND v(bus_rdata_11_) AT=4170.0n
.meas tran rdata_k37_b12 FIND v(bus_rdata_12_) AT=4170.0n
.meas tran rdata_k37_b13 FIND v(bus_rdata_13_) AT=4170.0n
.meas tran rdata_k37_b14 FIND v(bus_rdata_14_) AT=4170.0n
.meas tran rdata_k37_b15 FIND v(bus_rdata_15_) AT=4170.0n
.meas tran rdata_k37_b16 FIND v(bus_rdata_16_) AT=4170.0n
.meas tran rdata_k37_b17 FIND v(bus_rdata_17_) AT=4170.0n
.meas tran rdata_k37_b18 FIND v(bus_rdata_18_) AT=4170.0n
.meas tran rdata_k37_b19 FIND v(bus_rdata_19_) AT=4170.0n
.meas tran rdata_k37_b20 FIND v(bus_rdata_20_) AT=4170.0n
.meas tran rdata_k37_b21 FIND v(bus_rdata_21_) AT=4170.0n
.meas tran rdata_k37_b22 FIND v(bus_rdata_22_) AT=4170.0n
.meas tran rdata_k37_b23 FIND v(bus_rdata_23_) AT=4170.0n
.meas tran rdata_k37_b24 FIND v(bus_rdata_24_) AT=4170.0n
.meas tran rdata_k37_b25 FIND v(bus_rdata_25_) AT=4170.0n
.meas tran rdata_k37_b26 FIND v(bus_rdata_26_) AT=4170.0n
.meas tran rdata_k37_b27 FIND v(bus_rdata_27_) AT=4170.0n
.meas tran rdata_k37_b28 FIND v(bus_rdata_28_) AT=4170.0n
.meas tran rdata_k37_b29 FIND v(bus_rdata_29_) AT=4170.0n
.meas tran rdata_k37_b30 FIND v(bus_rdata_30_) AT=4170.0n
.meas tran rdata_k37_b31 FIND v(bus_rdata_31_) AT=4170.0n
.meas tran rdata_k38_b0 FIND v(bus_rdata_0_) AT=4270.0n
.meas tran rdata_k38_b1 FIND v(bus_rdata_1_) AT=4270.0n
.meas tran rdata_k38_b2 FIND v(bus_rdata_2_) AT=4270.0n
.meas tran rdata_k38_b3 FIND v(bus_rdata_3_) AT=4270.0n
.meas tran rdata_k38_b4 FIND v(bus_rdata_4_) AT=4270.0n
.meas tran rdata_k38_b5 FIND v(bus_rdata_5_) AT=4270.0n
.meas tran rdata_k38_b6 FIND v(bus_rdata_6_) AT=4270.0n
.meas tran rdata_k38_b7 FIND v(bus_rdata_7_) AT=4270.0n
.meas tran rdata_k38_b8 FIND v(bus_rdata_8_) AT=4270.0n
.meas tran rdata_k38_b9 FIND v(bus_rdata_9_) AT=4270.0n
.meas tran rdata_k38_b10 FIND v(bus_rdata_10_) AT=4270.0n
.meas tran rdata_k38_b11 FIND v(bus_rdata_11_) AT=4270.0n
.meas tran rdata_k38_b12 FIND v(bus_rdata_12_) AT=4270.0n
.meas tran rdata_k38_b13 FIND v(bus_rdata_13_) AT=4270.0n
.meas tran rdata_k38_b14 FIND v(bus_rdata_14_) AT=4270.0n
.meas tran rdata_k38_b15 FIND v(bus_rdata_15_) AT=4270.0n
.meas tran rdata_k38_b16 FIND v(bus_rdata_16_) AT=4270.0n
.meas tran rdata_k38_b17 FIND v(bus_rdata_17_) AT=4270.0n
.meas tran rdata_k38_b18 FIND v(bus_rdata_18_) AT=4270.0n
.meas tran rdata_k38_b19 FIND v(bus_rdata_19_) AT=4270.0n
.meas tran rdata_k38_b20 FIND v(bus_rdata_20_) AT=4270.0n
.meas tran rdata_k38_b21 FIND v(bus_rdata_21_) AT=4270.0n
.meas tran rdata_k38_b22 FIND v(bus_rdata_22_) AT=4270.0n
.meas tran rdata_k38_b23 FIND v(bus_rdata_23_) AT=4270.0n
.meas tran rdata_k38_b24 FIND v(bus_rdata_24_) AT=4270.0n
.meas tran rdata_k38_b25 FIND v(bus_rdata_25_) AT=4270.0n
.meas tran rdata_k38_b26 FIND v(bus_rdata_26_) AT=4270.0n
.meas tran rdata_k38_b27 FIND v(bus_rdata_27_) AT=4270.0n
.meas tran rdata_k38_b28 FIND v(bus_rdata_28_) AT=4270.0n
.meas tran rdata_k38_b29 FIND v(bus_rdata_29_) AT=4270.0n
.meas tran rdata_k38_b30 FIND v(bus_rdata_30_) AT=4270.0n
.meas tran rdata_k38_b31 FIND v(bus_rdata_31_) AT=4270.0n
.meas tran rdata_k39_b0 FIND v(bus_rdata_0_) AT=4370.0n
.meas tran rdata_k39_b1 FIND v(bus_rdata_1_) AT=4370.0n
.meas tran rdata_k39_b2 FIND v(bus_rdata_2_) AT=4370.0n
.meas tran rdata_k39_b3 FIND v(bus_rdata_3_) AT=4370.0n
.meas tran rdata_k39_b4 FIND v(bus_rdata_4_) AT=4370.0n
.meas tran rdata_k39_b5 FIND v(bus_rdata_5_) AT=4370.0n
.meas tran rdata_k39_b6 FIND v(bus_rdata_6_) AT=4370.0n
.meas tran rdata_k39_b7 FIND v(bus_rdata_7_) AT=4370.0n
.meas tran rdata_k39_b8 FIND v(bus_rdata_8_) AT=4370.0n
.meas tran rdata_k39_b9 FIND v(bus_rdata_9_) AT=4370.0n
.meas tran rdata_k39_b10 FIND v(bus_rdata_10_) AT=4370.0n
.meas tran rdata_k39_b11 FIND v(bus_rdata_11_) AT=4370.0n
.meas tran rdata_k39_b12 FIND v(bus_rdata_12_) AT=4370.0n
.meas tran rdata_k39_b13 FIND v(bus_rdata_13_) AT=4370.0n
.meas tran rdata_k39_b14 FIND v(bus_rdata_14_) AT=4370.0n
.meas tran rdata_k39_b15 FIND v(bus_rdata_15_) AT=4370.0n
.meas tran rdata_k39_b16 FIND v(bus_rdata_16_) AT=4370.0n
.meas tran rdata_k39_b17 FIND v(bus_rdata_17_) AT=4370.0n
.meas tran rdata_k39_b18 FIND v(bus_rdata_18_) AT=4370.0n
.meas tran rdata_k39_b19 FIND v(bus_rdata_19_) AT=4370.0n
.meas tran rdata_k39_b20 FIND v(bus_rdata_20_) AT=4370.0n
.meas tran rdata_k39_b21 FIND v(bus_rdata_21_) AT=4370.0n
.meas tran rdata_k39_b22 FIND v(bus_rdata_22_) AT=4370.0n
.meas tran rdata_k39_b23 FIND v(bus_rdata_23_) AT=4370.0n
.meas tran rdata_k39_b24 FIND v(bus_rdata_24_) AT=4370.0n
.meas tran rdata_k39_b25 FIND v(bus_rdata_25_) AT=4370.0n
.meas tran rdata_k39_b26 FIND v(bus_rdata_26_) AT=4370.0n
.meas tran rdata_k39_b27 FIND v(bus_rdata_27_) AT=4370.0n
.meas tran rdata_k39_b28 FIND v(bus_rdata_28_) AT=4370.0n
.meas tran rdata_k39_b29 FIND v(bus_rdata_29_) AT=4370.0n
.meas tran rdata_k39_b30 FIND v(bus_rdata_30_) AT=4370.0n
.meas tran rdata_k39_b31 FIND v(bus_rdata_31_) AT=4370.0n
.meas tran rdata_k40_b0 FIND v(bus_rdata_0_) AT=4470.0n
.meas tran rdata_k40_b1 FIND v(bus_rdata_1_) AT=4470.0n
.meas tran rdata_k40_b2 FIND v(bus_rdata_2_) AT=4470.0n
.meas tran rdata_k40_b3 FIND v(bus_rdata_3_) AT=4470.0n
.meas tran rdata_k40_b4 FIND v(bus_rdata_4_) AT=4470.0n
.meas tran rdata_k40_b5 FIND v(bus_rdata_5_) AT=4470.0n
.meas tran rdata_k40_b6 FIND v(bus_rdata_6_) AT=4470.0n
.meas tran rdata_k40_b7 FIND v(bus_rdata_7_) AT=4470.0n
.meas tran rdata_k40_b8 FIND v(bus_rdata_8_) AT=4470.0n
.meas tran rdata_k40_b9 FIND v(bus_rdata_9_) AT=4470.0n
.meas tran rdata_k40_b10 FIND v(bus_rdata_10_) AT=4470.0n
.meas tran rdata_k40_b11 FIND v(bus_rdata_11_) AT=4470.0n
.meas tran rdata_k40_b12 FIND v(bus_rdata_12_) AT=4470.0n
.meas tran rdata_k40_b13 FIND v(bus_rdata_13_) AT=4470.0n
.meas tran rdata_k40_b14 FIND v(bus_rdata_14_) AT=4470.0n
.meas tran rdata_k40_b15 FIND v(bus_rdata_15_) AT=4470.0n
.meas tran rdata_k40_b16 FIND v(bus_rdata_16_) AT=4470.0n
.meas tran rdata_k40_b17 FIND v(bus_rdata_17_) AT=4470.0n
.meas tran rdata_k40_b18 FIND v(bus_rdata_18_) AT=4470.0n
.meas tran rdata_k40_b19 FIND v(bus_rdata_19_) AT=4470.0n
.meas tran rdata_k40_b20 FIND v(bus_rdata_20_) AT=4470.0n
.meas tran rdata_k40_b21 FIND v(bus_rdata_21_) AT=4470.0n
.meas tran rdata_k40_b22 FIND v(bus_rdata_22_) AT=4470.0n
.meas tran rdata_k40_b23 FIND v(bus_rdata_23_) AT=4470.0n
.meas tran rdata_k40_b24 FIND v(bus_rdata_24_) AT=4470.0n
.meas tran rdata_k40_b25 FIND v(bus_rdata_25_) AT=4470.0n
.meas tran rdata_k40_b26 FIND v(bus_rdata_26_) AT=4470.0n
.meas tran rdata_k40_b27 FIND v(bus_rdata_27_) AT=4470.0n
.meas tran rdata_k40_b28 FIND v(bus_rdata_28_) AT=4470.0n
.meas tran rdata_k40_b29 FIND v(bus_rdata_29_) AT=4470.0n
.meas tran rdata_k40_b30 FIND v(bus_rdata_30_) AT=4470.0n
.meas tran rdata_k40_b31 FIND v(bus_rdata_31_) AT=4470.0n
.meas tran rdata_k41_b0 FIND v(bus_rdata_0_) AT=4570.0n
.meas tran rdata_k41_b1 FIND v(bus_rdata_1_) AT=4570.0n
.meas tran rdata_k41_b2 FIND v(bus_rdata_2_) AT=4570.0n
.meas tran rdata_k41_b3 FIND v(bus_rdata_3_) AT=4570.0n
.meas tran rdata_k41_b4 FIND v(bus_rdata_4_) AT=4570.0n
.meas tran rdata_k41_b5 FIND v(bus_rdata_5_) AT=4570.0n
.meas tran rdata_k41_b6 FIND v(bus_rdata_6_) AT=4570.0n
.meas tran rdata_k41_b7 FIND v(bus_rdata_7_) AT=4570.0n
.meas tran rdata_k41_b8 FIND v(bus_rdata_8_) AT=4570.0n
.meas tran rdata_k41_b9 FIND v(bus_rdata_9_) AT=4570.0n
.meas tran rdata_k41_b10 FIND v(bus_rdata_10_) AT=4570.0n
.meas tran rdata_k41_b11 FIND v(bus_rdata_11_) AT=4570.0n
.meas tran rdata_k41_b12 FIND v(bus_rdata_12_) AT=4570.0n
.meas tran rdata_k41_b13 FIND v(bus_rdata_13_) AT=4570.0n
.meas tran rdata_k41_b14 FIND v(bus_rdata_14_) AT=4570.0n
.meas tran rdata_k41_b15 FIND v(bus_rdata_15_) AT=4570.0n
.meas tran rdata_k41_b16 FIND v(bus_rdata_16_) AT=4570.0n
.meas tran rdata_k41_b17 FIND v(bus_rdata_17_) AT=4570.0n
.meas tran rdata_k41_b18 FIND v(bus_rdata_18_) AT=4570.0n
.meas tran rdata_k41_b19 FIND v(bus_rdata_19_) AT=4570.0n
.meas tran rdata_k41_b20 FIND v(bus_rdata_20_) AT=4570.0n
.meas tran rdata_k41_b21 FIND v(bus_rdata_21_) AT=4570.0n
.meas tran rdata_k41_b22 FIND v(bus_rdata_22_) AT=4570.0n
.meas tran rdata_k41_b23 FIND v(bus_rdata_23_) AT=4570.0n
.meas tran rdata_k41_b24 FIND v(bus_rdata_24_) AT=4570.0n
.meas tran rdata_k41_b25 FIND v(bus_rdata_25_) AT=4570.0n
.meas tran rdata_k41_b26 FIND v(bus_rdata_26_) AT=4570.0n
.meas tran rdata_k41_b27 FIND v(bus_rdata_27_) AT=4570.0n
.meas tran rdata_k41_b28 FIND v(bus_rdata_28_) AT=4570.0n
.meas tran rdata_k41_b29 FIND v(bus_rdata_29_) AT=4570.0n
.meas tran rdata_k41_b30 FIND v(bus_rdata_30_) AT=4570.0n
.meas tran rdata_k41_b31 FIND v(bus_rdata_31_) AT=4570.0n
.meas tran odata_k36_b0 FIND v(out_data_0_) AT=3970.0n
.meas tran odata_k36_b1 FIND v(out_data_1_) AT=3970.0n
.meas tran odata_k36_b2 FIND v(out_data_2_) AT=3970.0n
.meas tran odata_k36_b3 FIND v(out_data_3_) AT=3970.0n
.meas tran odata_k36_b4 FIND v(out_data_4_) AT=3970.0n
.meas tran odata_k36_b5 FIND v(out_data_5_) AT=3970.0n
.meas tran odata_k36_b6 FIND v(out_data_6_) AT=3970.0n
.meas tran odata_k36_b7 FIND v(out_data_7_) AT=3970.0n
.meas tran odata_k36_b8 FIND v(out_data_8_) AT=3970.0n
.meas tran odata_k36_b9 FIND v(out_data_9_) AT=3970.0n
.meas tran odata_k36_b10 FIND v(out_data_10_) AT=3970.0n
.meas tran odata_k36_b11 FIND v(out_data_11_) AT=3970.0n
.meas tran odata_k36_b12 FIND v(out_data_12_) AT=3970.0n
.meas tran odata_k36_b13 FIND v(out_data_13_) AT=3970.0n
.meas tran odata_k36_b14 FIND v(out_data_14_) AT=3970.0n
.meas tran odata_k36_b15 FIND v(out_data_15_) AT=3970.0n
.meas tran odata_k36_b16 FIND v(out_data_16_) AT=3970.0n
.meas tran odata_k36_b17 FIND v(out_data_17_) AT=3970.0n
.meas tran odata_k36_b18 FIND v(out_data_18_) AT=3970.0n
.meas tran odata_k36_b19 FIND v(out_data_19_) AT=3970.0n
.meas tran odata_k36_b20 FIND v(out_data_20_) AT=3970.0n
.meas tran odata_k36_b21 FIND v(out_data_21_) AT=3970.0n
.meas tran odata_k36_b22 FIND v(out_data_22_) AT=3970.0n
.meas tran odata_k36_b23 FIND v(out_data_23_) AT=3970.0n
.meas tran odata_k36_b24 FIND v(out_data_24_) AT=3970.0n
.meas tran odata_k36_b25 FIND v(out_data_25_) AT=3970.0n
.meas tran odata_k36_b26 FIND v(out_data_26_) AT=3970.0n
.meas tran odata_k36_b27 FIND v(out_data_27_) AT=3970.0n
.meas tran odata_k36_b28 FIND v(out_data_28_) AT=3970.0n
.meas tran odata_k36_b29 FIND v(out_data_29_) AT=3970.0n
.meas tran odata_k36_b30 FIND v(out_data_30_) AT=3970.0n
.meas tran odata_k36_b31 FIND v(out_data_31_) AT=3970.0n
.meas tran odata_k37_b0 FIND v(out_data_0_) AT=4070.0n
.meas tran odata_k37_b1 FIND v(out_data_1_) AT=4070.0n
.meas tran odata_k37_b2 FIND v(out_data_2_) AT=4070.0n
.meas tran odata_k37_b3 FIND v(out_data_3_) AT=4070.0n
.meas tran odata_k37_b4 FIND v(out_data_4_) AT=4070.0n
.meas tran odata_k37_b5 FIND v(out_data_5_) AT=4070.0n
.meas tran odata_k37_b6 FIND v(out_data_6_) AT=4070.0n
.meas tran odata_k37_b7 FIND v(out_data_7_) AT=4070.0n
.meas tran odata_k37_b8 FIND v(out_data_8_) AT=4070.0n
.meas tran odata_k37_b9 FIND v(out_data_9_) AT=4070.0n
.meas tran odata_k37_b10 FIND v(out_data_10_) AT=4070.0n
.meas tran odata_k37_b11 FIND v(out_data_11_) AT=4070.0n
.meas tran odata_k37_b12 FIND v(out_data_12_) AT=4070.0n
.meas tran odata_k37_b13 FIND v(out_data_13_) AT=4070.0n
.meas tran odata_k37_b14 FIND v(out_data_14_) AT=4070.0n
.meas tran odata_k37_b15 FIND v(out_data_15_) AT=4070.0n
.meas tran odata_k37_b16 FIND v(out_data_16_) AT=4070.0n
.meas tran odata_k37_b17 FIND v(out_data_17_) AT=4070.0n
.meas tran odata_k37_b18 FIND v(out_data_18_) AT=4070.0n
.meas tran odata_k37_b19 FIND v(out_data_19_) AT=4070.0n
.meas tran odata_k37_b20 FIND v(out_data_20_) AT=4070.0n
.meas tran odata_k37_b21 FIND v(out_data_21_) AT=4070.0n
.meas tran odata_k37_b22 FIND v(out_data_22_) AT=4070.0n
.meas tran odata_k37_b23 FIND v(out_data_23_) AT=4070.0n
.meas tran odata_k37_b24 FIND v(out_data_24_) AT=4070.0n
.meas tran odata_k37_b25 FIND v(out_data_25_) AT=4070.0n
.meas tran odata_k37_b26 FIND v(out_data_26_) AT=4070.0n
.meas tran odata_k37_b27 FIND v(out_data_27_) AT=4070.0n
.meas tran odata_k37_b28 FIND v(out_data_28_) AT=4070.0n
.meas tran odata_k37_b29 FIND v(out_data_29_) AT=4070.0n
.meas tran odata_k37_b30 FIND v(out_data_30_) AT=4070.0n
.meas tran odata_k37_b31 FIND v(out_data_31_) AT=4070.0n
.meas tran odata_k72_b0 FIND v(out_data_0_) AT=7570.0n
.meas tran odata_k72_b1 FIND v(out_data_1_) AT=7570.0n
.meas tran odata_k72_b2 FIND v(out_data_2_) AT=7570.0n
.meas tran odata_k72_b3 FIND v(out_data_3_) AT=7570.0n
.meas tran odata_k72_b4 FIND v(out_data_4_) AT=7570.0n
.meas tran odata_k72_b5 FIND v(out_data_5_) AT=7570.0n
.meas tran odata_k72_b6 FIND v(out_data_6_) AT=7570.0n
.meas tran odata_k72_b7 FIND v(out_data_7_) AT=7570.0n
.meas tran odata_k72_b8 FIND v(out_data_8_) AT=7570.0n
.meas tran odata_k72_b9 FIND v(out_data_9_) AT=7570.0n
.meas tran odata_k72_b10 FIND v(out_data_10_) AT=7570.0n
.meas tran odata_k72_b11 FIND v(out_data_11_) AT=7570.0n
.meas tran odata_k72_b12 FIND v(out_data_12_) AT=7570.0n
.meas tran odata_k72_b13 FIND v(out_data_13_) AT=7570.0n
.meas tran odata_k72_b14 FIND v(out_data_14_) AT=7570.0n
.meas tran odata_k72_b15 FIND v(out_data_15_) AT=7570.0n
.meas tran odata_k72_b16 FIND v(out_data_16_) AT=7570.0n
.meas tran odata_k72_b17 FIND v(out_data_17_) AT=7570.0n
.meas tran odata_k72_b18 FIND v(out_data_18_) AT=7570.0n
.meas tran odata_k72_b19 FIND v(out_data_19_) AT=7570.0n
.meas tran odata_k72_b20 FIND v(out_data_20_) AT=7570.0n
.meas tran odata_k72_b21 FIND v(out_data_21_) AT=7570.0n
.meas tran odata_k72_b22 FIND v(out_data_22_) AT=7570.0n
.meas tran odata_k72_b23 FIND v(out_data_23_) AT=7570.0n
.meas tran odata_k72_b24 FIND v(out_data_24_) AT=7570.0n
.meas tran odata_k72_b25 FIND v(out_data_25_) AT=7570.0n
.meas tran odata_k72_b26 FIND v(out_data_26_) AT=7570.0n
.meas tran odata_k72_b27 FIND v(out_data_27_) AT=7570.0n
.meas tran odata_k72_b28 FIND v(out_data_28_) AT=7570.0n
.meas tran odata_k72_b29 FIND v(out_data_29_) AT=7570.0n
.meas tran odata_k72_b30 FIND v(out_data_30_) AT=7570.0n
.meas tran odata_k72_b31 FIND v(out_data_31_) AT=7570.0n
.meas tran odata_k73_b0 FIND v(out_data_0_) AT=7670.0n
.meas tran odata_k73_b1 FIND v(out_data_1_) AT=7670.0n
.meas tran odata_k73_b2 FIND v(out_data_2_) AT=7670.0n
.meas tran odata_k73_b3 FIND v(out_data_3_) AT=7670.0n
.meas tran odata_k73_b4 FIND v(out_data_4_) AT=7670.0n
.meas tran odata_k73_b5 FIND v(out_data_5_) AT=7670.0n
.meas tran odata_k73_b6 FIND v(out_data_6_) AT=7670.0n
.meas tran odata_k73_b7 FIND v(out_data_7_) AT=7670.0n
.meas tran odata_k73_b8 FIND v(out_data_8_) AT=7670.0n
.meas tran odata_k73_b9 FIND v(out_data_9_) AT=7670.0n
.meas tran odata_k73_b10 FIND v(out_data_10_) AT=7670.0n
.meas tran odata_k73_b11 FIND v(out_data_11_) AT=7670.0n
.meas tran odata_k73_b12 FIND v(out_data_12_) AT=7670.0n
.meas tran odata_k73_b13 FIND v(out_data_13_) AT=7670.0n
.meas tran odata_k73_b14 FIND v(out_data_14_) AT=7670.0n
.meas tran odata_k73_b15 FIND v(out_data_15_) AT=7670.0n
.meas tran odata_k73_b16 FIND v(out_data_16_) AT=7670.0n
.meas tran odata_k73_b17 FIND v(out_data_17_) AT=7670.0n
.meas tran odata_k73_b18 FIND v(out_data_18_) AT=7670.0n
.meas tran odata_k73_b19 FIND v(out_data_19_) AT=7670.0n
.meas tran odata_k73_b20 FIND v(out_data_20_) AT=7670.0n
.meas tran odata_k73_b21 FIND v(out_data_21_) AT=7670.0n
.meas tran odata_k73_b22 FIND v(out_data_22_) AT=7670.0n
.meas tran odata_k73_b23 FIND v(out_data_23_) AT=7670.0n
.meas tran odata_k73_b24 FIND v(out_data_24_) AT=7670.0n
.meas tran odata_k73_b25 FIND v(out_data_25_) AT=7670.0n
.meas tran odata_k73_b26 FIND v(out_data_26_) AT=7670.0n
.meas tran odata_k73_b27 FIND v(out_data_27_) AT=7670.0n
.meas tran odata_k73_b28 FIND v(out_data_28_) AT=7670.0n
.meas tran odata_k73_b29 FIND v(out_data_29_) AT=7670.0n
.meas tran odata_k73_b30 FIND v(out_data_30_) AT=7670.0n
.meas tran odata_k73_b31 FIND v(out_data_31_) AT=7670.0n
.meas tran odata_k74_b0 FIND v(out_data_0_) AT=7770.0n
.meas tran odata_k74_b1 FIND v(out_data_1_) AT=7770.0n
.meas tran odata_k74_b2 FIND v(out_data_2_) AT=7770.0n
.meas tran odata_k74_b3 FIND v(out_data_3_) AT=7770.0n
.meas tran odata_k74_b4 FIND v(out_data_4_) AT=7770.0n
.meas tran odata_k74_b5 FIND v(out_data_5_) AT=7770.0n
.meas tran odata_k74_b6 FIND v(out_data_6_) AT=7770.0n
.meas tran odata_k74_b7 FIND v(out_data_7_) AT=7770.0n
.meas tran odata_k74_b8 FIND v(out_data_8_) AT=7770.0n
.meas tran odata_k74_b9 FIND v(out_data_9_) AT=7770.0n
.meas tran odata_k74_b10 FIND v(out_data_10_) AT=7770.0n
.meas tran odata_k74_b11 FIND v(out_data_11_) AT=7770.0n
.meas tran odata_k74_b12 FIND v(out_data_12_) AT=7770.0n
.meas tran odata_k74_b13 FIND v(out_data_13_) AT=7770.0n
.meas tran odata_k74_b14 FIND v(out_data_14_) AT=7770.0n
.meas tran odata_k74_b15 FIND v(out_data_15_) AT=7770.0n
.meas tran odata_k74_b16 FIND v(out_data_16_) AT=7770.0n
.meas tran odata_k74_b17 FIND v(out_data_17_) AT=7770.0n
.meas tran odata_k74_b18 FIND v(out_data_18_) AT=7770.0n
.meas tran odata_k74_b19 FIND v(out_data_19_) AT=7770.0n
.meas tran odata_k74_b20 FIND v(out_data_20_) AT=7770.0n
.meas tran odata_k74_b21 FIND v(out_data_21_) AT=7770.0n
.meas tran odata_k74_b22 FIND v(out_data_22_) AT=7770.0n
.meas tran odata_k74_b23 FIND v(out_data_23_) AT=7770.0n
.meas tran odata_k74_b24 FIND v(out_data_24_) AT=7770.0n
.meas tran odata_k74_b25 FIND v(out_data_25_) AT=7770.0n
.meas tran odata_k74_b26 FIND v(out_data_26_) AT=7770.0n
.meas tran odata_k74_b27 FIND v(out_data_27_) AT=7770.0n
.meas tran odata_k74_b28 FIND v(out_data_28_) AT=7770.0n
.meas tran odata_k74_b29 FIND v(out_data_29_) AT=7770.0n
.meas tran odata_k74_b30 FIND v(out_data_30_) AT=7770.0n
.meas tran odata_k74_b31 FIND v(out_data_31_) AT=7770.0n
.meas tran alarm_k0 FIND v(alarm) AT=370.0n
.meas tran gated_k0 FIND v(gated) AT=370.0n
.meas tran startup_done_k0 FIND v(startup_done) AT=370.0n
.meas tran out_valid_k0 FIND v(out_valid) AT=370.0n
.meas tran alarm_k1 FIND v(alarm) AT=470.0n
.meas tran gated_k1 FIND v(gated) AT=470.0n
.meas tran startup_done_k1 FIND v(startup_done) AT=470.0n
.meas tran out_valid_k1 FIND v(out_valid) AT=470.0n
.meas tran alarm_k2 FIND v(alarm) AT=570.0n
.meas tran gated_k2 FIND v(gated) AT=570.0n
.meas tran startup_done_k2 FIND v(startup_done) AT=570.0n
.meas tran out_valid_k2 FIND v(out_valid) AT=570.0n
.meas tran alarm_k3 FIND v(alarm) AT=670.0n
.meas tran gated_k3 FIND v(gated) AT=670.0n
.meas tran startup_done_k3 FIND v(startup_done) AT=670.0n
.meas tran out_valid_k3 FIND v(out_valid) AT=670.0n
.meas tran alarm_k4 FIND v(alarm) AT=770.0n
.meas tran gated_k4 FIND v(gated) AT=770.0n
.meas tran startup_done_k4 FIND v(startup_done) AT=770.0n
.meas tran out_valid_k4 FIND v(out_valid) AT=770.0n
.meas tran alarm_k5 FIND v(alarm) AT=870.0n
.meas tran gated_k5 FIND v(gated) AT=870.0n
.meas tran startup_done_k5 FIND v(startup_done) AT=870.0n
.meas tran out_valid_k5 FIND v(out_valid) AT=870.0n
.meas tran alarm_k6 FIND v(alarm) AT=970.0n
.meas tran gated_k6 FIND v(gated) AT=970.0n
.meas tran startup_done_k6 FIND v(startup_done) AT=970.0n
.meas tran out_valid_k6 FIND v(out_valid) AT=970.0n
.meas tran alarm_k7 FIND v(alarm) AT=1070.0n
.meas tran gated_k7 FIND v(gated) AT=1070.0n
.meas tran startup_done_k7 FIND v(startup_done) AT=1070.0n
.meas tran out_valid_k7 FIND v(out_valid) AT=1070.0n
.meas tran alarm_k8 FIND v(alarm) AT=1170.0n
.meas tran gated_k8 FIND v(gated) AT=1170.0n
.meas tran startup_done_k8 FIND v(startup_done) AT=1170.0n
.meas tran out_valid_k8 FIND v(out_valid) AT=1170.0n
.meas tran alarm_k9 FIND v(alarm) AT=1270.0n
.meas tran gated_k9 FIND v(gated) AT=1270.0n
.meas tran startup_done_k9 FIND v(startup_done) AT=1270.0n
.meas tran out_valid_k9 FIND v(out_valid) AT=1270.0n
.meas tran alarm_k10 FIND v(alarm) AT=1370.0n
.meas tran gated_k10 FIND v(gated) AT=1370.0n
.meas tran startup_done_k10 FIND v(startup_done) AT=1370.0n
.meas tran out_valid_k10 FIND v(out_valid) AT=1370.0n
.meas tran alarm_k11 FIND v(alarm) AT=1470.0n
.meas tran gated_k11 FIND v(gated) AT=1470.0n
.meas tran startup_done_k11 FIND v(startup_done) AT=1470.0n
.meas tran out_valid_k11 FIND v(out_valid) AT=1470.0n
.meas tran alarm_k12 FIND v(alarm) AT=1570.0n
.meas tran gated_k12 FIND v(gated) AT=1570.0n
.meas tran startup_done_k12 FIND v(startup_done) AT=1570.0n
.meas tran out_valid_k12 FIND v(out_valid) AT=1570.0n
.meas tran alarm_k13 FIND v(alarm) AT=1670.0n
.meas tran gated_k13 FIND v(gated) AT=1670.0n
.meas tran startup_done_k13 FIND v(startup_done) AT=1670.0n
.meas tran out_valid_k13 FIND v(out_valid) AT=1670.0n
.meas tran alarm_k14 FIND v(alarm) AT=1770.0n
.meas tran gated_k14 FIND v(gated) AT=1770.0n
.meas tran startup_done_k14 FIND v(startup_done) AT=1770.0n
.meas tran out_valid_k14 FIND v(out_valid) AT=1770.0n
.meas tran alarm_k15 FIND v(alarm) AT=1870.0n
.meas tran gated_k15 FIND v(gated) AT=1870.0n
.meas tran startup_done_k15 FIND v(startup_done) AT=1870.0n
.meas tran out_valid_k15 FIND v(out_valid) AT=1870.0n
.meas tran alarm_k16 FIND v(alarm) AT=1970.0n
.meas tran gated_k16 FIND v(gated) AT=1970.0n
.meas tran startup_done_k16 FIND v(startup_done) AT=1970.0n
.meas tran out_valid_k16 FIND v(out_valid) AT=1970.0n
.meas tran alarm_k17 FIND v(alarm) AT=2070.0n
.meas tran gated_k17 FIND v(gated) AT=2070.0n
.meas tran startup_done_k17 FIND v(startup_done) AT=2070.0n
.meas tran out_valid_k17 FIND v(out_valid) AT=2070.0n
.meas tran alarm_k18 FIND v(alarm) AT=2170.0n
.meas tran gated_k18 FIND v(gated) AT=2170.0n
.meas tran startup_done_k18 FIND v(startup_done) AT=2170.0n
.meas tran out_valid_k18 FIND v(out_valid) AT=2170.0n
.meas tran alarm_k19 FIND v(alarm) AT=2270.0n
.meas tran gated_k19 FIND v(gated) AT=2270.0n
.meas tran startup_done_k19 FIND v(startup_done) AT=2270.0n
.meas tran out_valid_k19 FIND v(out_valid) AT=2270.0n
.meas tran alarm_k20 FIND v(alarm) AT=2370.0n
.meas tran gated_k20 FIND v(gated) AT=2370.0n
.meas tran startup_done_k20 FIND v(startup_done) AT=2370.0n
.meas tran out_valid_k20 FIND v(out_valid) AT=2370.0n
.meas tran alarm_k21 FIND v(alarm) AT=2470.0n
.meas tran gated_k21 FIND v(gated) AT=2470.0n
.meas tran startup_done_k21 FIND v(startup_done) AT=2470.0n
.meas tran out_valid_k21 FIND v(out_valid) AT=2470.0n
.meas tran alarm_k22 FIND v(alarm) AT=2570.0n
.meas tran gated_k22 FIND v(gated) AT=2570.0n
.meas tran startup_done_k22 FIND v(startup_done) AT=2570.0n
.meas tran out_valid_k22 FIND v(out_valid) AT=2570.0n
.meas tran alarm_k23 FIND v(alarm) AT=2670.0n
.meas tran gated_k23 FIND v(gated) AT=2670.0n
.meas tran startup_done_k23 FIND v(startup_done) AT=2670.0n
.meas tran out_valid_k23 FIND v(out_valid) AT=2670.0n
.meas tran alarm_k24 FIND v(alarm) AT=2770.0n
.meas tran gated_k24 FIND v(gated) AT=2770.0n
.meas tran startup_done_k24 FIND v(startup_done) AT=2770.0n
.meas tran out_valid_k24 FIND v(out_valid) AT=2770.0n
.meas tran alarm_k25 FIND v(alarm) AT=2870.0n
.meas tran gated_k25 FIND v(gated) AT=2870.0n
.meas tran startup_done_k25 FIND v(startup_done) AT=2870.0n
.meas tran out_valid_k25 FIND v(out_valid) AT=2870.0n
.meas tran alarm_k26 FIND v(alarm) AT=2970.0n
.meas tran gated_k26 FIND v(gated) AT=2970.0n
.meas tran startup_done_k26 FIND v(startup_done) AT=2970.0n
.meas tran out_valid_k26 FIND v(out_valid) AT=2970.0n
.meas tran alarm_k27 FIND v(alarm) AT=3070.0n
.meas tran gated_k27 FIND v(gated) AT=3070.0n
.meas tran startup_done_k27 FIND v(startup_done) AT=3070.0n
.meas tran out_valid_k27 FIND v(out_valid) AT=3070.0n
.meas tran alarm_k28 FIND v(alarm) AT=3170.0n
.meas tran gated_k28 FIND v(gated) AT=3170.0n
.meas tran startup_done_k28 FIND v(startup_done) AT=3170.0n
.meas tran out_valid_k28 FIND v(out_valid) AT=3170.0n
.meas tran alarm_k29 FIND v(alarm) AT=3270.0n
.meas tran gated_k29 FIND v(gated) AT=3270.0n
.meas tran startup_done_k29 FIND v(startup_done) AT=3270.0n
.meas tran out_valid_k29 FIND v(out_valid) AT=3270.0n
.meas tran alarm_k30 FIND v(alarm) AT=3370.0n
.meas tran gated_k30 FIND v(gated) AT=3370.0n
.meas tran startup_done_k30 FIND v(startup_done) AT=3370.0n
.meas tran out_valid_k30 FIND v(out_valid) AT=3370.0n
.meas tran alarm_k31 FIND v(alarm) AT=3470.0n
.meas tran gated_k31 FIND v(gated) AT=3470.0n
.meas tran startup_done_k31 FIND v(startup_done) AT=3470.0n
.meas tran out_valid_k31 FIND v(out_valid) AT=3470.0n
.meas tran alarm_k32 FIND v(alarm) AT=3570.0n
.meas tran gated_k32 FIND v(gated) AT=3570.0n
.meas tran startup_done_k32 FIND v(startup_done) AT=3570.0n
.meas tran out_valid_k32 FIND v(out_valid) AT=3570.0n
.meas tran alarm_k33 FIND v(alarm) AT=3670.0n
.meas tran gated_k33 FIND v(gated) AT=3670.0n
.meas tran startup_done_k33 FIND v(startup_done) AT=3670.0n
.meas tran out_valid_k33 FIND v(out_valid) AT=3670.0n
.meas tran alarm_k34 FIND v(alarm) AT=3770.0n
.meas tran gated_k34 FIND v(gated) AT=3770.0n
.meas tran startup_done_k34 FIND v(startup_done) AT=3770.0n
.meas tran out_valid_k34 FIND v(out_valid) AT=3770.0n
.meas tran alarm_k35 FIND v(alarm) AT=3870.0n
.meas tran gated_k35 FIND v(gated) AT=3870.0n
.meas tran startup_done_k35 FIND v(startup_done) AT=3870.0n
.meas tran out_valid_k35 FIND v(out_valid) AT=3870.0n
.meas tran alarm_k36 FIND v(alarm) AT=3970.0n
.meas tran gated_k36 FIND v(gated) AT=3970.0n
.meas tran startup_done_k36 FIND v(startup_done) AT=3970.0n
.meas tran out_valid_k36 FIND v(out_valid) AT=3970.0n
.meas tran alarm_k37 FIND v(alarm) AT=4070.0n
.meas tran gated_k37 FIND v(gated) AT=4070.0n
.meas tran startup_done_k37 FIND v(startup_done) AT=4070.0n
.meas tran out_valid_k37 FIND v(out_valid) AT=4070.0n
.meas tran alarm_k38 FIND v(alarm) AT=4170.0n
.meas tran gated_k38 FIND v(gated) AT=4170.0n
.meas tran startup_done_k38 FIND v(startup_done) AT=4170.0n
.meas tran out_valid_k38 FIND v(out_valid) AT=4170.0n
.meas tran alarm_k39 FIND v(alarm) AT=4270.0n
.meas tran gated_k39 FIND v(gated) AT=4270.0n
.meas tran startup_done_k39 FIND v(startup_done) AT=4270.0n
.meas tran out_valid_k39 FIND v(out_valid) AT=4270.0n
.meas tran alarm_k40 FIND v(alarm) AT=4370.0n
.meas tran gated_k40 FIND v(gated) AT=4370.0n
.meas tran startup_done_k40 FIND v(startup_done) AT=4370.0n
.meas tran out_valid_k40 FIND v(out_valid) AT=4370.0n
.meas tran alarm_k41 FIND v(alarm) AT=4470.0n
.meas tran gated_k41 FIND v(gated) AT=4470.0n
.meas tran startup_done_k41 FIND v(startup_done) AT=4470.0n
.meas tran out_valid_k41 FIND v(out_valid) AT=4470.0n
.meas tran alarm_k42 FIND v(alarm) AT=4570.0n
.meas tran gated_k42 FIND v(gated) AT=4570.0n
.meas tran startup_done_k42 FIND v(startup_done) AT=4570.0n
.meas tran out_valid_k42 FIND v(out_valid) AT=4570.0n
.meas tran alarm_k43 FIND v(alarm) AT=4670.0n
.meas tran gated_k43 FIND v(gated) AT=4670.0n
.meas tran startup_done_k43 FIND v(startup_done) AT=4670.0n
.meas tran out_valid_k43 FIND v(out_valid) AT=4670.0n
.meas tran alarm_k44 FIND v(alarm) AT=4770.0n
.meas tran gated_k44 FIND v(gated) AT=4770.0n
.meas tran startup_done_k44 FIND v(startup_done) AT=4770.0n
.meas tran out_valid_k44 FIND v(out_valid) AT=4770.0n
.meas tran alarm_k45 FIND v(alarm) AT=4870.0n
.meas tran gated_k45 FIND v(gated) AT=4870.0n
.meas tran startup_done_k45 FIND v(startup_done) AT=4870.0n
.meas tran out_valid_k45 FIND v(out_valid) AT=4870.0n
.meas tran alarm_k46 FIND v(alarm) AT=4970.0n
.meas tran gated_k46 FIND v(gated) AT=4970.0n
.meas tran startup_done_k46 FIND v(startup_done) AT=4970.0n
.meas tran out_valid_k46 FIND v(out_valid) AT=4970.0n
.meas tran alarm_k47 FIND v(alarm) AT=5070.0n
.meas tran gated_k47 FIND v(gated) AT=5070.0n
.meas tran startup_done_k47 FIND v(startup_done) AT=5070.0n
.meas tran out_valid_k47 FIND v(out_valid) AT=5070.0n
.meas tran alarm_k48 FIND v(alarm) AT=5170.0n
.meas tran gated_k48 FIND v(gated) AT=5170.0n
.meas tran startup_done_k48 FIND v(startup_done) AT=5170.0n
.meas tran out_valid_k48 FIND v(out_valid) AT=5170.0n
.meas tran alarm_k49 FIND v(alarm) AT=5270.0n
.meas tran gated_k49 FIND v(gated) AT=5270.0n
.meas tran startup_done_k49 FIND v(startup_done) AT=5270.0n
.meas tran out_valid_k49 FIND v(out_valid) AT=5270.0n
.meas tran alarm_k50 FIND v(alarm) AT=5370.0n
.meas tran gated_k50 FIND v(gated) AT=5370.0n
.meas tran startup_done_k50 FIND v(startup_done) AT=5370.0n
.meas tran out_valid_k50 FIND v(out_valid) AT=5370.0n
.meas tran alarm_k51 FIND v(alarm) AT=5470.0n
.meas tran gated_k51 FIND v(gated) AT=5470.0n
.meas tran startup_done_k51 FIND v(startup_done) AT=5470.0n
.meas tran out_valid_k51 FIND v(out_valid) AT=5470.0n
.meas tran alarm_k52 FIND v(alarm) AT=5570.0n
.meas tran gated_k52 FIND v(gated) AT=5570.0n
.meas tran startup_done_k52 FIND v(startup_done) AT=5570.0n
.meas tran out_valid_k52 FIND v(out_valid) AT=5570.0n
.meas tran alarm_k53 FIND v(alarm) AT=5670.0n
.meas tran gated_k53 FIND v(gated) AT=5670.0n
.meas tran startup_done_k53 FIND v(startup_done) AT=5670.0n
.meas tran out_valid_k53 FIND v(out_valid) AT=5670.0n
.meas tran alarm_k54 FIND v(alarm) AT=5770.0n
.meas tran gated_k54 FIND v(gated) AT=5770.0n
.meas tran startup_done_k54 FIND v(startup_done) AT=5770.0n
.meas tran out_valid_k54 FIND v(out_valid) AT=5770.0n
.meas tran alarm_k55 FIND v(alarm) AT=5870.0n
.meas tran gated_k55 FIND v(gated) AT=5870.0n
.meas tran startup_done_k55 FIND v(startup_done) AT=5870.0n
.meas tran out_valid_k55 FIND v(out_valid) AT=5870.0n
.meas tran alarm_k56 FIND v(alarm) AT=5970.0n
.meas tran gated_k56 FIND v(gated) AT=5970.0n
.meas tran startup_done_k56 FIND v(startup_done) AT=5970.0n
.meas tran out_valid_k56 FIND v(out_valid) AT=5970.0n
.meas tran alarm_k57 FIND v(alarm) AT=6070.0n
.meas tran gated_k57 FIND v(gated) AT=6070.0n
.meas tran startup_done_k57 FIND v(startup_done) AT=6070.0n
.meas tran out_valid_k57 FIND v(out_valid) AT=6070.0n
.meas tran alarm_k58 FIND v(alarm) AT=6170.0n
.meas tran gated_k58 FIND v(gated) AT=6170.0n
.meas tran startup_done_k58 FIND v(startup_done) AT=6170.0n
.meas tran out_valid_k58 FIND v(out_valid) AT=6170.0n
.meas tran alarm_k59 FIND v(alarm) AT=6270.0n
.meas tran gated_k59 FIND v(gated) AT=6270.0n
.meas tran startup_done_k59 FIND v(startup_done) AT=6270.0n
.meas tran out_valid_k59 FIND v(out_valid) AT=6270.0n
.meas tran alarm_k60 FIND v(alarm) AT=6370.0n
.meas tran gated_k60 FIND v(gated) AT=6370.0n
.meas tran startup_done_k60 FIND v(startup_done) AT=6370.0n
.meas tran out_valid_k60 FIND v(out_valid) AT=6370.0n
.meas tran alarm_k61 FIND v(alarm) AT=6470.0n
.meas tran gated_k61 FIND v(gated) AT=6470.0n
.meas tran startup_done_k61 FIND v(startup_done) AT=6470.0n
.meas tran out_valid_k61 FIND v(out_valid) AT=6470.0n
.meas tran alarm_k62 FIND v(alarm) AT=6570.0n
.meas tran gated_k62 FIND v(gated) AT=6570.0n
.meas tran startup_done_k62 FIND v(startup_done) AT=6570.0n
.meas tran out_valid_k62 FIND v(out_valid) AT=6570.0n
.meas tran alarm_k63 FIND v(alarm) AT=6670.0n
.meas tran gated_k63 FIND v(gated) AT=6670.0n
.meas tran startup_done_k63 FIND v(startup_done) AT=6670.0n
.meas tran out_valid_k63 FIND v(out_valid) AT=6670.0n
.meas tran alarm_k64 FIND v(alarm) AT=6770.0n
.meas tran gated_k64 FIND v(gated) AT=6770.0n
.meas tran startup_done_k64 FIND v(startup_done) AT=6770.0n
.meas tran out_valid_k64 FIND v(out_valid) AT=6770.0n
.meas tran alarm_k65 FIND v(alarm) AT=6870.0n
.meas tran gated_k65 FIND v(gated) AT=6870.0n
.meas tran startup_done_k65 FIND v(startup_done) AT=6870.0n
.meas tran out_valid_k65 FIND v(out_valid) AT=6870.0n
.meas tran alarm_k66 FIND v(alarm) AT=6970.0n
.meas tran gated_k66 FIND v(gated) AT=6970.0n
.meas tran startup_done_k66 FIND v(startup_done) AT=6970.0n
.meas tran out_valid_k66 FIND v(out_valid) AT=6970.0n
.meas tran alarm_k67 FIND v(alarm) AT=7070.0n
.meas tran gated_k67 FIND v(gated) AT=7070.0n
.meas tran startup_done_k67 FIND v(startup_done) AT=7070.0n
.meas tran out_valid_k67 FIND v(out_valid) AT=7070.0n
.meas tran alarm_k68 FIND v(alarm) AT=7170.0n
.meas tran gated_k68 FIND v(gated) AT=7170.0n
.meas tran startup_done_k68 FIND v(startup_done) AT=7170.0n
.meas tran out_valid_k68 FIND v(out_valid) AT=7170.0n
.meas tran alarm_k69 FIND v(alarm) AT=7270.0n
.meas tran gated_k69 FIND v(gated) AT=7270.0n
.meas tran startup_done_k69 FIND v(startup_done) AT=7270.0n
.meas tran out_valid_k69 FIND v(out_valid) AT=7270.0n
.meas tran alarm_k70 FIND v(alarm) AT=7370.0n
.meas tran gated_k70 FIND v(gated) AT=7370.0n
.meas tran startup_done_k70 FIND v(startup_done) AT=7370.0n
.meas tran out_valid_k70 FIND v(out_valid) AT=7370.0n
.meas tran alarm_k71 FIND v(alarm) AT=7470.0n
.meas tran gated_k71 FIND v(gated) AT=7470.0n
.meas tran startup_done_k71 FIND v(startup_done) AT=7470.0n
.meas tran out_valid_k71 FIND v(out_valid) AT=7470.0n
.meas tran alarm_k72 FIND v(alarm) AT=7570.0n
.meas tran gated_k72 FIND v(gated) AT=7570.0n
.meas tran startup_done_k72 FIND v(startup_done) AT=7570.0n
.meas tran out_valid_k72 FIND v(out_valid) AT=7570.0n
.meas tran alarm_k73 FIND v(alarm) AT=7670.0n
.meas tran gated_k73 FIND v(gated) AT=7670.0n
.meas tran startup_done_k73 FIND v(startup_done) AT=7670.0n
.meas tran out_valid_k73 FIND v(out_valid) AT=7670.0n
.meas tran alarm_k74 FIND v(alarm) AT=7770.0n
.meas tran gated_k74 FIND v(gated) AT=7770.0n
.meas tran startup_done_k74 FIND v(startup_done) AT=7770.0n
.meas tran out_valid_k74 FIND v(out_valid) AT=7770.0n
.meas tran t_clk_first WHEN v(clk)=0.9 RISE=1
.meas tran raw_bit_k0 FIND v(raw_bit) AT=400.0n
.meas tran raw_valid_k0 FIND v(raw_valid) AT=400.0n
.meas tran raw_bit_k1 FIND v(raw_bit) AT=500.0n
.meas tran raw_valid_k1 FIND v(raw_valid) AT=500.0n
.meas tran raw_bit_k2 FIND v(raw_bit) AT=600.0n
.meas tran raw_valid_k2 FIND v(raw_valid) AT=600.0n
.meas tran raw_bit_k3 FIND v(raw_bit) AT=700.0n
.meas tran raw_valid_k3 FIND v(raw_valid) AT=700.0n
.meas tran raw_bit_k4 FIND v(raw_bit) AT=800.0n
.meas tran raw_valid_k4 FIND v(raw_valid) AT=800.0n
.meas tran raw_bit_k5 FIND v(raw_bit) AT=900.0n
.meas tran raw_valid_k5 FIND v(raw_valid) AT=900.0n
.meas tran raw_bit_k6 FIND v(raw_bit) AT=1000.0n
.meas tran raw_valid_k6 FIND v(raw_valid) AT=1000.0n
.meas tran raw_bit_k7 FIND v(raw_bit) AT=1100.0n
.meas tran raw_valid_k7 FIND v(raw_valid) AT=1100.0n
.meas tran raw_bit_k8 FIND v(raw_bit) AT=1200.0n
.meas tran raw_valid_k8 FIND v(raw_valid) AT=1200.0n
.meas tran raw_bit_k9 FIND v(raw_bit) AT=1300.0n
.meas tran raw_valid_k9 FIND v(raw_valid) AT=1300.0n
.meas tran raw_bit_k10 FIND v(raw_bit) AT=1400.0n
.meas tran raw_valid_k10 FIND v(raw_valid) AT=1400.0n
.meas tran raw_bit_k11 FIND v(raw_bit) AT=1500.0n
.meas tran raw_valid_k11 FIND v(raw_valid) AT=1500.0n
.meas tran raw_bit_k12 FIND v(raw_bit) AT=1600.0n
.meas tran raw_valid_k12 FIND v(raw_valid) AT=1600.0n
.meas tran raw_bit_k13 FIND v(raw_bit) AT=1700.0n
.meas tran raw_valid_k13 FIND v(raw_valid) AT=1700.0n
.meas tran raw_bit_k14 FIND v(raw_bit) AT=1800.0n
.meas tran raw_valid_k14 FIND v(raw_valid) AT=1800.0n
.meas tran raw_bit_k15 FIND v(raw_bit) AT=1900.0n
.meas tran raw_valid_k15 FIND v(raw_valid) AT=1900.0n
.meas tran raw_bit_k16 FIND v(raw_bit) AT=2000.0n
.meas tran raw_valid_k16 FIND v(raw_valid) AT=2000.0n
.meas tran raw_bit_k17 FIND v(raw_bit) AT=2100.0n
.meas tran raw_valid_k17 FIND v(raw_valid) AT=2100.0n
.meas tran raw_bit_k18 FIND v(raw_bit) AT=2200.0n
.meas tran raw_valid_k18 FIND v(raw_valid) AT=2200.0n
.meas tran raw_bit_k19 FIND v(raw_bit) AT=2300.0n
.meas tran raw_valid_k19 FIND v(raw_valid) AT=2300.0n
.meas tran raw_bit_k20 FIND v(raw_bit) AT=2400.0n
.meas tran raw_valid_k20 FIND v(raw_valid) AT=2400.0n
.meas tran raw_bit_k21 FIND v(raw_bit) AT=2500.0n
.meas tran raw_valid_k21 FIND v(raw_valid) AT=2500.0n
.meas tran raw_bit_k22 FIND v(raw_bit) AT=2600.0n
.meas tran raw_valid_k22 FIND v(raw_valid) AT=2600.0n
.meas tran raw_bit_k23 FIND v(raw_bit) AT=2700.0n
.meas tran raw_valid_k23 FIND v(raw_valid) AT=2700.0n
.meas tran raw_bit_k24 FIND v(raw_bit) AT=2800.0n
.meas tran raw_valid_k24 FIND v(raw_valid) AT=2800.0n
.meas tran raw_bit_k25 FIND v(raw_bit) AT=2900.0n
.meas tran raw_valid_k25 FIND v(raw_valid) AT=2900.0n
.meas tran raw_bit_k26 FIND v(raw_bit) AT=3000.0n
.meas tran raw_valid_k26 FIND v(raw_valid) AT=3000.0n
.meas tran raw_bit_k27 FIND v(raw_bit) AT=3100.0n
.meas tran raw_valid_k27 FIND v(raw_valid) AT=3100.0n
.meas tran raw_bit_k28 FIND v(raw_bit) AT=3200.0n
.meas tran raw_valid_k28 FIND v(raw_valid) AT=3200.0n
.meas tran raw_bit_k29 FIND v(raw_bit) AT=3300.0n
.meas tran raw_valid_k29 FIND v(raw_valid) AT=3300.0n
.meas tran raw_bit_k30 FIND v(raw_bit) AT=3400.0n
.meas tran raw_valid_k30 FIND v(raw_valid) AT=3400.0n
.meas tran raw_bit_k31 FIND v(raw_bit) AT=3500.0n
.meas tran raw_valid_k31 FIND v(raw_valid) AT=3500.0n
.meas tran raw_bit_k32 FIND v(raw_bit) AT=3600.0n
.meas tran raw_valid_k32 FIND v(raw_valid) AT=3600.0n
.meas tran raw_bit_k33 FIND v(raw_bit) AT=3700.0n
.meas tran raw_valid_k33 FIND v(raw_valid) AT=3700.0n
.meas tran raw_bit_k34 FIND v(raw_bit) AT=3800.0n
.meas tran raw_valid_k34 FIND v(raw_valid) AT=3800.0n
.meas tran raw_bit_k35 FIND v(raw_bit) AT=3900.0n
.meas tran raw_valid_k35 FIND v(raw_valid) AT=3900.0n
.meas tran raw_bit_k36 FIND v(raw_bit) AT=4000.0n
.meas tran raw_valid_k36 FIND v(raw_valid) AT=4000.0n
.meas tran raw_bit_k37 FIND v(raw_bit) AT=4100.0n
.meas tran raw_valid_k37 FIND v(raw_valid) AT=4100.0n
.meas tran raw_bit_k38 FIND v(raw_bit) AT=4200.0n
.meas tran raw_valid_k38 FIND v(raw_valid) AT=4200.0n
.meas tran raw_bit_k39 FIND v(raw_bit) AT=4300.0n
.meas tran raw_valid_k39 FIND v(raw_valid) AT=4300.0n
.meas tran raw_bit_k40 FIND v(raw_bit) AT=4400.0n
.meas tran raw_valid_k40 FIND v(raw_valid) AT=4400.0n
.meas tran raw_bit_k41 FIND v(raw_bit) AT=4500.0n
.meas tran raw_valid_k41 FIND v(raw_valid) AT=4500.0n
.meas tran raw_bit_k42 FIND v(raw_bit) AT=4600.0n
.meas tran raw_valid_k42 FIND v(raw_valid) AT=4600.0n
.meas tran raw_bit_k43 FIND v(raw_bit) AT=4700.0n
.meas tran raw_valid_k43 FIND v(raw_valid) AT=4700.0n
.meas tran raw_bit_k44 FIND v(raw_bit) AT=4800.0n
.meas tran raw_valid_k44 FIND v(raw_valid) AT=4800.0n
.meas tran raw_bit_k45 FIND v(raw_bit) AT=4900.0n
.meas tran raw_valid_k45 FIND v(raw_valid) AT=4900.0n
.meas tran raw_bit_k46 FIND v(raw_bit) AT=5000.0n
.meas tran raw_valid_k46 FIND v(raw_valid) AT=5000.0n
.meas tran raw_bit_k47 FIND v(raw_bit) AT=5100.0n
.meas tran raw_valid_k47 FIND v(raw_valid) AT=5100.0n
.meas tran raw_bit_k48 FIND v(raw_bit) AT=5200.0n
.meas tran raw_valid_k48 FIND v(raw_valid) AT=5200.0n
.meas tran raw_bit_k49 FIND v(raw_bit) AT=5300.0n
.meas tran raw_valid_k49 FIND v(raw_valid) AT=5300.0n
.meas tran raw_bit_k50 FIND v(raw_bit) AT=5400.0n
.meas tran raw_valid_k50 FIND v(raw_valid) AT=5400.0n
.meas tran raw_bit_k51 FIND v(raw_bit) AT=5500.0n
.meas tran raw_valid_k51 FIND v(raw_valid) AT=5500.0n
.meas tran raw_bit_k52 FIND v(raw_bit) AT=5600.0n
.meas tran raw_valid_k52 FIND v(raw_valid) AT=5600.0n
.meas tran raw_bit_k53 FIND v(raw_bit) AT=5700.0n
.meas tran raw_valid_k53 FIND v(raw_valid) AT=5700.0n
.meas tran raw_bit_k54 FIND v(raw_bit) AT=5800.0n
.meas tran raw_valid_k54 FIND v(raw_valid) AT=5800.0n
.meas tran raw_bit_k55 FIND v(raw_bit) AT=5900.0n
.meas tran raw_valid_k55 FIND v(raw_valid) AT=5900.0n
.meas tran raw_bit_k56 FIND v(raw_bit) AT=6000.0n
.meas tran raw_valid_k56 FIND v(raw_valid) AT=6000.0n
.meas tran raw_bit_k57 FIND v(raw_bit) AT=6100.0n
.meas tran raw_valid_k57 FIND v(raw_valid) AT=6100.0n
.meas tran raw_bit_k58 FIND v(raw_bit) AT=6200.0n
.meas tran raw_valid_k58 FIND v(raw_valid) AT=6200.0n
.meas tran raw_bit_k59 FIND v(raw_bit) AT=6300.0n
.meas tran raw_valid_k59 FIND v(raw_valid) AT=6300.0n
.meas tran raw_bit_k60 FIND v(raw_bit) AT=6400.0n
.meas tran raw_valid_k60 FIND v(raw_valid) AT=6400.0n
.meas tran raw_bit_k61 FIND v(raw_bit) AT=6500.0n
.meas tran raw_valid_k61 FIND v(raw_valid) AT=6500.0n
.meas tran raw_bit_k62 FIND v(raw_bit) AT=6600.0n
.meas tran raw_valid_k62 FIND v(raw_valid) AT=6600.0n
.meas tran raw_bit_k63 FIND v(raw_bit) AT=6700.0n
.meas tran raw_valid_k63 FIND v(raw_valid) AT=6700.0n
.meas tran raw_bit_k64 FIND v(raw_bit) AT=6800.0n
.meas tran raw_valid_k64 FIND v(raw_valid) AT=6800.0n
.meas tran raw_bit_k65 FIND v(raw_bit) AT=6900.0n
.meas tran raw_valid_k65 FIND v(raw_valid) AT=6900.0n
.meas tran raw_bit_k66 FIND v(raw_bit) AT=7000.0n
.meas tran raw_valid_k66 FIND v(raw_valid) AT=7000.0n
.meas tran raw_bit_k67 FIND v(raw_bit) AT=7100.0n
.meas tran raw_valid_k67 FIND v(raw_valid) AT=7100.0n
.meas tran raw_bit_k68 FIND v(raw_bit) AT=7200.0n
.meas tran raw_valid_k68 FIND v(raw_valid) AT=7200.0n
.meas tran raw_bit_k69 FIND v(raw_bit) AT=7300.0n
.meas tran raw_valid_k69 FIND v(raw_valid) AT=7300.0n
.meas tran raw_bit_k70 FIND v(raw_bit) AT=7400.0n
.meas tran raw_valid_k70 FIND v(raw_valid) AT=7400.0n
.meas tran raw_bit_k71 FIND v(raw_bit) AT=7500.0n
.meas tran raw_valid_k71 FIND v(raw_valid) AT=7500.0n
.meas tran raw_bit_k72 FIND v(raw_bit) AT=7600.0n
.meas tran raw_valid_k72 FIND v(raw_valid) AT=7600.0n
.meas tran raw_bit_k73 FIND v(raw_bit) AT=7700.0n
.meas tran raw_valid_k73 FIND v(raw_valid) AT=7700.0n
.meas tran raw_bit_k74 FIND v(raw_bit) AT=7800.0n
.meas tran raw_valid_k74 FIND v(raw_valid) AT=7800.0n
.meas tran clk_at_stop FIND v(clk) AT=7870n
.meas tran t_out_valid_first WHEN v(out_valid)=1.215 RISE=1
.meas tran i_vdd_w1 AVG i(Vvdd) FROM=50n TO=250n
.meas tran i_vdd_w2 AVG i(Vvdd) FROM=520n TO=7770n
.meas tran q_vdd_w2 INTEG i(Vvdd) FROM=520n TO=7770n
.meas tran i_vddr1_w1 AVG i(Vvddr1) FROM=50n TO=250n
.meas tran i_vddr1_w2 AVG i(Vvddr1) FROM=520n TO=7770n
.meas tran q_vddr1_w2 INTEG i(Vvddr1) FROM=520n TO=7770n
.meas tran i_vddr2_w1 AVG i(Vvddr2) FROM=50n TO=250n
.meas tran i_vddr2_w2 AVG i(Vvddr2) FROM=520n TO=7770n
.meas tran q_vddr2_w2 INTEG i(Vvddr2) FROM=520n TO=7770n
.meas tran i_vddr3_w1 AVG i(Vvddr3) FROM=50n TO=250n
.meas tran i_vddr3_w2 AVG i(Vvddr3) FROM=520n TO=7770n
.meas tran q_vddr3_w2 INTEG i(Vvddr3) FROM=520n TO=7770n
.meas tran i_vddr4_w1 AVG i(Vvddr4) FROM=50n TO=250n
.meas tran i_vddr4_w2 AVG i(Vvddr4) FROM=520n TO=7770n
.meas tran q_vddr4_w2 INTEG i(Vvddr4) FROM=520n TO=7770n
.meas tran i_vss_w2 AVG i(Vvss) FROM=520n TO=7770n
.control
alter Vvdd=1.62
alter Vvddr1=1.62
alter Vvddr2=1.62
alter Vvddr3=1.62
alter Vvddr4=1.62
tran 20p 7870n
quit
.endc
.end
